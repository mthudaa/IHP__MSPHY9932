* adc8b Hierarchical LVS+PEX
* side_cap8b: PEX-CC, sar12b/cmp/diff_bsw: LVS

.include side_cap8b_pex_cc.spice
.include sar12b_lvs.spice
.include cmp_lvs.spice
.include diff_bsw_lvs.spice

.subckt adc8b_hier vdd vddr vss vip vin cks d0 d1 d2 cko frame

* side_cap8b x7 - connects to sar12b ph_sw/pl_sw
x_sc0 vddr vss ph0 ph1 ph2 ph3 ph4 ph5 ph6 ph7 ph8 ph9 ph10 pl0 pl1 pl2 pl3 pl4 pl5 pl6 pl7 pl8 pl9 pl10 vcp side_cap8b_pex
x_sc1 vdd vss nh0 nh1 nh2 nh3 nh4 nh5 nh6 nh7 nh8 nh9 nh10 nl0 nl1 nl2 nl3 nl4 nl5 nl6 nl7 nl8 nl9 nl10 vcn side_cap8b_pex

* sar12b
x_sar vss vdd nh0 nh10 nh1 nh2 nh3 nh4 nh5 nh6 nh7 nh8 nh9 nl0 nl10 nl1 nl2 nl3 nl4 nl5 nl6 nl7 nl8 nl9 ph0 ph10 ph1 ph2 ph3 ph4 ph5 ph6 ph7 ph8 ph9 pl0 pl10 pl1 pl2 pl3 pl4 pl5 pl6 pl7 pl8 pl9 ckc cko cks comp_p d0 d1 d2 frame rdy sar12b_flat

* diff_bsw
x_dbs vip vin cks vdd vss vcp vcn diff_bsw_flat

* cmp
x_cmp vdd vss vcp vcn ckc rdy comp_p comp_n cmp_flat

.ends
