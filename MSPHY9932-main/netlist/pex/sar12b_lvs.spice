* NGSPICE file created from sar12b_flat.ext - technology: ihp-sg13cmos5l

.subckt sar12b_flat VGND VPWR nh_sw[0] nh_sw[10] nh_sw[1] nh_sw[2] nh_sw[3] nh_sw[4]
+ nh_sw[5] nh_sw[6] nh_sw[7] nh_sw[8] nh_sw[9] nl_sw[0] nl_sw[10] nl_sw[1] nl_sw[2]
+ nl_sw[3] nl_sw[4] nl_sw[5] nl_sw[6] nl_sw[7] nl_sw[8] nl_sw[9] ph_sw[0] ph_sw[10]
+ ph_sw[1] ph_sw[2] ph_sw[3] ph_sw[4] ph_sw[5] ph_sw[6] ph_sw[7] ph_sw[8] ph_sw[9]
+ pl_sw[0] pl_sw[10] pl_sw[1] pl_sw[2] pl_sw[3] pl_sw[4] pl_sw[5] pl_sw[6] pl_sw[7]
+ pl_sw[8] pl_sw[9] ckc cko cks comp_p d_out[0] d_out[1] d_out[2] frame rdy
X0 a_15974_6162# sg13cmos5l_buf_1_57.X VPWR VPWR sg13_lv_pmos ad=79.8f pd=0.8u as=0.1428p ps=1.52u w=0.42u l=0.13u
X1 a_7440_1948# a_6889_1680# VPWR VPWR sg13_lv_pmos ad=0.105p pd=1.21u as=1.86162p ps=11.935u w=1u l=0.13u
X2 VPWR sg13cmos5l_inv_1_27.Y a_14632_9224# VPWR sg13_lv_pmos ad=0.2114p pd=1.54u as=0.2856p ps=2.36u w=0.84u l=0.13u
X3 VGND a_7820_9150# sg13cmos5l_buf_1_73.X VGND sg13_lv_nmos ad=0.14875p pd=1.16u as=0.2886p ps=2.26u w=0.74u l=0.13u
X4 VPWR sg13cmos5l_dfrbp_1_6.RESET_B a_12490_6385# VPWR sg13_lv_pmos ad=0.1563p pd=1.22u as=0.147p ps=1.54u w=0.42u l=0.13u
X5 VPWR a_10473_9186# a_10406_9624# VPWR sg13_lv_pmos ad=0.2387p pd=1.84u as=0.1008p ps=0.9u w=0.42u l=0.13u
X6 VGND a_15429_7653# a_15531_7796# VGND sg13_lv_nmos ad=1.49685p pd=9.6u as=0.2516p ps=2.16u w=0.74u l=0.13u
X7 VPWR a_16940_3102# nh_sw[8] VPWR sg13_lv_pmos ad=0.2114p pd=1.54u as=0.42p ps=2.99u w=1.12u l=0.13u
X8 VPWR a_12976_2630# a_12921_2511# VPWR sg13_lv_pmos ad=1.86162p pd=11.935u as=93.45f ps=0.865u w=0.42u l=0.13u
X9 sg13cmos5l_buf_1_44.A a_5673_3138# VGND VGND sg13_lv_nmos ad=0.2516p pd=2.16u as=0.1406p ps=1.12u w=0.74u l=0.13u
X10 a_13072_4142# a_12815_4261# a_13234_4338# VGND sg13_lv_nmos ad=0.1428p pd=1.52u as=37.8f ps=0.6u w=0.42u l=0.13u
X11 VPWR sg13cmos5l_inv_1_6.A sg13cmos5l_buf_1_0.A VPWR sg13_lv_pmos ad=0.3808p pd=2.92u as=0.3808p ps=2.92u w=1.12u l=0.13u
X12 a_5104_4870# a_4847_4727# a_5266_4650# VGND sg13_lv_nmos ad=0.1428p pd=1.52u as=37.8f ps=0.6u w=0.42u l=0.13u
X13 a_18615_5770# sg13cmos5l_dfrbp_1_8.D VGND VGND sg13_lv_nmos ad=0.2516p pd=2.16u as=0.15055p ps=1.17u w=0.74u l=0.13u
X14 a_11072_5347# sg13cmos5l_nor2_1_0.A VPWR VPWR sg13_lv_pmos ad=0.2856p pd=2.36u as=0.1596p ps=1.22u w=0.84u l=0.13u
X15 VPWR sg13cmos5l_dfrbp_1_21.Q_N a_18793_6216# VPWR sg13_lv_pmos ad=1.07253p pd=6.75u as=0.2856p ps=2.36u w=0.84u l=0.13u
X16 VPWR a_14543_3215# a_15380_3436# VPWR sg13_lv_pmos ad=0.2128p pd=1.5u as=0.3864p ps=2.93u w=1.12u l=0.13u
X17 pl_sw[5] a_7336_9224# VGND VGND sg13_lv_nmos ad=0.2886p pd=2.26u as=0.14875p ps=1.16u w=0.74u l=0.13u
X18 a_11973_1605# sg13cmos5l_dfrbp_1_0.CLK VGND VGND sg13_lv_nmos ad=0.2516p pd=2.16u as=5.84582p ps=38.34u w=0.74u l=0.13u
X19 VPWR a_11973_3911# a_12075_3911# VPWR sg13_lv_pmos ad=1.43437p pd=9.105u as=0.3864p ps=2.93u w=1.12u l=0.13u
X20 VGND a_3407_8797# a_4244_8436# VGND sg13_lv_nmos ad=0.1406p pd=1.12u as=0.2516p ps=2.16u w=0.74u l=0.13u
X21 VPWR a_19209_5769# a_19734_5842# VPWR sg13_lv_pmos ad=0.1974p pd=1.5u as=0.2856p ps=2.36u w=0.84u l=0.13u
X22 sg13cmos5l_dlhr_1_16.Q a_19209_5769# VGND VGND sg13_lv_nmos ad=0.2516p pd=2.16u as=0.1406p ps=1.12u w=0.74u l=0.13u
X23 VPWR a_19340_8400# pl_sw[9] VPWR sg13_lv_pmos ad=0.2114p pd=1.54u as=0.42p ps=2.99u w=1.12u l=0.13u
X24 sg13cmos5l_dlhr_1_2.D a_6479_2749# VGND VGND sg13_lv_nmos ad=0.2849p pd=2.25u as=0.2516p ps=2.16u w=0.74u l=0.13u
X25 a_13100_8400# sg13cmos5l_buf_1_90.X VGND VGND sg13_lv_nmos ad=0.187p pd=1.78u as=0.14875p ps=1.16u w=0.55u l=0.13u
X26 a_10071_7282# sg13cmos5l_dfrbp_1_18.Q VGND VGND sg13_lv_nmos ad=0.2516p pd=2.16u as=0.15055p ps=1.17u w=0.74u l=0.13u
X27 VPWR a_10288_8678# a_10233_8559# VPWR sg13_lv_pmos ad=1.15047p pd=7.175u as=93.45f ps=0.865u w=0.42u l=0.13u
X28 a_13701_3117# sg13cmos5l_dfrbp_1_0.CLK VGND VGND sg13_lv_nmos ad=0.2516p pd=2.16u as=2.43055p ps=15.415u w=0.74u l=0.13u
X29 a_1484_9150# sg13cmos5l_inv_1_19.A VGND VGND sg13_lv_nmos ad=0.187p pd=1.78u as=0.14875p ps=1.16u w=0.55u l=0.13u
X30 a_934_7349# sg13cmos5l_dfrbp_1_6.RESET_B VGND VGND sg13_lv_nmos ad=37.8f pd=0.6u as=0.1701p ps=1.65u w=0.42u l=0.13u
X31 VPWR a_14889_7281# a_14822_6924# VPWR sg13_lv_pmos ad=0.2387p pd=1.84u as=0.1008p ps=0.9u w=0.42u l=0.13u
X32 sg13cmos5l_buf_1_19.A a_18856_8436# VPWR VPWR sg13_lv_pmos ad=0.42p pd=2.99u as=0.2114p ps=1.54u w=1.12u l=0.13u
X33 a_16068_6928# a_16042_6892# VPWR VPWR sg13_lv_pmos ad=0.34p pd=2.68u as=0.36237p ps=2.605u w=1u l=0.13u
X34 VPWR a_16748_9150# pl_sw[7] VPWR sg13_lv_pmos ad=0.2114p pd=1.54u as=0.42p ps=2.99u w=1.12u l=0.13u
X35 sg13cmos5l_buf_1_96.A a_10665_7281# VGND VGND sg13_lv_nmos ad=0.2516p pd=2.16u as=0.1406p ps=1.12u w=0.74u l=0.13u
X36 a_14889_7281# a_14708_6924# VPWR VPWR sg13_lv_pmos ad=0.2128p pd=1.5u as=0.2387p ps=1.84u w=1.12u l=0.13u
X37 a_6898_2826# sg13cmos5l_dfrbp_1_6.RESET_B VGND VGND sg13_lv_nmos ad=37.8f pd=0.6u as=79.8f ps=0.8u w=0.42u l=0.13u
X38 a_11530_1849# a_11973_1605# a_11913_2017# VPWR sg13_lv_pmos ad=79.8f pd=0.8u as=63f ps=0.72u w=0.42u l=0.13u
X39 VGND sg13cmos5l_buf_1_111.A a_18376_9224# VGND sg13_lv_nmos ad=0.14875p pd=1.16u as=0.187p ps=1.78u w=0.55u l=0.13u
X40 a_16677_6141# sg13cmos5l_dfrbp_1_8.D VPWR VPWR sg13_lv_pmos ad=0.4088p pd=2.97u as=1.04815p ps=6.595u w=1.12u l=0.13u
X41 a_13284_3456# a_13258_3361# VPWR VPWR sg13_lv_pmos ad=0.34p pd=2.68u as=0.36237p ps=2.605u w=1u l=0.13u
X42 a_16271_7751# a_15429_7653# a_16177_7751# VGND sg13_lv_nmos ad=0.12665p pd=1.145u as=0.1428p ps=1.52u w=0.42u l=0.13u
X43 VPWR a_7689_1626# a_7622_2064# VPWR sg13_lv_pmos ad=0.2387p pd=1.84u as=0.1008p ps=0.9u w=0.42u l=0.13u
X44 VGND a_9705_4650# a_9660_4686# VGND sg13_lv_nmos ad=0.1428p pd=1.52u as=47.25f ps=0.645u w=0.42u l=0.13u
X45 sg13cmos5l_dfrbp_1_12.Q_N a_7055_4261# VGND VGND sg13_lv_nmos ad=0.2849p pd=2.25u as=0.2516p ps=2.16u w=0.74u l=0.13u
X46 sg13cmos5l_nor2_1_2.A sg13cmos5l_inv_1_9.Y VPWR VPWR sg13_lv_pmos ad=0.3808p pd=2.92u as=0.3808p ps=2.92u w=1.12u l=0.13u
X47 VGND a_2565_8447# a_2667_8447# VGND sg13_lv_nmos ad=2.92392p pd=18.89u as=0.2516p ps=2.16u w=0.74u l=0.13u
X48 a_1997_6126# a_2727_6380# a_2748_6126# VGND sg13_lv_nmos ad=0.12665p pd=1.145u as=0.3473p ps=2.71u w=0.74u l=0.13u
X49 VGND VPWR VGND VGND sg13_lv_nmos ad=0.1428p pd=1.52u as=0.40368n ps=2.16158m w=0.42u l=1u
X50 a_15702_4187# a_15821_3864# VPWR VPWR sg13_lv_pmos ad=0.3864p pd=2.93u as=0.2128p ps=1.5u w=1.12u l=0.13u
X51 a_10031_8797# a_9189_8447# a_9937_8797# VGND sg13_lv_nmos ad=0.12665p pd=1.145u as=0.1428p ps=1.52u w=0.42u l=0.13u
X52 a_5414_6162# sg13cmos5l_dfrbp_1_6.D VPWR VPWR sg13_lv_pmos ad=79.8f pd=0.8u as=0.1428p ps=1.52u w=0.42u l=0.13u
X53 VPWR a_15429_7653# a_15531_7796# VPWR sg13_lv_pmos ad=1.15047p pd=7.175u as=0.3864p ps=2.93u w=1.12u l=0.13u
X54 VPWR a_1967_7285# a_2804_6924# VPWR sg13_lv_pmos ad=0.2128p pd=1.5u as=0.3864p ps=2.93u w=1.12u l=0.13u
X55 nl_sw[3] a_4456_1664# VGND VGND sg13_lv_nmos ad=0.2886p pd=2.26u as=0.14875p ps=1.16u w=0.74u l=0.13u
X56 VGND sg13cmos5l_nor2_1_0.A a_12814_4692# VGND sg13_lv_nmos ad=0.17255p pd=1.25u as=0.187p ps=1.78u w=0.55u l=0.13u
X57 sg13cmos5l_buf_1_78.X a_6184_9224# VPWR VPWR sg13_lv_pmos ad=0.42p pd=2.99u as=0.2114p ps=1.54u w=1.12u l=0.13u
X58 a_12980_6924# a_12567_7282# a_12912_6924# VPWR sg13_lv_pmos ad=0.191p pd=1.44u as=0.105p ps=1.21u w=1u l=0.13u
X59 VGND a_1402_3864# a_1121_4166# VGND sg13_lv_nmos ad=79.8f pd=0.8u as=0.1428p ps=1.52u w=0.42u l=0.5u
X60 a_9940_4636# a_9524_4972# a_9705_4650# VGND sg13_lv_nmos ad=77.7f pd=0.95u as=0.2516p ps=2.16u w=0.74u l=0.13u
X61 a_2732_1590# sg13cmos5l_buf_1_37.A VGND VGND sg13_lv_nmos ad=0.187p pd=1.78u as=0.14875p ps=1.16u w=0.55u l=0.13u
X62 a_11556_1944# a_12075_1748# a_12815_1703# VGND sg13_lv_nmos ad=0.3473p pd=2.71u as=0.12665p ps=1.145u w=0.74u l=0.13u
X63 a_2566_3151# sg13cmos5l_dfrbp_1_6.RESET_B VGND VGND sg13_lv_nmos ad=37.8f pd=0.6u as=0.1701p ps=1.65u w=0.42u l=0.13u
X64 VGND sg13cmos5l_buf_1_5.A sg13cmos5l_inv_1_27.Y VGND sg13_lv_nmos ad=0.2516p pd=2.16u as=0.2516p ps=2.16u w=0.74u l=0.13u
X65 a_11973_1605# sg13cmos5l_dfrbp_1_0.CLK VPWR VPWR sg13_lv_pmos ad=0.4088p pd=2.97u as=1.777p ps=11.395u w=1.12u l=0.13u
X66 a_3575_6553# a_2879_6432# a_3669_6320# VGND sg13_lv_nmos ad=0.1296p pd=1.52u as=79.8f ps=0.8u w=0.42u l=0.13u
X67 a_4652_6126# sg13cmos5l_buf_1_59.A VGND VGND sg13_lv_nmos ad=0.187p pd=1.78u as=0.14875p ps=1.16u w=0.55u l=0.13u
X68 a_5673_3138# a_5492_3460# VPWR VPWR sg13_lv_pmos ad=0.2128p pd=1.5u as=0.2387p ps=1.84u w=1.12u l=0.13u
X69 a_10224_9508# a_9673_9240# VPWR VPWR sg13_lv_pmos ad=0.105p pd=1.21u as=4.11675p ps=27.17u w=1u l=0.13u
X70 sg13cmos5l_dlhr_1_1.Q a_2409_4650# VGND VGND sg13_lv_nmos ad=0.2516p pd=2.16u as=0.1406p ps=1.12u w=0.74u l=0.13u
X71 VPWR sg13cmos5l_dlhr_1_0.D a_6889_1680# VPWR sg13_lv_pmos ad=1.86162p pd=11.935u as=0.2856p ps=2.36u w=0.84u l=0.13u
X72 a_19090_1626# sg13cmos5l_dfrbp_1_0.RESET_B VGND VGND sg13_lv_nmos ad=37.8f pd=0.6u as=79.8f ps=0.8u w=0.42u l=0.13u
X73 a_17493_3947# a_16551_3987# a_17354_4180# VGND sg13_lv_nmos ad=79.8f pd=0.8u as=0.2373p ps=1.97u w=0.42u l=0.13u
X74 a_5132_3864# sg13cmos5l_buf_1_44.A VGND VGND sg13_lv_nmos ad=0.187p pd=1.78u as=0.14875p ps=1.16u w=0.55u l=0.13u
X75 VGND VPWR VGND VGND sg13_lv_nmos ad=0.1428p pd=1.52u as=0 ps=0 w=0.42u l=1u
X76 VPWR sg13cmos5l_dfrbp_1_6.RESET_B a_2314_3361# VPWR sg13_lv_pmos ad=0.1563p pd=1.22u as=0.147p ps=1.54u w=0.42u l=0.13u
X77 sg13cmos5l_dlhr_1_16.Q a_19209_5769# VPWR VPWR sg13_lv_pmos ad=0.3808p pd=2.92u as=0.2128p ps=1.5u w=1.12u l=0.13u
X78 a_13701_3117# sg13cmos5l_dfrbp_1_0.CLK VPWR VPWR sg13_lv_pmos ad=0.4088p pd=2.97u as=1.38655p ps=8.8u w=1.12u l=0.13u
X79 a_1967_5773# a_1125_5423# a_1873_5773# VGND sg13_lv_nmos ad=0.12665p pd=1.145u as=0.1428p ps=1.52u w=0.42u l=0.13u
X80 a_14295_7282# sg13cmos5l_dfrbp_1_23.CLK VPWR VPWR sg13_lv_pmos ad=0.3234p pd=2.45u as=1.04815p ps=6.595u w=0.84u l=0.13u
X81 sg13cmos5l_dlhr_1_12.D a_16271_7751# VPWR VPWR sg13_lv_pmos ad=0.4312p pd=3.01u as=0.2639p ps=1.81u w=1.12u l=0.13u
X82 VPWR a_17327_7285# a_18164_6924# VPWR sg13_lv_pmos ad=0.2128p pd=1.5u as=0.3864p ps=2.93u w=1.12u l=0.13u
X83 VPWR a_15177_5769# a_15702_5842# VPWR sg13_lv_pmos ad=0.1974p pd=1.5u as=0.2856p ps=2.36u w=0.84u l=0.13u
X84 a_16748_9150# sg13cmos5l_buf_1_93.X VPWR VPWR sg13_lv_pmos ad=0.2856p pd=2.36u as=0.2114p ps=1.54u w=0.84u l=0.13u
X85 VPWR a_7689_1626# a_8214_1608# VPWR sg13_lv_pmos ad=0.1974p pd=1.5u as=0.2856p ps=2.36u w=0.84u l=0.13u
X86 a_13460_7996# a_13178_7684# a_13393_7666# VGND sg13_lv_nmos ad=0.141p pd=1.17u as=71.99999f ps=0.865u w=0.64u l=0.13u
X87 a_1402_3864# sg13cmos5l_dlygate4sd2_1_0.X VPWR VPWR sg13_lv_pmos ad=0.1428p pd=1.52u as=0.1523p ps=1.38u w=0.42u l=0.13u
X88 VPWR a_12716_8400# ph_sw[5] VPWR sg13_lv_pmos ad=0.2114p pd=1.54u as=0.42p ps=2.99u w=1.12u l=0.13u
X89 a_12324_6162# sg13cmos5l_buf_1_57.X a_12230_6162# VGND sg13_lv_nmos ad=60.89999f pd=0.71u as=0.1428p ps=1.52u w=0.42u l=0.13u
X90 a_6117_6141# sg13cmos5l_dlhr_1_5.GATE VPWR VPWR sg13_lv_pmos ad=0.4088p pd=2.97u as=1.04815p ps=6.595u w=1.12u l=0.13u
X91 VPWR sg13cmos5l_dfrbp_1_6.RESET_B a_8457_7281# VPWR sg13_lv_pmos ad=0.2128p pd=1.5u as=0.2128p ps=1.5u w=1.12u l=0.13u
X92 VGND a_12549_9165# a_12651_9308# VGND sg13_lv_nmos ad=2.92392p pd=18.89u as=0.2516p ps=2.16u w=0.74u l=0.13u
X93 VPWR a_18860_9150# ph_sw[8] VPWR sg13_lv_pmos ad=0.2114p pd=1.54u as=0.42p ps=2.99u w=1.12u l=0.13u
X94 VPWR sg13cmos5l_buf_1_96.A a_11464_8436# VPWR sg13_lv_pmos ad=0.2114p pd=1.54u as=0.2856p ps=2.36u w=0.84u l=0.13u
X95 sg13cmos5l_dfrbp_1_1.D sg13cmos5l_a22oi_1_2.B2 a_9823_2780# VGND sg13_lv_nmos ad=0.2664p pd=1.46u as=0.13875p ps=1.115u w=0.74u l=0.13u
X96 VPWR a_16751_2749# a_17588_2388# VPWR sg13_lv_pmos ad=0.2128p pd=1.5u as=0.3864p ps=2.93u w=1.12u l=0.13u
X97 sg13cmos5l_dlhr_1_0.D a_7316_2388# VGND VGND sg13_lv_nmos ad=0.2516p pd=2.16u as=0.1406p ps=1.12u w=0.74u l=0.13u
X98 a_2122_8404# a_2565_8447# a_1862_8874# VGND sg13_lv_nmos ad=79.8f pd=0.8u as=0.1296p ps=1.52u w=0.42u l=0.13u
X99 a_17367_8794# sg13cmos5l_dfrbp_1_22.D VPWR VPWR sg13_lv_pmos ad=0.3234p pd=2.45u as=1.12242p ps=7u w=0.84u l=0.13u
X100 sg13cmos5l_buf_1_25.A sg13cmos5l_inv_1_14.A VGND VGND sg13_lv_nmos ad=0.2516p pd=2.16u as=0.2516p ps=2.16u w=0.74u l=0.13u
X101 a_20204_5376# sg13cmos5l_dlhr_1_16.Q VPWR VPWR sg13_lv_pmos ad=0.2856p pd=2.36u as=0.2114p ps=1.54u w=0.84u l=0.13u
X102 VPWR rdy a_424_8436# VPWR sg13_lv_pmos ad=0.2114p pd=1.54u as=0.2856p ps=2.36u w=0.84u l=0.13u
X103 sg13cmos5l_buf_1_87.A a_18376_9224# VPWR VPWR sg13_lv_pmos ad=0.42p pd=2.99u as=0.2114p ps=1.54u w=1.12u l=0.13u
X104 a_6479_2749# a_5637_2399# a_6385_2749# VGND sg13_lv_nmos ad=0.12665p pd=1.145u as=0.1428p ps=1.52u w=0.42u l=0.13u
X105 a_7888_4870# a_7631_4727# a_8050_4650# VGND sg13_lv_nmos ad=0.1428p pd=1.52u as=37.8f ps=0.6u w=0.42u l=0.13u
X106 VGND a_2831_7630# a_2786_7666# VGND sg13_lv_nmos ad=1.49685p pd=9.6u as=71.99999f ps=0.865u w=0.64u l=0.13u
X107 frame a_20008_7712# VGND VGND sg13_lv_nmos ad=0.2886p pd=2.26u as=0.14875p ps=1.16u w=0.74u l=0.13u
X108 a_6598_4663# sg13cmos5l_dfrbp_1_8.RESET_B VGND VGND sg13_lv_nmos ad=37.8f pd=0.6u as=0.1701p ps=1.65u w=0.42u l=0.13u
X109 a_1125_6935# sg13cmos5l_dfrbp_1_15.D VGND VGND sg13_lv_nmos ad=0.2516p pd=2.16u as=1.49685p ps=9.6u w=0.74u l=0.13u
X110 a_20012_2352# sg13cmos5l_buf_1_0.X VPWR VPWR sg13_lv_pmos ad=0.2856p pd=2.36u as=0.2114p ps=1.54u w=0.84u l=0.13u
X111 a_8486_8874# a_9291_8447# a_8746_8404# VPWR sg13_lv_pmos ad=0.1428p pd=1.52u as=79.8f ps=0.8u w=0.42u l=0.13u
X112 VPWR a_15887_8797# a_16724_8436# VPWR sg13_lv_pmos ad=0.2128p pd=1.5u as=0.3864p ps=2.93u w=1.12u l=0.13u
X113 VGND comp_p a_424_1664# VGND sg13_lv_nmos ad=0.14875p pd=1.16u as=0.187p ps=1.78u w=0.55u l=0.13u
X114 VPWR a_3664_4142# a_3609_4023# VPWR sg13_lv_pmos ad=1.43437p pd=9.105u as=93.45f ps=0.865u w=0.42u l=0.13u
X115 nh_sw[1] a_2824_2388# VGND VGND sg13_lv_nmos ad=0.2886p pd=2.26u as=0.14875p ps=1.16u w=0.74u l=0.13u
X116 VPWR sg13cmos5l_dfrbp_1_0.RESET_B a_17414_3138# VPWR sg13_lv_pmos ad=0.36237p pd=2.605u as=79.8f ps=0.8u w=0.42u l=0.13u
X117 a_2122_3868# a_2565_3911# a_2505_3947# VPWR sg13_lv_pmos ad=79.8f pd=0.8u as=63f ps=0.72u w=0.42u l=0.13u
X118 VGND a_4460_9150# sg13cmos5l_buf_1_60.X VGND sg13_lv_nmos ad=0.14875p pd=1.16u as=0.2886p ps=2.26u w=0.74u l=0.13u
X119 a_11846_9186# sg13cmos5l_dlhr_1_11.GATE VPWR VPWR sg13_lv_pmos ad=79.8f pd=0.8u as=0.1428p ps=1.52u w=0.42u l=0.13u
X120 a_3801_3453# a_2859_3260# a_3599_3215# VPWR sg13_lv_pmos ad=93.45f pd=0.865u as=0.2048p ps=1.63u w=0.42u l=0.13u
X121 a_13234_4338# sg13cmos5l_dfrbp_1_0.RESET_B VGND VGND sg13_lv_nmos ad=37.8f pd=0.6u as=79.8f ps=0.8u w=0.42u l=0.13u
X122 a_17751_7690# sg13cmos5l_dfrbp_1_22.D VGND VGND sg13_lv_nmos ad=0.2516p pd=2.16u as=0.15055p ps=1.17u w=0.74u l=0.13u
X123 a_7316_3460# a_7034_3148# a_7249_3130# VGND sg13_lv_nmos ad=0.141p pd=1.17u as=71.99999f ps=0.865u w=0.64u l=0.13u
X124 sg13cmos5l_buf_1_116.A a_15177_5769# VPWR VPWR sg13_lv_pmos ad=0.3808p pd=2.92u as=0.2128p ps=1.5u w=1.12u l=0.13u
X125 VPWR sg13cmos5l_dfrbp_1_15.D a_2621_7636# VPWR sg13_lv_pmos ad=1.15047p pd=7.175u as=0.3234p ps=2.45u w=0.84u l=0.13u
X126 a_14928_5412# a_14377_5770# VPWR VPWR sg13_lv_pmos ad=0.105p pd=1.21u as=1.28962p ps=8.195u w=1u l=0.13u
X127 a_7247_8797# a_6405_8447# a_5988_8440# VPWR sg13_lv_pmos ad=0.2048p pd=1.63u as=0.34p ps=2.68u w=1u l=0.13u
X128 ph_sw[2] a_3976_9224# VGND VGND sg13_lv_nmos ad=0.2886p pd=2.26u as=0.14875p ps=1.16u w=0.74u l=0.13u
X129 a_18196_8824# a_17780_8436# a_17961_8793# VGND sg13_lv_nmos ad=77.7f pd=0.95u as=0.2516p ps=2.16u w=0.74u l=0.13u
X130 a_8204_2352# sg13cmos5l_dlhr_1_2.Q VGND VGND sg13_lv_nmos ad=0.187p pd=1.78u as=0.14875p ps=1.16u w=0.55u l=0.13u
X131 a_5104_4870# sg13cmos5l_dfrbp_1_8.RESET_B VPWR VPWR sg13_lv_pmos ad=79.8f pd=0.8u as=1.2517p ps=7.955u w=0.42u l=0.13u
X132 sg13cmos5l_buf_1_59.A a_4425_7281# VPWR VPWR sg13_lv_pmos ad=0.3808p pd=2.92u as=0.2128p ps=1.5u w=1.12u l=0.13u
X133 a_16485_6935# sg13cmos5l_inv_1_2.A VGND VGND sg13_lv_nmos ad=0.2516p pd=2.16u as=1.49685p ps=9.6u w=0.74u l=0.13u
X134 a_17392_4870# a_17135_4727# a_17554_4650# VGND sg13_lv_nmos ad=0.1428p pd=1.52u as=37.8f ps=0.6u w=0.42u l=0.13u
X135 a_18860_9150# sg13cmos5l_buf_1_101.X VPWR VPWR sg13_lv_pmos ad=0.2856p pd=2.36u as=0.2114p ps=1.54u w=0.84u l=0.13u
X136 sg13cmos5l_dfrbp_1_7.Q_N a_14543_3215# VGND VGND sg13_lv_nmos ad=0.2849p pd=2.25u as=0.2516p ps=2.16u w=0.74u l=0.13u
X137 a_3575_6553# sg13cmos5l_dfrbp_1_15.D a_4322_6162# VGND sg13_lv_nmos ad=0.1428p pd=1.52u as=60.89999f ps=0.71u w=0.42u l=0.13u
X138 VPWR sg13cmos5l_buf_1_5.A sg13cmos5l_inv_1_27.Y VPWR sg13_lv_pmos ad=0.3808p pd=2.92u as=0.3808p ps=2.92u w=1.12u l=0.13u
X139 a_7095_1642# sg13cmos5l_dlhr_1_0.GATE VGND VGND sg13_lv_nmos ad=0.2516p pd=2.16u as=0.15055p ps=1.17u w=0.74u l=0.13u
X140 a_2697_3529# a_2340_3456# VPWR VPWR sg13_lv_pmos ad=63f pd=0.72u as=0.1563p ps=1.22u w=0.42u l=0.13u
X141 VGND a_5104_4870# a_4753_4727# VGND sg13_lv_nmos ad=79.8f pd=0.8u as=0.1428p ps=1.52u w=0.42u l=0.13u
X142 sg13cmos5l_nor2_1_0.A a_13556_2388# VPWR VPWR sg13_lv_pmos ad=0.3808p pd=2.92u as=0.2128p ps=1.5u w=1.12u l=0.13u
X143 VGND sg13cmos5l_dfrbp_1_21.Q a_18409_5770# VGND sg13_lv_nmos ad=0.15055p pd=1.17u as=0.187p ps=1.78u w=0.55u l=0.13u
X144 a_13698_5412# sg13cmos5l_dfrbp_1_23.Q a_13486_5412# VPWR sg13_lv_pmos ad=0.2128p pd=1.5u as=0.2128p ps=1.5u w=1.12u l=0.13u
X145 a_19526_6600# a_19130_6172# a_19412_6484# VPWR sg13_lv_pmos ad=0.1008p pd=0.9u as=0.191p ps=1.44u w=0.42u l=0.13u
X146 VPWR a_17776_6382# a_17721_6477# VPWR sg13_lv_pmos ad=1.07253p pd=6.75u as=93.45f ps=0.865u w=0.42u l=0.13u
X147 VPWR a_16268_3102# nl_sw[8] VPWR sg13_lv_pmos ad=0.2114p pd=1.54u as=0.42p ps=2.99u w=1.12u l=0.13u
X148 VPWR a_6213_3911# a_6315_3911# VPWR sg13_lv_pmos ad=1.43437p pd=9.105u as=0.3864p ps=2.93u w=1.12u l=0.13u
X149 VGND sg13cmos5l_dfrbp_1_0.RESET_B a_11268_2826# VGND sg13_lv_nmos ad=0.1626p pd=1.415u as=60.89999f ps=0.71u w=0.42u l=0.13u
X150 VGND a_17493_3947# a_16572_4261# VGND sg13_lv_nmos ad=0.1626p pd=1.415u as=0.2516p ps=2.16u w=0.74u l=0.13u
X151 VGND sg13cmos5l_buf_1_65.X a_8488_9224# VGND sg13_lv_nmos ad=0.14875p pd=1.16u as=0.187p ps=1.78u w=0.55u l=0.13u
X152 a_708_6928# a_682_6892# VGND VGND sg13_lv_nmos ad=0.2516p pd=2.16u as=0.1626p ps=1.415u w=0.74u l=0.13u
X153 a_1948_7964# sg13cmos5l_dfrbp_1_6.RESET_B VPWR VPWR sg13_lv_pmos ad=0.2128p pd=1.5u as=0.2128p ps=1.5u w=1.12u l=0.13u
X154 a_19161_3453# a_18219_3260# a_18959_3215# VPWR sg13_lv_pmos ad=93.45f pd=0.865u as=0.2048p ps=1.63u w=0.42u l=0.13u
X155 VPWR a_4041_2745# a_3974_2388# VPWR sg13_lv_pmos ad=0.2387p pd=1.84u as=0.1008p ps=0.9u w=0.42u l=0.13u
X156 a_16260_6480# a_16779_6284# a_17519_6239# VGND sg13_lv_nmos ad=0.3473p pd=2.71u as=0.12665p ps=1.145u w=0.74u l=0.13u
X157 VGND a_1484_6126# sg13cmos5l_buf_1_40.A VGND sg13_lv_nmos ad=0.14875p pd=1.16u as=0.2886p ps=2.26u w=0.74u l=0.13u
X158 VGND sg13cmos5l_inv_1_3.A a_15016_9224# VGND sg13_lv_nmos ad=0.14875p pd=1.16u as=0.187p ps=1.78u w=0.55u l=0.13u
X159 VPWR a_18671_1703# a_18928_1846# VPWR sg13_lv_pmos ad=0.2639p pd=1.81u as=79.8f ps=0.8u w=0.42u l=0.13u
X160 VGND sg13cmos5l_dfrbp_1_8.RESET_B a_11940_9186# VGND sg13_lv_nmos ad=0.1626p pd=1.415u as=60.89999f ps=0.71u w=0.42u l=0.13u
X161 VPWR a_9033_6162# a_8966_6600# VPWR sg13_lv_pmos ad=0.2387p pd=1.84u as=0.1008p ps=0.9u w=0.42u l=0.13u
X162 a_12913_7326# a_12361_7282# VGND VGND sg13_lv_nmos ad=71.99999f pd=0.865u as=1.49685p ps=9.6u w=0.64u l=0.13u
X163 a_5508_2813# a_5220_2392# a_5446_2813# VGND sg13_lv_nmos ad=0.1428p pd=1.52u as=37.8f ps=0.6u w=0.42u l=0.13u
X164 VGND a_19593_6162# a_19548_6198# VGND sg13_lv_nmos ad=0.1428p pd=1.52u as=47.25f ps=0.645u w=0.42u l=0.13u
X165 a_18057_3529# a_17700_3456# VPWR VPWR sg13_lv_pmos ad=63f pd=0.72u as=0.1563p ps=1.22u w=0.42u l=0.13u
X166 VGND a_7631_4727# a_8468_4948# VGND sg13_lv_nmos ad=0.1406p pd=1.12u as=0.2516p ps=2.16u w=0.74u l=0.13u
X167 VPWR VGND VPWR VPWR sg13_lv_pmos ad=0.34p pd=2.68u as=0.43217n ps=2.29179m w=1u l=1u
X168 VPWR a_10473_9186# a_10998_9168# VPWR sg13_lv_pmos ad=0.1974p pd=1.5u as=0.2856p ps=2.36u w=0.84u l=0.13u
X169 a_17220_1626# sg13cmos5l_dfrbp_1_0.D a_17126_1626# VGND sg13_lv_nmos ad=60.89999f pd=0.71u as=0.1428p ps=1.52u w=0.42u l=0.13u
X170 VPWR a_620_7638# pl_sw[0] VPWR sg13_lv_pmos ad=0.2114p pd=1.54u as=0.42p ps=2.99u w=1.12u l=0.13u
X171 a_10665_8065# a_10308_7992# VPWR VPWR sg13_lv_pmos ad=63f pd=0.72u as=0.1563p ps=1.22u w=0.42u l=0.13u
X172 VPWR a_14800_3358# a_14745_3453# VPWR sg13_lv_pmos ad=1.43437p pd=9.105u as=93.45f ps=0.865u w=0.42u l=0.13u
X173 VGND sg13cmos5l_nor2_1_1.A a_15439_1630# VGND sg13_lv_nmos ad=0.14505p pd=1.15u as=0.1406p ps=1.12u w=0.74u l=0.13u
X174 a_2148_3138# sg13cmos5l_dfrbp_1_6.D a_2054_3138# VGND sg13_lv_nmos ad=60.89999f pd=0.71u as=0.1428p ps=1.52u w=0.42u l=0.13u
X175 a_3860_2388# a_3578_2752# a_3793_2790# VGND sg13_lv_nmos ad=0.141p pd=1.17u as=71.99999f ps=0.865u w=0.64u l=0.13u
X176 sg13cmos5l_dlygate4sd2_1_0.A sg13cmos5l_inv_1_8.Y VPWR VPWR sg13_lv_pmos ad=0.2128p pd=1.5u as=0.3808p ps=2.92u w=1.12u l=0.13u
X177 a_1065_5459# a_708_5416# VPWR VPWR sg13_lv_pmos ad=63f pd=0.72u as=0.1563p ps=1.22u w=0.42u l=0.13u
X178 VGND a_5132_9150# sg13cmos5l_buf_1_64.A VGND sg13_lv_nmos ad=0.14875p pd=1.16u as=0.2886p ps=2.26u w=0.74u l=0.13u
X179 a_1862_8874# a_2667_8447# a_2122_8404# VPWR sg13_lv_pmos ad=0.1428p pd=1.52u as=79.8f ps=0.8u w=0.42u l=0.13u
X180 a_13392_7996# a_12841_7728# VPWR VPWR sg13_lv_pmos ad=0.105p pd=1.21u as=1.15047p ps=7.175u w=1u l=0.13u
X181 VGND sg13cmos5l_dfrbp_1_6.RESET_B a_8692_7312# VGND sg13_lv_nmos ad=0.1406p pd=1.12u as=77.7f ps=0.95u w=0.74u l=0.13u
X182 a_13284_3456# a_13803_3260# a_14543_3215# VGND sg13_lv_nmos ad=0.3473p pd=2.71u as=0.12665p ps=1.145u w=0.74u l=0.13u
X183 sg13cmos5l_nand2_1_2.B sg13cmos5l_or2_1_0.A a_650_3900# VPWR sg13_lv_pmos ad=0.3808p pd=2.92u as=0.1176p ps=1.33u w=1.12u l=0.13u
X184 VGND a_4425_7281# a_4950_7354# VGND sg13_lv_nmos ad=0.1491p pd=1.18u as=0.187p ps=1.78u w=0.55u l=0.13u
X185 VPWR sg13cmos5l_dfrbp_1_0.RESET_B a_17386_1849# VPWR sg13_lv_pmos ad=0.1563p pd=1.22u as=0.147p ps=1.54u w=0.42u l=0.13u
X186 a_14628_8440# a_14602_8404# VPWR VPWR sg13_lv_pmos ad=0.34p pd=2.68u as=0.36237p ps=2.605u w=1u l=0.13u
X187 a_20492_8400# sg13cmos5l_buf_1_104.X VGND VGND sg13_lv_nmos ad=0.187p pd=1.78u as=0.14875p ps=1.16u w=0.55u l=0.13u
X188 a_13486_5412# sg13cmos5l_nor2b_1_0.Y VPWR VPWR sg13_lv_pmos ad=0.2128p pd=1.5u as=0.3808p ps=2.92u w=1.12u l=0.13u
X189 sg13cmos5l_dfrbp_1_6.D a_1672_3176# VGND VGND sg13_lv_nmos ad=0.2886p pd=2.26u as=0.14875p ps=1.16u w=0.74u l=0.13u
X190 sg13cmos5l_buf_1_98.A a_13641_7674# VPWR VPWR sg13_lv_pmos ad=0.3808p pd=2.92u as=0.2128p ps=1.5u w=1.12u l=0.13u
X191 VPWR a_1997_6126# sg13cmos5l_dfrbp_1_15.Q_N VPWR sg13_lv_pmos ad=0.2639p pd=1.81u as=0.4312p ps=3.01u w=1.12u l=0.13u
X192 d_out[1] a_20008_3900# VPWR VPWR sg13_lv_pmos ad=0.42p pd=2.99u as=0.2114p ps=1.54u w=1.12u l=0.13u
X193 VPWR a_4950_5699# sg13cmos5l_dlhr_1_5.GATE VPWR sg13_lv_pmos ad=0.2128p pd=1.5u as=0.3808p ps=2.92u w=1.12u l=0.13u
X194 a_6572_1590# sg13cmos5l_buf_1_24.A VPWR VPWR sg13_lv_pmos ad=0.2856p pd=2.36u as=0.2114p ps=1.54u w=0.84u l=0.13u
X195 a_8966_6600# a_8570_6172# a_8852_6484# VPWR sg13_lv_pmos ad=0.1008p pd=0.9u as=0.191p ps=1.44u w=0.42u l=0.13u
X196 sg13cmos5l_buf_1_97.A a_10473_9186# VGND VGND sg13_lv_nmos ad=0.2516p pd=2.16u as=0.1406p ps=1.12u w=0.74u l=0.13u
X197 a_10331_1924# sg13cmos5l_nand2_1_1.B sg13cmos5l_a22oi_1_2.B1 VPWR sg13_lv_pmos ad=0.2128p pd=1.5u as=0.3808p ps=2.92u w=1.12u l=0.13u
X198 VGND sg13cmos5l_dfrbp_1_6.RESET_B a_516_5850# VGND sg13_lv_nmos ad=0.1626p pd=1.415u as=60.89999f ps=0.71u w=0.42u l=0.13u
X199 sg13cmos5l_a221oi_1_0.A2 a_7892_3900# VPWR VPWR sg13_lv_pmos ad=0.3808p pd=2.92u as=0.2128p ps=1.5u w=1.12u l=0.13u
X200 a_18300_7710# a_17751_7690# a_18164_7996# VGND sg13_lv_nmos ad=47.25f pd=0.645u as=0.141p ps=1.17u w=0.42u l=0.13u
X201 VPWR sg13cmos5l_dfrbp_1_8.RESET_B a_14602_8404# VPWR sg13_lv_pmos ad=0.1563p pd=1.22u as=0.147p ps=1.54u w=0.42u l=0.13u
X202 sg13cmos5l_dfrbp_1_1.Q a_13652_1924# VGND VGND sg13_lv_nmos ad=0.2516p pd=2.16u as=0.1406p ps=1.12u w=0.74u l=0.13u
X203 sg13cmos5l_a221oi_1_0.C1 sg13cmos5l_inv_1_0.A VGND VGND sg13_lv_nmos ad=0.1406p pd=1.12u as=0.2516p ps=2.16u w=0.74u l=0.13u
X204 VPWR a_8972_9150# sg13cmos5l_buf_1_77.X VPWR sg13_lv_pmos ad=0.2114p pd=1.54u as=0.42p ps=2.99u w=1.12u l=0.13u
X205 VPWR sg13cmos5l_dfrbp_1_6.RESET_B a_422_7362# VPWR sg13_lv_pmos ad=0.36237p pd=2.605u as=79.8f ps=0.8u w=0.42u l=0.13u
X206 VGND a_11372_3102# nh_sw[5] VGND sg13_lv_nmos ad=0.14875p pd=1.16u as=0.2886p ps=2.26u w=0.74u l=0.13u
X207 a_11530_3868# a_11973_3911# a_11270_4338# VGND sg13_lv_nmos ad=79.8f pd=0.8u as=0.1296p ps=1.52u w=0.42u l=0.13u
X208 a_2161_4642# a_1609_4704# VGND VGND sg13_lv_nmos ad=71.99999f pd=0.865u as=2.41737p ps=15.64u w=0.64u l=0.13u
X209 VPWR sg13cmos5l_a22oi_1_1.A1 a_14814_3876# VPWR sg13_lv_pmos ad=0.3808p pd=2.92u as=0.2716p ps=1.605u w=1.12u l=0.13u
X210 VPWR a_10412_6126# sg13cmos5l_buf_1_29.A VPWR sg13_lv_pmos ad=0.2114p pd=1.54u as=0.42p ps=2.99u w=1.12u l=0.13u
X211 VPWR sg13cmos5l_dfrbp_1_0.RESET_B a_15466_2356# VPWR sg13_lv_pmos ad=0.1563p pd=1.22u as=0.147p ps=1.54u w=0.42u l=0.13u
X212 VPWR VGND VPWR VPWR sg13_lv_pmos ad=0.34p pd=2.68u as=0 ps=0 w=1u l=1u
X213 a_6188_1590# sg13cmos5l_buf_1_25.A VGND VGND sg13_lv_nmos ad=0.187p pd=1.78u as=0.14875p ps=1.16u w=0.55u l=0.13u
X214 sg13cmos5l_dlhr_1_11.Q_N a_13686_7354# VPWR VPWR sg13_lv_pmos ad=0.3808p pd=2.92u as=0.1974p ps=1.5u w=1.12u l=0.13u
X215 a_16425_6971# a_16068_6928# VPWR VPWR sg13_lv_pmos ad=63f pd=0.72u as=0.1563p ps=1.22u w=0.42u l=0.13u
X216 sg13cmos5l_nand2_1_1.A a_15380_3436# VGND VGND sg13_lv_nmos ad=0.2516p pd=2.16u as=0.1406p ps=1.12u w=0.74u l=0.13u
X217 sg13cmos5l_inv_1_2.A a_8488_9224# VPWR VPWR sg13_lv_pmos ad=0.42p pd=2.99u as=0.2114p ps=1.54u w=1.12u l=0.13u
X218 a_9040_7894# a_8783_7751# a_9202_7674# VGND sg13_lv_nmos ad=0.1428p pd=1.52u as=37.8f ps=0.6u w=0.42u l=0.13u
X219 VPWR a_7631_4727# a_7888_4870# VPWR sg13_lv_pmos ad=0.2639p pd=1.81u as=79.8f ps=0.8u w=0.42u l=0.13u
X220 a_2374_4325# sg13cmos5l_dfrbp_1_8.RESET_B VGND VGND sg13_lv_nmos ad=37.8f pd=0.6u as=0.1701p ps=1.65u w=0.42u l=0.13u
X221 a_3831_7282# sg13cmos5l_dfrbp_1_15.D VGND VGND sg13_lv_nmos ad=0.2516p pd=2.16u as=0.15055p ps=1.17u w=0.74u l=0.13u
X222 a_10598_6924# a_10202_7288# a_10484_6924# VPWR sg13_lv_pmos ad=0.1008p pd=0.9u as=0.191p ps=1.44u w=0.42u l=0.13u
X223 a_7750_7687# sg13cmos5l_dfrbp_1_6.RESET_B VGND VGND sg13_lv_nmos ad=37.8f pd=0.6u as=0.1701p ps=1.65u w=0.42u l=0.13u
X224 d_out[0] a_20392_2388# VPWR VPWR sg13_lv_pmos ad=0.42p pd=2.99u as=0.2114p ps=1.54u w=1.12u l=0.13u
X225 VGND sg13cmos5l_dfrbp_1_20.Q_N a_9673_9240# VGND sg13_lv_nmos ad=0.15055p pd=1.17u as=0.187p ps=1.78u w=0.55u l=0.13u
X226 a_8412_7326# a_7863_7282# a_8276_6924# VGND sg13_lv_nmos ad=47.25f pd=0.645u as=0.141p ps=1.17u w=0.42u l=0.13u
X227 sg13cmos5l_buf_1_94.X a_15016_9224# VPWR VPWR sg13_lv_pmos ad=0.42p pd=2.99u as=0.2114p ps=1.54u w=1.12u l=0.13u
X228 VPWR a_6380_7638# pl_sw[3] VPWR sg13_lv_pmos ad=0.2114p pd=1.54u as=0.42p ps=2.99u w=1.12u l=0.13u
X229 VPWR a_17493_3947# a_16572_4261# VPWR sg13_lv_pmos ad=0.36237p pd=2.605u as=0.34p ps=2.68u w=1u l=0.13u
X230 a_11364_4338# sg13cmos5l_dfrbp_1_2.D a_11270_4338# VGND sg13_lv_nmos ad=60.89999f pd=0.71u as=0.1428p ps=1.52u w=0.42u l=0.13u
X231 VPWR a_13484_8400# sg13cmos5l_buf_1_5.A VPWR sg13_lv_pmos ad=0.2114p pd=1.54u as=0.42p ps=2.99u w=1.12u l=0.13u
X232 a_2638_6162# a_2380_6162# VGND VGND sg13_lv_nmos ad=0.1428p pd=1.52u as=79.8f ps=0.8u w=0.42u l=0.13u
X233 sg13cmos5l_dlhr_1_10.Q_N a_20118_6144# VPWR VPWR sg13_lv_pmos ad=0.3808p pd=2.92u as=0.1974p ps=1.5u w=1.12u l=0.13u
X234 a_11460_2392# a_11434_2356# VPWR VPWR sg13_lv_pmos ad=0.34p pd=2.68u as=0.36237p ps=2.605u w=1u l=0.13u
X235 sg13cmos5l_buf_1_59.A a_4425_7281# VGND VGND sg13_lv_nmos ad=0.2516p pd=2.16u as=0.1406p ps=1.12u w=0.74u l=0.13u
X236 VPWR sg13cmos5l_inv_1_29.Y a_11771_5412# VPWR sg13_lv_pmos ad=0.2128p pd=1.5u as=0.2128p ps=1.5u w=1.12u l=0.13u
X237 VPWR a_18959_3215# a_19796_3436# VPWR sg13_lv_pmos ad=0.2128p pd=1.5u as=0.3864p ps=2.93u w=1.12u l=0.13u
X238 VGND sg13cmos5l_buf_1_24.X a_5704_1664# VGND sg13_lv_nmos ad=0.14875p pd=1.16u as=0.187p ps=1.78u w=0.55u l=0.13u
X239 a_10433_4248# sg13cmos5l_dfrbp_1_10.Q sg13cmos5l_a22oi_1_1.B1 VGND sg13_lv_nmos ad=0.1406p pd=1.12u as=0.1406p ps=1.12u w=0.74u l=0.13u
X240 a_2436_4325# a_2667_3911# a_2122_3868# VGND sg13_lv_nmos ad=0.2373p pd=1.97u as=79.8f ps=0.8u w=0.42u l=0.13u
X241 VGND sg13cmos5l_buf_1_34.X sg13cmos5l_buf_1_60.A VGND sg13_lv_nmos ad=0.2516p pd=2.16u as=0.2516p ps=2.16u w=0.74u l=0.13u
X242 a_10484_6924# a_10202_7288# a_10417_7326# VGND sg13_lv_nmos ad=0.141p pd=1.17u as=71.99999f ps=0.865u w=0.64u l=0.13u
X243 VGND VPWR VGND VGND sg13_lv_nmos ad=0.1428p pd=1.52u as=0 ps=0 w=0.42u l=1u
X244 a_4559_7630# sg13cmos5l_dlhr_1_9.D VPWR VPWR sg13_lv_pmos ad=0.2856p pd=2.36u as=1.15047p ps=7.175u w=0.84u l=0.13u
X245 VPWR sg13cmos5l_dfrbp_1_6.RESET_B a_12230_6162# VPWR sg13_lv_pmos ad=0.36237p pd=2.605u as=79.8f ps=0.8u w=0.42u l=0.13u
X246 a_18117_3117# sg13cmos5l_dfrbp_1_0.CLK VGND VGND sg13_lv_nmos ad=0.2516p pd=2.16u as=2.43055p ps=15.415u w=0.74u l=0.13u
X247 VGND sg13cmos5l_dfrbp_1_6.RESET_B a_7732_3124# VGND sg13_lv_nmos ad=0.1406p pd=1.12u as=77.7f ps=0.95u w=0.74u l=0.13u
X248 VPWR a_2224_5654# a_2169_5535# VPWR sg13_lv_pmos ad=1.28962p pd=8.195u as=93.45f ps=0.865u w=0.42u l=0.13u
X249 VGND sg13cmos5l_buf_1_61.X a_1000_9224# VGND sg13_lv_nmos ad=0.14875p pd=1.16u as=0.187p ps=1.78u w=0.55u l=0.13u
X250 a_13017_4023# a_12075_3911# a_12815_4261# VPWR sg13_lv_pmos ad=93.45f pd=0.865u as=0.2048p ps=1.63u w=0.42u l=0.13u
X251 VPWR a_17135_4727# a_17392_4870# VPWR sg13_lv_pmos ad=0.2639p pd=1.81u as=79.8f ps=0.8u w=0.42u l=0.13u
X252 sg13cmos5l_buf_1_111.A a_19240_7712# VGND VGND sg13_lv_nmos ad=0.2886p pd=2.26u as=0.14875p ps=1.16u w=0.74u l=0.13u
X253 VPWR sg13cmos5l_inv_1_6.A a_20008_8436# VPWR sg13_lv_pmos ad=0.2114p pd=1.54u as=0.2856p ps=2.36u w=0.84u l=0.13u
X254 a_4172_1590# sg13cmos5l_buf_1_38.A VGND VGND sg13_lv_nmos ad=0.187p pd=1.78u as=0.14875p ps=1.16u w=0.55u l=0.13u
X255 VGND a_9879_9202# a_10010_9196# VGND sg13_lv_nmos ad=2.92392p pd=18.89u as=0.2775p ps=2.23u w=0.74u l=0.13u
X256 a_7474_4338# sg13cmos5l_dfrbp_1_6.RESET_B VGND VGND sg13_lv_nmos ad=37.8f pd=0.6u as=79.8f ps=0.8u w=0.42u l=0.13u
X257 sg13cmos5l_dlhr_1_5.D a_6959_6239# VGND VGND sg13_lv_nmos ad=0.2849p pd=2.25u as=0.2516p ps=2.16u w=0.74u l=0.13u
X258 a_8593_5814# a_8041_5770# VGND VGND sg13_lv_nmos ad=71.99999f pd=0.865u as=1.97045p ps=12.335u w=0.64u l=0.13u
X259 a_11877_2399# sg13cmos5l_dfrbp_1_0.CLK VGND VGND sg13_lv_nmos ad=0.2516p pd=2.16u as=2.43055p ps=15.415u w=0.74u l=0.13u
X260 a_17554_4650# sg13cmos5l_dfrbp_1_8.RESET_B VGND VGND sg13_lv_nmos ad=37.8f pd=0.6u as=79.8f ps=0.8u w=0.42u l=0.13u
X261 a_17132_9150# sg13cmos5l_buf_1_94.X VGND VGND sg13_lv_nmos ad=0.187p pd=1.78u as=0.14875p ps=1.16u w=0.55u l=0.13u
X262 VPWR sg13cmos5l_buf_1_19.A a_18760_2388# VPWR sg13_lv_pmos ad=0.2114p pd=1.54u as=0.2856p ps=2.36u w=0.84u l=0.13u
X263 a_5674_6385# a_6117_6141# a_6057_6553# VPWR sg13_lv_pmos ad=79.8f pd=0.8u as=63f ps=0.72u w=0.42u l=0.13u
X264 VPWR sg13cmos5l_buf_1_98.A a_13768_8436# VPWR sg13_lv_pmos ad=0.2114p pd=1.54u as=0.2856p ps=2.36u w=0.84u l=0.13u
X265 sg13cmos5l_dlhr_1_5.Q_N a_8982_7354# VPWR VPWR sg13_lv_pmos ad=0.3808p pd=2.92u as=0.1974p ps=1.5u w=1.12u l=0.13u
X266 a_17700_3456# a_17674_3361# VPWR VPWR sg13_lv_pmos ad=0.34p pd=2.68u as=0.36237p ps=2.605u w=1u l=0.13u
X267 a_10220_3102# sg13cmos5l_buf_1_28.X VPWR VPWR sg13_lv_pmos ad=0.2856p pd=2.36u as=0.2114p ps=1.54u w=0.84u l=0.13u
X268 sg13cmos5l_a22oi_1_1.Y sg13cmos5l_a22oi_1_1.B2 a_14814_3876# VPWR sg13_lv_pmos ad=0.2128p pd=1.5u as=0.2744p ps=1.61u w=1.12u l=0.13u
X269 a_8660_5412# a_8247_5770# a_8592_5412# VPWR sg13_lv_pmos ad=0.191p pd=1.44u as=0.105p ps=1.21u w=1u l=0.13u
X270 a_8796_5814# a_8247_5770# a_8660_5412# VGND sg13_lv_nmos ad=47.25f pd=0.645u as=0.141p ps=1.17u w=0.42u l=0.13u
X271 VGND a_17961_8793# a_18486_8866# VGND sg13_lv_nmos ad=0.1491p pd=1.18u as=0.187p ps=1.78u w=0.55u l=0.13u
X272 VPWR sg13cmos5l_inv_1_29.A a_12841_7728# VPWR sg13_lv_pmos ad=1.15047p pd=7.175u as=0.2856p ps=2.36u w=0.84u l=0.13u
X273 VPWR a_13641_7674# a_13574_8112# VPWR sg13_lv_pmos ad=0.2387p pd=1.84u as=0.1008p ps=0.9u w=0.42u l=0.13u
X274 VPWR a_19593_6162# a_20118_6144# VPWR sg13_lv_pmos ad=0.1974p pd=1.5u as=0.2856p ps=2.36u w=0.84u l=0.13u
X275 a_10028_6126# sg13cmos5l_buf_1_56.A VGND VGND sg13_lv_nmos ad=0.187p pd=1.78u as=0.14875p ps=1.16u w=0.55u l=0.13u
X276 VGND sg13cmos5l_buf_1_33.A a_2248_1664# VGND sg13_lv_nmos ad=0.14875p pd=1.16u as=0.187p ps=1.78u w=0.55u l=0.13u
X277 VGND sg13cmos5l_buf_8_1.A a_18363_4270# VGND sg13_lv_nmos ad=0.1406p pd=1.12u as=0.2553p ps=2.17u w=0.74u l=0.13u
X278 VGND a_13076_5376# sg13cmos5l_or2_1_1.B VGND sg13_lv_nmos ad=0.17255p pd=1.25u as=0.1406p ps=1.12u w=0.74u l=0.13u
X279 sg13cmos5l_dfrbp_1_21.Q a_18356_6460# VGND VGND sg13_lv_nmos ad=0.2516p pd=2.16u as=0.1406p ps=1.12u w=0.74u l=0.13u
X280 a_13161_7281# a_12980_6924# VPWR VPWR sg13_lv_pmos ad=0.2128p pd=1.5u as=0.2387p ps=1.84u w=1.12u l=0.13u
X281 a_7820_2352# sg13cmos5l_dlhr_1_0.Q VGND VGND sg13_lv_nmos ad=0.187p pd=1.78u as=0.14875p ps=1.16u w=0.55u l=0.13u
X282 VPWR sg13cmos5l_dlhr_1_6.D a_8233_6216# VPWR sg13_lv_pmos ad=1.07253p pd=6.75u as=0.2856p ps=2.36u w=0.84u l=0.13u
X283 a_3302_4650# sg13cmos5l_dfrbp_1_9.Q VPWR VPWR sg13_lv_pmos ad=79.8f pd=0.8u as=0.1428p ps=1.52u w=0.42u l=0.13u
X284 sg13cmos5l_o21ai_1_0.A2 sg13cmos5l_nand2_1_0.B VPWR VPWR sg13_lv_pmos ad=0.2128p pd=1.5u as=0.3808p ps=2.92u w=1.12u l=0.13u
X285 VPWR a_15884_3102# nh_sw[7] VPWR sg13_lv_pmos ad=0.2114p pd=1.54u as=0.42p ps=2.99u w=1.12u l=0.13u
X286 a_12106_9409# a_12549_9165# a_11846_9186# VGND sg13_lv_nmos ad=79.8f pd=0.8u as=0.1296p ps=1.52u w=0.42u l=0.13u
X287 a_8985_7989# a_8043_7796# a_8783_7751# VPWR sg13_lv_pmos ad=93.45f pd=0.865u as=0.2048p ps=1.63u w=0.42u l=0.13u
X288 a_4177_7326# a_3625_7282# VGND VGND sg13_lv_nmos ad=71.99999f pd=0.865u as=1.49685p ps=9.6u w=0.64u l=0.13u
X289 VPWR a_12815_4261# a_13072_4142# VPWR sg13_lv_pmos ad=0.2639p pd=1.81u as=79.8f ps=0.8u w=0.42u l=0.13u
X290 VGND a_6903_3154# a_7034_3148# VGND sg13_lv_nmos ad=2.59257p pd=16.445u as=0.2775p ps=2.23u w=0.74u l=0.13u
X291 a_18117_3117# sg13cmos5l_dfrbp_1_0.CLK VPWR VPWR sg13_lv_pmos ad=0.4088p pd=2.97u as=1.38655p ps=8.8u w=1.12u l=0.13u
X292 VPWR sg13cmos5l_buf_1_28.A a_9448_1664# VPWR sg13_lv_pmos ad=0.2114p pd=1.54u as=0.2856p ps=2.36u w=0.84u l=0.13u
X293 a_17584_7166# sg13cmos5l_dfrbp_1_8.RESET_B VPWR VPWR sg13_lv_pmos ad=79.8f pd=0.8u as=1.04815p ps=6.595u w=0.42u l=0.13u
X294 VPWR sg13cmos5l_buf_1_86.A a_20392_6924# VPWR sg13_lv_pmos ad=0.2114p pd=1.54u as=0.2856p ps=2.36u w=0.84u l=0.13u
X295 a_17519_6239# a_16677_6141# a_16260_6480# VPWR sg13_lv_pmos ad=0.2048p pd=1.63u as=0.34p ps=2.68u w=1u l=0.13u
X296 a_996_5837# a_708_5416# a_934_5837# VGND sg13_lv_nmos ad=0.1428p pd=1.52u as=37.8f ps=0.6u w=0.42u l=0.13u
X297 VPWR VGND VPWR VPWR sg13_lv_pmos ad=0.19p pd=1.38u as=0 ps=0 w=1u l=1u
X298 VPWR sg13cmos5l_inv_1_8.A a_2879_6432# VPWR sg13_lv_pmos ad=1.07253p pd=6.75u as=0.4088p ps=2.97u w=1.12u l=0.13u
X299 a_2054_3138# a_2859_3260# a_2314_3361# VPWR sg13_lv_pmos ad=0.1428p pd=1.52u as=79.8f ps=0.8u w=0.42u l=0.13u
X300 VPWR a_1484_9150# sg13cmos5l_buf_1_68.X VPWR sg13_lv_pmos ad=0.2114p pd=1.54u as=0.42p ps=2.99u w=1.12u l=0.13u
X301 VPWR sg13cmos5l_dfrbp_1_0.RESET_B a_17126_1626# VPWR sg13_lv_pmos ad=0.36237p pd=2.605u as=79.8f ps=0.8u w=0.42u l=0.13u
X302 sg13cmos5l_dfrbp_1_0.D sg13cmos5l_nor2_1_1.A VGND VGND sg13_lv_nmos ad=0.1406p pd=1.12u as=0.2516p ps=2.16u w=0.74u l=0.13u
X303 VPWR sg13cmos5l_buf_1_78.A a_6184_9224# VPWR sg13_lv_pmos ad=0.2114p pd=1.54u as=0.2856p ps=2.36u w=0.84u l=0.13u
X304 a_5194_2356# a_5637_2399# a_5577_2435# VPWR sg13_lv_pmos ad=79.8f pd=0.8u as=63f ps=0.72u w=0.42u l=0.13u
X305 a_14543_3215# a_13701_3117# a_14449_3215# VGND sg13_lv_nmos ad=0.12665p pd=1.145u as=0.1428p ps=1.52u w=0.42u l=0.13u
X306 VGND a_12719_2749# a_13556_2388# VGND sg13_lv_nmos ad=0.1406p pd=1.12u as=0.2516p ps=2.16u w=0.74u l=0.13u
X307 VPWR sg13cmos5l_dfrbp_1_6.RESET_B a_2054_3138# VPWR sg13_lv_pmos ad=0.36237p pd=2.605u as=79.8f ps=0.8u w=0.42u l=0.13u
X308 sg13cmos5l_buf_8_0.X a_19227_4654# VGND VGND sg13_lv_nmos ad=0.1406p pd=1.12u as=0.1406p ps=1.12u w=0.74u l=0.13u
X309 a_3945_5041# a_3588_4968# VPWR VPWR sg13_lv_pmos ad=63f pd=0.72u as=0.1563p ps=1.22u w=0.42u l=0.13u
X310 pl_sw[1] a_1000_9224# VPWR VPWR sg13_lv_pmos ad=0.42p pd=2.99u as=0.2114p ps=1.54u w=1.12u l=0.13u
X311 a_3407_8797# a_2565_8447# a_2148_8440# VPWR sg13_lv_pmos ad=0.2048p pd=1.63u as=0.34p ps=2.68u w=1u l=0.13u
X312 a_12815_1703# a_11973_1605# a_11556_1944# VPWR sg13_lv_pmos ad=0.2048p pd=1.63u as=0.34p ps=2.68u w=1u l=0.13u
X313 VGND sg13cmos5l_dlygate4sd3_1_0.X sg13cmos5l_buf_1_43.A VGND sg13_lv_nmos ad=0.2516p pd=2.16u as=0.2516p ps=2.16u w=0.74u l=0.13u
X314 sg13cmos5l_buf_1_6.A a_12520_3176# VGND VGND sg13_lv_nmos ad=0.2886p pd=2.26u as=0.14875p ps=1.16u w=0.74u l=0.13u
X315 a_15876_4968# a_15850_4873# VGND VGND sg13_lv_nmos ad=0.2516p pd=2.16u as=0.1626p ps=1.415u w=0.74u l=0.13u
X316 ph_sw[0] a_616_9224# VGND VGND sg13_lv_nmos ad=0.2886p pd=2.26u as=0.14875p ps=1.16u w=0.74u l=0.13u
X317 a_11846_9186# a_12651_9308# a_12106_9409# VPWR sg13_lv_pmos ad=0.1428p pd=1.52u as=79.8f ps=0.8u w=0.42u l=0.13u
X318 VPWR a_4559_7630# a_4518_7996# VPWR sg13_lv_pmos ad=1.15047p pd=7.175u as=0.105p ps=1.21u w=1u l=0.13u
X319 a_1948_7964# a_2348_7624# a_2306_7660# VGND sg13_lv_nmos ad=0.2516p pd=2.16u as=77.7f ps=0.95u w=0.74u l=0.13u
X320 a_15124_7312# a_14708_6924# a_14889_7281# VGND sg13_lv_nmos ad=77.7f pd=0.95u as=0.2516p ps=2.16u w=0.74u l=0.13u
X321 VGND a_3308_9150# sg13cmos5l_inv_1_8.A VGND sg13_lv_nmos ad=0.14875p pd=1.16u as=0.2886p ps=2.26u w=0.74u l=0.13u
X322 a_15821_3864# a_16551_3987# a_16572_4261# VGND sg13_lv_nmos ad=0.12665p pd=1.145u as=0.3473p ps=2.71u w=0.74u l=0.13u
X323 a_12804_6175# a_12516_6480# a_12742_6175# VGND sg13_lv_nmos ad=0.1428p pd=1.52u as=37.8f ps=0.6u w=0.42u l=0.13u
X324 a_8208_6924# a_7657_7282# VPWR VPWR sg13_lv_pmos ad=0.105p pd=1.21u as=1.07253p ps=6.75u w=1u l=0.13u
X325 VGND sg13cmos5l_buf_1_5.A a_14440_1664# VGND sg13_lv_nmos ad=0.14875p pd=1.16u as=0.187p ps=1.78u w=0.55u l=0.13u
X326 sg13cmos5l_a22oi_1_0.Y sg13cmos5l_a22oi_1_0.B1 a_10783_3876# VPWR sg13_lv_pmos ad=0.2128p pd=1.5u as=0.2716p ps=1.605u w=1.12u l=0.13u
X327 a_13648_9406# a_13391_9263# a_13810_9186# VGND sg13_lv_nmos ad=0.1428p pd=1.52u as=37.8f ps=0.6u w=0.42u l=0.13u
X328 sg13cmos5l_buf_1_103.A a_15784_9224# VGND VGND sg13_lv_nmos ad=0.2886p pd=2.26u as=0.14875p ps=1.16u w=0.74u l=0.13u
X329 a_17414_3138# a_18219_3260# a_17674_3361# VPWR sg13_lv_pmos ad=0.1428p pd=1.52u as=79.8f ps=0.8u w=0.42u l=0.13u
X330 sg13cmos5l_dlhr_1_6.D a_7796_6460# VGND VGND sg13_lv_nmos ad=0.2516p pd=2.16u as=0.1406p ps=1.12u w=0.74u l=0.13u
X331 VGND VPWR VGND VGND sg13_lv_nmos ad=79.8f pd=0.8u as=0 ps=0 w=0.42u l=1u
X332 a_6959_6239# a_6117_6141# a_6865_6239# VGND sg13_lv_nmos ad=0.12665p pd=1.145u as=0.1428p ps=1.52u w=0.42u l=0.13u
X333 VGND a_1580_2352# nh_sw[0] VGND sg13_lv_nmos ad=0.14875p pd=1.16u as=0.2886p ps=2.26u w=0.74u l=0.13u
X334 a_7238_7674# a_8043_7796# a_7498_7897# VPWR sg13_lv_pmos ad=0.1428p pd=1.52u as=79.8f ps=0.8u w=0.42u l=0.13u
X335 a_14543_3215# a_13701_3117# a_13284_3456# VPWR sg13_lv_pmos ad=0.2048p pd=1.63u as=0.34p ps=2.68u w=1u l=0.13u
X336 a_19412_6484# a_18999_6178# a_19344_6484# VPWR sg13_lv_pmos ad=0.191p pd=1.44u as=0.105p ps=1.21u w=1u l=0.13u
X337 sg13cmos5l_dlhr_1_15.Q a_18345_7674# VGND VGND sg13_lv_nmos ad=0.2516p pd=2.16u as=0.1406p ps=1.12u w=0.74u l=0.13u
X338 VPWR a_4652_6126# sg13cmos5l_inv_1_19.A VPWR sg13_lv_pmos ad=0.2114p pd=1.54u as=0.42p ps=2.99u w=1.12u l=0.13u
X339 VGND sg13cmos5l_dfrbp_1_6.RESET_B a_13396_7312# VGND sg13_lv_nmos ad=0.1406p pd=1.12u as=77.7f ps=0.95u w=0.74u l=0.13u
X340 VPWR a_8588_2352# nl_sw[4] VPWR sg13_lv_pmos ad=0.2114p pd=1.54u as=0.42p ps=2.99u w=1.12u l=0.13u
X341 a_15466_2356# a_15909_2399# a_15206_2826# VGND sg13_lv_nmos ad=79.8f pd=0.8u as=0.1296p ps=1.52u w=0.42u l=0.13u
X342 a_16102_4663# sg13cmos5l_dfrbp_1_8.RESET_B VGND VGND sg13_lv_nmos ad=37.8f pd=0.6u as=0.1701p ps=1.65u w=0.42u l=0.13u
X343 VPWR VGND VPWR VPWR sg13_lv_pmos ad=0.19p pd=1.38u as=0 ps=0 w=1u l=1u
X344 a_2409_4650# a_2228_4972# VPWR VPWR sg13_lv_pmos ad=0.2128p pd=1.5u as=0.2387p ps=1.84u w=1.12u l=0.13u
X345 a_13017_1941# a_12075_1748# a_12815_1703# VPWR sg13_lv_pmos ad=93.45f pd=0.865u as=0.2048p ps=1.63u w=0.42u l=0.13u
X346 a_9040_7894# sg13cmos5l_dfrbp_1_6.RESET_B VPWR VPWR sg13_lv_pmos ad=79.8f pd=0.8u as=1.12242p ps=7u w=0.42u l=0.13u
X347 a_13047_7690# sg13cmos5l_dlhr_1_11.GATE VGND VGND sg13_lv_nmos ad=0.2516p pd=2.16u as=0.15055p ps=1.17u w=0.74u l=0.13u
X348 sg13cmos5l_buf_1_2.X a_15784_1664# VPWR VPWR sg13_lv_pmos ad=0.42p pd=2.99u as=0.2114p ps=1.54u w=1.12u l=0.13u
X349 a_9524_4972# a_9242_4660# a_9457_4642# VGND sg13_lv_nmos ad=0.141p pd=1.17u as=71.99999f ps=0.865u w=0.64u l=0.13u
X350 VGND VPWR VGND VGND sg13_lv_nmos ad=79.8f pd=0.8u as=0 ps=0 w=0.42u l=1u
X351 VPWR sg13cmos5l_dfrbp_1_0.RESET_B a_11270_4338# VPWR sg13_lv_pmos ad=0.36237p pd=2.605u as=79.8f ps=0.8u w=0.42u l=0.13u
X352 VPWR a_19227_4654# sg13cmos5l_buf_8_0.X VPWR sg13_lv_pmos ad=0.3864p pd=2.93u as=0.2128p ps=1.5u w=1.12u l=0.13u
X353 VPWR sg13cmos5l_buf_1_31.X a_9448_6924# VPWR sg13_lv_pmos ad=0.2114p pd=1.54u as=0.2856p ps=2.36u w=0.84u l=0.13u
X354 a_18999_6178# sg13cmos5l_dfrbp_1_8.D VPWR VPWR sg13_lv_pmos ad=0.3234p pd=2.45u as=1.04815p ps=6.595u w=0.84u l=0.13u
X355 sg13cmos5l_dlhr_1_15.D a_17108_7972# VPWR VPWR sg13_lv_pmos ad=0.3808p pd=2.92u as=0.2128p ps=1.5u w=1.12u l=0.13u
X356 a_1484_9150# sg13cmos5l_inv_1_19.A VPWR VPWR sg13_lv_pmos ad=0.2856p pd=2.36u as=0.2114p ps=1.54u w=0.84u l=0.13u
X357 a_6959_6239# a_6117_6141# a_5700_6480# VPWR sg13_lv_pmos ad=0.2048p pd=1.63u as=0.34p ps=2.68u w=1u l=0.13u
X358 sg13cmos5l_dlhr_1_0.Q a_7689_1626# VGND VGND sg13_lv_nmos ad=0.2516p pd=2.16u as=0.1406p ps=1.12u w=0.74u l=0.13u
X359 a_15782_7362# sg13cmos5l_dfrbp_1_22.D VPWR VPWR sg13_lv_pmos ad=79.8f pd=0.8u as=0.1428p ps=1.52u w=0.42u l=0.13u
X360 a_19593_6162# a_19412_6484# VPWR VPWR sg13_lv_pmos ad=0.2128p pd=1.5u as=0.2387p ps=1.84u w=1.12u l=0.13u
X361 a_1125_6935# sg13cmos5l_dfrbp_1_15.D VPWR VPWR sg13_lv_pmos ad=0.4088p pd=2.97u as=1.04815p ps=6.595u w=1.12u l=0.13u
X362 VGND a_620_2352# nl_sw[0] VGND sg13_lv_nmos ad=0.14875p pd=1.16u as=0.2886p ps=2.26u w=0.74u l=0.13u
X363 a_5604_4338# sg13cmos5l_dfrbp_1_6.D a_5510_4338# VGND sg13_lv_nmos ad=60.89999f pd=0.71u as=0.1428p ps=1.52u w=0.42u l=0.13u
X364 a_5028_2826# sg13cmos5l_dfrbp_1_6.D a_4934_2826# VGND sg13_lv_nmos ad=60.89999f pd=0.71u as=0.1428p ps=1.52u w=0.42u l=0.13u
X365 sg13cmos5l_buf_1_104.A sg13cmos5l_buf_1_3.A VPWR VPWR sg13_lv_pmos ad=0.3808p pd=2.92u as=0.3808p ps=2.92u w=1.12u l=0.13u
X366 a_15684_4650# sg13cmos5l_dfrbp_1_8.D a_15590_4650# VGND sg13_lv_nmos ad=60.89999f pd=0.71u as=0.1428p ps=1.52u w=0.42u l=0.13u
X367 sg13cmos5l_o21ai_1_0.A1 sg13cmos5l_a221oi_1_0.C1 VGND VGND sg13_lv_nmos ad=0.2516p pd=2.16u as=0.1406p ps=1.12u w=0.74u l=0.13u
X368 a_2474_6162# a_1997_6126# a_2380_6162# VGND sg13_lv_nmos ad=37.8f pd=0.6u as=0.1428p ps=1.52u w=0.42u l=0.13u
X369 VPWR sg13cmos5l_buf_1_111.A a_18376_9224# VPWR sg13_lv_pmos ad=0.2114p pd=1.54u as=0.2856p ps=2.36u w=0.84u l=0.13u
X370 a_18097_7666# a_17545_7728# VGND VGND sg13_lv_nmos ad=71.99999f pd=0.865u as=1.49685p ps=9.6u w=0.64u l=0.13u
X371 VGND a_3447_2746# a_3578_2752# VGND sg13_lv_nmos ad=2.59257p pd=16.445u as=0.2775p ps=2.23u w=0.74u l=0.13u
X372 VPWR sg13cmos5l_dfrbp_1_6.RESET_B a_16234_6385# VPWR sg13_lv_pmos ad=0.1563p pd=1.22u as=0.147p ps=1.54u w=0.42u l=0.13u
X373 a_10665_7281# a_10484_6924# VPWR VPWR sg13_lv_pmos ad=0.2128p pd=1.5u as=0.2387p ps=1.84u w=1.12u l=0.13u
X374 VPWR sg13cmos5l_dfrbp_1_8.RESET_B a_6086_4650# VPWR sg13_lv_pmos ad=0.36237p pd=2.605u as=79.8f ps=0.8u w=0.42u l=0.13u
X375 VGND sg13cmos5l_buf_8_1.A a_16703_3871# VGND sg13_lv_nmos ad=2.41737p pd=15.64u as=0.2516p ps=2.16u w=0.74u l=0.13u
X376 VPWR sg13cmos5l_nor2_1_0.A a_13324_4696# VPWR sg13_lv_pmos ad=0.1596p pd=1.22u as=0.2856p ps=2.36u w=0.84u l=0.13u
X377 a_996_5837# a_1227_5423# a_682_5380# VGND sg13_lv_nmos ad=0.2373p pd=1.97u as=79.8f ps=0.8u w=0.42u l=0.13u
X378 a_10282_7897# a_10725_7653# a_10665_8065# VPWR sg13_lv_pmos ad=79.8f pd=0.8u as=63f ps=0.72u w=0.42u l=0.13u
X379 a_5424_3460# a_4873_3192# VPWR VPWR sg13_lv_pmos ad=0.105p pd=1.21u as=1.43437p ps=9.105u w=1u l=0.13u
X380 a_1402_3864# sg13cmos5l_dlygate4sd2_1_0.X VGND VGND sg13_lv_nmos ad=0.1428p pd=1.52u as=79.8f ps=0.8u w=0.42u l=0.13u
X381 VGND sg13cmos5l_inv_1_29.A a_12841_7728# VGND sg13_lv_nmos ad=0.15055p pd=1.17u as=0.187p ps=1.78u w=0.55u l=0.13u
X382 VPWR sg13cmos5l_dfrbp_1_21.Q a_18409_5770# VPWR sg13_lv_pmos ad=1.28962p pd=8.195u as=0.2856p ps=2.36u w=0.84u l=0.13u
X383 VPWR sg13cmos5l_dfrbp_1_10.Q_N a_3241_2746# VPWR sg13_lv_pmos ad=1.86162p pd=11.935u as=0.2856p ps=2.36u w=0.84u l=0.13u
X384 VGND a_19227_9190# sg13cmos5l_buf_8_2.X VGND sg13_lv_nmos ad=0.2516p pd=2.16u as=0.1406p ps=1.12u w=0.74u l=0.13u
X385 VGND a_10071_7282# a_10202_7288# VGND sg13_lv_nmos ad=1.49685p pd=9.6u as=0.2775p ps=2.23u w=0.74u l=0.13u
X386 VPWR a_7504_8678# a_7449_8559# VPWR sg13_lv_pmos ad=1.15047p pd=7.175u as=93.45f ps=0.865u w=0.42u l=0.13u
X387 a_4282_8112# a_3676_7964# VPWR VPWR sg13_lv_pmos ad=0.1008p pd=0.9u as=0.2387p ps=1.84u w=0.42u l=0.13u
X388 a_682_5380# a_1125_5423# a_1065_5459# VPWR sg13_lv_pmos ad=79.8f pd=0.8u as=63f ps=0.72u w=0.42u l=0.13u
X389 VPWR a_11824_7894# a_11769_7989# VPWR sg13_lv_pmos ad=1.15047p pd=7.175u as=93.45f ps=0.865u w=0.42u l=0.13u
X390 VPWR a_4425_7281# a_4358_6924# VPWR sg13_lv_pmos ad=0.2387p pd=1.84u as=0.1008p ps=0.9u w=0.42u l=0.13u
X391 a_2732_1590# sg13cmos5l_buf_1_37.A VPWR VPWR sg13_lv_pmos ad=0.2856p pd=2.36u as=0.2114p ps=1.54u w=0.84u l=0.13u
X392 a_16485_6935# sg13cmos5l_inv_1_2.A VPWR VPWR sg13_lv_pmos ad=0.4088p pd=2.97u as=1.07253p ps=6.75u w=1.12u l=0.13u
X393 a_13036_4948# a_12814_4692# VPWR VPWR sg13_lv_pmos ad=0.1176p pd=1.33u as=0.2618p ps=1.63u w=1.12u l=0.13u
X394 VGND a_18615_5770# a_18746_5776# VGND sg13_lv_nmos ad=1.97045p pd=12.335u as=0.2775p ps=2.23u w=0.74u l=0.13u
X395 VPWR a_3574_7850# sg13cmos5l_dlhr_1_9.Q_N VPWR sg13_lv_pmos ad=0.1974p pd=1.5u as=0.3808p ps=2.92u w=1.12u l=0.13u
X396 VPWR a_16271_7751# a_16528_7894# VPWR sg13_lv_pmos ad=0.2639p pd=1.81u as=79.8f ps=0.8u w=0.42u l=0.13u
X397 a_6084_4325# a_5796_3904# a_6022_4325# VGND sg13_lv_nmos ad=0.1428p pd=1.52u as=37.8f ps=0.6u w=0.42u l=0.13u
X398 VPWR a_12815_1703# a_13072_1846# VPWR sg13_lv_pmos ad=0.2639p pd=1.81u as=79.8f ps=0.8u w=0.42u l=0.13u
X399 sg13cmos5l_a22oi_1_1.B2 sg13cmos5l_dlhr_1_6.D a_13486_5760# VGND sg13_lv_nmos ad=0.2516p pd=2.16u as=0.1406p ps=1.12u w=0.74u l=0.13u
X400 a_11072_5347# sg13cmos5l_nor2_1_0.A a_11370_5760# VGND sg13_lv_nmos ad=0.2176p pd=1.96u as=0.1216p ps=1.02u w=0.64u l=0.13u
X401 VGND sg13cmos5l_buf_1_4.A a_16552_1664# VGND sg13_lv_nmos ad=0.14875p pd=1.16u as=0.187p ps=1.78u w=0.55u l=0.13u
X402 VGND a_16485_6935# a_16587_6935# VGND sg13_lv_nmos ad=1.49685p pd=9.6u as=0.2516p ps=2.16u w=0.74u l=0.13u
X403 VGND sg13cmos5l_inv_1_7.A a_12232_8436# VGND sg13_lv_nmos ad=0.14875p pd=1.16u as=0.187p ps=1.78u w=0.55u l=0.13u
X404 VGND a_8972_3864# sg13cmos5l_buf_1_45.X VGND sg13_lv_nmos ad=0.14875p pd=1.16u as=0.2886p ps=2.26u w=0.74u l=0.13u
X405 a_10308_7992# a_10827_7796# a_11567_7751# VGND sg13_lv_nmos ad=0.3473p pd=2.71u as=0.12665p ps=1.145u w=0.74u l=0.13u
X406 sg13cmos5l_dfrbp_1_22.Q_N a_17327_7285# VPWR VPWR sg13_lv_pmos ad=0.4312p pd=3.01u as=0.2639p ps=1.81u w=1.12u l=0.13u
X407 sg13cmos5l_dfrbp_1_17.Q_N a_3407_8797# VPWR VPWR sg13_lv_pmos ad=0.4312p pd=3.01u as=0.2639p ps=1.81u w=1.12u l=0.13u
X408 VPWR a_15909_2399# a_16011_2399# VPWR sg13_lv_pmos ad=1.86162p pd=11.935u as=0.3864p ps=2.93u w=1.12u l=0.13u
X409 a_16306_8874# sg13cmos5l_dfrbp_1_8.RESET_B VGND VGND sg13_lv_nmos ad=37.8f pd=0.6u as=79.8f ps=0.8u w=0.42u l=0.13u
X410 sg13cmos5l_dlhr_1_11.Q_N a_13686_7354# VGND VGND sg13_lv_nmos ad=0.2516p pd=2.16u as=0.1491p ps=1.18u w=0.74u l=0.13u
X411 sg13cmos5l_buf_1_31.X a_424_1664# VGND VGND sg13_lv_nmos ad=0.2886p pd=2.26u as=0.14875p ps=1.16u w=0.74u l=0.13u
X412 a_5069_5376# a_5799_5499# a_5710_5535# VPWR sg13_lv_pmos ad=0.2048p pd=1.63u as=93.45f ps=0.865u w=0.42u l=0.13u
X413 a_3664_8678# a_3407_8797# a_3826_8874# VGND sg13_lv_nmos ad=0.1428p pd=1.52u as=37.8f ps=0.6u w=0.42u l=0.13u
X414 a_11434_2356# a_11877_2399# a_11174_2826# VGND sg13_lv_nmos ad=79.8f pd=0.8u as=0.1296p ps=1.52u w=0.42u l=0.13u
X415 VPWR sg13cmos5l_dfrbp_1_8.RESET_B a_15590_4650# VPWR sg13_lv_pmos ad=0.36237p pd=2.605u as=79.8f ps=0.8u w=0.42u l=0.13u
X416 sg13cmos5l_buf_1_3.A a_19528_6924# VGND VGND sg13_lv_nmos ad=0.2886p pd=2.26u as=0.14875p ps=1.16u w=0.74u l=0.13u
X417 VPWR sg13cmos5l_dfrbp_1_6.D a_17399_3947# VPWR sg13_lv_pmos ad=0.1428p pd=1.52u as=79.8f ps=0.8u w=0.42u l=0.13u
X418 VPWR sg13cmos5l_buf_8_1.A a_18363_4270# VPWR sg13_lv_pmos ad=0.2128p pd=1.5u as=0.3808p ps=2.92u w=1.12u l=0.13u
X419 a_1065_6971# a_708_6928# VPWR VPWR sg13_lv_pmos ad=63f pd=0.72u as=0.1563p ps=1.22u w=0.42u l=0.13u
X420 a_17700_1639# a_17412_1944# a_17638_1639# VGND sg13_lv_nmos ad=0.1428p pd=1.52u as=37.8f ps=0.6u w=0.42u l=0.13u
X421 a_11986_7674# sg13cmos5l_dfrbp_1_6.RESET_B VGND VGND sg13_lv_nmos ad=37.8f pd=0.6u as=79.8f ps=0.8u w=0.42u l=0.13u
X422 a_7689_1626# a_7508_1948# VPWR VPWR sg13_lv_pmos ad=0.2128p pd=1.5u as=0.2387p ps=1.84u w=1.12u l=0.13u
X423 VPWR sg13cmos5l_dfrbp_1_0.RESET_B a_11530_1849# VPWR sg13_lv_pmos ad=0.1563p pd=1.22u as=0.147p ps=1.54u w=0.42u l=0.13u
X424 VPWR a_3308_5376# sg13cmos5l_buf_1_41.A VPWR sg13_lv_pmos ad=0.2114p pd=1.54u as=0.42p ps=2.99u w=1.12u l=0.13u
X425 a_16042_6892# a_16485_6935# a_16425_6971# VPWR sg13_lv_pmos ad=79.8f pd=0.8u as=63f ps=0.72u w=0.42u l=0.13u
X426 a_12420_9199# a_12132_9504# a_12358_9199# VGND sg13_lv_nmos ad=0.1428p pd=1.52u as=37.8f ps=0.6u w=0.42u l=0.13u
X427 VPWR sg13cmos5l_dfrbp_1_6.RESET_B a_5674_6385# VPWR sg13_lv_pmos ad=0.1563p pd=1.22u as=0.147p ps=1.54u w=0.42u l=0.13u
X428 VPWR a_2565_8447# a_2667_8447# VPWR sg13_lv_pmos ad=1.15047p pd=7.175u as=0.3864p ps=2.93u w=1.12u l=0.13u
X429 VPWR a_18671_1703# a_19508_1924# VPWR sg13_lv_pmos ad=0.2128p pd=1.5u as=0.3864p ps=2.93u w=1.12u l=0.13u
X430 sg13cmos5l_dlygate4sd2_1_0.X a_1290_3206# VPWR VPWR sg13_lv_pmos ad=0.3808p pd=2.92u as=0.2245p ps=1.53u w=1.12u l=0.13u
X431 VPWR a_7055_4261# a_7312_4142# VPWR sg13_lv_pmos ad=0.2639p pd=1.81u as=79.8f ps=0.8u w=0.42u l=0.13u
X432 a_4005_4629# sg13cmos5l_inv_1_8.A VPWR VPWR sg13_lv_pmos ad=0.4088p pd=2.97u as=1.2517p ps=7.955u w=1.12u l=0.13u
X433 a_934_5837# sg13cmos5l_dfrbp_1_6.RESET_B VGND VGND sg13_lv_nmos ad=37.8f pd=0.6u as=0.1701p ps=1.65u w=0.42u l=0.13u
X434 a_7378_6162# sg13cmos5l_dfrbp_1_6.RESET_B VGND VGND sg13_lv_nmos ad=37.8f pd=0.6u as=79.8f ps=0.8u w=0.42u l=0.13u
X435 VGND sg13cmos5l_buf_1_35.A a_1864_1664# VGND sg13_lv_nmos ad=0.14875p pd=1.16u as=0.187p ps=1.78u w=0.55u l=0.13u
X436 VGND a_16528_7894# a_16177_7751# VGND sg13_lv_nmos ad=79.8f pd=0.8u as=0.1428p ps=1.52u w=0.42u l=0.13u
X437 sg13cmos5l_buf_8_0.X a_19227_4654# VGND VGND sg13_lv_nmos ad=0.1406p pd=1.12u as=0.1406p ps=1.12u w=0.74u l=0.13u
X438 a_2596_7996# a_2621_7636# VPWR VPWR sg13_lv_pmos ad=0.2856p pd=2.36u as=1.15047p ps=7.175u w=0.84u l=0.13u
X439 sg13cmos5l_dfrbp_1_1.D sg13cmos5l_a22oi_1_2.B1 a_9823_2364# VPWR sg13_lv_pmos ad=0.2128p pd=1.5u as=0.2716p ps=1.605u w=1.12u l=0.13u
X440 VPWR a_13391_9263# a_14228_9484# VPWR sg13_lv_pmos ad=0.2128p pd=1.5u as=0.3864p ps=2.93u w=1.12u l=0.13u
X441 VPWR a_3599_3215# a_4436_3436# VPWR sg13_lv_pmos ad=0.2128p pd=1.5u as=0.3864p ps=2.93u w=1.12u l=0.13u
X442 VGND sg13cmos5l_or2_1_1.B a_11873_5760# VGND sg13_lv_nmos ad=0.2516p pd=2.16u as=0.1406p ps=1.12u w=0.74u l=0.13u
X443 a_17337_4965# a_16395_4772# a_17135_4727# VPWR sg13_lv_pmos ad=93.45f pd=0.865u as=0.2048p ps=1.63u w=0.42u l=0.13u
X444 VGND sg13cmos5l_dfrbp_1_6.RESET_B a_9076_5800# VGND sg13_lv_nmos ad=0.1406p pd=1.12u as=77.7f ps=0.95u w=0.74u l=0.13u
X445 sg13cmos5l_dlhr_1_17.Q_N a_9366_5842# VPWR VPWR sg13_lv_pmos ad=0.3808p pd=2.92u as=0.1974p ps=1.5u w=1.12u l=0.13u
X446 VGND VPWR VGND VGND sg13_lv_nmos ad=0.1428p pd=1.52u as=0 ps=0 w=0.42u l=1u
X447 VGND VPWR VGND VGND sg13_lv_nmos ad=79.8f pd=0.8u as=0 ps=0 w=0.42u l=1u
X448 a_6729_5041# a_6372_4968# VPWR VPWR sg13_lv_pmos ad=63f pd=0.72u as=0.1563p ps=1.22u w=0.42u l=0.13u
X449 a_16617_6553# a_16260_6480# VPWR VPWR sg13_lv_pmos ad=63f pd=0.72u as=0.1563p ps=1.22u w=0.42u l=0.13u
X450 VGND a_9033_6162# a_8988_6198# VGND sg13_lv_nmos ad=0.1428p pd=1.52u as=47.25f ps=0.645u w=0.42u l=0.13u
X451 sg13cmos5l_dlhr_1_1.Q_N a_2934_4632# VGND VGND sg13_lv_nmos ad=0.2516p pd=2.16u as=0.1491p ps=1.18u w=0.74u l=0.13u
X452 sg13cmos5l_dfrbp_1_4.D sg13cmos5l_nand2_1_1.B a_10707_2388# VPWR sg13_lv_pmos ad=0.2408p pd=1.55u as=0.1428p ps=1.375u w=1.12u l=0.13u
X453 VPWR comp_p a_424_1664# VPWR sg13_lv_pmos ad=0.2114p pd=1.54u as=0.2856p ps=2.36u w=0.84u l=0.13u
X454 nh_sw[10] a_20392_3176# VGND VGND sg13_lv_nmos ad=0.2886p pd=2.26u as=0.14875p ps=1.16u w=0.74u l=0.13u
X455 sg13cmos5l_or2_1_0.A a_18363_4270# VGND VGND sg13_lv_nmos ad=0.1406p pd=1.12u as=0.1406p ps=1.12u w=0.74u l=0.13u
X456 a_17126_1626# a_17931_1748# a_17386_1849# VPWR sg13_lv_pmos ad=0.1428p pd=1.52u as=79.8f ps=0.8u w=0.42u l=0.13u
X457 sg13cmos5l_dfrbp_1_18.Q a_8084_8436# VGND VGND sg13_lv_nmos ad=0.2516p pd=2.16u as=0.1406p ps=1.12u w=0.74u l=0.13u
X458 a_708_6928# a_1227_6935# a_1967_7285# VGND sg13_lv_nmos ad=0.3473p pd=2.71u as=0.12665p ps=1.145u w=0.74u l=0.13u
X459 sg13cmos5l_dlhr_1_5.Q_N a_8982_7354# VGND VGND sg13_lv_nmos ad=0.2516p pd=2.16u as=0.1491p ps=1.18u w=0.74u l=0.13u
X460 a_2757_3117# sg13cmos5l_dfrbp_1_9.Q VGND VGND sg13_lv_nmos ad=0.2516p pd=2.16u as=2.59257p ps=16.445u w=0.74u l=0.13u
X461 a_9456_4972# a_8905_4704# VPWR VPWR sg13_lv_pmos ad=0.105p pd=1.21u as=1.28962p ps=8.195u w=1u l=0.13u
X462 VGND sg13cmos5l_dfrbp_1_8.RESET_B a_1956_8874# VGND sg13_lv_nmos ad=0.1626p pd=1.415u as=60.89999f ps=0.71u w=0.42u l=0.13u
X463 a_19028_5412# a_18746_5776# a_18961_5814# VGND sg13_lv_nmos ad=0.141p pd=1.17u as=71.99999f ps=0.865u w=0.64u l=0.13u
X464 a_7524_7992# a_7498_7897# VGND VGND sg13_lv_nmos ad=0.2516p pd=2.16u as=0.1626p ps=1.415u w=0.74u l=0.13u
X465 a_17412_1944# a_17386_1849# VPWR VPWR sg13_lv_pmos ad=0.34p pd=2.68u as=0.36237p ps=2.605u w=1u l=0.13u
X466 a_9268_6148# a_8852_6484# a_9033_6162# VGND sg13_lv_nmos ad=77.7f pd=0.95u as=0.2516p ps=2.16u w=0.74u l=0.13u
X467 VGND a_18363_4270# sg13cmos5l_or2_1_0.A VGND sg13_lv_nmos ad=0.1406p pd=1.12u as=0.1406p ps=1.12u w=0.74u l=0.13u
X468 a_11556_1944# a_11530_1849# VGND VGND sg13_lv_nmos ad=0.2516p pd=2.16u as=0.1626p ps=1.415u w=0.74u l=0.13u
X469 VPWR a_19227_4654# sg13cmos5l_buf_8_0.X VPWR sg13_lv_pmos ad=0.2128p pd=1.5u as=0.2128p ps=1.5u w=1.12u l=0.13u
X470 VGND cks sg13cmos5l_dfrbp_1_6.RESET_B VGND sg13_lv_nmos ad=0.2516p pd=2.16u as=0.1443p ps=1.13u w=0.74u l=0.13u
X471 a_14708_6924# a_14295_7282# a_14640_6924# VPWR sg13_lv_pmos ad=0.191p pd=1.44u as=0.105p ps=1.21u w=1u l=0.13u
X472 a_15718_2813# sg13cmos5l_dfrbp_1_0.RESET_B VGND VGND sg13_lv_nmos ad=37.8f pd=0.6u as=0.1701p ps=1.65u w=0.42u l=0.13u
X473 a_2340_3456# a_2314_3361# VPWR VPWR sg13_lv_pmos ad=0.34p pd=2.68u as=0.36237p ps=2.605u w=1u l=0.13u
X474 sg13cmos5l_buf_8_2.X a_19227_9190# VPWR VPWR sg13_lv_pmos ad=0.2128p pd=1.5u as=0.2128p ps=1.5u w=1.12u l=0.13u
X475 a_2386_7362# sg13cmos5l_dfrbp_1_6.RESET_B VGND VGND sg13_lv_nmos ad=37.8f pd=0.6u as=79.8f ps=0.8u w=0.42u l=0.13u
X476 VPWR sg13cmos5l_buf_8_0.X a_20392_7712# VPWR sg13_lv_pmos ad=0.2114p pd=1.54u as=0.2856p ps=2.36u w=0.84u l=0.13u
X477 a_2596_7996# a_2621_7636# VGND VGND sg13_lv_nmos ad=0.2775p pd=2.23u as=1.49685p ps=9.6u w=0.74u l=0.13u
X478 VGND sg13cmos5l_buf_1_30.A a_8680_1664# VGND sg13_lv_nmos ad=0.14875p pd=1.16u as=0.187p ps=1.78u w=0.55u l=0.13u
X479 a_17750_4325# a_16572_4261# a_17354_4180# VGND sg13_lv_nmos ad=37.8f pd=0.6u as=0.1428p ps=1.52u w=0.42u l=0.13u
X480 a_16268_3102# sg13cmos5l_buf_1_2.X VGND VGND sg13_lv_nmos ad=0.187p pd=1.78u as=0.14875p ps=1.16u w=0.55u l=0.13u
X481 sg13cmos5l_dfrbp_1_23.Q_N a_13775_6239# VGND VGND sg13_lv_nmos ad=0.2849p pd=2.25u as=0.2516p ps=2.16u w=0.74u l=0.13u
X482 a_13284_3456# a_13258_3361# VGND VGND sg13_lv_nmos ad=0.2516p pd=2.16u as=0.1626p ps=1.415u w=0.74u l=0.13u
X483 VGND sg13cmos5l_inv_1_29.A sg13cmos5l_inv_1_29.Y VGND sg13_lv_nmos ad=0.2516p pd=2.16u as=0.2516p ps=2.16u w=0.74u l=0.13u
X484 a_2831_7630# sg13cmos5l_dfrbp_1_16.Q_N VPWR VPWR sg13_lv_pmos ad=0.2856p pd=2.36u as=1.15047p ps=7.175u w=0.84u l=0.13u
X485 VGND sg13cmos5l_buf_1_3.A a_20296_1664# VGND sg13_lv_nmos ad=0.14875p pd=1.16u as=0.187p ps=1.78u w=0.55u l=0.13u
X486 VPWR sg13cmos5l_buf_1_41.X a_2824_2388# VPWR sg13_lv_pmos ad=0.2114p pd=1.54u as=0.2856p ps=2.36u w=0.84u l=0.13u
X487 VGND sg13cmos5l_buf_1_8.X a_11656_3176# VGND sg13_lv_nmos ad=0.14875p pd=1.16u as=0.187p ps=1.78u w=0.55u l=0.13u
X488 a_19412_6484# a_19130_6172# a_19345_6154# VGND sg13_lv_nmos ad=0.141p pd=1.17u as=71.99999f ps=0.865u w=0.64u l=0.13u
X489 a_16068_6162# sg13cmos5l_buf_1_57.X a_15974_6162# VGND sg13_lv_nmos ad=60.89999f pd=0.71u as=0.1428p ps=1.52u w=0.42u l=0.13u
X490 VPWR sg13cmos5l_buf_1_65.X a_8488_9224# VPWR sg13_lv_pmos ad=0.2114p pd=1.54u as=0.2856p ps=2.36u w=0.84u l=0.13u
X491 VGND sg13cmos5l_buf_1_76.X a_5416_9224# VGND sg13_lv_nmos ad=0.14875p pd=1.16u as=0.187p ps=1.78u w=0.55u l=0.13u
X492 VPWR sg13cmos5l_dfrbp_1_6.RESET_B a_9705_4650# VPWR sg13_lv_pmos ad=0.2128p pd=1.5u as=0.2128p ps=1.5u w=1.12u l=0.13u
X493 VGND a_15821_3864# sg13cmos5l_dfrbp_1_6.Q_N VGND sg13_lv_nmos ad=0.2516p pd=2.16u as=0.2849p ps=2.25u w=0.74u l=0.13u
X494 a_9260_2352# sg13cmos5l_buf_1_30.X VGND VGND sg13_lv_nmos ad=0.187p pd=1.78u as=0.14875p ps=1.16u w=0.55u l=0.13u
X495 VPWR sg13cmos5l_inv_1_19.A sg13cmos5l_buf_1_32.A VPWR sg13_lv_pmos ad=0.3808p pd=2.92u as=0.3808p ps=2.92u w=1.12u l=0.13u
X496 VPWR sg13cmos5l_dfrbp_1_6.RESET_B a_5510_4338# VPWR sg13_lv_pmos ad=0.36237p pd=2.605u as=79.8f ps=0.8u w=0.42u l=0.13u
X497 VPWR sg13cmos5l_buf_1_4.A sg13cmos5l_buf_1_110.A VPWR sg13_lv_pmos ad=0.3808p pd=2.92u as=0.3808p ps=2.92u w=1.12u l=0.13u
X498 a_10292_9508# a_9879_9202# a_10224_9508# VPWR sg13_lv_pmos ad=0.191p pd=1.44u as=0.105p ps=1.21u w=1u l=0.13u
X499 VGND a_10031_8797# a_10868_8436# VGND sg13_lv_nmos ad=0.1406p pd=1.12u as=0.2516p ps=2.16u w=0.74u l=0.13u
X500 VPWR sg13cmos5l_buf_8_0.A a_19227_4654# VPWR sg13_lv_pmos ad=0.2128p pd=1.5u as=0.3808p ps=2.92u w=1.12u l=0.13u
X501 VPWR a_7631_4727# a_8468_4948# VPWR sg13_lv_pmos ad=0.2128p pd=1.5u as=0.3864p ps=2.93u w=1.12u l=0.13u
X502 VPWR sg13cmos5l_inv_1_3.A a_15016_9224# VPWR sg13_lv_pmos ad=0.2114p pd=1.54u as=0.2856p ps=2.36u w=0.84u l=0.13u
X503 sg13cmos5l_dfrbp_1_8.RESET_B cks VGND VGND sg13_lv_nmos ad=0.2516p pd=2.16u as=0.2516p ps=2.16u w=0.74u l=0.13u
X504 VGND a_3212_1590# sg13cmos5l_buf_1_41.X VGND sg13_lv_nmos ad=0.14875p pd=1.16u as=0.2886p ps=2.26u w=0.74u l=0.13u
X505 VGND VPWR VGND VGND sg13_lv_nmos ad=79.8f pd=0.8u as=0 ps=0 w=0.42u l=1u
X506 a_2148_3904# a_2122_3868# VPWR VPWR sg13_lv_pmos ad=0.34p pd=2.68u as=0.36237p ps=2.605u w=1u l=0.13u
X507 sg13cmos5l_buf_1_4.A a_15592_6200# VGND VGND sg13_lv_nmos ad=0.2886p pd=2.26u as=0.14875p ps=1.16u w=0.74u l=0.13u
X508 VGND a_19227_9190# sg13cmos5l_buf_8_2.X VGND sg13_lv_nmos ad=0.1406p pd=1.12u as=0.1406p ps=1.12u w=0.74u l=0.13u
X509 VPWR VGND VPWR VPWR sg13_lv_pmos ad=0.19p pd=1.38u as=0 ps=0 w=1u l=1u
X510 a_11460_2392# a_11434_2356# VGND VGND sg13_lv_nmos ad=0.2516p pd=2.16u as=0.1626p ps=1.415u w=0.74u l=0.13u
X511 a_2757_3117# sg13cmos5l_dfrbp_1_9.Q VPWR VPWR sg13_lv_pmos ad=0.4088p pd=2.97u as=1.38655p ps=8.8u w=1.12u l=0.13u
X512 a_14342_8874# sg13cmos5l_dfrbp_1_23.CLK VPWR VPWR sg13_lv_pmos ad=79.8f pd=0.8u as=0.1428p ps=1.52u w=0.42u l=0.13u
X513 sg13cmos5l_dlhr_1_17.Q_N a_9366_5842# VGND VGND sg13_lv_nmos ad=0.2516p pd=2.16u as=0.1491p ps=1.18u w=0.74u l=0.13u
X514 VPWR a_5069_5376# sg13cmos5l_dfrbp_1_29.Q_N VPWR sg13_lv_pmos ad=0.2639p pd=1.81u as=0.4312p ps=3.01u w=1.12u l=0.13u
X515 a_15238_7687# sg13cmos5l_dfrbp_1_6.RESET_B VGND VGND sg13_lv_nmos ad=37.8f pd=0.6u as=0.1701p ps=1.65u w=0.42u l=0.13u
X516 VGND VPWR VGND VGND sg13_lv_nmos ad=79.8f pd=0.8u as=0 ps=0 w=0.42u l=1u
X517 a_5820_5773# a_5951_5383# a_5069_5376# VPWR sg13_lv_pmos ad=0.34p pd=2.68u as=0.2048p ps=1.63u w=1u l=0.13u
X518 a_8841_5769# a_8660_5412# VPWR VPWR sg13_lv_pmos ad=0.2128p pd=1.5u as=0.2387p ps=1.84u w=1.12u l=0.13u
X519 a_2732_9150# sg13cmos5l_inv_1_20.Y VGND VGND sg13_lv_nmos ad=0.187p pd=1.78u as=0.14875p ps=1.16u w=0.55u l=0.13u
X520 a_15206_2826# sg13cmos5l_nor2b_1_1.Y VPWR VPWR sg13_lv_pmos ad=79.8f pd=0.8u as=0.1428p ps=1.52u w=0.42u l=0.13u
X521 VPWR sg13cmos5l_dfrbp_1_8.RESET_B a_2122_3868# VPWR sg13_lv_pmos ad=0.1563p pd=1.22u as=0.147p ps=1.54u w=0.42u l=0.13u
X522 a_15012_7992# a_14986_7897# VGND VGND sg13_lv_nmos ad=0.2516p pd=2.16u as=0.1626p ps=1.415u w=0.74u l=0.13u
X523 VPWR a_4041_2745# a_4566_2818# VPWR sg13_lv_pmos ad=0.1974p pd=1.5u as=0.2856p ps=2.36u w=0.84u l=0.13u
X524 a_1125_5423# sg13cmos5l_dlhr_1_1.GATE VGND VGND sg13_lv_nmos ad=0.2516p pd=2.16u as=1.97045p ps=12.335u w=0.74u l=0.13u
X525 ph_sw[4] a_6568_9224# VGND VGND sg13_lv_nmos ad=0.2886p pd=2.26u as=0.14875p ps=1.16u w=0.74u l=0.13u
X526 VPWR sg13cmos5l_nand2_1_1.B a_10464_2427# VPWR sg13_lv_pmos ad=0.2891p pd=1.695u as=0.1596p ps=1.22u w=0.84u l=0.13u
X527 a_11913_3947# a_11556_3904# VPWR VPWR sg13_lv_pmos ad=63f pd=0.72u as=0.1563p ps=1.22u w=0.42u l=0.13u
X528 VPWR a_3831_7282# a_3962_7288# VPWR sg13_lv_pmos ad=1.07253p pd=6.75u as=0.2856p ps=2.36u w=0.84u l=0.13u
X529 a_13574_8112# a_13178_7684# a_13460_7996# VPWR sg13_lv_pmos ad=0.1008p pd=0.9u as=0.191p ps=1.44u w=0.42u l=0.13u
X530 a_1878_6337# a_1997_6126# VPWR VPWR sg13_lv_pmos ad=0.3864p pd=2.93u as=0.2128p ps=1.5u w=1.12u l=0.13u
X531 a_13418_4696# sg13cmos5l_nor2_1_0.A a_13324_4696# VGND sg13_lv_nmos ad=0.1216p pd=1.02u as=0.2176p ps=1.96u w=0.64u l=0.13u
X532 a_6372_4968# a_6346_4873# VPWR VPWR sg13_lv_pmos ad=0.34p pd=2.68u as=0.36237p ps=2.605u w=1u l=0.13u
X533 VGND cks sg13cmos5l_dfrbp_1_6.RESET_B VGND sg13_lv_nmos ad=0.1406p pd=1.12u as=0.1406p ps=1.12u w=0.74u l=0.13u
X534 VGND cks a_19227_9190# VGND sg13_lv_nmos ad=0.1406p pd=1.12u as=0.2553p ps=2.17u w=0.74u l=0.13u
X535 VPWR sg13cmos5l_dfrbp_1_12.Q_N a_8905_4704# VPWR sg13_lv_pmos ad=1.28962p pd=8.195u as=0.2856p ps=2.36u w=0.84u l=0.13u
X536 a_1484_6126# sg13cmos5l_buf_1_58.A VPWR VPWR sg13_lv_pmos ad=0.2856p pd=2.36u as=0.2114p ps=1.54u w=0.84u l=0.13u
X537 sg13cmos5l_dlhr_1_2.Q a_7497_3138# VPWR VPWR sg13_lv_pmos ad=0.3808p pd=2.92u as=0.2128p ps=1.5u w=1.12u l=0.13u
X538 sg13cmos5l_buf_8_2.X a_19227_9190# VPWR VPWR sg13_lv_pmos ad=0.2128p pd=1.5u as=0.2128p ps=1.5u w=1.12u l=0.13u
X539 VGND a_2409_4650# a_2934_4632# VGND sg13_lv_nmos ad=0.1491p pd=1.18u as=0.187p ps=1.78u w=0.55u l=0.13u
X540 a_18860_6888# sg13cmos5l_buf_1_87.A VGND VGND sg13_lv_nmos ad=0.187p pd=1.78u as=0.14875p ps=1.16u w=0.55u l=0.13u
X541 VGND a_19244_2352# nl_sw[9] VGND sg13_lv_nmos ad=0.14875p pd=1.16u as=0.2886p ps=2.26u w=0.74u l=0.13u
X542 VGND VPWR VGND VGND sg13_lv_nmos ad=0.1428p pd=1.52u as=0 ps=0 w=0.42u l=1u
X543 a_5508_6162# sg13cmos5l_dfrbp_1_6.D a_5414_6162# VGND sg13_lv_nmos ad=60.89999f pd=0.71u as=0.1428p ps=1.52u w=0.42u l=0.13u
X544 sg13cmos5l_dfrbp_1_6.RESET_B cks VPWR VPWR sg13_lv_pmos ad=0.2128p pd=1.5u as=0.2128p ps=1.5u w=1.12u l=0.13u
X545 VPWR a_3407_4261# a_4244_3900# VPWR sg13_lv_pmos ad=0.2128p pd=1.5u as=0.3864p ps=2.93u w=1.12u l=0.13u
X546 VGND sg13cmos5l_or2_1_0.A a_18480_5028# VGND sg13_lv_nmos ad=0.1469p pd=1.155u as=0.1045p ps=0.93u w=0.55u l=0.13u
X547 VGND a_5637_2399# a_5739_2399# VGND sg13_lv_nmos ad=2.59257p pd=16.445u as=0.2516p ps=2.16u w=0.74u l=0.13u
X548 a_7508_1948# a_7226_1636# a_7441_1618# VGND sg13_lv_nmos ad=0.141p pd=1.17u as=71.99999f ps=0.865u w=0.64u l=0.13u
X549 VGND a_3664_8678# a_3313_8797# VGND sg13_lv_nmos ad=79.8f pd=0.8u as=0.1428p ps=1.52u w=0.42u l=0.13u
X550 VPWR a_13076_5376# a_13034_5412# VPWR sg13_lv_pmos ad=0.2618p pd=1.63u as=0.1176p ps=1.33u w=1.12u l=0.13u
X551 VPWR a_16268_1590# nl_sw[7] VPWR sg13_lv_pmos ad=0.2114p pd=1.54u as=0.42p ps=2.99u w=1.12u l=0.13u
X552 VPWR sg13cmos5l_dfrbp_1_0.RESET_B a_11270_1626# VPWR sg13_lv_pmos ad=0.36237p pd=2.605u as=79.8f ps=0.8u w=0.42u l=0.13u
X553 sg13cmos5l_dfrbp_1_10.Q_N a_3599_3215# VGND VGND sg13_lv_nmos ad=0.2849p pd=2.25u as=0.2516p ps=2.16u w=0.74u l=0.13u
X554 a_3588_4968# a_4107_4772# a_4847_4727# VGND sg13_lv_nmos ad=0.3473p pd=2.71u as=0.12665p ps=1.145u w=0.74u l=0.13u
X555 a_14929_5814# a_14377_5770# VGND VGND sg13_lv_nmos ad=71.99999f pd=0.865u as=1.97045p ps=12.335u w=0.64u l=0.13u
X556 VPWR a_10665_7281# a_11190_7354# VPWR sg13_lv_pmos ad=0.1974p pd=1.5u as=0.2856p ps=2.36u w=0.84u l=0.13u
X557 a_3792_2388# a_3241_2746# VPWR VPWR sg13_lv_pmos ad=0.105p pd=1.21u as=1.86162p ps=11.935u w=1u l=0.13u
X558 VPWR a_17132_9150# ph_sw[7] VPWR sg13_lv_pmos ad=0.2114p pd=1.54u as=0.42p ps=2.99u w=1.12u l=0.13u
X559 VPWR sg13cmos5l_inv_1_17.A sg13cmos5l_buf_1_37.A VPWR sg13_lv_pmos ad=0.3808p pd=2.92u as=0.3808p ps=2.92u w=1.12u l=0.13u
X560 a_18959_3215# a_18117_3117# a_18865_3215# VGND sg13_lv_nmos ad=0.12665p pd=1.145u as=0.1428p ps=1.52u w=0.42u l=0.13u
X561 a_6188_1590# sg13cmos5l_buf_1_25.A VPWR VPWR sg13_lv_pmos ad=0.2856p pd=2.36u as=0.2114p ps=1.54u w=0.84u l=0.13u
X562 nh_sw[2] a_3688_1664# VGND VGND sg13_lv_nmos ad=0.2886p pd=2.26u as=0.14875p ps=1.16u w=0.74u l=0.13u
X563 sg13cmos5l_dfrbp_1_2.Q_N a_12815_4261# VGND VGND sg13_lv_nmos ad=0.2849p pd=2.25u as=0.2516p ps=2.16u w=0.74u l=0.13u
X564 a_6789_4629# sg13cmos5l_inv_1_8.A VPWR VPWR sg13_lv_pmos ad=0.4088p pd=2.97u as=1.2517p ps=7.955u w=1.12u l=0.13u
X565 a_708_5416# a_682_5380# VGND VGND sg13_lv_nmos ad=0.2516p pd=2.16u as=0.1626p ps=1.415u w=0.74u l=0.13u
X566 VPWR sg13cmos5l_buf_1_105.A a_18856_8436# VPWR sg13_lv_pmos ad=0.2114p pd=1.54u as=0.2856p ps=2.36u w=0.84u l=0.13u
X567 a_15876_4968# a_15850_4873# VPWR VPWR sg13_lv_pmos ad=0.34p pd=2.68u as=0.36237p ps=2.605u w=1u l=0.13u
X568 ph_sw[3] a_5416_9224# VPWR VPWR sg13_lv_pmos ad=0.42p pd=2.99u as=0.2114p ps=1.54u w=1.12u l=0.13u
X569 a_19227_9190# cks VPWR VPWR sg13_lv_pmos ad=0.2128p pd=1.5u as=0.2128p ps=1.5u w=1.12u l=0.13u
X570 VPWR sg13cmos5l_dfrbp_1_0.RESET_B a_11174_2826# VPWR sg13_lv_pmos ad=0.36237p pd=2.605u as=79.8f ps=0.8u w=0.42u l=0.13u
X571 a_16298_4338# a_15821_3864# a_16204_4338# VGND sg13_lv_nmos ad=37.8f pd=0.6u as=0.1428p ps=1.52u w=0.42u l=0.13u
X572 sg13cmos5l_dfrbp_1_23.Q a_14612_6460# VGND VGND sg13_lv_nmos ad=0.2516p pd=2.16u as=0.1406p ps=1.12u w=0.74u l=0.13u
X573 a_14800_3358# a_14543_3215# a_14962_3138# VGND sg13_lv_nmos ad=0.1428p pd=1.52u as=37.8f ps=0.6u w=0.42u l=0.13u
X574 sg13cmos5l_buf_1_8.A sg13cmos5l_inv_1_7.A VGND VGND sg13_lv_nmos ad=0.2516p pd=2.16u as=0.2516p ps=2.16u w=0.74u l=0.13u
X575 sg13cmos5l_dfrbp_1_0.Q_N a_18671_1703# VGND VGND sg13_lv_nmos ad=0.2849p pd=2.25u as=0.2516p ps=2.16u w=0.74u l=0.13u
X576 VGND sg13cmos5l_inv_1_28.Y a_11464_9224# VGND sg13_lv_nmos ad=0.14875p pd=1.16u as=0.187p ps=1.78u w=0.55u l=0.13u
X577 a_19142_5412# a_18746_5776# a_19028_5412# VPWR sg13_lv_pmos ad=0.1008p pd=0.9u as=0.191p ps=1.44u w=0.42u l=0.13u
X578 VPWR a_4076_5376# sg13cmos5l_inv_1_17.A VPWR sg13_lv_pmos ad=0.2114p pd=1.54u as=0.42p ps=2.99u w=1.12u l=0.13u
X579 sg13cmos5l_dfrbp_1_24.Q_N a_13391_9263# VGND VGND sg13_lv_nmos ad=0.2849p pd=2.25u as=0.2516p ps=2.16u w=0.74u l=0.13u
X580 a_8580_8874# sg13cmos5l_dfrbp_1_18.Q a_8486_8874# VGND sg13_lv_nmos ad=60.89999f pd=0.71u as=0.1428p ps=1.52u w=0.42u l=0.13u
X581 VGND a_11567_7751# a_12404_7972# VGND sg13_lv_nmos ad=0.1406p pd=1.12u as=0.2516p ps=2.16u w=0.74u l=0.13u
X582 VPWR a_10028_6126# sg13cmos5l_inv_1_18.A VPWR sg13_lv_pmos ad=0.2114p pd=1.54u as=0.42p ps=2.99u w=1.12u l=0.13u
X583 a_5770_3868# a_6213_3911# a_5510_4338# VGND sg13_lv_nmos ad=79.8f pd=0.8u as=0.1296p ps=1.52u w=0.42u l=0.13u
X584 VPWR sg13cmos5l_dfrbp_1_6.RESET_B a_16204_4338# VPWR sg13_lv_pmos ad=1.38655p pd=8.8u as=79.8f ps=0.8u w=0.42u l=0.13u
X585 a_18959_3215# a_18117_3117# a_17700_3456# VPWR sg13_lv_pmos ad=0.2048p pd=1.63u as=0.34p ps=2.68u w=1u l=0.13u
X586 a_2306_7660# sg13cmos5l_dfrbp_1_6.RESET_B VGND VGND sg13_lv_nmos ad=77.7f pd=0.95u as=0.1406p ps=1.12u w=0.74u l=0.13u
X587 sg13cmos5l_buf_1_98.A a_13641_7674# VGND VGND sg13_lv_nmos ad=0.2516p pd=2.16u as=0.1406p ps=1.12u w=0.74u l=0.13u
X588 a_16473_7989# a_15531_7796# a_16271_7751# VPWR sg13_lv_pmos ad=93.45f pd=0.865u as=0.2048p ps=1.63u w=0.42u l=0.13u
X589 VPWR sg13cmos5l_buf_1_24.X a_5704_1664# VPWR sg13_lv_pmos ad=0.2114p pd=1.54u as=0.2856p ps=2.36u w=0.84u l=0.13u
X590 a_2348_7624# a_2621_7636# a_2583_7710# VGND sg13_lv_nmos ad=0.141p pd=1.17u as=47.25f ps=0.645u w=0.42u l=0.13u
X591 sg13cmos5l_dlhr_1_6.Q_N a_9558_6144# VPWR VPWR sg13_lv_pmos ad=0.3808p pd=2.92u as=0.1974p ps=1.5u w=1.12u l=0.13u
X592 a_17493_3947# a_16551_3987# a_17399_3947# VPWR sg13_lv_pmos ad=79.8f pd=0.8u as=0.1428p ps=1.52u w=0.42u l=0.13u
X593 VPWR a_1967_5773# a_2804_5412# VPWR sg13_lv_pmos ad=0.2128p pd=1.5u as=0.3864p ps=2.93u w=1.12u l=0.13u
X594 sg13cmos5l_or2_1_0.A a_18363_4270# VPWR VPWR sg13_lv_pmos ad=0.2128p pd=1.5u as=0.2128p ps=1.5u w=1.12u l=0.13u
X595 VGND a_524_4614# ckc VGND sg13_lv_nmos ad=0.14875p pd=1.16u as=0.2886p ps=2.26u w=0.74u l=0.13u
X596 VGND a_13641_7674# a_13596_7710# VGND sg13_lv_nmos ad=0.1428p pd=1.52u as=47.25f ps=0.645u w=0.42u l=0.13u
X597 VGND sg13cmos5l_dfrbp_1_8.RESET_B a_15876_7362# VGND sg13_lv_nmos ad=0.1626p pd=1.415u as=60.89999f ps=0.71u w=0.42u l=0.13u
X598 a_13396_7312# a_12980_6924# a_13161_7281# VGND sg13_lv_nmos ad=77.7f pd=0.95u as=0.2516p ps=2.16u w=0.74u l=0.13u
X599 VPWR a_17008_2630# a_16953_2511# VPWR sg13_lv_pmos ad=1.86162p pd=11.935u as=93.45f ps=0.865u w=0.42u l=0.13u
X600 VPWR VGND VPWR VPWR sg13_lv_pmos ad=0.34p pd=2.68u as=0 ps=0 w=1u l=1u
X601 VPWR sg13cmos5l_buf_1_61.X a_1000_9224# VPWR sg13_lv_pmos ad=0.2114p pd=1.54u as=0.2856p ps=2.36u w=0.84u l=0.13u
X602 a_15887_8797# a_15045_8447# a_14628_8440# VPWR sg13_lv_pmos ad=0.2048p pd=1.63u as=0.34p ps=2.68u w=1u l=0.13u
X603 a_6741_5459# sg13cmos5l_dfrbp_1_8.RESET_B VPWR VPWR sg13_lv_pmos ad=0.147p pd=1.54u as=0.1563p ps=1.22u w=0.42u l=0.13u
X604 VGND a_7941_7653# a_8043_7796# VGND sg13_lv_nmos ad=1.49685p pd=9.6u as=0.2516p ps=2.16u w=0.74u l=0.13u
X605 a_4172_1590# sg13cmos5l_buf_1_38.A VPWR VPWR sg13_lv_pmos ad=0.2856p pd=2.36u as=0.2114p ps=1.54u w=0.84u l=0.13u
X606 a_13076_5376# sg13cmos5l_inv_1_0.A VGND VGND sg13_lv_nmos ad=0.187p pd=1.78u as=0.17255p ps=1.25u w=0.55u l=0.13u
X607 a_9060_8861# a_8772_8440# a_8998_8861# VGND sg13_lv_nmos ad=0.1428p pd=1.52u as=37.8f ps=0.6u w=0.42u l=0.13u
X608 VPWR sg13cmos5l_dfrbp_1_6.RESET_B a_17961_8793# VPWR sg13_lv_pmos ad=0.2128p pd=1.5u as=0.2128p ps=1.5u w=1.12u l=0.13u
X609 VPWR a_18363_4270# sg13cmos5l_or2_1_0.A VPWR sg13_lv_pmos ad=0.2128p pd=1.5u as=0.2128p ps=1.5u w=1.12u l=0.13u
X610 a_17132_9150# sg13cmos5l_buf_1_94.X VPWR VPWR sg13_lv_pmos ad=0.2856p pd=2.36u as=0.2114p ps=1.54u w=0.84u l=0.13u
X611 VPWR a_18928_1846# a_18873_1941# VPWR sg13_lv_pmos ad=1.86162p pd=11.935u as=93.45f ps=0.865u w=0.42u l=0.13u
X612 sg13cmos5l_dfrbp_1_16.Q_N a_1967_7285# VPWR VPWR sg13_lv_pmos ad=0.4312p pd=3.01u as=0.2639p ps=1.81u w=1.12u l=0.13u
X613 a_2565_3911# sg13cmos5l_inv_1_8.A VGND VGND sg13_lv_nmos ad=0.2516p pd=2.16u as=2.27517p ps=14.72u w=0.74u l=0.13u
X614 sg13cmos5l_buf_1_107.X a_17896_9224# VGND VGND sg13_lv_nmos ad=0.2886p pd=2.26u as=0.14875p ps=1.16u w=0.74u l=0.13u
X615 VPWR a_17961_8793# a_17894_8436# VPWR sg13_lv_pmos ad=0.2387p pd=1.84u as=0.1008p ps=0.9u w=0.42u l=0.13u
X616 VPWR a_13100_8400# pl_sw[6] VPWR sg13_lv_pmos ad=0.2114p pd=1.54u as=0.42p ps=2.99u w=1.12u l=0.13u
X617 VGND sg13cmos5l_dfrbp_1_6.RESET_B a_19828_6148# VGND sg13_lv_nmos ad=0.1406p pd=1.12u as=77.7f ps=0.95u w=0.74u l=0.13u
X618 a_12216_5728# sg13cmos5l_or2_1_1.B a_12358_5388# VPWR sg13_lv_pmos ad=0.2856p pd=2.36u as=0.1596p ps=1.22u w=0.84u l=0.13u
X619 VPWR sg13cmos5l_dfrbp_1_6.RESET_B a_422_5850# VPWR sg13_lv_pmos ad=0.36237p pd=2.605u as=79.8f ps=0.8u w=0.42u l=0.13u
X620 a_13460_7996# a_13047_7690# a_13392_7996# VPWR sg13_lv_pmos ad=0.191p pd=1.44u as=0.105p ps=1.21u w=1u l=0.13u
X621 VPWR a_2409_4650# a_2342_5088# VPWR sg13_lv_pmos ad=0.2387p pd=1.84u as=0.1008p ps=0.9u w=0.42u l=0.13u
X622 a_15974_6162# a_16779_6284# a_16234_6385# VPWR sg13_lv_pmos ad=0.1428p pd=1.52u as=79.8f ps=0.8u w=0.42u l=0.13u
X623 a_7257_4023# a_6315_3911# a_7055_4261# VPWR sg13_lv_pmos ad=93.45f pd=0.865u as=0.2048p ps=1.63u w=0.42u l=0.13u
X624 a_13648_9406# sg13cmos5l_dfrbp_1_8.RESET_B VPWR VPWR sg13_lv_pmos ad=79.8f pd=0.8u as=4.11675p ps=27.17u w=0.42u l=0.13u
X625 VPWR a_11567_7751# a_11824_7894# VPWR sg13_lv_pmos ad=0.2639p pd=1.81u as=79.8f ps=0.8u w=0.42u l=0.13u
X626 a_10071_7282# sg13cmos5l_dfrbp_1_18.Q VPWR VPWR sg13_lv_pmos ad=0.3234p pd=2.45u as=1.07253p ps=6.75u w=0.84u l=0.13u
X627 VPWR sg13cmos5l_buf_1_33.A a_2248_1664# VPWR sg13_lv_pmos ad=0.2114p pd=1.54u as=0.2856p ps=2.36u w=0.84u l=0.13u
X628 VGND VPWR VGND VGND sg13_lv_nmos ad=79.8f pd=0.8u as=0 ps=0 w=0.42u l=1u
X629 VPWR a_14032_6382# a_13977_6477# VPWR sg13_lv_pmos ad=1.07253p pd=6.75u as=93.45f ps=0.865u w=0.42u l=0.13u
X630 sg13cmos5l_buf_1_8.X a_10888_1664# VGND VGND sg13_lv_nmos ad=0.2886p pd=2.26u as=0.14875p ps=1.16u w=0.74u l=0.13u
X631 VPWR a_9033_6162# a_9558_6144# VPWR sg13_lv_pmos ad=0.1974p pd=1.5u as=0.2856p ps=2.36u w=0.84u l=0.13u
X632 a_682_6892# a_1125_6935# a_1065_6971# VPWR sg13_lv_pmos ad=79.8f pd=0.8u as=63f ps=0.72u w=0.42u l=0.13u
X633 a_15884_3102# sg13cmos5l_buf_1_5.X VGND VGND sg13_lv_nmos ad=0.187p pd=1.78u as=0.14875p ps=1.16u w=0.55u l=0.13u
X634 a_15110_5412# a_14714_5776# a_14996_5412# VPWR sg13_lv_pmos ad=0.1008p pd=0.9u as=0.191p ps=1.44u w=0.42u l=0.13u
X635 VPWR sg13cmos5l_dfrbp_1_6.RESET_B a_15974_6162# VPWR sg13_lv_pmos ad=0.36237p pd=2.605u as=79.8f ps=0.8u w=0.42u l=0.13u
X636 VGND a_3692_9150# sg13cmos5l_buf_1_62.X VGND sg13_lv_nmos ad=0.14875p pd=1.16u as=0.2886p ps=2.26u w=0.74u l=0.13u
X637 a_8772_8440# a_9291_8447# a_10031_8797# VGND sg13_lv_nmos ad=0.3473p pd=2.71u as=0.12665p ps=1.145u w=0.74u l=0.13u
X638 a_7238_7674# sg13cmos5l_dfrbp_1_6.D VPWR VPWR sg13_lv_pmos ad=79.8f pd=0.8u as=0.1428p ps=1.52u w=0.42u l=0.13u
X639 a_6346_4873# a_6789_4629# a_6729_5041# VPWR sg13_lv_pmos ad=79.8f pd=0.8u as=63f ps=0.72u w=0.42u l=0.13u
X640 VPWR sg13cmos5l_buf_8_1.A a_16703_3871# VPWR sg13_lv_pmos ad=1.43437p pd=9.105u as=0.4088p ps=2.97u w=1.12u l=0.13u
X641 VGND a_5673_3138# a_5628_3174# VGND sg13_lv_nmos ad=0.1428p pd=1.52u as=47.25f ps=0.645u w=0.42u l=0.13u
X642 sg13cmos5l_buf_1_90.X a_11464_9224# VPWR VPWR sg13_lv_pmos ad=0.42p pd=2.99u as=0.2114p ps=1.54u w=1.12u l=0.13u
X643 a_13641_7674# a_13460_7996# VPWR VPWR sg13_lv_pmos ad=0.2128p pd=1.5u as=0.2387p ps=1.84u w=1.12u l=0.13u
X644 sg13cmos5l_nor2b_1_1.Y a_14254_2444# VGND VGND sg13_lv_nmos ad=0.1406p pd=1.12u as=0.17255p ps=1.25u w=0.74u l=0.13u
X645 d_out[2] a_20392_3900# VGND VGND sg13_lv_nmos ad=0.2886p pd=2.26u as=0.14875p ps=1.16u w=0.74u l=0.13u
X646 a_12719_2749# a_11877_2399# a_11460_2392# VPWR sg13_lv_pmos ad=0.2048p pd=1.63u as=0.34p ps=2.68u w=1u l=0.13u
X647 a_12976_2630# sg13cmos5l_dfrbp_1_0.RESET_B VPWR VPWR sg13_lv_pmos ad=79.8f pd=0.8u as=1.777p ps=11.395u w=0.42u l=0.13u
X648 a_10726_5760# sg13cmos5l_dfrbp_1_20.Q sg13cmos5l_a22oi_1_2.B2 VGND sg13_lv_nmos ad=0.1406p pd=1.12u as=0.2516p ps=2.16u w=0.74u l=0.13u
X649 sg13cmos5l_buf_1_65.X a_424_8436# VPWR VPWR sg13_lv_pmos ad=0.42p pd=2.99u as=0.2114p ps=1.54u w=1.12u l=0.13u
X650 a_8439_6178# sg13cmos5l_dlhr_1_5.GATE VPWR VPWR sg13_lv_pmos ad=0.3234p pd=2.45u as=1.04815p ps=6.595u w=0.84u l=0.13u
X651 VGND VPWR VGND VGND sg13_lv_nmos ad=0.1428p pd=1.52u as=0 ps=0 w=0.42u l=1u
X652 VPWR a_7941_7653# a_8043_7796# VPWR sg13_lv_pmos ad=1.15047p pd=7.175u as=0.3864p ps=2.93u w=1.12u l=0.13u
X653 a_16293_4629# sg13cmos5l_inv_1_2.A VGND VGND sg13_lv_nmos ad=0.2516p pd=2.16u as=2.41737p ps=15.64u w=0.74u l=0.13u
X654 a_9638_5088# a_9242_4660# a_9524_4972# VPWR sg13_lv_pmos ad=0.1008p pd=0.9u as=0.191p ps=1.44u w=0.42u l=0.13u
X655 VGND sg13cmos5l_inv_1_1.A a_16264_9224# VGND sg13_lv_nmos ad=0.14875p pd=1.16u as=0.187p ps=1.78u w=0.55u l=0.13u
X656 a_5908_3124# a_5492_3460# a_5673_3138# VGND sg13_lv_nmos ad=77.7f pd=0.95u as=0.2516p ps=2.16u w=0.74u l=0.13u
X657 a_9033_6162# a_8852_6484# VPWR VPWR sg13_lv_pmos ad=0.2128p pd=1.5u as=0.2387p ps=1.84u w=1.12u l=0.13u
X658 sg13cmos5l_dfrbp_1_17.D a_1662_8374# VPWR VPWR sg13_lv_pmos ad=0.3927p pd=2.99u as=1.15047p ps=7.175u w=1.155u l=0.13u
X659 sg13cmos5l_dfrbp_1_15.D a_4244_8436# VGND VGND sg13_lv_nmos ad=0.2516p pd=2.16u as=0.1406p ps=1.12u w=0.74u l=0.13u
X660 VPWR VGND VPWR VPWR sg13_lv_pmos ad=0.34p pd=2.68u as=0 ps=0 w=1u l=1u
X661 a_6405_8447# sg13cmos5l_inv_1_8.A VGND VGND sg13_lv_nmos ad=0.2516p pd=2.16u as=2.71505p ps=17.54u w=0.74u l=0.13u
X662 VPWR a_16485_6935# a_16587_6935# VPWR sg13_lv_pmos ad=1.07253p pd=6.75u as=0.3864p ps=2.93u w=1.12u l=0.13u
X663 sg13cmos5l_dlhr_1_0.Q a_7689_1626# VPWR VPWR sg13_lv_pmos ad=0.3808p pd=2.92u as=0.2128p ps=1.5u w=1.12u l=0.13u
X664 a_8204_9150# sg13cmos5l_buf_1_45.X VGND VGND sg13_lv_nmos ad=0.187p pd=1.78u as=0.14875p ps=1.16u w=0.55u l=0.13u
X665 VPWR a_20012_1590# sg13cmos5l_buf_1_0.X VPWR sg13_lv_pmos ad=0.2114p pd=1.54u as=0.42p ps=2.99u w=1.12u l=0.13u
X666 a_10288_8678# sg13cmos5l_dfrbp_1_8.RESET_B VPWR VPWR sg13_lv_pmos ad=79.8f pd=0.8u as=1.12242p ps=7u w=0.42u l=0.13u
X667 VGND sg13cmos5l_dlhr_1_12.D a_17161_8794# VGND sg13_lv_nmos ad=0.15055p pd=1.17u as=0.187p ps=1.78u w=0.55u l=0.13u
X668 a_7316_3460# a_6903_3154# a_7248_3460# VPWR sg13_lv_pmos ad=0.191p pd=1.44u as=0.105p ps=1.21u w=1u l=0.13u
X669 VPWR a_7888_4870# a_7833_4965# VPWR sg13_lv_pmos ad=1.28962p pd=8.195u as=93.45f ps=0.865u w=0.42u l=0.13u
X670 VGND sg13cmos5l_a221oi_1_1.C1 sg13cmos5l_a22oi_1_2.B2 VGND sg13_lv_nmos ad=0.1406p pd=1.12u as=0.2516p ps=2.16u w=0.74u l=0.13u
X671 a_9060_8861# a_9291_8447# a_8746_8404# VGND sg13_lv_nmos ad=0.2373p pd=1.97u as=79.8f ps=0.8u w=0.42u l=0.13u
X672 VGND sg13cmos5l_buf_1_34.A a_4840_1664# VGND sg13_lv_nmos ad=0.14875p pd=1.16u as=0.187p ps=1.78u w=0.55u l=0.13u
X673 VPWR a_12815_1703# a_13652_1924# VPWR sg13_lv_pmos ad=0.2128p pd=1.5u as=0.3864p ps=2.93u w=1.12u l=0.13u
X674 VGND a_1158_3142# a_1290_3206# VGND sg13_lv_nmos ad=0.1405p pd=1.15u as=0.2163p ps=1.87u w=0.42u l=0.18u
X675 sg13cmos5l_dfrbp_1_20.Q_N a_8783_7751# VPWR VPWR sg13_lv_pmos ad=0.4312p pd=3.01u as=0.2639p ps=1.81u w=1.12u l=0.13u
X676 a_6903_3154# sg13cmos5l_dlhr_1_0.GATE VGND VGND sg13_lv_nmos ad=0.2516p pd=2.16u as=0.15055p ps=1.17u w=0.74u l=0.13u
X677 sg13cmos5l_dfrbp_1_25.Q_N a_15887_8797# VPWR VPWR sg13_lv_pmos ad=0.4312p pd=3.01u as=0.2639p ps=1.81u w=1.12u l=0.13u
X678 a_2638_6162# a_2879_6432# a_1997_6126# VGND sg13_lv_nmos ad=0.1428p pd=1.52u as=0.12665p ps=1.145u w=0.42u l=0.13u
X679 VGND a_4425_7281# a_4380_7326# VGND sg13_lv_nmos ad=0.1428p pd=1.52u as=47.25f ps=0.645u w=0.42u l=0.13u
X680 a_6372_4968# a_6891_4772# a_7631_4727# VGND sg13_lv_nmos ad=0.3473p pd=2.71u as=0.12665p ps=1.145u w=0.74u l=0.13u
X681 VGND VPWR VGND VGND sg13_lv_nmos ad=0.1428p pd=1.52u as=0 ps=0 w=0.42u l=1u
X682 VPWR sg13cmos5l_buf_1_5.A a_14440_1664# VPWR sg13_lv_pmos ad=0.2114p pd=1.54u as=0.2856p ps=2.36u w=0.84u l=0.13u
X683 VPWR a_5132_3864# sg13cmos5l_buf_1_44.X VPWR sg13_lv_pmos ad=0.2114p pd=1.54u as=0.42p ps=2.99u w=1.12u l=0.13u
X684 VPWR VGND VPWR VPWR sg13_lv_pmos ad=0.34p pd=2.68u as=0 ps=0 w=1u l=1u
X685 a_10900_7312# a_10484_6924# a_10665_7281# VGND sg13_lv_nmos ad=77.7f pd=0.95u as=0.2516p ps=2.16u w=0.74u l=0.13u
X686 a_10331_3900# sg13cmos5l_nand2_1_1.B sg13cmos5l_a22oi_1_1.B1 VPWR sg13_lv_pmos ad=0.2128p pd=1.5u as=0.3808p ps=2.92u w=1.12u l=0.13u
X687 VPWR sg13cmos5l_dfrbp_1_6.RESET_B a_5414_6162# VPWR sg13_lv_pmos ad=0.36237p pd=2.605u as=79.8f ps=0.8u w=0.42u l=0.13u
X688 sg13cmos5l_dfrbp_1_16.Q a_2804_6924# VPWR VPWR sg13_lv_pmos ad=0.3808p pd=2.92u as=0.2128p ps=1.5u w=1.12u l=0.13u
X689 a_9076_5800# a_8660_5412# a_8841_5769# VGND sg13_lv_nmos ad=77.7f pd=0.95u as=0.2516p ps=2.16u w=0.74u l=0.13u
X690 a_14726_7674# sg13cmos5l_buf_1_57.X VPWR VPWR sg13_lv_pmos ad=79.8f pd=0.8u as=0.1428p ps=1.52u w=0.42u l=0.13u
X691 a_16233_5041# a_15876_4968# VPWR VPWR sg13_lv_pmos ad=63f pd=0.72u as=0.1563p ps=1.22u w=0.42u l=0.13u
X692 a_5220_2392# a_5739_2399# a_6479_2749# VGND sg13_lv_nmos ad=0.3473p pd=2.71u as=0.12665p ps=1.145u w=0.74u l=0.13u
X693 a_14602_8404# a_15045_8447# a_14985_8483# VPWR sg13_lv_pmos ad=79.8f pd=0.8u as=63f ps=0.72u w=0.42u l=0.13u
X694 a_11556_1944# a_11530_1849# VPWR VPWR sg13_lv_pmos ad=0.34p pd=2.68u as=0.36237p ps=2.605u w=1u l=0.13u
X695 VPWR sg13cmos5l_dfrbp_1_6.RESET_B a_5673_3138# VPWR sg13_lv_pmos ad=0.2128p pd=1.5u as=0.2128p ps=1.5u w=1.12u l=0.13u
X696 a_19628_2352# sg13cmos5l_buf_1_19.X VGND VGND sg13_lv_nmos ad=0.187p pd=1.78u as=0.14875p ps=1.16u w=0.55u l=0.13u
X697 VPWR sg13cmos5l_inv_1_29.A sg13cmos5l_inv_1_29.Y VPWR sg13_lv_pmos ad=0.3808p pd=2.92u as=0.3808p ps=2.92u w=1.12u l=0.13u
X698 sg13cmos5l_buf_1_40.X a_1192_1664# VPWR VPWR sg13_lv_pmos ad=0.42p pd=2.99u as=0.2114p ps=1.54u w=1.12u l=0.13u
X699 VPWR sg13cmos5l_buf_1_104.A a_19624_8436# VPWR sg13_lv_pmos ad=0.2114p pd=1.54u as=0.2856p ps=2.36u w=0.84u l=0.13u
X700 sg13cmos5l_buf_1_18.X a_18376_2388# VGND VGND sg13_lv_nmos ad=0.2886p pd=2.26u as=0.14875p ps=1.16u w=0.74u l=0.13u
X701 a_17399_3947# a_16703_3871# a_17493_3947# VGND sg13_lv_nmos ad=0.1296p pd=1.52u as=79.8f ps=0.8u w=0.42u l=0.13u
X702 sg13cmos5l_nand2_1_0.A sg13cmos5l_dfrbp_1_0.Q VGND VGND sg13_lv_nmos ad=0.1406p pd=1.12u as=0.2516p ps=2.16u w=0.74u l=0.13u
X703 VGND sg13cmos5l_o21ai_1_0.A1 a_12022_3134# VGND sg13_lv_nmos ad=0.1406p pd=1.12u as=0.2516p ps=2.16u w=0.74u l=0.15u
X704 sg13cmos5l_dfrbp_1_8.D a_18164_6924# VPWR VPWR sg13_lv_pmos ad=0.3808p pd=2.92u as=0.2128p ps=1.5u w=1.12u l=0.13u
X705 VPWR sg13cmos5l_dfrbp_1_6.RESET_B a_5194_2356# VPWR sg13_lv_pmos ad=0.1563p pd=1.22u as=0.147p ps=1.54u w=0.42u l=0.13u
X706 a_17700_3456# a_17674_3361# VGND VGND sg13_lv_nmos ad=0.2516p pd=2.16u as=0.1626p ps=1.415u w=0.74u l=0.13u
X707 sg13cmos5l_dlhr_1_19.Q_N a_15702_5842# VPWR VPWR sg13_lv_pmos ad=0.3808p pd=2.92u as=0.1974p ps=1.5u w=1.12u l=0.13u
X708 sg13cmos5l_dfrbp_1_4.Q_N a_12719_2749# VPWR VPWR sg13_lv_pmos ad=0.4312p pd=3.01u as=0.2639p ps=1.81u w=1.12u l=0.13u
X709 a_1580_2352# sg13cmos5l_buf_1_40.X VPWR VPWR sg13_lv_pmos ad=0.2856p pd=2.36u as=0.2114p ps=1.54u w=0.84u l=0.13u
X710 VGND sg13cmos5l_dfrbp_1_6.RESET_B a_7332_7674# VGND sg13_lv_nmos ad=0.1626p pd=1.415u as=60.89999f ps=0.71u w=0.42u l=0.13u
X711 sg13cmos5l_buf_1_101.X a_16264_9224# VPWR VPWR sg13_lv_pmos ad=0.42p pd=2.99u as=0.2114p ps=1.54u w=1.12u l=0.13u
X712 VGND VPWR VGND VGND sg13_lv_nmos ad=0.1428p pd=1.52u as=0 ps=0 w=0.42u l=1u
X713 a_19209_5769# a_19028_5412# VPWR VPWR sg13_lv_pmos ad=0.2128p pd=1.5u as=0.2387p ps=1.84u w=1.12u l=0.13u
X714 a_7452_3174# a_6903_3154# a_7316_3460# VGND sg13_lv_nmos ad=47.25f pd=0.645u as=0.141p ps=1.17u w=0.42u l=0.13u
X715 VGND a_4847_4727# a_5684_4948# VGND sg13_lv_nmos ad=0.1406p pd=1.12u as=0.2516p ps=2.16u w=0.74u l=0.13u
X716 VGND a_14800_3358# a_14449_3215# VGND sg13_lv_nmos ad=79.8f pd=0.8u as=0.1428p ps=1.52u w=0.42u l=0.13u
X717 VPWR a_12216_5728# sg13cmos5l_a221oi_1_0.B1 VPWR sg13_lv_pmos ad=0.2226p pd=1.535u as=0.3976p ps=2.95u w=1.12u l=0.13u
X718 a_11844_1639# a_12075_1748# a_11530_1849# VGND sg13_lv_nmos ad=0.2373p pd=1.97u as=79.8f ps=0.8u w=0.42u l=0.13u
X719 a_2148_3904# a_2667_3911# a_3407_4261# VGND sg13_lv_nmos ad=0.3473p pd=2.71u as=0.12665p ps=1.145u w=0.74u l=0.13u
X720 a_18960_5412# a_18409_5770# VPWR VPWR sg13_lv_pmos ad=0.105p pd=1.21u as=1.28962p ps=8.195u w=1u l=0.13u
X721 a_19345_6154# a_18793_6216# VGND VGND sg13_lv_nmos ad=71.99999f pd=0.865u as=1.97045p ps=12.335u w=0.64u l=0.13u
X722 VGND VPWR VGND VGND sg13_lv_nmos ad=0.1428p pd=1.52u as=0 ps=0 w=0.42u l=1u
X723 a_11530_3868# a_11973_3911# a_11913_3947# VPWR sg13_lv_pmos ad=79.8f pd=0.8u as=63f ps=0.72u w=0.42u l=0.13u
X724 VPWR a_8204_2352# sg13cmos5l_buf_1_24.A VPWR sg13_lv_pmos ad=0.2114p pd=1.54u as=0.42p ps=2.99u w=1.12u l=0.13u
X725 a_6057_6553# a_5700_6480# VPWR VPWR sg13_lv_pmos ad=63f pd=0.72u as=0.1563p ps=1.22u w=0.42u l=0.13u
X726 VGND a_13161_7281# a_13686_7354# VGND sg13_lv_nmos ad=0.1491p pd=1.18u as=0.187p ps=1.78u w=0.55u l=0.13u
X727 sg13cmos5l_nor2_1_1.A a_17588_2388# VPWR VPWR sg13_lv_pmos ad=0.3808p pd=2.92u as=0.2128p ps=1.5u w=1.12u l=0.13u
X728 VPWR a_9705_4650# a_10230_4632# VPWR sg13_lv_pmos ad=0.1974p pd=1.5u as=0.2856p ps=2.36u w=0.84u l=0.13u
X729 a_16548_6175# a_16260_6480# a_16486_6175# VGND sg13_lv_nmos ad=0.1428p pd=1.52u as=37.8f ps=0.6u w=0.42u l=0.13u
X730 VGND sg13cmos5l_dfrbp_1_0.RESET_B a_15300_2826# VGND sg13_lv_nmos ad=0.1626p pd=1.415u as=60.89999f ps=0.71u w=0.42u l=0.13u
X731 a_3447_2746# sg13cmos5l_dfrbp_1_9.Q VPWR VPWR sg13_lv_pmos ad=0.3234p pd=2.45u as=1.86162p ps=11.935u w=0.84u l=0.13u
X732 a_2436_8861# a_2667_8447# a_2122_8404# VGND sg13_lv_nmos ad=0.2373p pd=1.97u as=79.8f ps=0.8u w=0.42u l=0.13u
X733 VPWR sg13cmos5l_buf_1_4.A a_16552_1664# VPWR sg13_lv_pmos ad=0.2114p pd=1.54u as=0.2856p ps=2.36u w=0.84u l=0.13u
X734 VPWR a_17367_8794# a_17498_8800# VPWR sg13_lv_pmos ad=1.15047p pd=7.175u as=0.2856p ps=2.36u w=0.84u l=0.13u
X735 a_620_2352# sg13cmos5l_buf_1_32.X VPWR VPWR sg13_lv_pmos ad=0.2856p pd=2.36u as=0.2114p ps=1.54u w=0.84u l=0.13u
X736 a_18146_4338# sg13cmos5l_dfrbp_1_6.RESET_B VGND VGND sg13_lv_nmos ad=60.89999f pd=0.71u as=0.1626p ps=1.415u w=0.42u l=0.13u
X737 a_3669_6320# a_2727_6380# a_3575_6553# VPWR sg13_lv_pmos ad=79.8f pd=0.8u as=0.1428p ps=1.52u w=0.42u l=0.13u
X738 a_12815_4261# a_11973_3911# a_12721_4261# VGND sg13_lv_nmos ad=0.12665p pd=1.145u as=0.1428p ps=1.52u w=0.42u l=0.13u
X739 VGND sg13cmos5l_buf_1_60.X a_2248_9224# VGND sg13_lv_nmos ad=0.14875p pd=1.16u as=0.187p ps=1.78u w=0.55u l=0.13u
X740 VPWR VGND VPWR VPWR sg13_lv_pmos ad=0.19p pd=1.38u as=0 ps=0 w=1u l=1u
X741 a_10308_7992# a_10282_7897# VGND VGND sg13_lv_nmos ad=0.2516p pd=2.16u as=0.1626p ps=1.415u w=0.74u l=0.13u
X742 ph_sw[1] a_1864_9224# VGND VGND sg13_lv_nmos ad=0.2886p pd=2.26u as=0.14875p ps=1.16u w=0.74u l=0.13u
X743 a_18671_1703# a_17829_1605# a_18577_1703# VGND sg13_lv_nmos ad=0.12665p pd=1.145u as=0.1428p ps=1.52u w=0.42u l=0.13u
X744 a_6741_5459# a_5799_5499# a_6602_5692# VGND sg13_lv_nmos ad=79.8f pd=0.8u as=0.2373p ps=1.97u w=0.42u l=0.13u
X745 VPWR a_17519_6239# a_18356_6460# VPWR sg13_lv_pmos ad=0.2128p pd=1.5u as=0.3864p ps=2.93u w=1.12u l=0.13u
X746 VPWR a_1196_8400# sg13cmos5l_buf_1_63.X VPWR sg13_lv_pmos ad=0.2114p pd=1.54u as=0.42p ps=2.99u w=1.12u l=0.13u
X747 a_17780_8436# a_17498_8800# a_17713_8838# VGND sg13_lv_nmos ad=0.141p pd=1.17u as=71.99999f ps=0.865u w=0.64u l=0.13u
X748 VGND a_3676_7964# sg13cmos5l_dlhr_1_9.Q VGND sg13_lv_nmos ad=0.1406p pd=1.12u as=0.2516p ps=2.16u w=0.74u l=0.13u
X749 sg13cmos5l_dfrbp_1_20.Q a_9620_7972# VPWR VPWR sg13_lv_pmos ad=0.3808p pd=2.92u as=0.2128p ps=1.5u w=1.12u l=0.13u
X750 sg13cmos5l_dfrbp_1_22.D a_16724_8436# VPWR VPWR sg13_lv_pmos ad=0.3808p pd=2.92u as=0.2128p ps=1.5u w=1.12u l=0.13u
X751 a_3676_7964# a_4076_7624# a_4034_7660# VGND sg13_lv_nmos ad=0.2516p pd=2.16u as=77.7f ps=0.95u w=0.74u l=0.13u
X752 a_13391_9263# a_12549_9165# a_13297_9263# VGND sg13_lv_nmos ad=0.12665p pd=1.145u as=0.1428p ps=1.52u w=0.42u l=0.13u
X753 VGND sg13cmos5l_inv_1_26.Y a_17896_9224# VGND sg13_lv_nmos ad=0.14875p pd=1.16u as=0.187p ps=1.78u w=0.55u l=0.13u
X754 a_18615_5770# sg13cmos5l_dfrbp_1_8.D VPWR VPWR sg13_lv_pmos ad=0.3234p pd=2.45u as=1.28962p ps=8.195u w=0.84u l=0.13u
X755 a_1862_4338# a_2667_3911# a_2122_3868# VPWR sg13_lv_pmos ad=0.1428p pd=1.52u as=79.8f ps=0.8u w=0.42u l=0.13u
X756 VGND a_8588_3864# sg13cmos5l_buf_1_30.A VGND sg13_lv_nmos ad=0.14875p pd=1.16u as=0.2886p ps=2.26u w=0.74u l=0.13u
X757 a_16677_6141# sg13cmos5l_dfrbp_1_8.D VGND VGND sg13_lv_nmos ad=0.2516p pd=2.16u as=1.97045p ps=12.335u w=0.74u l=0.13u
X758 VPWR a_12549_9165# a_12651_9308# VPWR sg13_lv_pmos ad=4.11675p pd=27.17u as=0.3864p ps=2.93u w=1.12u l=0.13u
X759 VGND a_17961_8793# a_17916_8838# VGND sg13_lv_nmos ad=0.1428p pd=1.52u as=47.25f ps=0.645u w=0.42u l=0.13u
X760 nl_sw[1] a_1864_1664# VPWR VPWR sg13_lv_pmos ad=0.42p pd=2.99u as=0.2114p ps=1.54u w=1.12u l=0.13u
X761 VGND sg13cmos5l_dfrbp_1_6.RESET_B a_15124_7312# VGND sg13_lv_nmos ad=0.1406p pd=1.12u as=77.7f ps=0.95u w=0.74u l=0.13u
X762 a_18671_1703# a_17829_1605# a_17412_1944# VPWR sg13_lv_pmos ad=0.2048p pd=1.63u as=0.34p ps=2.68u w=1u l=0.13u
X763 a_10783_4292# sg13cmos5l_a22oi_1_0.B1 VGND VGND sg13_lv_nmos ad=0.13875p pd=1.115u as=0.2553p ps=2.17u w=0.74u l=0.13u
X764 a_8276_6924# a_7863_7282# a_8208_6924# VPWR sg13_lv_pmos ad=0.191p pd=1.44u as=0.105p ps=1.21u w=1u l=0.13u
X765 a_13572_3151# a_13284_3456# a_13510_3151# VGND sg13_lv_nmos ad=0.1428p pd=1.52u as=37.8f ps=0.6u w=0.42u l=0.13u
X766 a_20204_5376# sg13cmos5l_dlhr_1_16.Q VGND VGND sg13_lv_nmos ad=0.187p pd=1.78u as=0.14875p ps=1.16u w=0.55u l=0.13u
X767 a_3609_8559# a_2667_8447# a_3407_8797# VPWR sg13_lv_pmos ad=93.45f pd=0.865u as=0.2048p ps=1.63u w=0.42u l=0.13u
X768 VPWR a_4847_4727# a_5104_4870# VPWR sg13_lv_pmos ad=0.2639p pd=1.81u as=79.8f ps=0.8u w=0.42u l=0.13u
X769 sg13cmos5l_dfrbp_1_6.RESET_B cks VPWR VPWR sg13_lv_pmos ad=0.2128p pd=1.5u as=0.2128p ps=1.5u w=1.12u l=0.13u
X770 VPWR sg13cmos5l_buf_1_35.A a_1864_1664# VPWR sg13_lv_pmos ad=0.2114p pd=1.54u as=0.2856p ps=2.36u w=0.84u l=0.13u
X771 a_3664_4142# sg13cmos5l_dfrbp_1_8.RESET_B VPWR VPWR sg13_lv_pmos ad=79.8f pd=0.8u as=1.43437p ps=9.105u w=0.42u l=0.13u
X772 sg13cmos5l_dlhr_1_19.Q_N a_15702_5842# VGND VGND sg13_lv_nmos ad=0.2516p pd=2.16u as=0.1491p ps=1.18u w=0.74u l=0.13u
X773 a_15132_5814# a_14583_5770# a_14996_5412# VGND sg13_lv_nmos ad=47.25f pd=0.645u as=0.141p ps=1.17u w=0.42u l=0.13u
X774 sg13cmos5l_buf_1_95.X a_12232_8436# VPWR VPWR sg13_lv_pmos ad=0.42p pd=2.99u as=0.2114p ps=1.54u w=1.12u l=0.13u
X775 a_16260_6480# a_16234_6385# VPWR VPWR sg13_lv_pmos ad=0.34p pd=2.68u as=0.36237p ps=2.605u w=1u l=0.13u
X776 a_9189_8447# sg13cmos5l_inv_1_2.A VGND VGND sg13_lv_nmos ad=0.2516p pd=2.16u as=2.71505p ps=17.54u w=0.74u l=0.13u
X777 a_3599_3215# a_2757_3117# a_2340_3456# VPWR sg13_lv_pmos ad=0.2048p pd=1.63u as=0.34p ps=2.68u w=1u l=0.13u
X778 a_8785_6154# a_8233_6216# VGND VGND sg13_lv_nmos ad=71.99999f pd=0.865u as=1.97045p ps=12.335u w=0.64u l=0.13u
X779 VGND sg13cmos5l_buf_8_0.X a_20392_7712# VGND sg13_lv_nmos ad=0.14875p pd=1.16u as=0.187p ps=1.78u w=0.55u l=0.13u
X780 sg13cmos5l_dfrbp_1_1.Q_N a_12815_1703# VGND VGND sg13_lv_nmos ad=0.2849p pd=2.25u as=0.2516p ps=2.16u w=0.74u l=0.13u
X781 a_15177_5769# a_14996_5412# VPWR VPWR sg13_lv_pmos ad=0.2128p pd=1.5u as=0.2387p ps=1.84u w=1.12u l=0.13u
X782 a_17776_6382# sg13cmos5l_dfrbp_1_6.RESET_B VPWR VPWR sg13_lv_pmos ad=79.8f pd=0.8u as=1.04815p ps=6.595u w=0.42u l=0.13u
X783 VPWR a_12933_6141# a_13035_6284# VPWR sg13_lv_pmos ad=1.07253p pd=6.75u as=0.3864p ps=2.93u w=1.12u l=0.13u
X784 a_5577_2435# a_5220_2392# VPWR VPWR sg13_lv_pmos ad=63f pd=0.72u as=0.1563p ps=1.22u w=0.42u l=0.13u
X785 VPWR a_3669_6320# a_2748_6126# VPWR sg13_lv_pmos ad=0.36237p pd=2.605u as=0.34p ps=2.68u w=1u l=0.13u
X786 a_3692_9150# sg13cmos5l_inv_1_17.A VGND VGND sg13_lv_nmos ad=0.187p pd=1.78u as=0.14875p ps=1.16u w=0.55u l=0.13u
X787 VGND sg13cmos5l_dfrbp_1_21.Q_N a_18793_6216# VGND sg13_lv_nmos ad=0.15055p pd=1.17u as=0.187p ps=1.78u w=0.55u l=0.13u
X788 VPWR a_2348_7624# a_1948_7964# VPWR sg13_lv_pmos ad=0.2387p pd=1.84u as=0.2128p ps=1.5u w=1.12u l=0.13u
X789 a_1210_4654# sg13cmos5l_inv_1_8.Y sg13cmos5l_dlygate4sd2_1_0.A VGND sg13_lv_nmos ad=0.1406p pd=1.12u as=0.2516p ps=2.16u w=0.74u l=0.13u
X790 a_5988_6175# a_5700_6480# a_5926_6175# VGND sg13_lv_nmos ad=0.1428p pd=1.52u as=37.8f ps=0.6u w=0.42u l=0.13u
X791 VPWR a_9164_1590# sg13cmos5l_buf_1_26.X VPWR sg13_lv_pmos ad=0.2114p pd=1.54u as=0.42p ps=2.99u w=1.12u l=0.13u
X792 sg13cmos5l_dfrbp_1_3.Q_N a_18959_3215# VPWR VPWR sg13_lv_pmos ad=0.4312p pd=3.01u as=0.2639p ps=1.81u w=1.12u l=0.13u
X793 a_8972_9150# sg13cmos5l_buf_1_77.A VGND VGND sg13_lv_nmos ad=0.187p pd=1.78u as=0.14875p ps=1.16u w=0.55u l=0.13u
X794 a_5799_5499# a_5951_5383# VGND VGND sg13_lv_nmos ad=0.2516p pd=2.16u as=1.97045p ps=12.335u w=0.74u l=0.13u
X795 VPWR a_6959_6239# a_7796_6460# VPWR sg13_lv_pmos ad=0.2128p pd=1.5u as=0.3864p ps=2.93u w=1.12u l=0.13u
X796 VPWR a_2732_9150# sg13cmos5l_buf_1_61.X VPWR sg13_lv_pmos ad=0.2114p pd=1.54u as=0.42p ps=2.99u w=1.12u l=0.13u
X797 sg13cmos5l_nor2b_1_0.Y sg13cmos5l_inv_1_0.A a_13036_4948# VPWR sg13_lv_pmos ad=0.3808p pd=2.92u as=0.1176p ps=1.33u w=1.12u l=0.13u
X798 a_7820_9150# sg13cmos5l_buf_1_73.A VGND VGND sg13_lv_nmos ad=0.187p pd=1.78u as=0.14875p ps=1.16u w=0.55u l=0.13u
X799 VPWR VGND VPWR VPWR sg13_lv_pmos ad=0.19p pd=1.38u as=0 ps=0 w=1u l=1u
X800 a_10707_2388# sg13cmos5l_nor2_1_0.A VPWR VPWR sg13_lv_pmos ad=0.1428p pd=1.375u as=0.2891p ps=1.695u w=1.12u l=0.13u
X801 sg13cmos5l_dfrbp_1_11.Q a_8468_4948# VGND VGND sg13_lv_nmos ad=0.2516p pd=2.16u as=0.1406p ps=1.12u w=0.74u l=0.13u
X802 a_7631_4727# a_6789_4629# a_7537_4727# VGND sg13_lv_nmos ad=0.12665p pd=1.145u as=0.1428p ps=1.52u w=0.42u l=0.13u
X803 a_3407_4261# a_2565_3911# a_3313_4261# VGND sg13_lv_nmos ad=0.12665p pd=1.145u as=0.1428p ps=1.52u w=0.42u l=0.13u
X804 VPWR sg13cmos5l_buf_1_30.A a_8680_1664# VPWR sg13_lv_pmos ad=0.2114p pd=1.54u as=0.2856p ps=2.36u w=0.84u l=0.13u
X805 a_5492_3460# a_5079_3154# a_5424_3460# VPWR sg13_lv_pmos ad=0.191p pd=1.44u as=0.105p ps=1.21u w=1u l=0.13u
X806 a_7863_7282# sg13cmos5l_dlhr_1_5.GATE VGND VGND sg13_lv_nmos ad=0.2516p pd=2.16u as=0.15055p ps=1.17u w=0.74u l=0.13u
X807 a_14800_3358# sg13cmos5l_dfrbp_1_0.RESET_B VPWR VPWR sg13_lv_pmos ad=79.8f pd=0.8u as=1.38655p ps=8.8u w=0.42u l=0.13u
X808 pl_sw[2] a_2248_9224# VPWR VPWR sg13_lv_pmos ad=0.42p pd=2.99u as=0.2114p ps=1.54u w=1.12u l=0.13u
X809 a_2148_8440# a_2122_8404# VGND VGND sg13_lv_nmos ad=0.2516p pd=2.16u as=0.1626p ps=1.415u w=0.74u l=0.13u
X810 a_6117_6141# sg13cmos5l_dlhr_1_5.GATE VGND VGND sg13_lv_nmos ad=0.2516p pd=2.16u as=1.97045p ps=12.335u w=0.74u l=0.13u
X811 a_16268_3102# sg13cmos5l_buf_1_2.X VPWR VPWR sg13_lv_pmos ad=0.2856p pd=2.36u as=0.2114p ps=1.54u w=0.84u l=0.13u
X812 sg13cmos5l_buf_1_1.A a_14056_1664# VPWR VPWR sg13_lv_pmos ad=0.42p pd=2.99u as=0.2114p ps=1.54u w=1.12u l=0.13u
X813 VPWR sg13cmos5l_dfrbp_1_8.RESET_B a_16042_6892# VPWR sg13_lv_pmos ad=0.1563p pd=1.22u as=0.147p ps=1.54u w=0.42u l=0.13u
X814 a_14583_5770# sg13cmos5l_dfrbp_1_23.CLK VPWR VPWR sg13_lv_pmos ad=0.3234p pd=2.45u as=1.28962p ps=8.195u w=0.84u l=0.13u
X815 VPWR a_3599_3215# a_3856_3358# VPWR sg13_lv_pmos ad=0.2639p pd=1.81u as=79.8f ps=0.8u w=0.42u l=0.13u
X816 VPWR sg13cmos5l_buf_1_3.A a_20296_1664# VPWR sg13_lv_pmos ad=0.2114p pd=1.54u as=0.2856p ps=2.36u w=0.84u l=0.13u
X817 VPWR sg13cmos5l_buf_1_8.X a_11656_3176# VPWR sg13_lv_pmos ad=0.2114p pd=1.54u as=0.2856p ps=2.36u w=0.84u l=0.13u
X818 VPWR a_1815_4666# a_1946_4660# VPWR sg13_lv_pmos ad=1.28962p pd=8.195u as=0.2856p ps=2.36u w=0.84u l=0.13u
X819 VPWR sg13cmos5l_nand2_1_2.B sg13cmos5l_dlygate4sd2_1_0.A VPWR sg13_lv_pmos ad=0.3808p pd=2.92u as=0.2128p ps=1.5u w=1.12u l=0.13u
X820 VPWR a_908_1590# sg13cmos5l_buf_1_32.X VPWR sg13_lv_pmos ad=0.2114p pd=1.54u as=0.42p ps=2.99u w=1.12u l=0.13u
X821 a_15492_2392# a_15466_2356# VPWR VPWR sg13_lv_pmos ad=0.34p pd=2.68u as=0.36237p ps=2.605u w=1u l=0.13u
X822 VPWR sg13cmos5l_buf_1_76.X a_5416_9224# VPWR sg13_lv_pmos ad=0.2114p pd=1.54u as=0.2856p ps=2.36u w=0.84u l=0.13u
X823 sg13cmos5l_dlhr_1_5.Q a_8457_7281# VGND VGND sg13_lv_nmos ad=0.2516p pd=2.16u as=0.1406p ps=1.12u w=0.74u l=0.13u
X824 a_3831_7282# sg13cmos5l_dfrbp_1_15.D VPWR VPWR sg13_lv_pmos ad=0.3234p pd=2.45u as=1.04815p ps=6.595u w=0.84u l=0.13u
X825 VGND a_8841_5769# a_9366_5842# VGND sg13_lv_nmos ad=0.1491p pd=1.18u as=0.187p ps=1.78u w=0.55u l=0.13u
X826 sg13cmos5l_dlhr_1_13.Q_N a_15414_7354# VGND VGND sg13_lv_nmos ad=0.2516p pd=2.16u as=0.1491p ps=1.18u w=0.74u l=0.13u
X827 a_11782_4325# sg13cmos5l_dfrbp_1_0.RESET_B VGND VGND sg13_lv_nmos ad=37.8f pd=0.6u as=0.1701p ps=1.65u w=0.42u l=0.13u
X828 VPWR sg13cmos5l_dlhr_1_6.D a_13486_5412# VPWR sg13_lv_pmos ad=0.3808p pd=2.92u as=0.2128p ps=1.5u w=1.12u l=0.13u
X829 a_5700_6480# a_5674_6385# VPWR VPWR sg13_lv_pmos ad=0.34p pd=2.68u as=0.36237p ps=2.605u w=1u l=0.13u
X830 VPWR sg13cmos5l_buf_8_2.X a_20008_7712# VPWR sg13_lv_pmos ad=0.2114p pd=1.54u as=0.2856p ps=2.36u w=0.84u l=0.13u
X831 VPWR a_14295_7282# a_14426_7288# VPWR sg13_lv_pmos ad=1.07253p pd=6.75u as=0.2856p ps=2.36u w=0.84u l=0.13u
X832 a_7631_4727# a_6789_4629# a_6372_4968# VPWR sg13_lv_pmos ad=0.2048p pd=1.63u as=0.34p ps=2.68u w=1u l=0.13u
X833 a_12815_4261# a_11973_3911# a_11556_3904# VPWR sg13_lv_pmos ad=0.2048p pd=1.63u as=0.34p ps=2.68u w=1u l=0.13u
X834 a_1862_4338# sg13cmos5l_dlhr_1_1.GATE VPWR VPWR sg13_lv_pmos ad=79.8f pd=0.8u as=0.1428p ps=1.52u w=0.42u l=0.13u
X835 VGND a_19340_8400# pl_sw[9] VGND sg13_lv_nmos ad=0.14875p pd=1.16u as=0.2886p ps=2.26u w=0.74u l=0.13u
X836 VPWR sg13cmos5l_dlhr_1_0.D a_10331_1924# VPWR sg13_lv_pmos ad=0.2128p pd=1.5u as=0.2128p ps=1.5u w=1.12u l=0.13u
X837 VPWR a_7497_3138# a_8022_3120# VPWR sg13_lv_pmos ad=0.1974p pd=1.5u as=0.2856p ps=2.36u w=0.84u l=0.13u
X838 a_15702_4187# a_15821_3864# VGND VGND sg13_lv_nmos ad=0.2516p pd=2.16u as=0.1406p ps=1.12u w=0.74u l=0.13u
X839 VGND sg13cmos5l_dfrbp_1_0.RESET_B a_17508_3138# VGND sg13_lv_nmos ad=0.1626p pd=1.415u as=60.89999f ps=0.71u w=0.42u l=0.13u
X840 VGND a_1967_7285# a_2804_6924# VGND sg13_lv_nmos ad=0.1406p pd=1.12u as=0.2516p ps=2.16u w=0.74u l=0.13u
X841 sg13cmos5l_buf_1_19.A a_18856_8436# VGND VGND sg13_lv_nmos ad=0.2886p pd=2.26u as=0.14875p ps=1.16u w=0.74u l=0.13u
X842 cko a_20392_7712# VPWR VPWR sg13_lv_pmos ad=0.42p pd=2.99u as=0.2114p ps=1.54u w=1.12u l=0.13u
X843 a_17493_3947# sg13cmos5l_dfrbp_1_6.RESET_B VPWR VPWR sg13_lv_pmos ad=0.147p pd=1.54u as=0.1563p ps=1.22u w=0.42u l=0.13u
X844 a_2732_9150# sg13cmos5l_inv_1_20.Y VPWR VPWR sg13_lv_pmos ad=0.2856p pd=2.36u as=0.2114p ps=1.54u w=0.84u l=0.13u
X845 a_15909_2399# sg13cmos5l_dfrbp_1_0.CLK VGND VGND sg13_lv_nmos ad=0.2516p pd=2.16u as=2.43055p ps=15.415u w=0.74u l=0.13u
X846 a_17894_8436# a_17498_8800# a_17780_8436# VPWR sg13_lv_pmos ad=0.1008p pd=0.9u as=0.191p ps=1.44u w=0.42u l=0.13u
X847 a_4324_7996# a_4349_7636# VPWR VPWR sg13_lv_pmos ad=0.2856p pd=2.36u as=1.15047p ps=7.175u w=0.84u l=0.13u
X848 sg13cmos5l_inv_1_1.A a_15208_6200# VGND VGND sg13_lv_nmos ad=0.2886p pd=2.26u as=0.14875p ps=1.16u w=0.74u l=0.13u
X849 VPWR a_6736_2630# a_6681_2511# VPWR sg13_lv_pmos ad=1.86162p pd=11.935u as=93.45f ps=0.865u w=0.42u l=0.13u
X850 sg13cmos5l_dfrbp_1_21.Q_N a_17519_6239# VGND VGND sg13_lv_nmos ad=0.2849p pd=2.25u as=0.2516p ps=2.16u w=0.74u l=0.13u
X851 a_2565_3911# sg13cmos5l_inv_1_8.A VPWR VPWR sg13_lv_pmos ad=0.4088p pd=2.97u as=1.43437p ps=9.105u w=1.12u l=0.13u
X852 VGND VPWR VGND VGND sg13_lv_nmos ad=0.1428p pd=1.52u as=0 ps=0 w=0.42u l=1u
X853 a_708_5416# a_1227_5423# a_1967_5773# VGND sg13_lv_nmos ad=0.3473p pd=2.71u as=0.12665p ps=1.145u w=0.74u l=0.13u
X854 VGND a_4950_5699# sg13cmos5l_dlhr_1_5.GATE VGND sg13_lv_nmos ad=0.1406p pd=1.12u as=0.2516p ps=2.16u w=0.74u l=0.13u
X855 VPWR VGND VPWR VPWR sg13_lv_pmos ad=0.34p pd=2.68u as=0 ps=0 w=1u l=1u
X856 a_9524_4972# a_9111_4666# a_9456_4972# VPWR sg13_lv_pmos ad=0.191p pd=1.44u as=0.105p ps=1.21u w=1u l=0.13u
X857 VGND a_17327_7285# a_18164_6924# VGND sg13_lv_nmos ad=0.1406p pd=1.12u as=0.2516p ps=2.16u w=0.74u l=0.13u
X858 VPWR sg13cmos5l_dfrbp_1_8.RESET_B a_1862_8874# VPWR sg13_lv_pmos ad=0.36237p pd=2.605u as=79.8f ps=0.8u w=0.42u l=0.13u
X859 sg13cmos5l_dlhr_1_4.Q_N a_6198_3120# VPWR VPWR sg13_lv_pmos ad=0.3808p pd=2.92u as=0.1974p ps=1.5u w=1.12u l=0.13u
X860 a_11771_5412# sg13cmos5l_or2_1_1.B VPWR VPWR sg13_lv_pmos ad=0.3808p pd=2.92u as=0.2128p ps=1.5u w=1.12u l=0.13u
X861 VPWR sg13cmos5l_dfrbp_1_8.RESET_B a_2380_6162# VPWR sg13_lv_pmos ad=1.04815p pd=6.595u as=79.8f ps=0.8u w=0.42u l=0.13u
X862 VPWR a_7820_2352# sg13cmos5l_inv_1_14.A VPWR sg13_lv_pmos ad=0.2114p pd=1.54u as=0.42p ps=2.99u w=1.12u l=0.13u
X863 sg13cmos5l_inv_1_5.A a_19796_3436# VPWR VPWR sg13_lv_pmos ad=0.3808p pd=2.92u as=0.2128p ps=1.5u w=1.12u l=0.13u
X864 VGND sg13cmos5l_a221oi_1_0.C1 a_10433_4248# VGND sg13_lv_nmos ad=0.2516p pd=2.16u as=0.1406p ps=1.12u w=0.74u l=0.13u
X865 a_2386_5850# sg13cmos5l_dfrbp_1_6.RESET_B VGND VGND sg13_lv_nmos ad=37.8f pd=0.6u as=79.8f ps=0.8u w=0.42u l=0.13u
X866 a_12490_6385# a_12933_6141# a_12230_6162# VGND sg13_lv_nmos ad=79.8f pd=0.8u as=0.1296p ps=1.52u w=0.42u l=0.13u
X867 a_6153_3947# a_5796_3904# VPWR VPWR sg13_lv_pmos ad=63f pd=0.72u as=0.1563p ps=1.22u w=0.42u l=0.13u
X868 a_16268_1590# sg13cmos5l_buf_1_1.A VGND VGND sg13_lv_nmos ad=0.187p pd=1.78u as=0.14875p ps=1.16u w=0.55u l=0.13u
X869 a_8209_7326# a_7657_7282# VGND VGND sg13_lv_nmos ad=71.99999f pd=0.865u as=1.49685p ps=9.6u w=0.64u l=0.13u
X870 a_19444_5800# a_19028_5412# a_19209_5769# VGND sg13_lv_nmos ad=77.7f pd=0.95u as=0.2516p ps=2.16u w=0.74u l=0.13u
X871 VPWR sg13cmos5l_inv_1_3.A sg13cmos5l_buf_1_7.A VPWR sg13_lv_pmos ad=0.3808p pd=2.92u as=0.3808p ps=2.92u w=1.12u l=0.13u
X872 a_4324_7996# a_4349_7636# VGND VGND sg13_lv_nmos ad=0.2775p pd=2.23u as=1.49685p ps=9.6u w=0.74u l=0.13u
X873 a_15300_7687# a_15531_7796# a_14986_7897# VGND sg13_lv_nmos ad=0.2373p pd=1.97u as=79.8f ps=0.8u w=0.42u l=0.13u
X874 sg13cmos5l_dlhr_1_2.Q a_7497_3138# VGND VGND sg13_lv_nmos ad=0.2516p pd=2.16u as=0.1406p ps=1.12u w=0.74u l=0.13u
X875 VGND sg13cmos5l_buf_1_62.X a_1864_9224# VGND sg13_lv_nmos ad=0.14875p pd=1.16u as=0.187p ps=1.78u w=0.55u l=0.13u
X876 VGND sg13cmos5l_dfrbp_1_6.RESET_B a_9268_6148# VGND sg13_lv_nmos ad=0.1406p pd=1.12u as=77.7f ps=0.95u w=0.74u l=0.13u
X877 a_8772_8440# a_8746_8404# VPWR VPWR sg13_lv_pmos ad=0.34p pd=2.68u as=0.36237p ps=2.605u w=1u l=0.13u
X878 a_11002_3142# sg13cmos5l_nand2_1_0.B VGND VGND sg13_lv_nmos ad=0.1406p pd=1.12u as=0.2516p ps=2.16u w=0.74u l=0.13u
X879 VGND sg13cmos5l_dlygate4sd2_1_0.A a_902_3142# VGND sg13_lv_nmos ad=0.1323p pd=1.05u as=0.1428p ps=1.52u w=0.42u l=0.13u
X880 a_5414_6162# a_6219_6284# a_5674_6385# VPWR sg13_lv_pmos ad=0.1428p pd=1.52u as=79.8f ps=0.8u w=0.42u l=0.13u
X881 a_3407_4261# a_2565_3911# a_2148_3904# VPWR sg13_lv_pmos ad=0.2048p pd=1.63u as=0.34p ps=2.68u w=1u l=0.13u
X882 a_8050_4650# sg13cmos5l_dfrbp_1_8.RESET_B VGND VGND sg13_lv_nmos ad=37.8f pd=0.6u as=79.8f ps=0.8u w=0.42u l=0.13u
X883 a_1125_5423# sg13cmos5l_dlhr_1_1.GATE VPWR VPWR sg13_lv_pmos ad=0.4088p pd=2.97u as=1.2517p ps=7.955u w=1.12u l=0.13u
X884 VPWR sg13cmos5l_inv_1_28.Y a_11464_9224# VPWR sg13_lv_pmos ad=0.2114p pd=1.54u as=0.2856p ps=2.36u w=0.84u l=0.13u
X885 VGND a_12716_8400# ph_sw[5] VGND sg13_lv_nmos ad=0.14875p pd=1.16u as=0.2886p ps=2.26u w=0.74u l=0.13u
X886 VGND a_17584_7166# a_17233_7285# VGND sg13_lv_nmos ad=79.8f pd=0.8u as=0.1428p ps=1.52u w=0.42u l=0.13u
X887 a_17412_1944# a_17386_1849# VGND VGND sg13_lv_nmos ad=0.2516p pd=2.16u as=0.1626p ps=1.415u w=0.74u l=0.13u
X888 VPWR a_17392_4870# a_17337_4965# VPWR sg13_lv_pmos ad=1.28962p pd=8.195u as=93.45f ps=0.865u w=0.42u l=0.13u
X889 VGND sg13cmos5l_buf_1_2.A a_15784_1664# VGND sg13_lv_nmos ad=0.14875p pd=1.16u as=0.187p ps=1.78u w=0.55u l=0.13u
X890 VGND a_18363_4270# sg13cmos5l_or2_1_0.A VGND sg13_lv_nmos ad=0.1406p pd=1.12u as=0.1406p ps=1.12u w=0.74u l=0.13u
X891 VGND sg13cmos5l_buf_1_96.A a_11464_8436# VGND sg13_lv_nmos ad=0.14875p pd=1.16u as=0.187p ps=1.78u w=0.55u l=0.13u
X892 VGND a_16751_2749# a_17588_2388# VGND sg13_lv_nmos ad=0.1406p pd=1.12u as=0.2516p ps=2.16u w=0.74u l=0.13u
X893 sg13cmos5l_buf_1_28.X a_9448_1664# VGND VGND sg13_lv_nmos ad=0.2886p pd=2.26u as=0.14875p ps=1.16u w=0.74u l=0.13u
X894 VPWR sg13cmos5l_dfrbp_1_8.RESET_B a_8746_8404# VPWR sg13_lv_pmos ad=0.1563p pd=1.22u as=0.147p ps=1.54u w=0.42u l=0.13u
X895 a_19244_2352# sg13cmos5l_buf_1_18.X VPWR VPWR sg13_lv_pmos ad=0.2856p pd=2.36u as=0.2114p ps=1.54u w=0.84u l=0.13u
X896 VGND a_4041_2745# a_4566_2818# VGND sg13_lv_nmos ad=0.1491p pd=1.18u as=0.187p ps=1.78u w=0.55u l=0.13u
X897 VPWR a_524_4614# ckc VPWR sg13_lv_pmos ad=0.2114p pd=1.54u as=0.42p ps=2.99u w=1.12u l=0.13u
X898 a_10022_7674# sg13cmos5l_buf_1_57.X VPWR VPWR sg13_lv_pmos ad=79.8f pd=0.8u as=0.1428p ps=1.52u w=0.42u l=0.13u
X899 a_17008_2630# a_16751_2749# a_17170_2826# VGND sg13_lv_nmos ad=0.1428p pd=1.52u as=37.8f ps=0.6u w=0.42u l=0.13u
X900 a_17386_1849# a_17829_1605# a_17126_1626# VGND sg13_lv_nmos ad=79.8f pd=0.8u as=0.1296p ps=1.52u w=0.42u l=0.13u
X901 a_2340_3456# a_2314_3361# VGND VGND sg13_lv_nmos ad=0.2516p pd=2.16u as=0.1626p ps=1.415u w=0.74u l=0.13u
X902 a_15876_4968# a_16395_4772# a_17135_4727# VGND sg13_lv_nmos ad=0.3473p pd=2.71u as=0.12665p ps=1.145u w=0.74u l=0.13u
X903 a_11182_4948# sg13cmos5l_a221oi_1_0.B1 a_11394_4948# VPWR sg13_lv_pmos ad=0.2128p pd=1.5u as=0.3808p ps=2.92u w=1.12u l=0.13u
X904 VGND a_1815_4666# a_1946_4660# VGND sg13_lv_nmos ad=2.41737p pd=15.64u as=0.2775p ps=2.23u w=0.74u l=0.13u
X905 VGND rdy a_424_8436# VGND sg13_lv_nmos ad=0.14875p pd=1.16u as=0.187p ps=1.78u w=0.55u l=0.13u
X906 a_16462_4338# a_16703_3871# a_15821_3864# VGND sg13_lv_nmos ad=0.1428p pd=1.52u as=0.12665p ps=1.145u w=0.42u l=0.13u
X907 a_18363_4270# sg13cmos5l_buf_8_1.A VGND VGND sg13_lv_nmos ad=0.1406p pd=1.12u as=0.1406p ps=1.12u w=0.74u l=0.13u
X908 VPWR sg13cmos5l_dfrbp_1_6.RESET_B a_13161_7281# VPWR sg13_lv_pmos ad=0.2128p pd=1.5u as=0.2128p ps=1.5u w=1.12u l=0.13u
X909 sg13cmos5l_buf_1_104.A sg13cmos5l_buf_1_3.A VGND VGND sg13_lv_nmos ad=0.2516p pd=2.16u as=0.2516p ps=2.16u w=0.74u l=0.13u
X910 VGND a_2409_4650# a_2364_4686# VGND sg13_lv_nmos ad=0.1428p pd=1.52u as=47.25f ps=0.645u w=0.42u l=0.13u
X911 a_20012_2352# sg13cmos5l_buf_1_0.X VGND VGND sg13_lv_nmos ad=0.187p pd=1.78u as=0.14875p ps=1.16u w=0.55u l=0.13u
X912 VPWR sg13cmos5l_dfrbp_1_8.RESET_B a_3302_4650# VPWR sg13_lv_pmos ad=0.36237p pd=2.605u as=79.8f ps=0.8u w=0.42u l=0.13u
X913 VPWR sg13cmos5l_dlhr_1_15.D a_17545_7728# VPWR sg13_lv_pmos ad=1.15047p pd=7.175u as=0.2856p ps=2.36u w=0.84u l=0.13u
X914 a_4460_9150# sg13cmos5l_buf_1_60.A VGND VGND sg13_lv_nmos ad=0.187p pd=1.78u as=0.14875p ps=1.16u w=0.55u l=0.13u
X915 VPWR a_18345_7674# a_18278_8112# VPWR sg13_lv_pmos ad=0.2387p pd=1.84u as=0.1008p ps=0.9u w=0.42u l=0.13u
X916 a_11182_4948# sg13cmos5l_a221oi_1_0.A2 VPWR VPWR sg13_lv_pmos ad=0.2128p pd=1.5u as=0.3808p ps=2.92u w=1.12u l=0.13u
X917 VGND a_15887_8797# a_16724_8436# VGND sg13_lv_nmos ad=0.1406p pd=1.12u as=0.2516p ps=2.16u w=0.74u l=0.13u
X918 a_3575_6553# sg13cmos5l_dfrbp_1_8.RESET_B VPWR VPWR sg13_lv_pmos ad=79.8f pd=0.8u as=0.36237p ps=2.605u w=0.42u l=0.13u
X919 a_5079_3154# sg13cmos5l_dfrbp_1_9.Q VPWR VPWR sg13_lv_pmos ad=0.3234p pd=2.45u as=1.38655p ps=8.8u w=0.84u l=0.13u
X920 VGND a_8783_7751# a_9620_7972# VGND sg13_lv_nmos ad=0.1406p pd=1.12u as=0.2516p ps=2.16u w=0.74u l=0.13u
X921 a_2644_4636# a_2228_4972# a_2409_4650# VGND sg13_lv_nmos ad=77.7f pd=0.95u as=0.2516p ps=2.16u w=0.74u l=0.13u
X922 a_17519_6239# a_16677_6141# a_17425_6239# VGND sg13_lv_nmos ad=0.12665p pd=1.145u as=0.1428p ps=1.52u w=0.42u l=0.13u
X923 VPWR VGND VPWR VPWR sg13_lv_pmos ad=0.34p pd=2.68u as=0 ps=0 w=1u l=1u
X924 VGND VPWR VGND VGND sg13_lv_nmos ad=0.1428p pd=1.52u as=0 ps=0 w=0.42u l=1u
X925 a_1967_5773# a_1125_5423# a_708_5416# VPWR sg13_lv_pmos ad=0.2048p pd=1.63u as=0.34p ps=2.68u w=1u l=0.13u
X926 VPWR a_17327_7285# a_17584_7166# VPWR sg13_lv_pmos ad=0.2639p pd=1.81u as=79.8f ps=0.8u w=0.42u l=0.13u
X927 sg13cmos5l_buf_1_9.A a_9832_1664# VGND VGND sg13_lv_nmos ad=0.2886p pd=2.26u as=0.14875p ps=1.16u w=0.74u l=0.13u
X928 VPWR a_8204_9150# sg13cmos5l_buf_1_74.X VPWR sg13_lv_pmos ad=0.2114p pd=1.54u as=0.42p ps=2.99u w=1.12u l=0.13u
X929 a_8783_7751# a_7941_7653# a_7524_7992# VPWR sg13_lv_pmos ad=0.2048p pd=1.63u as=0.34p ps=2.68u w=1u l=0.13u
X930 VPWR a_13072_4142# a_13017_4023# VPWR sg13_lv_pmos ad=1.43437p pd=9.105u as=93.45f ps=0.865u w=0.42u l=0.13u
X931 VGND sg13cmos5l_dfrbp_1_0.Q sg13cmos5l_dfrbp_1_0.D VGND sg13_lv_nmos ad=0.2516p pd=2.16u as=0.1406p ps=1.12u w=0.74u l=0.13u
X932 a_708_6928# a_682_6892# VPWR VPWR sg13_lv_pmos ad=0.34p pd=2.68u as=0.36237p ps=2.605u w=1u l=0.13u
X933 VGND sg13cmos5l_dlhr_1_5.D a_7657_7282# VGND sg13_lv_nmos ad=0.15055p pd=1.17u as=0.187p ps=1.78u w=0.55u l=0.13u
X934 a_15412_5800# a_14996_5412# a_15177_5769# VGND sg13_lv_nmos ad=77.7f pd=0.95u as=0.2516p ps=2.16u w=0.74u l=0.13u
X935 a_5492_3460# a_5210_3148# a_5425_3130# VGND sg13_lv_nmos ad=0.141p pd=1.17u as=71.99999f ps=0.865u w=0.64u l=0.13u
X936 a_4934_2826# a_5739_2399# a_5194_2356# VPWR sg13_lv_pmos ad=0.1428p pd=1.52u as=79.8f ps=0.8u w=0.42u l=0.13u
X937 VGND sg13cmos5l_inv_1_3.A sg13cmos5l_buf_1_7.A VGND sg13_lv_nmos ad=0.2516p pd=2.16u as=0.2516p ps=2.16u w=0.74u l=0.13u
X938 a_5049_4965# a_4107_4772# a_4847_4727# VPWR sg13_lv_pmos ad=93.45f pd=0.865u as=0.2048p ps=1.63u w=0.42u l=0.13u
X939 sg13cmos5l_nor2_1_0.A a_13556_2388# VGND VGND sg13_lv_nmos ad=0.2516p pd=2.16u as=0.1406p ps=1.12u w=0.74u l=0.13u
X940 a_12815_1703# a_11973_1605# a_12721_1703# VGND sg13_lv_nmos ad=0.12665p pd=1.145u as=0.1428p ps=1.52u w=0.42u l=0.13u
X941 VGND a_14889_7281# a_14844_7326# VGND sg13_lv_nmos ad=0.1428p pd=1.52u as=47.25f ps=0.645u w=0.42u l=0.13u
X942 VGND a_19227_4654# sg13cmos5l_buf_8_0.X VGND sg13_lv_nmos ad=0.2516p pd=2.16u as=0.1406p ps=1.12u w=0.74u l=0.13u
X943 a_6022_4325# sg13cmos5l_dfrbp_1_6.RESET_B VGND VGND sg13_lv_nmos ad=37.8f pd=0.6u as=0.1701p ps=1.65u w=0.42u l=0.13u
X944 a_1484_6126# sg13cmos5l_buf_1_58.A VGND VGND sg13_lv_nmos ad=0.187p pd=1.78u as=0.14875p ps=1.16u w=0.55u l=0.13u
X945 a_5446_2813# sg13cmos5l_dfrbp_1_6.RESET_B VGND VGND sg13_lv_nmos ad=37.8f pd=0.6u as=0.1701p ps=1.65u w=0.42u l=0.13u
X946 a_15884_3102# sg13cmos5l_buf_1_5.X VPWR VPWR sg13_lv_pmos ad=0.2856p pd=2.36u as=0.2114p ps=1.54u w=0.84u l=0.13u
X947 a_4559_7630# sg13cmos5l_dlhr_1_9.D VGND VGND sg13_lv_nmos ad=0.187p pd=1.78u as=0.15055p ps=1.17u w=0.55u l=0.13u
X948 a_6372_4968# a_6346_4873# VGND VGND sg13_lv_nmos ad=0.2516p pd=2.16u as=0.1626p ps=1.415u w=0.74u l=0.13u
X949 sg13cmos5l_a22oi_1_2.B1 sg13cmos5l_nand2_1_1.B VGND VGND sg13_lv_nmos ad=0.1406p pd=1.12u as=0.2516p ps=2.16u w=0.74u l=0.13u
X950 a_10783_3876# sg13cmos5l_inv_1_0.A sg13cmos5l_a22oi_1_0.Y VPWR sg13_lv_pmos ad=0.2744p pd=1.61u as=0.2128p ps=1.5u w=1.12u l=0.13u
X951 a_12976_2630# a_12719_2749# a_13138_2826# VGND sg13_lv_nmos ad=0.1428p pd=1.52u as=37.8f ps=0.6u w=0.42u l=0.13u
X952 sg13cmos5l_dfrbp_1_6.RESET_B cks VGND VGND sg13_lv_nmos ad=0.1406p pd=1.12u as=0.2516p ps=2.16u w=0.74u l=0.13u
X953 VPWR sg13cmos5l_dlhr_1_15.Q a_19240_7712# VPWR sg13_lv_pmos ad=0.2114p pd=1.54u as=0.2856p ps=2.36u w=0.84u l=0.13u
X954 VPWR a_8457_7281# a_8390_6924# VPWR sg13_lv_pmos ad=0.2387p pd=1.84u as=0.1008p ps=0.9u w=0.42u l=0.13u
X955 VGND sg13cmos5l_dfrbp_1_6.RESET_B a_13876_7660# VGND sg13_lv_nmos ad=0.1406p pd=1.12u as=77.7f ps=0.95u w=0.74u l=0.13u
X956 VPWR a_5324_1590# sg13cmos5l_buf_1_39.A VPWR sg13_lv_pmos ad=0.2114p pd=1.54u as=0.42p ps=2.99u w=1.12u l=0.13u
X957 VPWR sg13cmos5l_inv_1_1.A a_16264_9224# VPWR sg13_lv_pmos ad=0.2114p pd=1.54u as=0.2856p ps=2.36u w=0.84u l=0.13u
X958 a_3669_6320# sg13cmos5l_dfrbp_1_8.RESET_B VPWR VPWR sg13_lv_pmos ad=0.147p pd=1.54u as=0.1563p ps=1.22u w=0.42u l=0.13u
X959 a_3860_2388# a_3447_2746# a_3792_2388# VPWR sg13_lv_pmos ad=0.191p pd=1.44u as=0.105p ps=1.21u w=1u l=0.13u
X960 VPWR a_10464_2427# sg13cmos5l_dfrbp_1_4.D VPWR sg13_lv_pmos ad=0.3808p pd=2.92u as=0.2408p ps=1.55u w=1.12u l=0.13u
X961 a_14924_1590# sg13cmos5l_buf_1_6.A VGND VGND sg13_lv_nmos ad=0.187p pd=1.78u as=0.14875p ps=1.16u w=0.55u l=0.13u
X962 a_20012_1590# sg13cmos5l_buf_1_0.A VGND VGND sg13_lv_nmos ad=0.187p pd=1.78u as=0.14875p ps=1.16u w=0.55u l=0.13u
X963 VPWR a_8783_7751# a_9040_7894# VPWR sg13_lv_pmos ad=0.2639p pd=1.81u as=79.8f ps=0.8u w=0.42u l=0.13u
X964 a_5132_9150# sg13cmos5l_buf_1_44.X VGND VGND sg13_lv_nmos ad=0.187p pd=1.78u as=0.14875p ps=1.16u w=0.55u l=0.13u
X965 a_8204_9150# sg13cmos5l_buf_1_45.X VPWR VPWR sg13_lv_pmos ad=0.2856p pd=2.36u as=0.2114p ps=1.54u w=0.84u l=0.13u
X966 d_out[1] a_20008_3900# VGND VGND sg13_lv_nmos ad=0.2886p pd=2.26u as=0.14875p ps=1.16u w=0.74u l=0.13u
X967 sg13cmos5l_buf_1_34.X a_4840_1664# VPWR VPWR sg13_lv_pmos ad=0.42p pd=2.99u as=0.2114p ps=1.54u w=1.12u l=0.13u
X968 sg13cmos5l_dlhr_1_20.Q_N a_10230_4632# VGND VGND sg13_lv_nmos ad=0.2516p pd=2.16u as=0.1491p ps=1.18u w=0.74u l=0.13u
X969 a_5988_8440# a_6507_8447# a_7247_8797# VGND sg13_lv_nmos ad=0.3473p pd=2.71u as=0.12665p ps=1.145u w=0.74u l=0.13u
X970 sg13cmos5l_nor2b_1_0.Y a_12814_4692# VGND VGND sg13_lv_nmos ad=0.1406p pd=1.12u as=0.17255p ps=1.25u w=0.74u l=0.13u
X971 a_4076_7624# a_4349_7636# a_4311_7710# VGND sg13_lv_nmos ad=0.141p pd=1.17u as=47.25f ps=0.645u w=0.42u l=0.13u
X972 VGND a_7689_1626# a_7644_1662# VGND sg13_lv_nmos ad=0.1428p pd=1.52u as=47.25f ps=0.645u w=0.42u l=0.13u
X973 sg13cmos5l_a221oi_1_0.A2 a_7892_3900# VGND VGND sg13_lv_nmos ad=0.2516p pd=2.16u as=0.1406p ps=1.12u w=0.74u l=0.13u
X974 a_17988_3151# a_17700_3456# a_17926_3151# VGND sg13_lv_nmos ad=0.1428p pd=1.52u as=37.8f ps=0.6u w=0.42u l=0.13u
X975 VPWR sg13cmos5l_dfrbp_1_8.RESET_B a_15782_7362# VPWR sg13_lv_pmos ad=0.36237p pd=2.605u as=79.8f ps=0.8u w=0.42u l=0.13u
X976 VPWR sg13cmos5l_dfrbp_1_6.RESET_B a_19593_6162# VPWR sg13_lv_pmos ad=0.2128p pd=1.5u as=0.2128p ps=1.5u w=1.12u l=0.13u
X977 VPWR sg13cmos5l_buf_1_34.A a_4840_1664# VPWR sg13_lv_pmos ad=0.2114p pd=1.54u as=0.2856p ps=2.36u w=0.84u l=0.13u
X978 a_6346_4873# a_6789_4629# a_6086_4650# VGND sg13_lv_nmos ad=79.8f pd=0.8u as=0.1296p ps=1.52u w=0.42u l=0.13u
X979 a_4934_2826# sg13cmos5l_dfrbp_1_6.D VPWR VPWR sg13_lv_pmos ad=79.8f pd=0.8u as=0.1428p ps=1.52u w=0.42u l=0.13u
X980 a_6180_4650# sg13cmos5l_dlhr_1_0.GATE a_6086_4650# VGND sg13_lv_nmos ad=60.89999f pd=0.71u as=0.1428p ps=1.52u w=0.42u l=0.13u
X981 a_10725_7653# sg13cmos5l_dlhr_1_11.GATE VGND VGND sg13_lv_nmos ad=0.2516p pd=2.16u as=1.49685p ps=9.6u w=0.74u l=0.13u
X982 a_7924_1612# a_7508_1948# a_7689_1626# VGND sg13_lv_nmos ad=77.7f pd=0.95u as=0.2516p ps=2.16u w=0.74u l=0.13u
X983 a_7666_8874# sg13cmos5l_dfrbp_1_8.RESET_B VGND VGND sg13_lv_nmos ad=37.8f pd=0.6u as=79.8f ps=0.8u w=0.42u l=0.13u
X984 VPWR sg13cmos5l_dfrbp_1_6.RESET_B a_10665_7281# VPWR sg13_lv_pmos ad=0.2128p pd=1.5u as=0.2128p ps=1.5u w=1.12u l=0.13u
X985 VGND sg13cmos5l_dfrbp_1_16.Q a_3625_7282# VGND sg13_lv_nmos ad=0.15055p pd=1.17u as=0.187p ps=1.78u w=0.55u l=0.13u
X986 a_13324_4696# sg13cmos5l_inv_1_0.A VPWR VPWR sg13_lv_pmos ad=0.1596p pd=1.22u as=0.1596p ps=1.22u w=0.84u l=0.13u
X987 a_10022_7674# a_10827_7796# a_10282_7897# VPWR sg13_lv_pmos ad=0.1428p pd=1.52u as=79.8f ps=0.8u w=0.42u l=0.13u
X988 sg13cmos5l_dlhr_1_6.Q_N a_9558_6144# VGND VGND sg13_lv_nmos ad=0.2516p pd=2.16u as=0.1491p ps=1.18u w=0.74u l=0.13u
X989 a_10484_6924# a_10071_7282# a_10416_6924# VPWR sg13_lv_pmos ad=0.191p pd=1.44u as=0.105p ps=1.21u w=1u l=0.13u
X990 a_19216_3358# a_18959_3215# a_19378_3138# VGND sg13_lv_nmos ad=0.1428p pd=1.52u as=37.8f ps=0.6u w=0.42u l=0.13u
X991 sg13cmos5l_a22oi_1_1.B2 sg13cmos5l_and3_1_0.X VGND VGND sg13_lv_nmos ad=0.2516p pd=2.16u as=0.1406p ps=1.12u w=0.74u l=0.13u
X992 VGND a_17516_9150# pl_sw[8] VGND sg13_lv_nmos ad=0.14875p pd=1.16u as=0.2886p ps=2.26u w=0.74u l=0.13u
X993 VPWR a_13775_6239# a_14612_6460# VPWR sg13_lv_pmos ad=0.2128p pd=1.5u as=0.3864p ps=2.93u w=1.12u l=0.13u
X994 VGND a_6572_1590# sg13cmos5l_buf_1_24.X VGND sg13_lv_nmos ad=0.14875p pd=1.16u as=0.2886p ps=2.26u w=0.74u l=0.13u
X995 VPWR sg13cmos5l_dfrbp_1_8.RESET_B a_6346_4873# VPWR sg13_lv_pmos ad=0.1563p pd=1.22u as=0.147p ps=1.54u w=0.42u l=0.13u
X996 pl_sw[4] a_5800_9224# VGND VGND sg13_lv_nmos ad=0.2886p pd=2.26u as=0.14875p ps=1.16u w=0.74u l=0.13u
X997 a_422_5850# a_1227_5423# a_682_5380# VPWR sg13_lv_pmos ad=0.1428p pd=1.52u as=79.8f ps=0.8u w=0.42u l=0.13u
X998 a_18999_6178# sg13cmos5l_dfrbp_1_8.D VGND VGND sg13_lv_nmos ad=0.2516p pd=2.16u as=0.15055p ps=1.17u w=0.74u l=0.13u
X999 a_11748_2813# a_11460_2392# a_11686_2813# VGND sg13_lv_nmos ad=0.1428p pd=1.52u as=37.8f ps=0.6u w=0.42u l=0.13u
X1000 a_15062_4292# sg13cmos5l_a22oi_1_1.B2 sg13cmos5l_a22oi_1_1.Y VGND sg13_lv_nmos ad=0.13875p pd=1.115u as=0.2664p ps=1.46u w=0.74u l=0.13u
X1001 VPWR sg13cmos5l_or2_1_0.A a_18574_5028# VPWR sg13_lv_pmos ad=0.2226p pd=1.535u as=0.1596p ps=1.22u w=0.84u l=0.13u
X1002 VGND a_9040_7894# a_8689_7751# VGND sg13_lv_nmos ad=79.8f pd=0.8u as=0.1428p ps=1.52u w=0.42u l=0.13u
X1003 a_14986_7897# a_15429_7653# a_15369_8065# VPWR sg13_lv_pmos ad=79.8f pd=0.8u as=63f ps=0.72u w=0.42u l=0.13u
X1004 VGND sg13cmos5l_dfrbp_1_0.RESET_B a_17220_1626# VGND sg13_lv_nmos ad=0.1626p pd=1.415u as=60.89999f ps=0.71u w=0.42u l=0.13u
X1005 VGND sg13cmos5l_buf_1_77.X a_7336_9224# VGND sg13_lv_nmos ad=0.14875p pd=1.16u as=0.187p ps=1.78u w=0.55u l=0.13u
X1006 a_6405_8447# sg13cmos5l_inv_1_8.A VPWR VPWR sg13_lv_pmos ad=0.4088p pd=2.97u as=1.12242p ps=7u w=1.12u l=0.13u
X1007 a_7249_3130# a_6697_3192# VGND VGND sg13_lv_nmos ad=71.99999f pd=0.865u as=2.59257p ps=16.445u w=0.64u l=0.13u
X1008 sg13cmos5l_dlygate4sd2_1_0.X a_1290_3206# VGND VGND sg13_lv_nmos ad=0.2516p pd=2.16u as=0.1405p ps=1.15u w=0.74u l=0.13u
X1009 VGND sg13cmos5l_inv_1_8.A a_2879_6432# VGND sg13_lv_nmos ad=1.88087p pd=11.775u as=0.2516p ps=2.16u w=0.74u l=0.13u
X1010 d_out[0] a_20392_2388# VGND VGND sg13_lv_nmos ad=0.2886p pd=2.26u as=0.14875p ps=1.16u w=0.74u l=0.13u
X1011 VPWR a_18363_4270# sg13cmos5l_or2_1_0.A VPWR sg13_lv_pmos ad=0.2128p pd=1.5u as=0.2128p ps=1.5u w=1.12u l=0.13u
X1012 VGND sg13cmos5l_dfrbp_1_6.RESET_B a_2148_3138# VGND sg13_lv_nmos ad=0.1626p pd=1.415u as=60.89999f ps=0.71u w=0.42u l=0.13u
X1013 sg13cmos5l_buf_8_0.X a_19227_4654# VPWR VPWR sg13_lv_pmos ad=0.2128p pd=1.5u as=0.2128p ps=1.5u w=1.12u l=0.13u
X1014 VPWR a_13072_1846# a_13017_1941# VPWR sg13_lv_pmos ad=1.86162p pd=11.935u as=93.45f ps=0.865u w=0.42u l=0.13u
X1015 VPWR VGND VPWR VPWR sg13_lv_pmos ad=0.34p pd=2.68u as=0 ps=0 w=1u l=1u
X1016 VPWR a_4847_4727# a_5684_4948# VPWR sg13_lv_pmos ad=0.2128p pd=1.5u as=0.3864p ps=2.93u w=1.12u l=0.13u
X1017 a_10613_2758# sg13cmos5l_nand2_1_1.B VGND VGND sg13_lv_nmos ad=0.1406p pd=1.12u as=0.1898p ps=1.36u w=0.74u l=0.13u
X1018 a_11748_2813# a_11979_2399# a_11434_2356# VGND sg13_lv_nmos ad=0.2373p pd=1.97u as=79.8f ps=0.8u w=0.42u l=0.13u
X1019 VGND a_13484_8400# sg13cmos5l_buf_1_5.A VGND sg13_lv_nmos ad=0.14875p pd=1.16u as=0.2886p ps=2.26u w=0.74u l=0.13u
X1020 a_17135_4727# a_16293_4629# a_17041_4727# VGND sg13_lv_nmos ad=0.12665p pd=1.145u as=0.1428p ps=1.52u w=0.42u l=0.13u
X1021 VGND VPWR VGND VGND sg13_lv_nmos ad=0.1428p pd=1.52u as=0 ps=0 w=0.42u l=1u
X1022 a_12516_6480# a_12490_6385# VPWR VPWR sg13_lv_pmos ad=0.34p pd=2.68u as=0.36237p ps=2.605u w=1u l=0.13u
X1023 VGND sg13cmos5l_buf_1_4.A sg13cmos5l_buf_1_110.A VGND sg13_lv_nmos ad=0.2516p pd=2.16u as=0.2516p ps=2.16u w=0.74u l=0.13u
X1024 VGND sg13cmos5l_dlhr_1_2.D a_6697_3192# VGND sg13_lv_nmos ad=0.15055p pd=1.17u as=0.187p ps=1.78u w=0.55u l=0.13u
X1025 a_18363_4270# sg13cmos5l_buf_8_1.A VPWR VPWR sg13_lv_pmos ad=0.2128p pd=1.5u as=0.2128p ps=1.5u w=1.12u l=0.13u
X1026 a_10725_7653# sg13cmos5l_dlhr_1_11.GATE VPWR VPWR sg13_lv_pmos ad=0.4088p pd=2.97u as=1.12242p ps=7u w=1.12u l=0.13u
X1027 VPWR a_16293_4629# a_16395_4772# VPWR sg13_lv_pmos ad=1.28962p pd=8.195u as=0.3864p ps=2.93u w=1.12u l=0.13u
X1028 a_13116_7326# a_12567_7282# a_12980_6924# VGND sg13_lv_nmos ad=47.25f pd=0.645u as=0.141p ps=1.17u w=0.42u l=0.13u
X1029 VGND a_15500_9150# ph_sw[6] VGND sg13_lv_nmos ad=0.14875p pd=1.16u as=0.2886p ps=2.26u w=0.74u l=0.13u
X1030 VPWR a_12567_7282# a_12698_7288# VPWR sg13_lv_pmos ad=1.07253p pd=6.75u as=0.2856p ps=2.36u w=0.84u l=0.13u
X1031 a_15782_7362# a_16587_6935# a_16042_6892# VPWR sg13_lv_pmos ad=0.1428p pd=1.52u as=79.8f ps=0.8u w=0.42u l=0.13u
X1032 VPWR sg13cmos5l_dlhr_1_5.D a_7657_7282# VPWR sg13_lv_pmos ad=1.07253p pd=6.75u as=0.2856p ps=2.36u w=0.84u l=0.13u
X1033 a_10464_2427# sg13cmos5l_nand2_1_1.B a_10427_2736# VGND sg13_lv_nmos ad=0.2176p pd=1.96u as=78.39999f ps=0.885u w=0.64u l=0.13u
X1034 VGND sg13cmos5l_dlhr_1_6.D a_8233_6216# VGND sg13_lv_nmos ad=0.15055p pd=1.17u as=0.187p ps=1.78u w=0.55u l=0.13u
X1035 sg13cmos5l_dfrbp_1_0.Q a_19508_1924# VPWR VPWR sg13_lv_pmos ad=0.3808p pd=2.92u as=0.2128p ps=1.5u w=1.12u l=0.13u
X1036 a_17135_4727# a_16293_4629# a_15876_4968# VPWR sg13_lv_pmos ad=0.2048p pd=1.63u as=0.34p ps=2.68u w=1u l=0.13u
X1037 a_10420_5412# sg13cmos5l_dfrbp_1_20.Q VPWR VPWR sg13_lv_pmos ad=0.2128p pd=1.5u as=0.3808p ps=2.92u w=1.12u l=0.13u
X1038 VGND a_19227_4654# sg13cmos5l_buf_8_0.X VGND sg13_lv_nmos ad=0.1406p pd=1.12u as=0.1406p ps=1.12u w=0.74u l=0.13u
X1039 a_16690_7674# sg13cmos5l_dfrbp_1_6.RESET_B VGND VGND sg13_lv_nmos ad=37.8f pd=0.6u as=79.8f ps=0.8u w=0.42u l=0.13u
X1040 a_1158_3142# a_902_3142# VPWR VPWR sg13_lv_pmos ad=0.34p pd=2.68u as=0.2481p ps=1.56u w=1u l=0.25u
X1041 a_3588_4968# a_3562_4873# VPWR VPWR sg13_lv_pmos ad=0.34p pd=2.68u as=0.36237p ps=2.605u w=1u l=0.13u
X1042 sg13cmos5l_buf_8_2.X a_19227_9190# VGND VGND sg13_lv_nmos ad=0.1406p pd=1.12u as=0.1406p ps=1.12u w=0.74u l=0.13u
X1043 VGND sg13cmos5l_inv_1_6.A a_20008_8436# VGND sg13_lv_nmos ad=0.14875p pd=1.16u as=0.187p ps=1.78u w=0.55u l=0.13u
X1044 sg13cmos5l_dfrbp_1_23.CLK a_14228_9484# VPWR VPWR sg13_lv_pmos ad=0.3808p pd=2.92u as=0.2128p ps=1.5u w=1.12u l=0.13u
X1045 VGND sg13cmos5l_buf_1_24.A sg13cmos5l_buf_1_78.A VGND sg13_lv_nmos ad=0.2516p pd=2.16u as=0.2516p ps=2.16u w=0.74u l=0.13u
X1046 a_7508_1948# a_7095_1642# a_7440_1948# VPWR sg13_lv_pmos ad=0.191p pd=1.44u as=0.105p ps=1.21u w=1u l=0.13u
X1047 VPWR a_7216_6382# a_7161_6477# VPWR sg13_lv_pmos ad=1.07253p pd=6.75u as=93.45f ps=0.865u w=0.42u l=0.13u
X1048 VGND sg13cmos5l_nor2b_1_0.Y a_11054_4292# VGND sg13_lv_nmos ad=0.2516p pd=2.16u as=96.2f ps=1u w=0.74u l=0.13u
X1049 a_19548_6198# a_18999_6178# a_19412_6484# VGND sg13_lv_nmos ad=47.25f pd=0.645u as=0.141p ps=1.17u w=0.42u l=0.13u
X1050 VGND a_4041_2745# a_3996_2790# VGND sg13_lv_nmos ad=0.1428p pd=1.52u as=47.25f ps=0.645u w=0.42u l=0.13u
X1051 sg13cmos5l_dfrbp_1_10.Q a_4436_3436# VPWR VPWR sg13_lv_pmos ad=0.3808p pd=2.92u as=0.2128p ps=1.5u w=1.12u l=0.13u
X1052 VGND a_1006_4167# sg13cmos5l_dlygate4sd3_1_0.X VGND sg13_lv_nmos ad=0.1426p pd=1.16u as=0.2516p ps=2.16u w=0.74u l=0.13u
X1053 VGND sg13cmos5l_buf_1_19.A a_18760_2388# VGND sg13_lv_nmos ad=0.14875p pd=1.16u as=0.187p ps=1.78u w=0.55u l=0.13u
X1054 VGND sg13cmos5l_dfrbp_1_6.RESET_B a_5908_3124# VGND sg13_lv_nmos ad=0.1406p pd=1.12u as=77.7f ps=0.95u w=0.74u l=0.13u
X1055 VPWR sg13cmos5l_buf_1_60.X a_2248_9224# VPWR sg13_lv_pmos ad=0.2114p pd=1.54u as=0.2856p ps=2.36u w=0.84u l=0.13u
X1056 VGND sg13cmos5l_buf_1_98.A a_13768_8436# VGND sg13_lv_nmos ad=0.14875p pd=1.16u as=0.187p ps=1.78u w=0.55u l=0.13u
X1057 VGND a_11072_5347# sg13cmos5l_a221oi_1_1.C1 VGND sg13_lv_nmos ad=0.1371p pd=1.12u as=0.2516p ps=2.16u w=0.74u l=0.13u
X1058 a_14628_8440# a_14602_8404# VGND VGND sg13_lv_nmos ad=0.2516p pd=2.16u as=0.1626p ps=1.415u w=0.74u l=0.13u
X1059 VPWR a_9260_2352# nh_sw[4] VPWR sg13_lv_pmos ad=0.2114p pd=1.54u as=0.42p ps=2.99u w=1.12u l=0.13u
X1060 VPWR a_7312_4142# a_7257_4023# VPWR sg13_lv_pmos ad=1.43437p pd=9.105u as=93.45f ps=0.865u w=0.42u l=0.13u
X1061 VGND a_17135_4727# a_17972_4948# VGND sg13_lv_nmos ad=0.1406p pd=1.12u as=0.2516p ps=2.16u w=0.74u l=0.13u
X1062 a_908_1590# sg13cmos5l_buf_1_32.A VGND VGND sg13_lv_nmos ad=0.187p pd=1.78u as=0.14875p ps=1.16u w=0.55u l=0.13u
X1063 a_7247_8797# a_6405_8447# a_7153_8797# VGND sg13_lv_nmos ad=0.12665p pd=1.145u as=0.1428p ps=1.52u w=0.42u l=0.13u
X1064 a_5700_6480# a_6219_6284# a_6959_6239# VGND sg13_lv_nmos ad=0.3473p pd=2.71u as=0.12665p ps=1.145u w=0.74u l=0.13u
X1065 VPWR sg13cmos5l_dfrbp_1_1.Q sg13cmos5l_inv_1_11.Y VPWR sg13_lv_pmos ad=0.3808p pd=2.92u as=0.3808p ps=2.92u w=1.12u l=0.13u
X1066 a_5770_3868# a_6213_3911# a_6153_3947# VPWR sg13_lv_pmos ad=79.8f pd=0.8u as=63f ps=0.72u w=0.42u l=0.13u
X1067 VGND a_10473_9186# a_10428_9222# VGND sg13_lv_nmos ad=0.1428p pd=1.52u as=47.25f ps=0.645u w=0.42u l=0.13u
X1068 a_524_4614# sg13cmos5l_buf_1_43.A VPWR VPWR sg13_lv_pmos ad=0.2856p pd=2.36u as=0.2114p ps=1.54u w=0.84u l=0.13u
X1069 VPWR sg13cmos5l_buf_1_116.A a_15592_6200# VPWR sg13_lv_pmos ad=0.2114p pd=1.54u as=0.2856p ps=2.36u w=0.84u l=0.13u
X1070 a_15492_2392# a_15466_2356# VGND VGND sg13_lv_nmos ad=0.2516p pd=2.16u as=0.1626p ps=1.415u w=0.74u l=0.13u
X1071 VGND a_18363_4270# sg13cmos5l_or2_1_0.A VGND sg13_lv_nmos ad=0.2516p pd=2.16u as=0.1406p ps=1.12u w=0.74u l=0.13u
X1072 VGND a_3308_5376# sg13cmos5l_buf_1_41.A VGND sg13_lv_nmos ad=0.14875p pd=1.16u as=0.2886p ps=2.26u w=0.74u l=0.13u
X1073 VPWR sg13cmos5l_inv_1_26.Y a_17896_9224# VPWR sg13_lv_pmos ad=0.2114p pd=1.54u as=0.2856p ps=2.36u w=0.84u l=0.13u
X1074 a_6345_8483# a_5988_8440# VPWR VPWR sg13_lv_pmos ad=63f pd=0.72u as=0.1563p ps=1.22u w=0.42u l=0.13u
X1075 VGND a_10220_3102# nl_sw[5] VGND sg13_lv_nmos ad=0.14875p pd=1.16u as=0.2886p ps=2.26u w=0.74u l=0.13u
X1076 VPWR a_7820_9150# sg13cmos5l_buf_1_73.X VPWR sg13_lv_pmos ad=0.2114p pd=1.54u as=0.42p ps=2.99u w=1.12u l=0.13u
X1077 a_16144_8678# sg13cmos5l_dfrbp_1_8.RESET_B VPWR VPWR sg13_lv_pmos ad=79.8f pd=0.8u as=1.12242p ps=7u w=0.42u l=0.13u
X1078 VGND sg13cmos5l_inv_1_0.A sg13cmos5l_inv_1_0.Y VGND sg13_lv_nmos ad=0.2516p pd=2.16u as=0.2516p ps=2.16u w=0.74u l=0.13u
X1079 a_10318_5412# sg13cmos5l_a221oi_1_1.C1 sg13cmos5l_a22oi_1_2.B2 VPWR sg13_lv_pmos ad=0.2128p pd=1.5u as=0.3808p ps=2.92u w=1.12u l=0.13u
X1080 VGND a_9033_6162# a_9558_6144# VGND sg13_lv_nmos ad=0.1491p pd=1.18u as=0.187p ps=1.78u w=0.55u l=0.13u
X1081 VGND sg13cmos5l_buf_8_0.A a_19227_4654# VGND sg13_lv_nmos ad=0.1406p pd=1.12u as=0.2553p ps=2.17u w=0.74u l=0.13u
X1082 a_11556_3904# a_11530_3868# VPWR VPWR sg13_lv_pmos ad=0.34p pd=2.68u as=0.36237p ps=2.605u w=1u l=0.13u
X1083 VGND sg13cmos5l_buf_1_86.A a_20392_6924# VGND sg13_lv_nmos ad=0.14875p pd=1.16u as=0.187p ps=1.78u w=0.55u l=0.13u
X1084 sg13cmos5l_or2_1_0.A a_18363_4270# VGND VGND sg13_lv_nmos ad=0.1406p pd=1.12u as=0.1406p ps=1.12u w=0.74u l=0.13u
X1085 a_7055_4261# a_6213_3911# a_6961_4261# VGND sg13_lv_nmos ad=0.12665p pd=1.145u as=0.1428p ps=1.52u w=0.42u l=0.13u
X1086 sg13cmos5l_buf_8_0.X a_19227_4654# VPWR VPWR sg13_lv_pmos ad=0.2128p pd=1.5u as=0.2128p ps=1.5u w=1.12u l=0.13u
X1087 VPWR a_19227_9190# sg13cmos5l_buf_8_2.X VPWR sg13_lv_pmos ad=0.2128p pd=1.5u as=0.2128p ps=1.5u w=1.12u l=0.13u
X1088 pl_sw[5] a_7336_9224# VPWR VPWR sg13_lv_pmos ad=0.42p pd=2.99u as=0.2114p ps=1.54u w=1.12u l=0.13u
X1089 a_16042_6892# a_16485_6935# a_15782_7362# VGND sg13_lv_nmos ad=79.8f pd=0.8u as=0.1296p ps=1.52u w=0.42u l=0.13u
X1090 VGND sg13cmos5l_dfrbp_1_6.RESET_B a_10900_7312# VGND sg13_lv_nmos ad=0.1406p pd=1.12u as=77.7f ps=0.95u w=0.74u l=0.13u
X1091 a_6647_5459# sg13cmos5l_dfrbp_1_11.Q a_7394_5850# VGND sg13_lv_nmos ad=0.1428p pd=1.52u as=60.89999f ps=0.71u w=0.42u l=0.13u
X1092 a_6647_5459# sg13cmos5l_dfrbp_1_8.RESET_B VPWR VPWR sg13_lv_pmos ad=79.8f pd=0.8u as=0.36237p ps=2.605u w=0.42u l=0.13u
X1093 a_5606_3576# a_5210_3148# a_5492_3460# VPWR sg13_lv_pmos ad=0.1008p pd=0.9u as=0.191p ps=1.44u w=0.42u l=0.13u
X1094 a_3664_4142# a_3407_4261# a_3826_4338# VGND sg13_lv_nmos ad=0.1428p pd=1.52u as=37.8f ps=0.6u w=0.42u l=0.13u
X1095 VGND sg13cmos5l_dlhr_1_11.D a_12361_7282# VGND sg13_lv_nmos ad=0.15055p pd=1.17u as=0.187p ps=1.78u w=0.55u l=0.13u
X1096 a_2727_6380# a_2879_6432# VPWR VPWR sg13_lv_pmos ad=0.3864p pd=2.93u as=1.07253p ps=6.75u w=1.12u l=0.13u
X1097 VPWR sg13cmos5l_dfrbp_1_0.RESET_B a_11530_3868# VPWR sg13_lv_pmos ad=0.1563p pd=1.22u as=0.147p ps=1.54u w=0.42u l=0.13u
X1098 VPWR sg13cmos5l_nor2_1_0.A a_11980_4948# VPWR sg13_lv_pmos ad=0.4032p pd=2.96u as=0.1176p ps=1.33u w=1.12u l=0.13u
X1099 a_5796_8874# sg13cmos5l_dlhr_1_5.GATE a_5702_8874# VGND sg13_lv_nmos ad=60.89999f pd=0.71u as=0.1428p ps=1.52u w=0.42u l=0.13u
X1100 a_9164_1590# sg13cmos5l_buf_1_26.A VGND VGND sg13_lv_nmos ad=0.187p pd=1.78u as=0.14875p ps=1.16u w=0.55u l=0.13u
X1101 a_12230_6162# a_13035_6284# a_12490_6385# VPWR sg13_lv_pmos ad=0.1428p pd=1.52u as=79.8f ps=0.8u w=0.42u l=0.13u
X1102 a_3692_9150# sg13cmos5l_inv_1_17.A VPWR VPWR sg13_lv_pmos ad=0.2856p pd=2.36u as=0.2114p ps=1.54u w=0.84u l=0.13u
X1103 a_7332_7674# sg13cmos5l_dfrbp_1_6.D a_7238_7674# VGND sg13_lv_nmos ad=60.89999f pd=0.71u as=0.1428p ps=1.52u w=0.42u l=0.13u
X1104 sg13cmos5l_buf_1_46.A a_9705_4650# VPWR VPWR sg13_lv_pmos ad=0.3808p pd=2.92u as=0.2128p ps=1.5u w=1.12u l=0.13u
X1105 VPWR sg13cmos5l_dfrbp_1_16.Q a_3625_7282# VPWR sg13_lv_pmos ad=1.07253p pd=6.75u as=0.2856p ps=2.36u w=0.84u l=0.13u
X1106 sg13cmos5l_dlhr_1_11.D a_11567_7751# VGND VGND sg13_lv_nmos ad=0.2849p pd=2.25u as=0.2516p ps=2.16u w=0.74u l=0.13u
X1107 a_17529_7047# a_16587_6935# a_17327_7285# VPWR sg13_lv_pmos ad=93.45f pd=0.865u as=0.2048p ps=1.63u w=0.42u l=0.13u
X1108 a_8988_6198# a_8439_6178# a_8852_6484# VGND sg13_lv_nmos ad=47.25f pd=0.645u as=0.141p ps=1.17u w=0.42u l=0.13u
X1109 sg13cmos5l_buf_1_10.A a_11848_8436# VPWR VPWR sg13_lv_pmos ad=0.42p pd=2.99u as=0.2114p ps=1.54u w=1.12u l=0.13u
X1110 a_19227_4654# sg13cmos5l_buf_8_0.A VPWR VPWR sg13_lv_pmos ad=0.2128p pd=1.5u as=0.2128p ps=1.5u w=1.12u l=0.13u
X1111 sg13cmos5l_dfrbp_1_11.Q a_8468_4948# VPWR VPWR sg13_lv_pmos ad=0.3808p pd=2.92u as=0.2128p ps=1.5u w=1.12u l=0.13u
X1112 VGND sg13cmos5l_dfrbp_1_6.RESET_B a_9940_4636# VGND sg13_lv_nmos ad=0.1406p pd=1.12u as=77.7f ps=0.95u w=0.74u l=0.13u
X1113 a_12742_6175# sg13cmos5l_dfrbp_1_6.RESET_B VGND VGND sg13_lv_nmos ad=37.8f pd=0.6u as=0.1701p ps=1.65u w=0.42u l=0.13u
X1114 VGND sg13cmos5l_buf_8_2.X a_20008_7712# VGND sg13_lv_nmos ad=0.14875p pd=1.16u as=0.187p ps=1.78u w=0.55u l=0.13u
X1115 a_8972_9150# sg13cmos5l_buf_1_77.A VPWR VPWR sg13_lv_pmos ad=0.2856p pd=2.36u as=0.2114p ps=1.54u w=0.84u l=0.13u
X1116 sg13cmos5l_buf_8_2.X a_19227_9190# VGND VGND sg13_lv_nmos ad=0.1406p pd=1.12u as=0.1406p ps=1.12u w=0.74u l=0.13u
X1117 VGND a_12976_2630# a_12625_2749# VGND sg13_lv_nmos ad=79.8f pd=0.8u as=0.1428p ps=1.52u w=0.42u l=0.13u
X1118 a_10473_9186# a_10292_9508# VPWR VPWR sg13_lv_pmos ad=0.2128p pd=1.5u as=0.2387p ps=1.84u w=1.12u l=0.13u
X1119 sg13cmos5l_dlhr_1_1.D a_1967_5773# VPWR VPWR sg13_lv_pmos ad=0.4312p pd=3.01u as=0.2639p ps=1.81u w=1.12u l=0.13u
X1120 VPWR sg13cmos5l_dfrbp_1_8.RESET_B a_14342_8874# VPWR sg13_lv_pmos ad=0.36237p pd=2.605u as=79.8f ps=0.8u w=0.42u l=0.13u
X1121 a_18961_5814# a_18409_5770# VGND VGND sg13_lv_nmos ad=71.99999f pd=0.865u as=1.97045p ps=12.335u w=0.64u l=0.13u
X1122 VPWR sg13cmos5l_dfrbp_1_6.RESET_B a_7498_7897# VPWR sg13_lv_pmos ad=0.1563p pd=1.22u as=0.147p ps=1.54u w=0.42u l=0.13u
X1123 a_7820_9150# sg13cmos5l_buf_1_73.A VPWR VPWR sg13_lv_pmos ad=0.2856p pd=2.36u as=0.2114p ps=1.54u w=0.84u l=0.13u
X1124 a_3308_9150# sg13cmos5l_buf_1_65.X VGND VGND sg13_lv_nmos ad=0.187p pd=1.78u as=0.14875p ps=1.16u w=0.55u l=0.13u
X1125 VPWR a_18860_6888# ph_sw[9] VPWR sg13_lv_pmos ad=0.2114p pd=1.54u as=0.42p ps=2.99u w=1.12u l=0.13u
X1126 VGND a_18928_1846# a_18577_1703# VGND sg13_lv_nmos ad=79.8f pd=0.8u as=0.1428p ps=1.52u w=0.42u l=0.13u
X1127 a_12120_3456# sg13cmos5l_o21ai_1_0.A1 VPWR VPWR sg13_lv_pmos ad=0.2128p pd=1.5u as=0.3808p ps=2.92u w=1.12u l=0.15u
X1128 nl_sw[3] a_4456_1664# VPWR VPWR sg13_lv_pmos ad=0.42p pd=2.99u as=0.2114p ps=1.54u w=1.12u l=0.13u
X1129 VPWR a_12815_4261# a_13652_3900# VPWR sg13_lv_pmos ad=0.2128p pd=1.5u as=0.3864p ps=2.93u w=1.12u l=0.13u
X1130 a_6276_8861# a_5988_8440# a_6214_8861# VGND sg13_lv_nmos ad=0.1428p pd=1.52u as=37.8f ps=0.6u w=0.42u l=0.13u
X1131 VGND sg13cmos5l_inv_1_18.A sg13cmos5l_buf_1_28.A VGND sg13_lv_nmos ad=0.2516p pd=2.16u as=0.2516p ps=2.16u w=0.74u l=0.13u
X1132 VPWR sg13cmos5l_dfrbp_1_6.RESET_B a_8841_5769# VPWR sg13_lv_pmos ad=0.2128p pd=1.5u as=0.2128p ps=1.5u w=1.12u l=0.13u
X1133 VGND a_14889_7281# a_15414_7354# VGND sg13_lv_nmos ad=0.1491p pd=1.18u as=0.187p ps=1.78u w=0.55u l=0.13u
X1134 VPWR sg13cmos5l_dfrbp_1_0.RESET_B a_15206_2826# VPWR sg13_lv_pmos ad=0.36237p pd=2.605u as=79.8f ps=0.8u w=0.42u l=0.13u
X1135 VGND a_13648_9406# a_13297_9263# VGND sg13_lv_nmos ad=79.8f pd=0.8u as=0.1428p ps=1.52u w=0.42u l=0.13u
X1136 a_10620_7326# a_10071_7282# a_10484_6924# VGND sg13_lv_nmos ad=47.25f pd=0.645u as=0.141p ps=1.17u w=0.42u l=0.13u
X1137 a_8588_3864# sg13cmos5l_buf_1_46.A VPWR VPWR sg13_lv_pmos ad=0.2856p pd=2.36u as=0.2114p ps=1.54u w=0.84u l=0.13u
X1138 VGND a_11973_1605# a_12075_1748# VGND sg13_lv_nmos ad=7.01497p pd=46.005u as=0.2516p ps=2.16u w=0.74u l=0.13u
X1139 VGND sg13cmos5l_dfrbp_1_6.RESET_B a_4276_2776# VGND sg13_lv_nmos ad=0.1406p pd=1.12u as=77.7f ps=0.95u w=0.74u l=0.13u
X1140 sg13cmos5l_dlhr_1_3.Q_N a_4566_2818# VPWR VPWR sg13_lv_pmos ad=0.3808p pd=2.92u as=0.1974p ps=1.5u w=1.12u l=0.13u
X1141 VGND sg13cmos5l_buf_1_31.X a_9448_6924# VGND sg13_lv_nmos ad=0.14875p pd=1.16u as=0.187p ps=1.78u w=0.55u l=0.13u
X1142 a_2224_7166# sg13cmos5l_dfrbp_1_6.RESET_B VPWR VPWR sg13_lv_pmos ad=79.8f pd=0.8u as=1.04815p ps=6.595u w=0.42u l=0.13u
X1143 VPWR a_8841_5769# a_8774_5412# VPWR sg13_lv_pmos ad=0.2387p pd=1.84u as=0.1008p ps=0.9u w=0.42u l=0.13u
X1144 a_9189_8447# sg13cmos5l_inv_1_2.A VPWR VPWR sg13_lv_pmos ad=0.4088p pd=2.97u as=1.12242p ps=7u w=1.12u l=0.13u
X1145 a_13520_4696# sg13cmos5l_inv_1_0.A a_13418_4696# VGND sg13_lv_nmos ad=0.1216p pd=1.02u as=0.1216p ps=1.02u w=0.64u l=0.13u
X1146 a_4005_4629# sg13cmos5l_inv_1_8.A VGND VGND sg13_lv_nmos ad=0.2516p pd=2.16u as=2.27517p ps=14.72u w=0.74u l=0.13u
X1147 sg13cmos5l_dfrbp_1_6.RESET_B cks VGND VGND sg13_lv_nmos ad=0.1443p pd=1.13u as=0.1406p ps=1.12u w=0.74u l=0.13u
X1148 VGND sg13cmos5l_buf_1_64.A a_3976_9224# VGND sg13_lv_nmos ad=0.14875p pd=1.16u as=0.187p ps=1.78u w=0.55u l=0.13u
X1149 VGND sg13cmos5l_dfrbp_1_8.RESET_B a_1956_4338# VGND sg13_lv_nmos ad=0.1626p pd=1.415u as=60.89999f ps=0.71u w=0.42u l=0.13u
X1150 a_19227_9190# cks VGND VGND sg13_lv_nmos ad=0.1406p pd=1.12u as=0.1406p ps=1.12u w=0.74u l=0.13u
X1151 a_13258_3361# a_13701_3117# a_12998_3138# VGND sg13_lv_nmos ad=79.8f pd=0.8u as=0.1296p ps=1.52u w=0.42u l=0.13u
X1152 VGND a_8588_2352# nl_sw[4] VGND sg13_lv_nmos ad=0.14875p pd=1.16u as=0.2886p ps=2.26u w=0.74u l=0.13u
X1153 VGND a_13701_3117# a_13803_3260# VGND sg13_lv_nmos ad=2.59257p pd=16.445u as=0.2516p ps=2.16u w=0.74u l=0.13u
X1154 a_8998_8861# sg13cmos5l_dfrbp_1_8.RESET_B VGND VGND sg13_lv_nmos ad=37.8f pd=0.6u as=0.1701p ps=1.65u w=0.42u l=0.13u
X1155 VPWR sg13cmos5l_dlygate4sd3_1_0.X sg13cmos5l_buf_1_43.A VPWR sg13_lv_pmos ad=0.3808p pd=2.92u as=0.3808p ps=2.92u w=1.12u l=0.13u
X1156 VPWR a_19227_9190# sg13cmos5l_buf_8_2.X VPWR sg13_lv_pmos ad=0.2128p pd=1.5u as=0.2128p ps=1.5u w=1.12u l=0.13u
X1157 a_16953_2511# a_16011_2399# a_16751_2749# VPWR sg13_lv_pmos ad=93.45f pd=0.865u as=0.2048p ps=1.63u w=0.42u l=0.13u
X1158 VGND a_5069_5376# sg13cmos5l_dfrbp_1_29.Q_N VGND sg13_lv_nmos ad=0.2516p pd=2.16u as=0.2849p ps=2.25u w=0.74u l=0.13u
X1159 VGND cks sg13cmos5l_dfrbp_1_6.RESET_B VGND sg13_lv_nmos ad=0.1406p pd=1.12u as=0.1406p ps=1.12u w=0.74u l=0.13u
X1160 VPWR a_16677_6141# a_16779_6284# VPWR sg13_lv_pmos ad=1.07253p pd=6.75u as=0.3864p ps=2.93u w=1.12u l=0.13u
X1161 a_1967_7285# a_1125_6935# a_708_6928# VPWR sg13_lv_pmos ad=0.2048p pd=1.63u as=0.34p ps=2.68u w=1u l=0.13u
X1162 sg13cmos5l_dfrbp_1_9.Q a_4244_3900# VPWR VPWR sg13_lv_pmos ad=0.3808p pd=2.92u as=0.2128p ps=1.5u w=1.12u l=0.13u
X1163 a_14820_7674# sg13cmos5l_buf_1_57.X a_14726_7674# VGND sg13_lv_nmos ad=60.89999f pd=0.71u as=0.1428p ps=1.52u w=0.42u l=0.13u
X1164 a_6736_2630# a_6479_2749# a_6898_2826# VGND sg13_lv_nmos ad=0.1428p pd=1.52u as=37.8f ps=0.6u w=0.42u l=0.13u
X1165 a_5799_5499# a_5951_5383# VPWR VPWR sg13_lv_pmos ad=0.3864p pd=2.93u as=1.28962p ps=8.195u w=1.12u l=0.13u
X1166 sg13cmos5l_inv_1_20.Y sg13cmos5l_buf_1_41.A VGND VGND sg13_lv_nmos ad=0.2516p pd=2.16u as=0.2516p ps=2.16u w=0.74u l=0.13u
X1167 VPWR VGND VPWR VPWR sg13_lv_pmos ad=0.19p pd=1.38u as=0 ps=0 w=1u l=1u
X1168 nh_sw[3] a_5704_1664# VGND VGND sg13_lv_nmos ad=0.2886p pd=2.26u as=0.14875p ps=1.16u w=0.74u l=0.13u
X1169 sg13cmos5l_dlhr_1_18.Q_N a_11190_7354# VPWR VPWR sg13_lv_pmos ad=0.3808p pd=2.92u as=0.1974p ps=1.5u w=1.12u l=0.13u
X1170 VGND a_15045_8447# a_15147_8447# VGND sg13_lv_nmos ad=2.92392p pd=18.89u as=0.2516p ps=2.16u w=0.74u l=0.13u
X1171 a_17367_8794# sg13cmos5l_dfrbp_1_22.D VGND VGND sg13_lv_nmos ad=0.2516p pd=2.16u as=0.15055p ps=1.17u w=0.74u l=0.13u
X1172 sg13cmos5l_nand2_1_0.B sg13cmos5l_a221oi_1_0.C1 VPWR VPWR sg13_lv_pmos ad=0.2128p pd=1.5u as=0.2198p ps=1.53u w=1.12u l=0.13u
X1173 sg13cmos5l_dlhr_1_11.GATE a_10868_8436# VPWR VPWR sg13_lv_pmos ad=0.3808p pd=2.92u as=0.2128p ps=1.5u w=1.12u l=0.13u
X1174 VPWR a_11973_1605# a_12075_1748# VPWR sg13_lv_pmos ad=1.86162p pd=11.935u as=0.3864p ps=2.93u w=1.12u l=0.13u
X1175 sg13cmos5l_dfrbp_1_22.Q_N a_17327_7285# VGND VGND sg13_lv_nmos ad=0.2849p pd=2.25u as=0.2516p ps=2.16u w=0.74u l=0.13u
X1176 VPWR a_1463_8741# a_1463_8511# VPWR sg13_lv_pmos ad=1.15047p pd=7.175u as=0.2442p ps=2.06u w=0.66u l=0.13u
X1177 a_2831_7630# sg13cmos5l_dfrbp_1_16.Q_N VGND VGND sg13_lv_nmos ad=0.187p pd=1.78u as=0.15055p ps=1.17u w=0.55u l=0.13u
X1178 a_12980_6924# a_12698_7288# a_12913_7326# VGND sg13_lv_nmos ad=0.141p pd=1.17u as=71.99999f ps=0.865u w=0.64u l=0.13u
X1179 a_18122_2388# sg13cmos5l_nor2_1_1.A VPWR VPWR sg13_lv_pmos ad=0.1176p pd=1.33u as=0.4032p ps=2.96u w=1.12u l=0.13u
X1180 a_2628_3151# a_2340_3456# a_2566_3151# VGND sg13_lv_nmos ad=0.1428p pd=1.52u as=37.8f ps=0.6u w=0.42u l=0.13u
X1181 a_4322_6162# sg13cmos5l_dfrbp_1_8.RESET_B VGND VGND sg13_lv_nmos ad=60.89999f pd=0.71u as=0.1626p ps=1.415u w=0.42u l=0.13u
X1182 sg13cmos5l_buf_1_105.A a_17961_8793# VGND VGND sg13_lv_nmos ad=0.2516p pd=2.16u as=0.1406p ps=1.12u w=0.74u l=0.13u
X1183 a_17327_7285# a_16485_6935# a_16068_6928# VPWR sg13_lv_pmos ad=0.2048p pd=1.63u as=0.34p ps=2.68u w=1u l=0.13u
X1184 a_3826_8874# sg13cmos5l_dfrbp_1_8.RESET_B VGND VGND sg13_lv_nmos ad=37.8f pd=0.6u as=79.8f ps=0.8u w=0.42u l=0.13u
X1185 a_19340_8400# sg13cmos5l_buf_1_107.X VPWR VPWR sg13_lv_pmos ad=0.2856p pd=2.36u as=0.2114p ps=1.54u w=0.84u l=0.13u
X1186 VPWR a_4076_7624# a_3676_7964# VPWR sg13_lv_pmos ad=0.2387p pd=1.84u as=0.2128p ps=1.5u w=1.12u l=0.13u
X1187 frame a_20008_7712# VPWR VPWR sg13_lv_pmos ad=0.42p pd=2.99u as=0.2114p ps=1.54u w=1.12u l=0.13u
X1188 sg13cmos5l_inv_1_29.A a_12404_7972# VGND VGND sg13_lv_nmos ad=0.2516p pd=2.16u as=0.1406p ps=1.12u w=0.74u l=0.13u
X1189 VGND sg13cmos5l_nand2_1_1.B a_10094_2780# VGND sg13_lv_nmos ad=0.2516p pd=2.16u as=96.2f ps=1u w=0.74u l=0.13u
X1190 VGND sg13cmos5l_a221oi_1_0.A2 a_8041_5770# VGND sg13_lv_nmos ad=0.15055p pd=1.17u as=0.187p ps=1.78u w=0.55u l=0.13u
X1191 a_8486_8874# sg13cmos5l_dfrbp_1_18.Q VPWR VPWR sg13_lv_pmos ad=79.8f pd=0.8u as=0.1428p ps=1.52u w=0.42u l=0.13u
X1192 a_16462_4023# a_16204_4338# VPWR VPWR sg13_lv_pmos ad=93.45f pd=0.865u as=1.43437p ps=9.105u w=0.42u l=0.13u
X1193 a_6084_4325# a_6315_3911# a_5770_3868# VGND sg13_lv_nmos ad=0.2373p pd=1.97u as=79.8f ps=0.8u w=0.42u l=0.13u
X1194 a_11973_3911# sg13cmos5l_dfrbp_1_0.CLK VGND VGND sg13_lv_nmos ad=0.2516p pd=2.16u as=2.41737p ps=15.64u w=0.74u l=0.13u
X1195 sg13cmos5l_buf_1_79.X a_9256_9224# VGND VGND sg13_lv_nmos ad=0.2886p pd=2.26u as=0.14875p ps=1.16u w=0.74u l=0.13u
X1196 VPWR VGND VPWR VPWR sg13_lv_pmos ad=0.19p pd=1.38u as=0 ps=0 w=1u l=1u
X1197 VPWR a_13701_3117# a_13803_3260# VPWR sg13_lv_pmos ad=1.43437p pd=9.105u as=0.3864p ps=2.93u w=1.12u l=0.13u
X1198 a_18928_1846# a_18671_1703# a_19090_1626# VGND sg13_lv_nmos ad=0.1428p pd=1.52u as=37.8f ps=0.6u w=0.42u l=0.13u
X1199 a_16940_3102# sg13cmos5l_buf_1_4.X VGND VGND sg13_lv_nmos ad=0.187p pd=1.78u as=0.14875p ps=1.16u w=0.55u l=0.13u
X1200 a_9129_8483# a_8772_8440# VPWR VPWR sg13_lv_pmos ad=63f pd=0.72u as=0.1563p ps=1.22u w=0.42u l=0.13u
X1201 a_7881_8065# a_7524_7992# VPWR VPWR sg13_lv_pmos ad=63f pd=0.72u as=0.1563p ps=1.22u w=0.42u l=0.13u
X1202 VPWR cks a_19227_9190# VPWR sg13_lv_pmos ad=0.2128p pd=1.5u as=0.2128p ps=1.5u w=1.12u l=0.13u
X1203 a_17638_1639# sg13cmos5l_dfrbp_1_0.RESET_B VGND VGND sg13_lv_nmos ad=37.8f pd=0.6u as=0.1701p ps=1.65u w=0.42u l=0.13u
X1204 a_14996_5412# a_14583_5770# a_14928_5412# VPWR sg13_lv_pmos ad=0.191p pd=1.44u as=0.105p ps=1.21u w=1u l=0.13u
X1205 VGND sg13cmos5l_dfrbp_1_8.RESET_B a_5546_5850# VGND sg13_lv_nmos ad=79.8f pd=0.8u as=37.8f ps=0.6u w=0.42u l=0.13u
X1206 VGND a_2732_1590# sg13cmos5l_buf_1_35.A VGND sg13_lv_nmos ad=0.14875p pd=1.16u as=0.2886p ps=2.26u w=0.74u l=0.13u
X1207 a_17595_3947# a_16703_3871# a_17493_3947# VPWR sg13_lv_pmos ad=63f pd=0.72u as=79.8f ps=0.8u w=0.42u l=0.13u
X1208 sg13cmos5l_dlhr_1_9.D a_2804_5412# VPWR VPWR sg13_lv_pmos ad=0.3808p pd=2.92u as=0.2128p ps=1.5u w=1.12u l=0.13u
X1209 VPWR a_4460_9150# sg13cmos5l_buf_1_60.X VPWR sg13_lv_pmos ad=0.2114p pd=1.54u as=0.42p ps=2.99u w=1.12u l=0.13u
X1210 sg13cmos5l_dfrbp_1_17.Q_N a_3407_8797# VGND VGND sg13_lv_nmos ad=0.2849p pd=2.25u as=0.2516p ps=2.16u w=0.74u l=0.13u
X1211 a_16268_1590# sg13cmos5l_buf_1_1.A VPWR VPWR sg13_lv_pmos ad=0.2856p pd=2.36u as=0.2114p ps=1.54u w=0.84u l=0.13u
X1212 VGND a_16271_7751# a_17108_7972# VGND sg13_lv_nmos ad=0.1406p pd=1.12u as=0.2516p ps=2.16u w=0.74u l=0.13u
X1213 a_4041_2745# a_3860_2388# VPWR VPWR sg13_lv_pmos ad=0.2128p pd=1.5u as=0.2387p ps=1.84u w=1.12u l=0.13u
X1214 a_12358_9199# sg13cmos5l_dfrbp_1_8.RESET_B VGND VGND sg13_lv_nmos ad=37.8f pd=0.6u as=0.1701p ps=1.65u w=0.42u l=0.13u
X1215 a_13876_7660# a_13460_7996# a_13641_7674# VGND sg13_lv_nmos ad=77.7f pd=0.95u as=0.2516p ps=2.16u w=0.74u l=0.13u
X1216 VPWR a_18363_4270# sg13cmos5l_or2_1_0.A VPWR sg13_lv_pmos ad=0.3864p pd=2.93u as=0.2128p ps=1.5u w=1.12u l=0.13u
X1217 sg13cmos5l_buf_1_93.X a_14632_9224# VGND VGND sg13_lv_nmos ad=0.2886p pd=2.26u as=0.14875p ps=1.16u w=0.74u l=0.13u
X1218 a_16751_2749# a_15909_2399# a_15492_2392# VPWR sg13_lv_pmos ad=0.2048p pd=1.63u as=0.34p ps=2.68u w=1u l=0.13u
X1219 a_17008_2630# sg13cmos5l_dfrbp_1_0.RESET_B VPWR VPWR sg13_lv_pmos ad=79.8f pd=0.8u as=1.777p ps=11.395u w=0.42u l=0.13u
X1220 nl_sw[2] a_2248_1664# VGND VGND sg13_lv_nmos ad=0.2886p pd=2.26u as=0.14875p ps=1.16u w=0.74u l=0.13u
X1221 a_14458_4270# sg13cmos5l_nand2_1_1.B VGND VGND sg13_lv_nmos ad=0.1406p pd=1.12u as=0.2516p ps=2.16u w=0.74u l=0.13u
X1222 a_11567_7751# a_10725_7653# a_10308_7992# VPWR sg13_lv_pmos ad=0.2048p pd=1.63u as=0.34p ps=2.68u w=1u l=0.13u
X1223 VPWR a_6117_6141# a_6219_6284# VPWR sg13_lv_pmos ad=1.07253p pd=6.75u as=0.3864p ps=2.93u w=1.12u l=0.13u
X1224 VPWR sg13cmos5l_buf_1_62.X a_1864_9224# VPWR sg13_lv_pmos ad=0.2114p pd=1.54u as=0.2856p ps=2.36u w=0.84u l=0.13u
X1225 a_12921_2511# a_11979_2399# a_12719_2749# VPWR sg13_lv_pmos ad=93.45f pd=0.865u as=0.2048p ps=1.63u w=0.42u l=0.13u
X1226 ph_sw[2] a_3976_9224# VPWR VPWR sg13_lv_pmos ad=0.42p pd=2.99u as=0.2114p ps=1.54u w=1.12u l=0.13u
X1227 VPWR a_3664_8678# a_3609_8559# VPWR sg13_lv_pmos ad=1.15047p pd=7.175u as=93.45f ps=0.865u w=0.42u l=0.13u
X1228 sg13cmos5l_buf_1_105.A a_17961_8793# VPWR VPWR sg13_lv_pmos ad=0.3808p pd=2.92u as=0.2128p ps=1.5u w=1.12u l=0.13u
X1229 VGND a_4076_5376# sg13cmos5l_inv_1_17.A VGND sg13_lv_nmos ad=0.14875p pd=1.16u as=0.2886p ps=2.26u w=0.74u l=0.13u
X1230 sg13cmos5l_or2_1_0.A a_18363_4270# VPWR VPWR sg13_lv_pmos ad=0.2128p pd=1.5u as=0.2128p ps=1.5u w=1.12u l=0.13u
X1231 a_5796_3904# a_5770_3868# VPWR VPWR sg13_lv_pmos ad=0.34p pd=2.68u as=0.36237p ps=2.605u w=1u l=0.13u
X1232 VGND sg13cmos5l_dfrbp_1_8.RESET_B a_6998_5837# VGND sg13_lv_nmos ad=0.1701p pd=1.65u as=37.8f ps=0.6u w=0.42u l=0.13u
X1233 sg13cmos5l_buf_1_104.X a_19624_8436# VPWR VPWR sg13_lv_pmos ad=0.42p pd=2.99u as=0.2114p ps=1.54u w=1.12u l=0.13u
X1234 sg13cmos5l_dfrbp_1_7.Q_N a_14543_3215# VPWR VPWR sg13_lv_pmos ad=0.4312p pd=3.01u as=0.2639p ps=1.81u w=1.12u l=0.13u
X1235 VGND a_18345_7674# a_18300_7710# VGND sg13_lv_nmos ad=0.1428p pd=1.52u as=47.25f ps=0.645u w=0.42u l=0.13u
X1236 VPWR VGND VPWR VPWR sg13_lv_pmos ad=0.19p pd=1.38u as=0 ps=0 w=1u l=1u
X1237 VPWR a_6479_2749# a_7316_2388# VPWR sg13_lv_pmos ad=0.2128p pd=1.5u as=0.3864p ps=2.93u w=1.12u l=0.13u
X1238 a_11940_9186# sg13cmos5l_dlhr_1_11.GATE a_11846_9186# VGND sg13_lv_nmos ad=60.89999f pd=0.71u as=0.1428p ps=1.52u w=0.42u l=0.13u
X1239 a_2228_4972# a_1946_4660# a_2161_4642# VGND sg13_lv_nmos ad=0.141p pd=1.17u as=71.99999f ps=0.865u w=0.64u l=0.13u
X1240 VPWR sg13cmos5l_buf_1_2.A a_15784_1664# VPWR sg13_lv_pmos ad=0.2114p pd=1.54u as=0.2856p ps=2.36u w=0.84u l=0.13u
X1241 a_10783_3876# sg13cmos5l_nand2_1_0.A VPWR VPWR sg13_lv_pmos ad=0.2716p pd=1.605u as=0.3808p ps=2.92u w=1.12u l=0.13u
X1242 a_524_4614# sg13cmos5l_buf_1_43.A VGND VGND sg13_lv_nmos ad=0.187p pd=1.78u as=0.14875p ps=1.16u w=0.55u l=0.13u
X1243 VPWR sg13cmos5l_inv_1_5.A a_20392_3900# VPWR sg13_lv_pmos ad=0.2114p pd=1.54u as=0.2856p ps=2.36u w=0.84u l=0.13u
X1244 a_14602_8404# a_15045_8447# a_14342_8874# VGND sg13_lv_nmos ad=79.8f pd=0.8u as=0.1296p ps=1.52u w=0.42u l=0.13u
X1245 sg13cmos5l_dlhr_1_10.Q a_19593_6162# VGND VGND sg13_lv_nmos ad=0.2516p pd=2.16u as=0.1406p ps=1.12u w=0.74u l=0.13u
X1246 VGND a_1967_5773# a_2804_5412# VGND sg13_lv_nmos ad=0.1406p pd=1.12u as=0.2516p ps=2.16u w=0.74u l=0.13u
X1247 VGND a_3664_4142# a_3313_4261# VGND sg13_lv_nmos ad=79.8f pd=0.8u as=0.1428p ps=1.52u w=0.42u l=0.13u
X1248 VGND sg13cmos5l_buf_1_40.A a_1192_1664# VGND sg13_lv_nmos ad=0.14875p pd=1.16u as=0.187p ps=1.78u w=0.55u l=0.13u
X1249 VPWR sg13cmos5l_dfrbp_1_6.RESET_B a_5770_3868# VPWR sg13_lv_pmos ad=0.1563p pd=1.22u as=0.147p ps=1.54u w=0.42u l=0.13u
X1250 VGND a_1125_6935# a_1227_6935# VGND sg13_lv_nmos ad=1.49685p pd=9.6u as=0.2516p ps=2.16u w=0.74u l=0.13u
X1251 VPWR a_1484_6126# sg13cmos5l_buf_1_40.A VPWR sg13_lv_pmos ad=0.2114p pd=1.54u as=0.42p ps=2.99u w=1.12u l=0.13u
X1252 a_6660_4663# a_6372_4968# a_6598_4663# VGND sg13_lv_nmos ad=0.1428p pd=1.52u as=37.8f ps=0.6u w=0.42u l=0.13u
X1253 a_16234_6385# a_16677_6141# a_15974_6162# VGND sg13_lv_nmos ad=79.8f pd=0.8u as=0.1296p ps=1.52u w=0.42u l=0.13u
X1254 VPWR a_13391_9263# a_13648_9406# VPWR sg13_lv_pmos ad=0.2639p pd=1.81u as=79.8f ps=0.8u w=0.42u l=0.13u
X1255 sg13cmos5l_dlhr_1_0.Q_N a_8214_1608# VPWR VPWR sg13_lv_pmos ad=0.3808p pd=2.92u as=0.1974p ps=1.5u w=1.12u l=0.13u
X1256 a_10292_9508# a_10010_9196# a_10225_9178# VGND sg13_lv_nmos ad=0.141p pd=1.17u as=71.99999f ps=0.865u w=0.64u l=0.13u
X1257 sg13cmos5l_dlhr_1_2.Q_N a_8022_3120# VGND VGND sg13_lv_nmos ad=0.2516p pd=2.16u as=0.1491p ps=1.18u w=0.74u l=0.13u
X1258 a_10416_6924# a_9865_7282# VPWR VPWR sg13_lv_pmos ad=0.105p pd=1.21u as=1.07253p ps=6.75u w=1u l=0.13u
X1259 a_14032_6382# sg13cmos5l_dfrbp_1_6.RESET_B VPWR VPWR sg13_lv_pmos ad=79.8f pd=0.8u as=1.04815p ps=6.595u w=0.42u l=0.13u
X1260 VGND sg13cmos5l_dfrbp_1_8.RESET_B a_3926_6175# VGND sg13_lv_nmos ad=0.1701p pd=1.65u as=37.8f ps=0.6u w=0.42u l=0.13u
X1261 VPWR a_3856_3358# a_3801_3453# VPWR sg13_lv_pmos ad=1.43437p pd=9.105u as=93.45f ps=0.865u w=0.42u l=0.13u
X1262 VGND a_8457_7281# a_8412_7326# VGND sg13_lv_nmos ad=0.1428p pd=1.52u as=47.25f ps=0.645u w=0.42u l=0.13u
X1263 a_422_7362# a_1227_6935# a_682_6892# VPWR sg13_lv_pmos ad=0.1428p pd=1.52u as=79.8f ps=0.8u w=0.42u l=0.13u
X1264 VPWR sg13cmos5l_dfrbp_1_6.RESET_B a_7238_7674# VPWR sg13_lv_pmos ad=0.36237p pd=2.605u as=79.8f ps=0.8u w=0.42u l=0.13u
X1265 a_18164_7996# a_17751_7690# a_18096_7996# VPWR sg13_lv_pmos ad=0.191p pd=1.44u as=0.105p ps=1.21u w=1u l=0.13u
X1266 VPWR sg13cmos5l_buf_1_29.A sg13cmos5l_buf_1_77.A VPWR sg13_lv_pmos ad=0.3808p pd=2.92u as=0.3808p ps=2.92u w=1.12u l=0.13u
X1267 VPWR VGND VPWR VPWR sg13_lv_pmos ad=0.34p pd=2.68u as=0 ps=0 w=1u l=1u
X1268 a_5452_5850# a_5069_5376# VPWR VPWR sg13_lv_pmos ad=79.8f pd=0.8u as=0.2639p ps=1.81u w=0.42u l=0.13u
X1269 a_4460_9150# sg13cmos5l_buf_1_60.A VPWR VPWR sg13_lv_pmos ad=0.2856p pd=2.36u as=0.2114p ps=1.54u w=0.84u l=0.13u
X1270 sg13cmos5l_inv_1_20.Y sg13cmos5l_buf_1_41.A VPWR VPWR sg13_lv_pmos ad=0.3808p pd=2.92u as=0.3808p ps=2.92u w=1.12u l=0.13u
X1271 VPWR sg13cmos5l_dfrbp_1_20.Q_N a_9673_9240# VPWR sg13_lv_pmos ad=4.11675p pd=27.17u as=0.2856p ps=2.36u w=0.84u l=0.13u
X1272 a_11877_2399# sg13cmos5l_dfrbp_1_0.CLK VPWR VPWR sg13_lv_pmos ad=0.4088p pd=2.97u as=1.777p ps=11.395u w=1.12u l=0.13u
X1273 VGND sg13cmos5l_dfrbp_1_0.RESET_B a_11364_1626# VGND sg13_lv_nmos ad=0.1626p pd=1.415u as=60.89999f ps=0.71u w=0.42u l=0.13u
X1274 VPWR sg13cmos5l_dfrbp_1_6.RESET_B a_13641_7674# VPWR sg13_lv_pmos ad=0.2128p pd=1.5u as=0.2128p ps=1.5u w=1.12u l=0.13u
X1275 VGND a_14924_1590# nh_sw[6] VGND sg13_lv_nmos ad=0.14875p pd=1.16u as=0.2886p ps=2.26u w=0.74u l=0.13u
X1276 a_2340_3456# a_2859_3260# a_3599_3215# VGND sg13_lv_nmos ad=0.3473p pd=2.71u as=0.12665p ps=1.145u w=0.74u l=0.13u
X1277 VPWR sg13cmos5l_dlhr_1_9.D a_10587_4692# VPWR sg13_lv_pmos ad=0.2198p pd=1.53u as=0.2856p ps=2.36u w=0.84u l=0.13u
X1278 VPWR VGND VPWR VPWR sg13_lv_pmos ad=0.19p pd=1.38u as=0 ps=0 w=1u l=1u
X1279 VGND sg13cmos5l_nor2_1_1.A sg13cmos5l_nor2b_1_1.Y VGND sg13_lv_nmos ad=0.2516p pd=2.16u as=0.1406p ps=1.12u w=0.74u l=0.13u
X1280 VPWR a_12719_2749# a_12976_2630# VPWR sg13_lv_pmos ad=0.2639p pd=1.81u as=79.8f ps=0.8u w=0.42u l=0.13u
X1281 sg13cmos5l_dfrbp_1_18.Q_N a_7247_8797# VPWR VPWR sg13_lv_pmos ad=0.4312p pd=3.01u as=0.2639p ps=1.81u w=1.12u l=0.13u
X1282 VGND sg13cmos5l_or2_1_1.B a_10726_5760# VGND sg13_lv_nmos ad=0.2516p pd=2.16u as=0.1406p ps=1.12u w=0.74u l=0.13u
X1283 sg13cmos5l_dfrbp_1_14.Q_N a_4847_4727# VGND VGND sg13_lv_nmos ad=0.2849p pd=2.25u as=0.2516p ps=2.16u w=0.74u l=0.13u
X1284 a_12716_8400# sg13cmos5l_buf_1_79.X VPWR VPWR sg13_lv_pmos ad=0.2856p pd=2.36u as=0.2114p ps=1.54u w=0.84u l=0.13u
X1285 a_17751_7690# sg13cmos5l_dfrbp_1_22.D VPWR VPWR sg13_lv_pmos ad=0.3234p pd=2.45u as=1.12242p ps=7u w=0.84u l=0.13u
X1286 sg13cmos5l_nor2b_1_1.Y sg13cmos5l_nor2_1_1.A a_14476_2388# VPWR sg13_lv_pmos ad=0.3808p pd=2.92u as=0.1176p ps=1.33u w=1.12u l=0.13u
X1287 VPWR a_7055_4261# a_7892_3900# VPWR sg13_lv_pmos ad=0.2128p pd=1.5u as=0.3864p ps=2.93u w=1.12u l=0.13u
X1288 VPWR a_5132_9150# sg13cmos5l_buf_1_64.A VPWR sg13_lv_pmos ad=0.2114p pd=1.54u as=0.42p ps=2.99u w=1.12u l=0.13u
X1289 sg13cmos5l_inv_1_7.A a_11464_8436# VPWR VPWR sg13_lv_pmos ad=0.42p pd=2.99u as=0.2114p ps=1.54u w=1.12u l=0.13u
X1290 a_6789_4629# sg13cmos5l_inv_1_8.A VGND VGND sg13_lv_nmos ad=0.2516p pd=2.16u as=2.27517p ps=14.72u w=0.74u l=0.13u
X1291 VGND sg13cmos5l_dlhr_1_15.Q a_19240_7712# VGND sg13_lv_nmos ad=0.14875p pd=1.16u as=0.187p ps=1.78u w=0.55u l=0.13u
X1292 sg13cmos5l_buf_1_5.X a_14440_1664# VGND VGND sg13_lv_nmos ad=0.2886p pd=2.26u as=0.14875p ps=1.16u w=0.74u l=0.13u
X1293 VGND sg13cmos5l_dfrbp_1_0.RESET_B a_13092_3138# VGND sg13_lv_nmos ad=0.1626p pd=1.415u as=60.89999f ps=0.71u w=0.42u l=0.13u
X1294 a_1196_8400# sg13cmos5l_buf_1_63.A VPWR VPWR sg13_lv_pmos ad=0.2856p pd=2.36u as=0.2114p ps=1.54u w=0.84u l=0.13u
X1295 VPWR sg13cmos5l_dfrbp_1_6.RESET_B a_9033_6162# VPWR sg13_lv_pmos ad=0.2128p pd=1.5u as=0.2128p ps=1.5u w=1.12u l=0.13u
X1296 a_12022_3134# sg13cmos5l_o21ai_1_0.A2 VGND VGND sg13_lv_nmos ad=0.1406p pd=1.12u as=0.1406p ps=1.12u w=0.74u l=0.15u
X1297 a_18345_7674# a_18164_7996# VPWR VPWR sg13_lv_pmos ad=0.2128p pd=1.5u as=0.2387p ps=1.84u w=1.12u l=0.13u
X1298 VPWR a_8247_5770# a_8378_5776# VPWR sg13_lv_pmos ad=1.28962p pd=8.195u as=0.2856p ps=2.36u w=0.84u l=0.13u
X1299 VPWR a_19628_2352# nh_sw[9] VPWR sg13_lv_pmos ad=0.2114p pd=1.54u as=0.42p ps=2.99u w=1.12u l=0.13u
X1300 VPWR a_19216_3358# a_19161_3453# VPWR sg13_lv_pmos ad=1.43437p pd=9.105u as=93.45f ps=0.865u w=0.42u l=0.13u
X1301 sg13cmos5l_dfrbp_1_6.D a_1672_3176# VPWR VPWR sg13_lv_pmos ad=0.42p pd=2.99u as=0.2114p ps=1.54u w=1.12u l=0.13u
X1302 VPWR sg13cmos5l_buf_1_24.A sg13cmos5l_buf_1_78.A VPWR sg13_lv_pmos ad=0.3808p pd=2.92u as=0.3808p ps=2.92u w=1.12u l=0.13u
X1303 VPWR sg13cmos5l_buf_1_18.A a_18376_2388# VPWR sg13_lv_pmos ad=0.2114p pd=1.54u as=0.2856p ps=2.36u w=0.84u l=0.13u
X1304 VGND sg13cmos5l_dfrbp_1_10.Q_N a_3241_2746# VGND sg13_lv_nmos ad=0.15055p pd=1.17u as=0.187p ps=1.78u w=0.55u l=0.13u
X1305 VPWR a_10031_8797# a_10288_8678# VPWR sg13_lv_pmos ad=0.2639p pd=1.81u as=79.8f ps=0.8u w=0.42u l=0.13u
X1306 a_8660_5412# a_8378_5776# a_8593_5814# VGND sg13_lv_nmos ad=0.141p pd=1.17u as=71.99999f ps=0.865u w=0.64u l=0.13u
X1307 a_5962_8404# a_6405_8447# a_6345_8483# VPWR sg13_lv_pmos ad=79.8f pd=0.8u as=63f ps=0.72u w=0.42u l=0.13u
X1308 a_17700_3456# a_18219_3260# a_18959_3215# VGND sg13_lv_nmos ad=0.3473p pd=2.71u as=0.12665p ps=1.145u w=0.74u l=0.13u
X1309 a_17776_6382# a_17519_6239# a_17938_6162# VGND sg13_lv_nmos ad=0.1428p pd=1.52u as=37.8f ps=0.6u w=0.42u l=0.13u
X1310 VGND sg13cmos5l_buf_1_41.X a_2824_2388# VGND sg13_lv_nmos ad=0.14875p pd=1.16u as=0.187p ps=1.78u w=0.55u l=0.13u
X1311 a_10420_5760# sg13cmos5l_dfrbp_1_16.Q VGND VGND sg13_lv_nmos ad=0.1406p pd=1.12u as=0.1406p ps=1.12u w=0.74u l=0.13u
X1312 sg13cmos5l_dfrbp_1_1.Q a_13652_1924# VPWR VPWR sg13_lv_pmos ad=0.3808p pd=2.92u as=0.2128p ps=1.5u w=1.12u l=0.13u
X1313 VPWR a_11372_3102# nh_sw[5] VPWR sg13_lv_pmos ad=0.2114p pd=1.54u as=0.42p ps=2.99u w=1.12u l=0.13u
X1314 a_4358_6924# a_3962_7288# a_4244_6924# VPWR sg13_lv_pmos ad=0.1008p pd=0.9u as=0.191p ps=1.44u w=0.42u l=0.13u
X1315 VGND VPWR VGND VGND sg13_lv_nmos ad=0.1428p pd=1.52u as=0 ps=0 w=0.42u l=1u
X1316 VGND sg13cmos5l_dfrbp_1_12.Q_N a_8905_4704# VGND sg13_lv_nmos ad=0.15055p pd=1.17u as=0.187p ps=1.78u w=0.55u l=0.13u
X1317 a_8439_6178# sg13cmos5l_dlhr_1_5.GATE VGND VGND sg13_lv_nmos ad=0.2516p pd=2.16u as=0.15055p ps=1.17u w=0.74u l=0.13u
X1318 a_682_6892# a_1125_6935# a_422_7362# VGND sg13_lv_nmos ad=79.8f pd=0.8u as=0.1296p ps=1.52u w=0.42u l=0.13u
X1319 VGND a_8841_5769# a_8796_5814# VGND sg13_lv_nmos ad=0.1428p pd=1.52u as=47.25f ps=0.645u w=0.42u l=0.13u
X1320 a_1956_8874# sg13cmos5l_dfrbp_1_17.D a_1862_8874# VGND sg13_lv_nmos ad=60.89999f pd=0.71u as=0.1428p ps=1.52u w=0.42u l=0.13u
X1321 a_5324_1590# sg13cmos5l_buf_1_34.X VGND VGND sg13_lv_nmos ad=0.187p pd=1.78u as=0.14875p ps=1.16u w=0.55u l=0.13u
X1322 VPWR a_7497_3138# a_7430_3576# VPWR sg13_lv_pmos ad=0.2387p pd=1.84u as=0.1008p ps=0.9u w=0.42u l=0.13u
X1323 VPWR sg13cmos5l_dfrbp_1_10.Q a_10331_3900# VPWR sg13_lv_pmos ad=0.2128p pd=1.5u as=0.2128p ps=1.5u w=1.12u l=0.13u
X1324 VGND VPWR VGND VGND sg13_lv_nmos ad=79.8f pd=0.8u as=0 ps=0 w=0.42u l=1u
X1325 VPWR sg13cmos5l_inv_1_0.A sg13cmos5l_inv_1_0.Y VPWR sg13_lv_pmos ad=0.3808p pd=2.92u as=0.3808p ps=2.92u w=1.12u l=0.13u
X1326 sg13cmos5l_nand2_1_1.A a_15380_3436# VPWR VPWR sg13_lv_pmos ad=0.3808p pd=2.92u as=0.2128p ps=1.5u w=1.12u l=0.13u
X1327 VPWR sg13cmos5l_dfrbp_1_6.RESET_B a_14726_7674# VPWR sg13_lv_pmos ad=0.36237p pd=2.605u as=79.8f ps=0.8u w=0.42u l=0.13u
X1328 sg13cmos5l_a22oi_1_0.B1 sg13cmos5l_nand2_1_0.A VPWR VPWR sg13_lv_pmos ad=0.2128p pd=1.5u as=0.3808p ps=2.92u w=1.12u l=0.13u
X1329 sg13cmos5l_dlhr_1_16.Q_N a_19734_5842# VPWR VPWR sg13_lv_pmos ad=0.3808p pd=2.92u as=0.1974p ps=1.5u w=1.12u l=0.13u
X1330 sg13cmos5l_dlhr_1_10.Q_N a_20118_6144# VGND VGND sg13_lv_nmos ad=0.2516p pd=2.16u as=0.1491p ps=1.18u w=0.74u l=0.13u
X1331 a_2748_6126# a_2879_6432# a_1997_6126# VPWR sg13_lv_pmos ad=0.34p pd=2.68u as=0.2048p ps=1.63u w=1u l=0.13u
X1332 sg13cmos5l_dfrbp_1_5.Q_N a_16751_2749# VPWR VPWR sg13_lv_pmos ad=0.4312p pd=3.01u as=0.2639p ps=1.81u w=1.12u l=0.13u
X1333 a_20012_1590# sg13cmos5l_buf_1_0.A VPWR VPWR sg13_lv_pmos ad=0.2856p pd=2.36u as=0.2114p ps=1.54u w=0.84u l=0.13u
X1334 a_14924_1590# sg13cmos5l_buf_1_6.A VPWR VPWR sg13_lv_pmos ad=0.2856p pd=2.36u as=0.2114p ps=1.54u w=0.84u l=0.13u
X1335 a_11556_3904# a_12075_3911# a_12815_4261# VGND sg13_lv_nmos ad=0.3473p pd=2.71u as=0.12665p ps=1.145u w=0.74u l=0.13u
X1336 a_11072_5347# sg13cmos5l_dlhr_1_15.D VPWR VPWR sg13_lv_pmos ad=0.1596p pd=1.22u as=0.36195p ps=1.84u w=0.84u l=0.13u
X1337 VPWR a_15702_4187# sg13cmos5l_and3_1_0.C VPWR sg13_lv_pmos ad=0.2128p pd=1.5u as=0.3808p ps=2.92u w=1.12u l=0.13u
X1338 a_5132_9150# sg13cmos5l_buf_1_44.X VPWR VPWR sg13_lv_pmos ad=0.2856p pd=2.36u as=0.2114p ps=1.54u w=0.84u l=0.13u
X1339 a_14342_8874# a_15147_8447# a_14602_8404# VPWR sg13_lv_pmos ad=0.1428p pd=1.52u as=79.8f ps=0.8u w=0.42u l=0.13u
X1340 a_4244_6924# a_3962_7288# a_4177_7326# VGND sg13_lv_nmos ad=0.141p pd=1.17u as=71.99999f ps=0.865u w=0.64u l=0.13u
X1341 VPWR a_18999_6178# a_19130_6172# VPWR sg13_lv_pmos ad=1.07253p pd=6.75u as=0.2856p ps=2.36u w=0.84u l=0.13u
X1342 sg13cmos5l_dfrbp_1_8.RESET_B cks VPWR VPWR sg13_lv_pmos ad=0.3808p pd=2.92u as=0.3808p ps=2.92u w=1.12u l=0.13u
X1343 VGND a_3407_4261# a_4244_3900# VGND sg13_lv_nmos ad=0.1406p pd=1.12u as=0.2516p ps=2.16u w=0.74u l=0.13u
X1344 a_2436_8861# a_2148_8440# a_2374_8861# VGND sg13_lv_nmos ad=0.1428p pd=1.52u as=37.8f ps=0.6u w=0.42u l=0.13u
X1345 VPWR sg13cmos5l_dfrbp_1_6.RESET_B a_14889_7281# VPWR sg13_lv_pmos ad=0.2128p pd=1.5u as=0.2128p ps=1.5u w=1.12u l=0.13u
X1346 sg13cmos5l_buf_1_4.X a_16552_1664# VGND VGND sg13_lv_nmos ad=0.2886p pd=2.26u as=0.14875p ps=1.16u w=0.74u l=0.13u
X1347 a_6213_3911# sg13cmos5l_dfrbp_1_11.Q VGND VGND sg13_lv_nmos ad=0.2516p pd=2.16u as=2.41737p ps=15.64u w=0.74u l=0.13u
X1348 a_2160_4972# a_1609_4704# VPWR VPWR sg13_lv_pmos ad=0.105p pd=1.21u as=1.28962p ps=8.195u w=1u l=0.13u
X1349 a_5637_2399# sg13cmos5l_dlhr_1_0.GATE VGND VGND sg13_lv_nmos ad=0.2516p pd=2.16u as=2.59257p ps=16.445u w=0.74u l=0.13u
X1350 VGND sg13cmos5l_dfrbp_1_6.RESET_B a_16068_6162# VGND sg13_lv_nmos ad=0.1626p pd=1.415u as=60.89999f ps=0.71u w=0.42u l=0.13u
X1351 sg13cmos5l_buf_1_111.A a_19240_7712# VPWR VPWR sg13_lv_pmos ad=0.42p pd=2.99u as=0.2114p ps=1.54u w=1.12u l=0.13u
X1352 VPWR cks sg13cmos5l_dfrbp_1_6.RESET_B VPWR sg13_lv_pmos ad=0.3808p pd=2.92u as=0.2184p ps=1.51u w=1.12u l=0.13u
X1353 sg13cmos5l_dlhr_1_0.GATE a_5684_4948# VGND VGND sg13_lv_nmos ad=0.2516p pd=2.16u as=0.1406p ps=1.12u w=0.74u l=0.13u
X1354 VGND sg13cmos5l_buf_1_68.X a_616_9224# VGND sg13_lv_nmos ad=0.14875p pd=1.16u as=0.187p ps=1.78u w=0.55u l=0.13u
X1355 a_14962_3138# sg13cmos5l_dfrbp_1_0.RESET_B VGND VGND sg13_lv_nmos ad=37.8f pd=0.6u as=79.8f ps=0.8u w=0.42u l=0.13u
X1356 sg13cmos5l_dlhr_1_5.D a_6959_6239# VPWR VPWR sg13_lv_pmos ad=0.4312p pd=3.01u as=0.2639p ps=1.81u w=1.12u l=0.13u
X1357 a_4847_4727# a_4005_4629# a_4753_4727# VGND sg13_lv_nmos ad=0.12665p pd=1.145u as=0.1428p ps=1.52u w=0.42u l=0.13u
X1358 a_15206_2826# a_16011_2399# a_15466_2356# VPWR sg13_lv_pmos ad=0.1428p pd=1.52u as=79.8f ps=0.8u w=0.42u l=0.13u
X1359 sg13cmos5l_o21ai_1_0.B1 sg13cmos5l_nand2_1_1.B VPWR VPWR sg13_lv_pmos ad=0.2128p pd=1.5u as=0.3808p ps=2.92u w=1.12u l=0.13u
X1360 a_19164_5814# a_18615_5770# a_19028_5412# VGND sg13_lv_nmos ad=47.25f pd=0.645u as=0.141p ps=1.17u w=0.42u l=0.13u
X1361 sg13cmos5l_or2_1_1.B sg13cmos5l_nor2_1_0.A VGND VGND sg13_lv_nmos ad=0.1406p pd=1.12u as=0.2516p ps=2.16u w=0.74u l=0.13u
X1362 VGND sg13cmos5l_buf_1_110.A a_15784_9224# VGND sg13_lv_nmos ad=0.14875p pd=1.16u as=0.187p ps=1.78u w=0.55u l=0.13u
X1363 VGND a_14900_2352# sg13cmos5l_nand2_1_0.A VGND sg13_lv_nmos ad=0.17255p pd=1.25u as=0.1406p ps=1.12u w=0.74u l=0.13u
X1364 VGND sg13cmos5l_buf_1_7.A a_14056_1664# VGND sg13_lv_nmos ad=0.14875p pd=1.16u as=0.187p ps=1.78u w=0.55u l=0.13u
X1365 VGND sg13cmos5l_buf_1_105.A a_18856_8436# VGND sg13_lv_nmos ad=0.14875p pd=1.16u as=0.187p ps=1.78u w=0.55u l=0.13u
X1366 VPWR sg13cmos5l_buf_1_77.X a_7336_9224# VPWR sg13_lv_pmos ad=0.2114p pd=1.54u as=0.2856p ps=2.36u w=0.84u l=0.13u
X1367 a_1846_7850# a_1948_7964# VGND VGND sg13_lv_nmos ad=0.187p pd=1.78u as=0.1491p ps=1.18u w=0.55u l=0.13u
X1368 a_3771_6553# a_2879_6432# a_3669_6320# VPWR sg13_lv_pmos ad=63f pd=0.72u as=79.8f ps=0.8u w=0.42u l=0.13u
X1369 VGND sg13cmos5l_dfrbp_1_8.RESET_B a_14436_8874# VGND sg13_lv_nmos ad=0.1626p pd=1.415u as=60.89999f ps=0.71u w=0.42u l=0.13u
X1370 sg13cmos5l_dlhr_1_18.Q_N a_11190_7354# VGND VGND sg13_lv_nmos ad=0.2516p pd=2.16u as=0.1491p ps=1.18u w=0.74u l=0.13u
X1371 a_4847_4727# a_4005_4629# a_3588_4968# VPWR sg13_lv_pmos ad=0.2048p pd=1.63u as=0.34p ps=2.68u w=1u l=0.13u
X1372 VGND a_6188_1590# sg13cmos5l_buf_1_25.X VGND sg13_lv_nmos ad=0.14875p pd=1.16u as=0.2886p ps=2.26u w=0.74u l=0.13u
X1373 VGND sg13cmos5l_dlhr_1_1.GATE a_4349_7636# VGND sg13_lv_nmos ad=0.15055p pd=1.17u as=0.2516p ps=2.16u w=0.74u l=0.13u
X1374 sg13cmos5l_dlhr_1_16.Q_N a_19734_5842# VGND VGND sg13_lv_nmos ad=0.2516p pd=2.16u as=0.1491p ps=1.18u w=0.74u l=0.13u
X1375 sg13cmos5l_dfrbp_1_21.Q a_18356_6460# VPWR VPWR sg13_lv_pmos ad=0.3808p pd=2.92u as=0.2128p ps=1.5u w=1.12u l=0.13u
X1376 VGND sg13cmos5l_dfrbp_1_6.RESET_B a_15412_5800# VGND sg13_lv_nmos ad=0.1406p pd=1.12u as=77.7f ps=0.95u w=0.74u l=0.13u
X1377 a_6647_5459# a_5951_5383# a_6741_5459# VGND sg13_lv_nmos ad=0.1296p pd=1.52u as=79.8f ps=0.8u w=0.42u l=0.13u
X1378 VGND a_7052_9150# sg13cmos5l_buf_1_76.X VGND sg13_lv_nmos ad=0.14875p pd=1.16u as=0.2886p ps=2.26u w=0.74u l=0.13u
X1379 VGND a_1878_6337# sg13cmos5l_dlhr_1_1.GATE VGND sg13_lv_nmos ad=0.1406p pd=1.12u as=0.2516p ps=2.16u w=0.74u l=0.13u
X1380 VPWR a_8439_6178# a_8570_6172# VPWR sg13_lv_pmos ad=1.07253p pd=6.75u as=0.2856p ps=2.36u w=0.84u l=0.13u
X1381 a_9823_2780# sg13cmos5l_a22oi_1_2.B1 VGND VGND sg13_lv_nmos ad=0.13875p pd=1.115u as=0.2553p ps=2.17u w=0.74u l=0.13u
X1382 a_14295_7282# sg13cmos5l_dfrbp_1_23.CLK VGND VGND sg13_lv_nmos ad=0.2516p pd=2.16u as=0.15055p ps=1.17u w=0.74u l=0.13u
X1383 a_6741_5459# a_5799_5499# a_6647_5459# VPWR sg13_lv_pmos ad=79.8f pd=0.8u as=0.1428p ps=1.52u w=0.42u l=0.13u
X1384 a_4276_2776# a_3860_2388# a_4041_2745# VGND sg13_lv_nmos ad=77.7f pd=0.95u as=0.2516p ps=2.16u w=0.74u l=0.13u
X1385 VPWR a_18345_7674# a_18870_7656# VPWR sg13_lv_pmos ad=0.1974p pd=1.5u as=0.2856p ps=2.36u w=0.84u l=0.13u
X1386 VGND a_18117_3117# a_18219_3260# VGND sg13_lv_nmos ad=2.59257p pd=16.445u as=0.2516p ps=2.16u w=0.74u l=0.13u
X1387 VGND sg13cmos5l_buf_1_8.A a_10888_1664# VGND sg13_lv_nmos ad=0.14875p pd=1.16u as=0.187p ps=1.78u w=0.55u l=0.13u
X1388 sg13cmos5l_buf_8_0.A a_18480_5028# VPWR VPWR sg13_lv_pmos ad=0.3976p pd=2.95u as=0.2226p ps=1.535u w=1.12u l=0.13u
X1389 a_7941_7653# sg13cmos5l_dfrbp_1_18.Q VGND VGND sg13_lv_nmos ad=0.2516p pd=2.16u as=1.49685p ps=9.6u w=0.74u l=0.13u
X1390 a_8746_8404# a_9189_8447# a_9129_8483# VPWR sg13_lv_pmos ad=79.8f pd=0.8u as=63f ps=0.72u w=0.42u l=0.13u
X1391 sg13cmos5l_dfrbp_1_16.Q_N a_1967_7285# VGND VGND sg13_lv_nmos ad=0.2849p pd=2.25u as=0.2516p ps=2.16u w=0.74u l=0.13u
X1392 sg13cmos5l_dlhr_1_5.Q a_8457_7281# VPWR VPWR sg13_lv_pmos ad=0.3808p pd=2.92u as=0.2128p ps=1.5u w=1.12u l=0.13u
X1393 sg13cmos5l_buf_1_8.A sg13cmos5l_inv_1_7.A VPWR VPWR sg13_lv_pmos ad=0.3808p pd=2.92u as=0.3808p ps=2.92u w=1.12u l=0.13u
X1394 a_8774_5412# a_8378_5776# a_8660_5412# VPWR sg13_lv_pmos ad=0.1008p pd=0.9u as=0.191p ps=1.44u w=0.42u l=0.13u
X1395 sg13cmos5l_buf_1_89.A a_14889_7281# VGND VGND sg13_lv_nmos ad=0.2516p pd=2.16u as=0.1406p ps=1.12u w=0.74u l=0.13u
X1396 VGND a_19593_6162# a_20118_6144# VGND sg13_lv_nmos ad=0.1491p pd=1.18u as=0.187p ps=1.78u w=0.55u l=0.13u
X1397 VGND sg13cmos5l_dfrbp_1_6.RESET_B a_5508_6162# VGND sg13_lv_nmos ad=0.1626p pd=1.415u as=60.89999f ps=0.71u w=0.42u l=0.13u
X1398 VGND a_11877_2399# a_11979_2399# VGND sg13_lv_nmos ad=2.59257p pd=16.445u as=0.2516p ps=2.16u w=0.74u l=0.13u
X1399 a_3599_3215# a_2757_3117# a_3505_3215# VGND sg13_lv_nmos ad=0.12665p pd=1.145u as=0.1428p ps=1.52u w=0.42u l=0.13u
X1400 a_18164_7996# a_17882_7684# a_18097_7666# VGND sg13_lv_nmos ad=0.141p pd=1.17u as=71.99999f ps=0.865u w=0.64u l=0.13u
X1401 VPWR VGND VPWR VPWR sg13_lv_pmos ad=0.34p pd=2.68u as=0 ps=0 w=1u l=1u
X1402 a_10116_7674# sg13cmos5l_buf_1_57.X a_10022_7674# VGND sg13_lv_nmos ad=60.89999f pd=0.71u as=0.1428p ps=1.52u w=0.42u l=0.13u
X1403 VPWR a_17135_4727# a_17972_4948# VPWR sg13_lv_pmos ad=0.2128p pd=1.5u as=0.3864p ps=2.93u w=1.12u l=0.13u
X1404 VPWR cks sg13cmos5l_dfrbp_1_6.RESET_B VPWR sg13_lv_pmos ad=0.2128p pd=1.5u as=0.2128p ps=1.5u w=1.12u l=0.13u
X1405 VPWR a_3407_4261# a_3664_4142# VPWR sg13_lv_pmos ad=0.2639p pd=1.81u as=79.8f ps=0.8u w=0.42u l=0.13u
X1406 a_3562_4873# a_4005_4629# a_3945_5041# VPWR sg13_lv_pmos ad=79.8f pd=0.8u as=63f ps=0.72u w=0.42u l=0.13u
X1407 a_4514_7666# a_4324_7996# a_4076_7624# VGND sg13_lv_nmos ad=71.99999f pd=0.865u as=0.141p ps=1.17u w=0.64u l=0.13u
X1408 sg13cmos5l_dfrbp_1_8.Q_N a_17135_4727# VGND VGND sg13_lv_nmos ad=0.2849p pd=2.25u as=0.2516p ps=2.16u w=0.74u l=0.13u
X1409 VGND sg13cmos5l_inv_1_1.A sg13cmos5l_buf_1_2.A VGND sg13_lv_nmos ad=0.2516p pd=2.16u as=0.2516p ps=2.16u w=0.74u l=0.13u
X1410 VPWR sg13cmos5l_dlhr_1_1.D a_1609_4704# VPWR sg13_lv_pmos ad=1.28962p pd=8.195u as=0.2856p ps=2.36u w=0.84u l=0.13u
X1411 VPWR sg13cmos5l_dfrbp_1_6.RESET_B a_15177_5769# VPWR sg13_lv_pmos ad=0.2128p pd=1.5u as=0.2128p ps=1.5u w=1.12u l=0.13u
X1412 a_17584_7166# a_17327_7285# a_17746_7362# VGND sg13_lv_nmos ad=0.1428p pd=1.52u as=37.8f ps=0.6u w=0.42u l=0.13u
X1413 VGND a_1463_8741# a_1463_8741# VGND sg13_lv_nmos ad=2.92392p pd=18.89u as=0.111p ps=1.34u w=0.3u l=0.13u
X1414 sg13cmos5l_buf_1_30.X a_8680_1664# VGND VGND sg13_lv_nmos ad=0.2886p pd=2.26u as=0.14875p ps=1.16u w=0.74u l=0.13u
X1415 a_13484_8400# sg13cmos5l_dlhr_1_11.Q VPWR VPWR sg13_lv_pmos ad=0.2856p pd=2.36u as=0.2114p ps=1.54u w=0.84u l=0.13u
X1416 VPWR a_5104_4870# a_5049_4965# VPWR sg13_lv_pmos ad=1.28962p pd=8.195u as=93.45f ps=0.865u w=0.42u l=0.13u
X1417 a_7498_7897# a_7941_7653# a_7881_8065# VPWR sg13_lv_pmos ad=79.8f pd=0.8u as=63f ps=0.72u w=0.42u l=0.13u
X1418 a_908_1590# sg13cmos5l_buf_1_32.A VPWR VPWR sg13_lv_pmos ad=0.2856p pd=2.36u as=0.2114p ps=1.54u w=0.84u l=0.13u
X1419 a_11054_4292# sg13cmos5l_nand2_1_0.A sg13cmos5l_a22oi_1_0.Y VGND sg13_lv_nmos ad=96.2f pd=1u as=0.2664p ps=1.46u w=0.74u l=0.13u
X1420 VGND a_4172_1590# sg13cmos5l_buf_1_33.A VGND sg13_lv_nmos ad=0.14875p pd=1.16u as=0.2886p ps=2.26u w=0.74u l=0.13u
X1421 a_1846_7850# a_1948_7964# VPWR VPWR sg13_lv_pmos ad=0.2856p pd=2.36u as=0.1974p ps=1.5u w=0.84u l=0.13u
X1422 VPWR sg13cmos5l_dfrbp_1_6.RESET_B a_10282_7897# VPWR sg13_lv_pmos ad=0.1563p pd=1.22u as=0.147p ps=1.54u w=0.42u l=0.13u
X1423 VPWR a_16572_4261# a_17595_3947# VPWR sg13_lv_pmos ad=0.1563p pd=1.22u as=63f ps=0.72u w=0.42u l=0.13u
X1424 VGND sg13cmos5l_nand2_1_2.B a_1210_4654# VGND sg13_lv_nmos ad=0.2516p pd=2.16u as=0.1406p ps=1.12u w=0.74u l=0.13u
X1425 VGND a_13100_8400# pl_sw[6] VGND sg13_lv_nmos ad=0.14875p pd=1.16u as=0.2886p ps=2.26u w=0.74u l=0.13u
X1426 sg13cmos5l_buf_1_6.A a_12520_3176# VPWR VPWR sg13_lv_pmos ad=0.42p pd=2.99u as=0.2114p ps=1.54u w=1.12u l=0.13u
X1427 ph_sw[0] a_616_9224# VPWR VPWR sg13_lv_pmos ad=0.42p pd=2.99u as=0.2114p ps=1.54u w=1.12u l=0.13u
X1428 sg13cmos5l_buf_1_3.X a_20296_1664# VGND VGND sg13_lv_nmos ad=0.2886p pd=2.26u as=0.14875p ps=1.16u w=0.74u l=0.13u
X1429 nl_sw[6] a_11656_3176# VGND VGND sg13_lv_nmos ad=0.2886p pd=2.26u as=0.14875p ps=1.16u w=0.74u l=0.13u
X1430 a_11782_1639# sg13cmos5l_dfrbp_1_0.RESET_B VGND VGND sg13_lv_nmos ad=37.8f pd=0.6u as=0.1701p ps=1.65u w=0.42u l=0.13u
X1431 sg13cmos5l_and3_1_0.X a_13324_4696# VGND VGND sg13_lv_nmos ad=0.2516p pd=2.16u as=0.1371p ps=1.12u w=0.74u l=0.13u
X1432 VGND a_18999_6178# a_19130_6172# VGND sg13_lv_nmos ad=1.97045p pd=12.335u as=0.2775p ps=2.23u w=0.74u l=0.13u
X1433 VGND sg13cmos5l_dfrbp_1_8.RESET_B a_8580_8874# VGND sg13_lv_nmos ad=0.1626p pd=1.415u as=60.89999f ps=0.71u w=0.42u l=0.13u
X1434 VPWR sg13cmos5l_buf_1_44.X sg13cmos5l_buf_1_38.A VPWR sg13_lv_pmos ad=0.3808p pd=2.92u as=0.3808p ps=2.92u w=1.12u l=0.13u
X1435 VPWR a_3308_9150# sg13cmos5l_inv_1_8.A VPWR sg13_lv_pmos ad=0.2114p pd=1.54u as=0.42p ps=2.99u w=1.12u l=0.13u
X1436 VPWR a_20492_8400# pl_sw[10] VPWR sg13_lv_pmos ad=0.2114p pd=1.54u as=0.42p ps=2.99u w=1.12u l=0.13u
X1437 sg13cmos5l_buf_1_103.A a_15784_9224# VPWR VPWR sg13_lv_pmos ad=0.42p pd=2.99u as=0.2114p ps=1.54u w=1.12u l=0.13u
X1438 sg13cmos5l_dlhr_1_6.D a_7796_6460# VPWR VPWR sg13_lv_pmos ad=0.3808p pd=2.92u as=0.2128p ps=1.5u w=1.12u l=0.13u
X1439 VPWR a_18117_3117# a_18219_3260# VPWR sg13_lv_pmos ad=1.43437p pd=9.105u as=0.3864p ps=2.93u w=1.12u l=0.13u
X1440 a_13593_9501# a_12651_9308# a_13391_9263# VPWR sg13_lv_pmos ad=93.45f pd=0.865u as=0.2048p ps=1.63u w=0.42u l=0.13u
X1441 a_7524_7992# a_8043_7796# a_8783_7751# VGND sg13_lv_nmos ad=0.3473p pd=2.71u as=0.12665p ps=1.145u w=0.74u l=0.13u
X1442 VGND sg13cmos5l_dfrbp_1_6.RESET_B a_7924_1612# VGND sg13_lv_nmos ad=0.1406p pd=1.12u as=77.7f ps=0.95u w=0.74u l=0.13u
X1443 a_5988_8440# a_5962_8404# VPWR VPWR sg13_lv_pmos ad=0.34p pd=2.68u as=0.36237p ps=2.605u w=1u l=0.13u
X1444 sg13cmos5l_buf_1_86.A a_20008_8436# VPWR VPWR sg13_lv_pmos ad=0.42p pd=2.99u as=0.2114p ps=1.54u w=1.12u l=0.13u
X1445 a_7941_7653# sg13cmos5l_dfrbp_1_18.Q VPWR VPWR sg13_lv_pmos ad=0.4088p pd=2.97u as=1.15047p ps=7.175u w=1.12u l=0.13u
X1446 VPWR sg13cmos5l_buf_1_89.A a_15208_6200# VPWR sg13_lv_pmos ad=0.2114p pd=1.54u as=0.2856p ps=2.36u w=0.84u l=0.13u
X1447 sg13cmos5l_dlhr_1_14.Q_N a_14166_7656# VPWR VPWR sg13_lv_pmos ad=0.3808p pd=2.92u as=0.1974p ps=1.5u w=1.12u l=0.13u
X1448 VGND VPWR VGND VGND sg13_lv_nmos ad=0.1428p pd=1.52u as=0 ps=0 w=0.42u l=1u
X1449 a_11556_3904# a_11530_3868# VGND VGND sg13_lv_nmos ad=0.2516p pd=2.16u as=0.1626p ps=1.415u w=0.74u l=0.13u
X1450 VGND a_8457_7281# a_8982_7354# VGND sg13_lv_nmos ad=0.1491p pd=1.18u as=0.187p ps=1.78u w=0.55u l=0.13u
X1451 a_5266_4650# sg13cmos5l_dfrbp_1_8.RESET_B VGND VGND sg13_lv_nmos ad=37.8f pd=0.6u as=79.8f ps=0.8u w=0.42u l=0.13u
X1452 sg13cmos5l_inv_1_3.A a_13768_8436# VPWR VPWR sg13_lv_pmos ad=0.42p pd=2.99u as=0.2114p ps=1.54u w=1.12u l=0.13u
X1453 sg13cmos5l_buf_1_19.X a_18760_2388# VPWR VPWR sg13_lv_pmos ad=0.42p pd=2.99u as=0.2114p ps=1.54u w=1.12u l=0.13u
X1454 sg13cmos5l_a22oi_1_1.B2 sg13cmos5l_and3_1_0.X a_13698_5412# VPWR sg13_lv_pmos ad=0.3808p pd=2.92u as=0.2128p ps=1.5u w=1.12u l=0.13u
X1455 a_7441_1618# a_6889_1680# VGND VGND sg13_lv_nmos ad=71.99999f pd=0.865u as=7.01497p ps=46.005u w=0.64u l=0.13u
X1456 sg13cmos5l_buf_1_65.X a_424_8436# VGND VGND sg13_lv_nmos ad=0.2886p pd=2.26u as=0.14875p ps=1.16u w=0.74u l=0.13u
X1457 VGND a_1846_7850# sg13cmos5l_dlhr_1_8.Q_N VGND sg13_lv_nmos ad=0.1491p pd=1.18u as=0.2516p ps=2.16u w=0.74u l=0.13u
X1458 VGND VPWR VGND VGND sg13_lv_nmos ad=0.1428p pd=1.52u as=0 ps=0 w=0.42u l=1u
X1459 VGND a_17776_6382# a_17425_6239# VGND sg13_lv_nmos ad=79.8f pd=0.8u as=0.1428p ps=1.52u w=0.42u l=0.13u
X1460 a_4425_7281# a_4244_6924# VPWR VPWR sg13_lv_pmos ad=0.2128p pd=1.5u as=0.2387p ps=1.84u w=1.12u l=0.13u
X1461 a_9164_1590# sg13cmos5l_buf_1_26.A VPWR VPWR sg13_lv_pmos ad=0.2856p pd=2.36u as=0.2114p ps=1.54u w=0.84u l=0.13u
X1462 a_9823_2364# sg13cmos5l_a22oi_1_2.B2 sg13cmos5l_dfrbp_1_1.D VPWR sg13_lv_pmos ad=0.2744p pd=1.61u as=0.2128p ps=1.5u w=1.12u l=0.13u
X1463 a_11973_3911# sg13cmos5l_dfrbp_1_0.CLK VPWR VPWR sg13_lv_pmos ad=0.4088p pd=2.97u as=1.38655p ps=8.8u w=1.12u l=0.13u
X1464 a_15012_7992# a_14986_7897# VPWR VPWR sg13_lv_pmos ad=0.34p pd=2.68u as=0.36237p ps=2.605u w=1u l=0.13u
X1465 VGND a_3831_7282# a_3962_7288# VGND sg13_lv_nmos ad=1.49685p pd=9.6u as=0.2775p ps=2.23u w=0.74u l=0.13u
X1466 VPWR sg13cmos5l_dlhr_1_2.D a_6697_3192# VPWR sg13_lv_pmos ad=1.43437p pd=9.105u as=0.2856p ps=2.36u w=0.84u l=0.13u
X1467 a_10331_1924# sg13cmos5l_nor2b_1_0.Y VPWR VPWR sg13_lv_pmos ad=0.3808p pd=2.92u as=0.2128p ps=1.5u w=1.12u l=0.13u
X1468 VGND a_5132_3864# sg13cmos5l_buf_1_44.X VGND sg13_lv_nmos ad=0.14875p pd=1.16u as=0.2886p ps=2.26u w=0.74u l=0.13u
X1469 a_3308_9150# sg13cmos5l_buf_1_65.X VPWR VPWR sg13_lv_pmos ad=0.2856p pd=2.36u as=0.2114p ps=1.54u w=0.84u l=0.13u
X1470 a_10233_8559# a_9291_8447# a_10031_8797# VPWR sg13_lv_pmos ad=93.45f pd=0.865u as=0.2048p ps=1.63u w=0.42u l=0.13u
X1471 sg13cmos5l_dfrbp_1_16.Q a_2804_6924# VGND VGND sg13_lv_nmos ad=0.2516p pd=2.16u as=0.1406p ps=1.12u w=0.74u l=0.13u
X1472 VGND a_8439_6178# a_8570_6172# VGND sg13_lv_nmos ad=1.97045p pd=12.335u as=0.2775p ps=2.23u w=0.74u l=0.13u
X1473 sg13cmos5l_dfrbp_1_25.Q_N a_15887_8797# VGND VGND sg13_lv_nmos ad=0.2849p pd=2.25u as=0.2516p ps=2.16u w=0.74u l=0.13u
X1474 a_708_5416# a_682_5380# VPWR VPWR sg13_lv_pmos ad=0.34p pd=2.68u as=0.36237p ps=2.605u w=1u l=0.13u
X1475 a_7812_7687# a_8043_7796# a_7498_7897# VGND sg13_lv_nmos ad=0.2373p pd=1.97u as=79.8f ps=0.8u w=0.42u l=0.13u
X1476 a_6736_2630# sg13cmos5l_dfrbp_1_6.RESET_B VPWR VPWR sg13_lv_pmos ad=79.8f pd=0.8u as=1.86162p ps=11.935u w=0.42u l=0.13u
X1477 ph_sw[10] a_20392_6924# VPWR VPWR sg13_lv_pmos ad=0.42p pd=2.99u as=0.2114p ps=1.54u w=1.12u l=0.13u
X1478 a_5194_2356# a_5637_2399# a_4934_2826# VGND sg13_lv_nmos ad=79.8f pd=0.8u as=0.1296p ps=1.52u w=0.42u l=0.13u
X1479 VGND sg13cmos5l_buf_1_44.X sg13cmos5l_buf_1_38.A VGND sg13_lv_nmos ad=0.2516p pd=2.16u as=0.2516p ps=2.16u w=0.74u l=0.13u
X1480 a_16164_4663# a_15876_4968# a_16102_4663# VGND sg13_lv_nmos ad=0.1428p pd=1.52u as=37.8f ps=0.6u w=0.42u l=0.13u
X1481 VGND a_16940_3102# nh_sw[8] VGND sg13_lv_nmos ad=0.14875p pd=1.16u as=0.2886p ps=2.26u w=0.74u l=0.13u
X1482 VPWR sg13cmos5l_buf_1_64.A a_3976_9224# VPWR sg13_lv_pmos ad=0.2114p pd=1.54u as=0.2856p ps=2.36u w=0.84u l=0.13u
X1483 a_15369_8065# a_15012_7992# VPWR VPWR sg13_lv_pmos ad=63f pd=0.72u as=0.1563p ps=1.22u w=0.42u l=0.13u
X1484 VPWR sg13cmos5l_dfrbp_1_6.RESET_B a_682_5380# VPWR sg13_lv_pmos ad=0.1563p pd=1.22u as=0.147p ps=1.54u w=0.42u l=0.13u
X1485 VGND a_12933_6141# a_13035_6284# VGND sg13_lv_nmos ad=1.97045p pd=12.335u as=0.2516p ps=2.16u w=0.74u l=0.13u
X1486 VGND a_14543_3215# a_15380_3436# VGND sg13_lv_nmos ad=0.1406p pd=1.12u as=0.2516p ps=2.16u w=0.74u l=0.13u
X1487 VPWR a_1125_6935# a_1227_6935# VPWR sg13_lv_pmos ad=1.07253p pd=6.75u as=0.3864p ps=2.93u w=1.12u l=0.13u
X1488 sg13cmos5l_buf_1_31.X a_424_1664# VPWR VPWR sg13_lv_pmos ad=0.42p pd=2.99u as=0.2114p ps=1.54u w=1.12u l=0.13u
X1489 a_13047_7690# sg13cmos5l_dlhr_1_11.GATE VPWR VPWR sg13_lv_pmos ad=0.3234p pd=2.45u as=1.12242p ps=7u w=0.84u l=0.13u
X1490 a_18096_7996# a_17545_7728# VPWR VPWR sg13_lv_pmos ad=0.105p pd=1.21u as=1.15047p ps=7.175u w=1u l=0.13u
X1491 sg13cmos5l_dfrbp_1_8.D a_18164_6924# VGND VGND sg13_lv_nmos ad=0.2516p pd=2.16u as=0.1406p ps=1.12u w=0.74u l=0.13u
X1492 VPWR a_20204_5376# sg13cmos5l_inv_1_6.A VPWR sg13_lv_pmos ad=0.2114p pd=1.54u as=0.42p ps=2.99u w=1.12u l=0.13u
X1493 a_2638_6477# a_2380_6162# VPWR VPWR sg13_lv_pmos ad=93.45f pd=0.865u as=1.07253p ps=6.75u w=0.42u l=0.13u
X1494 VGND sg13cmos5l_buf_1_104.A a_19624_8436# VGND sg13_lv_nmos ad=0.14875p pd=1.16u as=0.187p ps=1.78u w=0.55u l=0.13u
X1495 VPWR a_20012_2352# nl_sw[10] VPWR sg13_lv_pmos ad=0.2114p pd=1.54u as=0.42p ps=2.99u w=1.12u l=0.13u
X1496 a_2148_3904# a_2122_3868# VGND VGND sg13_lv_nmos ad=0.2516p pd=2.16u as=0.1626p ps=1.415u w=0.74u l=0.13u
X1497 a_3588_4968# a_3562_4873# VGND VGND sg13_lv_nmos ad=0.2516p pd=2.16u as=0.1626p ps=1.415u w=0.74u l=0.13u
X1498 VGND a_2565_3911# a_2667_3911# VGND sg13_lv_nmos ad=2.41737p pd=15.64u as=0.2516p ps=2.16u w=0.74u l=0.13u
X1499 a_14476_2388# a_14254_2444# VPWR VPWR sg13_lv_pmos ad=0.1176p pd=1.33u as=0.2618p ps=1.63u w=1.12u l=0.13u
X1500 VGND sg13cmos5l_buf_1_116.A a_15592_6200# VGND sg13_lv_nmos ad=0.14875p pd=1.16u as=0.187p ps=1.78u w=0.55u l=0.13u
X1501 a_10282_7897# a_10725_7653# a_10022_7674# VGND sg13_lv_nmos ad=79.8f pd=0.8u as=0.1296p ps=1.52u w=0.42u l=0.13u
X1502 VGND a_16748_9150# pl_sw[7] VGND sg13_lv_nmos ad=0.14875p pd=1.16u as=0.2886p ps=2.26u w=0.74u l=0.13u
X1503 a_516_7362# sg13cmos5l_dfrbp_1_6.D a_422_7362# VGND sg13_lv_nmos ad=60.89999f pd=0.71u as=0.1428p ps=1.52u w=0.42u l=0.13u
X1504 sg13cmos5l_dfrbp_1_4.Q_N a_12719_2749# VGND VGND sg13_lv_nmos ad=0.2849p pd=2.25u as=0.2516p ps=2.16u w=0.74u l=0.13u
X1505 a_1580_2352# sg13cmos5l_buf_1_40.X VGND VGND sg13_lv_nmos ad=0.187p pd=1.78u as=0.14875p ps=1.16u w=0.55u l=0.13u
X1506 sg13cmos5l_buf_1_56.A a_9033_6162# VGND VGND sg13_lv_nmos ad=0.2516p pd=2.16u as=0.1406p ps=1.12u w=0.74u l=0.13u
X1507 VGND sg13cmos5l_dfrbp_1_23.Q a_14089_7282# VGND sg13_lv_nmos ad=0.15055p pd=1.17u as=0.187p ps=1.78u w=0.55u l=0.13u
X1508 a_2342_5088# a_1946_4660# a_2228_4972# VPWR sg13_lv_pmos ad=0.1008p pd=0.9u as=0.191p ps=1.44u w=0.42u l=0.13u
X1509 VPWR a_11072_5347# sg13cmos5l_a221oi_1_1.C1 VPWR sg13_lv_pmos ad=0.36195p pd=1.84u as=0.3808p ps=2.92u w=1.12u l=0.13u
X1510 a_8588_2352# sg13cmos5l_buf_1_26.X VPWR VPWR sg13_lv_pmos ad=0.2856p pd=2.36u as=0.2114p ps=1.54u w=0.84u l=0.13u
X1511 sg13cmos5l_nand2_1_1.B a_15357_1816# VPWR VPWR sg13_lv_pmos ad=0.2128p pd=1.5u as=0.3808p ps=2.92u w=1.12u l=0.13u
X1512 a_5674_6385# a_6117_6141# a_5414_6162# VGND sg13_lv_nmos ad=79.8f pd=0.8u as=0.1296p ps=1.52u w=0.42u l=0.13u
X1513 VPWR VGND VPWR VPWR sg13_lv_pmos ad=0.19p pd=1.38u as=0 ps=0 w=1u l=1u
X1514 a_17392_4870# sg13cmos5l_dfrbp_1_8.RESET_B VPWR VPWR sg13_lv_pmos ad=79.8f pd=0.8u as=1.2517p ps=7.955u w=0.42u l=0.13u
X1515 VGND a_8204_2352# sg13cmos5l_buf_1_24.A VGND sg13_lv_nmos ad=0.14875p pd=1.16u as=0.2886p ps=2.26u w=0.74u l=0.13u
X1516 VGND sg13cmos5l_buf_1_74.X a_6568_9224# VGND sg13_lv_nmos ad=0.14875p pd=1.16u as=0.187p ps=1.78u w=0.55u l=0.13u
X1517 a_5628_3174# a_5079_3154# a_5492_3460# VGND sg13_lv_nmos ad=47.25f pd=0.645u as=0.141p ps=1.17u w=0.42u l=0.13u
X1518 VPWR sg13cmos5l_a22oi_1_0.Y sg13cmos5l_dfrbp_1_2.D VPWR sg13_lv_pmos ad=0.3808p pd=2.92u as=0.3808p ps=2.92u w=1.12u l=0.13u
X1519 sg13cmos5l_or2_1_0.A a_18363_4270# VGND VGND sg13_lv_nmos ad=0.1406p pd=1.12u as=0.1406p ps=1.12u w=0.74u l=0.13u
X1520 a_15850_4873# a_16293_4629# a_16233_5041# VPWR sg13_lv_pmos ad=79.8f pd=0.8u as=63f ps=0.72u w=0.42u l=0.13u
X1521 sg13cmos5l_buf_1_57.X a_9448_6924# VPWR VPWR sg13_lv_pmos ad=0.42p pd=2.99u as=0.2114p ps=1.54u w=1.12u l=0.13u
X1522 sg13cmos5l_buf_1_78.X a_6184_9224# VGND VGND sg13_lv_nmos ad=0.2886p pd=2.26u as=0.14875p ps=1.16u w=0.74u l=0.13u
X1523 sg13cmos5l_nor2_1_1.A a_17588_2388# VGND VGND sg13_lv_nmos ad=0.2516p pd=2.16u as=0.1406p ps=1.12u w=0.74u l=0.13u
X1524 a_11270_1626# a_12075_1748# a_11530_1849# VPWR sg13_lv_pmos ad=0.1428p pd=1.52u as=79.8f ps=0.8u w=0.42u l=0.13u
X1525 VPWR sg13cmos5l_dfrbp_1_6.RESET_B a_10022_7674# VPWR sg13_lv_pmos ad=0.36237p pd=2.605u as=79.8f ps=0.8u w=0.42u l=0.13u
X1526 VPWR a_5637_2399# a_5739_2399# VPWR sg13_lv_pmos ad=1.86162p pd=11.935u as=0.3864p ps=2.93u w=1.12u l=0.13u
X1527 a_11460_2392# a_11979_2399# a_12719_2749# VGND sg13_lv_nmos ad=0.3473p pd=2.71u as=0.12665p ps=1.145u w=0.74u l=0.13u
X1528 nh_sw[10] a_20392_3176# VPWR VPWR sg13_lv_pmos ad=0.42p pd=2.99u as=0.2114p ps=1.54u w=1.12u l=0.13u
X1529 a_16940_3102# sg13cmos5l_buf_1_4.X VPWR VPWR sg13_lv_pmos ad=0.2856p pd=2.36u as=0.2114p ps=1.54u w=0.84u l=0.13u
X1530 a_10094_2780# sg13cmos5l_inv_1_11.Y sg13cmos5l_dfrbp_1_1.D VGND sg13_lv_nmos ad=96.2f pd=1u as=0.2664p ps=1.46u w=0.74u l=0.13u
X1531 VPWR sg13cmos5l_nor2b_1_0.Y a_10783_3876# VPWR sg13_lv_pmos ad=0.3808p pd=2.92u as=0.2744p ps=1.61u w=1.12u l=0.13u
X1532 a_11394_4948# sg13cmos5l_a221oi_1_0.B2 a_11182_4948# VPWR sg13_lv_pmos ad=0.2128p pd=1.5u as=0.2128p ps=1.5u w=1.12u l=0.13u
X1533 a_16751_2749# a_15909_2399# a_16657_2749# VGND sg13_lv_nmos ad=0.12665p pd=1.145u as=0.1428p ps=1.52u w=0.42u l=0.13u
X1534 a_620_2352# sg13cmos5l_buf_1_32.X VGND VGND sg13_lv_nmos ad=0.187p pd=1.78u as=0.14875p ps=1.16u w=0.55u l=0.13u
X1535 a_16144_8678# a_15887_8797# a_16306_8874# VGND sg13_lv_nmos ad=0.1428p pd=1.52u as=37.8f ps=0.6u w=0.42u l=0.13u
X1536 VGND sg13cmos5l_buf_8_1.A a_18363_4270# VGND sg13_lv_nmos ad=0.1406p pd=1.12u as=0.1406p ps=1.12u w=0.74u l=0.13u
X1537 sg13cmos5l_dfrbp_1_27.Q_N a_10031_8797# VPWR VPWR sg13_lv_pmos ad=0.4312p pd=3.01u as=0.2639p ps=1.81u w=1.12u l=0.13u
X1538 a_3396_4650# sg13cmos5l_dfrbp_1_9.Q a_3302_4650# VGND sg13_lv_nmos ad=60.89999f pd=0.71u as=0.1428p ps=1.52u w=0.42u l=0.13u
X1539 VGND sg13cmos5l_buf_1_10.A sg13cmos5l_inv_1_28.Y VGND sg13_lv_nmos ad=0.2516p pd=2.16u as=0.2516p ps=2.16u w=0.74u l=0.13u
X1540 sg13cmos5l_dlhr_1_11.Q a_13161_7281# VPWR VPWR sg13_lv_pmos ad=0.3808p pd=2.92u as=0.2128p ps=1.5u w=1.12u l=0.13u
X1541 VGND a_1196_8400# sg13cmos5l_buf_1_63.X VGND sg13_lv_nmos ad=0.14875p pd=1.16u as=0.2886p ps=2.26u w=0.74u l=0.13u
X1542 a_2224_5654# sg13cmos5l_dfrbp_1_6.RESET_B VPWR VPWR sg13_lv_pmos ad=79.8f pd=0.8u as=1.28962p ps=8.195u w=0.42u l=0.13u
X1543 sg13cmos5l_nand2_1_2.B sg13cmos5l_nor2_1_2.A VGND VGND sg13_lv_nmos ad=0.1406p pd=1.12u as=0.2516p ps=2.16u w=0.74u l=0.13u
X1544 VPWR sg13cmos5l_inv_1_0.Y a_11182_4948# VPWR sg13_lv_pmos ad=0.3808p pd=2.92u as=0.2128p ps=1.5u w=1.12u l=0.13u
X1545 a_10406_9624# a_10010_9196# a_10292_9508# VPWR sg13_lv_pmos ad=0.1008p pd=0.9u as=0.191p ps=1.44u w=0.42u l=0.13u
X1546 sg13cmos5l_dfrbp_1_22.D a_16724_8436# VGND VGND sg13_lv_nmos ad=0.2516p pd=2.16u as=0.1406p ps=1.12u w=0.74u l=0.13u
X1547 sg13cmos5l_dlhr_1_12.D a_16271_7751# VGND VGND sg13_lv_nmos ad=0.2849p pd=2.25u as=0.2516p ps=2.16u w=0.74u l=0.13u
X1548 a_2314_3361# a_2757_3117# a_2054_3138# VGND sg13_lv_nmos ad=79.8f pd=0.8u as=0.1296p ps=1.52u w=0.42u l=0.13u
X1549 VPWR sg13cmos5l_dfrbp_1_8.RESET_B a_3562_4873# VPWR sg13_lv_pmos ad=0.1563p pd=1.22u as=0.147p ps=1.54u w=0.42u l=0.13u
X1550 VPWR a_15045_8447# a_15147_8447# VPWR sg13_lv_pmos ad=1.15047p pd=7.175u as=0.3864p ps=2.93u w=1.12u l=0.13u
X1551 VPWR a_4005_4629# a_4107_4772# VPWR sg13_lv_pmos ad=1.28962p pd=8.195u as=0.3864p ps=2.93u w=1.12u l=0.13u
X1552 a_16356_7349# a_16068_6928# a_16294_7349# VGND sg13_lv_nmos ad=0.1428p pd=1.52u as=37.8f ps=0.6u w=0.42u l=0.13u
X1553 sg13cmos5l_dfrbp_1_23.Q_N a_13775_6239# VPWR VPWR sg13_lv_pmos ad=0.4312p pd=3.01u as=0.2639p ps=1.81u w=1.12u l=0.13u
X1554 a_12933_6141# sg13cmos5l_dfrbp_1_23.CLK VPWR VPWR sg13_lv_pmos ad=0.4088p pd=2.97u as=1.04815p ps=6.595u w=1.12u l=0.13u
X1555 a_7216_6382# a_6959_6239# a_7378_6162# VGND sg13_lv_nmos ad=0.1428p pd=1.52u as=37.8f ps=0.6u w=0.42u l=0.13u
X1556 VPWR a_2748_6126# a_3771_6553# VPWR sg13_lv_pmos ad=0.1563p pd=1.22u as=63f ps=0.72u w=0.42u l=0.13u
X1557 a_5796_3904# a_5770_3868# VGND VGND sg13_lv_nmos ad=0.2516p pd=2.16u as=0.1626p ps=1.415u w=0.74u l=0.13u
X1558 a_5926_6175# sg13cmos5l_dfrbp_1_6.RESET_B VGND VGND sg13_lv_nmos ad=37.8f pd=0.6u as=0.1701p ps=1.65u w=0.42u l=0.13u
X1559 a_5220_2392# a_5194_2356# VGND VGND sg13_lv_nmos ad=0.2516p pd=2.16u as=0.1626p ps=1.415u w=0.74u l=0.13u
X1560 a_13072_4142# sg13cmos5l_dfrbp_1_0.RESET_B VPWR VPWR sg13_lv_pmos ad=79.8f pd=0.8u as=1.38655p ps=8.8u w=0.42u l=0.13u
X1561 a_12216_5728# sg13cmos5l_dfrbp_1_21.Q VGND VGND sg13_lv_nmos ad=0.1045p pd=0.93u as=0.1469p ps=1.155u w=0.55u l=0.13u
X1562 VGND a_17829_1605# a_17931_1748# VGND sg13_lv_nmos ad=7.01497p pd=46.005u as=0.2516p ps=2.16u w=0.74u l=0.13u
X1563 VGND a_13072_1846# a_12721_1703# VGND sg13_lv_nmos ad=79.8f pd=0.8u as=0.1428p ps=1.52u w=0.42u l=0.13u
X1564 VGND a_18860_9150# ph_sw[8] VGND sg13_lv_nmos ad=0.14875p pd=1.16u as=0.2886p ps=2.26u w=0.74u l=0.13u
X1565 sg13cmos5l_buf_1_95.X a_12232_8436# VGND VGND sg13_lv_nmos ad=0.2886p pd=2.26u as=0.14875p ps=1.16u w=0.74u l=0.13u
X1566 VPWR sg13cmos5l_buf_1_40.A a_1192_1664# VPWR sg13_lv_pmos ad=0.2114p pd=1.54u as=0.2856p ps=2.36u w=0.84u l=0.13u
X1567 VPWR a_17584_7166# a_17529_7047# VPWR sg13_lv_pmos ad=1.07253p pd=6.75u as=93.45f ps=0.865u w=0.42u l=0.13u
X1568 VPWR a_3212_1590# sg13cmos5l_buf_1_41.X VPWR sg13_lv_pmos ad=0.2114p pd=1.54u as=0.42p ps=2.99u w=1.12u l=0.13u
X1569 a_14822_6924# a_14426_7288# a_14708_6924# VPWR sg13_lv_pmos ad=0.1008p pd=0.9u as=0.191p ps=1.44u w=0.42u l=0.13u
X1570 sg13cmos5l_buf_1_4.A a_15592_6200# VPWR VPWR sg13_lv_pmos ad=0.42p pd=2.99u as=0.2114p ps=1.54u w=1.12u l=0.13u
X1571 VPWR a_7247_8797# a_8084_8436# VPWR sg13_lv_pmos ad=0.2128p pd=1.5u as=0.3864p ps=2.93u w=1.12u l=0.13u
X1572 a_9660_4686# a_9111_4666# a_9524_4972# VGND sg13_lv_nmos ad=47.25f pd=0.645u as=0.141p ps=1.17u w=0.42u l=0.13u
X1573 a_6213_3911# sg13cmos5l_dfrbp_1_11.Q VPWR VPWR sg13_lv_pmos ad=0.4088p pd=2.97u as=1.43437p ps=9.105u w=1.12u l=0.13u
X1574 VPWR VGND VPWR VPWR sg13_lv_pmos ad=0.34p pd=2.68u as=0 ps=0 w=1u l=1u
X1575 a_17399_3947# sg13cmos5l_dfrbp_1_6.D a_18146_4338# VGND sg13_lv_nmos ad=0.1428p pd=1.52u as=60.89999f ps=0.71u w=0.42u l=0.13u
X1576 a_17674_3361# a_18117_3117# a_17414_3138# VGND sg13_lv_nmos ad=79.8f pd=0.8u as=0.1296p ps=1.52u w=0.42u l=0.13u
X1577 sg13cmos5l_dfrbp_1_14.Q_N a_4847_4727# VPWR VPWR sg13_lv_pmos ad=0.4312p pd=3.01u as=0.2639p ps=1.81u w=1.12u l=0.13u
X1578 sg13cmos5l_buf_1_87.A a_18376_9224# VGND VGND sg13_lv_nmos ad=0.2886p pd=2.26u as=0.14875p ps=1.16u w=0.74u l=0.13u
X1579 VPWR sg13cmos5l_nand2_1_1.A a_20008_3900# VPWR sg13_lv_pmos ad=0.2114p pd=1.54u as=0.2856p ps=2.36u w=0.84u l=0.13u
X1580 a_7622_2064# a_7226_1636# a_7508_1948# VPWR sg13_lv_pmos ad=0.1008p pd=0.9u as=0.191p ps=1.44u w=0.42u l=0.13u
X1581 a_12420_9199# a_12651_9308# a_12106_9409# VGND sg13_lv_nmos ad=0.2373p pd=1.97u as=79.8f ps=0.8u w=0.42u l=0.13u
X1582 VPWR sg13cmos5l_inv_1_5.A sg13cmos5l_a22oi_1_1.A1 VPWR sg13_lv_pmos ad=0.3808p pd=2.92u as=0.3808p ps=2.92u w=1.12u l=0.13u
X1583 VGND sg13cmos5l_a22oi_1_0.Y sg13cmos5l_dfrbp_1_2.D VGND sg13_lv_nmos ad=0.2516p pd=2.16u as=0.2516p ps=2.16u w=0.74u l=0.13u
X1584 a_10433_1652# sg13cmos5l_dlhr_1_0.D sg13cmos5l_a22oi_1_2.B1 VGND sg13_lv_nmos ad=0.1406p pd=1.12u as=0.1406p ps=1.12u w=0.74u l=0.13u
X1585 a_3308_5376# sg13cmos5l_dlhr_1_1.Q VPWR VPWR sg13_lv_pmos ad=0.2856p pd=2.36u as=0.2114p ps=1.54u w=0.84u l=0.13u
X1586 ph_sw[4] a_6568_9224# VPWR VPWR sg13_lv_pmos ad=0.42p pd=2.99u as=0.2114p ps=1.54u w=1.12u l=0.13u
X1587 VGND cks sg13cmos5l_dfrbp_1_6.RESET_B VGND sg13_lv_nmos ad=0.1406p pd=1.12u as=0.1406p ps=1.12u w=0.74u l=0.13u
X1588 a_12106_9409# a_12549_9165# a_12489_9577# VPWR sg13_lv_pmos ad=79.8f pd=0.8u as=63f ps=0.72u w=0.42u l=0.13u
X1589 a_12719_2749# a_11877_2399# a_12625_2749# VGND sg13_lv_nmos ad=0.12665p pd=1.145u as=0.1428p ps=1.52u w=0.42u l=0.13u
X1590 a_15780_2813# a_15492_2392# a_15718_2813# VGND sg13_lv_nmos ad=0.1428p pd=1.52u as=37.8f ps=0.6u w=0.42u l=0.13u
X1591 a_2224_7166# a_1967_7285# a_2386_7362# VGND sg13_lv_nmos ad=0.1428p pd=1.52u as=37.8f ps=0.6u w=0.42u l=0.13u
X1592 a_14708_6924# a_14426_7288# a_14641_7326# VGND sg13_lv_nmos ad=0.141p pd=1.17u as=71.99999f ps=0.865u w=0.64u l=0.13u
X1593 a_9879_9202# sg13cmos5l_dfrbp_1_18.Q VPWR VPWR sg13_lv_pmos ad=0.3234p pd=2.45u as=4.11675p ps=27.17u w=0.84u l=0.13u
X1594 VGND sg13cmos5l_dfrbp_1_6.RESET_B a_12324_6162# VGND sg13_lv_nmos ad=0.1626p pd=1.415u as=60.89999f ps=0.71u w=0.42u l=0.13u
X1595 VPWR a_13641_7674# a_14166_7656# VPWR sg13_lv_pmos ad=0.1974p pd=1.5u as=0.2856p ps=2.36u w=0.84u l=0.13u
X1596 VPWR sg13cmos5l_inv_1_1.A sg13cmos5l_buf_1_2.A VPWR sg13_lv_pmos ad=0.3808p pd=2.92u as=0.3808p ps=2.92u w=1.12u l=0.13u
X1597 VPWR sg13cmos5l_dfrbp_1_1.Q a_20392_2388# VPWR sg13_lv_pmos ad=0.2114p pd=1.54u as=0.2856p ps=2.36u w=0.84u l=0.13u
X1598 sg13cmos5l_dfrbp_1_0.D sg13cmos5l_dfrbp_1_0.Q a_18122_2388# VPWR sg13_lv_pmos ad=0.3808p pd=2.92u as=0.1176p ps=1.33u w=1.12u l=0.13u
X1599 VGND sg13cmos5l_inv_1_0.A sg13cmos5l_nor2b_1_0.Y VGND sg13_lv_nmos ad=0.2516p pd=2.16u as=0.1406p ps=1.12u w=0.74u l=0.13u
X1600 VPWR a_17829_1605# a_17931_1748# VPWR sg13_lv_pmos ad=1.86162p pd=11.935u as=0.3864p ps=2.93u w=1.12u l=0.13u
X1601 VPWR a_4425_7281# a_4950_7354# VPWR sg13_lv_pmos ad=0.1974p pd=1.5u as=0.2856p ps=2.36u w=0.84u l=0.13u
X1602 a_14745_3453# a_13803_3260# a_14543_3215# VPWR sg13_lv_pmos ad=93.45f pd=0.865u as=0.2048p ps=1.63u w=0.42u l=0.13u
X1603 sg13cmos5l_inv_1_26.Y sg13cmos5l_buf_1_19.A VGND VGND sg13_lv_nmos ad=0.2516p pd=2.16u as=0.2516p ps=2.16u w=0.74u l=0.13u
X1604 VGND VPWR VGND VGND sg13_lv_nmos ad=0.1428p pd=1.52u as=0 ps=0 w=0.42u l=1u
X1605 sg13cmos5l_dlhr_1_10.Q a_19593_6162# VPWR VPWR sg13_lv_pmos ad=0.3808p pd=2.92u as=0.2128p ps=1.5u w=1.12u l=0.13u
X1606 a_11372_3102# sg13cmos5l_buf_1_9.A VGND VGND sg13_lv_nmos ad=0.187p pd=1.78u as=0.14875p ps=1.16u w=0.55u l=0.13u
X1607 VPWR sg13cmos5l_dfrbp_1_8.RESET_B a_11846_9186# VPWR sg13_lv_pmos ad=0.36237p pd=2.605u as=79.8f ps=0.8u w=0.42u l=0.13u
X1608 a_16572_4261# a_16703_3871# a_15821_3864# VPWR sg13_lv_pmos ad=0.34p pd=2.68u as=0.2048p ps=1.63u w=1u l=0.13u
X1609 VPWR sg13cmos5l_dfrbp_1_23.Q a_14089_7282# VPWR sg13_lv_pmos ad=1.07253p pd=6.75u as=0.2856p ps=2.36u w=0.84u l=0.13u
X1610 VGND a_16268_3102# nl_sw[8] VGND sg13_lv_nmos ad=0.14875p pd=1.16u as=0.2886p ps=2.26u w=0.74u l=0.13u
X1611 VPWR sg13cmos5l_dfrbp_1_6.RESET_B a_4934_2826# VPWR sg13_lv_pmos ad=0.36237p pd=2.605u as=79.8f ps=0.8u w=0.42u l=0.13u
X1612 a_11270_4338# sg13cmos5l_dfrbp_1_2.D VPWR VPWR sg13_lv_pmos ad=79.8f pd=0.8u as=0.1428p ps=1.52u w=0.42u l=0.13u
X1613 a_13393_7666# a_12841_7728# VGND VGND sg13_lv_nmos ad=71.99999f pd=0.865u as=1.49685p ps=9.6u w=0.64u l=0.13u
X1614 VPWR sg13cmos5l_buf_1_10.A sg13cmos5l_inv_1_28.Y VPWR sg13_lv_pmos ad=0.3808p pd=2.92u as=0.3808p ps=2.92u w=1.12u l=0.13u
X1615 VGND sg13cmos5l_dfrbp_1_1.Q sg13cmos5l_inv_1_11.Y VGND sg13_lv_nmos ad=0.2516p pd=2.16u as=0.2516p ps=2.16u w=0.74u l=0.13u
X1616 a_12567_7282# sg13cmos5l_dlhr_1_11.GATE VGND VGND sg13_lv_nmos ad=0.2516p pd=2.16u as=0.15055p ps=1.17u w=0.74u l=0.13u
X1617 sg13cmos5l_buf_8_0.X a_19227_4654# VGND VGND sg13_lv_nmos ad=0.1406p pd=1.12u as=0.1406p ps=1.12u w=0.74u l=0.13u
X1618 VPWR a_3676_7964# sg13cmos5l_dlhr_1_9.Q VPWR sg13_lv_pmos ad=0.2128p pd=1.5u as=0.3808p ps=2.92u w=1.12u l=0.13u
X1619 sg13cmos5l_dfrbp_1_10.Q_N a_3599_3215# VPWR VPWR sg13_lv_pmos ad=0.4312p pd=3.01u as=0.2639p ps=1.81u w=1.12u l=0.13u
X1620 VPWR a_6903_3154# a_7034_3148# VPWR sg13_lv_pmos ad=1.43437p pd=9.105u as=0.2856p ps=2.36u w=0.84u l=0.13u
X1621 VPWR sg13cmos5l_and3_1_0.C a_13324_4696# VPWR sg13_lv_pmos ad=0.36195p pd=1.84u as=0.1596p ps=1.22u w=0.84u l=0.13u
X1622 nh_sw[2] a_3688_1664# VPWR VPWR sg13_lv_pmos ad=0.42p pd=2.99u as=0.2114p ps=1.54u w=1.12u l=0.13u
X1623 a_5324_1590# sg13cmos5l_buf_1_34.X VPWR VPWR sg13_lv_pmos ad=0.2856p pd=2.36u as=0.2114p ps=1.54u w=0.84u l=0.13u
X1624 a_13641_3529# a_13284_3456# VPWR VPWR sg13_lv_pmos ad=63f pd=0.72u as=0.1563p ps=1.22u w=0.42u l=0.13u
X1625 VPWR a_15177_5769# a_15110_5412# VPWR sg13_lv_pmos ad=0.2387p pd=1.84u as=0.1008p ps=0.9u w=0.42u l=0.13u
X1626 a_10596_7687# a_10308_7992# a_10534_7687# VGND sg13_lv_nmos ad=0.1428p pd=1.52u as=37.8f ps=0.6u w=0.42u l=0.13u
X1627 sg13cmos5l_dlhr_1_11.Q a_13161_7281# VGND VGND sg13_lv_nmos ad=0.2516p pd=2.16u as=0.1406p ps=1.12u w=0.74u l=0.13u
X1628 VGND a_1125_5423# a_1227_5423# VGND sg13_lv_nmos ad=1.97045p pd=12.335u as=0.2516p ps=2.16u w=0.74u l=0.13u
X1629 VPWR sg13cmos5l_buf_1_97.A a_11848_8436# VPWR sg13_lv_pmos ad=0.2114p pd=1.54u as=0.2856p ps=2.36u w=0.84u l=0.13u
X1630 sg13cmos5l_dfrbp_1_23.Q a_14612_6460# VPWR VPWR sg13_lv_pmos ad=0.3808p pd=2.92u as=0.2128p ps=1.5u w=1.12u l=0.13u
X1631 VPWR sg13cmos5l_dfrbp_1_6.RESET_B a_2409_4650# VPWR sg13_lv_pmos ad=0.2128p pd=1.5u as=0.2128p ps=1.5u w=1.12u l=0.13u
X1632 sg13cmos5l_dfrbp_1_0.Q_N a_18671_1703# VPWR VPWR sg13_lv_pmos ad=0.4312p pd=3.01u as=0.2639p ps=1.81u w=1.12u l=0.13u
X1633 a_2786_7666# a_2596_7996# a_2348_7624# VGND sg13_lv_nmos ad=71.99999f pd=0.865u as=0.141p ps=1.17u w=0.64u l=0.13u
X1634 sg13cmos5l_dfrbp_1_24.Q_N a_13391_9263# VPWR VPWR sg13_lv_pmos ad=0.4312p pd=3.01u as=0.2639p ps=1.81u w=1.12u l=0.13u
X1635 a_5069_5376# a_5799_5499# a_5820_5773# VGND sg13_lv_nmos ad=0.12665p pd=1.145u as=0.3473p ps=2.71u w=0.74u l=0.13u
X1636 a_9202_7674# sg13cmos5l_dfrbp_1_6.RESET_B VGND VGND sg13_lv_nmos ad=37.8f pd=0.6u as=79.8f ps=0.8u w=0.42u l=0.13u
X1637 VPWR a_11567_7751# a_12404_7972# VPWR sg13_lv_pmos ad=0.2128p pd=1.5u as=0.3864p ps=2.93u w=1.12u l=0.13u
X1638 a_13792_5760# sg13cmos5l_or2_1_1.B sg13cmos5l_a22oi_1_1.B2 VGND sg13_lv_nmos ad=0.1406p pd=1.12u as=0.2516p ps=2.16u w=0.74u l=0.13u
X1639 VGND a_620_7638# pl_sw[0] VGND sg13_lv_nmos ad=0.14875p pd=1.16u as=0.2886p ps=2.26u w=0.74u l=0.13u
X1640 a_8972_3864# sg13cmos5l_buf_1_45.A VPWR VPWR sg13_lv_pmos ad=0.2856p pd=2.36u as=0.2114p ps=1.54u w=0.84u l=0.13u
X1641 VGND sg13cmos5l_inv_1_5.A sg13cmos5l_a22oi_1_1.A1 VGND sg13_lv_nmos ad=0.2516p pd=2.16u as=0.2516p ps=2.16u w=0.74u l=0.13u
X1642 VPWR sg13cmos5l_dlhr_1_10.Q a_19528_6924# VPWR sg13_lv_pmos ad=0.2114p pd=1.54u as=0.2856p ps=2.36u w=0.84u l=0.13u
X1643 sg13cmos5l_a22oi_1_1.Y sg13cmos5l_a22oi_1_1.A1 a_14814_4292# VGND sg13_lv_nmos ad=0.2664p pd=1.46u as=96.2f ps=1u w=0.74u l=0.13u
X1644 sg13cmos5l_or2_1_0.A a_18363_4270# VPWR VPWR sg13_lv_pmos ad=0.2128p pd=1.5u as=0.2128p ps=1.5u w=1.12u l=0.13u
X1645 VPWR a_19227_4654# sg13cmos5l_buf_8_0.X VPWR sg13_lv_pmos ad=0.2128p pd=1.5u as=0.2128p ps=1.5u w=1.12u l=0.13u
X1646 a_13072_1846# sg13cmos5l_dfrbp_1_0.RESET_B VPWR VPWR sg13_lv_pmos ad=79.8f pd=0.8u as=1.777p ps=11.395u w=0.42u l=0.13u
X1647 sg13cmos5l_dlhr_1_0.GATE a_5684_4948# VPWR VPWR sg13_lv_pmos ad=0.3808p pd=2.92u as=0.2128p ps=1.5u w=1.12u l=0.13u
X1648 a_15429_7653# sg13cmos5l_dfrbp_1_22.D VGND VGND sg13_lv_nmos ad=0.2516p pd=2.16u as=1.49685p ps=9.6u w=0.74u l=0.13u
X1649 sg13cmos5l_dfrbp_1_4.D a_10464_2427# a_10613_2758# VGND sg13_lv_nmos ad=0.2516p pd=2.16u as=0.1406p ps=1.12u w=0.74u l=0.13u
X1650 a_10031_8797# a_9189_8447# a_8772_8440# VPWR sg13_lv_pmos ad=0.2048p pd=1.63u as=0.34p ps=2.68u w=1u l=0.13u
X1651 VPWR sg13cmos5l_buf_8_1.A a_18363_4270# VPWR sg13_lv_pmos ad=0.2128p pd=1.5u as=0.2128p ps=1.5u w=1.12u l=0.13u
X1652 a_5796_3904# a_6315_3911# a_7055_4261# VGND sg13_lv_nmos ad=0.3473p pd=2.71u as=0.12665p ps=1.145u w=0.74u l=0.13u
X1653 a_11488_4676# sg13cmos5l_a221oi_1_0.B1 sg13cmos5l_o21ai_1_0.A1 VGND sg13_lv_nmos ad=0.1406p pd=1.12u as=0.2516p ps=2.16u w=0.74u l=0.13u
X1654 VGND a_1997_6126# sg13cmos5l_dfrbp_1_15.Q_N VGND sg13_lv_nmos ad=0.2516p pd=2.16u as=0.2849p ps=2.25u w=0.74u l=0.13u
X1655 VGND a_7820_2352# sg13cmos5l_inv_1_14.A VGND sg13_lv_nmos ad=0.14875p pd=1.16u as=0.2886p ps=2.26u w=0.74u l=0.13u
X1656 VPWR a_6741_5459# a_5820_5773# VPWR sg13_lv_pmos ad=0.36237p pd=2.605u as=0.34p ps=2.68u w=1u l=0.13u
X1657 VPWR sg13cmos5l_buf_1_68.X a_616_9224# VPWR sg13_lv_pmos ad=0.2114p pd=1.54u as=0.2856p ps=2.36u w=0.84u l=0.13u
X1658 VGND a_16144_8678# a_15793_8797# VGND sg13_lv_nmos ad=79.8f pd=0.8u as=0.1428p ps=1.52u w=0.42u l=0.13u
X1659 a_10308_7992# a_10282_7897# VPWR VPWR sg13_lv_pmos ad=0.34p pd=2.68u as=0.36237p ps=2.605u w=1u l=0.13u
X1660 VGND sg13cmos5l_buf_1_25.X a_4456_1664# VGND sg13_lv_nmos ad=0.14875p pd=1.16u as=0.187p ps=1.78u w=0.55u l=0.13u
X1661 a_15590_4650# sg13cmos5l_dfrbp_1_8.D VPWR VPWR sg13_lv_pmos ad=79.8f pd=0.8u as=0.1428p ps=1.52u w=0.42u l=0.13u
X1662 VPWR a_6789_4629# a_6891_4772# VPWR sg13_lv_pmos ad=1.28962p pd=8.195u as=0.3864p ps=2.93u w=1.12u l=0.13u
X1663 a_7504_8678# sg13cmos5l_dfrbp_1_8.RESET_B VPWR VPWR sg13_lv_pmos ad=79.8f pd=0.8u as=1.12242p ps=7u w=0.42u l=0.13u
X1664 a_650_3900# sg13cmos5l_nor2_1_2.A VPWR VPWR sg13_lv_pmos ad=0.1176p pd=1.33u as=0.4032p ps=2.96u w=1.12u l=0.13u
X1665 VGND a_10665_7281# a_11190_7354# VGND sg13_lv_nmos ad=0.1491p pd=1.18u as=0.187p ps=1.78u w=0.55u l=0.13u
X1666 a_11824_7894# sg13cmos5l_dfrbp_1_6.RESET_B VPWR VPWR sg13_lv_pmos ad=79.8f pd=0.8u as=1.12242p ps=7u w=0.42u l=0.13u
X1667 VPWR sg13cmos5l_buf_1_110.A a_15784_9224# VPWR sg13_lv_pmos ad=0.2114p pd=1.54u as=0.2856p ps=2.36u w=0.84u l=0.13u
X1668 a_11182_4676# sg13cmos5l_a221oi_1_0.A2 VGND VGND sg13_lv_nmos ad=0.1406p pd=1.12u as=0.2516p ps=2.16u w=0.74u l=0.13u
X1669 VGND a_19209_5769# a_19734_5842# VGND sg13_lv_nmos ad=0.1491p pd=1.18u as=0.187p ps=1.78u w=0.55u l=0.13u
X1670 sg13cmos5l_buf_1_107.X a_17896_9224# VPWR VPWR sg13_lv_pmos ad=0.42p pd=2.99u as=0.2114p ps=1.54u w=1.12u l=0.13u
X1671 VGND a_8972_9150# sg13cmos5l_buf_1_77.X VGND sg13_lv_nmos ad=0.14875p pd=1.16u as=0.2886p ps=2.26u w=0.74u l=0.13u
X1672 VPWR sg13cmos5l_buf_1_7.A a_14056_1664# VPWR sg13_lv_pmos ad=0.2114p pd=1.54u as=0.2856p ps=2.36u w=0.84u l=0.13u
X1673 VGND a_11824_7894# a_11473_7751# VGND sg13_lv_nmos ad=79.8f pd=0.8u as=0.1428p ps=1.52u w=0.42u l=0.13u
X1674 VGND sg13cmos5l_dlhr_1_15.D a_17545_7728# VGND sg13_lv_nmos ad=0.15055p pd=1.17u as=0.187p ps=1.78u w=0.55u l=0.13u
X1675 VGND sg13cmos5l_dfrbp_1_6.RESET_B a_16298_4338# VGND sg13_lv_nmos ad=79.8f pd=0.8u as=37.8f ps=0.6u w=0.42u l=0.13u
X1676 VPWR sg13cmos5l_or2_1_1.B a_10420_5412# VPWR sg13_lv_pmos ad=0.3808p pd=2.92u as=0.2128p ps=1.5u w=1.12u l=0.13u
X1677 sg13cmos5l_buf_8_0.X a_19227_4654# VGND VGND sg13_lv_nmos ad=0.1406p pd=1.12u as=0.1406p ps=1.12u w=0.74u l=0.13u
X1678 VGND a_19227_9190# sg13cmos5l_buf_8_2.X VGND sg13_lv_nmos ad=0.1406p pd=1.12u as=0.1406p ps=1.12u w=0.74u l=0.13u
X1679 VGND a_17367_8794# a_17498_8800# VGND sg13_lv_nmos ad=2.92392p pd=18.89u as=0.2775p ps=2.23u w=0.74u l=0.13u
X1680 VGND a_10412_6126# sg13cmos5l_buf_1_29.A VGND sg13_lv_nmos ad=0.14875p pd=1.16u as=0.2886p ps=2.26u w=0.74u l=0.13u
X1681 a_4950_5699# a_5069_5376# VPWR VPWR sg13_lv_pmos ad=0.3864p pd=2.93u as=0.2128p ps=1.5u w=1.12u l=0.13u
X1682 a_7216_6382# sg13cmos5l_dfrbp_1_6.RESET_B VPWR VPWR sg13_lv_pmos ad=79.8f pd=0.8u as=1.04815p ps=6.595u w=0.42u l=0.13u
X1683 VPWR a_16528_7894# a_16473_7989# VPWR sg13_lv_pmos ad=1.15047p pd=7.175u as=93.45f ps=0.865u w=0.42u l=0.13u
X1684 VPWR VGND VPWR VPWR sg13_lv_pmos ad=0.19p pd=1.38u as=0 ps=0 w=1u l=1u
X1685 a_11268_5760# sg13cmos5l_dlhr_1_15.D VGND VGND sg13_lv_nmos ad=0.1216p pd=1.02u as=0.1371p ps=1.12u w=0.64u l=0.13u
X1686 sg13cmos5l_inv_1_2.A a_8488_9224# VGND VGND sg13_lv_nmos ad=0.2886p pd=2.26u as=0.14875p ps=1.16u w=0.74u l=0.13u
X1687 a_7312_4142# sg13cmos5l_dfrbp_1_6.RESET_B VPWR VPWR sg13_lv_pmos ad=79.8f pd=0.8u as=1.38655p ps=8.8u w=0.42u l=0.13u
X1688 sg13cmos5l_o21ai_1_0.Y sg13cmos5l_o21ai_1_0.A2 a_12120_3456# VPWR sg13_lv_pmos ad=0.2128p pd=1.5u as=0.2128p ps=1.5u w=1.12u l=0.15u
X1689 sg13cmos5l_buf_8_1.A a_17972_4948# VGND VGND sg13_lv_nmos ad=0.2516p pd=2.16u as=0.1406p ps=1.12u w=0.74u l=0.13u
X1690 sg13cmos5l_inv_1_26.Y sg13cmos5l_buf_1_19.A VPWR VPWR sg13_lv_pmos ad=0.3808p pd=2.92u as=0.3808p ps=2.92u w=1.12u l=0.13u
X1691 a_6479_2749# a_5637_2399# a_5220_2392# VPWR sg13_lv_pmos ad=0.2048p pd=1.63u as=0.34p ps=2.68u w=1u l=0.13u
X1692 sg13cmos5l_buf_8_0.A a_18480_5028# VGND VGND sg13_lv_nmos ad=0.2516p pd=2.16u as=0.1469p ps=1.155u w=0.74u l=0.13u
X1693 VGND sg13cmos5l_nor2_1_0.A sg13cmos5l_a221oi_1_0.C1 VGND sg13_lv_nmos ad=0.2516p pd=2.16u as=0.1406p ps=1.12u w=0.74u l=0.13u
X1694 VGND a_17008_2630# a_16657_2749# VGND sg13_lv_nmos ad=79.8f pd=0.8u as=0.1428p ps=1.52u w=0.42u l=0.13u
X1695 sg13cmos5l_buf_1_8.X a_10888_1664# VPWR VPWR sg13_lv_pmos ad=0.42p pd=2.99u as=0.2114p ps=1.54u w=1.12u l=0.13u
X1696 a_11844_4325# a_12075_3911# a_11530_3868# VGND sg13_lv_nmos ad=0.2373p pd=1.97u as=79.8f ps=0.8u w=0.42u l=0.13u
X1697 a_5510_4338# a_6315_3911# a_5770_3868# VPWR sg13_lv_pmos ad=0.1428p pd=1.52u as=79.8f ps=0.8u w=0.42u l=0.13u
X1698 a_10708_9172# a_10292_9508# a_10473_9186# VGND sg13_lv_nmos ad=77.7f pd=0.95u as=0.2516p ps=2.16u w=0.74u l=0.13u
X1699 a_2565_8447# sg13cmos5l_inv_1_8.A VGND VGND sg13_lv_nmos ad=0.2516p pd=2.16u as=2.71505p ps=17.54u w=0.74u l=0.13u
X1700 a_15012_7992# a_15531_7796# a_16271_7751# VGND sg13_lv_nmos ad=0.3473p pd=2.71u as=0.12665p ps=1.145u w=0.74u l=0.13u
X1701 VPWR sg13cmos5l_inv_1_8.A sg13cmos5l_inv_1_8.Y VPWR sg13_lv_pmos ad=0.3808p pd=2.92u as=0.3808p ps=2.92u w=1.12u l=0.13u
X1702 VGND a_9705_4650# a_10230_4632# VGND sg13_lv_nmos ad=0.1491p pd=1.18u as=0.187p ps=1.78u w=0.55u l=0.13u
X1703 sg13cmos5l_buf_1_94.X a_15016_9224# VGND VGND sg13_lv_nmos ad=0.2886p pd=2.26u as=0.14875p ps=1.16u w=0.74u l=0.13u
X1704 VPWR a_3692_9150# sg13cmos5l_buf_1_62.X VPWR sg13_lv_pmos ad=0.2114p pd=1.54u as=0.42p ps=2.99u w=1.12u l=0.13u
X1705 VGND a_6380_7638# pl_sw[3] VGND sg13_lv_nmos ad=0.14875p pd=1.16u as=0.2886p ps=2.26u w=0.74u l=0.13u
X1706 a_19244_2352# sg13cmos5l_buf_1_18.X VGND VGND sg13_lv_nmos ad=0.187p pd=1.78u as=0.14875p ps=1.16u w=0.55u l=0.13u
X1707 a_15429_7653# sg13cmos5l_dfrbp_1_22.D VPWR VPWR sg13_lv_pmos ad=0.4088p pd=2.97u as=1.12242p ps=7u w=1.12u l=0.13u
X1708 VPWR a_15887_8797# a_16144_8678# VPWR sg13_lv_pmos ad=0.2639p pd=1.81u as=79.8f ps=0.8u w=0.42u l=0.13u
X1709 VPWR sg13cmos5l_dfrbp_1_6.RESET_B a_7689_1626# VPWR sg13_lv_pmos ad=0.2128p pd=1.5u as=0.2128p ps=1.5u w=1.12u l=0.13u
X1710 VPWR sg13cmos5l_buf_1_8.A a_10888_1664# VPWR sg13_lv_pmos ad=0.2114p pd=1.54u as=0.2856p ps=2.36u w=0.84u l=0.13u
X1711 a_10420_5412# sg13cmos5l_dfrbp_1_16.Q a_10318_5412# VPWR sg13_lv_pmos ad=0.2128p pd=1.5u as=0.2128p ps=1.5u w=1.12u l=0.13u
X1712 a_1006_4167# a_1121_4166# VPWR VPWR sg13_lv_pmos ad=0.34p pd=2.68u as=0.2254p ps=1.53u w=1u l=0.5u
X1713 a_19227_4654# sg13cmos5l_buf_8_0.A VGND VGND sg13_lv_nmos ad=0.1406p pd=1.12u as=0.1406p ps=1.12u w=0.74u l=0.13u
X1714 VGND a_18345_7674# a_18870_7656# VGND sg13_lv_nmos ad=0.1491p pd=1.18u as=0.187p ps=1.78u w=0.55u l=0.13u
X1715 VGND a_18959_3215# a_19796_3436# VGND sg13_lv_nmos ad=0.1406p pd=1.12u as=0.2516p ps=2.16u w=0.74u l=0.13u
X1716 sg13cmos5l_dfrbp_1_8.Q_N a_17135_4727# VPWR VPWR sg13_lv_pmos ad=0.4312p pd=3.01u as=0.2639p ps=1.81u w=1.12u l=0.13u
X1717 VGND a_18363_4270# sg13cmos5l_or2_1_0.A VGND sg13_lv_nmos ad=0.1406p pd=1.12u as=0.1406p ps=1.12u w=0.74u l=0.13u
X1718 a_17386_1849# a_17829_1605# a_17769_2017# VPWR sg13_lv_pmos ad=79.8f pd=0.8u as=63f ps=0.72u w=0.42u l=0.13u
X1719 VPWR a_19227_4654# sg13cmos5l_buf_8_0.X VPWR sg13_lv_pmos ad=0.2128p pd=1.5u as=0.2128p ps=1.5u w=1.12u l=0.13u
X1720 a_8247_5770# sg13cmos5l_dfrbp_1_11.Q VGND VGND sg13_lv_nmos ad=0.2516p pd=2.16u as=0.15055p ps=1.17u w=0.74u l=0.13u
X1721 sg13cmos5l_buf_8_2.X a_19227_9190# VPWR VPWR sg13_lv_pmos ad=0.2128p pd=1.5u as=0.2128p ps=1.5u w=1.12u l=0.13u
X1722 VPWR sg13cmos5l_dfrbp_1_6.RESET_B a_682_6892# VPWR sg13_lv_pmos ad=0.1563p pd=1.22u as=0.147p ps=1.54u w=0.42u l=0.13u
X1723 a_3793_2790# a_3241_2746# VGND VGND sg13_lv_nmos ad=71.99999f pd=0.865u as=2.59257p ps=16.445u w=0.64u l=0.13u
X1724 a_16356_7349# a_16587_6935# a_16042_6892# VGND sg13_lv_nmos ad=0.2373p pd=1.97u as=79.8f ps=0.8u w=0.42u l=0.13u
X1725 VPWR sg13cmos5l_dfrbp_1_11.Q a_6647_5459# VPWR sg13_lv_pmos ad=0.1428p pd=1.52u as=79.8f ps=0.8u w=0.42u l=0.13u
X1726 sg13cmos5l_dfrbp_1_9.Q_N a_3407_4261# VPWR VPWR sg13_lv_pmos ad=0.4312p pd=3.01u as=0.2639p ps=1.81u w=1.12u l=0.13u
X1727 sg13cmos5l_buf_1_45.A a_8841_5769# VGND VGND sg13_lv_nmos ad=0.2516p pd=2.16u as=0.1406p ps=1.12u w=0.74u l=0.13u
X1728 a_4076_5376# sg13cmos5l_dlhr_1_9.Q VPWR VPWR sg13_lv_pmos ad=0.2856p pd=2.36u as=0.2114p ps=1.54u w=0.84u l=0.13u
X1729 VGND a_2224_7166# a_1873_7285# VGND sg13_lv_nmos ad=79.8f pd=0.8u as=0.1428p ps=1.52u w=0.42u l=0.13u
X1730 VPWR VGND VPWR VPWR sg13_lv_pmos ad=0.34p pd=2.68u as=0 ps=0 w=1u l=1u
X1731 a_5702_8874# sg13cmos5l_dlhr_1_5.GATE VPWR VPWR sg13_lv_pmos ad=79.8f pd=0.8u as=0.1428p ps=1.52u w=0.42u l=0.13u
X1732 a_3996_2790# a_3447_2746# a_3860_2388# VGND sg13_lv_nmos ad=47.25f pd=0.645u as=0.141p ps=1.17u w=0.42u l=0.13u
X1733 a_9111_4666# sg13cmos5l_dfrbp_1_11.Q VPWR VPWR sg13_lv_pmos ad=0.3234p pd=2.45u as=1.2517p ps=7.955u w=0.84u l=0.13u
X1734 a_4660_7312# a_4244_6924# a_4425_7281# VGND sg13_lv_nmos ad=77.7f pd=0.95u as=0.2516p ps=2.16u w=0.74u l=0.13u
X1735 sg13cmos5l_a221oi_1_0.B2 sg13cmos5l_nor2b_1_0.Y VGND VGND sg13_lv_nmos ad=0.1406p pd=1.12u as=0.2516p ps=2.16u w=0.74u l=0.13u
X1736 VGND sg13cmos5l_dfrbp_1_0.RESET_B a_11364_4338# VGND sg13_lv_nmos ad=0.1626p pd=1.415u as=60.89999f ps=0.71u w=0.42u l=0.13u
X1737 a_15466_2356# a_15909_2399# a_15849_2435# VPWR sg13_lv_pmos ad=79.8f pd=0.8u as=63f ps=0.72u w=0.42u l=0.13u
X1738 a_7732_3124# a_7316_3460# a_7497_3138# VGND sg13_lv_nmos ad=77.7f pd=0.95u as=0.2516p ps=2.16u w=0.74u l=0.13u
X1739 VGND a_15177_5769# a_15702_5842# VGND sg13_lv_nmos ad=0.1491p pd=1.18u as=0.187p ps=1.78u w=0.55u l=0.13u
X1740 a_10288_8678# a_10031_8797# a_10450_8874# VGND sg13_lv_nmos ad=0.1428p pd=1.52u as=37.8f ps=0.6u w=0.42u l=0.13u
X1741 VGND a_19227_9190# sg13cmos5l_buf_8_2.X VGND sg13_lv_nmos ad=0.1406p pd=1.12u as=0.1406p ps=1.12u w=0.74u l=0.13u
X1742 a_13138_2826# sg13cmos5l_dfrbp_1_0.RESET_B VGND VGND sg13_lv_nmos ad=37.8f pd=0.6u as=79.8f ps=0.8u w=0.42u l=0.13u
X1743 VPWR a_2565_3911# a_2667_3911# VPWR sg13_lv_pmos ad=1.43437p pd=9.105u as=0.3864p ps=2.93u w=1.12u l=0.13u
X1744 a_12549_9165# sg13cmos5l_inv_1_2.A VGND VGND sg13_lv_nmos ad=0.2516p pd=2.16u as=2.71505p ps=17.54u w=0.74u l=0.13u
X1745 VPWR sg13cmos5l_dfrbp_1_6.RESET_B a_10473_9186# VPWR sg13_lv_pmos ad=0.2128p pd=1.5u as=0.2128p ps=1.5u w=1.12u l=0.13u
X1746 VGND a_5079_3154# a_5210_3148# VGND sg13_lv_nmos ad=2.59257p pd=16.445u as=0.2775p ps=2.23u w=0.74u l=0.13u
X1747 a_2228_4972# a_1815_4666# a_2160_4972# VPWR sg13_lv_pmos ad=0.191p pd=1.44u as=0.105p ps=1.21u w=1u l=0.13u
X1748 a_5510_4338# sg13cmos5l_dfrbp_1_6.D VPWR VPWR sg13_lv_pmos ad=79.8f pd=0.8u as=0.1428p ps=1.52u w=0.42u l=0.13u
X1749 a_10534_7687# sg13cmos5l_dfrbp_1_6.RESET_B VGND VGND sg13_lv_nmos ad=37.8f pd=0.6u as=0.1701p ps=1.65u w=0.42u l=0.13u
X1750 VGND a_14295_7282# a_14426_7288# VGND sg13_lv_nmos ad=1.49685p pd=9.6u as=0.2775p ps=2.23u w=0.74u l=0.13u
X1751 VPWR a_7863_7282# a_7994_7288# VPWR sg13_lv_pmos ad=1.07253p pd=6.75u as=0.2856p ps=2.36u w=0.84u l=0.13u
X1752 sg13cmos5l_inv_1_0.A a_13652_3900# VPWR VPWR sg13_lv_pmos ad=0.3808p pd=2.92u as=0.2128p ps=1.5u w=1.12u l=0.13u
X1753 a_3562_4873# a_4005_4629# a_3302_4650# VGND sg13_lv_nmos ad=79.8f pd=0.8u as=0.1296p ps=1.52u w=0.42u l=0.13u
X1754 sg13cmos5l_buf_1_45.A a_8841_5769# VPWR VPWR sg13_lv_pmos ad=0.3808p pd=2.92u as=0.2128p ps=1.5u w=1.12u l=0.13u
X1755 VGND a_16293_4629# a_16395_4772# VGND sg13_lv_nmos ad=2.41737p pd=15.64u as=0.2516p ps=2.16u w=0.74u l=0.13u
X1756 a_8772_8440# a_8746_8404# VGND VGND sg13_lv_nmos ad=0.2516p pd=2.16u as=0.1626p ps=1.415u w=0.74u l=0.13u
X1757 a_12132_9504# a_12106_9409# VPWR VPWR sg13_lv_pmos ad=0.34p pd=2.68u as=0.36237p ps=2.605u w=1u l=0.13u
X1758 a_13810_9186# sg13cmos5l_dfrbp_1_8.RESET_B VGND VGND sg13_lv_nmos ad=37.8f pd=0.6u as=79.8f ps=0.8u w=0.42u l=0.13u
X1759 VPWR sg13cmos5l_buf_8_0.A a_19227_4654# VPWR sg13_lv_pmos ad=0.2128p pd=1.5u as=0.2128p ps=1.5u w=1.12u l=0.13u
X1760 a_1815_4666# sg13cmos5l_dlhr_1_1.GATE VPWR VPWR sg13_lv_pmos ad=0.3234p pd=2.45u as=1.2517p ps=7.955u w=0.84u l=0.13u
X1761 VPWR a_3407_8797# a_4244_8436# VPWR sg13_lv_pmos ad=0.2128p pd=1.5u as=0.3864p ps=2.93u w=1.12u l=0.13u
X1762 a_14814_3876# sg13cmos5l_a22oi_1_1.B1 sg13cmos5l_a22oi_1_1.Y VPWR sg13_lv_pmos ad=0.2716p pd=1.605u as=0.2128p ps=1.5u w=1.12u l=0.13u
X1763 VGND a_15884_3102# nh_sw[7] VGND sg13_lv_nmos ad=0.14875p pd=1.16u as=0.2886p ps=2.26u w=0.74u l=0.13u
X1764 VGND a_6405_8447# a_6507_8447# VGND sg13_lv_nmos ad=2.92392p pd=18.89u as=0.2516p ps=2.16u w=0.74u l=0.13u
X1765 a_3574_7850# a_3676_7964# VGND VGND sg13_lv_nmos ad=0.187p pd=1.78u as=0.1491p ps=1.18u w=0.55u l=0.13u
X1766 VPWR a_1967_7285# a_2224_7166# VPWR sg13_lv_pmos ad=0.2639p pd=1.81u as=79.8f ps=0.8u w=0.42u l=0.13u
X1767 VPWR sg13cmos5l_nor2_1_0.A a_12814_4692# VPWR sg13_lv_pmos ad=0.2618p pd=1.63u as=0.2856p ps=2.36u w=0.84u l=0.13u
X1768 a_17926_3151# sg13cmos5l_dfrbp_1_0.RESET_B VGND VGND sg13_lv_nmos ad=37.8f pd=0.6u as=0.1701p ps=1.65u w=0.42u l=0.13u
X1769 VGND sg13cmos5l_and3_1_0.C a_13520_4696# VGND sg13_lv_nmos ad=0.1371p pd=1.12u as=0.1216p ps=1.02u w=0.64u l=0.13u
X1770 a_10789_4654# sg13cmos5l_a221oi_1_0.C1 VGND VGND sg13_lv_nmos ad=0.1406p pd=1.12u as=0.14505p ps=1.15u w=0.74u l=0.13u
X1771 sg13cmos5l_dlhr_1_2.D a_6479_2749# VPWR VPWR sg13_lv_pmos ad=0.4312p pd=3.01u as=0.2639p ps=1.81u w=1.12u l=0.13u
X1772 a_13100_8400# sg13cmos5l_buf_1_90.X VPWR VPWR sg13_lv_pmos ad=0.2856p pd=2.36u as=0.2114p ps=1.54u w=0.84u l=0.13u
X1773 sg13cmos5l_nor2_1_2.A sg13cmos5l_inv_1_9.Y VGND VGND sg13_lv_nmos ad=0.2516p pd=2.16u as=0.2516p ps=2.16u w=0.74u l=0.13u
X1774 a_13572_3151# a_13803_3260# a_13258_3361# VGND sg13_lv_nmos ad=0.2373p pd=1.97u as=79.8f ps=0.8u w=0.42u l=0.13u
X1775 a_11530_1849# a_11973_1605# a_11270_1626# VGND sg13_lv_nmos ad=79.8f pd=0.8u as=0.1296p ps=1.52u w=0.42u l=0.13u
X1776 a_14032_6382# a_13775_6239# a_14194_6162# VGND sg13_lv_nmos ad=0.1428p pd=1.52u as=37.8f ps=0.6u w=0.42u l=0.13u
X1777 a_10464_2427# sg13cmos5l_nor2_1_0.A VPWR VPWR sg13_lv_pmos ad=0.1596p pd=1.22u as=0.4536p ps=2.76u w=0.84u l=0.13u
X1778 VGND a_3856_3358# a_3505_3215# VGND sg13_lv_nmos ad=79.8f pd=0.8u as=0.1428p ps=1.52u w=0.42u l=0.13u
X1779 a_3876_4663# a_3588_4968# a_3814_4663# VGND sg13_lv_nmos ad=0.1428p pd=1.52u as=37.8f ps=0.6u w=0.42u l=0.13u
X1780 a_6998_5837# a_5820_5773# a_6602_5692# VGND sg13_lv_nmos ad=37.8f pd=0.6u as=0.1428p ps=1.52u w=0.42u l=0.13u
X1781 sg13cmos5l_dlhr_1_1.D a_1967_5773# VGND VGND sg13_lv_nmos ad=0.2849p pd=2.25u as=0.2516p ps=2.16u w=0.74u l=0.13u
X1782 VGND VPWR VGND VGND sg13_lv_nmos ad=0.1428p pd=1.52u as=0 ps=0 w=0.42u l=1u
X1783 a_10417_7326# a_9865_7282# VGND VGND sg13_lv_nmos ad=71.99999f pd=0.865u as=1.49685p ps=9.6u w=0.64u l=0.13u
X1784 VPWR sg13cmos5l_nand2_1_0.A sg13cmos5l_o21ai_1_0.A2 VPWR sg13_lv_pmos ad=0.3808p pd=2.92u as=0.2128p ps=1.5u w=1.12u l=0.13u
X1785 VGND a_1484_9150# sg13cmos5l_buf_1_68.X VGND sg13_lv_nmos ad=0.14875p pd=1.16u as=0.2886p ps=2.26u w=0.74u l=0.13u
X1786 VGND sg13cmos5l_buf_1_40.A sg13cmos5l_buf_1_63.A VGND sg13_lv_nmos ad=0.2516p pd=2.16u as=0.2516p ps=2.16u w=0.74u l=0.13u
X1787 VPWR a_13161_7281# a_13094_6924# VPWR sg13_lv_pmos ad=0.2387p pd=1.84u as=0.1008p ps=0.9u w=0.42u l=0.13u
X1788 VPWR sg13cmos5l_nand2_1_1.B a_9823_2364# VPWR sg13_lv_pmos ad=0.3808p pd=2.92u as=0.2744p ps=1.61u w=1.12u l=0.13u
X1789 a_14858_2388# sg13cmos5l_dfrbp_1_0.Q sg13cmos5l_nand2_1_0.A VPWR sg13_lv_pmos ad=0.1176p pd=1.33u as=0.3808p ps=2.92u w=1.12u l=0.13u
X1790 VGND cks a_19227_9190# VGND sg13_lv_nmos ad=0.1406p pd=1.12u as=0.1406p ps=1.12u w=0.74u l=0.13u
X1791 a_16068_6928# a_16042_6892# VGND VGND sg13_lv_nmos ad=0.2516p pd=2.16u as=0.1626p ps=1.415u w=0.74u l=0.13u
X1792 VPWR a_19593_6162# a_19526_6600# VPWR sg13_lv_pmos ad=0.2387p pd=1.84u as=0.1008p ps=0.9u w=0.42u l=0.13u
X1793 pl_sw[1] a_1000_9224# VGND VGND sg13_lv_nmos ad=0.2886p pd=2.26u as=0.14875p ps=1.16u w=0.74u l=0.13u
X1794 VGND sg13cmos5l_buf_1_29.A sg13cmos5l_buf_1_77.A VGND sg13_lv_nmos ad=0.2516p pd=2.16u as=0.2516p ps=2.16u w=0.74u l=0.13u
X1795 a_3447_2746# sg13cmos5l_dfrbp_1_9.Q VGND VGND sg13_lv_nmos ad=0.2516p pd=2.16u as=0.15055p ps=1.17u w=0.74u l=0.13u
X1796 a_18480_5028# sg13cmos5l_dfrbp_1_0.D VGND VGND sg13_lv_nmos ad=0.1045p pd=0.93u as=0.187p ps=1.78u w=0.55u l=0.13u
X1797 a_17516_9150# sg13cmos5l_buf_1_103.A VGND VGND sg13_lv_nmos ad=0.187p pd=1.78u as=0.14875p ps=1.16u w=0.55u l=0.13u
X1798 a_11434_2356# a_11877_2399# a_11817_2435# VPWR sg13_lv_pmos ad=79.8f pd=0.8u as=63f ps=0.72u w=0.42u l=0.13u
X1799 VPWR a_10587_4692# sg13cmos5l_nand2_1_0.B VPWR sg13_lv_pmos ad=0.3808p pd=2.92u as=0.2128p ps=1.5u w=1.12u l=0.13u
X1800 VGND a_19216_3358# a_18865_3215# VGND sg13_lv_nmos ad=79.8f pd=0.8u as=0.1428p ps=1.52u w=0.42u l=0.13u
X1801 a_7497_3138# a_7316_3460# VPWR VPWR sg13_lv_pmos ad=0.2128p pd=1.5u as=0.2387p ps=1.84u w=1.12u l=0.13u
X1802 a_11270_1626# sg13cmos5l_dfrbp_1_1.D VPWR VPWR sg13_lv_pmos ad=79.8f pd=0.8u as=0.1428p ps=1.52u w=0.42u l=0.13u
X1803 sg13cmos5l_dlhr_1_1.Q_N a_2934_4632# VPWR VPWR sg13_lv_pmos ad=0.3808p pd=2.92u as=0.1974p ps=1.5u w=1.12u l=0.13u
X1804 sg13cmos5l_dfrbp_1_12.Q_N a_7055_4261# VPWR VPWR sg13_lv_pmos ad=0.4312p pd=3.01u as=0.2639p ps=1.81u w=1.12u l=0.13u
X1805 a_2727_6380# a_2879_6432# VGND VGND sg13_lv_nmos ad=0.2516p pd=2.16u as=1.97045p ps=12.335u w=0.74u l=0.13u
X1806 a_5425_3130# a_4873_3192# VGND VGND sg13_lv_nmos ad=71.99999f pd=0.865u as=2.59257p ps=16.445u w=0.64u l=0.13u
X1807 a_2148_8440# a_2667_8447# a_3407_8797# VGND sg13_lv_nmos ad=0.3473p pd=2.71u as=0.12665p ps=1.145u w=0.74u l=0.13u
X1808 a_3574_7850# a_3676_7964# VPWR VPWR sg13_lv_pmos ad=0.2856p pd=2.36u as=0.1974p ps=1.5u w=0.84u l=0.13u
X1809 VGND sg13cmos5l_buf_1_31.X a_1672_3176# VGND sg13_lv_nmos ad=0.14875p pd=1.16u as=0.187p ps=1.78u w=0.55u l=0.13u
X1810 ph_sw[1] a_1864_9224# VPWR VPWR sg13_lv_pmos ad=0.42p pd=2.99u as=0.2114p ps=1.54u w=1.12u l=0.13u
X1811 VPWR sg13cmos5l_dfrbp_1_8.RESET_B a_8486_8874# VPWR sg13_lv_pmos ad=0.36237p pd=2.605u as=79.8f ps=0.8u w=0.42u l=0.13u
X1812 VGND a_4652_6126# sg13cmos5l_inv_1_19.A VGND sg13_lv_nmos ad=0.14875p pd=1.16u as=0.2886p ps=2.26u w=0.74u l=0.13u
X1813 a_18278_8112# a_17882_7684# a_18164_7996# VPWR sg13_lv_pmos ad=0.1008p pd=0.9u as=0.191p ps=1.44u w=0.42u l=0.13u
X1814 a_7055_4261# a_6213_3911# a_5796_3904# VPWR sg13_lv_pmos ad=0.2048p pd=1.63u as=0.34p ps=2.68u w=1u l=0.13u
X1815 a_12998_3138# sg13cmos5l_o21ai_1_0.Y VPWR VPWR sg13_lv_pmos ad=79.8f pd=0.8u as=0.1428p ps=1.52u w=0.42u l=0.13u
X1816 a_5962_8404# a_6405_8447# a_5702_8874# VGND sg13_lv_nmos ad=79.8f pd=0.8u as=0.1296p ps=1.52u w=0.42u l=0.13u
X1817 sg13cmos5l_buf_1_2.X a_15784_1664# VGND VGND sg13_lv_nmos ad=0.2886p pd=2.26u as=0.14875p ps=1.16u w=0.74u l=0.13u
X1818 sg13cmos5l_buf_8_2.X a_19227_9190# VPWR VPWR sg13_lv_pmos ad=0.2128p pd=1.5u as=0.2128p ps=1.5u w=1.12u l=0.13u
X1819 VPWR a_17961_8793# a_18486_8866# VPWR sg13_lv_pmos ad=0.1974p pd=1.5u as=0.2856p ps=2.36u w=0.84u l=0.13u
X1820 a_5710_5850# a_5452_5850# VGND VGND sg13_lv_nmos ad=0.1428p pd=1.52u as=79.8f ps=0.8u w=0.42u l=0.13u
X1821 VPWR a_9111_4666# a_9242_4660# VPWR sg13_lv_pmos ad=1.28962p pd=8.195u as=0.2856p ps=2.36u w=0.84u l=0.13u
X1822 sg13cmos5l_dlhr_1_15.D a_17108_7972# VGND VGND sg13_lv_nmos ad=0.2516p pd=2.16u as=0.1406p ps=1.12u w=0.74u l=0.13u
X1823 VPWR sg13cmos5l_dfrbp_1_6.RESET_B a_4041_2745# VPWR sg13_lv_pmos ad=0.2128p pd=1.5u as=0.2128p ps=1.5u w=1.12u l=0.13u
X1824 a_19344_6484# a_18793_6216# VPWR VPWR sg13_lv_pmos ad=0.105p pd=1.21u as=1.07253p ps=6.75u w=1u l=0.13u
X1825 a_15909_2399# sg13cmos5l_dfrbp_1_0.CLK VPWR VPWR sg13_lv_pmos ad=0.4088p pd=2.97u as=1.777p ps=11.395u w=1.12u l=0.13u
X1826 VGND a_1948_7964# sg13cmos5l_buf_1_58.A VGND sg13_lv_nmos ad=0.1406p pd=1.12u as=0.2516p ps=2.16u w=0.74u l=0.13u
X1827 a_13258_3361# a_13701_3117# a_13641_3529# VPWR sg13_lv_pmos ad=79.8f pd=0.8u as=63f ps=0.72u w=0.42u l=0.13u
X1828 VPWR VGND VPWR VPWR sg13_lv_pmos ad=0.34p pd=2.68u as=0 ps=0 w=1u l=1u
X1829 VPWR a_16751_2749# a_17008_2630# VPWR sg13_lv_pmos ad=0.2639p pd=1.81u as=79.8f ps=0.8u w=0.42u l=0.13u
X1830 sg13cmos5l_dfrbp_1_6.RESET_B cks VPWR VPWR sg13_lv_pmos ad=0.2128p pd=1.5u as=0.3808p ps=2.92u w=1.12u l=0.13u
X1831 sg13cmos5l_o21ai_1_0.B1 sg13cmos5l_nand2_1_1.A a_14458_4270# VGND sg13_lv_nmos ad=0.2516p pd=2.16u as=0.1406p ps=1.12u w=0.74u l=0.13u
X1832 a_5132_3864# sg13cmos5l_buf_1_44.A VPWR VPWR sg13_lv_pmos ad=0.2856p pd=2.36u as=0.2114p ps=1.54u w=0.84u l=0.13u
X1833 VGND sg13cmos5l_dfrbp_1_8.RESET_B a_6180_4650# VGND sg13_lv_nmos ad=0.1626p pd=1.415u as=60.89999f ps=0.71u w=0.42u l=0.13u
X1834 a_15500_9150# sg13cmos5l_buf_1_95.X VGND VGND sg13_lv_nmos ad=0.187p pd=1.78u as=0.14875p ps=1.16u w=0.55u l=0.13u
X1835 a_14844_7326# a_14295_7282# a_14708_6924# VGND sg13_lv_nmos ad=47.25f pd=0.645u as=0.141p ps=1.17u w=0.42u l=0.13u
X1836 a_3856_3358# a_3599_3215# a_4018_3138# VGND sg13_lv_nmos ad=0.1428p pd=1.52u as=37.8f ps=0.6u w=0.42u l=0.13u
X1837 VPWR a_18363_4270# sg13cmos5l_or2_1_0.A VPWR sg13_lv_pmos ad=0.2128p pd=1.5u as=0.2128p ps=1.5u w=1.12u l=0.13u
X1838 VGND a_3574_7850# sg13cmos5l_dlhr_1_9.Q_N VGND sg13_lv_nmos ad=0.1491p pd=1.18u as=0.2516p ps=2.16u w=0.74u l=0.13u
X1839 a_18580_7660# a_18164_7996# a_18345_7674# VGND sg13_lv_nmos ad=77.7f pd=0.95u as=0.2516p ps=2.16u w=0.74u l=0.13u
X1840 sg13cmos5l_dfrbp_1_1.Q_N a_12815_1703# VPWR VPWR sg13_lv_pmos ad=0.4312p pd=3.01u as=0.2639p ps=1.81u w=1.12u l=0.13u
X1841 VGND sg13cmos5l_dfrbp_1_10.Q a_4873_3192# VGND sg13_lv_nmos ad=0.15055p pd=1.17u as=0.187p ps=1.78u w=0.55u l=0.13u
X1842 a_13977_6477# a_13035_6284# a_13775_6239# VPWR sg13_lv_pmos ad=93.45f pd=0.865u as=0.2048p ps=1.63u w=0.42u l=0.13u
X1843 sg13cmos5l_dlhr_1_0.D a_7316_2388# VPWR VPWR sg13_lv_pmos ad=0.3808p pd=2.92u as=0.2128p ps=1.5u w=1.12u l=0.13u
X1844 VPWR cks sg13cmos5l_dfrbp_1_0.RESET_B VPWR sg13_lv_pmos ad=0.3808p pd=2.92u as=0.3808p ps=2.92u w=1.12u l=0.13u
X1845 a_11268_2826# sg13cmos5l_dfrbp_1_4.D a_11174_2826# VGND sg13_lv_nmos ad=60.89999f pd=0.71u as=0.1428p ps=1.52u w=0.42u l=0.13u
X1846 a_16271_7751# a_15429_7653# a_15012_7992# VPWR sg13_lv_pmos ad=0.2048p pd=1.63u as=0.34p ps=2.68u w=1u l=0.13u
X1847 VGND sg13cmos5l_dfrbp_1_6.RESET_B a_5028_2826# VGND sg13_lv_nmos ad=0.1626p pd=1.415u as=60.89999f ps=0.71u w=0.42u l=0.13u
X1848 VGND sg13cmos5l_buf_1_89.A a_15208_6200# VGND sg13_lv_nmos ad=0.14875p pd=1.16u as=0.187p ps=1.78u w=0.55u l=0.13u
X1849 VPWR sg13cmos5l_buf_1_74.X a_6568_9224# VPWR sg13_lv_pmos ad=0.2114p pd=1.54u as=0.2856p ps=2.36u w=0.84u l=0.13u
X1850 sg13cmos5l_o21ai_1_0.Y sg13cmos5l_o21ai_1_0.B1 a_12022_3134# VGND sg13_lv_nmos ad=0.2516p pd=2.16u as=0.1406p ps=1.12u w=0.74u l=0.15u
X1851 a_14916_8861# a_15147_8447# a_14602_8404# VGND sg13_lv_nmos ad=0.2373p pd=1.97u as=79.8f ps=0.8u w=0.42u l=0.13u
X1852 VGND VPWR VGND VGND sg13_lv_nmos ad=0.1428p pd=1.52u as=0 ps=0 w=0.42u l=1u
X1853 sg13cmos5l_dlhr_1_9.D a_2804_5412# VGND VGND sg13_lv_nmos ad=0.2516p pd=2.16u as=0.1406p ps=1.12u w=0.74u l=0.13u
X1854 sg13cmos5l_dlhr_1_14.Q_N a_14166_7656# VGND VGND sg13_lv_nmos ad=0.2516p pd=2.16u as=0.1491p ps=1.18u w=0.74u l=0.13u
X1855 a_17712_8436# a_17161_8794# VPWR VPWR sg13_lv_pmos ad=0.105p pd=1.21u as=1.15047p ps=7.175u w=1u l=0.13u
X1856 a_3664_8678# sg13cmos5l_dfrbp_1_8.RESET_B VPWR VPWR sg13_lv_pmos ad=79.8f pd=0.8u as=1.12242p ps=7u w=0.42u l=0.13u
X1857 a_16548_6175# a_16779_6284# a_16234_6385# VGND sg13_lv_nmos ad=0.2373p pd=1.97u as=79.8f ps=0.8u w=0.42u l=0.13u
X1858 a_8390_6924# a_7994_7288# a_8276_6924# VPWR sg13_lv_pmos ad=0.1008p pd=0.9u as=0.191p ps=1.44u w=0.42u l=0.13u
X1859 VPWR sg13cmos5l_dlhr_1_11.D a_12361_7282# VPWR sg13_lv_pmos ad=1.07253p pd=6.75u as=0.2856p ps=2.36u w=0.84u l=0.13u
X1860 a_3856_3358# sg13cmos5l_dfrbp_1_6.RESET_B VPWR VPWR sg13_lv_pmos ad=79.8f pd=0.8u as=1.38655p ps=8.8u w=0.42u l=0.13u
X1861 VGND a_9260_2352# nh_sw[4] VGND sg13_lv_nmos ad=0.14875p pd=1.16u as=0.2886p ps=2.26u w=0.74u l=0.13u
X1862 nh_sw[1] a_2824_2388# VPWR VPWR sg13_lv_pmos ad=0.42p pd=2.99u as=0.2114p ps=1.54u w=1.12u l=0.13u
X1863 VGND sg13cmos5l_dfrbp_1_6.RESET_B a_5604_4338# VGND sg13_lv_nmos ad=0.1626p pd=1.415u as=60.89999f ps=0.71u w=0.42u l=0.13u
X1864 VGND a_16677_6141# a_16779_6284# VGND sg13_lv_nmos ad=1.97045p pd=12.335u as=0.2516p ps=2.16u w=0.74u l=0.13u
X1865 VPWR a_10665_7281# a_10598_6924# VPWR sg13_lv_pmos ad=0.2387p pd=1.84u as=0.1008p ps=0.9u w=0.42u l=0.13u
X1866 VGND sg13cmos5l_dfrbp_1_8.RESET_B a_15684_4650# VGND sg13_lv_nmos ad=0.1626p pd=1.415u as=60.89999f ps=0.71u w=0.42u l=0.13u
X1867 VPWR sg13cmos5l_dfrbp_1_8.RESET_B a_5452_5850# VPWR sg13_lv_pmos ad=1.2517p pd=7.955u as=79.8f ps=0.8u w=0.42u l=0.13u
X1868 a_7644_1662# a_7095_1642# a_7508_1948# VGND sg13_lv_nmos ad=47.25f pd=0.645u as=0.141p ps=1.17u w=0.42u l=0.13u
X1869 a_3826_4338# sg13cmos5l_dfrbp_1_8.RESET_B VGND VGND sg13_lv_nmos ad=37.8f pd=0.6u as=79.8f ps=0.8u w=0.42u l=0.13u
X1870 a_8784_6484# a_8233_6216# VPWR VPWR sg13_lv_pmos ad=0.105p pd=1.21u as=1.07253p ps=6.75u w=1u l=0.13u
X1871 sg13cmos5l_inv_1_9.Y cks VGND VGND sg13_lv_nmos ad=0.2516p pd=2.16u as=0.2516p ps=2.16u w=0.74u l=0.13u
X1872 a_8204_2352# sg13cmos5l_dlhr_1_2.Q VPWR VPWR sg13_lv_pmos ad=0.2856p pd=2.36u as=0.2114p ps=1.54u w=0.84u l=0.13u
X1873 VGND a_9189_8447# a_9291_8447# VGND sg13_lv_nmos ad=2.92392p pd=18.89u as=0.2516p ps=2.16u w=0.74u l=0.13u
X1874 a_9457_4642# a_8905_4704# VGND VGND sg13_lv_nmos ad=71.99999f pd=0.865u as=2.41737p ps=15.64u w=0.64u l=0.13u
X1875 a_16089_8559# a_15147_8447# a_15887_8797# VPWR sg13_lv_pmos ad=93.45f pd=0.865u as=0.2048p ps=1.63u w=0.42u l=0.13u
X1876 a_15850_4873# a_16293_4629# a_15590_4650# VGND sg13_lv_nmos ad=79.8f pd=0.8u as=0.1296p ps=1.52u w=0.42u l=0.13u
X1877 a_8276_6924# a_7994_7288# a_8209_7326# VGND sg13_lv_nmos ad=0.141p pd=1.17u as=71.99999f ps=0.865u w=0.64u l=0.13u
X1878 sg13cmos5l_buf_1_56.A a_9033_6162# VPWR VPWR sg13_lv_pmos ad=0.3808p pd=2.92u as=0.2128p ps=1.5u w=1.12u l=0.13u
X1879 a_6214_8861# sg13cmos5l_dfrbp_1_8.RESET_B VGND VGND sg13_lv_nmos ad=37.8f pd=0.6u as=0.1701p ps=1.65u w=0.42u l=0.13u
X1880 VPWR sg13cmos5l_dfrbp_1_6.RESET_B a_18345_7674# VPWR sg13_lv_pmos ad=0.2128p pd=1.5u as=0.2128p ps=1.5u w=1.12u l=0.13u
X1881 VPWR a_14889_7281# a_15414_7354# VPWR sg13_lv_pmos ad=0.1974p pd=1.5u as=0.2856p ps=2.36u w=0.84u l=0.13u
X1882 a_19216_3358# sg13cmos5l_dfrbp_1_0.RESET_B VPWR VPWR sg13_lv_pmos ad=79.8f pd=0.8u as=1.38655p ps=8.8u w=0.42u l=0.13u
X1883 a_3212_1590# sg13cmos5l_buf_1_41.A VGND VGND sg13_lv_nmos ad=0.187p pd=1.78u as=0.14875p ps=1.16u w=0.55u l=0.13u
X1884 a_10618_3142# sg13cmos5l_nand2_1_0.A VGND VGND sg13_lv_nmos ad=0.1406p pd=1.12u as=0.2516p ps=2.16u w=0.74u l=0.13u
X1885 sg13cmos5l_buf_1_26.A sg13cmos5l_buf_1_45.X VPWR VPWR sg13_lv_pmos ad=0.3808p pd=2.92u as=0.3808p ps=2.92u w=1.12u l=0.13u
X1886 a_3407_8797# a_2565_8447# a_3313_8797# VGND sg13_lv_nmos ad=0.12665p pd=1.145u as=0.1428p ps=1.52u w=0.42u l=0.13u
X1887 VGND a_18671_1703# a_19508_1924# VGND sg13_lv_nmos ad=0.1406p pd=1.12u as=0.2516p ps=2.16u w=0.74u l=0.13u
X1888 VGND a_10288_8678# a_9937_8797# VGND sg13_lv_nmos ad=79.8f pd=0.8u as=0.1428p ps=1.52u w=0.42u l=0.13u
X1889 a_5702_8874# a_6507_8447# a_5962_8404# VPWR sg13_lv_pmos ad=0.1428p pd=1.52u as=79.8f ps=0.8u w=0.42u l=0.13u
X1890 a_516_5850# sg13cmos5l_dfrbp_1_6.D a_422_5850# VGND sg13_lv_nmos ad=60.89999f pd=0.71u as=0.1428p ps=1.52u w=0.42u l=0.13u
X1891 VGND a_13391_9263# a_14228_9484# VGND sg13_lv_nmos ad=0.1406p pd=1.12u as=0.2516p ps=2.16u w=0.74u l=0.13u
X1892 a_2505_8483# a_2148_8440# VPWR VPWR sg13_lv_pmos ad=63f pd=0.72u as=0.1563p ps=1.22u w=0.42u l=0.13u
X1893 VGND a_3599_3215# a_4436_3436# VGND sg13_lv_nmos ad=0.1406p pd=1.12u as=0.2516p ps=2.16u w=0.74u l=0.13u
X1894 VPWR sg13cmos5l_dfrbp_1_8.RESET_B a_15850_4873# VPWR sg13_lv_pmos ad=0.1563p pd=1.22u as=0.147p ps=1.54u w=0.42u l=0.13u
X1895 sg13cmos5l_a22oi_1_2.B2 sg13cmos5l_a221oi_1_0.C1 a_10420_5760# VGND sg13_lv_nmos ad=0.2516p pd=2.16u as=0.1406p ps=1.12u w=0.74u l=0.13u
X1896 VGND sg13cmos5l_inv_1_8.A a_5951_5383# VGND sg13_lv_nmos ad=1.88087p pd=11.775u as=0.2516p ps=2.16u w=0.74u l=0.13u
X1897 VGND a_18860_6888# ph_sw[9] VGND sg13_lv_nmos ad=0.14875p pd=1.16u as=0.2886p ps=2.26u w=0.74u l=0.13u
X1898 VGND a_14032_6382# a_13681_6239# VGND sg13_lv_nmos ad=79.8f pd=0.8u as=0.1428p ps=1.52u w=0.42u l=0.13u
X1899 a_6086_4650# a_6891_4772# a_6346_4873# VPWR sg13_lv_pmos ad=0.1428p pd=1.52u as=79.8f ps=0.8u w=0.42u l=0.13u
X1900 VGND a_12815_4261# a_13652_3900# VGND sg13_lv_nmos ad=0.1406p pd=1.12u as=0.2516p ps=2.16u w=0.74u l=0.13u
X1901 a_996_7349# a_1227_6935# a_682_6892# VGND sg13_lv_nmos ad=0.2373p pd=1.97u as=79.8f ps=0.8u w=0.42u l=0.13u
X1902 a_8588_3864# sg13cmos5l_buf_1_46.A VGND VGND sg13_lv_nmos ad=0.187p pd=1.78u as=0.14875p ps=1.16u w=0.55u l=0.13u
X1903 sg13cmos5l_buf_1_10.A a_11848_8436# VGND VGND sg13_lv_nmos ad=0.2886p pd=2.26u as=0.14875p ps=1.16u w=0.74u l=0.13u
X1904 sg13cmos5l_dlhr_1_21.Q_N a_10998_9168# VPWR VPWR sg13_lv_pmos ad=0.3808p pd=2.92u as=0.1974p ps=1.5u w=1.12u l=0.13u
X1905 sg13cmos5l_buf_1_18.A sg13cmos5l_buf_1_111.A VGND VGND sg13_lv_nmos ad=0.2516p pd=2.16u as=0.2516p ps=2.16u w=0.74u l=0.13u
X1906 VGND a_9111_4666# a_9242_4660# VGND sg13_lv_nmos ad=2.41737p pd=15.64u as=0.2775p ps=2.23u w=0.74u l=0.13u
X1907 a_1862_8874# sg13cmos5l_dfrbp_1_17.D VPWR VPWR sg13_lv_pmos ad=79.8f pd=0.8u as=0.1428p ps=1.52u w=0.42u l=0.13u
X1908 a_8746_8404# a_9189_8447# a_8486_8874# VGND sg13_lv_nmos ad=79.8f pd=0.8u as=0.1296p ps=1.52u w=0.42u l=0.13u
X1909 a_10331_3900# sg13cmos5l_a221oi_1_0.C1 VPWR VPWR sg13_lv_pmos ad=0.3808p pd=2.92u as=0.2128p ps=1.5u w=1.12u l=0.13u
X1910 sg13cmos5l_inv_1_1.A a_15208_6200# VPWR VPWR sg13_lv_pmos ad=0.42p pd=2.99u as=0.2114p ps=1.54u w=1.12u l=0.13u
X1911 sg13cmos5l_dfrbp_1_21.Q_N a_17519_6239# VPWR VPWR sg13_lv_pmos ad=0.4312p pd=3.01u as=0.2639p ps=1.81u w=1.12u l=0.13u
X1912 VGND a_6117_6141# a_6219_6284# VGND sg13_lv_nmos ad=1.97045p pd=12.335u as=0.2516p ps=2.16u w=0.74u l=0.13u
X1913 VPWR sg13cmos5l_nor2_1_0.A sg13cmos5l_a22oi_1_0.B1 VPWR sg13_lv_pmos ad=0.3808p pd=2.92u as=0.2128p ps=1.5u w=1.12u l=0.13u
X1914 VPWR sg13cmos5l_inv_1_0.A a_11072_5347# VPWR sg13_lv_pmos ad=0.1596p pd=1.22u as=0.1596p ps=1.22u w=0.84u l=0.13u
X1915 VGND a_13641_7674# a_14166_7656# VGND sg13_lv_nmos ad=0.1491p pd=1.18u as=0.187p ps=1.78u w=0.55u l=0.13u
X1916 a_5220_2392# a_5194_2356# VPWR VPWR sg13_lv_pmos ad=0.34p pd=2.68u as=0.36237p ps=2.605u w=1u l=0.13u
X1917 a_7095_1642# sg13cmos5l_dlhr_1_0.GATE VPWR VPWR sg13_lv_pmos ad=0.3234p pd=2.45u as=1.777p ps=11.395u w=0.84u l=0.13u
X1918 a_20492_8400# sg13cmos5l_buf_1_104.X VPWR VPWR sg13_lv_pmos ad=0.2856p pd=2.36u as=0.2114p ps=1.54u w=0.84u l=0.13u
X1919 VGND sg13cmos5l_dfrbp_1_6.RESET_B a_19444_5800# VGND sg13_lv_nmos ad=0.1406p pd=1.12u as=77.7f ps=0.95u w=0.74u l=0.13u
X1920 a_1997_6126# a_2727_6380# a_2638_6477# VPWR sg13_lv_pmos ad=0.2048p pd=1.63u as=93.45f ps=0.865u w=0.42u l=0.13u
X1921 a_11844_4325# a_11556_3904# a_11782_4325# VGND sg13_lv_nmos ad=0.1428p pd=1.52u as=37.8f ps=0.6u w=0.42u l=0.13u
X1922 sg13cmos5l_dfrbp_1_9.Q a_4244_3900# VGND VGND sg13_lv_nmos ad=0.2516p pd=2.16u as=0.1406p ps=1.12u w=0.74u l=0.13u
X1923 sg13cmos5l_buf_1_89.A a_14889_7281# VPWR VPWR sg13_lv_pmos ad=0.3808p pd=2.92u as=0.2128p ps=1.5u w=1.12u l=0.13u
X1924 a_11372_3102# sg13cmos5l_buf_1_9.A VPWR VPWR sg13_lv_pmos ad=0.2856p pd=2.36u as=0.2114p ps=1.54u w=0.84u l=0.13u
X1925 VGND sg13cmos5l_buf_1_10.A a_12520_3176# VGND sg13_lv_nmos ad=0.14875p pd=1.16u as=0.187p ps=1.78u w=0.55u l=0.13u
X1926 VGND a_7888_4870# a_7537_4727# VGND sg13_lv_nmos ad=79.8f pd=0.8u as=0.1428p ps=1.52u w=0.42u l=0.13u
X1927 a_2169_7047# a_1227_6935# a_1967_7285# VPWR sg13_lv_pmos ad=93.45f pd=0.865u as=0.2048p ps=1.63u w=0.42u l=0.13u
X1928 a_14640_6924# a_14089_7282# VPWR VPWR sg13_lv_pmos ad=0.105p pd=1.21u as=1.07253p ps=6.75u w=1u l=0.13u
X1929 VGND sg13cmos5l_dfrbp_1_8.RESET_B a_5796_8874# VGND sg13_lv_nmos ad=0.1626p pd=1.415u as=60.89999f ps=0.71u w=0.42u l=0.13u
X1930 a_11567_7751# a_10725_7653# a_11473_7751# VGND sg13_lv_nmos ad=0.12665p pd=1.145u as=0.1428p ps=1.52u w=0.42u l=0.13u
X1931 VPWR sg13cmos5l_inv_1_18.A sg13cmos5l_buf_1_28.A VPWR sg13_lv_pmos ad=0.3808p pd=2.92u as=0.3808p ps=2.92u w=1.12u l=0.13u
X1932 sg13cmos5l_dlhr_1_3.Q_N a_4566_2818# VGND VGND sg13_lv_nmos ad=0.2516p pd=2.16u as=0.1491p ps=1.18u w=0.74u l=0.13u
X1933 VGND a_6736_2630# a_6385_2749# VGND sg13_lv_nmos ad=79.8f pd=0.8u as=0.1428p ps=1.52u w=0.42u l=0.13u
X1934 sg13cmos5l_dlhr_1_2.Q_N a_8022_3120# VPWR VPWR sg13_lv_pmos ad=0.3808p pd=2.92u as=0.1974p ps=1.5u w=1.12u l=0.13u
X1935 a_15045_8447# sg13cmos5l_inv_1_2.A VGND VGND sg13_lv_nmos ad=0.2516p pd=2.16u as=2.71505p ps=17.54u w=0.74u l=0.13u
X1936 VGND a_15909_2399# a_16011_2399# VGND sg13_lv_nmos ad=2.59257p pd=16.445u as=0.2516p ps=2.16u w=0.74u l=0.13u
X1937 a_12873_6553# a_12516_6480# VPWR VPWR sg13_lv_pmos ad=63f pd=0.72u as=0.1563p ps=1.22u w=0.42u l=0.13u
X1938 VPWR VGND VPWR VPWR sg13_lv_pmos ad=0.34p pd=2.68u as=0 ps=0 w=1u l=1u
X1939 a_9823_2364# sg13cmos5l_inv_1_11.Y VPWR VPWR sg13_lv_pmos ad=0.2716p pd=1.605u as=0.3808p ps=2.92u w=1.12u l=0.13u
X1940 a_10428_9222# a_9879_9202# a_10292_9508# VGND sg13_lv_nmos ad=47.25f pd=0.645u as=0.141p ps=1.17u w=0.42u l=0.13u
X1941 VPWR sg13cmos5l_nand2_1_1.A sg13cmos5l_o21ai_1_0.B1 VPWR sg13_lv_pmos ad=0.3808p pd=2.92u as=0.2128p ps=1.5u w=1.12u l=0.13u
X1942 VGND a_3669_6320# a_2748_6126# VGND sg13_lv_nmos ad=0.1626p pd=1.415u as=0.2516p ps=2.16u w=0.74u l=0.13u
X1943 VPWR VGND VPWR VPWR sg13_lv_pmos ad=0.19p pd=1.38u as=0 ps=0 w=1u l=1u
X1944 VPWR VGND VPWR VPWR sg13_lv_pmos ad=0.19p pd=1.38u as=0 ps=0 w=1u l=1u
X1945 sg13cmos5l_buf_1_28.X a_9448_1664# VPWR VPWR sg13_lv_pmos ad=0.42p pd=2.99u as=0.2114p ps=1.54u w=1.12u l=0.13u
X1946 VPWR sg13cmos5l_dfrbp_1_8.RESET_B a_12106_9409# VPWR sg13_lv_pmos ad=0.1563p pd=1.22u as=0.147p ps=1.54u w=0.42u l=0.13u
X1947 a_14583_5770# sg13cmos5l_dfrbp_1_23.CLK VGND VGND sg13_lv_nmos ad=0.2516p pd=2.16u as=0.15055p ps=1.17u w=0.74u l=0.13u
X1948 sg13cmos5l_dlhr_1_11.GATE a_10868_8436# VGND VGND sg13_lv_nmos ad=0.2516p pd=2.16u as=0.1406p ps=1.12u w=0.74u l=0.13u
X1949 VGND a_7497_3138# a_8022_3120# VGND sg13_lv_nmos ad=0.1491p pd=1.18u as=0.187p ps=1.78u w=0.55u l=0.13u
X1950 a_5546_5850# a_5069_5376# a_5452_5850# VGND sg13_lv_nmos ad=37.8f pd=0.6u as=0.1428p ps=1.52u w=0.42u l=0.13u
X1951 VGND a_12567_7282# a_12698_7288# VGND sg13_lv_nmos ad=1.49685p pd=9.6u as=0.2775p ps=2.23u w=0.74u l=0.13u
X1952 a_3669_6320# a_2727_6380# a_3530_6320# VGND sg13_lv_nmos ad=79.8f pd=0.8u as=0.2373p ps=1.97u w=0.42u l=0.13u
X1953 VPWR sg13cmos5l_dfrbp_1_0.Q a_14254_2444# VPWR sg13_lv_pmos ad=0.2618p pd=1.63u as=0.2856p ps=2.36u w=0.84u l=0.13u
X1954 a_1956_4338# sg13cmos5l_dlhr_1_1.GATE a_1862_4338# VGND sg13_lv_nmos ad=60.89999f pd=0.71u as=0.1428p ps=1.52u w=0.42u l=0.13u
X1955 a_1878_6337# a_1997_6126# VGND VGND sg13_lv_nmos ad=0.2516p pd=2.16u as=0.1406p ps=1.12u w=0.74u l=0.13u
X1956 a_14814_4292# sg13cmos5l_nand2_1_1.B VGND VGND sg13_lv_nmos ad=96.2f pd=1u as=0.2516p ps=2.16u w=0.74u l=0.13u
X1957 sg13cmos5l_buf_1_116.A a_15177_5769# VGND VGND sg13_lv_nmos ad=0.2516p pd=2.16u as=0.1406p ps=1.12u w=0.74u l=0.13u
X1958 a_12516_6480# a_12490_6385# VGND VGND sg13_lv_nmos ad=0.2516p pd=2.16u as=0.1626p ps=1.415u w=0.74u l=0.13u
X1959 a_19340_8400# sg13cmos5l_buf_1_107.X VGND VGND sg13_lv_nmos ad=0.187p pd=1.78u as=0.14875p ps=1.16u w=0.55u l=0.13u
X1960 VGND sg13cmos5l_dfrbp_1_6.RESET_B a_2644_4636# VGND sg13_lv_nmos ad=0.1406p pd=1.12u as=77.7f ps=0.95u w=0.74u l=0.13u
X1961 a_7812_7687# a_7524_7992# a_7750_7687# VGND sg13_lv_nmos ad=0.1428p pd=1.52u as=37.8f ps=0.6u w=0.42u l=0.13u
X1962 a_2224_5654# a_1967_5773# a_2386_5850# VGND sg13_lv_nmos ad=0.1428p pd=1.52u as=37.8f ps=0.6u w=0.42u l=0.13u
X1963 VPWR a_17751_7690# a_17882_7684# VPWR sg13_lv_pmos ad=1.15047p pd=7.175u as=0.2856p ps=2.36u w=0.84u l=0.13u
X1964 VPWR sg13cmos5l_dfrbp_1_6.RESET_B a_19209_5769# VPWR sg13_lv_pmos ad=0.2128p pd=1.5u as=0.2128p ps=1.5u w=1.12u l=0.13u
X1965 a_6843_5459# a_5951_5383# a_6741_5459# VPWR sg13_lv_pmos ad=63f pd=0.72u as=79.8f ps=0.8u w=0.42u l=0.13u
X1966 VPWR sg13cmos5l_buf_1_40.A sg13cmos5l_buf_1_63.A VPWR sg13_lv_pmos ad=0.3808p pd=2.92u as=0.3808p ps=2.92u w=1.12u l=0.13u
X1967 VPWR sg13cmos5l_inv_1_2.A sg13cmos5l_dfrbp_1_0.CLK VPWR sg13_lv_pmos ad=0.3808p pd=2.92u as=0.3808p ps=2.92u w=1.12u l=0.13u
X1968 sg13cmos5l_and3_1_0.X a_13324_4696# VPWR VPWR sg13_lv_pmos ad=0.3808p pd=2.92u as=0.36195p ps=1.84u w=1.12u l=0.13u
X1969 VPWR a_10071_7282# a_10202_7288# VPWR sg13_lv_pmos ad=1.07253p pd=6.75u as=0.2856p ps=2.36u w=0.84u l=0.13u
X1970 a_19028_5412# a_18615_5770# a_18960_5412# VPWR sg13_lv_pmos ad=0.191p pd=1.44u as=0.105p ps=1.21u w=1u l=0.13u
X1971 a_10427_2736# sg13cmos5l_nor2_1_0.A VGND VGND sg13_lv_nmos ad=78.39999f pd=0.885u as=0.2272p ps=1.99u w=0.64u l=0.13u
X1972 VPWR sg13cmos5l_buf_1_25.X a_4456_1664# VPWR sg13_lv_pmos ad=0.2114p pd=1.54u as=0.2856p ps=2.36u w=0.84u l=0.13u
X1973 VPWR a_8783_7751# a_9620_7972# VPWR sg13_lv_pmos ad=0.2128p pd=1.5u as=0.3864p ps=2.93u w=1.12u l=0.13u
X1974 sg13cmos5l_buf_1_9.A a_9832_1664# VPWR VPWR sg13_lv_pmos ad=0.42p pd=2.99u as=0.2114p ps=1.54u w=1.12u l=0.13u
X1975 VGND sg13cmos5l_dfrbp_1_6.RESET_B a_14820_7674# VGND sg13_lv_nmos ad=0.1626p pd=1.415u as=60.89999f ps=0.71u w=0.42u l=0.13u
X1976 VGND sg13cmos5l_inv_1_5.A a_20392_3900# VGND sg13_lv_nmos ad=0.14875p pd=1.16u as=0.187p ps=1.78u w=0.55u l=0.13u
X1977 VPWR a_1125_5423# a_1227_5423# VPWR sg13_lv_pmos ad=1.28962p pd=8.195u as=0.3864p ps=2.93u w=1.12u l=0.13u
X1978 a_2436_4325# a_2148_3904# a_2374_4325# VGND sg13_lv_nmos ad=0.1428p pd=1.52u as=37.8f ps=0.6u w=0.42u l=0.13u
X1979 sg13cmos5l_buf_8_1.A a_17972_4948# VPWR VPWR sg13_lv_pmos ad=0.3808p pd=2.92u as=0.2128p ps=1.5u w=1.12u l=0.13u
X1980 sg13cmos5l_dfrbp_1_6.RESET_B cks VPWR VPWR sg13_lv_pmos ad=0.2184p pd=1.51u as=0.2128p ps=1.5u w=1.12u l=0.13u
X1981 a_3302_4650# a_4107_4772# a_3562_4873# VPWR sg13_lv_pmos ad=0.1428p pd=1.52u as=79.8f ps=0.8u w=0.42u l=0.13u
X1982 VGND a_16268_1590# nl_sw[7] VGND sg13_lv_nmos ad=0.14875p pd=1.16u as=0.2886p ps=2.26u w=0.74u l=0.13u
X1983 a_8457_7281# a_8276_6924# VPWR VPWR sg13_lv_pmos ad=0.2128p pd=1.5u as=0.2387p ps=1.84u w=1.12u l=0.13u
X1984 sg13cmos5l_dfrbp_1_11.Q_N a_7631_4727# VGND VGND sg13_lv_nmos ad=0.2849p pd=2.25u as=0.2516p ps=2.16u w=0.74u l=0.13u
X1985 VGND a_17132_9150# ph_sw[7] VGND sg13_lv_nmos ad=0.14875p pd=1.16u as=0.2886p ps=2.26u w=0.74u l=0.13u
X1986 VGND sg13cmos5l_buf_1_73.X a_5800_9224# VGND sg13_lv_nmos ad=0.14875p pd=1.16u as=0.187p ps=1.78u w=0.55u l=0.13u
X1987 sg13cmos5l_buf_1_104.X a_19624_8436# VGND VGND sg13_lv_nmos ad=0.2886p pd=2.26u as=0.14875p ps=1.16u w=0.74u l=0.13u
X1988 ph_sw[3] a_5416_9224# VGND VGND sg13_lv_nmos ad=0.2886p pd=2.26u as=0.14875p ps=1.16u w=0.74u l=0.13u
X1989 a_3926_6175# a_2748_6126# a_3530_6320# VGND sg13_lv_nmos ad=37.8f pd=0.6u as=0.1428p ps=1.52u w=0.42u l=0.13u
X1990 a_13094_6924# a_12698_7288# a_12980_6924# VPWR sg13_lv_pmos ad=0.1008p pd=0.9u as=0.191p ps=1.44u w=0.42u l=0.13u
X1991 VGND a_6479_2749# a_7316_2388# VGND sg13_lv_nmos ad=0.1406p pd=1.12u as=0.2516p ps=2.16u w=0.74u l=0.13u
X1992 a_9705_4650# a_9524_4972# VPWR VPWR sg13_lv_pmos ad=0.2128p pd=1.5u as=0.2387p ps=1.84u w=1.12u l=0.13u
X1993 VPWR cks sg13cmos5l_dfrbp_1_6.RESET_B VPWR sg13_lv_pmos ad=0.2128p pd=1.5u as=0.2128p ps=1.5u w=1.12u l=0.13u
X1994 a_18873_1941# a_17931_1748# a_18671_1703# VPWR sg13_lv_pmos ad=93.45f pd=0.865u as=0.2048p ps=1.63u w=0.42u l=0.13u
X1995 VPWR a_1402_3864# a_1121_4166# VPWR sg13_lv_pmos ad=0.1523p pd=1.38u as=0.34p ps=2.68u w=1u l=0.5u
X1996 a_13034_5412# sg13cmos5l_nor2_1_0.A sg13cmos5l_or2_1_1.B VPWR sg13_lv_pmos ad=0.1176p pd=1.33u as=0.3808p ps=2.92u w=1.12u l=0.13u
X1997 VGND a_7863_7282# a_7994_7288# VGND sg13_lv_nmos ad=1.49685p pd=9.6u as=0.2775p ps=2.23u w=0.74u l=0.13u
X1998 a_16551_3987# a_16703_3871# VGND VGND sg13_lv_nmos ad=0.2516p pd=2.16u as=2.41737p ps=15.64u w=0.74u l=0.13u
X1999 a_7524_7992# a_7498_7897# VPWR VPWR sg13_lv_pmos ad=0.34p pd=2.68u as=0.36237p ps=2.605u w=1u l=0.13u
X2000 VPWR a_7095_1642# a_7226_1636# VPWR sg13_lv_pmos ad=1.86162p pd=11.935u as=0.2856p ps=2.36u w=0.84u l=0.13u
X2001 a_7820_2352# sg13cmos5l_dlhr_1_0.Q VPWR VPWR sg13_lv_pmos ad=0.2856p pd=2.36u as=0.2114p ps=1.54u w=0.84u l=0.13u
X2002 VGND a_10028_6126# sg13cmos5l_inv_1_18.A VGND sg13_lv_nmos ad=0.14875p pd=1.16u as=0.2886p ps=2.26u w=0.74u l=0.13u
X2003 a_4076_7624# a_4324_7996# a_4282_8112# VPWR sg13_lv_pmos ad=0.191p pd=1.44u as=0.1008p ps=0.9u w=0.42u l=0.13u
X2004 sg13cmos5l_a22oi_1_0.Y sg13cmos5l_inv_1_0.A a_10783_4292# VGND sg13_lv_nmos ad=0.2664p pd=1.46u as=0.13875p ps=1.115u w=0.74u l=0.13u
X2005 VGND VPWR VGND VGND sg13_lv_nmos ad=0.1428p pd=1.52u as=0 ps=0 w=0.42u l=1u
X2006 VPWR sg13cmos5l_dfrbp_1_6.RESET_B a_14986_7897# VPWR sg13_lv_pmos ad=0.1563p pd=1.22u as=0.147p ps=1.54u w=0.42u l=0.13u
X2007 a_2790_7996# a_2621_7636# a_2348_7624# VPWR sg13_lv_pmos ad=0.105p pd=1.21u as=0.191p ps=1.44u w=1u l=0.13u
X2008 VGND a_7055_4261# a_7892_3900# VGND sg13_lv_nmos ad=0.1406p pd=1.12u as=0.2516p ps=2.16u w=0.74u l=0.13u
X2009 a_7312_4142# a_7055_4261# a_7474_4338# VGND sg13_lv_nmos ad=0.1428p pd=1.52u as=37.8f ps=0.6u w=0.42u l=0.13u
X2010 a_17414_3138# sg13cmos5l_a22oi_1_1.Y VPWR VPWR sg13_lv_pmos ad=79.8f pd=0.8u as=0.1428p ps=1.52u w=0.42u l=0.13u
X2011 a_12489_9577# a_12132_9504# VPWR VPWR sg13_lv_pmos ad=63f pd=0.72u as=0.1563p ps=1.22u w=0.42u l=0.13u
X2012 VGND a_13072_4142# a_12721_4261# VGND sg13_lv_nmos ad=79.8f pd=0.8u as=0.1428p ps=1.52u w=0.42u l=0.13u
X2013 a_10412_6126# sg13cmos5l_dlhr_1_5.Q VPWR VPWR sg13_lv_pmos ad=0.2856p pd=2.36u as=0.2114p ps=1.54u w=0.84u l=0.13u
X2014 sg13cmos5l_dlhr_1_4.Q_N a_6198_3120# VGND VGND sg13_lv_nmos ad=0.2516p pd=2.16u as=0.1491p ps=1.18u w=0.74u l=0.13u
X2015 VGND a_12216_5728# sg13cmos5l_a221oi_1_0.B1 VGND sg13_lv_nmos ad=0.1469p pd=1.155u as=0.2516p ps=2.16u w=0.74u l=0.13u
X2016 a_7863_7282# sg13cmos5l_dlhr_1_5.GATE VPWR VPWR sg13_lv_pmos ad=0.3234p pd=2.45u as=1.04815p ps=6.595u w=0.84u l=0.13u
X2017 sg13cmos5l_dfrbp_1_18.Q_N a_7247_8797# VGND VGND sg13_lv_nmos ad=0.2849p pd=2.25u as=0.2516p ps=2.16u w=0.74u l=0.13u
X2018 a_13391_9263# a_12549_9165# a_12132_9504# VPWR sg13_lv_pmos ad=0.2048p pd=1.63u as=0.34p ps=2.68u w=1u l=0.13u
X2019 a_12716_8400# sg13cmos5l_buf_1_79.X VGND VGND sg13_lv_nmos ad=0.187p pd=1.78u as=0.14875p ps=1.16u w=0.55u l=0.13u
X2020 a_15357_1816# sg13cmos5l_dfrbp_1_0.Q VPWR VPWR sg13_lv_pmos ad=0.2856p pd=2.36u as=0.2198p ps=1.53u w=0.84u l=0.13u
X2021 VGND sg13cmos5l_inv_1_2.A sg13cmos5l_dfrbp_1_0.CLK VGND sg13_lv_nmos ad=0.2516p pd=2.16u as=0.2516p ps=2.16u w=0.74u l=0.13u
X2022 a_17938_6162# sg13cmos5l_dfrbp_1_6.RESET_B VGND VGND sg13_lv_nmos ad=37.8f pd=0.6u as=79.8f ps=0.8u w=0.42u l=0.13u
X2023 VGND a_13161_7281# a_13116_7326# VGND sg13_lv_nmos ad=0.1428p pd=1.52u as=47.25f ps=0.645u w=0.42u l=0.13u
X2024 VPWR sg13cmos5l_dfrbp_1_6.RESET_B a_4425_7281# VPWR sg13_lv_pmos ad=0.2128p pd=1.5u as=0.2128p ps=1.5u w=1.12u l=0.13u
X2025 sg13cmos5l_inv_1_7.A a_11464_8436# VGND VGND sg13_lv_nmos ad=0.2886p pd=2.26u as=0.14875p ps=1.16u w=0.74u l=0.13u
X2026 sg13cmos5l_dlhr_1_15.Q_N a_18870_7656# VPWR VPWR sg13_lv_pmos ad=0.3808p pd=2.92u as=0.1974p ps=1.5u w=1.12u l=0.13u
X2027 a_1196_8400# sg13cmos5l_buf_1_63.A VGND VGND sg13_lv_nmos ad=0.187p pd=1.78u as=0.14875p ps=1.16u w=0.55u l=0.13u
X2028 a_13072_1846# a_12815_1703# a_13234_1626# VGND sg13_lv_nmos ad=0.1428p pd=1.52u as=37.8f ps=0.6u w=0.42u l=0.13u
X2029 a_13486_5412# sg13cmos5l_or2_1_1.B a_13698_5412# VPWR sg13_lv_pmos ad=0.2128p pd=1.5u as=0.3808p ps=2.92u w=1.12u l=0.13u
X2030 VPWR a_12719_2749# a_13556_2388# VPWR sg13_lv_pmos ad=0.2128p pd=1.5u as=0.3864p ps=2.93u w=1.12u l=0.13u
X2031 a_4244_6924# a_3831_7282# a_4176_6924# VPWR sg13_lv_pmos ad=0.191p pd=1.44u as=0.105p ps=1.21u w=1u l=0.13u
X2032 VGND sg13cmos5l_buf_1_3.X a_20392_3176# VGND sg13_lv_nmos ad=0.14875p pd=1.16u as=0.187p ps=1.78u w=0.55u l=0.13u
X2033 VGND a_19628_2352# nh_sw[9] VGND sg13_lv_nmos ad=0.14875p pd=1.16u as=0.2886p ps=2.26u w=0.74u l=0.13u
X2034 VPWR a_1158_3142# a_1290_3206# VPWR sg13_lv_pmos ad=0.2245p pd=1.53u as=0.445p ps=2.89u w=1u l=0.25u
X2035 a_2565_8447# sg13cmos5l_inv_1_8.A VPWR VPWR sg13_lv_pmos ad=0.4088p pd=2.97u as=1.12242p ps=7u w=1.12u l=0.13u
X2036 a_14628_8440# a_15147_8447# a_15887_8797# VGND sg13_lv_nmos ad=0.3473p pd=2.71u as=0.12665p ps=1.145u w=0.74u l=0.13u
X2037 VPWR a_1948_7964# sg13cmos5l_buf_1_58.A VPWR sg13_lv_pmos ad=0.2128p pd=1.5u as=0.3808p ps=2.92u w=1.12u l=0.13u
X2038 VGND sg13cmos5l_buf_1_18.A a_18376_2388# VGND sg13_lv_nmos ad=0.14875p pd=1.16u as=0.187p ps=1.78u w=0.55u l=0.13u
X2039 VGND a_8247_5770# a_8378_5776# VGND sg13_lv_nmos ad=1.97045p pd=12.335u as=0.2775p ps=2.23u w=0.74u l=0.13u
X2040 a_3974_2388# a_3578_2752# a_3860_2388# VPWR sg13_lv_pmos ad=0.1008p pd=0.9u as=0.191p ps=1.44u w=0.42u l=0.13u
X2041 VPWR a_2409_4650# a_2934_4632# VPWR sg13_lv_pmos ad=0.1974p pd=1.5u as=0.2856p ps=2.36u w=0.84u l=0.13u
X2042 a_2374_8861# sg13cmos5l_dfrbp_1_8.RESET_B VGND VGND sg13_lv_nmos ad=37.8f pd=0.6u as=0.1701p ps=1.65u w=0.42u l=0.13u
X2043 a_18928_1846# sg13cmos5l_dfrbp_1_0.RESET_B VPWR VPWR sg13_lv_pmos ad=79.8f pd=0.8u as=1.777p ps=11.395u w=0.42u l=0.13u
X2044 VPWR a_17516_9150# pl_sw[8] VPWR sg13_lv_pmos ad=0.2114p pd=1.54u as=0.42p ps=2.99u w=1.12u l=0.13u
X2045 VGND sg13cmos5l_dlhr_1_9.D a_10587_4692# VGND sg13_lv_nmos ad=0.14505p pd=1.15u as=0.187p ps=1.78u w=0.55u l=0.13u
X2046 a_1158_3142# a_902_3142# VGND VGND sg13_lv_nmos ad=0.1428p pd=1.52u as=0.1323p ps=1.05u w=0.42u l=0.18u
X2047 VPWR a_6572_1590# sg13cmos5l_buf_1_24.X VPWR sg13_lv_pmos ad=0.2114p pd=1.54u as=0.42p ps=2.99u w=1.12u l=0.13u
X2048 VPWR a_1580_2352# nh_sw[0] VPWR sg13_lv_pmos ad=0.2114p pd=1.54u as=0.42p ps=2.99u w=1.12u l=0.13u
X2049 VPWR sg13cmos5l_a221oi_1_0.A2 a_8041_5770# VPWR sg13_lv_pmos ad=1.28962p pd=8.195u as=0.2856p ps=2.36u w=0.84u l=0.13u
X2050 a_7833_4965# a_6891_4772# a_7631_4727# VPWR sg13_lv_pmos ad=93.45f pd=0.865u as=0.2048p ps=1.63u w=0.42u l=0.13u
X2051 pl_sw[4] a_5800_9224# VPWR VPWR sg13_lv_pmos ad=0.42p pd=2.99u as=0.2114p ps=1.54u w=1.12u l=0.13u
X2052 VGND a_17751_7690# a_17882_7684# VGND sg13_lv_nmos ad=1.49685p pd=9.6u as=0.2775p ps=2.23u w=0.74u l=0.13u
X2053 a_19828_6148# a_19412_6484# a_19593_6162# VGND sg13_lv_nmos ad=77.7f pd=0.95u as=0.2516p ps=2.16u w=0.74u l=0.13u
X2054 VGND a_15702_4187# sg13cmos5l_and3_1_0.C VGND sg13_lv_nmos ad=0.1406p pd=1.12u as=0.2516p ps=2.16u w=0.74u l=0.13u
X2055 VPWR a_6479_2749# a_6736_2630# VPWR sg13_lv_pmos ad=0.2639p pd=1.81u as=79.8f ps=0.8u w=0.42u l=0.13u
X2056 sg13cmos5l_inv_1_9.Y cks VPWR VPWR sg13_lv_pmos ad=0.3808p pd=2.92u as=0.3808p ps=2.92u w=1.12u l=0.13u
X2057 a_5508_2813# a_5739_2399# a_5194_2356# VGND sg13_lv_nmos ad=0.2373p pd=1.97u as=79.8f ps=0.8u w=0.42u l=0.13u
X2058 VPWR a_9879_9202# a_10010_9196# VPWR sg13_lv_pmos ad=4.11675p pd=27.17u as=0.2856p ps=2.36u w=0.84u l=0.13u
X2059 sg13cmos5l_buf_1_90.X a_11464_9224# VGND VGND sg13_lv_nmos ad=0.2886p pd=2.26u as=0.14875p ps=1.16u w=0.74u l=0.13u
X2060 VPWR VGND VPWR VPWR sg13_lv_pmos ad=0.34p pd=2.68u as=0 ps=0 w=1u l=1u
X2061 a_15492_2392# a_16011_2399# a_16751_2749# VGND sg13_lv_nmos ad=0.3473p pd=2.71u as=0.12665p ps=1.145u w=0.74u l=0.13u
X2062 a_2583_7710# a_1948_7964# VGND VGND sg13_lv_nmos ad=47.25f pd=0.645u as=0.1428p ps=1.52u w=0.42u l=0.13u
X2063 VPWR a_5673_3138# a_5606_3576# VPWR sg13_lv_pmos ad=0.2387p pd=1.84u as=0.1008p ps=0.9u w=0.42u l=0.13u
X2064 sg13cmos5l_dfrbp_1_5.Q_N a_16751_2749# VGND VGND sg13_lv_nmos ad=0.2849p pd=2.25u as=0.2516p ps=2.16u w=0.74u l=0.13u
X2065 a_15439_1630# a_15357_1816# sg13cmos5l_nand2_1_1.B VGND sg13_lv_nmos ad=0.1406p pd=1.12u as=0.333p ps=2.38u w=0.74u l=0.13u
X2066 sg13cmos5l_buf_1_25.A sg13cmos5l_inv_1_14.A VPWR VPWR sg13_lv_pmos ad=0.3808p pd=2.92u as=0.3808p ps=2.92u w=1.12u l=0.13u
X2067 VPWR VGND VPWR VPWR sg13_lv_pmos ad=0.34p pd=2.68u as=0 ps=0 w=1u l=1u
X2068 a_2122_8404# a_2565_8447# a_2505_8483# VPWR sg13_lv_pmos ad=79.8f pd=0.8u as=63f ps=0.72u w=0.42u l=0.13u
X2069 a_10225_9178# a_9673_9240# VGND VGND sg13_lv_nmos ad=71.99999f pd=0.865u as=2.92392p ps=18.89u w=0.64u l=0.13u
X2070 VPWR a_3447_2746# a_3578_2752# VPWR sg13_lv_pmos ad=1.86162p pd=11.935u as=0.2856p ps=2.36u w=0.84u l=0.13u
X2071 VPWR a_620_2352# nl_sw[0] VPWR sg13_lv_pmos ad=0.2114p pd=1.54u as=0.42p ps=2.99u w=1.12u l=0.13u
X2072 a_13596_7710# a_13047_7690# a_13460_7996# VGND sg13_lv_nmos ad=47.25f pd=0.645u as=0.141p ps=1.17u w=0.42u l=0.13u
X2073 VGND sg13cmos5l_dfrbp_1_23.Q_N a_14377_5770# VGND sg13_lv_nmos ad=0.15055p pd=1.17u as=0.187p ps=1.78u w=0.55u l=0.13u
X2074 VGND a_10725_7653# a_10827_7796# VGND sg13_lv_nmos ad=1.49685p pd=9.6u as=0.2516p ps=2.16u w=0.74u l=0.13u
X2075 VGND a_20012_1590# sg13cmos5l_buf_1_0.X VGND sg13_lv_nmos ad=0.14875p pd=1.16u as=0.2886p ps=2.26u w=0.74u l=0.13u
X2076 VGND sg13cmos5l_dfrbp_1_6.RESET_B a_10708_9172# VGND sg13_lv_nmos ad=0.1406p pd=1.12u as=77.7f ps=0.95u w=0.74u l=0.13u
X2077 sg13cmos5l_buf_1_46.A a_9705_4650# VGND VGND sg13_lv_nmos ad=0.2516p pd=2.16u as=0.1406p ps=1.12u w=0.74u l=0.13u
X2078 a_7504_8678# a_7247_8797# a_7666_8874# VGND sg13_lv_nmos ad=0.1428p pd=1.52u as=37.8f ps=0.6u w=0.42u l=0.13u
X2079 VPWR a_15500_9150# ph_sw[6] VPWR sg13_lv_pmos ad=0.2114p pd=1.54u as=0.42p ps=2.99u w=1.12u l=0.13u
X2080 a_2380_6162# a_1997_6126# VPWR VPWR sg13_lv_pmos ad=79.8f pd=0.8u as=0.2639p ps=1.81u w=0.42u l=0.13u
X2081 VGND a_7095_1642# a_7226_1636# VGND sg13_lv_nmos ad=7.01497p pd=46.005u as=0.2775p ps=2.23u w=0.74u l=0.13u
X2082 a_10596_7687# a_10827_7796# a_10282_7897# VGND sg13_lv_nmos ad=0.2373p pd=1.97u as=79.8f ps=0.8u w=0.42u l=0.13u
X2083 VPWR VGND VPWR VPWR sg13_lv_pmos ad=0.34p pd=2.68u as=0 ps=0 w=1u l=1u
X2084 VGND a_5673_3138# a_6198_3120# VGND sg13_lv_nmos ad=0.1491p pd=1.18u as=0.187p ps=1.78u w=0.55u l=0.13u
X2085 VGND a_2224_5654# a_1873_5773# VGND sg13_lv_nmos ad=79.8f pd=0.8u as=0.1428p ps=1.52u w=0.42u l=0.13u
X2086 VGND a_12815_1703# a_13652_1924# VGND sg13_lv_nmos ad=0.1406p pd=1.12u as=0.2516p ps=2.16u w=0.74u l=0.13u
X2087 a_13076_5376# sg13cmos5l_inv_1_0.A VPWR VPWR sg13_lv_pmos ad=0.2856p pd=2.36u as=0.2618p ps=1.63u w=0.84u l=0.13u
X2088 a_17516_9150# sg13cmos5l_buf_1_103.A VPWR VPWR sg13_lv_pmos ad=0.2856p pd=2.36u as=0.2114p ps=1.54u w=0.84u l=0.13u
X2089 sg13cmos5l_buf_1_18.A sg13cmos5l_buf_1_111.A VPWR VPWR sg13_lv_pmos ad=0.3808p pd=2.92u as=0.3808p ps=2.92u w=1.12u l=0.13u
X2090 VPWR a_18615_5770# a_18746_5776# VPWR sg13_lv_pmos ad=1.28962p pd=8.195u as=0.2856p ps=2.36u w=0.84u l=0.13u
X2091 VGND sg13cmos5l_buf_1_30.A sg13cmos5l_buf_1_73.A VGND sg13_lv_nmos ad=0.2516p pd=2.16u as=0.2516p ps=2.16u w=0.74u l=0.13u
X2092 sg13cmos5l_dfrbp_1_20.Q_N a_8783_7751# VGND VGND sg13_lv_nmos ad=0.2849p pd=2.25u as=0.2516p ps=2.16u w=0.74u l=0.13u
X2093 a_422_7362# sg13cmos5l_dfrbp_1_6.D VPWR VPWR sg13_lv_pmos ad=79.8f pd=0.8u as=0.1428p ps=1.52u w=0.42u l=0.13u
X2094 a_15357_1816# sg13cmos5l_dfrbp_1_0.Q VGND VGND sg13_lv_nmos ad=0.187p pd=1.78u as=0.14505p ps=1.15u w=0.55u l=0.13u
X2095 a_7394_5850# sg13cmos5l_dfrbp_1_8.RESET_B VGND VGND sg13_lv_nmos ad=60.89999f pd=0.71u as=0.1626p ps=1.415u w=0.42u l=0.13u
X2096 VPWR sg13cmos5l_nor2_1_1.A sg13cmos5l_nand2_1_1.B VPWR sg13_lv_pmos ad=0.2198p pd=1.53u as=0.2128p ps=1.5u w=1.12u l=0.13u
X2097 a_7248_3460# a_6697_3192# VPWR VPWR sg13_lv_pmos ad=0.105p pd=1.21u as=1.43437p ps=9.105u w=1u l=0.13u
X2098 a_620_7638# sg13cmos5l_buf_1_63.X VPWR VPWR sg13_lv_pmos ad=0.2856p pd=2.36u as=0.2114p ps=1.54u w=0.84u l=0.13u
X2099 a_5988_6175# a_6219_6284# a_5674_6385# VGND sg13_lv_nmos ad=0.2373p pd=1.97u as=79.8f ps=0.8u w=0.42u l=0.13u
X2100 VGND a_20204_5376# sg13cmos5l_inv_1_6.A VGND sg13_lv_nmos ad=0.14875p pd=1.16u as=0.2886p ps=2.26u w=0.74u l=0.13u
X2101 VPWR a_6405_8447# a_6507_8447# VPWR sg13_lv_pmos ad=1.15047p pd=7.175u as=0.3864p ps=2.93u w=1.12u l=0.13u
X2102 a_14986_7897# a_15429_7653# a_14726_7674# VGND sg13_lv_nmos ad=79.8f pd=0.8u as=0.1296p ps=1.52u w=0.42u l=0.13u
X2103 VPWR a_13161_7281# a_13686_7354# VPWR sg13_lv_pmos ad=0.1974p pd=1.5u as=0.2856p ps=2.36u w=0.84u l=0.13u
X2104 VGND VPWR VGND VGND sg13_lv_nmos ad=0.1428p pd=1.52u as=0 ps=0 w=0.42u l=1u
X2105 VPWR sg13cmos5l_inv_1_7.A a_12232_8436# VPWR sg13_lv_pmos ad=0.2114p pd=1.54u as=0.2856p ps=2.36u w=0.84u l=0.13u
X2106 VPWR sg13cmos5l_buf_1_31.X a_1672_3176# VPWR sg13_lv_pmos ad=0.2114p pd=1.54u as=0.2856p ps=2.36u w=0.84u l=0.13u
X2107 a_7888_4870# sg13cmos5l_dfrbp_1_8.RESET_B VPWR VPWR sg13_lv_pmos ad=79.8f pd=0.8u as=1.2517p ps=7.955u w=0.42u l=0.13u
X2108 a_16486_6175# sg13cmos5l_dfrbp_1_6.RESET_B VGND VGND sg13_lv_nmos ad=37.8f pd=0.6u as=0.1701p ps=1.65u w=0.42u l=0.13u
X2109 a_15590_4650# a_16395_4772# a_15850_4873# VPWR sg13_lv_pmos ad=0.1428p pd=1.52u as=79.8f ps=0.8u w=0.42u l=0.13u
X2110 VGND a_10665_7281# a_10620_7326# VGND sg13_lv_nmos ad=0.1428p pd=1.52u as=47.25f ps=0.645u w=0.42u l=0.13u
X2111 a_12230_6162# sg13cmos5l_buf_1_57.X VPWR VPWR sg13_lv_pmos ad=79.8f pd=0.8u as=0.1428p ps=1.52u w=0.42u l=0.13u
X2112 VGND sg13cmos5l_dfrbp_1_8.RESET_B a_2474_6162# VGND sg13_lv_nmos ad=79.8f pd=0.8u as=37.8f ps=0.6u w=0.42u l=0.13u
X2113 sg13cmos5l_o21ai_1_0.A1 sg13cmos5l_a221oi_1_0.C1 a_11394_4948# VPWR sg13_lv_pmos ad=0.3808p pd=2.92u as=0.2128p ps=1.5u w=1.12u l=0.13u
X2114 a_7052_9150# sg13cmos5l_inv_1_14.A VGND VGND sg13_lv_nmos ad=0.187p pd=1.78u as=0.14875p ps=1.16u w=0.55u l=0.13u
X2115 VPWR a_10220_3102# nl_sw[5] VPWR sg13_lv_pmos ad=0.2114p pd=1.54u as=0.42p ps=2.99u w=1.12u l=0.13u
X2116 VGND sg13cmos5l_dfrbp_1_6.RESET_B a_4660_7312# VGND sg13_lv_nmos ad=0.1406p pd=1.12u as=77.7f ps=0.95u w=0.74u l=0.13u
X2117 sg13cmos5l_or2_1_0.A a_18363_4270# VGND VGND sg13_lv_nmos ad=0.1406p pd=1.12u as=0.1406p ps=1.12u w=0.74u l=0.13u
X2118 a_11771_5412# sg13cmos5l_nor2b_1_0.Y sg13cmos5l_a221oi_1_0.B2 VPWR sg13_lv_pmos ad=0.2128p pd=1.5u as=0.3808p ps=2.92u w=1.12u l=0.13u
X2119 VGND sg13cmos5l_dlhr_1_1.D a_1609_4704# VGND sg13_lv_nmos ad=0.15055p pd=1.17u as=0.187p ps=1.78u w=0.55u l=0.13u
X2120 a_15887_8797# a_15045_8447# a_15793_8797# VGND sg13_lv_nmos ad=0.12665p pd=1.145u as=0.1428p ps=1.52u w=0.42u l=0.13u
X2121 sg13cmos5l_buf_1_40.X a_1192_1664# VGND VGND sg13_lv_nmos ad=0.2886p pd=2.26u as=0.14875p ps=1.16u w=0.74u l=0.13u
X2122 VPWR a_10725_7653# a_10827_7796# VPWR sg13_lv_pmos ad=1.15047p pd=7.175u as=0.3864p ps=2.93u w=1.12u l=0.13u
X2123 a_16068_6928# a_16587_6935# a_17327_7285# VGND sg13_lv_nmos ad=0.3473p pd=2.71u as=0.12665p ps=1.145u w=0.74u l=0.13u
X2124 sg13cmos5l_a22oi_1_1.B1 sg13cmos5l_nand2_1_1.B VGND VGND sg13_lv_nmos ad=0.1406p pd=1.12u as=0.2516p ps=2.16u w=0.74u l=0.13u
X2125 VPWR a_8972_3864# sg13cmos5l_buf_1_45.X VPWR sg13_lv_pmos ad=0.2114p pd=1.54u as=0.42p ps=2.99u w=1.12u l=0.13u
X2126 a_2122_3868# a_2565_3911# a_1862_4338# VGND sg13_lv_nmos ad=79.8f pd=0.8u as=0.1296p ps=1.52u w=0.42u l=0.13u
X2127 a_12490_6385# a_12933_6141# a_12873_6553# VPWR sg13_lv_pmos ad=79.8f pd=0.8u as=63f ps=0.72u w=0.42u l=0.13u
X2128 VPWR a_1967_5773# a_2224_5654# VPWR sg13_lv_pmos ad=0.2639p pd=1.81u as=79.8f ps=0.8u w=0.42u l=0.13u
X2129 a_14985_8483# a_14628_8440# VPWR VPWR sg13_lv_pmos ad=63f pd=0.72u as=0.1563p ps=1.22u w=0.42u l=0.13u
X2130 VGND sg13cmos5l_buf_1_29.A a_9832_1664# VGND sg13_lv_nmos ad=0.14875p pd=1.16u as=0.187p ps=1.78u w=0.55u l=0.13u
X2131 VGND sg13cmos5l_or2_1_0.A sg13cmos5l_nand2_1_2.B VGND sg13_lv_nmos ad=0.2516p pd=2.16u as=0.1406p ps=1.12u w=0.74u l=0.13u
X2132 VGND sg13cmos5l_buf_1_39.A a_3688_1664# VGND sg13_lv_nmos ad=0.14875p pd=1.16u as=0.187p ps=1.78u w=0.55u l=0.13u
X2133 a_17769_2017# a_17412_1944# VPWR VPWR sg13_lv_pmos ad=63f pd=0.72u as=0.1563p ps=1.22u w=0.42u l=0.13u
X2134 a_15500_9150# sg13cmos5l_buf_1_95.X VPWR VPWR sg13_lv_pmos ad=0.2856p pd=2.36u as=0.2114p ps=1.54u w=0.84u l=0.13u
X2135 a_2628_3151# a_2859_3260# a_2314_3361# VGND sg13_lv_nmos ad=0.2373p pd=1.97u as=79.8f ps=0.8u w=0.42u l=0.13u
X2136 a_12912_6924# a_12361_7282# VPWR VPWR sg13_lv_pmos ad=0.105p pd=1.21u as=1.07253p ps=6.75u w=1u l=0.13u
X2137 a_17746_7362# sg13cmos5l_dfrbp_1_8.RESET_B VGND VGND sg13_lv_nmos ad=37.8f pd=0.6u as=79.8f ps=0.8u w=0.42u l=0.13u
X2138 sg13cmos5l_buf_1_3.A a_19528_6924# VPWR VPWR sg13_lv_pmos ad=0.42p pd=2.99u as=0.2114p ps=1.54u w=1.12u l=0.13u
X2139 sg13cmos5l_buf_1_44.A a_5673_3138# VPWR VPWR sg13_lv_pmos ad=0.3808p pd=2.92u as=0.2128p ps=1.5u w=1.12u l=0.13u
X2140 sg13cmos5l_buf_1_101.X a_16264_9224# VGND VGND sg13_lv_nmos ad=0.2886p pd=2.26u as=0.14875p ps=1.16u w=0.74u l=0.13u
X2141 a_13510_3151# sg13cmos5l_dfrbp_1_0.RESET_B VGND VGND sg13_lv_nmos ad=37.8f pd=0.6u as=0.1701p ps=1.65u w=0.42u l=0.13u
X2142 a_4652_6126# sg13cmos5l_buf_1_59.A VPWR VPWR sg13_lv_pmos ad=0.2856p pd=2.36u as=0.2114p ps=1.54u w=0.84u l=0.13u
X2143 VGND a_7312_4142# a_6961_4261# VGND sg13_lv_nmos ad=79.8f pd=0.8u as=0.1428p ps=1.52u w=0.42u l=0.13u
X2144 a_16528_7894# a_16271_7751# a_16690_7674# VGND sg13_lv_nmos ad=0.1428p pd=1.52u as=37.8f ps=0.6u w=0.42u l=0.13u
X2145 VGND a_17392_4870# a_17041_4727# VGND sg13_lv_nmos ad=79.8f pd=0.8u as=0.1428p ps=1.52u w=0.42u l=0.13u
X2146 VPWR sg13cmos5l_dfrbp_1_0.RESET_B a_11434_2356# VPWR sg13_lv_pmos ad=0.1563p pd=1.22u as=0.147p ps=1.54u w=0.42u l=0.13u
X2147 VGND sg13cmos5l_or2_1_1.B a_12216_5728# VGND sg13_lv_nmos ad=0.187p pd=1.78u as=0.1045p ps=0.93u w=0.55u l=0.13u
X2148 a_17700_1639# a_17931_1748# a_17386_1849# VGND sg13_lv_nmos ad=0.2373p pd=1.97u as=79.8f ps=0.8u w=0.42u l=0.13u
X2149 a_13234_1626# sg13cmos5l_dfrbp_1_0.RESET_B VGND VGND sg13_lv_nmos ad=37.8f pd=0.6u as=79.8f ps=0.8u w=0.42u l=0.13u
X2150 sg13cmos5l_dlhr_1_11.D a_11567_7751# VPWR VPWR sg13_lv_pmos ad=0.4312p pd=3.01u as=0.2639p ps=1.81u w=1.12u l=0.13u
X2151 VPWR VGND VPWR VPWR sg13_lv_pmos ad=0.34p pd=2.68u as=0 ps=0 w=1u l=1u
X2152 VPWR a_8457_7281# a_8982_7354# VPWR sg13_lv_pmos ad=0.1974p pd=1.5u as=0.2856p ps=2.36u w=0.84u l=0.13u
X2153 VPWR a_14583_5770# a_14714_5776# VPWR sg13_lv_pmos ad=1.28962p pd=8.195u as=0.2856p ps=2.36u w=0.84u l=0.13u
X2154 VPWR sg13cmos5l_dfrbp_1_0.RESET_B a_13258_3361# VPWR sg13_lv_pmos ad=0.1563p pd=1.22u as=0.147p ps=1.54u w=0.42u l=0.13u
X2155 a_12132_9504# a_12106_9409# VGND VGND sg13_lv_nmos ad=0.2516p pd=2.16u as=0.1626p ps=1.415u w=0.74u l=0.13u
X2156 a_6380_7638# sg13cmos5l_buf_1_78.X VPWR VPWR sg13_lv_pmos ad=0.2856p pd=2.36u as=0.2114p ps=1.54u w=0.84u l=0.13u
X2157 a_7430_3576# a_7034_3148# a_7316_3460# VPWR sg13_lv_pmos ad=0.1008p pd=0.9u as=0.191p ps=1.44u w=0.42u l=0.13u
X2158 a_15849_2435# a_15492_2392# VPWR VPWR sg13_lv_pmos ad=63f pd=0.72u as=0.1563p ps=1.22u w=0.42u l=0.13u
X2159 sg13cmos5l_dfrbp_1_18.Q a_8084_8436# VPWR VPWR sg13_lv_pmos ad=0.3808p pd=2.92u as=0.2128p ps=1.5u w=1.12u l=0.13u
X2160 a_4380_7326# a_3831_7282# a_4244_6924# VGND sg13_lv_nmos ad=47.25f pd=0.645u as=0.141p ps=1.17u w=0.42u l=0.13u
X2161 a_13484_8400# sg13cmos5l_dlhr_1_11.Q VGND VGND sg13_lv_nmos ad=0.187p pd=1.78u as=0.14875p ps=1.16u w=0.55u l=0.13u
X2162 VPWR a_5820_5773# a_6843_5459# VPWR sg13_lv_pmos ad=0.1563p pd=1.22u as=63f ps=0.72u w=0.42u l=0.13u
X2163 VGND sg13cmos5l_inv_1_18.A a_9256_9224# VGND sg13_lv_nmos ad=0.14875p pd=1.16u as=0.187p ps=1.78u w=0.55u l=0.13u
X2164 a_17988_3151# a_18219_3260# a_17674_3361# VGND sg13_lv_nmos ad=0.2373p pd=1.97u as=79.8f ps=0.8u w=0.42u l=0.13u
X2165 a_14996_5412# a_14714_5776# a_14929_5814# VGND sg13_lv_nmos ad=0.141p pd=1.17u as=71.99999f ps=0.865u w=0.64u l=0.13u
X2166 VPWR sg13cmos5l_dfrbp_1_15.D a_3575_6553# VPWR sg13_lv_pmos ad=0.1428p pd=1.52u as=79.8f ps=0.8u w=0.42u l=0.13u
X2167 VGND sg13cmos5l_dlhr_1_0.D a_6889_1680# VGND sg13_lv_nmos ad=0.15055p pd=1.17u as=0.187p ps=1.78u w=0.55u l=0.13u
X2168 a_11270_4338# a_12075_3911# a_11530_3868# VPWR sg13_lv_pmos ad=0.1428p pd=1.52u as=79.8f ps=0.8u w=0.42u l=0.13u
X2169 VPWR a_19209_5769# a_19142_5412# VPWR sg13_lv_pmos ad=0.2387p pd=1.84u as=0.1008p ps=0.9u w=0.42u l=0.13u
X2170 VGND a_17519_6239# a_18356_6460# VGND sg13_lv_nmos ad=0.1406p pd=1.12u as=0.2516p ps=2.16u w=0.74u l=0.13u
X2171 a_3609_4023# a_2667_3911# a_3407_4261# VPWR sg13_lv_pmos ad=93.45f pd=0.865u as=0.2048p ps=1.63u w=0.42u l=0.13u
X2172 sg13cmos5l_dfrbp_1_20.Q a_9620_7972# VGND VGND sg13_lv_nmos ad=0.2516p pd=2.16u as=0.1406p ps=1.12u w=0.74u l=0.13u
X2173 a_12567_7282# sg13cmos5l_dlhr_1_11.GATE VPWR VPWR sg13_lv_pmos ad=0.3234p pd=2.45u as=1.07253p ps=6.75u w=0.84u l=0.13u
X2174 VGND sg13cmos5l_nor2b_1_0.Y a_10433_1652# VGND sg13_lv_nmos ad=0.2516p pd=2.16u as=0.1406p ps=1.12u w=0.74u l=0.13u
X2175 VGND a_2757_3117# a_2859_3260# VGND sg13_lv_nmos ad=2.59257p pd=16.445u as=0.2516p ps=2.16u w=0.74u l=0.13u
X2176 VGND sg13cmos5l_inv_1_19.A sg13cmos5l_buf_1_32.A VGND sg13_lv_nmos ad=0.2516p pd=2.16u as=0.2516p ps=2.16u w=0.74u l=0.13u
X2177 VGND a_20492_8400# pl_sw[10] VGND sg13_lv_nmos ad=0.14875p pd=1.16u as=0.2886p ps=2.26u w=0.74u l=0.13u
X2178 sg13cmos5l_dfrbp_1_6.RESET_B cks VGND VGND sg13_lv_nmos ad=0.1406p pd=1.12u as=0.1406p ps=1.12u w=0.74u l=0.13u
X2179 VPWR a_14900_2352# a_14858_2388# VPWR sg13_lv_pmos ad=0.2618p pd=1.63u as=0.1176p ps=1.33u w=1.12u l=0.13u
X2180 VGND sg13cmos5l_inv_1_27.Y a_14632_9224# VGND sg13_lv_nmos ad=0.14875p pd=1.16u as=0.187p ps=1.78u w=0.55u l=0.13u
X2181 a_17721_6477# a_16779_6284# a_17519_6239# VPWR sg13_lv_pmos ad=93.45f pd=0.865u as=0.2048p ps=1.63u w=0.42u l=0.13u
X2182 VGND a_6741_5459# a_5820_5773# VGND sg13_lv_nmos ad=0.1626p pd=1.415u as=0.2516p ps=2.16u w=0.74u l=0.13u
X2183 VPWR a_13047_7690# a_13178_7684# VPWR sg13_lv_pmos ad=1.15047p pd=7.175u as=0.2856p ps=2.36u w=0.84u l=0.13u
X2184 a_14916_8861# a_14628_8440# a_14854_8861# VGND sg13_lv_nmos ad=0.1428p pd=1.52u as=37.8f ps=0.6u w=0.42u l=0.13u
X2185 a_1967_7285# a_1125_6935# a_1873_7285# VGND sg13_lv_nmos ad=0.12665p pd=1.145u as=0.1428p ps=1.52u w=0.42u l=0.13u
X2186 nl_sw[1] a_1864_1664# VGND VGND sg13_lv_nmos ad=0.2886p pd=2.26u as=0.14875p ps=1.16u w=0.74u l=0.13u
X2187 VGND VPWR VGND VGND sg13_lv_nmos ad=79.8f pd=0.8u as=0 ps=0 w=0.42u l=1u
X2188 sg13cmos5l_buf_1_86.A a_20008_8436# VGND VGND sg13_lv_nmos ad=0.2886p pd=2.26u as=0.14875p ps=1.16u w=0.74u l=0.13u
X2189 a_4034_7660# sg13cmos5l_dfrbp_1_6.RESET_B VGND VGND sg13_lv_nmos ad=77.7f pd=0.95u as=0.1406p ps=1.12u w=0.74u l=0.13u
X2190 VPWR sg13cmos5l_dlhr_1_1.GATE a_4349_7636# VPWR sg13_lv_pmos ad=1.15047p pd=7.175u as=0.3234p ps=2.45u w=0.84u l=0.13u
X2191 a_3212_1590# sg13cmos5l_buf_1_41.A VPWR VPWR sg13_lv_pmos ad=0.2856p pd=2.36u as=0.2114p ps=1.54u w=0.84u l=0.13u
X2192 a_1006_4167# a_1121_4166# VGND VGND sg13_lv_nmos ad=0.1428p pd=1.52u as=0.1426p ps=1.16u w=0.42u l=0.5u
X2193 sg13cmos5l_inv_1_3.A a_13768_8436# VGND VGND sg13_lv_nmos ad=0.2886p pd=2.26u as=0.14875p ps=1.16u w=0.74u l=0.13u
X2194 VGND sg13cmos5l_dfrbp_1_0.Q a_14254_2444# VGND sg13_lv_nmos ad=0.17255p pd=1.25u as=0.187p ps=1.78u w=0.55u l=0.13u
X2195 sg13cmos5l_buf_1_19.X a_18760_2388# VGND VGND sg13_lv_nmos ad=0.2886p pd=2.26u as=0.14875p ps=1.16u w=0.74u l=0.13u
X2196 VGND sg13cmos5l_dfrbp_1_6.RESET_B a_10116_7674# VGND sg13_lv_nmos ad=0.1626p pd=1.415u as=60.89999f ps=0.71u w=0.42u l=0.13u
X2197 a_9260_2352# sg13cmos5l_buf_1_30.X VPWR VPWR sg13_lv_pmos ad=0.2856p pd=2.36u as=0.2114p ps=1.54u w=0.84u l=0.13u
X2198 a_2314_3361# a_2757_3117# a_2697_3529# VPWR sg13_lv_pmos ad=79.8f pd=0.8u as=63f ps=0.72u w=0.42u l=0.13u
X2199 VGND sg13cmos5l_dfrbp_1_6.RESET_B a_17750_4325# VGND sg13_lv_nmos ad=0.1701p pd=1.65u as=37.8f ps=0.6u w=0.42u l=0.13u
X2200 VPWR a_10031_8797# a_10868_8436# VPWR sg13_lv_pmos ad=0.2128p pd=1.5u as=0.3864p ps=2.93u w=1.12u l=0.13u
X2201 sg13cmos5l_dlhr_1_7.Q_N a_4950_7354# VPWR VPWR sg13_lv_pmos ad=0.3808p pd=2.92u as=0.1974p ps=1.5u w=1.12u l=0.13u
X2202 a_17126_1626# sg13cmos5l_dfrbp_1_0.D VPWR VPWR sg13_lv_pmos ad=79.8f pd=0.8u as=0.1428p ps=1.52u w=0.42u l=0.13u
X2203 a_3308_5376# sg13cmos5l_dlhr_1_1.Q VGND VGND sg13_lv_nmos ad=0.187p pd=1.78u as=0.14875p ps=1.16u w=0.55u l=0.13u
X2204 a_14900_2352# sg13cmos5l_nor2_1_1.A VPWR VPWR sg13_lv_pmos ad=0.2856p pd=2.36u as=0.2618p ps=1.63u w=0.84u l=0.13u
X2205 VPWR sg13cmos5l_buf_1_34.X sg13cmos5l_buf_1_60.A VPWR sg13_lv_pmos ad=0.3808p pd=2.92u as=0.3808p ps=2.92u w=1.12u l=0.13u
X2206 VGND sg13cmos5l_inv_1_8.A sg13cmos5l_inv_1_8.Y VGND sg13_lv_nmos ad=0.2516p pd=2.16u as=0.2516p ps=2.16u w=0.74u l=0.13u
X2207 a_2054_3138# sg13cmos5l_dfrbp_1_6.D VPWR VPWR sg13_lv_pmos ad=79.8f pd=0.8u as=0.1428p ps=1.52u w=0.42u l=0.13u
X2208 VGND a_19227_4654# sg13cmos5l_buf_8_0.X VGND sg13_lv_nmos ad=0.1406p pd=1.12u as=0.1406p ps=1.12u w=0.74u l=0.13u
X2209 a_3676_7964# sg13cmos5l_dfrbp_1_6.RESET_B VPWR VPWR sg13_lv_pmos ad=0.2128p pd=1.5u as=0.2128p ps=1.5u w=1.12u l=0.13u
X2210 nh_sw[3] a_5704_1664# VPWR VPWR sg13_lv_pmos ad=0.42p pd=2.99u as=0.2114p ps=1.54u w=1.12u l=0.13u
X2211 VGND a_9164_1590# sg13cmos5l_buf_1_26.X VGND sg13_lv_nmos ad=0.14875p pd=1.16u as=0.2886p ps=2.26u w=0.74u l=0.13u
X2212 a_17327_7285# a_16485_6935# a_17233_7285# VGND sg13_lv_nmos ad=0.12665p pd=1.145u as=0.1428p ps=1.52u w=0.42u l=0.13u
X2213 VPWR a_15821_3864# sg13cmos5l_dfrbp_1_6.Q_N VPWR sg13_lv_pmos ad=0.2639p pd=1.81u as=0.4312p ps=3.01u w=1.12u l=0.13u
X2214 ph_sw[10] a_20392_6924# VGND VGND sg13_lv_nmos ad=0.2886p pd=2.26u as=0.14875p ps=1.16u w=0.74u l=0.13u
X2215 sg13cmos5l_dfrbp_1_3.Q_N a_18959_3215# VGND VGND sg13_lv_nmos ad=0.2849p pd=2.25u as=0.2516p ps=2.16u w=0.74u l=0.13u
X2216 VPWR a_2757_3117# a_2859_3260# VPWR sg13_lv_pmos ad=1.43437p pd=9.105u as=0.3864p ps=2.93u w=1.12u l=0.13u
X2217 a_11817_2435# a_11460_2392# VPWR VPWR sg13_lv_pmos ad=63f pd=0.72u as=0.1563p ps=1.22u w=0.42u l=0.13u
X2218 VPWR a_17519_6239# a_17776_6382# VPWR sg13_lv_pmos ad=0.2639p pd=1.81u as=79.8f ps=0.8u w=0.42u l=0.13u
X2219 VPWR sg13cmos5l_dfrbp_1_10.Q a_4873_3192# VPWR sg13_lv_pmos ad=1.43437p pd=9.105u as=0.2856p ps=2.36u w=0.84u l=0.13u
X2220 sg13cmos5l_dlhr_1_1.Q a_2409_4650# VPWR VPWR sg13_lv_pmos ad=0.3808p pd=2.92u as=0.2128p ps=1.5u w=1.12u l=0.13u
X2221 VGND a_6959_6239# a_7796_6460# VGND sg13_lv_nmos ad=0.1406p pd=1.12u as=0.2516p ps=2.16u w=0.74u l=0.13u
X2222 VGND a_7504_8678# a_7153_8797# VGND sg13_lv_nmos ad=79.8f pd=0.8u as=0.1428p ps=1.52u w=0.42u l=0.13u
X2223 a_17674_3361# a_18117_3117# a_18057_3529# VPWR sg13_lv_pmos ad=79.8f pd=0.8u as=63f ps=0.72u w=0.42u l=0.13u
X2224 VGND a_2732_9150# sg13cmos5l_buf_1_61.X VGND sg13_lv_nmos ad=0.14875p pd=1.16u as=0.2886p ps=2.26u w=0.74u l=0.13u
X2225 VPWR a_9189_8447# a_9291_8447# VPWR sg13_lv_pmos ad=1.15047p pd=7.175u as=0.3864p ps=2.93u w=1.12u l=0.13u
X2226 VGND a_4005_4629# a_4107_4772# VGND sg13_lv_nmos ad=2.41737p pd=15.64u as=0.2516p ps=2.16u w=0.74u l=0.13u
X2227 VPWR VGND VPWR VPWR sg13_lv_pmos ad=0.34p pd=2.68u as=0 ps=0 w=1u l=1u
X2228 sg13cmos5l_inv_1_29.A a_12404_7972# VPWR VPWR sg13_lv_pmos ad=0.3808p pd=2.92u as=0.2128p ps=1.5u w=1.12u l=0.13u
X2229 VGND sg13cmos5l_dfrbp_1_23.Q a_13792_5760# VGND sg13_lv_nmos ad=0.1406p pd=1.12u as=0.1406p ps=1.12u w=0.74u l=0.13u
X2230 VGND sg13cmos5l_dfrbp_1_6.RESET_B a_18580_7660# VGND sg13_lv_nmos ad=0.1406p pd=1.12u as=77.7f ps=0.95u w=0.74u l=0.13u
X2231 a_17713_8838# a_17161_8794# VGND VGND sg13_lv_nmos ad=71.99999f pd=0.865u as=2.92392p ps=18.89u w=0.64u l=0.13u
X2232 a_15300_7687# a_15012_7992# a_15238_7687# VGND sg13_lv_nmos ad=0.1428p pd=1.52u as=37.8f ps=0.6u w=0.42u l=0.13u
X2233 a_12933_6141# sg13cmos5l_dfrbp_1_23.CLK VGND VGND sg13_lv_nmos ad=0.2516p pd=2.16u as=1.97045p ps=12.335u w=0.74u l=0.13u
X2234 sg13cmos5l_buf_1_79.X a_9256_9224# VPWR VPWR sg13_lv_pmos ad=0.42p pd=2.99u as=0.2114p ps=1.54u w=1.12u l=0.13u
X2235 VGND sg13cmos5l_inv_1_17.A sg13cmos5l_buf_1_37.A VGND sg13_lv_nmos ad=0.2516p pd=2.16u as=0.2516p ps=2.16u w=0.74u l=0.13u
X2236 pl_sw[2] a_2248_9224# VGND VGND sg13_lv_nmos ad=0.2886p pd=2.26u as=0.14875p ps=1.16u w=0.74u l=0.13u
X2237 VPWR a_9040_7894# a_8985_7989# VPWR sg13_lv_pmos ad=1.15047p pd=7.175u as=93.45f ps=0.865u w=0.42u l=0.13u
X2238 sg13cmos5l_buf_1_1.A a_14056_1664# VGND VGND sg13_lv_nmos ad=0.2886p pd=2.26u as=0.14875p ps=1.16u w=0.74u l=0.13u
X2239 VPWR a_5673_3138# a_6198_3120# VPWR sg13_lv_pmos ad=0.1974p pd=1.5u as=0.2856p ps=2.36u w=0.84u l=0.13u
X2240 a_6660_4663# a_6891_4772# a_6346_4873# VGND sg13_lv_nmos ad=0.2373p pd=1.97u as=79.8f ps=0.8u w=0.42u l=0.13u
X2241 a_6681_2511# a_5739_2399# a_6479_2749# VPWR sg13_lv_pmos ad=93.45f pd=0.865u as=0.2048p ps=1.63u w=0.42u l=0.13u
X2242 VPWR a_2732_1590# sg13cmos5l_buf_1_35.A VPWR sg13_lv_pmos ad=0.2114p pd=1.54u as=0.42p ps=2.99u w=1.12u l=0.13u
X2243 sg13cmos5l_buf_8_0.X a_19227_4654# VPWR VPWR sg13_lv_pmos ad=0.2128p pd=1.5u as=0.2128p ps=1.5u w=1.12u l=0.13u
X2244 a_18574_5028# sg13cmos5l_dfrbp_1_0.D a_18480_5028# VPWR sg13_lv_pmos ad=0.1596p pd=1.22u as=0.2856p ps=2.36u w=0.84u l=0.13u
X2245 a_16551_3987# a_16703_3871# VPWR VPWR sg13_lv_pmos ad=0.3864p pd=2.93u as=1.43437p ps=9.105u w=1.12u l=0.13u
X2246 VPWR sg13cmos5l_buf_1_10.A a_12520_3176# VPWR sg13_lv_pmos ad=0.2114p pd=1.54u as=0.2856p ps=2.36u w=0.84u l=0.13u
X2247 VPWR sg13cmos5l_o21ai_1_0.B1 sg13cmos5l_o21ai_1_0.Y VPWR sg13_lv_pmos ad=0.3808p pd=2.92u as=0.2128p ps=1.5u w=1.12u l=0.15u
X2248 VPWR a_16271_7751# a_17108_7972# VPWR sg13_lv_pmos ad=0.2128p pd=1.5u as=0.3864p ps=2.93u w=1.12u l=0.13u
X2249 VPWR a_19244_2352# nl_sw[9] VPWR sg13_lv_pmos ad=0.2114p pd=1.54u as=0.42p ps=2.99u w=1.12u l=0.13u
X2250 VGND a_908_1590# sg13cmos5l_buf_1_32.X VGND sg13_lv_nmos ad=0.14875p pd=1.16u as=0.2886p ps=2.26u w=0.74u l=0.13u
X2251 VGND VPWR VGND VGND sg13_lv_nmos ad=79.8f pd=0.8u as=0 ps=0 w=0.42u l=1u
X2252 a_17780_8436# a_17367_8794# a_17712_8436# VPWR sg13_lv_pmos ad=0.191p pd=1.44u as=0.105p ps=1.21u w=1u l=0.13u
X2253 a_15876_7362# sg13cmos5l_dfrbp_1_22.D a_15782_7362# VGND sg13_lv_nmos ad=60.89999f pd=0.71u as=0.1428p ps=1.52u w=0.42u l=0.13u
X2254 a_17916_8838# a_17367_8794# a_17780_8436# VGND sg13_lv_nmos ad=47.25f pd=0.645u as=0.141p ps=1.17u w=0.42u l=0.13u
X2255 sg13cmos5l_buf_1_93.X a_14632_9224# VPWR VPWR sg13_lv_pmos ad=0.42p pd=2.99u as=0.2114p ps=1.54u w=1.12u l=0.13u
X2256 a_2348_7624# a_2596_7996# a_2554_8112# VPWR sg13_lv_pmos ad=0.191p pd=1.44u as=0.1008p ps=0.9u w=0.42u l=0.13u
X2257 VPWR a_9705_4650# a_9638_5088# VPWR sg13_lv_pmos ad=0.2387p pd=1.84u as=0.1008p ps=0.9u w=0.42u l=0.13u
X2258 VPWR sg13cmos5l_inv_1_8.A a_5951_5383# VPWR sg13_lv_pmos ad=1.2517p pd=7.955u as=0.4088p ps=2.97u w=1.12u l=0.13u
X2259 nl_sw[2] a_2248_1664# VPWR VPWR sg13_lv_pmos ad=0.42p pd=2.99u as=0.2114p ps=1.54u w=1.12u l=0.13u
X2260 sg13cmos5l_or2_1_0.A a_18363_4270# VPWR VPWR sg13_lv_pmos ad=0.2128p pd=1.5u as=0.2128p ps=1.5u w=1.12u l=0.13u
X2261 VGND sg13cmos5l_a221oi_1_0.B2 a_11488_4676# VGND sg13_lv_nmos ad=0.1406p pd=1.12u as=0.1406p ps=1.12u w=0.74u l=0.13u
X2262 VGND sg13cmos5l_a22oi_1_1.B1 a_15062_4292# VGND sg13_lv_nmos ad=0.2553p pd=2.17u as=0.13875p ps=1.115u w=0.74u l=0.13u
X2263 VPWR a_14543_3215# a_14800_3358# VPWR sg13_lv_pmos ad=0.2639p pd=1.81u as=79.8f ps=0.8u w=0.42u l=0.13u
X2264 a_18860_6888# sg13cmos5l_buf_1_87.A VPWR VPWR sg13_lv_pmos ad=0.2856p pd=2.36u as=0.2114p ps=1.54u w=0.84u l=0.13u
X2265 a_11364_1626# sg13cmos5l_dfrbp_1_1.D a_11270_1626# VGND sg13_lv_nmos ad=60.89999f pd=0.71u as=0.1428p ps=1.52u w=0.42u l=0.13u
X2266 VGND a_20012_2352# nl_sw[10] VGND sg13_lv_nmos ad=0.14875p pd=1.16u as=0.2886p ps=2.26u w=0.74u l=0.13u
X2267 a_6086_4650# sg13cmos5l_dlhr_1_0.GATE VPWR VPWR sg13_lv_pmos ad=79.8f pd=0.8u as=0.1428p ps=1.52u w=0.42u l=0.13u
X2268 a_16748_9150# sg13cmos5l_buf_1_93.X VGND VGND sg13_lv_nmos ad=0.187p pd=1.78u as=0.14875p ps=1.16u w=0.55u l=0.13u
X2269 a_5988_8440# a_5962_8404# VGND VGND sg13_lv_nmos ad=0.2516p pd=2.16u as=0.1626p ps=1.415u w=0.74u l=0.13u
X2270 VPWR a_7247_8797# a_7504_8678# VPWR sg13_lv_pmos ad=0.2639p pd=1.81u as=79.8f ps=0.8u w=0.42u l=0.13u
X2271 a_682_5380# a_1125_5423# a_422_5850# VGND sg13_lv_nmos ad=79.8f pd=0.8u as=0.1296p ps=1.52u w=0.42u l=0.13u
X2272 sg13cmos5l_o21ai_1_0.A1 sg13cmos5l_inv_1_0.Y a_11182_4676# VGND sg13_lv_nmos ad=0.2516p pd=2.16u as=0.1406p ps=1.12u w=0.74u l=0.13u
X2273 VPWR sg13cmos5l_dfrbp_1_8.RESET_B a_5962_8404# VPWR sg13_lv_pmos ad=0.1563p pd=1.22u as=0.147p ps=1.54u w=0.42u l=0.13u
X2274 a_14726_7674# a_15531_7796# a_14986_7897# VPWR sg13_lv_pmos ad=0.1428p pd=1.52u as=79.8f ps=0.8u w=0.42u l=0.13u
X2275 sg13cmos5l_buf_1_57.X a_9448_6924# VGND VGND sg13_lv_nmos ad=0.2886p pd=2.26u as=0.14875p ps=1.16u w=0.74u l=0.13u
X2276 a_8852_6484# a_8439_6178# a_8784_6484# VPWR sg13_lv_pmos ad=0.191p pd=1.44u as=0.105p ps=1.21u w=1u l=0.13u
X2277 a_4176_6924# a_3625_7282# VPWR VPWR sg13_lv_pmos ad=0.105p pd=1.21u as=1.07253p ps=6.75u w=1u l=0.13u
X2278 a_13092_3138# sg13cmos5l_o21ai_1_0.Y a_12998_3138# VGND sg13_lv_nmos ad=60.89999f pd=0.71u as=0.1428p ps=1.52u w=0.42u l=0.13u
X2279 a_16462_4338# a_16204_4338# VGND VGND sg13_lv_nmos ad=0.1428p pd=1.52u as=79.8f ps=0.8u w=0.42u l=0.13u
X2280 VPWR sg13cmos5l_dlhr_1_12.D a_17161_8794# VPWR sg13_lv_pmos ad=1.15047p pd=7.175u as=0.2856p ps=2.36u w=0.84u l=0.13u
X2281 cko a_20392_7712# VGND VGND sg13_lv_nmos ad=0.2886p pd=2.26u as=0.14875p ps=1.16u w=0.74u l=0.13u
X2282 a_15821_3864# a_16551_3987# a_16462_4023# VPWR sg13_lv_pmos ad=0.2048p pd=1.63u as=93.45f ps=0.865u w=0.42u l=0.13u
X2283 VGND a_19227_4654# sg13cmos5l_buf_8_0.X VGND sg13_lv_nmos ad=0.1406p pd=1.12u as=0.1406p ps=1.12u w=0.74u l=0.13u
X2284 sg13cmos5l_buf_8_2.X a_19227_9190# VGND VGND sg13_lv_nmos ad=0.1406p pd=1.12u as=0.1406p ps=1.12u w=0.74u l=0.13u
X2285 sg13cmos5l_dlhr_1_0.Q_N a_8214_1608# VGND VGND sg13_lv_nmos ad=0.2516p pd=2.16u as=0.1491p ps=1.18u w=0.74u l=0.13u
X2286 a_8783_7751# a_7941_7653# a_8689_7751# VGND sg13_lv_nmos ad=0.12665p pd=1.145u as=0.1428p ps=1.52u w=0.42u l=0.13u
X2287 VPWR sg13cmos5l_dfrbp_1_8.RESET_B a_1862_4338# VPWR sg13_lv_pmos ad=0.36237p pd=2.605u as=79.8f ps=0.8u w=0.42u l=0.13u
X2288 VPWR a_6959_6239# a_7216_6382# VPWR sg13_lv_pmos ad=0.2639p pd=1.81u as=79.8f ps=0.8u w=0.42u l=0.13u
X2289 a_16294_7349# sg13cmos5l_dfrbp_1_8.RESET_B VGND VGND sg13_lv_nmos ad=37.8f pd=0.6u as=0.1701p ps=1.65u w=0.42u l=0.13u
X2290 a_12516_6480# a_13035_6284# a_13775_6239# VGND sg13_lv_nmos ad=0.3473p pd=2.71u as=0.12665p ps=1.145u w=0.74u l=0.13u
X2291 a_16528_7894# sg13cmos5l_dfrbp_1_6.RESET_B VPWR VPWR sg13_lv_pmos ad=79.8f pd=0.8u as=1.12242p ps=7u w=0.42u l=0.13u
X2292 a_8692_7312# a_8276_6924# a_8457_7281# VGND sg13_lv_nmos ad=77.7f pd=0.95u as=0.2516p ps=2.16u w=0.74u l=0.13u
X2293 a_8588_2352# sg13cmos5l_buf_1_26.X VGND VGND sg13_lv_nmos ad=0.187p pd=1.78u as=0.14875p ps=1.16u w=0.55u l=0.13u
X2294 VGND a_11973_3911# a_12075_3911# VGND sg13_lv_nmos ad=2.41737p pd=15.64u as=0.2516p ps=2.16u w=0.74u l=0.13u
X2295 VGND a_13047_7690# a_13178_7684# VGND sg13_lv_nmos ad=1.49685p pd=9.6u as=0.2775p ps=2.23u w=0.74u l=0.13u
X2296 a_11370_5760# sg13cmos5l_inv_1_0.A a_11268_5760# VGND sg13_lv_nmos ad=0.1216p pd=1.02u as=0.1216p ps=1.02u w=0.64u l=0.13u
X2297 a_5637_2399# sg13cmos5l_dlhr_1_0.GATE VPWR VPWR sg13_lv_pmos ad=0.4088p pd=2.97u as=1.777p ps=11.395u w=1.12u l=0.13u
X2298 sg13cmos5l_dfrbp_1_2.Q_N a_12815_4261# VPWR VPWR sg13_lv_pmos ad=0.4312p pd=3.01u as=0.2639p ps=1.81u w=1.12u l=0.13u
X2299 a_13486_5760# sg13cmos5l_nor2b_1_0.Y VGND VGND sg13_lv_nmos ad=0.1406p pd=1.12u as=0.2516p ps=2.16u w=0.74u l=0.13u
X2300 a_17170_2826# sg13cmos5l_dfrbp_1_0.RESET_B VGND VGND sg13_lv_nmos ad=37.8f pd=0.6u as=79.8f ps=0.8u w=0.42u l=0.13u
X2301 VGND sg13cmos5l_dfrbp_1_20.Q a_9865_7282# VGND sg13_lv_nmos ad=0.15055p pd=1.17u as=0.187p ps=1.78u w=0.55u l=0.13u
X2302 VPWR a_14924_1590# nh_sw[6] VPWR sg13_lv_pmos ad=0.2114p pd=1.54u as=0.42p ps=2.99u w=1.12u l=0.13u
X2303 a_10318_5412# sg13cmos5l_a221oi_1_0.C1 a_10420_5412# VPWR sg13_lv_pmos ad=0.3808p pd=2.92u as=0.2128p ps=1.5u w=1.12u l=0.13u
X2304 sg13cmos5l_inv_1_5.A a_19796_3436# VGND VGND sg13_lv_nmos ad=0.2516p pd=2.16u as=0.1406p ps=1.12u w=0.74u l=0.13u
X2305 sg13cmos5l_dfrbp_1_27.Q_N a_10031_8797# VGND VGND sg13_lv_nmos ad=0.2849p pd=2.25u as=0.2516p ps=2.16u w=0.74u l=0.13u
X2306 a_5079_3154# sg13cmos5l_dfrbp_1_9.Q VGND VGND sg13_lv_nmos ad=0.2516p pd=2.16u as=0.15055p ps=1.17u w=0.74u l=0.13u
X2307 a_17399_3947# sg13cmos5l_dfrbp_1_6.RESET_B VPWR VPWR sg13_lv_pmos ad=79.8f pd=0.8u as=0.36237p ps=2.605u w=0.42u l=0.13u
X2308 sg13cmos5l_dfrbp_1_11.Q_N a_7631_4727# VPWR VPWR sg13_lv_pmos ad=0.4312p pd=3.01u as=0.2639p ps=1.81u w=1.12u l=0.13u
X2309 a_15045_8447# sg13cmos5l_inv_1_2.A VPWR VPWR sg13_lv_pmos ad=0.4088p pd=2.97u as=1.12242p ps=7u w=1.12u l=0.13u
X2310 VGND a_14583_5770# a_14714_5776# VGND sg13_lv_nmos ad=1.97045p pd=12.335u as=0.2775p ps=2.23u w=0.74u l=0.13u
X2311 a_4950_5699# a_5069_5376# VGND VGND sg13_lv_nmos ad=0.2516p pd=2.16u as=0.1406p ps=1.12u w=0.74u l=0.13u
X2312 VPWR a_19227_9190# sg13cmos5l_buf_8_2.X VPWR sg13_lv_pmos ad=0.3864p pd=2.93u as=0.2128p ps=1.5u w=1.12u l=0.13u
X2313 sg13cmos5l_dlhr_1_20.Q_N a_10230_4632# VPWR VPWR sg13_lv_pmos ad=0.3808p pd=2.92u as=0.1974p ps=1.5u w=1.12u l=0.13u
X2314 VGND sg13cmos5l_inv_1_6.A sg13cmos5l_buf_1_0.A VGND sg13_lv_nmos ad=0.2516p pd=2.16u as=0.2516p ps=2.16u w=0.74u l=0.13u
X2315 VPWR a_16144_8678# a_16089_8559# VPWR sg13_lv_pmos ad=1.15047p pd=7.175u as=93.45f ps=0.865u w=0.42u l=0.13u
X2316 sg13cmos5l_buf_1_5.X a_14440_1664# VPWR VPWR sg13_lv_pmos ad=0.42p pd=2.99u as=0.2114p ps=1.54u w=1.12u l=0.13u
X2317 a_14854_8861# sg13cmos5l_dfrbp_1_8.RESET_B VGND VGND sg13_lv_nmos ad=37.8f pd=0.6u as=0.1701p ps=1.65u w=0.42u l=0.13u
X2318 VPWR sg13cmos5l_buf_1_30.A sg13cmos5l_buf_1_73.A VPWR sg13_lv_pmos ad=0.3808p pd=2.92u as=0.3808p ps=2.92u w=1.12u l=0.13u
X2319 a_2169_5535# a_1227_5423# a_1967_5773# VPWR sg13_lv_pmos ad=93.45f pd=0.865u as=0.2048p ps=1.63u w=0.42u l=0.13u
X2320 sg13cmos5l_dlhr_1_21.Q_N a_10998_9168# VGND VGND sg13_lv_nmos ad=0.2516p pd=2.16u as=0.1491p ps=1.18u w=0.74u l=0.13u
X2321 VPWR sg13cmos5l_buf_1_73.X a_5800_9224# VPWR sg13_lv_pmos ad=0.2114p pd=1.54u as=0.2856p ps=2.36u w=0.84u l=0.13u
X2322 VPWR sg13cmos5l_dfrbp_1_23.Q_N a_14377_5770# VPWR sg13_lv_pmos ad=1.28962p pd=8.195u as=0.2856p ps=2.36u w=0.84u l=0.13u
X2323 VGND sg13cmos5l_dfrbp_1_6.RESET_B a_516_7362# VGND sg13_lv_nmos ad=0.1626p pd=1.415u as=60.89999f ps=0.71u w=0.42u l=0.13u
X2324 a_17829_1605# sg13cmos5l_dfrbp_1_0.CLK VGND VGND sg13_lv_nmos ad=0.2516p pd=2.16u as=5.84582p ps=38.34u w=0.74u l=0.13u
X2325 VGND a_7216_6382# a_6865_6239# VGND sg13_lv_nmos ad=79.8f pd=0.8u as=0.1428p ps=1.52u w=0.42u l=0.13u
X2326 VGND sg13cmos5l_buf_8_0.A a_19227_4654# VGND sg13_lv_nmos ad=0.1406p pd=1.12u as=0.1406p ps=1.12u w=0.74u l=0.13u
X2327 VPWR sg13cmos5l_dfrbp_1_8.RESET_B a_5702_8874# VPWR sg13_lv_pmos ad=0.36237p pd=2.605u as=79.8f ps=0.8u w=0.42u l=0.13u
X2328 a_12804_6175# a_13035_6284# a_12490_6385# VGND sg13_lv_nmos ad=0.2373p pd=1.97u as=79.8f ps=0.8u w=0.42u l=0.13u
X2329 a_18860_9150# sg13cmos5l_buf_1_101.X VGND VGND sg13_lv_nmos ad=0.187p pd=1.78u as=0.14875p ps=1.16u w=0.55u l=0.13u
X2330 VGND a_19209_5769# a_19164_5814# VGND sg13_lv_nmos ad=0.1428p pd=1.52u as=47.25f ps=0.645u w=0.42u l=0.13u
X2331 a_11873_5760# sg13cmos5l_inv_1_29.Y sg13cmos5l_a221oi_1_0.B2 VGND sg13_lv_nmos ad=0.1406p pd=1.12u as=0.1406p ps=1.12u w=0.74u l=0.13u
X2332 VGND sg13cmos5l_nand2_1_1.A a_20008_3900# VGND sg13_lv_nmos ad=0.14875p pd=1.16u as=0.187p ps=1.78u w=0.55u l=0.13u
X2333 a_11980_4948# sg13cmos5l_inv_1_0.A sg13cmos5l_a221oi_1_0.C1 VPWR sg13_lv_pmos ad=0.1176p pd=1.33u as=0.3808p ps=2.92u w=1.12u l=0.13u
X2334 VPWR a_8841_5769# a_9366_5842# VPWR sg13_lv_pmos ad=0.1974p pd=1.5u as=0.2856p ps=2.36u w=0.84u l=0.13u
X2335 VGND a_7497_3138# a_7452_3174# VGND sg13_lv_nmos ad=0.1428p pd=1.52u as=47.25f ps=0.645u w=0.42u l=0.13u
X2336 VGND VPWR VGND VGND sg13_lv_nmos ad=79.8f pd=0.8u as=0 ps=0 w=0.42u l=1u
X2337 sg13cmos5l_buf_1_97.A a_10473_9186# VPWR VPWR sg13_lv_pmos ad=0.3808p pd=2.92u as=0.2128p ps=1.5u w=1.12u l=0.13u
X2338 VPWR a_11877_2399# a_11979_2399# VPWR sg13_lv_pmos ad=1.86162p pd=11.935u as=0.3864p ps=2.93u w=1.12u l=0.13u
X2339 VPWR sg13cmos5l_dlygate4sd2_1_0.A a_902_3142# VPWR sg13_lv_pmos ad=0.2481p pd=1.56u as=0.1428p ps=1.52u w=0.42u l=0.13u
X2340 VGND a_7247_8797# a_8084_8436# VGND sg13_lv_nmos ad=0.1406p pd=1.12u as=0.2516p ps=2.16u w=0.74u l=0.13u
X2341 sg13cmos5l_o21ai_1_0.A2 sg13cmos5l_nand2_1_0.A a_11002_3142# VGND sg13_lv_nmos ad=0.2516p pd=2.16u as=0.1406p ps=1.12u w=0.74u l=0.13u
X2342 a_16260_6480# a_16234_6385# VGND VGND sg13_lv_nmos ad=0.2516p pd=2.16u as=0.1626p ps=1.415u w=0.74u l=0.13u
X2343 a_3876_4663# a_4107_4772# a_3562_4873# VGND sg13_lv_nmos ad=0.2373p pd=1.97u as=79.8f ps=0.8u w=0.42u l=0.13u
X2344 VGND sg13cmos5l_dfrbp_1_8.RESET_B a_3396_4650# VGND sg13_lv_nmos ad=0.1626p pd=1.415u as=60.89999f ps=0.71u w=0.42u l=0.13u
X2345 a_11913_2017# a_11556_1944# VPWR VPWR sg13_lv_pmos ad=63f pd=0.72u as=0.1563p ps=1.22u w=0.42u l=0.13u
X2346 a_4076_5376# sg13cmos5l_dlhr_1_9.Q VGND VGND sg13_lv_nmos ad=0.187p pd=1.78u as=0.14875p ps=1.16u w=0.55u l=0.13u
X2347 VGND a_6789_4629# a_6891_4772# VGND sg13_lv_nmos ad=2.41737p pd=15.64u as=0.2516p ps=2.16u w=0.74u l=0.13u
X2348 VGND a_7689_1626# a_8214_1608# VGND sg13_lv_nmos ad=0.1491p pd=1.18u as=0.187p ps=1.78u w=0.55u l=0.13u
X2349 sg13cmos5l_buf_8_0.X a_19227_4654# VPWR VPWR sg13_lv_pmos ad=0.2128p pd=1.5u as=0.2128p ps=1.5u w=1.12u l=0.13u
X2350 a_9111_4666# sg13cmos5l_dfrbp_1_11.Q VGND VGND sg13_lv_nmos ad=0.2516p pd=2.16u as=0.15055p ps=1.17u w=0.74u l=0.13u
X2351 sg13cmos5l_dfrbp_1_15.D a_4244_8436# VPWR VPWR sg13_lv_pmos ad=0.3808p pd=2.92u as=0.2128p ps=1.5u w=1.12u l=0.13u
X2352 a_17412_1944# a_17931_1748# a_18671_1703# VGND sg13_lv_nmos ad=0.3473p pd=2.71u as=0.12665p ps=1.145u w=0.74u l=0.13u
X2353 d_out[2] a_20392_3900# VPWR VPWR sg13_lv_pmos ad=0.42p pd=2.99u as=0.2114p ps=1.54u w=1.12u l=0.13u
X2354 sg13cmos5l_nand2_1_0.B a_10587_4692# a_10789_4654# VGND sg13_lv_nmos ad=0.333p pd=2.38u as=0.1406p ps=1.12u w=0.74u l=0.13u
X2355 VGND cks sg13cmos5l_dfrbp_1_0.RESET_B VGND sg13_lv_nmos ad=0.2516p pd=2.16u as=0.2516p ps=2.16u w=0.74u l=0.13u
X2356 a_1815_4666# sg13cmos5l_dlhr_1_1.GATE VGND VGND sg13_lv_nmos ad=0.2516p pd=2.16u as=0.15055p ps=1.17u w=0.74u l=0.13u
X2357 a_17829_1605# sg13cmos5l_dfrbp_1_0.CLK VPWR VPWR sg13_lv_pmos ad=0.4088p pd=2.97u as=1.777p ps=11.395u w=1.12u l=0.13u
X2358 a_8592_5412# a_8041_5770# VPWR VPWR sg13_lv_pmos ad=0.105p pd=1.21u as=1.28962p ps=8.195u w=1u l=0.13u
X2359 a_9879_9202# sg13cmos5l_dfrbp_1_18.Q VGND VGND sg13_lv_nmos ad=0.2516p pd=2.16u as=0.15055p ps=1.17u w=0.74u l=0.13u
X2360 a_12132_9504# a_12651_9308# a_13391_9263# VGND sg13_lv_nmos ad=0.3473p pd=2.71u as=0.12665p ps=1.145u w=0.74u l=0.13u
X2361 VPWR sg13cmos5l_buf_1_3.X a_20392_3176# VPWR sg13_lv_pmos ad=0.2114p pd=1.54u as=0.2856p ps=2.36u w=0.84u l=0.13u
X2362 a_10028_6126# sg13cmos5l_buf_1_56.A VPWR VPWR sg13_lv_pmos ad=0.2856p pd=2.36u as=0.2114p ps=1.54u w=0.84u l=0.13u
X2363 VGND VPWR VGND VGND sg13_lv_nmos ad=0.1428p pd=1.52u as=0 ps=0 w=0.42u l=1u
X2364 a_4018_3138# sg13cmos5l_dfrbp_1_6.RESET_B VGND VGND sg13_lv_nmos ad=37.8f pd=0.6u as=79.8f ps=0.8u w=0.42u l=0.13u
X2365 VGND a_8204_9150# sg13cmos5l_buf_1_74.X VGND sg13_lv_nmos ad=0.14875p pd=1.16u as=0.2886p ps=2.26u w=0.74u l=0.13u
X2366 a_1662_8374# a_1463_8511# VGND VGND sg13_lv_nmos ad=0.27427p pd=2.28u as=2.92392p ps=18.89u w=0.795u l=0.13u
X2367 sg13cmos5l_buf_1_4.X a_16552_1664# VPWR VPWR sg13_lv_pmos ad=0.42p pd=2.99u as=0.2114p ps=1.54u w=1.12u l=0.13u
X2368 VGND VPWR VGND VGND sg13_lv_nmos ad=79.8f pd=0.8u as=0 ps=0 w=0.42u l=1u
X2369 a_12549_9165# sg13cmos5l_inv_1_2.A VPWR VPWR sg13_lv_pmos ad=0.4088p pd=2.97u as=4.11675p ps=27.17u w=1.12u l=0.13u
X2370 VPWR a_2224_7166# a_2169_7047# VPWR sg13_lv_pmos ad=1.07253p pd=6.75u as=93.45f ps=0.865u w=0.42u l=0.13u
X2371 VGND a_4559_7630# a_4514_7666# VGND sg13_lv_nmos ad=1.49685p pd=9.6u as=71.99999f ps=0.865u w=0.64u l=0.13u
X2372 VGND sg13cmos5l_dfrbp_1_1.Q a_20392_2388# VGND sg13_lv_nmos ad=0.14875p pd=1.16u as=0.187p ps=1.78u w=0.55u l=0.13u
X2373 a_11824_7894# a_11567_7751# a_11986_7674# VGND sg13_lv_nmos ad=0.1428p pd=1.52u as=37.8f ps=0.6u w=0.42u l=0.13u
X2374 VPWR a_5079_3154# a_5210_3148# VPWR sg13_lv_pmos ad=1.43437p pd=9.105u as=0.2856p ps=2.36u w=0.84u l=0.13u
X2375 a_6572_1590# sg13cmos5l_buf_1_24.A VGND VGND sg13_lv_nmos ad=0.187p pd=1.78u as=0.14875p ps=1.16u w=0.55u l=0.13u
X2376 sg13cmos5l_buf_8_2.X a_19227_9190# VGND VGND sg13_lv_nmos ad=0.1406p pd=1.12u as=0.1406p ps=1.12u w=0.74u l=0.13u
X2377 VGND a_15177_5769# a_15132_5814# VGND sg13_lv_nmos ad=0.1428p pd=1.52u as=47.25f ps=0.645u w=0.42u l=0.13u
X2378 a_14436_8874# sg13cmos5l_dfrbp_1_23.CLK a_14342_8874# VGND sg13_lv_nmos ad=60.89999f pd=0.71u as=0.1428p ps=1.52u w=0.42u l=0.13u
X2379 VPWR VGND VPWR VPWR sg13_lv_pmos ad=0.34p pd=2.68u as=0 ps=0 w=1u l=1u
X2380 sg13cmos5l_dlhr_1_7.Q_N a_4950_7354# VGND VGND sg13_lv_nmos ad=0.2516p pd=2.16u as=0.1491p ps=1.18u w=0.74u l=0.13u
X2381 sg13cmos5l_buf_1_34.A a_4041_2745# VGND VGND sg13_lv_nmos ad=0.2516p pd=2.16u as=0.1406p ps=1.12u w=0.74u l=0.13u
X2382 VPWR sg13cmos5l_dfrbp_1_0.RESET_B a_17674_3361# VPWR sg13_lv_pmos ad=0.1563p pd=1.22u as=0.147p ps=1.54u w=0.42u l=0.13u
X2383 a_11174_2826# a_11979_2399# a_11434_2356# VPWR sg13_lv_pmos ad=0.1428p pd=1.52u as=79.8f ps=0.8u w=0.42u l=0.13u
X2384 VPWR sg13cmos5l_dfrbp_1_6.RESET_B a_7497_3138# VPWR sg13_lv_pmos ad=0.2128p pd=1.5u as=0.2128p ps=1.5u w=1.12u l=0.13u
X2385 VGND a_10473_9186# a_10998_9168# VGND sg13_lv_nmos ad=0.1491p pd=1.18u as=0.187p ps=1.78u w=0.55u l=0.13u
X2386 a_15300_2826# sg13cmos5l_nor2b_1_1.Y a_15206_2826# VGND sg13_lv_nmos ad=60.89999f pd=0.71u as=0.1428p ps=1.52u w=0.42u l=0.13u
X2387 a_19378_3138# sg13cmos5l_dfrbp_1_0.RESET_B VGND VGND sg13_lv_nmos ad=37.8f pd=0.6u as=79.8f ps=0.8u w=0.42u l=0.13u
X2388 a_8972_3864# sg13cmos5l_buf_1_45.A VGND VGND sg13_lv_nmos ad=0.187p pd=1.78u as=0.14875p ps=1.16u w=0.55u l=0.13u
X2389 a_8247_5770# sg13cmos5l_dfrbp_1_11.Q VPWR VPWR sg13_lv_pmos ad=0.3234p pd=2.45u as=1.2517p ps=7.955u w=0.84u l=0.13u
X2390 a_5700_6480# a_5674_6385# VGND VGND sg13_lv_nmos ad=0.2516p pd=2.16u as=0.1626p ps=1.415u w=0.74u l=0.13u
X2391 VGND sg13cmos5l_dlhr_1_10.Q a_19528_6924# VGND sg13_lv_nmos ad=0.14875p pd=1.16u as=0.187p ps=1.78u w=0.55u l=0.13u
X2392 VGND sg13cmos5l_buf_1_97.A a_11848_8436# VGND sg13_lv_nmos ad=0.14875p pd=1.16u as=0.187p ps=1.78u w=0.55u l=0.13u
X2393 a_11686_2813# sg13cmos5l_dfrbp_1_0.RESET_B VGND VGND sg13_lv_nmos ad=37.8f pd=0.6u as=0.1701p ps=1.65u w=0.42u l=0.13u
X2394 VPWR sg13cmos5l_dfrbp_1_20.Q a_9865_7282# VPWR sg13_lv_pmos ad=1.07253p pd=6.75u as=0.2856p ps=2.36u w=0.84u l=0.13u
X2395 a_19628_2352# sg13cmos5l_buf_1_19.X VPWR VPWR sg13_lv_pmos ad=0.2856p pd=2.36u as=0.2114p ps=1.54u w=0.84u l=0.13u
X2396 VPWR a_6188_1590# sg13cmos5l_buf_1_25.X VPWR sg13_lv_pmos ad=0.2114p pd=1.54u as=0.42p ps=2.99u w=1.12u l=0.13u
X2397 VPWR a_1006_4167# sg13cmos5l_dlygate4sd3_1_0.X VPWR sg13_lv_pmos ad=0.2254p pd=1.53u as=0.4256p ps=3u w=1.12u l=0.13u
X2398 a_620_7638# sg13cmos5l_buf_1_63.X VGND VGND sg13_lv_nmos ad=0.187p pd=1.78u as=0.14875p ps=1.16u w=0.55u l=0.13u
X2399 VGND a_5324_1590# sg13cmos5l_buf_1_39.A VGND sg13_lv_nmos ad=0.14875p pd=1.16u as=0.2886p ps=2.26u w=0.74u l=0.13u
X2400 a_5710_5850# a_5951_5383# a_5069_5376# VGND sg13_lv_nmos ad=0.1428p pd=1.52u as=0.12665p ps=1.145u w=0.42u l=0.13u
X2401 sg13cmos5l_dfrbp_1_6.RESET_B cks VGND VGND sg13_lv_nmos ad=0.1406p pd=1.12u as=0.1406p ps=1.12u w=0.74u l=0.13u
X2402 VPWR a_1878_6337# sg13cmos5l_dlhr_1_1.GATE VPWR sg13_lv_pmos ad=0.2128p pd=1.5u as=0.3808p ps=2.92u w=1.12u l=0.13u
X2403 sg13cmos5l_buf_1_18.X a_18376_2388# VPWR VPWR sg13_lv_pmos ad=0.42p pd=2.99u as=0.2114p ps=1.54u w=1.12u l=0.13u
X2404 VPWR a_7052_9150# sg13cmos5l_buf_1_76.X VPWR sg13_lv_pmos ad=0.2114p pd=1.54u as=0.42p ps=2.99u w=1.12u l=0.13u
X2405 a_8852_6484# a_8570_6172# a_8785_6154# VGND sg13_lv_nmos ad=0.141p pd=1.17u as=71.99999f ps=0.865u w=0.64u l=0.13u
X2406 sg13cmos5l_buf_1_26.A sg13cmos5l_buf_1_45.X VGND VGND sg13_lv_nmos ad=0.2516p pd=2.16u as=0.2516p ps=2.16u w=0.74u l=0.13u
X2407 a_13775_6239# a_12933_6141# a_13681_6239# VGND sg13_lv_nmos ad=0.12665p pd=1.145u as=0.1428p ps=1.52u w=0.42u l=0.13u
X2408 VPWR sg13cmos5l_dfrbp_1_0.RESET_B a_12998_3138# VPWR sg13_lv_pmos ad=0.36237p pd=2.605u as=79.8f ps=0.8u w=0.42u l=0.13u
X2409 VGND a_6213_3911# a_6315_3911# VGND sg13_lv_nmos ad=2.41737p pd=15.64u as=0.2516p ps=2.16u w=0.74u l=0.13u
X2410 a_2364_4686# a_1815_4666# a_2228_4972# VGND sg13_lv_nmos ad=47.25f pd=0.645u as=0.141p ps=1.17u w=0.42u l=0.13u
X2411 a_6276_8861# a_6507_8447# a_5962_8404# VGND sg13_lv_nmos ad=0.2373p pd=1.97u as=79.8f ps=0.8u w=0.42u l=0.13u
X2412 VGND sg13cmos5l_dfrbp_1_6.RESET_B a_18196_8824# VGND sg13_lv_nmos ad=0.1406p pd=1.12u as=77.7f ps=0.95u w=0.74u l=0.13u
X2413 VPWR a_19227_9190# sg13cmos5l_buf_8_2.X VPWR sg13_lv_pmos ad=0.2128p pd=1.5u as=0.2128p ps=1.5u w=1.12u l=0.13u
X2414 sg13cmos5l_dlhr_1_12.Q_N a_18486_8866# VPWR VPWR sg13_lv_pmos ad=0.3808p pd=2.92u as=0.1974p ps=1.5u w=1.12u l=0.13u
X2415 sg13cmos5l_buf_1_34.X a_4840_1664# VGND VGND sg13_lv_nmos ad=0.2886p pd=2.26u as=0.14875p ps=1.16u w=0.74u l=0.13u
X2416 sg13cmos5l_buf_1_34.A a_4041_2745# VPWR VPWR sg13_lv_pmos ad=0.3808p pd=2.92u as=0.2128p ps=1.5u w=1.12u l=0.13u
X2417 VPWR VGND VPWR VPWR sg13_lv_pmos ad=0.34p pd=2.68u as=0 ps=0 w=1u l=1u
X2418 a_4518_7996# a_4349_7636# a_4076_7624# VPWR sg13_lv_pmos ad=0.105p pd=1.21u as=0.191p ps=1.44u w=1u l=0.13u
X2419 VGND sg13cmos5l_dfrbp_1_15.D a_2621_7636# VGND sg13_lv_nmos ad=0.15055p pd=1.17u as=0.2516p ps=2.16u w=0.74u l=0.13u
X2420 a_12998_3138# a_13803_3260# a_13258_3361# VPWR sg13_lv_pmos ad=0.1428p pd=1.52u as=79.8f ps=0.8u w=0.42u l=0.13u
X2421 a_6903_3154# sg13cmos5l_dlhr_1_0.GATE VPWR VPWR sg13_lv_pmos ad=0.3234p pd=2.45u as=1.43437p ps=9.105u w=0.84u l=0.13u
X2422 a_14814_3876# sg13cmos5l_nand2_1_1.B VPWR VPWR sg13_lv_pmos ad=0.2744p pd=1.61u as=0.3808p ps=2.92u w=1.12u l=0.13u
X2423 a_996_7349# a_708_6928# a_934_7349# VGND sg13_lv_nmos ad=0.1428p pd=1.52u as=37.8f ps=0.6u w=0.42u l=0.13u
X2424 VPWR cks sg13cmos5l_dfrbp_1_6.RESET_B VPWR sg13_lv_pmos ad=0.2128p pd=1.5u as=0.2128p ps=1.5u w=1.12u l=0.13u
X2425 VGND VPWR VGND VGND sg13_lv_nmos ad=79.8f pd=0.8u as=0 ps=0 w=0.42u l=1u
X2426 a_13775_6239# a_12933_6141# a_12516_6480# VPWR sg13_lv_pmos ad=0.2048p pd=1.63u as=0.34p ps=2.68u w=1u l=0.13u
X2427 VPWR a_2831_7630# a_2790_7996# VPWR sg13_lv_pmos ad=1.15047p pd=7.175u as=0.105p ps=1.21u w=1u l=0.13u
X2428 a_2505_3947# a_2148_3904# VPWR VPWR sg13_lv_pmos ad=63f pd=0.72u as=0.1563p ps=1.22u w=0.42u l=0.13u
X2429 a_16293_4629# sg13cmos5l_inv_1_2.A VPWR VPWR sg13_lv_pmos ad=0.4088p pd=2.97u as=1.28962p ps=8.195u w=1.12u l=0.13u
X2430 VGND sg13cmos5l_nor2_1_0.A a_10613_2758# VGND sg13_lv_nmos ad=0.1898p pd=1.36u as=0.2516p ps=2.16u w=0.74u l=0.13u
X2431 sg13cmos5l_buf_1_30.X a_8680_1664# VPWR VPWR sg13_lv_pmos ad=0.42p pd=2.99u as=0.2114p ps=1.54u w=1.12u l=0.13u
X2432 VPWR cks a_19227_9190# VPWR sg13_lv_pmos ad=0.2128p pd=1.5u as=0.3808p ps=2.92u w=1.12u l=0.13u
X2433 a_10412_6126# sg13cmos5l_dlhr_1_5.Q VGND VGND sg13_lv_nmos ad=0.187p pd=1.78u as=0.14875p ps=1.16u w=0.55u l=0.13u
X2434 a_11174_2826# sg13cmos5l_dfrbp_1_4.D VPWR VPWR sg13_lv_pmos ad=79.8f pd=0.8u as=0.1428p ps=1.52u w=0.42u l=0.13u
X2435 VGND a_13775_6239# a_14612_6460# VGND sg13_lv_nmos ad=0.1406p pd=1.12u as=0.2516p ps=2.16u w=0.74u l=0.13u
X2436 a_2148_8440# a_2122_8404# VPWR VPWR sg13_lv_pmos ad=0.34p pd=2.68u as=0.36237p ps=2.605u w=1u l=0.13u
X2437 VPWR a_4172_1590# sg13cmos5l_buf_1_33.A VPWR sg13_lv_pmos ad=0.2114p pd=1.54u as=0.42p ps=2.99u w=1.12u l=0.13u
X2438 a_7449_8559# a_6507_8447# a_7247_8797# VPWR sg13_lv_pmos ad=93.45f pd=0.865u as=0.2048p ps=1.63u w=0.42u l=0.13u
X2439 a_11769_7989# a_10827_7796# a_11567_7751# VPWR sg13_lv_pmos ad=93.45f pd=0.865u as=0.2048p ps=1.63u w=0.42u l=0.13u
X2440 sg13cmos5l_buf_1_3.X a_20296_1664# VPWR VPWR sg13_lv_pmos ad=0.42p pd=2.99u as=0.2114p ps=1.54u w=1.12u l=0.13u
X2441 a_10220_3102# sg13cmos5l_buf_1_28.X VGND VGND sg13_lv_nmos ad=0.187p pd=1.78u as=0.14875p ps=1.16u w=0.55u l=0.13u
X2442 nl_sw[6] a_11656_3176# VPWR VPWR sg13_lv_pmos ad=0.42p pd=2.99u as=0.2114p ps=1.54u w=1.12u l=0.13u
X2443 sg13cmos5l_buf_1_96.A a_10665_7281# VPWR VPWR sg13_lv_pmos ad=0.3808p pd=2.92u as=0.2128p ps=1.5u w=1.12u l=0.13u
X2444 a_14641_7326# a_14089_7282# VGND VGND sg13_lv_nmos ad=71.99999f pd=0.865u as=1.49685p ps=9.6u w=0.64u l=0.13u
X2445 a_7052_9150# sg13cmos5l_inv_1_14.A VPWR VPWR sg13_lv_pmos ad=0.2856p pd=2.36u as=0.2114p ps=1.54u w=0.84u l=0.13u
X2446 VPWR a_3407_8797# a_3664_8678# VPWR sg13_lv_pmos ad=0.2639p pd=1.81u as=79.8f ps=0.8u w=0.42u l=0.13u
X2447 a_16204_4338# a_15821_3864# VPWR VPWR sg13_lv_pmos ad=79.8f pd=0.8u as=0.2639p ps=1.81u w=0.42u l=0.13u
X2448 VPWR sg13cmos5l_dfrbp_1_8.RESET_B a_2122_8404# VPWR sg13_lv_pmos ad=0.1563p pd=1.22u as=0.147p ps=1.54u w=0.42u l=0.13u
X2449 a_6380_7638# sg13cmos5l_buf_1_78.X VGND VGND sg13_lv_nmos ad=0.187p pd=1.78u as=0.14875p ps=1.16u w=0.55u l=0.13u
X2450 a_14900_2352# sg13cmos5l_nor2_1_1.A VGND VGND sg13_lv_nmos ad=0.187p pd=1.78u as=0.17255p ps=1.25u w=0.55u l=0.13u
X2451 a_7161_6477# a_6219_6284# a_6959_6239# VPWR sg13_lv_pmos ad=93.45f pd=0.865u as=0.2048p ps=1.63u w=0.42u l=0.13u
X2452 sg13cmos5l_dlhr_1_15.Q_N a_18870_7656# VGND VGND sg13_lv_nmos ad=0.2516p pd=2.16u as=0.1491p ps=1.18u w=0.74u l=0.13u
X2453 a_15780_2813# a_16011_2399# a_15466_2356# VGND sg13_lv_nmos ad=0.2373p pd=1.97u as=79.8f ps=0.8u w=0.42u l=0.13u
X2454 a_5710_5535# a_5452_5850# VPWR VPWR sg13_lv_pmos ad=93.45f pd=0.865u as=1.28962p ps=8.195u w=0.42u l=0.13u
X2455 VPWR sg13cmos5l_buf_1_29.A a_9832_1664# VPWR sg13_lv_pmos ad=0.2114p pd=1.54u as=0.2856p ps=2.36u w=0.84u l=0.13u
X2456 VPWR sg13cmos5l_buf_1_39.A a_3688_1664# VPWR sg13_lv_pmos ad=0.2114p pd=1.54u as=0.2856p ps=2.36u w=0.84u l=0.13u
X2457 sg13cmos5l_dfrbp_1_9.Q_N a_3407_4261# VGND VGND sg13_lv_nmos ad=0.2849p pd=2.25u as=0.2516p ps=2.16u w=0.74u l=0.13u
X2458 sg13cmos5l_dlhr_1_12.Q_N a_18486_8866# VGND VGND sg13_lv_nmos ad=0.2516p pd=2.16u as=0.1491p ps=1.18u w=0.74u l=0.13u
X2459 a_16164_4663# a_16395_4772# a_15850_4873# VGND sg13_lv_nmos ad=0.2373p pd=1.97u as=79.8f ps=0.8u w=0.42u l=0.13u
X2460 a_17961_8793# a_17780_8436# VPWR VPWR sg13_lv_pmos ad=0.2128p pd=1.5u as=0.2387p ps=1.84u w=1.12u l=0.13u
X2461 VPWR a_8588_3864# sg13cmos5l_buf_1_30.A VPWR sg13_lv_pmos ad=0.2114p pd=1.54u as=0.42p ps=2.99u w=1.12u l=0.13u
X2462 a_4311_7710# a_3676_7964# VGND VGND sg13_lv_nmos ad=47.25f pd=0.645u as=0.1428p ps=1.52u w=0.42u l=0.13u
X2463 sg13cmos5l_dlhr_1_15.Q a_18345_7674# VPWR VPWR sg13_lv_pmos ad=0.3808p pd=2.92u as=0.2128p ps=1.5u w=1.12u l=0.13u
X2464 VGND sg13cmos5l_buf_1_28.A a_9448_1664# VGND sg13_lv_nmos ad=0.14875p pd=1.16u as=0.187p ps=1.78u w=0.55u l=0.13u
X2465 VPWR a_18959_3215# a_19216_3358# VPWR sg13_lv_pmos ad=0.2639p pd=1.81u as=79.8f ps=0.8u w=0.42u l=0.13u
X2466 sg13cmos5l_a22oi_1_0.B1 sg13cmos5l_nor2_1_0.A a_10618_3142# VGND sg13_lv_nmos ad=0.2516p pd=2.16u as=0.1406p ps=1.12u w=0.74u l=0.13u
X2467 sg13cmos5l_dfrbp_1_0.Q a_19508_1924# VGND VGND sg13_lv_nmos ad=0.2516p pd=2.16u as=0.1406p ps=1.12u w=0.74u l=0.13u
X2468 a_10450_8874# sg13cmos5l_dfrbp_1_8.RESET_B VGND VGND sg13_lv_nmos ad=37.8f pd=0.6u as=79.8f ps=0.8u w=0.42u l=0.13u
X2469 a_2554_8112# a_1948_7964# VPWR VPWR sg13_lv_pmos ad=0.1008p pd=0.9u as=0.2387p ps=1.84u w=0.42u l=0.13u
X2470 a_7498_7897# a_7941_7653# a_7238_7674# VGND sg13_lv_nmos ad=79.8f pd=0.8u as=0.1296p ps=1.52u w=0.42u l=0.13u
X2471 VGND VPWR VGND VGND sg13_lv_nmos ad=79.8f pd=0.8u as=0 ps=0 w=0.42u l=1u
X2472 VPWR a_1846_7850# sg13cmos5l_dlhr_1_8.Q_N VPWR sg13_lv_pmos ad=0.1974p pd=1.5u as=0.3808p ps=2.92u w=1.12u l=0.13u
X2473 VPWR a_13775_6239# a_14032_6382# VPWR sg13_lv_pmos ad=0.2639p pd=1.81u as=79.8f ps=0.8u w=0.42u l=0.13u
X2474 sg13cmos5l_dfrbp_1_23.CLK a_14228_9484# VGND VGND sg13_lv_nmos ad=0.2516p pd=2.16u as=0.1406p ps=1.12u w=0.74u l=0.13u
X2475 a_12358_5388# sg13cmos5l_dfrbp_1_21.Q VPWR VPWR sg13_lv_pmos ad=0.1596p pd=1.22u as=0.2226p ps=1.535u w=0.84u l=0.13u
X2476 a_422_5850# sg13cmos5l_dfrbp_1_6.D VPWR VPWR sg13_lv_pmos ad=79.8f pd=0.8u as=0.1428p ps=1.52u w=0.42u l=0.13u
X2477 VPWR sg13cmos5l_inv_1_18.A a_9256_9224# VPWR sg13_lv_pmos ad=0.2114p pd=1.54u as=0.2856p ps=2.36u w=0.84u l=0.13u
X2478 VGND sg13cmos5l_buf_1_78.A a_6184_9224# VGND sg13_lv_nmos ad=0.14875p pd=1.16u as=0.187p ps=1.78u w=0.55u l=0.13u
X2479 sg13cmos5l_dfrbp_1_10.Q a_4436_3436# VGND VGND sg13_lv_nmos ad=0.2516p pd=2.16u as=0.1406p ps=1.12u w=0.74u l=0.13u
X2480 a_17508_3138# sg13cmos5l_a22oi_1_1.Y a_17414_3138# VGND sg13_lv_nmos ad=60.89999f pd=0.71u as=0.1428p ps=1.52u w=0.42u l=0.13u
X2481 a_16234_6385# a_16677_6141# a_16617_6553# VPWR sg13_lv_pmos ad=79.8f pd=0.8u as=63f ps=0.72u w=0.42u l=0.13u
X2482 a_14194_6162# sg13cmos5l_dfrbp_1_6.RESET_B VGND VGND sg13_lv_nmos ad=37.8f pd=0.6u as=79.8f ps=0.8u w=0.42u l=0.13u
X2483 a_11844_1639# a_11556_1944# a_11782_1639# VGND sg13_lv_nmos ad=0.1428p pd=1.52u as=37.8f ps=0.6u w=0.42u l=0.13u
X2484 VPWR a_13648_9406# a_13593_9501# VPWR sg13_lv_pmos ad=4.11675p pd=27.17u as=93.45f ps=0.865u w=0.42u l=0.13u
X2485 sg13cmos5l_inv_1_0.A a_13652_3900# VGND VGND sg13_lv_nmos ad=0.2516p pd=2.16u as=0.1406p ps=1.12u w=0.74u l=0.13u
X2486 a_3814_4663# sg13cmos5l_dfrbp_1_8.RESET_B VGND VGND sg13_lv_nmos ad=37.8f pd=0.6u as=0.1701p ps=1.65u w=0.42u l=0.13u
X2487 sg13cmos5l_dlhr_1_13.Q_N a_15414_7354# VPWR VPWR sg13_lv_pmos ad=0.3808p pd=2.92u as=0.1974p ps=1.5u w=1.12u l=0.13u
.ends
