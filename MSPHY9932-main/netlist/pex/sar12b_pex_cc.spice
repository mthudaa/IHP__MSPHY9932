* NGSPICE file created from sar12b_flat.ext - technology: ihp-sg13cmos5l

.subckt sar12b_flat VGND VPWR nh_sw[0] nh_sw[10] nh_sw[1] nh_sw[2] nh_sw[3] nh_sw[4]
+ nh_sw[5] nh_sw[6] nh_sw[7] nh_sw[8] nh_sw[9] nl_sw[0] nl_sw[10] nl_sw[1] nl_sw[2]
+ nl_sw[3] nl_sw[4] nl_sw[5] nl_sw[6] nl_sw[7] nl_sw[8] nl_sw[9] ph_sw[0] ph_sw[10]
+ ph_sw[1] ph_sw[2] ph_sw[3] ph_sw[4] ph_sw[5] ph_sw[6] ph_sw[7] ph_sw[8] ph_sw[9]
+ pl_sw[0] pl_sw[10] pl_sw[1] pl_sw[2] pl_sw[3] pl_sw[4] pl_sw[5] pl_sw[6] pl_sw[7]
+ pl_sw[8] pl_sw[9] ckc cko cks comp_p d_out[0] d_out[1] d_out[2] frame rdy
X0 a_15974_6162# sg13cmos5l_buf_1_57.X VPWR VPWR sg13_lv_pmos ad=79.8f pd=0.8u as=0.1428p ps=1.52u w=0.42u l=0.13u
X1 a_7440_1948# a_6889_1680# VPWR VPWR sg13_lv_pmos ad=0.105p pd=1.21u as=1.86162p ps=11.935u w=1u l=0.13u
X2 VPWR sg13cmos5l_inv_1_27.Y a_14632_9224# VPWR sg13_lv_pmos ad=0.2114p pd=1.54u as=0.2856p ps=2.36u w=0.84u l=0.13u
X3 VGND a_7820_9150# sg13cmos5l_buf_1_73.X VGND sg13_lv_nmos ad=0.14875p pd=1.16u as=0.2886p ps=2.26u w=0.74u l=0.13u
X4 VPWR sg13cmos5l_dfrbp_1_6.RESET_B a_12490_6385# VPWR sg13_lv_pmos ad=0.1563p pd=1.22u as=0.147p ps=1.54u w=0.42u l=0.13u
X5 VPWR a_10473_9186# a_10406_9624# VPWR sg13_lv_pmos ad=0.2387p pd=1.84u as=0.1008p ps=0.9u w=0.42u l=0.13u
X6 VGND a_15429_7653# a_15531_7796# VGND sg13_lv_nmos ad=1.49685p pd=9.6u as=0.2516p ps=2.16u w=0.74u l=0.13u
X7 VPWR a_16940_3102# nh_sw[8] VPWR sg13_lv_pmos ad=0.2114p pd=1.54u as=0.42p ps=2.99u w=1.12u l=0.13u
X8 VPWR a_12976_2630# a_12921_2511# VPWR sg13_lv_pmos ad=1.86162p pd=11.935u as=93.45f ps=0.865u w=0.42u l=0.13u
X9 sg13cmos5l_buf_1_44.A a_5673_3138# VGND VGND sg13_lv_nmos ad=0.2516p pd=2.16u as=0.1406p ps=1.12u w=0.74u l=0.13u
X10 a_13072_4142# a_12815_4261# a_13234_4338# VGND sg13_lv_nmos ad=0.1428p pd=1.52u as=37.8f ps=0.6u w=0.42u l=0.13u
X11 VPWR sg13cmos5l_inv_1_6.A sg13cmos5l_buf_1_0.A VPWR sg13_lv_pmos ad=0.3808p pd=2.92u as=0.3808p ps=2.92u w=1.12u l=0.13u
X12 a_5104_4870# a_4847_4727# a_5266_4650# VGND sg13_lv_nmos ad=0.1428p pd=1.52u as=37.8f ps=0.6u w=0.42u l=0.13u
X13 a_18615_5770# sg13cmos5l_dfrbp_1_8.D VGND VGND sg13_lv_nmos ad=0.2516p pd=2.16u as=0.15055p ps=1.17u w=0.74u l=0.13u
X14 a_11072_5347# sg13cmos5l_nor2_1_0.A VPWR VPWR sg13_lv_pmos ad=0.2856p pd=2.36u as=0.1596p ps=1.22u w=0.84u l=0.13u
X15 VPWR sg13cmos5l_dfrbp_1_21.Q_N a_18793_6216# VPWR sg13_lv_pmos ad=1.07253p pd=6.75u as=0.2856p ps=2.36u w=0.84u l=0.13u
X16 VPWR a_14543_3215# a_15380_3436# VPWR sg13_lv_pmos ad=0.2128p pd=1.5u as=0.3864p ps=2.93u w=1.12u l=0.13u
X17 pl_sw[5] a_7336_9224# VGND VGND sg13_lv_nmos ad=0.2886p pd=2.26u as=0.14875p ps=1.16u w=0.74u l=0.13u
X18 a_11973_1605# sg13cmos5l_dfrbp_1_0.CLK VGND VGND sg13_lv_nmos ad=0.2516p pd=2.16u as=5.84582p ps=38.34u w=0.74u l=0.13u
X19 VPWR a_11973_3911# a_12075_3911# VPWR sg13_lv_pmos ad=1.43437p pd=9.105u as=0.3864p ps=2.93u w=1.12u l=0.13u
X20 VGND a_3407_8797# a_4244_8436# VGND sg13_lv_nmos ad=0.1406p pd=1.12u as=0.2516p ps=2.16u w=0.74u l=0.13u
X21 VPWR a_19209_5769# a_19734_5842# VPWR sg13_lv_pmos ad=0.1974p pd=1.5u as=0.2856p ps=2.36u w=0.84u l=0.13u
X22 sg13cmos5l_dlhr_1_16.Q a_19209_5769# VGND VGND sg13_lv_nmos ad=0.2516p pd=2.16u as=0.1406p ps=1.12u w=0.74u l=0.13u
X23 VPWR a_19340_8400# pl_sw[9] VPWR sg13_lv_pmos ad=0.2114p pd=1.54u as=0.42p ps=2.99u w=1.12u l=0.13u
X24 sg13cmos5l_dlhr_1_2.D a_6479_2749# VGND VGND sg13_lv_nmos ad=0.2849p pd=2.25u as=0.2516p ps=2.16u w=0.74u l=0.13u
X25 a_13100_8400# sg13cmos5l_buf_1_90.X VGND VGND sg13_lv_nmos ad=0.187p pd=1.78u as=0.14875p ps=1.16u w=0.55u l=0.13u
X26 a_10071_7282# sg13cmos5l_dfrbp_1_18.Q VGND VGND sg13_lv_nmos ad=0.2516p pd=2.16u as=0.15055p ps=1.17u w=0.74u l=0.13u
X27 VPWR a_10288_8678# a_10233_8559# VPWR sg13_lv_pmos ad=1.15047p pd=7.175u as=93.45f ps=0.865u w=0.42u l=0.13u
X28 a_13701_3117# sg13cmos5l_dfrbp_1_0.CLK VGND VGND sg13_lv_nmos ad=0.2516p pd=2.16u as=2.43055p ps=15.415u w=0.74u l=0.13u
X29 a_1484_9150# sg13cmos5l_inv_1_19.A VGND VGND sg13_lv_nmos ad=0.187p pd=1.78u as=0.14875p ps=1.16u w=0.55u l=0.13u
X30 a_934_7349# sg13cmos5l_dfrbp_1_6.RESET_B VGND VGND sg13_lv_nmos ad=37.8f pd=0.6u as=0.1701p ps=1.65u w=0.42u l=0.13u
X31 VPWR a_14889_7281# a_14822_6924# VPWR sg13_lv_pmos ad=0.2387p pd=1.84u as=0.1008p ps=0.9u w=0.42u l=0.13u
X32 sg13cmos5l_buf_1_19.A a_18856_8436# VPWR VPWR sg13_lv_pmos ad=0.42p pd=2.99u as=0.2114p ps=1.54u w=1.12u l=0.13u
X33 a_16068_6928# a_16042_6892# VPWR VPWR sg13_lv_pmos ad=0.34p pd=2.68u as=0.36237p ps=2.605u w=1u l=0.13u
X34 VPWR a_16748_9150# pl_sw[7] VPWR sg13_lv_pmos ad=0.2114p pd=1.54u as=0.42p ps=2.99u w=1.12u l=0.13u
X35 sg13cmos5l_buf_1_96.A a_10665_7281# VGND VGND sg13_lv_nmos ad=0.2516p pd=2.16u as=0.1406p ps=1.12u w=0.74u l=0.13u
X36 a_14889_7281# a_14708_6924# VPWR VPWR sg13_lv_pmos ad=0.2128p pd=1.5u as=0.2387p ps=1.84u w=1.12u l=0.13u
X37 a_6898_2826# sg13cmos5l_dfrbp_1_6.RESET_B VGND VGND sg13_lv_nmos ad=37.8f pd=0.6u as=79.8f ps=0.8u w=0.42u l=0.13u
X38 a_11530_1849# a_11973_1605# a_11913_2017# VPWR sg13_lv_pmos ad=79.8f pd=0.8u as=63f ps=0.72u w=0.42u l=0.13u
X39 VGND sg13cmos5l_buf_1_111.A a_18376_9224# VGND sg13_lv_nmos ad=0.14875p pd=1.16u as=0.187p ps=1.78u w=0.55u l=0.13u
X40 a_16677_6141# sg13cmos5l_dfrbp_1_8.D VPWR VPWR sg13_lv_pmos ad=0.4088p pd=2.97u as=1.04815p ps=6.595u w=1.12u l=0.13u
X41 a_13284_3456# a_13258_3361# VPWR VPWR sg13_lv_pmos ad=0.34p pd=2.68u as=0.36237p ps=2.605u w=1u l=0.13u
X42 a_16271_7751# a_15429_7653# a_16177_7751# VGND sg13_lv_nmos ad=0.12665p pd=1.145u as=0.1428p ps=1.52u w=0.42u l=0.13u
X43 VPWR a_7689_1626# a_7622_2064# VPWR sg13_lv_pmos ad=0.2387p pd=1.84u as=0.1008p ps=0.9u w=0.42u l=0.13u
X44 VGND a_9705_4650# a_9660_4686# VGND sg13_lv_nmos ad=0.1428p pd=1.52u as=47.25f ps=0.645u w=0.42u l=0.13u
X45 sg13cmos5l_dfrbp_1_12.Q_N a_7055_4261# VGND VGND sg13_lv_nmos ad=0.2849p pd=2.25u as=0.2516p ps=2.16u w=0.74u l=0.13u
X46 sg13cmos5l_nor2_1_2.A sg13cmos5l_inv_1_9.Y VPWR VPWR sg13_lv_pmos ad=0.3808p pd=2.92u as=0.3808p ps=2.92u w=1.12u l=0.13u
X47 VGND a_2565_8447# a_2667_8447# VGND sg13_lv_nmos ad=2.92392p pd=18.89u as=0.2516p ps=2.16u w=0.74u l=0.13u
X48 a_1997_6126# a_2727_6380# a_2748_6126# VGND sg13_lv_nmos ad=0.12665p pd=1.145u as=0.3473p ps=2.71u w=0.74u l=0.13u
X49 VGND VPWR VGND VGND sg13_lv_nmos ad=0.1428p pd=1.52u as=0.40368n ps=2.16158m w=0.42u l=1u
X50 a_15702_4187# a_15821_3864# VPWR VPWR sg13_lv_pmos ad=0.3864p pd=2.93u as=0.2128p ps=1.5u w=1.12u l=0.13u
X51 a_10031_8797# a_9189_8447# a_9937_8797# VGND sg13_lv_nmos ad=0.12665p pd=1.145u as=0.1428p ps=1.52u w=0.42u l=0.13u
X52 a_5414_6162# sg13cmos5l_dfrbp_1_6.D VPWR VPWR sg13_lv_pmos ad=79.8f pd=0.8u as=0.1428p ps=1.52u w=0.42u l=0.13u
X53 VPWR a_15429_7653# a_15531_7796# VPWR sg13_lv_pmos ad=1.15047p pd=7.175u as=0.3864p ps=2.93u w=1.12u l=0.13u
X54 VPWR a_1967_7285# a_2804_6924# VPWR sg13_lv_pmos ad=0.2128p pd=1.5u as=0.3864p ps=2.93u w=1.12u l=0.13u
X55 nl_sw[3] a_4456_1664# VGND VGND sg13_lv_nmos ad=0.2886p pd=2.26u as=0.14875p ps=1.16u w=0.74u l=0.13u
X56 VGND sg13cmos5l_nor2_1_0.A a_12814_4692# VGND sg13_lv_nmos ad=0.17255p pd=1.25u as=0.187p ps=1.78u w=0.55u l=0.13u
X57 sg13cmos5l_buf_1_78.X a_6184_9224# VPWR VPWR sg13_lv_pmos ad=0.42p pd=2.99u as=0.2114p ps=1.54u w=1.12u l=0.13u
X58 a_12980_6924# a_12567_7282# a_12912_6924# VPWR sg13_lv_pmos ad=0.191p pd=1.44u as=0.105p ps=1.21u w=1u l=0.13u
X59 VGND a_1402_3864# a_1121_4166# VGND sg13_lv_nmos ad=79.8f pd=0.8u as=0.1428p ps=1.52u w=0.42u l=0.5u
X60 a_9940_4636# a_9524_4972# a_9705_4650# VGND sg13_lv_nmos ad=77.7f pd=0.95u as=0.2516p ps=2.16u w=0.74u l=0.13u
X61 a_2732_1590# sg13cmos5l_buf_1_37.A VGND VGND sg13_lv_nmos ad=0.187p pd=1.78u as=0.14875p ps=1.16u w=0.55u l=0.13u
X62 a_11556_1944# a_12075_1748# a_12815_1703# VGND sg13_lv_nmos ad=0.3473p pd=2.71u as=0.12665p ps=1.145u w=0.74u l=0.13u
X63 a_2566_3151# sg13cmos5l_dfrbp_1_6.RESET_B VGND VGND sg13_lv_nmos ad=37.8f pd=0.6u as=0.1701p ps=1.65u w=0.42u l=0.13u
X64 VGND sg13cmos5l_buf_1_5.A sg13cmos5l_inv_1_27.Y VGND sg13_lv_nmos ad=0.2516p pd=2.16u as=0.2516p ps=2.16u w=0.74u l=0.13u
X65 a_11973_1605# sg13cmos5l_dfrbp_1_0.CLK VPWR VPWR sg13_lv_pmos ad=0.4088p pd=2.97u as=1.777p ps=11.395u w=1.12u l=0.13u
X66 a_3575_6553# a_2879_6432# a_3669_6320# VGND sg13_lv_nmos ad=0.1296p pd=1.52u as=79.8f ps=0.8u w=0.42u l=0.13u
X67 a_4652_6126# sg13cmos5l_buf_1_59.A VGND VGND sg13_lv_nmos ad=0.187p pd=1.78u as=0.14875p ps=1.16u w=0.55u l=0.13u
X68 a_5673_3138# a_5492_3460# VPWR VPWR sg13_lv_pmos ad=0.2128p pd=1.5u as=0.2387p ps=1.84u w=1.12u l=0.13u
X69 a_10224_9508# a_9673_9240# VPWR VPWR sg13_lv_pmos ad=0.105p pd=1.21u as=4.11675p ps=27.17u w=1u l=0.13u
X70 sg13cmos5l_dlhr_1_1.Q a_2409_4650# VGND VGND sg13_lv_nmos ad=0.2516p pd=2.16u as=0.1406p ps=1.12u w=0.74u l=0.13u
X71 VPWR sg13cmos5l_dlhr_1_0.D a_6889_1680# VPWR sg13_lv_pmos ad=1.86162p pd=11.935u as=0.2856p ps=2.36u w=0.84u l=0.13u
X72 a_19090_1626# sg13cmos5l_dfrbp_1_0.RESET_B VGND VGND sg13_lv_nmos ad=37.8f pd=0.6u as=79.8f ps=0.8u w=0.42u l=0.13u
X73 a_17493_3947# a_16551_3987# a_17354_4180# VGND sg13_lv_nmos ad=79.8f pd=0.8u as=0.2373p ps=1.97u w=0.42u l=0.13u
X74 a_5132_3864# sg13cmos5l_buf_1_44.A VGND VGND sg13_lv_nmos ad=0.187p pd=1.78u as=0.14875p ps=1.16u w=0.55u l=0.13u
X75 VGND VPWR VGND VGND sg13_lv_nmos ad=0.1428p pd=1.52u as=0 ps=0 w=0.42u l=1u
X76 VPWR sg13cmos5l_dfrbp_1_6.RESET_B a_2314_3361# VPWR sg13_lv_pmos ad=0.1563p pd=1.22u as=0.147p ps=1.54u w=0.42u l=0.13u
X77 sg13cmos5l_dlhr_1_16.Q a_19209_5769# VPWR VPWR sg13_lv_pmos ad=0.3808p pd=2.92u as=0.2128p ps=1.5u w=1.12u l=0.13u
X78 a_13701_3117# sg13cmos5l_dfrbp_1_0.CLK VPWR VPWR sg13_lv_pmos ad=0.4088p pd=2.97u as=1.38655p ps=8.8u w=1.12u l=0.13u
X79 a_1967_5773# a_1125_5423# a_1873_5773# VGND sg13_lv_nmos ad=0.12665p pd=1.145u as=0.1428p ps=1.52u w=0.42u l=0.13u
X80 a_14295_7282# sg13cmos5l_dfrbp_1_23.CLK VPWR VPWR sg13_lv_pmos ad=0.3234p pd=2.45u as=1.04815p ps=6.595u w=0.84u l=0.13u
X81 sg13cmos5l_dlhr_1_12.D a_16271_7751# VPWR VPWR sg13_lv_pmos ad=0.4312p pd=3.01u as=0.2639p ps=1.81u w=1.12u l=0.13u
X82 VPWR a_17327_7285# a_18164_6924# VPWR sg13_lv_pmos ad=0.2128p pd=1.5u as=0.3864p ps=2.93u w=1.12u l=0.13u
X83 VPWR a_15177_5769# a_15702_5842# VPWR sg13_lv_pmos ad=0.1974p pd=1.5u as=0.2856p ps=2.36u w=0.84u l=0.13u
X84 a_16748_9150# sg13cmos5l_buf_1_93.X VPWR VPWR sg13_lv_pmos ad=0.2856p pd=2.36u as=0.2114p ps=1.54u w=0.84u l=0.13u
X85 VPWR a_7689_1626# a_8214_1608# VPWR sg13_lv_pmos ad=0.1974p pd=1.5u as=0.2856p ps=2.36u w=0.84u l=0.13u
X86 a_13460_7996# a_13178_7684# a_13393_7666# VGND sg13_lv_nmos ad=0.141p pd=1.17u as=71.99999f ps=0.865u w=0.64u l=0.13u
X87 a_1402_3864# sg13cmos5l_dlygate4sd2_1_0.X VPWR VPWR sg13_lv_pmos ad=0.1428p pd=1.52u as=0.1523p ps=1.38u w=0.42u l=0.13u
X88 VPWR a_12716_8400# ph_sw[5] VPWR sg13_lv_pmos ad=0.2114p pd=1.54u as=0.42p ps=2.99u w=1.12u l=0.13u
X89 a_12324_6162# sg13cmos5l_buf_1_57.X a_12230_6162# VGND sg13_lv_nmos ad=60.89999f pd=0.71u as=0.1428p ps=1.52u w=0.42u l=0.13u
X90 a_6117_6141# sg13cmos5l_dlhr_1_5.GATE VPWR VPWR sg13_lv_pmos ad=0.4088p pd=2.97u as=1.04815p ps=6.595u w=1.12u l=0.13u
X91 VPWR sg13cmos5l_dfrbp_1_6.RESET_B a_8457_7281# VPWR sg13_lv_pmos ad=0.2128p pd=1.5u as=0.2128p ps=1.5u w=1.12u l=0.13u
X92 VGND a_12549_9165# a_12651_9308# VGND sg13_lv_nmos ad=2.92392p pd=18.89u as=0.2516p ps=2.16u w=0.74u l=0.13u
X93 VPWR a_18860_9150# ph_sw[8] VPWR sg13_lv_pmos ad=0.2114p pd=1.54u as=0.42p ps=2.99u w=1.12u l=0.13u
X94 VPWR sg13cmos5l_buf_1_96.A a_11464_8436# VPWR sg13_lv_pmos ad=0.2114p pd=1.54u as=0.2856p ps=2.36u w=0.84u l=0.13u
X95 sg13cmos5l_dfrbp_1_1.D sg13cmos5l_a22oi_1_2.B2 a_9823_2780# VGND sg13_lv_nmos ad=0.2664p pd=1.46u as=0.13875p ps=1.115u w=0.74u l=0.13u
X96 VPWR a_16751_2749# a_17588_2388# VPWR sg13_lv_pmos ad=0.2128p pd=1.5u as=0.3864p ps=2.93u w=1.12u l=0.13u
X97 sg13cmos5l_dlhr_1_0.D a_7316_2388# VGND VGND sg13_lv_nmos ad=0.2516p pd=2.16u as=0.1406p ps=1.12u w=0.74u l=0.13u
X98 a_2122_8404# a_2565_8447# a_1862_8874# VGND sg13_lv_nmos ad=79.8f pd=0.8u as=0.1296p ps=1.52u w=0.42u l=0.13u
X99 a_17367_8794# sg13cmos5l_dfrbp_1_22.D VPWR VPWR sg13_lv_pmos ad=0.3234p pd=2.45u as=1.12242p ps=7u w=0.84u l=0.13u
X100 sg13cmos5l_buf_1_25.A sg13cmos5l_inv_1_14.A VGND VGND sg13_lv_nmos ad=0.2516p pd=2.16u as=0.2516p ps=2.16u w=0.74u l=0.13u
X101 a_20204_5376# sg13cmos5l_dlhr_1_16.Q VPWR VPWR sg13_lv_pmos ad=0.2856p pd=2.36u as=0.2114p ps=1.54u w=0.84u l=0.13u
X102 VPWR rdy a_424_8436# VPWR sg13_lv_pmos ad=0.2114p pd=1.54u as=0.2856p ps=2.36u w=0.84u l=0.13u
X103 sg13cmos5l_buf_1_87.A a_18376_9224# VPWR VPWR sg13_lv_pmos ad=0.42p pd=2.99u as=0.2114p ps=1.54u w=1.12u l=0.13u
X104 a_6479_2749# a_5637_2399# a_6385_2749# VGND sg13_lv_nmos ad=0.12665p pd=1.145u as=0.1428p ps=1.52u w=0.42u l=0.13u
X105 a_7888_4870# a_7631_4727# a_8050_4650# VGND sg13_lv_nmos ad=0.1428p pd=1.52u as=37.8f ps=0.6u w=0.42u l=0.13u
X106 VGND a_2831_7630# a_2786_7666# VGND sg13_lv_nmos ad=1.49685p pd=9.6u as=71.99999f ps=0.865u w=0.64u l=0.13u
X107 frame a_20008_7712# VGND VGND sg13_lv_nmos ad=0.2886p pd=2.26u as=0.14875p ps=1.16u w=0.74u l=0.13u
X108 a_6598_4663# sg13cmos5l_dfrbp_1_8.RESET_B VGND VGND sg13_lv_nmos ad=37.8f pd=0.6u as=0.1701p ps=1.65u w=0.42u l=0.13u
X109 a_1125_6935# sg13cmos5l_dfrbp_1_15.D VGND VGND sg13_lv_nmos ad=0.2516p pd=2.16u as=1.49685p ps=9.6u w=0.74u l=0.13u
X110 a_20012_2352# sg13cmos5l_buf_1_0.X VPWR VPWR sg13_lv_pmos ad=0.2856p pd=2.36u as=0.2114p ps=1.54u w=0.84u l=0.13u
X111 a_8486_8874# a_9291_8447# a_8746_8404# VPWR sg13_lv_pmos ad=0.1428p pd=1.52u as=79.8f ps=0.8u w=0.42u l=0.13u
X112 VPWR a_15887_8797# a_16724_8436# VPWR sg13_lv_pmos ad=0.2128p pd=1.5u as=0.3864p ps=2.93u w=1.12u l=0.13u
X113 VGND comp_p a_424_1664# VGND sg13_lv_nmos ad=0.14875p pd=1.16u as=0.187p ps=1.78u w=0.55u l=0.13u
X114 VPWR a_3664_4142# a_3609_4023# VPWR sg13_lv_pmos ad=1.43437p pd=9.105u as=93.45f ps=0.865u w=0.42u l=0.13u
X115 nh_sw[1] a_2824_2388# VGND VGND sg13_lv_nmos ad=0.2886p pd=2.26u as=0.14875p ps=1.16u w=0.74u l=0.13u
X116 VPWR sg13cmos5l_dfrbp_1_0.RESET_B a_17414_3138# VPWR sg13_lv_pmos ad=0.36237p pd=2.605u as=79.8f ps=0.8u w=0.42u l=0.13u
X117 a_2122_3868# a_2565_3911# a_2505_3947# VPWR sg13_lv_pmos ad=79.8f pd=0.8u as=63f ps=0.72u w=0.42u l=0.13u
X118 VGND a_4460_9150# sg13cmos5l_buf_1_60.X VGND sg13_lv_nmos ad=0.14875p pd=1.16u as=0.2886p ps=2.26u w=0.74u l=0.13u
X119 a_11846_9186# sg13cmos5l_dlhr_1_11.GATE VPWR VPWR sg13_lv_pmos ad=79.8f pd=0.8u as=0.1428p ps=1.52u w=0.42u l=0.13u
X120 a_3801_3453# a_2859_3260# a_3599_3215# VPWR sg13_lv_pmos ad=93.45f pd=0.865u as=0.2048p ps=1.63u w=0.42u l=0.13u
X121 a_13234_4338# sg13cmos5l_dfrbp_1_0.RESET_B VGND VGND sg13_lv_nmos ad=37.8f pd=0.6u as=79.8f ps=0.8u w=0.42u l=0.13u
X122 a_17751_7690# sg13cmos5l_dfrbp_1_22.D VGND VGND sg13_lv_nmos ad=0.2516p pd=2.16u as=0.15055p ps=1.17u w=0.74u l=0.13u
X123 a_7316_3460# a_7034_3148# a_7249_3130# VGND sg13_lv_nmos ad=0.141p pd=1.17u as=71.99999f ps=0.865u w=0.64u l=0.13u
X124 sg13cmos5l_buf_1_116.A a_15177_5769# VPWR VPWR sg13_lv_pmos ad=0.3808p pd=2.92u as=0.2128p ps=1.5u w=1.12u l=0.13u
X125 VPWR sg13cmos5l_dfrbp_1_15.D a_2621_7636# VPWR sg13_lv_pmos ad=1.15047p pd=7.175u as=0.3234p ps=2.45u w=0.84u l=0.13u
X126 a_14928_5412# a_14377_5770# VPWR VPWR sg13_lv_pmos ad=0.105p pd=1.21u as=1.28962p ps=8.195u w=1u l=0.13u
X127 a_7247_8797# a_6405_8447# a_5988_8440# VPWR sg13_lv_pmos ad=0.2048p pd=1.63u as=0.34p ps=2.68u w=1u l=0.13u
X128 ph_sw[2] a_3976_9224# VGND VGND sg13_lv_nmos ad=0.2886p pd=2.26u as=0.14875p ps=1.16u w=0.74u l=0.13u
X129 a_18196_8824# a_17780_8436# a_17961_8793# VGND sg13_lv_nmos ad=77.7f pd=0.95u as=0.2516p ps=2.16u w=0.74u l=0.13u
X130 a_8204_2352# sg13cmos5l_dlhr_1_2.Q VGND VGND sg13_lv_nmos ad=0.187p pd=1.78u as=0.14875p ps=1.16u w=0.55u l=0.13u
X131 a_5104_4870# sg13cmos5l_dfrbp_1_8.RESET_B VPWR VPWR sg13_lv_pmos ad=79.8f pd=0.8u as=1.2517p ps=7.955u w=0.42u l=0.13u
X132 sg13cmos5l_buf_1_59.A a_4425_7281# VPWR VPWR sg13_lv_pmos ad=0.3808p pd=2.92u as=0.2128p ps=1.5u w=1.12u l=0.13u
X133 a_16485_6935# sg13cmos5l_inv_1_2.A VGND VGND sg13_lv_nmos ad=0.2516p pd=2.16u as=1.49685p ps=9.6u w=0.74u l=0.13u
X134 a_17392_4870# a_17135_4727# a_17554_4650# VGND sg13_lv_nmos ad=0.1428p pd=1.52u as=37.8f ps=0.6u w=0.42u l=0.13u
X135 a_18860_9150# sg13cmos5l_buf_1_101.X VPWR VPWR sg13_lv_pmos ad=0.2856p pd=2.36u as=0.2114p ps=1.54u w=0.84u l=0.13u
X136 sg13cmos5l_dfrbp_1_7.Q_N a_14543_3215# VGND VGND sg13_lv_nmos ad=0.2849p pd=2.25u as=0.2516p ps=2.16u w=0.74u l=0.13u
X137 a_3575_6553# sg13cmos5l_dfrbp_1_15.D a_4322_6162# VGND sg13_lv_nmos ad=0.1428p pd=1.52u as=60.89999f ps=0.71u w=0.42u l=0.13u
X138 VPWR sg13cmos5l_buf_1_5.A sg13cmos5l_inv_1_27.Y VPWR sg13_lv_pmos ad=0.3808p pd=2.92u as=0.3808p ps=2.92u w=1.12u l=0.13u
X139 a_7095_1642# sg13cmos5l_dlhr_1_0.GATE VGND VGND sg13_lv_nmos ad=0.2516p pd=2.16u as=0.15055p ps=1.17u w=0.74u l=0.13u
X140 a_2697_3529# a_2340_3456# VPWR VPWR sg13_lv_pmos ad=63f pd=0.72u as=0.1563p ps=1.22u w=0.42u l=0.13u
X141 VGND a_5104_4870# a_4753_4727# VGND sg13_lv_nmos ad=79.8f pd=0.8u as=0.1428p ps=1.52u w=0.42u l=0.13u
X142 sg13cmos5l_nor2_1_0.A a_13556_2388# VPWR VPWR sg13_lv_pmos ad=0.3808p pd=2.92u as=0.2128p ps=1.5u w=1.12u l=0.13u
X143 VGND sg13cmos5l_dfrbp_1_21.Q a_18409_5770# VGND sg13_lv_nmos ad=0.15055p pd=1.17u as=0.187p ps=1.78u w=0.55u l=0.13u
X144 a_13698_5412# sg13cmos5l_dfrbp_1_23.Q a_13486_5412# VPWR sg13_lv_pmos ad=0.2128p pd=1.5u as=0.2128p ps=1.5u w=1.12u l=0.13u
X145 a_19526_6600# a_19130_6172# a_19412_6484# VPWR sg13_lv_pmos ad=0.1008p pd=0.9u as=0.191p ps=1.44u w=0.42u l=0.13u
X146 VPWR a_17776_6382# a_17721_6477# VPWR sg13_lv_pmos ad=1.07253p pd=6.75u as=93.45f ps=0.865u w=0.42u l=0.13u
X147 VPWR a_16268_3102# nl_sw[8] VPWR sg13_lv_pmos ad=0.2114p pd=1.54u as=0.42p ps=2.99u w=1.12u l=0.13u
X148 VPWR a_6213_3911# a_6315_3911# VPWR sg13_lv_pmos ad=1.43437p pd=9.105u as=0.3864p ps=2.93u w=1.12u l=0.13u
X149 VGND sg13cmos5l_dfrbp_1_0.RESET_B a_11268_2826# VGND sg13_lv_nmos ad=0.1626p pd=1.415u as=60.89999f ps=0.71u w=0.42u l=0.13u
X150 VGND a_17493_3947# a_16572_4261# VGND sg13_lv_nmos ad=0.1626p pd=1.415u as=0.2516p ps=2.16u w=0.74u l=0.13u
X151 VGND sg13cmos5l_buf_1_65.X a_8488_9224# VGND sg13_lv_nmos ad=0.14875p pd=1.16u as=0.187p ps=1.78u w=0.55u l=0.13u
X152 a_708_6928# a_682_6892# VGND VGND sg13_lv_nmos ad=0.2516p pd=2.16u as=0.1626p ps=1.415u w=0.74u l=0.13u
X153 a_1948_7964# sg13cmos5l_dfrbp_1_6.RESET_B VPWR VPWR sg13_lv_pmos ad=0.2128p pd=1.5u as=0.2128p ps=1.5u w=1.12u l=0.13u
X154 a_19161_3453# a_18219_3260# a_18959_3215# VPWR sg13_lv_pmos ad=93.45f pd=0.865u as=0.2048p ps=1.63u w=0.42u l=0.13u
X155 VPWR a_4041_2745# a_3974_2388# VPWR sg13_lv_pmos ad=0.2387p pd=1.84u as=0.1008p ps=0.9u w=0.42u l=0.13u
X156 a_16260_6480# a_16779_6284# a_17519_6239# VGND sg13_lv_nmos ad=0.3473p pd=2.71u as=0.12665p ps=1.145u w=0.74u l=0.13u
X157 VGND a_1484_6126# sg13cmos5l_buf_1_40.A VGND sg13_lv_nmos ad=0.14875p pd=1.16u as=0.2886p ps=2.26u w=0.74u l=0.13u
X158 VGND sg13cmos5l_inv_1_3.A a_15016_9224# VGND sg13_lv_nmos ad=0.14875p pd=1.16u as=0.187p ps=1.78u w=0.55u l=0.13u
X159 VPWR a_18671_1703# a_18928_1846# VPWR sg13_lv_pmos ad=0.2639p pd=1.81u as=79.8f ps=0.8u w=0.42u l=0.13u
X160 VGND sg13cmos5l_dfrbp_1_8.RESET_B a_11940_9186# VGND sg13_lv_nmos ad=0.1626p pd=1.415u as=60.89999f ps=0.71u w=0.42u l=0.13u
X161 VPWR a_9033_6162# a_8966_6600# VPWR sg13_lv_pmos ad=0.2387p pd=1.84u as=0.1008p ps=0.9u w=0.42u l=0.13u
X162 a_12913_7326# a_12361_7282# VGND VGND sg13_lv_nmos ad=71.99999f pd=0.865u as=1.49685p ps=9.6u w=0.64u l=0.13u
X163 a_5508_2813# a_5220_2392# a_5446_2813# VGND sg13_lv_nmos ad=0.1428p pd=1.52u as=37.8f ps=0.6u w=0.42u l=0.13u
X164 VGND a_19593_6162# a_19548_6198# VGND sg13_lv_nmos ad=0.1428p pd=1.52u as=47.25f ps=0.645u w=0.42u l=0.13u
X165 a_18057_3529# a_17700_3456# VPWR VPWR sg13_lv_pmos ad=63f pd=0.72u as=0.1563p ps=1.22u w=0.42u l=0.13u
X166 VGND a_7631_4727# a_8468_4948# VGND sg13_lv_nmos ad=0.1406p pd=1.12u as=0.2516p ps=2.16u w=0.74u l=0.13u
X167 VPWR VGND VPWR VPWR sg13_lv_pmos ad=0.34p pd=2.68u as=0.43217n ps=2.29179m w=1u l=1u
X168 VPWR a_10473_9186# a_10998_9168# VPWR sg13_lv_pmos ad=0.1974p pd=1.5u as=0.2856p ps=2.36u w=0.84u l=0.13u
X169 a_17220_1626# sg13cmos5l_dfrbp_1_0.D a_17126_1626# VGND sg13_lv_nmos ad=60.89999f pd=0.71u as=0.1428p ps=1.52u w=0.42u l=0.13u
X170 VPWR a_620_7638# pl_sw[0] VPWR sg13_lv_pmos ad=0.2114p pd=1.54u as=0.42p ps=2.99u w=1.12u l=0.13u
X171 a_10665_8065# a_10308_7992# VPWR VPWR sg13_lv_pmos ad=63f pd=0.72u as=0.1563p ps=1.22u w=0.42u l=0.13u
X172 VPWR a_14800_3358# a_14745_3453# VPWR sg13_lv_pmos ad=1.43437p pd=9.105u as=93.45f ps=0.865u w=0.42u l=0.13u
X173 VGND sg13cmos5l_nor2_1_1.A a_15439_1630# VGND sg13_lv_nmos ad=0.14505p pd=1.15u as=0.1406p ps=1.12u w=0.74u l=0.13u
X174 a_2148_3138# sg13cmos5l_dfrbp_1_6.D a_2054_3138# VGND sg13_lv_nmos ad=60.89999f pd=0.71u as=0.1428p ps=1.52u w=0.42u l=0.13u
X175 a_3860_2388# a_3578_2752# a_3793_2790# VGND sg13_lv_nmos ad=0.141p pd=1.17u as=71.99999f ps=0.865u w=0.64u l=0.13u
X176 sg13cmos5l_dlygate4sd2_1_0.A sg13cmos5l_inv_1_8.Y VPWR VPWR sg13_lv_pmos ad=0.2128p pd=1.5u as=0.3808p ps=2.92u w=1.12u l=0.13u
X177 a_1065_5459# a_708_5416# VPWR VPWR sg13_lv_pmos ad=63f pd=0.72u as=0.1563p ps=1.22u w=0.42u l=0.13u
X178 VGND a_5132_9150# sg13cmos5l_buf_1_64.A VGND sg13_lv_nmos ad=0.14875p pd=1.16u as=0.2886p ps=2.26u w=0.74u l=0.13u
X179 a_1862_8874# a_2667_8447# a_2122_8404# VPWR sg13_lv_pmos ad=0.1428p pd=1.52u as=79.8f ps=0.8u w=0.42u l=0.13u
X180 a_13392_7996# a_12841_7728# VPWR VPWR sg13_lv_pmos ad=0.105p pd=1.21u as=1.15047p ps=7.175u w=1u l=0.13u
X181 VGND sg13cmos5l_dfrbp_1_6.RESET_B a_8692_7312# VGND sg13_lv_nmos ad=0.1406p pd=1.12u as=77.7f ps=0.95u w=0.74u l=0.13u
X182 a_13284_3456# a_13803_3260# a_14543_3215# VGND sg13_lv_nmos ad=0.3473p pd=2.71u as=0.12665p ps=1.145u w=0.74u l=0.13u
X183 sg13cmos5l_nand2_1_2.B sg13cmos5l_or2_1_0.A a_650_3900# VPWR sg13_lv_pmos ad=0.3808p pd=2.92u as=0.1176p ps=1.33u w=1.12u l=0.13u
X184 VGND a_4425_7281# a_4950_7354# VGND sg13_lv_nmos ad=0.1491p pd=1.18u as=0.187p ps=1.78u w=0.55u l=0.13u
X185 VPWR sg13cmos5l_dfrbp_1_0.RESET_B a_17386_1849# VPWR sg13_lv_pmos ad=0.1563p pd=1.22u as=0.147p ps=1.54u w=0.42u l=0.13u
X186 a_14628_8440# a_14602_8404# VPWR VPWR sg13_lv_pmos ad=0.34p pd=2.68u as=0.36237p ps=2.605u w=1u l=0.13u
X187 a_20492_8400# sg13cmos5l_buf_1_104.X VGND VGND sg13_lv_nmos ad=0.187p pd=1.78u as=0.14875p ps=1.16u w=0.55u l=0.13u
X188 a_13486_5412# sg13cmos5l_nor2b_1_0.Y VPWR VPWR sg13_lv_pmos ad=0.2128p pd=1.5u as=0.3808p ps=2.92u w=1.12u l=0.13u
X189 sg13cmos5l_dfrbp_1_6.D a_1672_3176# VGND VGND sg13_lv_nmos ad=0.2886p pd=2.26u as=0.14875p ps=1.16u w=0.74u l=0.13u
X190 sg13cmos5l_buf_1_98.A a_13641_7674# VPWR VPWR sg13_lv_pmos ad=0.3808p pd=2.92u as=0.2128p ps=1.5u w=1.12u l=0.13u
X191 VPWR a_1997_6126# sg13cmos5l_dfrbp_1_15.Q_N VPWR sg13_lv_pmos ad=0.2639p pd=1.81u as=0.4312p ps=3.01u w=1.12u l=0.13u
X192 d_out[1] a_20008_3900# VPWR VPWR sg13_lv_pmos ad=0.42p pd=2.99u as=0.2114p ps=1.54u w=1.12u l=0.13u
X193 VPWR a_4950_5699# sg13cmos5l_dlhr_1_5.GATE VPWR sg13_lv_pmos ad=0.2128p pd=1.5u as=0.3808p ps=2.92u w=1.12u l=0.13u
X194 a_6572_1590# sg13cmos5l_buf_1_24.A VPWR VPWR sg13_lv_pmos ad=0.2856p pd=2.36u as=0.2114p ps=1.54u w=0.84u l=0.13u
X195 a_8966_6600# a_8570_6172# a_8852_6484# VPWR sg13_lv_pmos ad=0.1008p pd=0.9u as=0.191p ps=1.44u w=0.42u l=0.13u
X196 sg13cmos5l_buf_1_97.A a_10473_9186# VGND VGND sg13_lv_nmos ad=0.2516p pd=2.16u as=0.1406p ps=1.12u w=0.74u l=0.13u
X197 a_10331_1924# sg13cmos5l_nand2_1_1.B sg13cmos5l_a22oi_1_2.B1 VPWR sg13_lv_pmos ad=0.2128p pd=1.5u as=0.3808p ps=2.92u w=1.12u l=0.13u
X198 VGND sg13cmos5l_dfrbp_1_6.RESET_B a_516_5850# VGND sg13_lv_nmos ad=0.1626p pd=1.415u as=60.89999f ps=0.71u w=0.42u l=0.13u
X199 sg13cmos5l_a221oi_1_0.A2 a_7892_3900# VPWR VPWR sg13_lv_pmos ad=0.3808p pd=2.92u as=0.2128p ps=1.5u w=1.12u l=0.13u
X200 a_18300_7710# a_17751_7690# a_18164_7996# VGND sg13_lv_nmos ad=47.25f pd=0.645u as=0.141p ps=1.17u w=0.42u l=0.13u
X201 VPWR sg13cmos5l_dfrbp_1_8.RESET_B a_14602_8404# VPWR sg13_lv_pmos ad=0.1563p pd=1.22u as=0.147p ps=1.54u w=0.42u l=0.13u
X202 sg13cmos5l_dfrbp_1_1.Q a_13652_1924# VGND VGND sg13_lv_nmos ad=0.2516p pd=2.16u as=0.1406p ps=1.12u w=0.74u l=0.13u
X203 sg13cmos5l_a221oi_1_0.C1 sg13cmos5l_inv_1_0.A VGND VGND sg13_lv_nmos ad=0.1406p pd=1.12u as=0.2516p ps=2.16u w=0.74u l=0.13u
X204 VPWR a_8972_9150# sg13cmos5l_buf_1_77.X VPWR sg13_lv_pmos ad=0.2114p pd=1.54u as=0.42p ps=2.99u w=1.12u l=0.13u
X205 VPWR sg13cmos5l_dfrbp_1_6.RESET_B a_422_7362# VPWR sg13_lv_pmos ad=0.36237p pd=2.605u as=79.8f ps=0.8u w=0.42u l=0.13u
X206 VGND a_11372_3102# nh_sw[5] VGND sg13_lv_nmos ad=0.14875p pd=1.16u as=0.2886p ps=2.26u w=0.74u l=0.13u
X207 a_11530_3868# a_11973_3911# a_11270_4338# VGND sg13_lv_nmos ad=79.8f pd=0.8u as=0.1296p ps=1.52u w=0.42u l=0.13u
X208 a_2161_4642# a_1609_4704# VGND VGND sg13_lv_nmos ad=71.99999f pd=0.865u as=2.41737p ps=15.64u w=0.64u l=0.13u
X209 VPWR sg13cmos5l_a22oi_1_1.A1 a_14814_3876# VPWR sg13_lv_pmos ad=0.3808p pd=2.92u as=0.2716p ps=1.605u w=1.12u l=0.13u
X210 VPWR a_10412_6126# sg13cmos5l_buf_1_29.A VPWR sg13_lv_pmos ad=0.2114p pd=1.54u as=0.42p ps=2.99u w=1.12u l=0.13u
X211 VPWR sg13cmos5l_dfrbp_1_0.RESET_B a_15466_2356# VPWR sg13_lv_pmos ad=0.1563p pd=1.22u as=0.147p ps=1.54u w=0.42u l=0.13u
X212 VPWR VGND VPWR VPWR sg13_lv_pmos ad=0.34p pd=2.68u as=0 ps=0 w=1u l=1u
X213 a_6188_1590# sg13cmos5l_buf_1_25.A VGND VGND sg13_lv_nmos ad=0.187p pd=1.78u as=0.14875p ps=1.16u w=0.55u l=0.13u
X214 sg13cmos5l_dlhr_1_11.Q_N a_13686_7354# VPWR VPWR sg13_lv_pmos ad=0.3808p pd=2.92u as=0.1974p ps=1.5u w=1.12u l=0.13u
X215 a_16425_6971# a_16068_6928# VPWR VPWR sg13_lv_pmos ad=63f pd=0.72u as=0.1563p ps=1.22u w=0.42u l=0.13u
X216 sg13cmos5l_nand2_1_1.A a_15380_3436# VGND VGND sg13_lv_nmos ad=0.2516p pd=2.16u as=0.1406p ps=1.12u w=0.74u l=0.13u
X217 sg13cmos5l_inv_1_2.A a_8488_9224# VPWR VPWR sg13_lv_pmos ad=0.42p pd=2.99u as=0.2114p ps=1.54u w=1.12u l=0.13u
X218 a_9040_7894# a_8783_7751# a_9202_7674# VGND sg13_lv_nmos ad=0.1428p pd=1.52u as=37.8f ps=0.6u w=0.42u l=0.13u
X219 VPWR a_7631_4727# a_7888_4870# VPWR sg13_lv_pmos ad=0.2639p pd=1.81u as=79.8f ps=0.8u w=0.42u l=0.13u
X220 a_2374_4325# sg13cmos5l_dfrbp_1_8.RESET_B VGND VGND sg13_lv_nmos ad=37.8f pd=0.6u as=0.1701p ps=1.65u w=0.42u l=0.13u
X221 a_3831_7282# sg13cmos5l_dfrbp_1_15.D VGND VGND sg13_lv_nmos ad=0.2516p pd=2.16u as=0.15055p ps=1.17u w=0.74u l=0.13u
X222 a_10598_6924# a_10202_7288# a_10484_6924# VPWR sg13_lv_pmos ad=0.1008p pd=0.9u as=0.191p ps=1.44u w=0.42u l=0.13u
X223 a_7750_7687# sg13cmos5l_dfrbp_1_6.RESET_B VGND VGND sg13_lv_nmos ad=37.8f pd=0.6u as=0.1701p ps=1.65u w=0.42u l=0.13u
X224 d_out[0] a_20392_2388# VPWR VPWR sg13_lv_pmos ad=0.42p pd=2.99u as=0.2114p ps=1.54u w=1.12u l=0.13u
X225 VGND sg13cmos5l_dfrbp_1_20.Q_N a_9673_9240# VGND sg13_lv_nmos ad=0.15055p pd=1.17u as=0.187p ps=1.78u w=0.55u l=0.13u
X226 a_8412_7326# a_7863_7282# a_8276_6924# VGND sg13_lv_nmos ad=47.25f pd=0.645u as=0.141p ps=1.17u w=0.42u l=0.13u
X227 sg13cmos5l_buf_1_94.X a_15016_9224# VPWR VPWR sg13_lv_pmos ad=0.42p pd=2.99u as=0.2114p ps=1.54u w=1.12u l=0.13u
X228 VPWR a_6380_7638# pl_sw[3] VPWR sg13_lv_pmos ad=0.2114p pd=1.54u as=0.42p ps=2.99u w=1.12u l=0.13u
X229 VPWR a_17493_3947# a_16572_4261# VPWR sg13_lv_pmos ad=0.36237p pd=2.605u as=0.34p ps=2.68u w=1u l=0.13u
X230 a_11364_4338# sg13cmos5l_dfrbp_1_2.D a_11270_4338# VGND sg13_lv_nmos ad=60.89999f pd=0.71u as=0.1428p ps=1.52u w=0.42u l=0.13u
X231 VPWR a_13484_8400# sg13cmos5l_buf_1_5.A VPWR sg13_lv_pmos ad=0.2114p pd=1.54u as=0.42p ps=2.99u w=1.12u l=0.13u
X232 a_2638_6162# a_2380_6162# VGND VGND sg13_lv_nmos ad=0.1428p pd=1.52u as=79.8f ps=0.8u w=0.42u l=0.13u
X233 sg13cmos5l_dlhr_1_10.Q_N a_20118_6144# VPWR VPWR sg13_lv_pmos ad=0.3808p pd=2.92u as=0.1974p ps=1.5u w=1.12u l=0.13u
X234 a_11460_2392# a_11434_2356# VPWR VPWR sg13_lv_pmos ad=0.34p pd=2.68u as=0.36237p ps=2.605u w=1u l=0.13u
X235 sg13cmos5l_buf_1_59.A a_4425_7281# VGND VGND sg13_lv_nmos ad=0.2516p pd=2.16u as=0.1406p ps=1.12u w=0.74u l=0.13u
X236 VPWR sg13cmos5l_inv_1_29.Y a_11771_5412# VPWR sg13_lv_pmos ad=0.2128p pd=1.5u as=0.2128p ps=1.5u w=1.12u l=0.13u
X237 VPWR a_18959_3215# a_19796_3436# VPWR sg13_lv_pmos ad=0.2128p pd=1.5u as=0.3864p ps=2.93u w=1.12u l=0.13u
X238 VGND sg13cmos5l_buf_1_24.X a_5704_1664# VGND sg13_lv_nmos ad=0.14875p pd=1.16u as=0.187p ps=1.78u w=0.55u l=0.13u
X239 a_10433_4248# sg13cmos5l_dfrbp_1_10.Q sg13cmos5l_a22oi_1_1.B1 VGND sg13_lv_nmos ad=0.1406p pd=1.12u as=0.1406p ps=1.12u w=0.74u l=0.13u
X240 a_2436_4325# a_2667_3911# a_2122_3868# VGND sg13_lv_nmos ad=0.2373p pd=1.97u as=79.8f ps=0.8u w=0.42u l=0.13u
X241 VGND sg13cmos5l_buf_1_34.X sg13cmos5l_buf_1_60.A VGND sg13_lv_nmos ad=0.2516p pd=2.16u as=0.2516p ps=2.16u w=0.74u l=0.13u
X242 a_10484_6924# a_10202_7288# a_10417_7326# VGND sg13_lv_nmos ad=0.141p pd=1.17u as=71.99999f ps=0.865u w=0.64u l=0.13u
X243 VGND VPWR VGND VGND sg13_lv_nmos ad=0.1428p pd=1.52u as=0 ps=0 w=0.42u l=1u
X244 a_4559_7630# sg13cmos5l_dlhr_1_9.D VPWR VPWR sg13_lv_pmos ad=0.2856p pd=2.36u as=1.15047p ps=7.175u w=0.84u l=0.13u
X245 VPWR sg13cmos5l_dfrbp_1_6.RESET_B a_12230_6162# VPWR sg13_lv_pmos ad=0.36237p pd=2.605u as=79.8f ps=0.8u w=0.42u l=0.13u
X246 a_18117_3117# sg13cmos5l_dfrbp_1_0.CLK VGND VGND sg13_lv_nmos ad=0.2516p pd=2.16u as=2.43055p ps=15.415u w=0.74u l=0.13u
X247 VGND sg13cmos5l_dfrbp_1_6.RESET_B a_7732_3124# VGND sg13_lv_nmos ad=0.1406p pd=1.12u as=77.7f ps=0.95u w=0.74u l=0.13u
X248 VPWR a_2224_5654# a_2169_5535# VPWR sg13_lv_pmos ad=1.28962p pd=8.195u as=93.45f ps=0.865u w=0.42u l=0.13u
X249 VGND sg13cmos5l_buf_1_61.X a_1000_9224# VGND sg13_lv_nmos ad=0.14875p pd=1.16u as=0.187p ps=1.78u w=0.55u l=0.13u
X250 a_13017_4023# a_12075_3911# a_12815_4261# VPWR sg13_lv_pmos ad=93.45f pd=0.865u as=0.2048p ps=1.63u w=0.42u l=0.13u
X251 VPWR a_17135_4727# a_17392_4870# VPWR sg13_lv_pmos ad=0.2639p pd=1.81u as=79.8f ps=0.8u w=0.42u l=0.13u
X252 sg13cmos5l_buf_1_111.A a_19240_7712# VGND VGND sg13_lv_nmos ad=0.2886p pd=2.26u as=0.14875p ps=1.16u w=0.74u l=0.13u
X253 VPWR sg13cmos5l_inv_1_6.A a_20008_8436# VPWR sg13_lv_pmos ad=0.2114p pd=1.54u as=0.2856p ps=2.36u w=0.84u l=0.13u
X254 a_4172_1590# sg13cmos5l_buf_1_38.A VGND VGND sg13_lv_nmos ad=0.187p pd=1.78u as=0.14875p ps=1.16u w=0.55u l=0.13u
X255 VGND a_9879_9202# a_10010_9196# VGND sg13_lv_nmos ad=2.92392p pd=18.89u as=0.2775p ps=2.23u w=0.74u l=0.13u
X256 a_7474_4338# sg13cmos5l_dfrbp_1_6.RESET_B VGND VGND sg13_lv_nmos ad=37.8f pd=0.6u as=79.8f ps=0.8u w=0.42u l=0.13u
X257 sg13cmos5l_dlhr_1_5.D a_6959_6239# VGND VGND sg13_lv_nmos ad=0.2849p pd=2.25u as=0.2516p ps=2.16u w=0.74u l=0.13u
X258 a_8593_5814# a_8041_5770# VGND VGND sg13_lv_nmos ad=71.99999f pd=0.865u as=1.97045p ps=12.335u w=0.64u l=0.13u
X259 a_11877_2399# sg13cmos5l_dfrbp_1_0.CLK VGND VGND sg13_lv_nmos ad=0.2516p pd=2.16u as=2.43055p ps=15.415u w=0.74u l=0.13u
X260 a_17554_4650# sg13cmos5l_dfrbp_1_8.RESET_B VGND VGND sg13_lv_nmos ad=37.8f pd=0.6u as=79.8f ps=0.8u w=0.42u l=0.13u
X261 a_17132_9150# sg13cmos5l_buf_1_94.X VGND VGND sg13_lv_nmos ad=0.187p pd=1.78u as=0.14875p ps=1.16u w=0.55u l=0.13u
X262 VPWR sg13cmos5l_buf_1_19.A a_18760_2388# VPWR sg13_lv_pmos ad=0.2114p pd=1.54u as=0.2856p ps=2.36u w=0.84u l=0.13u
X263 a_5674_6385# a_6117_6141# a_6057_6553# VPWR sg13_lv_pmos ad=79.8f pd=0.8u as=63f ps=0.72u w=0.42u l=0.13u
X264 VPWR sg13cmos5l_buf_1_98.A a_13768_8436# VPWR sg13_lv_pmos ad=0.2114p pd=1.54u as=0.2856p ps=2.36u w=0.84u l=0.13u
X265 sg13cmos5l_dlhr_1_5.Q_N a_8982_7354# VPWR VPWR sg13_lv_pmos ad=0.3808p pd=2.92u as=0.1974p ps=1.5u w=1.12u l=0.13u
X266 a_17700_3456# a_17674_3361# VPWR VPWR sg13_lv_pmos ad=0.34p pd=2.68u as=0.36237p ps=2.605u w=1u l=0.13u
X267 a_10220_3102# sg13cmos5l_buf_1_28.X VPWR VPWR sg13_lv_pmos ad=0.2856p pd=2.36u as=0.2114p ps=1.54u w=0.84u l=0.13u
X268 sg13cmos5l_a22oi_1_1.Y sg13cmos5l_a22oi_1_1.B2 a_14814_3876# VPWR sg13_lv_pmos ad=0.2128p pd=1.5u as=0.2744p ps=1.61u w=1.12u l=0.13u
X269 a_8660_5412# a_8247_5770# a_8592_5412# VPWR sg13_lv_pmos ad=0.191p pd=1.44u as=0.105p ps=1.21u w=1u l=0.13u
X270 a_8796_5814# a_8247_5770# a_8660_5412# VGND sg13_lv_nmos ad=47.25f pd=0.645u as=0.141p ps=1.17u w=0.42u l=0.13u
X271 VGND a_17961_8793# a_18486_8866# VGND sg13_lv_nmos ad=0.1491p pd=1.18u as=0.187p ps=1.78u w=0.55u l=0.13u
X272 VPWR sg13cmos5l_inv_1_29.A a_12841_7728# VPWR sg13_lv_pmos ad=1.15047p pd=7.175u as=0.2856p ps=2.36u w=0.84u l=0.13u
X273 VPWR a_13641_7674# a_13574_8112# VPWR sg13_lv_pmos ad=0.2387p pd=1.84u as=0.1008p ps=0.9u w=0.42u l=0.13u
X274 VPWR a_19593_6162# a_20118_6144# VPWR sg13_lv_pmos ad=0.1974p pd=1.5u as=0.2856p ps=2.36u w=0.84u l=0.13u
X275 a_10028_6126# sg13cmos5l_buf_1_56.A VGND VGND sg13_lv_nmos ad=0.187p pd=1.78u as=0.14875p ps=1.16u w=0.55u l=0.13u
X276 VGND sg13cmos5l_buf_1_33.A a_2248_1664# VGND sg13_lv_nmos ad=0.14875p pd=1.16u as=0.187p ps=1.78u w=0.55u l=0.13u
X277 VGND sg13cmos5l_buf_8_1.A a_18363_4270# VGND sg13_lv_nmos ad=0.1406p pd=1.12u as=0.2553p ps=2.17u w=0.74u l=0.13u
X278 VGND a_13076_5376# sg13cmos5l_or2_1_1.B VGND sg13_lv_nmos ad=0.17255p pd=1.25u as=0.1406p ps=1.12u w=0.74u l=0.13u
X279 sg13cmos5l_dfrbp_1_21.Q a_18356_6460# VGND VGND sg13_lv_nmos ad=0.2516p pd=2.16u as=0.1406p ps=1.12u w=0.74u l=0.13u
X280 a_13161_7281# a_12980_6924# VPWR VPWR sg13_lv_pmos ad=0.2128p pd=1.5u as=0.2387p ps=1.84u w=1.12u l=0.13u
X281 a_7820_2352# sg13cmos5l_dlhr_1_0.Q VGND VGND sg13_lv_nmos ad=0.187p pd=1.78u as=0.14875p ps=1.16u w=0.55u l=0.13u
X282 VPWR sg13cmos5l_dlhr_1_6.D a_8233_6216# VPWR sg13_lv_pmos ad=1.07253p pd=6.75u as=0.2856p ps=2.36u w=0.84u l=0.13u
X283 a_3302_4650# sg13cmos5l_dfrbp_1_9.Q VPWR VPWR sg13_lv_pmos ad=79.8f pd=0.8u as=0.1428p ps=1.52u w=0.42u l=0.13u
X284 sg13cmos5l_o21ai_1_0.A2 sg13cmos5l_nand2_1_0.B VPWR VPWR sg13_lv_pmos ad=0.2128p pd=1.5u as=0.3808p ps=2.92u w=1.12u l=0.13u
X285 VPWR a_15884_3102# nh_sw[7] VPWR sg13_lv_pmos ad=0.2114p pd=1.54u as=0.42p ps=2.99u w=1.12u l=0.13u
X286 a_12106_9409# a_12549_9165# a_11846_9186# VGND sg13_lv_nmos ad=79.8f pd=0.8u as=0.1296p ps=1.52u w=0.42u l=0.13u
X287 a_8985_7989# a_8043_7796# a_8783_7751# VPWR sg13_lv_pmos ad=93.45f pd=0.865u as=0.2048p ps=1.63u w=0.42u l=0.13u
X288 a_4177_7326# a_3625_7282# VGND VGND sg13_lv_nmos ad=71.99999f pd=0.865u as=1.49685p ps=9.6u w=0.64u l=0.13u
X289 VPWR a_12815_4261# a_13072_4142# VPWR sg13_lv_pmos ad=0.2639p pd=1.81u as=79.8f ps=0.8u w=0.42u l=0.13u
X290 VGND a_6903_3154# a_7034_3148# VGND sg13_lv_nmos ad=2.59257p pd=16.445u as=0.2775p ps=2.23u w=0.74u l=0.13u
X291 a_18117_3117# sg13cmos5l_dfrbp_1_0.CLK VPWR VPWR sg13_lv_pmos ad=0.4088p pd=2.97u as=1.38655p ps=8.8u w=1.12u l=0.13u
X292 VPWR sg13cmos5l_buf_1_28.A a_9448_1664# VPWR sg13_lv_pmos ad=0.2114p pd=1.54u as=0.2856p ps=2.36u w=0.84u l=0.13u
X293 a_17584_7166# sg13cmos5l_dfrbp_1_8.RESET_B VPWR VPWR sg13_lv_pmos ad=79.8f pd=0.8u as=1.04815p ps=6.595u w=0.42u l=0.13u
X294 VPWR sg13cmos5l_buf_1_86.A a_20392_6924# VPWR sg13_lv_pmos ad=0.2114p pd=1.54u as=0.2856p ps=2.36u w=0.84u l=0.13u
X295 a_17519_6239# a_16677_6141# a_16260_6480# VPWR sg13_lv_pmos ad=0.2048p pd=1.63u as=0.34p ps=2.68u w=1u l=0.13u
X296 a_996_5837# a_708_5416# a_934_5837# VGND sg13_lv_nmos ad=0.1428p pd=1.52u as=37.8f ps=0.6u w=0.42u l=0.13u
X297 VPWR VGND VPWR VPWR sg13_lv_pmos ad=0.19p pd=1.38u as=0 ps=0 w=1u l=1u
X298 VPWR sg13cmos5l_inv_1_8.A a_2879_6432# VPWR sg13_lv_pmos ad=1.07253p pd=6.75u as=0.4088p ps=2.97u w=1.12u l=0.13u
X299 a_2054_3138# a_2859_3260# a_2314_3361# VPWR sg13_lv_pmos ad=0.1428p pd=1.52u as=79.8f ps=0.8u w=0.42u l=0.13u
X300 VPWR a_1484_9150# sg13cmos5l_buf_1_68.X VPWR sg13_lv_pmos ad=0.2114p pd=1.54u as=0.42p ps=2.99u w=1.12u l=0.13u
X301 VPWR sg13cmos5l_dfrbp_1_0.RESET_B a_17126_1626# VPWR sg13_lv_pmos ad=0.36237p pd=2.605u as=79.8f ps=0.8u w=0.42u l=0.13u
X302 sg13cmos5l_dfrbp_1_0.D sg13cmos5l_nor2_1_1.A VGND VGND sg13_lv_nmos ad=0.1406p pd=1.12u as=0.2516p ps=2.16u w=0.74u l=0.13u
X303 VPWR sg13cmos5l_buf_1_78.A a_6184_9224# VPWR sg13_lv_pmos ad=0.2114p pd=1.54u as=0.2856p ps=2.36u w=0.84u l=0.13u
X304 a_5194_2356# a_5637_2399# a_5577_2435# VPWR sg13_lv_pmos ad=79.8f pd=0.8u as=63f ps=0.72u w=0.42u l=0.13u
X305 a_14543_3215# a_13701_3117# a_14449_3215# VGND sg13_lv_nmos ad=0.12665p pd=1.145u as=0.1428p ps=1.52u w=0.42u l=0.13u
X306 VGND a_12719_2749# a_13556_2388# VGND sg13_lv_nmos ad=0.1406p pd=1.12u as=0.2516p ps=2.16u w=0.74u l=0.13u
X307 VPWR sg13cmos5l_dfrbp_1_6.RESET_B a_2054_3138# VPWR sg13_lv_pmos ad=0.36237p pd=2.605u as=79.8f ps=0.8u w=0.42u l=0.13u
X308 sg13cmos5l_buf_8_0.X a_19227_4654# VGND VGND sg13_lv_nmos ad=0.1406p pd=1.12u as=0.1406p ps=1.12u w=0.74u l=0.13u
X309 a_3945_5041# a_3588_4968# VPWR VPWR sg13_lv_pmos ad=63f pd=0.72u as=0.1563p ps=1.22u w=0.42u l=0.13u
X310 pl_sw[1] a_1000_9224# VPWR VPWR sg13_lv_pmos ad=0.42p pd=2.99u as=0.2114p ps=1.54u w=1.12u l=0.13u
X311 a_3407_8797# a_2565_8447# a_2148_8440# VPWR sg13_lv_pmos ad=0.2048p pd=1.63u as=0.34p ps=2.68u w=1u l=0.13u
X312 a_12815_1703# a_11973_1605# a_11556_1944# VPWR sg13_lv_pmos ad=0.2048p pd=1.63u as=0.34p ps=2.68u w=1u l=0.13u
X313 VGND sg13cmos5l_dlygate4sd3_1_0.X sg13cmos5l_buf_1_43.A VGND sg13_lv_nmos ad=0.2516p pd=2.16u as=0.2516p ps=2.16u w=0.74u l=0.13u
X314 sg13cmos5l_buf_1_6.A a_12520_3176# VGND VGND sg13_lv_nmos ad=0.2886p pd=2.26u as=0.14875p ps=1.16u w=0.74u l=0.13u
X315 a_15876_4968# a_15850_4873# VGND VGND sg13_lv_nmos ad=0.2516p pd=2.16u as=0.1626p ps=1.415u w=0.74u l=0.13u
X316 ph_sw[0] a_616_9224# VGND VGND sg13_lv_nmos ad=0.2886p pd=2.26u as=0.14875p ps=1.16u w=0.74u l=0.13u
X317 a_11846_9186# a_12651_9308# a_12106_9409# VPWR sg13_lv_pmos ad=0.1428p pd=1.52u as=79.8f ps=0.8u w=0.42u l=0.13u
X318 VPWR a_4559_7630# a_4518_7996# VPWR sg13_lv_pmos ad=1.15047p pd=7.175u as=0.105p ps=1.21u w=1u l=0.13u
X319 a_1948_7964# a_2348_7624# a_2306_7660# VGND sg13_lv_nmos ad=0.2516p pd=2.16u as=77.7f ps=0.95u w=0.74u l=0.13u
X320 a_15124_7312# a_14708_6924# a_14889_7281# VGND sg13_lv_nmos ad=77.7f pd=0.95u as=0.2516p ps=2.16u w=0.74u l=0.13u
X321 VGND a_3308_9150# sg13cmos5l_inv_1_8.A VGND sg13_lv_nmos ad=0.14875p pd=1.16u as=0.2886p ps=2.26u w=0.74u l=0.13u
X322 a_15821_3864# a_16551_3987# a_16572_4261# VGND sg13_lv_nmos ad=0.12665p pd=1.145u as=0.3473p ps=2.71u w=0.74u l=0.13u
X323 a_12804_6175# a_12516_6480# a_12742_6175# VGND sg13_lv_nmos ad=0.1428p pd=1.52u as=37.8f ps=0.6u w=0.42u l=0.13u
X324 a_8208_6924# a_7657_7282# VPWR VPWR sg13_lv_pmos ad=0.105p pd=1.21u as=1.07253p ps=6.75u w=1u l=0.13u
X325 VGND sg13cmos5l_buf_1_5.A a_14440_1664# VGND sg13_lv_nmos ad=0.14875p pd=1.16u as=0.187p ps=1.78u w=0.55u l=0.13u
X326 sg13cmos5l_a22oi_1_0.Y sg13cmos5l_a22oi_1_0.B1 a_10783_3876# VPWR sg13_lv_pmos ad=0.2128p pd=1.5u as=0.2716p ps=1.605u w=1.12u l=0.13u
X327 a_13648_9406# a_13391_9263# a_13810_9186# VGND sg13_lv_nmos ad=0.1428p pd=1.52u as=37.8f ps=0.6u w=0.42u l=0.13u
X328 sg13cmos5l_buf_1_103.A a_15784_9224# VGND VGND sg13_lv_nmos ad=0.2886p pd=2.26u as=0.14875p ps=1.16u w=0.74u l=0.13u
X329 a_17414_3138# a_18219_3260# a_17674_3361# VPWR sg13_lv_pmos ad=0.1428p pd=1.52u as=79.8f ps=0.8u w=0.42u l=0.13u
X330 sg13cmos5l_dlhr_1_6.D a_7796_6460# VGND VGND sg13_lv_nmos ad=0.2516p pd=2.16u as=0.1406p ps=1.12u w=0.74u l=0.13u
X331 VGND VPWR VGND VGND sg13_lv_nmos ad=79.8f pd=0.8u as=0 ps=0 w=0.42u l=1u
X332 a_6959_6239# a_6117_6141# a_6865_6239# VGND sg13_lv_nmos ad=0.12665p pd=1.145u as=0.1428p ps=1.52u w=0.42u l=0.13u
X333 VGND a_1580_2352# nh_sw[0] VGND sg13_lv_nmos ad=0.14875p pd=1.16u as=0.2886p ps=2.26u w=0.74u l=0.13u
X334 a_7238_7674# a_8043_7796# a_7498_7897# VPWR sg13_lv_pmos ad=0.1428p pd=1.52u as=79.8f ps=0.8u w=0.42u l=0.13u
X335 a_14543_3215# a_13701_3117# a_13284_3456# VPWR sg13_lv_pmos ad=0.2048p pd=1.63u as=0.34p ps=2.68u w=1u l=0.13u
X336 a_19412_6484# a_18999_6178# a_19344_6484# VPWR sg13_lv_pmos ad=0.191p pd=1.44u as=0.105p ps=1.21u w=1u l=0.13u
X337 sg13cmos5l_dlhr_1_15.Q a_18345_7674# VGND VGND sg13_lv_nmos ad=0.2516p pd=2.16u as=0.1406p ps=1.12u w=0.74u l=0.13u
X338 VPWR a_4652_6126# sg13cmos5l_inv_1_19.A VPWR sg13_lv_pmos ad=0.2114p pd=1.54u as=0.42p ps=2.99u w=1.12u l=0.13u
X339 VGND sg13cmos5l_dfrbp_1_6.RESET_B a_13396_7312# VGND sg13_lv_nmos ad=0.1406p pd=1.12u as=77.7f ps=0.95u w=0.74u l=0.13u
X340 VPWR a_8588_2352# nl_sw[4] VPWR sg13_lv_pmos ad=0.2114p pd=1.54u as=0.42p ps=2.99u w=1.12u l=0.13u
X341 a_15466_2356# a_15909_2399# a_15206_2826# VGND sg13_lv_nmos ad=79.8f pd=0.8u as=0.1296p ps=1.52u w=0.42u l=0.13u
X342 a_16102_4663# sg13cmos5l_dfrbp_1_8.RESET_B VGND VGND sg13_lv_nmos ad=37.8f pd=0.6u as=0.1701p ps=1.65u w=0.42u l=0.13u
X343 VPWR VGND VPWR VPWR sg13_lv_pmos ad=0.19p pd=1.38u as=0 ps=0 w=1u l=1u
X344 a_2409_4650# a_2228_4972# VPWR VPWR sg13_lv_pmos ad=0.2128p pd=1.5u as=0.2387p ps=1.84u w=1.12u l=0.13u
X345 a_13017_1941# a_12075_1748# a_12815_1703# VPWR sg13_lv_pmos ad=93.45f pd=0.865u as=0.2048p ps=1.63u w=0.42u l=0.13u
X346 a_9040_7894# sg13cmos5l_dfrbp_1_6.RESET_B VPWR VPWR sg13_lv_pmos ad=79.8f pd=0.8u as=1.12242p ps=7u w=0.42u l=0.13u
X347 a_13047_7690# sg13cmos5l_dlhr_1_11.GATE VGND VGND sg13_lv_nmos ad=0.2516p pd=2.16u as=0.15055p ps=1.17u w=0.74u l=0.13u
X348 sg13cmos5l_buf_1_2.X a_15784_1664# VPWR VPWR sg13_lv_pmos ad=0.42p pd=2.99u as=0.2114p ps=1.54u w=1.12u l=0.13u
X349 a_9524_4972# a_9242_4660# a_9457_4642# VGND sg13_lv_nmos ad=0.141p pd=1.17u as=71.99999f ps=0.865u w=0.64u l=0.13u
X350 VGND VPWR VGND VGND sg13_lv_nmos ad=79.8f pd=0.8u as=0 ps=0 w=0.42u l=1u
X351 VPWR sg13cmos5l_dfrbp_1_0.RESET_B a_11270_4338# VPWR sg13_lv_pmos ad=0.36237p pd=2.605u as=79.8f ps=0.8u w=0.42u l=0.13u
X352 VPWR a_19227_4654# sg13cmos5l_buf_8_0.X VPWR sg13_lv_pmos ad=0.3864p pd=2.93u as=0.2128p ps=1.5u w=1.12u l=0.13u
X353 VPWR sg13cmos5l_buf_1_31.X a_9448_6924# VPWR sg13_lv_pmos ad=0.2114p pd=1.54u as=0.2856p ps=2.36u w=0.84u l=0.13u
X354 a_18999_6178# sg13cmos5l_dfrbp_1_8.D VPWR VPWR sg13_lv_pmos ad=0.3234p pd=2.45u as=1.04815p ps=6.595u w=0.84u l=0.13u
X355 sg13cmos5l_dlhr_1_15.D a_17108_7972# VPWR VPWR sg13_lv_pmos ad=0.3808p pd=2.92u as=0.2128p ps=1.5u w=1.12u l=0.13u
X356 a_1484_9150# sg13cmos5l_inv_1_19.A VPWR VPWR sg13_lv_pmos ad=0.2856p pd=2.36u as=0.2114p ps=1.54u w=0.84u l=0.13u
X357 a_6959_6239# a_6117_6141# a_5700_6480# VPWR sg13_lv_pmos ad=0.2048p pd=1.63u as=0.34p ps=2.68u w=1u l=0.13u
X358 sg13cmos5l_dlhr_1_0.Q a_7689_1626# VGND VGND sg13_lv_nmos ad=0.2516p pd=2.16u as=0.1406p ps=1.12u w=0.74u l=0.13u
X359 a_15782_7362# sg13cmos5l_dfrbp_1_22.D VPWR VPWR sg13_lv_pmos ad=79.8f pd=0.8u as=0.1428p ps=1.52u w=0.42u l=0.13u
X360 a_19593_6162# a_19412_6484# VPWR VPWR sg13_lv_pmos ad=0.2128p pd=1.5u as=0.2387p ps=1.84u w=1.12u l=0.13u
X361 a_1125_6935# sg13cmos5l_dfrbp_1_15.D VPWR VPWR sg13_lv_pmos ad=0.4088p pd=2.97u as=1.04815p ps=6.595u w=1.12u l=0.13u
X362 VGND a_620_2352# nl_sw[0] VGND sg13_lv_nmos ad=0.14875p pd=1.16u as=0.2886p ps=2.26u w=0.74u l=0.13u
X363 a_5604_4338# sg13cmos5l_dfrbp_1_6.D a_5510_4338# VGND sg13_lv_nmos ad=60.89999f pd=0.71u as=0.1428p ps=1.52u w=0.42u l=0.13u
X364 a_5028_2826# sg13cmos5l_dfrbp_1_6.D a_4934_2826# VGND sg13_lv_nmos ad=60.89999f pd=0.71u as=0.1428p ps=1.52u w=0.42u l=0.13u
X365 sg13cmos5l_buf_1_104.A sg13cmos5l_buf_1_3.A VPWR VPWR sg13_lv_pmos ad=0.3808p pd=2.92u as=0.3808p ps=2.92u w=1.12u l=0.13u
X366 a_15684_4650# sg13cmos5l_dfrbp_1_8.D a_15590_4650# VGND sg13_lv_nmos ad=60.89999f pd=0.71u as=0.1428p ps=1.52u w=0.42u l=0.13u
X367 sg13cmos5l_o21ai_1_0.A1 sg13cmos5l_a221oi_1_0.C1 VGND VGND sg13_lv_nmos ad=0.2516p pd=2.16u as=0.1406p ps=1.12u w=0.74u l=0.13u
X368 a_2474_6162# a_1997_6126# a_2380_6162# VGND sg13_lv_nmos ad=37.8f pd=0.6u as=0.1428p ps=1.52u w=0.42u l=0.13u
X369 VPWR sg13cmos5l_buf_1_111.A a_18376_9224# VPWR sg13_lv_pmos ad=0.2114p pd=1.54u as=0.2856p ps=2.36u w=0.84u l=0.13u
X370 a_18097_7666# a_17545_7728# VGND VGND sg13_lv_nmos ad=71.99999f pd=0.865u as=1.49685p ps=9.6u w=0.64u l=0.13u
X371 VGND a_3447_2746# a_3578_2752# VGND sg13_lv_nmos ad=2.59257p pd=16.445u as=0.2775p ps=2.23u w=0.74u l=0.13u
X372 VPWR sg13cmos5l_dfrbp_1_6.RESET_B a_16234_6385# VPWR sg13_lv_pmos ad=0.1563p pd=1.22u as=0.147p ps=1.54u w=0.42u l=0.13u
X373 a_10665_7281# a_10484_6924# VPWR VPWR sg13_lv_pmos ad=0.2128p pd=1.5u as=0.2387p ps=1.84u w=1.12u l=0.13u
X374 VPWR sg13cmos5l_dfrbp_1_8.RESET_B a_6086_4650# VPWR sg13_lv_pmos ad=0.36237p pd=2.605u as=79.8f ps=0.8u w=0.42u l=0.13u
X375 VGND sg13cmos5l_buf_8_1.A a_16703_3871# VGND sg13_lv_nmos ad=2.41737p pd=15.64u as=0.2516p ps=2.16u w=0.74u l=0.13u
X376 VPWR sg13cmos5l_nor2_1_0.A a_13324_4696# VPWR sg13_lv_pmos ad=0.1596p pd=1.22u as=0.2856p ps=2.36u w=0.84u l=0.13u
X377 a_996_5837# a_1227_5423# a_682_5380# VGND sg13_lv_nmos ad=0.2373p pd=1.97u as=79.8f ps=0.8u w=0.42u l=0.13u
X378 a_10282_7897# a_10725_7653# a_10665_8065# VPWR sg13_lv_pmos ad=79.8f pd=0.8u as=63f ps=0.72u w=0.42u l=0.13u
X379 a_5424_3460# a_4873_3192# VPWR VPWR sg13_lv_pmos ad=0.105p pd=1.21u as=1.43437p ps=9.105u w=1u l=0.13u
X380 a_1402_3864# sg13cmos5l_dlygate4sd2_1_0.X VGND VGND sg13_lv_nmos ad=0.1428p pd=1.52u as=79.8f ps=0.8u w=0.42u l=0.13u
X381 VGND sg13cmos5l_inv_1_29.A a_12841_7728# VGND sg13_lv_nmos ad=0.15055p pd=1.17u as=0.187p ps=1.78u w=0.55u l=0.13u
X382 VPWR sg13cmos5l_dfrbp_1_21.Q a_18409_5770# VPWR sg13_lv_pmos ad=1.28962p pd=8.195u as=0.2856p ps=2.36u w=0.84u l=0.13u
X383 VPWR sg13cmos5l_dfrbp_1_10.Q_N a_3241_2746# VPWR sg13_lv_pmos ad=1.86162p pd=11.935u as=0.2856p ps=2.36u w=0.84u l=0.13u
X384 VGND a_19227_9190# sg13cmos5l_buf_8_2.X VGND sg13_lv_nmos ad=0.2516p pd=2.16u as=0.1406p ps=1.12u w=0.74u l=0.13u
X385 VGND a_10071_7282# a_10202_7288# VGND sg13_lv_nmos ad=1.49685p pd=9.6u as=0.2775p ps=2.23u w=0.74u l=0.13u
X386 VPWR a_7504_8678# a_7449_8559# VPWR sg13_lv_pmos ad=1.15047p pd=7.175u as=93.45f ps=0.865u w=0.42u l=0.13u
X387 a_4282_8112# a_3676_7964# VPWR VPWR sg13_lv_pmos ad=0.1008p pd=0.9u as=0.2387p ps=1.84u w=0.42u l=0.13u
X388 a_682_5380# a_1125_5423# a_1065_5459# VPWR sg13_lv_pmos ad=79.8f pd=0.8u as=63f ps=0.72u w=0.42u l=0.13u
X389 VPWR a_11824_7894# a_11769_7989# VPWR sg13_lv_pmos ad=1.15047p pd=7.175u as=93.45f ps=0.865u w=0.42u l=0.13u
X390 VPWR a_4425_7281# a_4358_6924# VPWR sg13_lv_pmos ad=0.2387p pd=1.84u as=0.1008p ps=0.9u w=0.42u l=0.13u
X391 a_2732_1590# sg13cmos5l_buf_1_37.A VPWR VPWR sg13_lv_pmos ad=0.2856p pd=2.36u as=0.2114p ps=1.54u w=0.84u l=0.13u
X392 a_16485_6935# sg13cmos5l_inv_1_2.A VPWR VPWR sg13_lv_pmos ad=0.4088p pd=2.97u as=1.07253p ps=6.75u w=1.12u l=0.13u
X393 a_13036_4948# a_12814_4692# VPWR VPWR sg13_lv_pmos ad=0.1176p pd=1.33u as=0.2618p ps=1.63u w=1.12u l=0.13u
X394 VGND a_18615_5770# a_18746_5776# VGND sg13_lv_nmos ad=1.97045p pd=12.335u as=0.2775p ps=2.23u w=0.74u l=0.13u
X395 VPWR a_3574_7850# sg13cmos5l_dlhr_1_9.Q_N VPWR sg13_lv_pmos ad=0.1974p pd=1.5u as=0.3808p ps=2.92u w=1.12u l=0.13u
X396 VPWR a_16271_7751# a_16528_7894# VPWR sg13_lv_pmos ad=0.2639p pd=1.81u as=79.8f ps=0.8u w=0.42u l=0.13u
X397 a_6084_4325# a_5796_3904# a_6022_4325# VGND sg13_lv_nmos ad=0.1428p pd=1.52u as=37.8f ps=0.6u w=0.42u l=0.13u
X398 VPWR a_12815_1703# a_13072_1846# VPWR sg13_lv_pmos ad=0.2639p pd=1.81u as=79.8f ps=0.8u w=0.42u l=0.13u
X399 sg13cmos5l_a22oi_1_1.B2 sg13cmos5l_dlhr_1_6.D a_13486_5760# VGND sg13_lv_nmos ad=0.2516p pd=2.16u as=0.1406p ps=1.12u w=0.74u l=0.13u
X400 a_11072_5347# sg13cmos5l_nor2_1_0.A a_11370_5760# VGND sg13_lv_nmos ad=0.2176p pd=1.96u as=0.1216p ps=1.02u w=0.64u l=0.13u
X401 VGND sg13cmos5l_buf_1_4.A a_16552_1664# VGND sg13_lv_nmos ad=0.14875p pd=1.16u as=0.187p ps=1.78u w=0.55u l=0.13u
X402 VGND a_16485_6935# a_16587_6935# VGND sg13_lv_nmos ad=1.49685p pd=9.6u as=0.2516p ps=2.16u w=0.74u l=0.13u
X403 VGND sg13cmos5l_inv_1_7.A a_12232_8436# VGND sg13_lv_nmos ad=0.14875p pd=1.16u as=0.187p ps=1.78u w=0.55u l=0.13u
X404 VGND a_8972_3864# sg13cmos5l_buf_1_45.X VGND sg13_lv_nmos ad=0.14875p pd=1.16u as=0.2886p ps=2.26u w=0.74u l=0.13u
X405 a_10308_7992# a_10827_7796# a_11567_7751# VGND sg13_lv_nmos ad=0.3473p pd=2.71u as=0.12665p ps=1.145u w=0.74u l=0.13u
X406 sg13cmos5l_dfrbp_1_22.Q_N a_17327_7285# VPWR VPWR sg13_lv_pmos ad=0.4312p pd=3.01u as=0.2639p ps=1.81u w=1.12u l=0.13u
X407 sg13cmos5l_dfrbp_1_17.Q_N a_3407_8797# VPWR VPWR sg13_lv_pmos ad=0.4312p pd=3.01u as=0.2639p ps=1.81u w=1.12u l=0.13u
X408 VPWR a_15909_2399# a_16011_2399# VPWR sg13_lv_pmos ad=1.86162p pd=11.935u as=0.3864p ps=2.93u w=1.12u l=0.13u
X409 a_16306_8874# sg13cmos5l_dfrbp_1_8.RESET_B VGND VGND sg13_lv_nmos ad=37.8f pd=0.6u as=79.8f ps=0.8u w=0.42u l=0.13u
X410 sg13cmos5l_dlhr_1_11.Q_N a_13686_7354# VGND VGND sg13_lv_nmos ad=0.2516p pd=2.16u as=0.1491p ps=1.18u w=0.74u l=0.13u
X411 sg13cmos5l_buf_1_31.X a_424_1664# VGND VGND sg13_lv_nmos ad=0.2886p pd=2.26u as=0.14875p ps=1.16u w=0.74u l=0.13u
X412 a_5069_5376# a_5799_5499# a_5710_5535# VPWR sg13_lv_pmos ad=0.2048p pd=1.63u as=93.45f ps=0.865u w=0.42u l=0.13u
X413 a_3664_8678# a_3407_8797# a_3826_8874# VGND sg13_lv_nmos ad=0.1428p pd=1.52u as=37.8f ps=0.6u w=0.42u l=0.13u
X414 a_11434_2356# a_11877_2399# a_11174_2826# VGND sg13_lv_nmos ad=79.8f pd=0.8u as=0.1296p ps=1.52u w=0.42u l=0.13u
X415 VPWR sg13cmos5l_dfrbp_1_8.RESET_B a_15590_4650# VPWR sg13_lv_pmos ad=0.36237p pd=2.605u as=79.8f ps=0.8u w=0.42u l=0.13u
X416 sg13cmos5l_buf_1_3.A a_19528_6924# VGND VGND sg13_lv_nmos ad=0.2886p pd=2.26u as=0.14875p ps=1.16u w=0.74u l=0.13u
X417 VPWR sg13cmos5l_dfrbp_1_6.D a_17399_3947# VPWR sg13_lv_pmos ad=0.1428p pd=1.52u as=79.8f ps=0.8u w=0.42u l=0.13u
X418 VPWR sg13cmos5l_buf_8_1.A a_18363_4270# VPWR sg13_lv_pmos ad=0.2128p pd=1.5u as=0.3808p ps=2.92u w=1.12u l=0.13u
X419 a_1065_6971# a_708_6928# VPWR VPWR sg13_lv_pmos ad=63f pd=0.72u as=0.1563p ps=1.22u w=0.42u l=0.13u
X420 a_17700_1639# a_17412_1944# a_17638_1639# VGND sg13_lv_nmos ad=0.1428p pd=1.52u as=37.8f ps=0.6u w=0.42u l=0.13u
X421 a_11986_7674# sg13cmos5l_dfrbp_1_6.RESET_B VGND VGND sg13_lv_nmos ad=37.8f pd=0.6u as=79.8f ps=0.8u w=0.42u l=0.13u
X422 a_7689_1626# a_7508_1948# VPWR VPWR sg13_lv_pmos ad=0.2128p pd=1.5u as=0.2387p ps=1.84u w=1.12u l=0.13u
X423 VPWR sg13cmos5l_dfrbp_1_0.RESET_B a_11530_1849# VPWR sg13_lv_pmos ad=0.1563p pd=1.22u as=0.147p ps=1.54u w=0.42u l=0.13u
X424 VPWR a_3308_5376# sg13cmos5l_buf_1_41.A VPWR sg13_lv_pmos ad=0.2114p pd=1.54u as=0.42p ps=2.99u w=1.12u l=0.13u
X425 a_16042_6892# a_16485_6935# a_16425_6971# VPWR sg13_lv_pmos ad=79.8f pd=0.8u as=63f ps=0.72u w=0.42u l=0.13u
X426 a_12420_9199# a_12132_9504# a_12358_9199# VGND sg13_lv_nmos ad=0.1428p pd=1.52u as=37.8f ps=0.6u w=0.42u l=0.13u
X427 VPWR sg13cmos5l_dfrbp_1_6.RESET_B a_5674_6385# VPWR sg13_lv_pmos ad=0.1563p pd=1.22u as=0.147p ps=1.54u w=0.42u l=0.13u
X428 VPWR a_2565_8447# a_2667_8447# VPWR sg13_lv_pmos ad=1.15047p pd=7.175u as=0.3864p ps=2.93u w=1.12u l=0.13u
X429 VPWR a_18671_1703# a_19508_1924# VPWR sg13_lv_pmos ad=0.2128p pd=1.5u as=0.3864p ps=2.93u w=1.12u l=0.13u
X430 sg13cmos5l_dlygate4sd2_1_0.X a_1290_3206# VPWR VPWR sg13_lv_pmos ad=0.3808p pd=2.92u as=0.2245p ps=1.53u w=1.12u l=0.13u
X431 VPWR a_7055_4261# a_7312_4142# VPWR sg13_lv_pmos ad=0.2639p pd=1.81u as=79.8f ps=0.8u w=0.42u l=0.13u
X432 a_4005_4629# sg13cmos5l_inv_1_8.A VPWR VPWR sg13_lv_pmos ad=0.4088p pd=2.97u as=1.2517p ps=7.955u w=1.12u l=0.13u
X433 a_934_5837# sg13cmos5l_dfrbp_1_6.RESET_B VGND VGND sg13_lv_nmos ad=37.8f pd=0.6u as=0.1701p ps=1.65u w=0.42u l=0.13u
X434 a_7378_6162# sg13cmos5l_dfrbp_1_6.RESET_B VGND VGND sg13_lv_nmos ad=37.8f pd=0.6u as=79.8f ps=0.8u w=0.42u l=0.13u
X435 VGND sg13cmos5l_buf_1_35.A a_1864_1664# VGND sg13_lv_nmos ad=0.14875p pd=1.16u as=0.187p ps=1.78u w=0.55u l=0.13u
X436 VGND a_16528_7894# a_16177_7751# VGND sg13_lv_nmos ad=79.8f pd=0.8u as=0.1428p ps=1.52u w=0.42u l=0.13u
X437 sg13cmos5l_buf_8_0.X a_19227_4654# VGND VGND sg13_lv_nmos ad=0.1406p pd=1.12u as=0.1406p ps=1.12u w=0.74u l=0.13u
X438 a_2596_7996# a_2621_7636# VPWR VPWR sg13_lv_pmos ad=0.2856p pd=2.36u as=1.15047p ps=7.175u w=0.84u l=0.13u
X439 sg13cmos5l_dfrbp_1_1.D sg13cmos5l_a22oi_1_2.B1 a_9823_2364# VPWR sg13_lv_pmos ad=0.2128p pd=1.5u as=0.2716p ps=1.605u w=1.12u l=0.13u
X440 VPWR a_13391_9263# a_14228_9484# VPWR sg13_lv_pmos ad=0.2128p pd=1.5u as=0.3864p ps=2.93u w=1.12u l=0.13u
X441 VPWR a_3599_3215# a_4436_3436# VPWR sg13_lv_pmos ad=0.2128p pd=1.5u as=0.3864p ps=2.93u w=1.12u l=0.13u
X442 VGND sg13cmos5l_or2_1_1.B a_11873_5760# VGND sg13_lv_nmos ad=0.2516p pd=2.16u as=0.1406p ps=1.12u w=0.74u l=0.13u
X443 a_17337_4965# a_16395_4772# a_17135_4727# VPWR sg13_lv_pmos ad=93.45f pd=0.865u as=0.2048p ps=1.63u w=0.42u l=0.13u
X444 VGND sg13cmos5l_dfrbp_1_6.RESET_B a_9076_5800# VGND sg13_lv_nmos ad=0.1406p pd=1.12u as=77.7f ps=0.95u w=0.74u l=0.13u
X445 sg13cmos5l_dlhr_1_17.Q_N a_9366_5842# VPWR VPWR sg13_lv_pmos ad=0.3808p pd=2.92u as=0.1974p ps=1.5u w=1.12u l=0.13u
X446 VGND VPWR VGND VGND sg13_lv_nmos ad=0.1428p pd=1.52u as=0 ps=0 w=0.42u l=1u
X447 VGND VPWR VGND VGND sg13_lv_nmos ad=79.8f pd=0.8u as=0 ps=0 w=0.42u l=1u
X448 a_6729_5041# a_6372_4968# VPWR VPWR sg13_lv_pmos ad=63f pd=0.72u as=0.1563p ps=1.22u w=0.42u l=0.13u
X449 a_16617_6553# a_16260_6480# VPWR VPWR sg13_lv_pmos ad=63f pd=0.72u as=0.1563p ps=1.22u w=0.42u l=0.13u
X450 VGND a_9033_6162# a_8988_6198# VGND sg13_lv_nmos ad=0.1428p pd=1.52u as=47.25f ps=0.645u w=0.42u l=0.13u
X451 sg13cmos5l_dlhr_1_1.Q_N a_2934_4632# VGND VGND sg13_lv_nmos ad=0.2516p pd=2.16u as=0.1491p ps=1.18u w=0.74u l=0.13u
X452 sg13cmos5l_dfrbp_1_4.D sg13cmos5l_nand2_1_1.B a_10707_2388# VPWR sg13_lv_pmos ad=0.2408p pd=1.55u as=0.1428p ps=1.375u w=1.12u l=0.13u
X453 VPWR comp_p a_424_1664# VPWR sg13_lv_pmos ad=0.2114p pd=1.54u as=0.2856p ps=2.36u w=0.84u l=0.13u
X454 nh_sw[10] a_20392_3176# VGND VGND sg13_lv_nmos ad=0.2886p pd=2.26u as=0.14875p ps=1.16u w=0.74u l=0.13u
X455 sg13cmos5l_or2_1_0.A a_18363_4270# VGND VGND sg13_lv_nmos ad=0.1406p pd=1.12u as=0.1406p ps=1.12u w=0.74u l=0.13u
X456 a_17126_1626# a_17931_1748# a_17386_1849# VPWR sg13_lv_pmos ad=0.1428p pd=1.52u as=79.8f ps=0.8u w=0.42u l=0.13u
X457 sg13cmos5l_dfrbp_1_18.Q a_8084_8436# VGND VGND sg13_lv_nmos ad=0.2516p pd=2.16u as=0.1406p ps=1.12u w=0.74u l=0.13u
X458 a_708_6928# a_1227_6935# a_1967_7285# VGND sg13_lv_nmos ad=0.3473p pd=2.71u as=0.12665p ps=1.145u w=0.74u l=0.13u
X459 sg13cmos5l_dlhr_1_5.Q_N a_8982_7354# VGND VGND sg13_lv_nmos ad=0.2516p pd=2.16u as=0.1491p ps=1.18u w=0.74u l=0.13u
X460 a_2757_3117# sg13cmos5l_dfrbp_1_9.Q VGND VGND sg13_lv_nmos ad=0.2516p pd=2.16u as=2.59257p ps=16.445u w=0.74u l=0.13u
X461 a_9456_4972# a_8905_4704# VPWR VPWR sg13_lv_pmos ad=0.105p pd=1.21u as=1.28962p ps=8.195u w=1u l=0.13u
X462 VGND sg13cmos5l_dfrbp_1_8.RESET_B a_1956_8874# VGND sg13_lv_nmos ad=0.1626p pd=1.415u as=60.89999f ps=0.71u w=0.42u l=0.13u
X463 a_19028_5412# a_18746_5776# a_18961_5814# VGND sg13_lv_nmos ad=0.141p pd=1.17u as=71.99999f ps=0.865u w=0.64u l=0.13u
X464 a_7524_7992# a_7498_7897# VGND VGND sg13_lv_nmos ad=0.2516p pd=2.16u as=0.1626p ps=1.415u w=0.74u l=0.13u
X465 a_17412_1944# a_17386_1849# VPWR VPWR sg13_lv_pmos ad=0.34p pd=2.68u as=0.36237p ps=2.605u w=1u l=0.13u
X466 a_9268_6148# a_8852_6484# a_9033_6162# VGND sg13_lv_nmos ad=77.7f pd=0.95u as=0.2516p ps=2.16u w=0.74u l=0.13u
X467 VGND a_18363_4270# sg13cmos5l_or2_1_0.A VGND sg13_lv_nmos ad=0.1406p pd=1.12u as=0.1406p ps=1.12u w=0.74u l=0.13u
X468 a_11556_1944# a_11530_1849# VGND VGND sg13_lv_nmos ad=0.2516p pd=2.16u as=0.1626p ps=1.415u w=0.74u l=0.13u
X469 VPWR a_19227_4654# sg13cmos5l_buf_8_0.X VPWR sg13_lv_pmos ad=0.2128p pd=1.5u as=0.2128p ps=1.5u w=1.12u l=0.13u
X470 VGND cks sg13cmos5l_dfrbp_1_6.RESET_B VGND sg13_lv_nmos ad=0.2516p pd=2.16u as=0.1443p ps=1.13u w=0.74u l=0.13u
X471 a_14708_6924# a_14295_7282# a_14640_6924# VPWR sg13_lv_pmos ad=0.191p pd=1.44u as=0.105p ps=1.21u w=1u l=0.13u
X472 a_15718_2813# sg13cmos5l_dfrbp_1_0.RESET_B VGND VGND sg13_lv_nmos ad=37.8f pd=0.6u as=0.1701p ps=1.65u w=0.42u l=0.13u
X473 a_2340_3456# a_2314_3361# VPWR VPWR sg13_lv_pmos ad=0.34p pd=2.68u as=0.36237p ps=2.605u w=1u l=0.13u
X474 sg13cmos5l_buf_8_2.X a_19227_9190# VPWR VPWR sg13_lv_pmos ad=0.2128p pd=1.5u as=0.2128p ps=1.5u w=1.12u l=0.13u
X475 a_2386_7362# sg13cmos5l_dfrbp_1_6.RESET_B VGND VGND sg13_lv_nmos ad=37.8f pd=0.6u as=79.8f ps=0.8u w=0.42u l=0.13u
X476 VPWR sg13cmos5l_buf_8_0.X a_20392_7712# VPWR sg13_lv_pmos ad=0.2114p pd=1.54u as=0.2856p ps=2.36u w=0.84u l=0.13u
X477 a_2596_7996# a_2621_7636# VGND VGND sg13_lv_nmos ad=0.2775p pd=2.23u as=1.49685p ps=9.6u w=0.74u l=0.13u
X478 VGND sg13cmos5l_buf_1_30.A a_8680_1664# VGND sg13_lv_nmos ad=0.14875p pd=1.16u as=0.187p ps=1.78u w=0.55u l=0.13u
X479 a_17750_4325# a_16572_4261# a_17354_4180# VGND sg13_lv_nmos ad=37.8f pd=0.6u as=0.1428p ps=1.52u w=0.42u l=0.13u
X480 a_16268_3102# sg13cmos5l_buf_1_2.X VGND VGND sg13_lv_nmos ad=0.187p pd=1.78u as=0.14875p ps=1.16u w=0.55u l=0.13u
X481 sg13cmos5l_dfrbp_1_23.Q_N a_13775_6239# VGND VGND sg13_lv_nmos ad=0.2849p pd=2.25u as=0.2516p ps=2.16u w=0.74u l=0.13u
X482 a_13284_3456# a_13258_3361# VGND VGND sg13_lv_nmos ad=0.2516p pd=2.16u as=0.1626p ps=1.415u w=0.74u l=0.13u
X483 VGND sg13cmos5l_inv_1_29.A sg13cmos5l_inv_1_29.Y VGND sg13_lv_nmos ad=0.2516p pd=2.16u as=0.2516p ps=2.16u w=0.74u l=0.13u
X484 a_2831_7630# sg13cmos5l_dfrbp_1_16.Q_N VPWR VPWR sg13_lv_pmos ad=0.2856p pd=2.36u as=1.15047p ps=7.175u w=0.84u l=0.13u
X485 VGND sg13cmos5l_buf_1_3.A a_20296_1664# VGND sg13_lv_nmos ad=0.14875p pd=1.16u as=0.187p ps=1.78u w=0.55u l=0.13u
X486 VPWR sg13cmos5l_buf_1_41.X a_2824_2388# VPWR sg13_lv_pmos ad=0.2114p pd=1.54u as=0.2856p ps=2.36u w=0.84u l=0.13u
X487 VGND sg13cmos5l_buf_1_8.X a_11656_3176# VGND sg13_lv_nmos ad=0.14875p pd=1.16u as=0.187p ps=1.78u w=0.55u l=0.13u
X488 a_19412_6484# a_19130_6172# a_19345_6154# VGND sg13_lv_nmos ad=0.141p pd=1.17u as=71.99999f ps=0.865u w=0.64u l=0.13u
X489 a_16068_6162# sg13cmos5l_buf_1_57.X a_15974_6162# VGND sg13_lv_nmos ad=60.89999f pd=0.71u as=0.1428p ps=1.52u w=0.42u l=0.13u
X490 VPWR sg13cmos5l_buf_1_65.X a_8488_9224# VPWR sg13_lv_pmos ad=0.2114p pd=1.54u as=0.2856p ps=2.36u w=0.84u l=0.13u
X491 VGND sg13cmos5l_buf_1_76.X a_5416_9224# VGND sg13_lv_nmos ad=0.14875p pd=1.16u as=0.187p ps=1.78u w=0.55u l=0.13u
X492 VPWR sg13cmos5l_dfrbp_1_6.RESET_B a_9705_4650# VPWR sg13_lv_pmos ad=0.2128p pd=1.5u as=0.2128p ps=1.5u w=1.12u l=0.13u
X493 VGND a_15821_3864# sg13cmos5l_dfrbp_1_6.Q_N VGND sg13_lv_nmos ad=0.2516p pd=2.16u as=0.2849p ps=2.25u w=0.74u l=0.13u
X494 a_9260_2352# sg13cmos5l_buf_1_30.X VGND VGND sg13_lv_nmos ad=0.187p pd=1.78u as=0.14875p ps=1.16u w=0.55u l=0.13u
X495 VPWR sg13cmos5l_inv_1_19.A sg13cmos5l_buf_1_32.A VPWR sg13_lv_pmos ad=0.3808p pd=2.92u as=0.3808p ps=2.92u w=1.12u l=0.13u
X496 VPWR sg13cmos5l_dfrbp_1_6.RESET_B a_5510_4338# VPWR sg13_lv_pmos ad=0.36237p pd=2.605u as=79.8f ps=0.8u w=0.42u l=0.13u
X497 VPWR sg13cmos5l_buf_1_4.A sg13cmos5l_buf_1_110.A VPWR sg13_lv_pmos ad=0.3808p pd=2.92u as=0.3808p ps=2.92u w=1.12u l=0.13u
X498 a_10292_9508# a_9879_9202# a_10224_9508# VPWR sg13_lv_pmos ad=0.191p pd=1.44u as=0.105p ps=1.21u w=1u l=0.13u
X499 VGND a_10031_8797# a_10868_8436# VGND sg13_lv_nmos ad=0.1406p pd=1.12u as=0.2516p ps=2.16u w=0.74u l=0.13u
X500 VPWR sg13cmos5l_buf_8_0.A a_19227_4654# VPWR sg13_lv_pmos ad=0.2128p pd=1.5u as=0.3808p ps=2.92u w=1.12u l=0.13u
X501 VPWR a_7631_4727# a_8468_4948# VPWR sg13_lv_pmos ad=0.2128p pd=1.5u as=0.3864p ps=2.93u w=1.12u l=0.13u
X502 VPWR sg13cmos5l_inv_1_3.A a_15016_9224# VPWR sg13_lv_pmos ad=0.2114p pd=1.54u as=0.2856p ps=2.36u w=0.84u l=0.13u
X503 sg13cmos5l_dfrbp_1_8.RESET_B cks VGND VGND sg13_lv_nmos ad=0.2516p pd=2.16u as=0.2516p ps=2.16u w=0.74u l=0.13u
X504 VGND a_3212_1590# sg13cmos5l_buf_1_41.X VGND sg13_lv_nmos ad=0.14875p pd=1.16u as=0.2886p ps=2.26u w=0.74u l=0.13u
X505 VGND VPWR VGND VGND sg13_lv_nmos ad=79.8f pd=0.8u as=0 ps=0 w=0.42u l=1u
X506 a_2148_3904# a_2122_3868# VPWR VPWR sg13_lv_pmos ad=0.34p pd=2.68u as=0.36237p ps=2.605u w=1u l=0.13u
X507 sg13cmos5l_buf_1_4.A a_15592_6200# VGND VGND sg13_lv_nmos ad=0.2886p pd=2.26u as=0.14875p ps=1.16u w=0.74u l=0.13u
X508 VGND a_19227_9190# sg13cmos5l_buf_8_2.X VGND sg13_lv_nmos ad=0.1406p pd=1.12u as=0.1406p ps=1.12u w=0.74u l=0.13u
X509 VPWR VGND VPWR VPWR sg13_lv_pmos ad=0.19p pd=1.38u as=0 ps=0 w=1u l=1u
X510 a_11460_2392# a_11434_2356# VGND VGND sg13_lv_nmos ad=0.2516p pd=2.16u as=0.1626p ps=1.415u w=0.74u l=0.13u
X511 a_2757_3117# sg13cmos5l_dfrbp_1_9.Q VPWR VPWR sg13_lv_pmos ad=0.4088p pd=2.97u as=1.38655p ps=8.8u w=1.12u l=0.13u
X512 a_14342_8874# sg13cmos5l_dfrbp_1_23.CLK VPWR VPWR sg13_lv_pmos ad=79.8f pd=0.8u as=0.1428p ps=1.52u w=0.42u l=0.13u
X513 sg13cmos5l_dlhr_1_17.Q_N a_9366_5842# VGND VGND sg13_lv_nmos ad=0.2516p pd=2.16u as=0.1491p ps=1.18u w=0.74u l=0.13u
X514 VPWR a_5069_5376# sg13cmos5l_dfrbp_1_29.Q_N VPWR sg13_lv_pmos ad=0.2639p pd=1.81u as=0.4312p ps=3.01u w=1.12u l=0.13u
X515 a_15238_7687# sg13cmos5l_dfrbp_1_6.RESET_B VGND VGND sg13_lv_nmos ad=37.8f pd=0.6u as=0.1701p ps=1.65u w=0.42u l=0.13u
X516 VGND VPWR VGND VGND sg13_lv_nmos ad=79.8f pd=0.8u as=0 ps=0 w=0.42u l=1u
X517 a_5820_5773# a_5951_5383# a_5069_5376# VPWR sg13_lv_pmos ad=0.34p pd=2.68u as=0.2048p ps=1.63u w=1u l=0.13u
X518 a_8841_5769# a_8660_5412# VPWR VPWR sg13_lv_pmos ad=0.2128p pd=1.5u as=0.2387p ps=1.84u w=1.12u l=0.13u
X519 a_2732_9150# sg13cmos5l_inv_1_20.Y VGND VGND sg13_lv_nmos ad=0.187p pd=1.78u as=0.14875p ps=1.16u w=0.55u l=0.13u
X520 a_15206_2826# sg13cmos5l_nor2b_1_1.Y VPWR VPWR sg13_lv_pmos ad=79.8f pd=0.8u as=0.1428p ps=1.52u w=0.42u l=0.13u
X521 VPWR sg13cmos5l_dfrbp_1_8.RESET_B a_2122_3868# VPWR sg13_lv_pmos ad=0.1563p pd=1.22u as=0.147p ps=1.54u w=0.42u l=0.13u
X522 a_15012_7992# a_14986_7897# VGND VGND sg13_lv_nmos ad=0.2516p pd=2.16u as=0.1626p ps=1.415u w=0.74u l=0.13u
X523 VPWR a_4041_2745# a_4566_2818# VPWR sg13_lv_pmos ad=0.1974p pd=1.5u as=0.2856p ps=2.36u w=0.84u l=0.13u
X524 a_1125_5423# sg13cmos5l_dlhr_1_1.GATE VGND VGND sg13_lv_nmos ad=0.2516p pd=2.16u as=1.97045p ps=12.335u w=0.74u l=0.13u
X525 ph_sw[4] a_6568_9224# VGND VGND sg13_lv_nmos ad=0.2886p pd=2.26u as=0.14875p ps=1.16u w=0.74u l=0.13u
X526 VPWR sg13cmos5l_nand2_1_1.B a_10464_2427# VPWR sg13_lv_pmos ad=0.2891p pd=1.695u as=0.1596p ps=1.22u w=0.84u l=0.13u
X527 a_11913_3947# a_11556_3904# VPWR VPWR sg13_lv_pmos ad=63f pd=0.72u as=0.1563p ps=1.22u w=0.42u l=0.13u
X528 VPWR a_3831_7282# a_3962_7288# VPWR sg13_lv_pmos ad=1.07253p pd=6.75u as=0.2856p ps=2.36u w=0.84u l=0.13u
X529 a_13574_8112# a_13178_7684# a_13460_7996# VPWR sg13_lv_pmos ad=0.1008p pd=0.9u as=0.191p ps=1.44u w=0.42u l=0.13u
X530 a_1878_6337# a_1997_6126# VPWR VPWR sg13_lv_pmos ad=0.3864p pd=2.93u as=0.2128p ps=1.5u w=1.12u l=0.13u
X531 a_13418_4696# sg13cmos5l_nor2_1_0.A a_13324_4696# VGND sg13_lv_nmos ad=0.1216p pd=1.02u as=0.2176p ps=1.96u w=0.64u l=0.13u
X532 a_6372_4968# a_6346_4873# VPWR VPWR sg13_lv_pmos ad=0.34p pd=2.68u as=0.36237p ps=2.605u w=1u l=0.13u
X533 VGND cks sg13cmos5l_dfrbp_1_6.RESET_B VGND sg13_lv_nmos ad=0.1406p pd=1.12u as=0.1406p ps=1.12u w=0.74u l=0.13u
X534 VGND cks a_19227_9190# VGND sg13_lv_nmos ad=0.1406p pd=1.12u as=0.2553p ps=2.17u w=0.74u l=0.13u
X535 VPWR sg13cmos5l_dfrbp_1_12.Q_N a_8905_4704# VPWR sg13_lv_pmos ad=1.28962p pd=8.195u as=0.2856p ps=2.36u w=0.84u l=0.13u
X536 a_1484_6126# sg13cmos5l_buf_1_58.A VPWR VPWR sg13_lv_pmos ad=0.2856p pd=2.36u as=0.2114p ps=1.54u w=0.84u l=0.13u
X537 sg13cmos5l_dlhr_1_2.Q a_7497_3138# VPWR VPWR sg13_lv_pmos ad=0.3808p pd=2.92u as=0.2128p ps=1.5u w=1.12u l=0.13u
X538 sg13cmos5l_buf_8_2.X a_19227_9190# VPWR VPWR sg13_lv_pmos ad=0.2128p pd=1.5u as=0.2128p ps=1.5u w=1.12u l=0.13u
X539 VGND a_2409_4650# a_2934_4632# VGND sg13_lv_nmos ad=0.1491p pd=1.18u as=0.187p ps=1.78u w=0.55u l=0.13u
X540 a_18860_6888# sg13cmos5l_buf_1_87.A VGND VGND sg13_lv_nmos ad=0.187p pd=1.78u as=0.14875p ps=1.16u w=0.55u l=0.13u
X541 VGND a_19244_2352# nl_sw[9] VGND sg13_lv_nmos ad=0.14875p pd=1.16u as=0.2886p ps=2.26u w=0.74u l=0.13u
X542 VGND VPWR VGND VGND sg13_lv_nmos ad=0.1428p pd=1.52u as=0 ps=0 w=0.42u l=1u
X543 a_5508_6162# sg13cmos5l_dfrbp_1_6.D a_5414_6162# VGND sg13_lv_nmos ad=60.89999f pd=0.71u as=0.1428p ps=1.52u w=0.42u l=0.13u
X544 sg13cmos5l_dfrbp_1_6.RESET_B cks VPWR VPWR sg13_lv_pmos ad=0.2128p pd=1.5u as=0.2128p ps=1.5u w=1.12u l=0.13u
X545 VPWR a_3407_4261# a_4244_3900# VPWR sg13_lv_pmos ad=0.2128p pd=1.5u as=0.3864p ps=2.93u w=1.12u l=0.13u
X546 VGND sg13cmos5l_or2_1_0.A a_18480_5028# VGND sg13_lv_nmos ad=0.1469p pd=1.155u as=0.1045p ps=0.93u w=0.55u l=0.13u
X547 VGND a_5637_2399# a_5739_2399# VGND sg13_lv_nmos ad=2.59257p pd=16.445u as=0.2516p ps=2.16u w=0.74u l=0.13u
X548 a_7508_1948# a_7226_1636# a_7441_1618# VGND sg13_lv_nmos ad=0.141p pd=1.17u as=71.99999f ps=0.865u w=0.64u l=0.13u
X549 VGND a_3664_8678# a_3313_8797# VGND sg13_lv_nmos ad=79.8f pd=0.8u as=0.1428p ps=1.52u w=0.42u l=0.13u
X550 VPWR a_13076_5376# a_13034_5412# VPWR sg13_lv_pmos ad=0.2618p pd=1.63u as=0.1176p ps=1.33u w=1.12u l=0.13u
X551 VPWR a_16268_1590# nl_sw[7] VPWR sg13_lv_pmos ad=0.2114p pd=1.54u as=0.42p ps=2.99u w=1.12u l=0.13u
X552 VPWR sg13cmos5l_dfrbp_1_0.RESET_B a_11270_1626# VPWR sg13_lv_pmos ad=0.36237p pd=2.605u as=79.8f ps=0.8u w=0.42u l=0.13u
X553 sg13cmos5l_dfrbp_1_10.Q_N a_3599_3215# VGND VGND sg13_lv_nmos ad=0.2849p pd=2.25u as=0.2516p ps=2.16u w=0.74u l=0.13u
X554 a_3588_4968# a_4107_4772# a_4847_4727# VGND sg13_lv_nmos ad=0.3473p pd=2.71u as=0.12665p ps=1.145u w=0.74u l=0.13u
X555 a_14929_5814# a_14377_5770# VGND VGND sg13_lv_nmos ad=71.99999f pd=0.865u as=1.97045p ps=12.335u w=0.64u l=0.13u
X556 VPWR a_10665_7281# a_11190_7354# VPWR sg13_lv_pmos ad=0.1974p pd=1.5u as=0.2856p ps=2.36u w=0.84u l=0.13u
X557 a_3792_2388# a_3241_2746# VPWR VPWR sg13_lv_pmos ad=0.105p pd=1.21u as=1.86162p ps=11.935u w=1u l=0.13u
X558 VPWR a_17132_9150# ph_sw[7] VPWR sg13_lv_pmos ad=0.2114p pd=1.54u as=0.42p ps=2.99u w=1.12u l=0.13u
X559 VPWR sg13cmos5l_inv_1_17.A sg13cmos5l_buf_1_37.A VPWR sg13_lv_pmos ad=0.3808p pd=2.92u as=0.3808p ps=2.92u w=1.12u l=0.13u
X560 a_18959_3215# a_18117_3117# a_18865_3215# VGND sg13_lv_nmos ad=0.12665p pd=1.145u as=0.1428p ps=1.52u w=0.42u l=0.13u
X561 a_6188_1590# sg13cmos5l_buf_1_25.A VPWR VPWR sg13_lv_pmos ad=0.2856p pd=2.36u as=0.2114p ps=1.54u w=0.84u l=0.13u
X562 nh_sw[2] a_3688_1664# VGND VGND sg13_lv_nmos ad=0.2886p pd=2.26u as=0.14875p ps=1.16u w=0.74u l=0.13u
X563 sg13cmos5l_dfrbp_1_2.Q_N a_12815_4261# VGND VGND sg13_lv_nmos ad=0.2849p pd=2.25u as=0.2516p ps=2.16u w=0.74u l=0.13u
X564 a_6789_4629# sg13cmos5l_inv_1_8.A VPWR VPWR sg13_lv_pmos ad=0.4088p pd=2.97u as=1.2517p ps=7.955u w=1.12u l=0.13u
X565 a_708_5416# a_682_5380# VGND VGND sg13_lv_nmos ad=0.2516p pd=2.16u as=0.1626p ps=1.415u w=0.74u l=0.13u
X566 VPWR sg13cmos5l_buf_1_105.A a_18856_8436# VPWR sg13_lv_pmos ad=0.2114p pd=1.54u as=0.2856p ps=2.36u w=0.84u l=0.13u
X567 a_15876_4968# a_15850_4873# VPWR VPWR sg13_lv_pmos ad=0.34p pd=2.68u as=0.36237p ps=2.605u w=1u l=0.13u
X568 ph_sw[3] a_5416_9224# VPWR VPWR sg13_lv_pmos ad=0.42p pd=2.99u as=0.2114p ps=1.54u w=1.12u l=0.13u
X569 a_19227_9190# cks VPWR VPWR sg13_lv_pmos ad=0.2128p pd=1.5u as=0.2128p ps=1.5u w=1.12u l=0.13u
X570 VPWR sg13cmos5l_dfrbp_1_0.RESET_B a_11174_2826# VPWR sg13_lv_pmos ad=0.36237p pd=2.605u as=79.8f ps=0.8u w=0.42u l=0.13u
X571 a_16298_4338# a_15821_3864# a_16204_4338# VGND sg13_lv_nmos ad=37.8f pd=0.6u as=0.1428p ps=1.52u w=0.42u l=0.13u
X572 sg13cmos5l_dfrbp_1_23.Q a_14612_6460# VGND VGND sg13_lv_nmos ad=0.2516p pd=2.16u as=0.1406p ps=1.12u w=0.74u l=0.13u
X573 a_14800_3358# a_14543_3215# a_14962_3138# VGND sg13_lv_nmos ad=0.1428p pd=1.52u as=37.8f ps=0.6u w=0.42u l=0.13u
X574 sg13cmos5l_buf_1_8.A sg13cmos5l_inv_1_7.A VGND VGND sg13_lv_nmos ad=0.2516p pd=2.16u as=0.2516p ps=2.16u w=0.74u l=0.13u
X575 sg13cmos5l_dfrbp_1_0.Q_N a_18671_1703# VGND VGND sg13_lv_nmos ad=0.2849p pd=2.25u as=0.2516p ps=2.16u w=0.74u l=0.13u
X576 VGND sg13cmos5l_inv_1_28.Y a_11464_9224# VGND sg13_lv_nmos ad=0.14875p pd=1.16u as=0.187p ps=1.78u w=0.55u l=0.13u
X577 a_19142_5412# a_18746_5776# a_19028_5412# VPWR sg13_lv_pmos ad=0.1008p pd=0.9u as=0.191p ps=1.44u w=0.42u l=0.13u
X578 VPWR a_4076_5376# sg13cmos5l_inv_1_17.A VPWR sg13_lv_pmos ad=0.2114p pd=1.54u as=0.42p ps=2.99u w=1.12u l=0.13u
X579 sg13cmos5l_dfrbp_1_24.Q_N a_13391_9263# VGND VGND sg13_lv_nmos ad=0.2849p pd=2.25u as=0.2516p ps=2.16u w=0.74u l=0.13u
X580 a_8580_8874# sg13cmos5l_dfrbp_1_18.Q a_8486_8874# VGND sg13_lv_nmos ad=60.89999f pd=0.71u as=0.1428p ps=1.52u w=0.42u l=0.13u
X581 VGND a_11567_7751# a_12404_7972# VGND sg13_lv_nmos ad=0.1406p pd=1.12u as=0.2516p ps=2.16u w=0.74u l=0.13u
X582 VPWR a_10028_6126# sg13cmos5l_inv_1_18.A VPWR sg13_lv_pmos ad=0.2114p pd=1.54u as=0.42p ps=2.99u w=1.12u l=0.13u
X583 a_5770_3868# a_6213_3911# a_5510_4338# VGND sg13_lv_nmos ad=79.8f pd=0.8u as=0.1296p ps=1.52u w=0.42u l=0.13u
X584 VPWR sg13cmos5l_dfrbp_1_6.RESET_B a_16204_4338# VPWR sg13_lv_pmos ad=1.38655p pd=8.8u as=79.8f ps=0.8u w=0.42u l=0.13u
X585 a_18959_3215# a_18117_3117# a_17700_3456# VPWR sg13_lv_pmos ad=0.2048p pd=1.63u as=0.34p ps=2.68u w=1u l=0.13u
X586 a_2306_7660# sg13cmos5l_dfrbp_1_6.RESET_B VGND VGND sg13_lv_nmos ad=77.7f pd=0.95u as=0.1406p ps=1.12u w=0.74u l=0.13u
X587 sg13cmos5l_buf_1_98.A a_13641_7674# VGND VGND sg13_lv_nmos ad=0.2516p pd=2.16u as=0.1406p ps=1.12u w=0.74u l=0.13u
X588 a_16473_7989# a_15531_7796# a_16271_7751# VPWR sg13_lv_pmos ad=93.45f pd=0.865u as=0.2048p ps=1.63u w=0.42u l=0.13u
X589 VPWR sg13cmos5l_buf_1_24.X a_5704_1664# VPWR sg13_lv_pmos ad=0.2114p pd=1.54u as=0.2856p ps=2.36u w=0.84u l=0.13u
X590 a_2348_7624# a_2621_7636# a_2583_7710# VGND sg13_lv_nmos ad=0.141p pd=1.17u as=47.25f ps=0.645u w=0.42u l=0.13u
X591 sg13cmos5l_dlhr_1_6.Q_N a_9558_6144# VPWR VPWR sg13_lv_pmos ad=0.3808p pd=2.92u as=0.1974p ps=1.5u w=1.12u l=0.13u
X592 a_17493_3947# a_16551_3987# a_17399_3947# VPWR sg13_lv_pmos ad=79.8f pd=0.8u as=0.1428p ps=1.52u w=0.42u l=0.13u
X593 VPWR a_1967_5773# a_2804_5412# VPWR sg13_lv_pmos ad=0.2128p pd=1.5u as=0.3864p ps=2.93u w=1.12u l=0.13u
X594 sg13cmos5l_or2_1_0.A a_18363_4270# VPWR VPWR sg13_lv_pmos ad=0.2128p pd=1.5u as=0.2128p ps=1.5u w=1.12u l=0.13u
X595 VGND a_524_4614# ckc VGND sg13_lv_nmos ad=0.14875p pd=1.16u as=0.2886p ps=2.26u w=0.74u l=0.13u
X596 VGND a_13641_7674# a_13596_7710# VGND sg13_lv_nmos ad=0.1428p pd=1.52u as=47.25f ps=0.645u w=0.42u l=0.13u
X597 VGND sg13cmos5l_dfrbp_1_8.RESET_B a_15876_7362# VGND sg13_lv_nmos ad=0.1626p pd=1.415u as=60.89999f ps=0.71u w=0.42u l=0.13u
X598 a_13396_7312# a_12980_6924# a_13161_7281# VGND sg13_lv_nmos ad=77.7f pd=0.95u as=0.2516p ps=2.16u w=0.74u l=0.13u
X599 VPWR a_17008_2630# a_16953_2511# VPWR sg13_lv_pmos ad=1.86162p pd=11.935u as=93.45f ps=0.865u w=0.42u l=0.13u
X600 VPWR VGND VPWR VPWR sg13_lv_pmos ad=0.34p pd=2.68u as=0 ps=0 w=1u l=1u
X601 VPWR sg13cmos5l_buf_1_61.X a_1000_9224# VPWR sg13_lv_pmos ad=0.2114p pd=1.54u as=0.2856p ps=2.36u w=0.84u l=0.13u
X602 a_15887_8797# a_15045_8447# a_14628_8440# VPWR sg13_lv_pmos ad=0.2048p pd=1.63u as=0.34p ps=2.68u w=1u l=0.13u
X603 a_6741_5459# sg13cmos5l_dfrbp_1_8.RESET_B VPWR VPWR sg13_lv_pmos ad=0.147p pd=1.54u as=0.1563p ps=1.22u w=0.42u l=0.13u
X604 VGND a_7941_7653# a_8043_7796# VGND sg13_lv_nmos ad=1.49685p pd=9.6u as=0.2516p ps=2.16u w=0.74u l=0.13u
X605 a_4172_1590# sg13cmos5l_buf_1_38.A VPWR VPWR sg13_lv_pmos ad=0.2856p pd=2.36u as=0.2114p ps=1.54u w=0.84u l=0.13u
X606 a_13076_5376# sg13cmos5l_inv_1_0.A VGND VGND sg13_lv_nmos ad=0.187p pd=1.78u as=0.17255p ps=1.25u w=0.55u l=0.13u
X607 a_9060_8861# a_8772_8440# a_8998_8861# VGND sg13_lv_nmos ad=0.1428p pd=1.52u as=37.8f ps=0.6u w=0.42u l=0.13u
X608 VPWR sg13cmos5l_dfrbp_1_6.RESET_B a_17961_8793# VPWR sg13_lv_pmos ad=0.2128p pd=1.5u as=0.2128p ps=1.5u w=1.12u l=0.13u
X609 VPWR a_18363_4270# sg13cmos5l_or2_1_0.A VPWR sg13_lv_pmos ad=0.2128p pd=1.5u as=0.2128p ps=1.5u w=1.12u l=0.13u
X610 a_17132_9150# sg13cmos5l_buf_1_94.X VPWR VPWR sg13_lv_pmos ad=0.2856p pd=2.36u as=0.2114p ps=1.54u w=0.84u l=0.13u
X611 VPWR a_18928_1846# a_18873_1941# VPWR sg13_lv_pmos ad=1.86162p pd=11.935u as=93.45f ps=0.865u w=0.42u l=0.13u
X612 sg13cmos5l_dfrbp_1_16.Q_N a_1967_7285# VPWR VPWR sg13_lv_pmos ad=0.4312p pd=3.01u as=0.2639p ps=1.81u w=1.12u l=0.13u
X613 a_2565_3911# sg13cmos5l_inv_1_8.A VGND VGND sg13_lv_nmos ad=0.2516p pd=2.16u as=2.27517p ps=14.72u w=0.74u l=0.13u
X614 sg13cmos5l_buf_1_107.X a_17896_9224# VGND VGND sg13_lv_nmos ad=0.2886p pd=2.26u as=0.14875p ps=1.16u w=0.74u l=0.13u
X615 VPWR a_17961_8793# a_17894_8436# VPWR sg13_lv_pmos ad=0.2387p pd=1.84u as=0.1008p ps=0.9u w=0.42u l=0.13u
X616 VPWR a_13100_8400# pl_sw[6] VPWR sg13_lv_pmos ad=0.2114p pd=1.54u as=0.42p ps=2.99u w=1.12u l=0.13u
X617 VGND sg13cmos5l_dfrbp_1_6.RESET_B a_19828_6148# VGND sg13_lv_nmos ad=0.1406p pd=1.12u as=77.7f ps=0.95u w=0.74u l=0.13u
X618 a_12216_5728# sg13cmos5l_or2_1_1.B a_12358_5388# VPWR sg13_lv_pmos ad=0.2856p pd=2.36u as=0.1596p ps=1.22u w=0.84u l=0.13u
X619 VPWR sg13cmos5l_dfrbp_1_6.RESET_B a_422_5850# VPWR sg13_lv_pmos ad=0.36237p pd=2.605u as=79.8f ps=0.8u w=0.42u l=0.13u
X620 a_13460_7996# a_13047_7690# a_13392_7996# VPWR sg13_lv_pmos ad=0.191p pd=1.44u as=0.105p ps=1.21u w=1u l=0.13u
X621 VPWR a_2409_4650# a_2342_5088# VPWR sg13_lv_pmos ad=0.2387p pd=1.84u as=0.1008p ps=0.9u w=0.42u l=0.13u
X622 a_15974_6162# a_16779_6284# a_16234_6385# VPWR sg13_lv_pmos ad=0.1428p pd=1.52u as=79.8f ps=0.8u w=0.42u l=0.13u
X623 a_7257_4023# a_6315_3911# a_7055_4261# VPWR sg13_lv_pmos ad=93.45f pd=0.865u as=0.2048p ps=1.63u w=0.42u l=0.13u
X624 a_13648_9406# sg13cmos5l_dfrbp_1_8.RESET_B VPWR VPWR sg13_lv_pmos ad=79.8f pd=0.8u as=4.11675p ps=27.17u w=0.42u l=0.13u
X625 VPWR a_11567_7751# a_11824_7894# VPWR sg13_lv_pmos ad=0.2639p pd=1.81u as=79.8f ps=0.8u w=0.42u l=0.13u
X626 a_10071_7282# sg13cmos5l_dfrbp_1_18.Q VPWR VPWR sg13_lv_pmos ad=0.3234p pd=2.45u as=1.07253p ps=6.75u w=0.84u l=0.13u
X627 VPWR sg13cmos5l_buf_1_33.A a_2248_1664# VPWR sg13_lv_pmos ad=0.2114p pd=1.54u as=0.2856p ps=2.36u w=0.84u l=0.13u
X628 VGND VPWR VGND VGND sg13_lv_nmos ad=79.8f pd=0.8u as=0 ps=0 w=0.42u l=1u
X629 VPWR a_14032_6382# a_13977_6477# VPWR sg13_lv_pmos ad=1.07253p pd=6.75u as=93.45f ps=0.865u w=0.42u l=0.13u
X630 sg13cmos5l_buf_1_8.X a_10888_1664# VGND VGND sg13_lv_nmos ad=0.2886p pd=2.26u as=0.14875p ps=1.16u w=0.74u l=0.13u
X631 VPWR a_9033_6162# a_9558_6144# VPWR sg13_lv_pmos ad=0.1974p pd=1.5u as=0.2856p ps=2.36u w=0.84u l=0.13u
X632 a_682_6892# a_1125_6935# a_1065_6971# VPWR sg13_lv_pmos ad=79.8f pd=0.8u as=63f ps=0.72u w=0.42u l=0.13u
X633 a_15884_3102# sg13cmos5l_buf_1_5.X VGND VGND sg13_lv_nmos ad=0.187p pd=1.78u as=0.14875p ps=1.16u w=0.55u l=0.13u
X634 a_15110_5412# a_14714_5776# a_14996_5412# VPWR sg13_lv_pmos ad=0.1008p pd=0.9u as=0.191p ps=1.44u w=0.42u l=0.13u
X635 VPWR sg13cmos5l_dfrbp_1_6.RESET_B a_15974_6162# VPWR sg13_lv_pmos ad=0.36237p pd=2.605u as=79.8f ps=0.8u w=0.42u l=0.13u
X636 VGND a_3692_9150# sg13cmos5l_buf_1_62.X VGND sg13_lv_nmos ad=0.14875p pd=1.16u as=0.2886p ps=2.26u w=0.74u l=0.13u
X637 a_8772_8440# a_9291_8447# a_10031_8797# VGND sg13_lv_nmos ad=0.3473p pd=2.71u as=0.12665p ps=1.145u w=0.74u l=0.13u
X638 a_7238_7674# sg13cmos5l_dfrbp_1_6.D VPWR VPWR sg13_lv_pmos ad=79.8f pd=0.8u as=0.1428p ps=1.52u w=0.42u l=0.13u
X639 a_6346_4873# a_6789_4629# a_6729_5041# VPWR sg13_lv_pmos ad=79.8f pd=0.8u as=63f ps=0.72u w=0.42u l=0.13u
X640 VPWR sg13cmos5l_buf_8_1.A a_16703_3871# VPWR sg13_lv_pmos ad=1.43437p pd=9.105u as=0.4088p ps=2.97u w=1.12u l=0.13u
X641 VGND a_5673_3138# a_5628_3174# VGND sg13_lv_nmos ad=0.1428p pd=1.52u as=47.25f ps=0.645u w=0.42u l=0.13u
X642 sg13cmos5l_buf_1_90.X a_11464_9224# VPWR VPWR sg13_lv_pmos ad=0.42p pd=2.99u as=0.2114p ps=1.54u w=1.12u l=0.13u
X643 a_13641_7674# a_13460_7996# VPWR VPWR sg13_lv_pmos ad=0.2128p pd=1.5u as=0.2387p ps=1.84u w=1.12u l=0.13u
X644 sg13cmos5l_nor2b_1_1.Y a_14254_2444# VGND VGND sg13_lv_nmos ad=0.1406p pd=1.12u as=0.17255p ps=1.25u w=0.74u l=0.13u
X645 d_out[2] a_20392_3900# VGND VGND sg13_lv_nmos ad=0.2886p pd=2.26u as=0.14875p ps=1.16u w=0.74u l=0.13u
X646 a_12719_2749# a_11877_2399# a_11460_2392# VPWR sg13_lv_pmos ad=0.2048p pd=1.63u as=0.34p ps=2.68u w=1u l=0.13u
X647 a_12976_2630# sg13cmos5l_dfrbp_1_0.RESET_B VPWR VPWR sg13_lv_pmos ad=79.8f pd=0.8u as=1.777p ps=11.395u w=0.42u l=0.13u
X648 a_10726_5760# sg13cmos5l_dfrbp_1_20.Q sg13cmos5l_a22oi_1_2.B2 VGND sg13_lv_nmos ad=0.1406p pd=1.12u as=0.2516p ps=2.16u w=0.74u l=0.13u
X649 sg13cmos5l_buf_1_65.X a_424_8436# VPWR VPWR sg13_lv_pmos ad=0.42p pd=2.99u as=0.2114p ps=1.54u w=1.12u l=0.13u
X650 a_8439_6178# sg13cmos5l_dlhr_1_5.GATE VPWR VPWR sg13_lv_pmos ad=0.3234p pd=2.45u as=1.04815p ps=6.595u w=0.84u l=0.13u
X651 VGND VPWR VGND VGND sg13_lv_nmos ad=0.1428p pd=1.52u as=0 ps=0 w=0.42u l=1u
X652 VPWR a_7941_7653# a_8043_7796# VPWR sg13_lv_pmos ad=1.15047p pd=7.175u as=0.3864p ps=2.93u w=1.12u l=0.13u
X653 a_16293_4629# sg13cmos5l_inv_1_2.A VGND VGND sg13_lv_nmos ad=0.2516p pd=2.16u as=2.41737p ps=15.64u w=0.74u l=0.13u
X654 a_9638_5088# a_9242_4660# a_9524_4972# VPWR sg13_lv_pmos ad=0.1008p pd=0.9u as=0.191p ps=1.44u w=0.42u l=0.13u
X655 VGND sg13cmos5l_inv_1_1.A a_16264_9224# VGND sg13_lv_nmos ad=0.14875p pd=1.16u as=0.187p ps=1.78u w=0.55u l=0.13u
X656 a_5908_3124# a_5492_3460# a_5673_3138# VGND sg13_lv_nmos ad=77.7f pd=0.95u as=0.2516p ps=2.16u w=0.74u l=0.13u
X657 a_9033_6162# a_8852_6484# VPWR VPWR sg13_lv_pmos ad=0.2128p pd=1.5u as=0.2387p ps=1.84u w=1.12u l=0.13u
X658 sg13cmos5l_dfrbp_1_17.D a_1662_8374# VPWR VPWR sg13_lv_pmos ad=0.3927p pd=2.99u as=1.15047p ps=7.175u w=1.155u l=0.13u
X659 sg13cmos5l_dfrbp_1_15.D a_4244_8436# VGND VGND sg13_lv_nmos ad=0.2516p pd=2.16u as=0.1406p ps=1.12u w=0.74u l=0.13u
X660 VPWR VGND VPWR VPWR sg13_lv_pmos ad=0.34p pd=2.68u as=0 ps=0 w=1u l=1u
X661 a_6405_8447# sg13cmos5l_inv_1_8.A VGND VGND sg13_lv_nmos ad=0.2516p pd=2.16u as=2.71505p ps=17.54u w=0.74u l=0.13u
X662 VPWR a_16485_6935# a_16587_6935# VPWR sg13_lv_pmos ad=1.07253p pd=6.75u as=0.3864p ps=2.93u w=1.12u l=0.13u
X663 sg13cmos5l_dlhr_1_0.Q a_7689_1626# VPWR VPWR sg13_lv_pmos ad=0.3808p pd=2.92u as=0.2128p ps=1.5u w=1.12u l=0.13u
X664 a_8204_9150# sg13cmos5l_buf_1_45.X VGND VGND sg13_lv_nmos ad=0.187p pd=1.78u as=0.14875p ps=1.16u w=0.55u l=0.13u
X665 VPWR a_20012_1590# sg13cmos5l_buf_1_0.X VPWR sg13_lv_pmos ad=0.2114p pd=1.54u as=0.42p ps=2.99u w=1.12u l=0.13u
X666 a_10288_8678# sg13cmos5l_dfrbp_1_8.RESET_B VPWR VPWR sg13_lv_pmos ad=79.8f pd=0.8u as=1.12242p ps=7u w=0.42u l=0.13u
X667 VGND sg13cmos5l_dlhr_1_12.D a_17161_8794# VGND sg13_lv_nmos ad=0.15055p pd=1.17u as=0.187p ps=1.78u w=0.55u l=0.13u
X668 a_7316_3460# a_6903_3154# a_7248_3460# VPWR sg13_lv_pmos ad=0.191p pd=1.44u as=0.105p ps=1.21u w=1u l=0.13u
X669 VPWR a_7888_4870# a_7833_4965# VPWR sg13_lv_pmos ad=1.28962p pd=8.195u as=93.45f ps=0.865u w=0.42u l=0.13u
X670 VGND sg13cmos5l_a221oi_1_1.C1 sg13cmos5l_a22oi_1_2.B2 VGND sg13_lv_nmos ad=0.1406p pd=1.12u as=0.2516p ps=2.16u w=0.74u l=0.13u
X671 a_9060_8861# a_9291_8447# a_8746_8404# VGND sg13_lv_nmos ad=0.2373p pd=1.97u as=79.8f ps=0.8u w=0.42u l=0.13u
X672 VGND sg13cmos5l_buf_1_34.A a_4840_1664# VGND sg13_lv_nmos ad=0.14875p pd=1.16u as=0.187p ps=1.78u w=0.55u l=0.13u
X673 VPWR a_12815_1703# a_13652_1924# VPWR sg13_lv_pmos ad=0.2128p pd=1.5u as=0.3864p ps=2.93u w=1.12u l=0.13u
X674 VGND a_1158_3142# a_1290_3206# VGND sg13_lv_nmos ad=0.1405p pd=1.15u as=0.2163p ps=1.87u w=0.42u l=0.18u
X675 sg13cmos5l_dfrbp_1_20.Q_N a_8783_7751# VPWR VPWR sg13_lv_pmos ad=0.4312p pd=3.01u as=0.2639p ps=1.81u w=1.12u l=0.13u
X676 a_6903_3154# sg13cmos5l_dlhr_1_0.GATE VGND VGND sg13_lv_nmos ad=0.2516p pd=2.16u as=0.15055p ps=1.17u w=0.74u l=0.13u
X677 sg13cmos5l_dfrbp_1_25.Q_N a_15887_8797# VPWR VPWR sg13_lv_pmos ad=0.4312p pd=3.01u as=0.2639p ps=1.81u w=1.12u l=0.13u
X678 a_2638_6162# a_2879_6432# a_1997_6126# VGND sg13_lv_nmos ad=0.1428p pd=1.52u as=0.12665p ps=1.145u w=0.42u l=0.13u
X679 VGND a_4425_7281# a_4380_7326# VGND sg13_lv_nmos ad=0.1428p pd=1.52u as=47.25f ps=0.645u w=0.42u l=0.13u
X680 a_6372_4968# a_6891_4772# a_7631_4727# VGND sg13_lv_nmos ad=0.3473p pd=2.71u as=0.12665p ps=1.145u w=0.74u l=0.13u
X681 VGND VPWR VGND VGND sg13_lv_nmos ad=0.1428p pd=1.52u as=0 ps=0 w=0.42u l=1u
X682 VPWR sg13cmos5l_buf_1_5.A a_14440_1664# VPWR sg13_lv_pmos ad=0.2114p pd=1.54u as=0.2856p ps=2.36u w=0.84u l=0.13u
X683 VPWR a_5132_3864# sg13cmos5l_buf_1_44.X VPWR sg13_lv_pmos ad=0.2114p pd=1.54u as=0.42p ps=2.99u w=1.12u l=0.13u
X684 VPWR VGND VPWR VPWR sg13_lv_pmos ad=0.34p pd=2.68u as=0 ps=0 w=1u l=1u
X685 a_10900_7312# a_10484_6924# a_10665_7281# VGND sg13_lv_nmos ad=77.7f pd=0.95u as=0.2516p ps=2.16u w=0.74u l=0.13u
X686 a_10331_3900# sg13cmos5l_nand2_1_1.B sg13cmos5l_a22oi_1_1.B1 VPWR sg13_lv_pmos ad=0.2128p pd=1.5u as=0.3808p ps=2.92u w=1.12u l=0.13u
X687 VPWR sg13cmos5l_dfrbp_1_6.RESET_B a_5414_6162# VPWR sg13_lv_pmos ad=0.36237p pd=2.605u as=79.8f ps=0.8u w=0.42u l=0.13u
X688 sg13cmos5l_dfrbp_1_16.Q a_2804_6924# VPWR VPWR sg13_lv_pmos ad=0.3808p pd=2.92u as=0.2128p ps=1.5u w=1.12u l=0.13u
X689 a_9076_5800# a_8660_5412# a_8841_5769# VGND sg13_lv_nmos ad=77.7f pd=0.95u as=0.2516p ps=2.16u w=0.74u l=0.13u
X690 a_14726_7674# sg13cmos5l_buf_1_57.X VPWR VPWR sg13_lv_pmos ad=79.8f pd=0.8u as=0.1428p ps=1.52u w=0.42u l=0.13u
X691 a_16233_5041# a_15876_4968# VPWR VPWR sg13_lv_pmos ad=63f pd=0.72u as=0.1563p ps=1.22u w=0.42u l=0.13u
X692 a_5220_2392# a_5739_2399# a_6479_2749# VGND sg13_lv_nmos ad=0.3473p pd=2.71u as=0.12665p ps=1.145u w=0.74u l=0.13u
X693 a_14602_8404# a_15045_8447# a_14985_8483# VPWR sg13_lv_pmos ad=79.8f pd=0.8u as=63f ps=0.72u w=0.42u l=0.13u
X694 a_11556_1944# a_11530_1849# VPWR VPWR sg13_lv_pmos ad=0.34p pd=2.68u as=0.36237p ps=2.605u w=1u l=0.13u
X695 VPWR sg13cmos5l_dfrbp_1_6.RESET_B a_5673_3138# VPWR sg13_lv_pmos ad=0.2128p pd=1.5u as=0.2128p ps=1.5u w=1.12u l=0.13u
X696 a_19628_2352# sg13cmos5l_buf_1_19.X VGND VGND sg13_lv_nmos ad=0.187p pd=1.78u as=0.14875p ps=1.16u w=0.55u l=0.13u
X697 VPWR sg13cmos5l_inv_1_29.A sg13cmos5l_inv_1_29.Y VPWR sg13_lv_pmos ad=0.3808p pd=2.92u as=0.3808p ps=2.92u w=1.12u l=0.13u
X698 sg13cmos5l_buf_1_40.X a_1192_1664# VPWR VPWR sg13_lv_pmos ad=0.42p pd=2.99u as=0.2114p ps=1.54u w=1.12u l=0.13u
X699 VPWR sg13cmos5l_buf_1_104.A a_19624_8436# VPWR sg13_lv_pmos ad=0.2114p pd=1.54u as=0.2856p ps=2.36u w=0.84u l=0.13u
X700 sg13cmos5l_buf_1_18.X a_18376_2388# VGND VGND sg13_lv_nmos ad=0.2886p pd=2.26u as=0.14875p ps=1.16u w=0.74u l=0.13u
X701 a_17399_3947# a_16703_3871# a_17493_3947# VGND sg13_lv_nmos ad=0.1296p pd=1.52u as=79.8f ps=0.8u w=0.42u l=0.13u
X702 sg13cmos5l_nand2_1_0.A sg13cmos5l_dfrbp_1_0.Q VGND VGND sg13_lv_nmos ad=0.1406p pd=1.12u as=0.2516p ps=2.16u w=0.74u l=0.13u
X703 VGND sg13cmos5l_o21ai_1_0.A1 a_12022_3134# VGND sg13_lv_nmos ad=0.1406p pd=1.12u as=0.2516p ps=2.16u w=0.74u l=0.15u
X704 sg13cmos5l_dfrbp_1_8.D a_18164_6924# VPWR VPWR sg13_lv_pmos ad=0.3808p pd=2.92u as=0.2128p ps=1.5u w=1.12u l=0.13u
X705 VPWR sg13cmos5l_dfrbp_1_6.RESET_B a_5194_2356# VPWR sg13_lv_pmos ad=0.1563p pd=1.22u as=0.147p ps=1.54u w=0.42u l=0.13u
X706 a_17700_3456# a_17674_3361# VGND VGND sg13_lv_nmos ad=0.2516p pd=2.16u as=0.1626p ps=1.415u w=0.74u l=0.13u
X707 sg13cmos5l_dlhr_1_19.Q_N a_15702_5842# VPWR VPWR sg13_lv_pmos ad=0.3808p pd=2.92u as=0.1974p ps=1.5u w=1.12u l=0.13u
X708 sg13cmos5l_dfrbp_1_4.Q_N a_12719_2749# VPWR VPWR sg13_lv_pmos ad=0.4312p pd=3.01u as=0.2639p ps=1.81u w=1.12u l=0.13u
X709 a_1580_2352# sg13cmos5l_buf_1_40.X VPWR VPWR sg13_lv_pmos ad=0.2856p pd=2.36u as=0.2114p ps=1.54u w=0.84u l=0.13u
X710 VGND sg13cmos5l_dfrbp_1_6.RESET_B a_7332_7674# VGND sg13_lv_nmos ad=0.1626p pd=1.415u as=60.89999f ps=0.71u w=0.42u l=0.13u
X711 sg13cmos5l_buf_1_101.X a_16264_9224# VPWR VPWR sg13_lv_pmos ad=0.42p pd=2.99u as=0.2114p ps=1.54u w=1.12u l=0.13u
X712 VGND VPWR VGND VGND sg13_lv_nmos ad=0.1428p pd=1.52u as=0 ps=0 w=0.42u l=1u
X713 a_19209_5769# a_19028_5412# VPWR VPWR sg13_lv_pmos ad=0.2128p pd=1.5u as=0.2387p ps=1.84u w=1.12u l=0.13u
X714 a_7452_3174# a_6903_3154# a_7316_3460# VGND sg13_lv_nmos ad=47.25f pd=0.645u as=0.141p ps=1.17u w=0.42u l=0.13u
X715 VGND a_4847_4727# a_5684_4948# VGND sg13_lv_nmos ad=0.1406p pd=1.12u as=0.2516p ps=2.16u w=0.74u l=0.13u
X716 VGND a_14800_3358# a_14449_3215# VGND sg13_lv_nmos ad=79.8f pd=0.8u as=0.1428p ps=1.52u w=0.42u l=0.13u
X717 VPWR a_12216_5728# sg13cmos5l_a221oi_1_0.B1 VPWR sg13_lv_pmos ad=0.2226p pd=1.535u as=0.3976p ps=2.95u w=1.12u l=0.13u
X718 a_11844_1639# a_12075_1748# a_11530_1849# VGND sg13_lv_nmos ad=0.2373p pd=1.97u as=79.8f ps=0.8u w=0.42u l=0.13u
X719 a_2148_3904# a_2667_3911# a_3407_4261# VGND sg13_lv_nmos ad=0.3473p pd=2.71u as=0.12665p ps=1.145u w=0.74u l=0.13u
X720 a_18960_5412# a_18409_5770# VPWR VPWR sg13_lv_pmos ad=0.105p pd=1.21u as=1.28962p ps=8.195u w=1u l=0.13u
X721 a_19345_6154# a_18793_6216# VGND VGND sg13_lv_nmos ad=71.99999f pd=0.865u as=1.97045p ps=12.335u w=0.64u l=0.13u
X722 VGND VPWR VGND VGND sg13_lv_nmos ad=0.1428p pd=1.52u as=0 ps=0 w=0.42u l=1u
X723 a_11530_3868# a_11973_3911# a_11913_3947# VPWR sg13_lv_pmos ad=79.8f pd=0.8u as=63f ps=0.72u w=0.42u l=0.13u
X724 VPWR a_8204_2352# sg13cmos5l_buf_1_24.A VPWR sg13_lv_pmos ad=0.2114p pd=1.54u as=0.42p ps=2.99u w=1.12u l=0.13u
X725 a_6057_6553# a_5700_6480# VPWR VPWR sg13_lv_pmos ad=63f pd=0.72u as=0.1563p ps=1.22u w=0.42u l=0.13u
X726 VGND a_13161_7281# a_13686_7354# VGND sg13_lv_nmos ad=0.1491p pd=1.18u as=0.187p ps=1.78u w=0.55u l=0.13u
X727 sg13cmos5l_nor2_1_1.A a_17588_2388# VPWR VPWR sg13_lv_pmos ad=0.3808p pd=2.92u as=0.2128p ps=1.5u w=1.12u l=0.13u
X728 VPWR a_9705_4650# a_10230_4632# VPWR sg13_lv_pmos ad=0.1974p pd=1.5u as=0.2856p ps=2.36u w=0.84u l=0.13u
X729 a_16548_6175# a_16260_6480# a_16486_6175# VGND sg13_lv_nmos ad=0.1428p pd=1.52u as=37.8f ps=0.6u w=0.42u l=0.13u
X730 VGND sg13cmos5l_dfrbp_1_0.RESET_B a_15300_2826# VGND sg13_lv_nmos ad=0.1626p pd=1.415u as=60.89999f ps=0.71u w=0.42u l=0.13u
X731 a_3447_2746# sg13cmos5l_dfrbp_1_9.Q VPWR VPWR sg13_lv_pmos ad=0.3234p pd=2.45u as=1.86162p ps=11.935u w=0.84u l=0.13u
X732 a_2436_8861# a_2667_8447# a_2122_8404# VGND sg13_lv_nmos ad=0.2373p pd=1.97u as=79.8f ps=0.8u w=0.42u l=0.13u
X733 VPWR sg13cmos5l_buf_1_4.A a_16552_1664# VPWR sg13_lv_pmos ad=0.2114p pd=1.54u as=0.2856p ps=2.36u w=0.84u l=0.13u
X734 VPWR a_17367_8794# a_17498_8800# VPWR sg13_lv_pmos ad=1.15047p pd=7.175u as=0.2856p ps=2.36u w=0.84u l=0.13u
X735 a_620_2352# sg13cmos5l_buf_1_32.X VPWR VPWR sg13_lv_pmos ad=0.2856p pd=2.36u as=0.2114p ps=1.54u w=0.84u l=0.13u
X736 a_18146_4338# sg13cmos5l_dfrbp_1_6.RESET_B VGND VGND sg13_lv_nmos ad=60.89999f pd=0.71u as=0.1626p ps=1.415u w=0.42u l=0.13u
X737 a_3669_6320# a_2727_6380# a_3575_6553# VPWR sg13_lv_pmos ad=79.8f pd=0.8u as=0.1428p ps=1.52u w=0.42u l=0.13u
X738 a_12815_4261# a_11973_3911# a_12721_4261# VGND sg13_lv_nmos ad=0.12665p pd=1.145u as=0.1428p ps=1.52u w=0.42u l=0.13u
X739 VGND sg13cmos5l_buf_1_60.X a_2248_9224# VGND sg13_lv_nmos ad=0.14875p pd=1.16u as=0.187p ps=1.78u w=0.55u l=0.13u
X740 VPWR VGND VPWR VPWR sg13_lv_pmos ad=0.19p pd=1.38u as=0 ps=0 w=1u l=1u
X741 a_10308_7992# a_10282_7897# VGND VGND sg13_lv_nmos ad=0.2516p pd=2.16u as=0.1626p ps=1.415u w=0.74u l=0.13u
X742 ph_sw[1] a_1864_9224# VGND VGND sg13_lv_nmos ad=0.2886p pd=2.26u as=0.14875p ps=1.16u w=0.74u l=0.13u
X743 a_18671_1703# a_17829_1605# a_18577_1703# VGND sg13_lv_nmos ad=0.12665p pd=1.145u as=0.1428p ps=1.52u w=0.42u l=0.13u
X744 a_6741_5459# a_5799_5499# a_6602_5692# VGND sg13_lv_nmos ad=79.8f pd=0.8u as=0.2373p ps=1.97u w=0.42u l=0.13u
X745 VPWR a_17519_6239# a_18356_6460# VPWR sg13_lv_pmos ad=0.2128p pd=1.5u as=0.3864p ps=2.93u w=1.12u l=0.13u
X746 VPWR a_1196_8400# sg13cmos5l_buf_1_63.X VPWR sg13_lv_pmos ad=0.2114p pd=1.54u as=0.42p ps=2.99u w=1.12u l=0.13u
X747 a_17780_8436# a_17498_8800# a_17713_8838# VGND sg13_lv_nmos ad=0.141p pd=1.17u as=71.99999f ps=0.865u w=0.64u l=0.13u
X748 VGND a_3676_7964# sg13cmos5l_dlhr_1_9.Q VGND sg13_lv_nmos ad=0.1406p pd=1.12u as=0.2516p ps=2.16u w=0.74u l=0.13u
X749 sg13cmos5l_dfrbp_1_20.Q a_9620_7972# VPWR VPWR sg13_lv_pmos ad=0.3808p pd=2.92u as=0.2128p ps=1.5u w=1.12u l=0.13u
X750 sg13cmos5l_dfrbp_1_22.D a_16724_8436# VPWR VPWR sg13_lv_pmos ad=0.3808p pd=2.92u as=0.2128p ps=1.5u w=1.12u l=0.13u
X751 a_3676_7964# a_4076_7624# a_4034_7660# VGND sg13_lv_nmos ad=0.2516p pd=2.16u as=77.7f ps=0.95u w=0.74u l=0.13u
X752 a_13391_9263# a_12549_9165# a_13297_9263# VGND sg13_lv_nmos ad=0.12665p pd=1.145u as=0.1428p ps=1.52u w=0.42u l=0.13u
X753 VGND sg13cmos5l_inv_1_26.Y a_17896_9224# VGND sg13_lv_nmos ad=0.14875p pd=1.16u as=0.187p ps=1.78u w=0.55u l=0.13u
X754 a_18615_5770# sg13cmos5l_dfrbp_1_8.D VPWR VPWR sg13_lv_pmos ad=0.3234p pd=2.45u as=1.28962p ps=8.195u w=0.84u l=0.13u
X755 a_1862_4338# a_2667_3911# a_2122_3868# VPWR sg13_lv_pmos ad=0.1428p pd=1.52u as=79.8f ps=0.8u w=0.42u l=0.13u
X756 VGND a_8588_3864# sg13cmos5l_buf_1_30.A VGND sg13_lv_nmos ad=0.14875p pd=1.16u as=0.2886p ps=2.26u w=0.74u l=0.13u
X757 a_16677_6141# sg13cmos5l_dfrbp_1_8.D VGND VGND sg13_lv_nmos ad=0.2516p pd=2.16u as=1.97045p ps=12.335u w=0.74u l=0.13u
X758 VPWR a_12549_9165# a_12651_9308# VPWR sg13_lv_pmos ad=4.11675p pd=27.17u as=0.3864p ps=2.93u w=1.12u l=0.13u
X759 VGND a_17961_8793# a_17916_8838# VGND sg13_lv_nmos ad=0.1428p pd=1.52u as=47.25f ps=0.645u w=0.42u l=0.13u
X760 nl_sw[1] a_1864_1664# VPWR VPWR sg13_lv_pmos ad=0.42p pd=2.99u as=0.2114p ps=1.54u w=1.12u l=0.13u
X761 VGND sg13cmos5l_dfrbp_1_6.RESET_B a_15124_7312# VGND sg13_lv_nmos ad=0.1406p pd=1.12u as=77.7f ps=0.95u w=0.74u l=0.13u
X762 a_18671_1703# a_17829_1605# a_17412_1944# VPWR sg13_lv_pmos ad=0.2048p pd=1.63u as=0.34p ps=2.68u w=1u l=0.13u
X763 a_10783_4292# sg13cmos5l_a22oi_1_0.B1 VGND VGND sg13_lv_nmos ad=0.13875p pd=1.115u as=0.2553p ps=2.17u w=0.74u l=0.13u
X764 a_8276_6924# a_7863_7282# a_8208_6924# VPWR sg13_lv_pmos ad=0.191p pd=1.44u as=0.105p ps=1.21u w=1u l=0.13u
X765 a_13572_3151# a_13284_3456# a_13510_3151# VGND sg13_lv_nmos ad=0.1428p pd=1.52u as=37.8f ps=0.6u w=0.42u l=0.13u
X766 a_20204_5376# sg13cmos5l_dlhr_1_16.Q VGND VGND sg13_lv_nmos ad=0.187p pd=1.78u as=0.14875p ps=1.16u w=0.55u l=0.13u
X767 a_3609_8559# a_2667_8447# a_3407_8797# VPWR sg13_lv_pmos ad=93.45f pd=0.865u as=0.2048p ps=1.63u w=0.42u l=0.13u
X768 VPWR a_4847_4727# a_5104_4870# VPWR sg13_lv_pmos ad=0.2639p pd=1.81u as=79.8f ps=0.8u w=0.42u l=0.13u
X769 sg13cmos5l_dfrbp_1_6.RESET_B cks VPWR VPWR sg13_lv_pmos ad=0.2128p pd=1.5u as=0.2128p ps=1.5u w=1.12u l=0.13u
X770 VPWR sg13cmos5l_buf_1_35.A a_1864_1664# VPWR sg13_lv_pmos ad=0.2114p pd=1.54u as=0.2856p ps=2.36u w=0.84u l=0.13u
X771 a_3664_4142# sg13cmos5l_dfrbp_1_8.RESET_B VPWR VPWR sg13_lv_pmos ad=79.8f pd=0.8u as=1.43437p ps=9.105u w=0.42u l=0.13u
X772 sg13cmos5l_dlhr_1_19.Q_N a_15702_5842# VGND VGND sg13_lv_nmos ad=0.2516p pd=2.16u as=0.1491p ps=1.18u w=0.74u l=0.13u
X773 a_15132_5814# a_14583_5770# a_14996_5412# VGND sg13_lv_nmos ad=47.25f pd=0.645u as=0.141p ps=1.17u w=0.42u l=0.13u
X774 sg13cmos5l_buf_1_95.X a_12232_8436# VPWR VPWR sg13_lv_pmos ad=0.42p pd=2.99u as=0.2114p ps=1.54u w=1.12u l=0.13u
X775 a_16260_6480# a_16234_6385# VPWR VPWR sg13_lv_pmos ad=0.34p pd=2.68u as=0.36237p ps=2.605u w=1u l=0.13u
X776 a_9189_8447# sg13cmos5l_inv_1_2.A VGND VGND sg13_lv_nmos ad=0.2516p pd=2.16u as=2.71505p ps=17.54u w=0.74u l=0.13u
X777 a_3599_3215# a_2757_3117# a_2340_3456# VPWR sg13_lv_pmos ad=0.2048p pd=1.63u as=0.34p ps=2.68u w=1u l=0.13u
X778 a_8785_6154# a_8233_6216# VGND VGND sg13_lv_nmos ad=71.99999f pd=0.865u as=1.97045p ps=12.335u w=0.64u l=0.13u
X779 VGND sg13cmos5l_buf_8_0.X a_20392_7712# VGND sg13_lv_nmos ad=0.14875p pd=1.16u as=0.187p ps=1.78u w=0.55u l=0.13u
X780 sg13cmos5l_dfrbp_1_1.Q_N a_12815_1703# VGND VGND sg13_lv_nmos ad=0.2849p pd=2.25u as=0.2516p ps=2.16u w=0.74u l=0.13u
X781 a_15177_5769# a_14996_5412# VPWR VPWR sg13_lv_pmos ad=0.2128p pd=1.5u as=0.2387p ps=1.84u w=1.12u l=0.13u
X782 a_17776_6382# sg13cmos5l_dfrbp_1_6.RESET_B VPWR VPWR sg13_lv_pmos ad=79.8f pd=0.8u as=1.04815p ps=6.595u w=0.42u l=0.13u
X783 VPWR a_12933_6141# a_13035_6284# VPWR sg13_lv_pmos ad=1.07253p pd=6.75u as=0.3864p ps=2.93u w=1.12u l=0.13u
X784 a_5577_2435# a_5220_2392# VPWR VPWR sg13_lv_pmos ad=63f pd=0.72u as=0.1563p ps=1.22u w=0.42u l=0.13u
X785 VPWR a_3669_6320# a_2748_6126# VPWR sg13_lv_pmos ad=0.36237p pd=2.605u as=0.34p ps=2.68u w=1u l=0.13u
X786 a_3692_9150# sg13cmos5l_inv_1_17.A VGND VGND sg13_lv_nmos ad=0.187p pd=1.78u as=0.14875p ps=1.16u w=0.55u l=0.13u
X787 VGND sg13cmos5l_dfrbp_1_21.Q_N a_18793_6216# VGND sg13_lv_nmos ad=0.15055p pd=1.17u as=0.187p ps=1.78u w=0.55u l=0.13u
X788 VPWR a_2348_7624# a_1948_7964# VPWR sg13_lv_pmos ad=0.2387p pd=1.84u as=0.2128p ps=1.5u w=1.12u l=0.13u
X789 a_1210_4654# sg13cmos5l_inv_1_8.Y sg13cmos5l_dlygate4sd2_1_0.A VGND sg13_lv_nmos ad=0.1406p pd=1.12u as=0.2516p ps=2.16u w=0.74u l=0.13u
X790 a_5988_6175# a_5700_6480# a_5926_6175# VGND sg13_lv_nmos ad=0.1428p pd=1.52u as=37.8f ps=0.6u w=0.42u l=0.13u
X791 VPWR a_9164_1590# sg13cmos5l_buf_1_26.X VPWR sg13_lv_pmos ad=0.2114p pd=1.54u as=0.42p ps=2.99u w=1.12u l=0.13u
X792 sg13cmos5l_dfrbp_1_3.Q_N a_18959_3215# VPWR VPWR sg13_lv_pmos ad=0.4312p pd=3.01u as=0.2639p ps=1.81u w=1.12u l=0.13u
X793 a_8972_9150# sg13cmos5l_buf_1_77.A VGND VGND sg13_lv_nmos ad=0.187p pd=1.78u as=0.14875p ps=1.16u w=0.55u l=0.13u
X794 a_5799_5499# a_5951_5383# VGND VGND sg13_lv_nmos ad=0.2516p pd=2.16u as=1.97045p ps=12.335u w=0.74u l=0.13u
X795 VPWR a_6959_6239# a_7796_6460# VPWR sg13_lv_pmos ad=0.2128p pd=1.5u as=0.3864p ps=2.93u w=1.12u l=0.13u
X796 VPWR a_2732_9150# sg13cmos5l_buf_1_61.X VPWR sg13_lv_pmos ad=0.2114p pd=1.54u as=0.42p ps=2.99u w=1.12u l=0.13u
X797 sg13cmos5l_nor2b_1_0.Y sg13cmos5l_inv_1_0.A a_13036_4948# VPWR sg13_lv_pmos ad=0.3808p pd=2.92u as=0.1176p ps=1.33u w=1.12u l=0.13u
X798 a_7820_9150# sg13cmos5l_buf_1_73.A VGND VGND sg13_lv_nmos ad=0.187p pd=1.78u as=0.14875p ps=1.16u w=0.55u l=0.13u
X799 VPWR VGND VPWR VPWR sg13_lv_pmos ad=0.19p pd=1.38u as=0 ps=0 w=1u l=1u
X800 a_10707_2388# sg13cmos5l_nor2_1_0.A VPWR VPWR sg13_lv_pmos ad=0.1428p pd=1.375u as=0.2891p ps=1.695u w=1.12u l=0.13u
X801 sg13cmos5l_dfrbp_1_11.Q a_8468_4948# VGND VGND sg13_lv_nmos ad=0.2516p pd=2.16u as=0.1406p ps=1.12u w=0.74u l=0.13u
X802 a_7631_4727# a_6789_4629# a_7537_4727# VGND sg13_lv_nmos ad=0.12665p pd=1.145u as=0.1428p ps=1.52u w=0.42u l=0.13u
X803 a_3407_4261# a_2565_3911# a_3313_4261# VGND sg13_lv_nmos ad=0.12665p pd=1.145u as=0.1428p ps=1.52u w=0.42u l=0.13u
X804 VPWR sg13cmos5l_buf_1_30.A a_8680_1664# VPWR sg13_lv_pmos ad=0.2114p pd=1.54u as=0.2856p ps=2.36u w=0.84u l=0.13u
X805 a_5492_3460# a_5079_3154# a_5424_3460# VPWR sg13_lv_pmos ad=0.191p pd=1.44u as=0.105p ps=1.21u w=1u l=0.13u
X806 a_7863_7282# sg13cmos5l_dlhr_1_5.GATE VGND VGND sg13_lv_nmos ad=0.2516p pd=2.16u as=0.15055p ps=1.17u w=0.74u l=0.13u
X807 a_14800_3358# sg13cmos5l_dfrbp_1_0.RESET_B VPWR VPWR sg13_lv_pmos ad=79.8f pd=0.8u as=1.38655p ps=8.8u w=0.42u l=0.13u
X808 pl_sw[2] a_2248_9224# VPWR VPWR sg13_lv_pmos ad=0.42p pd=2.99u as=0.2114p ps=1.54u w=1.12u l=0.13u
X809 a_2148_8440# a_2122_8404# VGND VGND sg13_lv_nmos ad=0.2516p pd=2.16u as=0.1626p ps=1.415u w=0.74u l=0.13u
X810 a_6117_6141# sg13cmos5l_dlhr_1_5.GATE VGND VGND sg13_lv_nmos ad=0.2516p pd=2.16u as=1.97045p ps=12.335u w=0.74u l=0.13u
X811 a_16268_3102# sg13cmos5l_buf_1_2.X VPWR VPWR sg13_lv_pmos ad=0.2856p pd=2.36u as=0.2114p ps=1.54u w=0.84u l=0.13u
X812 sg13cmos5l_buf_1_1.A a_14056_1664# VPWR VPWR sg13_lv_pmos ad=0.42p pd=2.99u as=0.2114p ps=1.54u w=1.12u l=0.13u
X813 VPWR sg13cmos5l_dfrbp_1_8.RESET_B a_16042_6892# VPWR sg13_lv_pmos ad=0.1563p pd=1.22u as=0.147p ps=1.54u w=0.42u l=0.13u
X814 a_14583_5770# sg13cmos5l_dfrbp_1_23.CLK VPWR VPWR sg13_lv_pmos ad=0.3234p pd=2.45u as=1.28962p ps=8.195u w=0.84u l=0.13u
X815 VPWR a_3599_3215# a_3856_3358# VPWR sg13_lv_pmos ad=0.2639p pd=1.81u as=79.8f ps=0.8u w=0.42u l=0.13u
X816 VPWR sg13cmos5l_buf_1_3.A a_20296_1664# VPWR sg13_lv_pmos ad=0.2114p pd=1.54u as=0.2856p ps=2.36u w=0.84u l=0.13u
X817 VPWR sg13cmos5l_buf_1_8.X a_11656_3176# VPWR sg13_lv_pmos ad=0.2114p pd=1.54u as=0.2856p ps=2.36u w=0.84u l=0.13u
X818 VPWR a_1815_4666# a_1946_4660# VPWR sg13_lv_pmos ad=1.28962p pd=8.195u as=0.2856p ps=2.36u w=0.84u l=0.13u
X819 VPWR sg13cmos5l_nand2_1_2.B sg13cmos5l_dlygate4sd2_1_0.A VPWR sg13_lv_pmos ad=0.3808p pd=2.92u as=0.2128p ps=1.5u w=1.12u l=0.13u
X820 VPWR a_908_1590# sg13cmos5l_buf_1_32.X VPWR sg13_lv_pmos ad=0.2114p pd=1.54u as=0.42p ps=2.99u w=1.12u l=0.13u
X821 a_15492_2392# a_15466_2356# VPWR VPWR sg13_lv_pmos ad=0.34p pd=2.68u as=0.36237p ps=2.605u w=1u l=0.13u
X822 VPWR sg13cmos5l_buf_1_76.X a_5416_9224# VPWR sg13_lv_pmos ad=0.2114p pd=1.54u as=0.2856p ps=2.36u w=0.84u l=0.13u
X823 sg13cmos5l_dlhr_1_5.Q a_8457_7281# VGND VGND sg13_lv_nmos ad=0.2516p pd=2.16u as=0.1406p ps=1.12u w=0.74u l=0.13u
X824 a_3831_7282# sg13cmos5l_dfrbp_1_15.D VPWR VPWR sg13_lv_pmos ad=0.3234p pd=2.45u as=1.04815p ps=6.595u w=0.84u l=0.13u
X825 VGND a_8841_5769# a_9366_5842# VGND sg13_lv_nmos ad=0.1491p pd=1.18u as=0.187p ps=1.78u w=0.55u l=0.13u
X826 sg13cmos5l_dlhr_1_13.Q_N a_15414_7354# VGND VGND sg13_lv_nmos ad=0.2516p pd=2.16u as=0.1491p ps=1.18u w=0.74u l=0.13u
X827 a_11782_4325# sg13cmos5l_dfrbp_1_0.RESET_B VGND VGND sg13_lv_nmos ad=37.8f pd=0.6u as=0.1701p ps=1.65u w=0.42u l=0.13u
X828 VPWR sg13cmos5l_dlhr_1_6.D a_13486_5412# VPWR sg13_lv_pmos ad=0.3808p pd=2.92u as=0.2128p ps=1.5u w=1.12u l=0.13u
X829 a_5700_6480# a_5674_6385# VPWR VPWR sg13_lv_pmos ad=0.34p pd=2.68u as=0.36237p ps=2.605u w=1u l=0.13u
X830 VPWR sg13cmos5l_buf_8_2.X a_20008_7712# VPWR sg13_lv_pmos ad=0.2114p pd=1.54u as=0.2856p ps=2.36u w=0.84u l=0.13u
X831 VPWR a_14295_7282# a_14426_7288# VPWR sg13_lv_pmos ad=1.07253p pd=6.75u as=0.2856p ps=2.36u w=0.84u l=0.13u
X832 a_7631_4727# a_6789_4629# a_6372_4968# VPWR sg13_lv_pmos ad=0.2048p pd=1.63u as=0.34p ps=2.68u w=1u l=0.13u
X833 a_12815_4261# a_11973_3911# a_11556_3904# VPWR sg13_lv_pmos ad=0.2048p pd=1.63u as=0.34p ps=2.68u w=1u l=0.13u
X834 a_1862_4338# sg13cmos5l_dlhr_1_1.GATE VPWR VPWR sg13_lv_pmos ad=79.8f pd=0.8u as=0.1428p ps=1.52u w=0.42u l=0.13u
X835 VGND a_19340_8400# pl_sw[9] VGND sg13_lv_nmos ad=0.14875p pd=1.16u as=0.2886p ps=2.26u w=0.74u l=0.13u
X836 VPWR sg13cmos5l_dlhr_1_0.D a_10331_1924# VPWR sg13_lv_pmos ad=0.2128p pd=1.5u as=0.2128p ps=1.5u w=1.12u l=0.13u
X837 VPWR a_7497_3138# a_8022_3120# VPWR sg13_lv_pmos ad=0.1974p pd=1.5u as=0.2856p ps=2.36u w=0.84u l=0.13u
X838 a_15702_4187# a_15821_3864# VGND VGND sg13_lv_nmos ad=0.2516p pd=2.16u as=0.1406p ps=1.12u w=0.74u l=0.13u
X839 VGND sg13cmos5l_dfrbp_1_0.RESET_B a_17508_3138# VGND sg13_lv_nmos ad=0.1626p pd=1.415u as=60.89999f ps=0.71u w=0.42u l=0.13u
X840 VGND a_1967_7285# a_2804_6924# VGND sg13_lv_nmos ad=0.1406p pd=1.12u as=0.2516p ps=2.16u w=0.74u l=0.13u
X841 sg13cmos5l_buf_1_19.A a_18856_8436# VGND VGND sg13_lv_nmos ad=0.2886p pd=2.26u as=0.14875p ps=1.16u w=0.74u l=0.13u
X842 cko a_20392_7712# VPWR VPWR sg13_lv_pmos ad=0.42p pd=2.99u as=0.2114p ps=1.54u w=1.12u l=0.13u
X843 a_17493_3947# sg13cmos5l_dfrbp_1_6.RESET_B VPWR VPWR sg13_lv_pmos ad=0.147p pd=1.54u as=0.1563p ps=1.22u w=0.42u l=0.13u
X844 a_2732_9150# sg13cmos5l_inv_1_20.Y VPWR VPWR sg13_lv_pmos ad=0.2856p pd=2.36u as=0.2114p ps=1.54u w=0.84u l=0.13u
X845 a_15909_2399# sg13cmos5l_dfrbp_1_0.CLK VGND VGND sg13_lv_nmos ad=0.2516p pd=2.16u as=2.43055p ps=15.415u w=0.74u l=0.13u
X846 a_17894_8436# a_17498_8800# a_17780_8436# VPWR sg13_lv_pmos ad=0.1008p pd=0.9u as=0.191p ps=1.44u w=0.42u l=0.13u
X847 a_4324_7996# a_4349_7636# VPWR VPWR sg13_lv_pmos ad=0.2856p pd=2.36u as=1.15047p ps=7.175u w=0.84u l=0.13u
X848 sg13cmos5l_inv_1_1.A a_15208_6200# VGND VGND sg13_lv_nmos ad=0.2886p pd=2.26u as=0.14875p ps=1.16u w=0.74u l=0.13u
X849 VPWR a_6736_2630# a_6681_2511# VPWR sg13_lv_pmos ad=1.86162p pd=11.935u as=93.45f ps=0.865u w=0.42u l=0.13u
X850 sg13cmos5l_dfrbp_1_21.Q_N a_17519_6239# VGND VGND sg13_lv_nmos ad=0.2849p pd=2.25u as=0.2516p ps=2.16u w=0.74u l=0.13u
X851 a_2565_3911# sg13cmos5l_inv_1_8.A VPWR VPWR sg13_lv_pmos ad=0.4088p pd=2.97u as=1.43437p ps=9.105u w=1.12u l=0.13u
X852 VGND VPWR VGND VGND sg13_lv_nmos ad=0.1428p pd=1.52u as=0 ps=0 w=0.42u l=1u
X853 a_708_5416# a_1227_5423# a_1967_5773# VGND sg13_lv_nmos ad=0.3473p pd=2.71u as=0.12665p ps=1.145u w=0.74u l=0.13u
X854 VGND a_4950_5699# sg13cmos5l_dlhr_1_5.GATE VGND sg13_lv_nmos ad=0.1406p pd=1.12u as=0.2516p ps=2.16u w=0.74u l=0.13u
X855 VPWR VGND VPWR VPWR sg13_lv_pmos ad=0.34p pd=2.68u as=0 ps=0 w=1u l=1u
X856 a_9524_4972# a_9111_4666# a_9456_4972# VPWR sg13_lv_pmos ad=0.191p pd=1.44u as=0.105p ps=1.21u w=1u l=0.13u
X857 VGND a_17327_7285# a_18164_6924# VGND sg13_lv_nmos ad=0.1406p pd=1.12u as=0.2516p ps=2.16u w=0.74u l=0.13u
X858 VPWR sg13cmos5l_dfrbp_1_8.RESET_B a_1862_8874# VPWR sg13_lv_pmos ad=0.36237p pd=2.605u as=79.8f ps=0.8u w=0.42u l=0.13u
X859 sg13cmos5l_dlhr_1_4.Q_N a_6198_3120# VPWR VPWR sg13_lv_pmos ad=0.3808p pd=2.92u as=0.1974p ps=1.5u w=1.12u l=0.13u
X860 a_11771_5412# sg13cmos5l_or2_1_1.B VPWR VPWR sg13_lv_pmos ad=0.3808p pd=2.92u as=0.2128p ps=1.5u w=1.12u l=0.13u
X861 VPWR sg13cmos5l_dfrbp_1_8.RESET_B a_2380_6162# VPWR sg13_lv_pmos ad=1.04815p pd=6.595u as=79.8f ps=0.8u w=0.42u l=0.13u
X862 VPWR a_7820_2352# sg13cmos5l_inv_1_14.A VPWR sg13_lv_pmos ad=0.2114p pd=1.54u as=0.42p ps=2.99u w=1.12u l=0.13u
X863 sg13cmos5l_inv_1_5.A a_19796_3436# VPWR VPWR sg13_lv_pmos ad=0.3808p pd=2.92u as=0.2128p ps=1.5u w=1.12u l=0.13u
X864 VGND sg13cmos5l_a221oi_1_0.C1 a_10433_4248# VGND sg13_lv_nmos ad=0.2516p pd=2.16u as=0.1406p ps=1.12u w=0.74u l=0.13u
X865 a_2386_5850# sg13cmos5l_dfrbp_1_6.RESET_B VGND VGND sg13_lv_nmos ad=37.8f pd=0.6u as=79.8f ps=0.8u w=0.42u l=0.13u
X866 a_12490_6385# a_12933_6141# a_12230_6162# VGND sg13_lv_nmos ad=79.8f pd=0.8u as=0.1296p ps=1.52u w=0.42u l=0.13u
X867 a_6153_3947# a_5796_3904# VPWR VPWR sg13_lv_pmos ad=63f pd=0.72u as=0.1563p ps=1.22u w=0.42u l=0.13u
X868 a_16268_1590# sg13cmos5l_buf_1_1.A VGND VGND sg13_lv_nmos ad=0.187p pd=1.78u as=0.14875p ps=1.16u w=0.55u l=0.13u
X869 a_8209_7326# a_7657_7282# VGND VGND sg13_lv_nmos ad=71.99999f pd=0.865u as=1.49685p ps=9.6u w=0.64u l=0.13u
X870 a_19444_5800# a_19028_5412# a_19209_5769# VGND sg13_lv_nmos ad=77.7f pd=0.95u as=0.2516p ps=2.16u w=0.74u l=0.13u
X871 VPWR sg13cmos5l_inv_1_3.A sg13cmos5l_buf_1_7.A VPWR sg13_lv_pmos ad=0.3808p pd=2.92u as=0.3808p ps=2.92u w=1.12u l=0.13u
X872 a_4324_7996# a_4349_7636# VGND VGND sg13_lv_nmos ad=0.2775p pd=2.23u as=1.49685p ps=9.6u w=0.74u l=0.13u
X873 a_15300_7687# a_15531_7796# a_14986_7897# VGND sg13_lv_nmos ad=0.2373p pd=1.97u as=79.8f ps=0.8u w=0.42u l=0.13u
X874 sg13cmos5l_dlhr_1_2.Q a_7497_3138# VGND VGND sg13_lv_nmos ad=0.2516p pd=2.16u as=0.1406p ps=1.12u w=0.74u l=0.13u
X875 VGND sg13cmos5l_buf_1_62.X a_1864_9224# VGND sg13_lv_nmos ad=0.14875p pd=1.16u as=0.187p ps=1.78u w=0.55u l=0.13u
X876 VGND sg13cmos5l_dfrbp_1_6.RESET_B a_9268_6148# VGND sg13_lv_nmos ad=0.1406p pd=1.12u as=77.7f ps=0.95u w=0.74u l=0.13u
X877 a_8772_8440# a_8746_8404# VPWR VPWR sg13_lv_pmos ad=0.34p pd=2.68u as=0.36237p ps=2.605u w=1u l=0.13u
X878 a_11002_3142# sg13cmos5l_nand2_1_0.B VGND VGND sg13_lv_nmos ad=0.1406p pd=1.12u as=0.2516p ps=2.16u w=0.74u l=0.13u
X879 VGND sg13cmos5l_dlygate4sd2_1_0.A a_902_3142# VGND sg13_lv_nmos ad=0.1323p pd=1.05u as=0.1428p ps=1.52u w=0.42u l=0.13u
X880 a_5414_6162# a_6219_6284# a_5674_6385# VPWR sg13_lv_pmos ad=0.1428p pd=1.52u as=79.8f ps=0.8u w=0.42u l=0.13u
X881 a_3407_4261# a_2565_3911# a_2148_3904# VPWR sg13_lv_pmos ad=0.2048p pd=1.63u as=0.34p ps=2.68u w=1u l=0.13u
X882 a_8050_4650# sg13cmos5l_dfrbp_1_8.RESET_B VGND VGND sg13_lv_nmos ad=37.8f pd=0.6u as=79.8f ps=0.8u w=0.42u l=0.13u
X883 a_1125_5423# sg13cmos5l_dlhr_1_1.GATE VPWR VPWR sg13_lv_pmos ad=0.4088p pd=2.97u as=1.2517p ps=7.955u w=1.12u l=0.13u
X884 VPWR sg13cmos5l_inv_1_28.Y a_11464_9224# VPWR sg13_lv_pmos ad=0.2114p pd=1.54u as=0.2856p ps=2.36u w=0.84u l=0.13u
X885 VGND a_12716_8400# ph_sw[5] VGND sg13_lv_nmos ad=0.14875p pd=1.16u as=0.2886p ps=2.26u w=0.74u l=0.13u
X886 VGND a_17584_7166# a_17233_7285# VGND sg13_lv_nmos ad=79.8f pd=0.8u as=0.1428p ps=1.52u w=0.42u l=0.13u
X887 a_17412_1944# a_17386_1849# VGND VGND sg13_lv_nmos ad=0.2516p pd=2.16u as=0.1626p ps=1.415u w=0.74u l=0.13u
X888 VPWR a_17392_4870# a_17337_4965# VPWR sg13_lv_pmos ad=1.28962p pd=8.195u as=93.45f ps=0.865u w=0.42u l=0.13u
X889 VGND sg13cmos5l_buf_1_2.A a_15784_1664# VGND sg13_lv_nmos ad=0.14875p pd=1.16u as=0.187p ps=1.78u w=0.55u l=0.13u
X890 VGND a_18363_4270# sg13cmos5l_or2_1_0.A VGND sg13_lv_nmos ad=0.1406p pd=1.12u as=0.1406p ps=1.12u w=0.74u l=0.13u
X891 VGND sg13cmos5l_buf_1_96.A a_11464_8436# VGND sg13_lv_nmos ad=0.14875p pd=1.16u as=0.187p ps=1.78u w=0.55u l=0.13u
X892 VGND a_16751_2749# a_17588_2388# VGND sg13_lv_nmos ad=0.1406p pd=1.12u as=0.2516p ps=2.16u w=0.74u l=0.13u
X893 sg13cmos5l_buf_1_28.X a_9448_1664# VGND VGND sg13_lv_nmos ad=0.2886p pd=2.26u as=0.14875p ps=1.16u w=0.74u l=0.13u
X894 VPWR sg13cmos5l_dfrbp_1_8.RESET_B a_8746_8404# VPWR sg13_lv_pmos ad=0.1563p pd=1.22u as=0.147p ps=1.54u w=0.42u l=0.13u
X895 a_19244_2352# sg13cmos5l_buf_1_18.X VPWR VPWR sg13_lv_pmos ad=0.2856p pd=2.36u as=0.2114p ps=1.54u w=0.84u l=0.13u
X896 VGND a_4041_2745# a_4566_2818# VGND sg13_lv_nmos ad=0.1491p pd=1.18u as=0.187p ps=1.78u w=0.55u l=0.13u
X897 VPWR a_524_4614# ckc VPWR sg13_lv_pmos ad=0.2114p pd=1.54u as=0.42p ps=2.99u w=1.12u l=0.13u
X898 a_10022_7674# sg13cmos5l_buf_1_57.X VPWR VPWR sg13_lv_pmos ad=79.8f pd=0.8u as=0.1428p ps=1.52u w=0.42u l=0.13u
X899 a_17008_2630# a_16751_2749# a_17170_2826# VGND sg13_lv_nmos ad=0.1428p pd=1.52u as=37.8f ps=0.6u w=0.42u l=0.13u
X900 a_17386_1849# a_17829_1605# a_17126_1626# VGND sg13_lv_nmos ad=79.8f pd=0.8u as=0.1296p ps=1.52u w=0.42u l=0.13u
X901 a_2340_3456# a_2314_3361# VGND VGND sg13_lv_nmos ad=0.2516p pd=2.16u as=0.1626p ps=1.415u w=0.74u l=0.13u
X902 a_15876_4968# a_16395_4772# a_17135_4727# VGND sg13_lv_nmos ad=0.3473p pd=2.71u as=0.12665p ps=1.145u w=0.74u l=0.13u
X903 a_11182_4948# sg13cmos5l_a221oi_1_0.B1 a_11394_4948# VPWR sg13_lv_pmos ad=0.2128p pd=1.5u as=0.3808p ps=2.92u w=1.12u l=0.13u
X904 VGND a_1815_4666# a_1946_4660# VGND sg13_lv_nmos ad=2.41737p pd=15.64u as=0.2775p ps=2.23u w=0.74u l=0.13u
X905 VGND rdy a_424_8436# VGND sg13_lv_nmos ad=0.14875p pd=1.16u as=0.187p ps=1.78u w=0.55u l=0.13u
X906 a_16462_4338# a_16703_3871# a_15821_3864# VGND sg13_lv_nmos ad=0.1428p pd=1.52u as=0.12665p ps=1.145u w=0.42u l=0.13u
X907 a_18363_4270# sg13cmos5l_buf_8_1.A VGND VGND sg13_lv_nmos ad=0.1406p pd=1.12u as=0.1406p ps=1.12u w=0.74u l=0.13u
X908 VPWR sg13cmos5l_dfrbp_1_6.RESET_B a_13161_7281# VPWR sg13_lv_pmos ad=0.2128p pd=1.5u as=0.2128p ps=1.5u w=1.12u l=0.13u
X909 sg13cmos5l_buf_1_104.A sg13cmos5l_buf_1_3.A VGND VGND sg13_lv_nmos ad=0.2516p pd=2.16u as=0.2516p ps=2.16u w=0.74u l=0.13u
X910 VGND a_2409_4650# a_2364_4686# VGND sg13_lv_nmos ad=0.1428p pd=1.52u as=47.25f ps=0.645u w=0.42u l=0.13u
X911 a_20012_2352# sg13cmos5l_buf_1_0.X VGND VGND sg13_lv_nmos ad=0.187p pd=1.78u as=0.14875p ps=1.16u w=0.55u l=0.13u
X912 VPWR sg13cmos5l_dfrbp_1_8.RESET_B a_3302_4650# VPWR sg13_lv_pmos ad=0.36237p pd=2.605u as=79.8f ps=0.8u w=0.42u l=0.13u
X913 VPWR sg13cmos5l_dlhr_1_15.D a_17545_7728# VPWR sg13_lv_pmos ad=1.15047p pd=7.175u as=0.2856p ps=2.36u w=0.84u l=0.13u
X914 a_4460_9150# sg13cmos5l_buf_1_60.A VGND VGND sg13_lv_nmos ad=0.187p pd=1.78u as=0.14875p ps=1.16u w=0.55u l=0.13u
X915 VPWR a_18345_7674# a_18278_8112# VPWR sg13_lv_pmos ad=0.2387p pd=1.84u as=0.1008p ps=0.9u w=0.42u l=0.13u
X916 a_11182_4948# sg13cmos5l_a221oi_1_0.A2 VPWR VPWR sg13_lv_pmos ad=0.2128p pd=1.5u as=0.3808p ps=2.92u w=1.12u l=0.13u
X917 VGND a_15887_8797# a_16724_8436# VGND sg13_lv_nmos ad=0.1406p pd=1.12u as=0.2516p ps=2.16u w=0.74u l=0.13u
X918 a_3575_6553# sg13cmos5l_dfrbp_1_8.RESET_B VPWR VPWR sg13_lv_pmos ad=79.8f pd=0.8u as=0.36237p ps=2.605u w=0.42u l=0.13u
X919 a_5079_3154# sg13cmos5l_dfrbp_1_9.Q VPWR VPWR sg13_lv_pmos ad=0.3234p pd=2.45u as=1.38655p ps=8.8u w=0.84u l=0.13u
X920 VGND a_8783_7751# a_9620_7972# VGND sg13_lv_nmos ad=0.1406p pd=1.12u as=0.2516p ps=2.16u w=0.74u l=0.13u
X921 a_2644_4636# a_2228_4972# a_2409_4650# VGND sg13_lv_nmos ad=77.7f pd=0.95u as=0.2516p ps=2.16u w=0.74u l=0.13u
X922 a_17519_6239# a_16677_6141# a_17425_6239# VGND sg13_lv_nmos ad=0.12665p pd=1.145u as=0.1428p ps=1.52u w=0.42u l=0.13u
X923 VPWR VGND VPWR VPWR sg13_lv_pmos ad=0.34p pd=2.68u as=0 ps=0 w=1u l=1u
X924 VGND VPWR VGND VGND sg13_lv_nmos ad=0.1428p pd=1.52u as=0 ps=0 w=0.42u l=1u
X925 a_1967_5773# a_1125_5423# a_708_5416# VPWR sg13_lv_pmos ad=0.2048p pd=1.63u as=0.34p ps=2.68u w=1u l=0.13u
X926 VPWR a_17327_7285# a_17584_7166# VPWR sg13_lv_pmos ad=0.2639p pd=1.81u as=79.8f ps=0.8u w=0.42u l=0.13u
X927 sg13cmos5l_buf_1_9.A a_9832_1664# VGND VGND sg13_lv_nmos ad=0.2886p pd=2.26u as=0.14875p ps=1.16u w=0.74u l=0.13u
X928 VPWR a_8204_9150# sg13cmos5l_buf_1_74.X VPWR sg13_lv_pmos ad=0.2114p pd=1.54u as=0.42p ps=2.99u w=1.12u l=0.13u
X929 a_8783_7751# a_7941_7653# a_7524_7992# VPWR sg13_lv_pmos ad=0.2048p pd=1.63u as=0.34p ps=2.68u w=1u l=0.13u
X930 VPWR a_13072_4142# a_13017_4023# VPWR sg13_lv_pmos ad=1.43437p pd=9.105u as=93.45f ps=0.865u w=0.42u l=0.13u
X931 VGND sg13cmos5l_dfrbp_1_0.Q sg13cmos5l_dfrbp_1_0.D VGND sg13_lv_nmos ad=0.2516p pd=2.16u as=0.1406p ps=1.12u w=0.74u l=0.13u
X932 a_708_6928# a_682_6892# VPWR VPWR sg13_lv_pmos ad=0.34p pd=2.68u as=0.36237p ps=2.605u w=1u l=0.13u
X933 VGND sg13cmos5l_dlhr_1_5.D a_7657_7282# VGND sg13_lv_nmos ad=0.15055p pd=1.17u as=0.187p ps=1.78u w=0.55u l=0.13u
X934 a_15412_5800# a_14996_5412# a_15177_5769# VGND sg13_lv_nmos ad=77.7f pd=0.95u as=0.2516p ps=2.16u w=0.74u l=0.13u
X935 a_5492_3460# a_5210_3148# a_5425_3130# VGND sg13_lv_nmos ad=0.141p pd=1.17u as=71.99999f ps=0.865u w=0.64u l=0.13u
X936 a_4934_2826# a_5739_2399# a_5194_2356# VPWR sg13_lv_pmos ad=0.1428p pd=1.52u as=79.8f ps=0.8u w=0.42u l=0.13u
X937 VGND sg13cmos5l_inv_1_3.A sg13cmos5l_buf_1_7.A VGND sg13_lv_nmos ad=0.2516p pd=2.16u as=0.2516p ps=2.16u w=0.74u l=0.13u
X938 a_5049_4965# a_4107_4772# a_4847_4727# VPWR sg13_lv_pmos ad=93.45f pd=0.865u as=0.2048p ps=1.63u w=0.42u l=0.13u
X939 sg13cmos5l_nor2_1_0.A a_13556_2388# VGND VGND sg13_lv_nmos ad=0.2516p pd=2.16u as=0.1406p ps=1.12u w=0.74u l=0.13u
X940 a_12815_1703# a_11973_1605# a_12721_1703# VGND sg13_lv_nmos ad=0.12665p pd=1.145u as=0.1428p ps=1.52u w=0.42u l=0.13u
X941 VGND a_14889_7281# a_14844_7326# VGND sg13_lv_nmos ad=0.1428p pd=1.52u as=47.25f ps=0.645u w=0.42u l=0.13u
X942 VGND a_19227_4654# sg13cmos5l_buf_8_0.X VGND sg13_lv_nmos ad=0.2516p pd=2.16u as=0.1406p ps=1.12u w=0.74u l=0.13u
X943 a_6022_4325# sg13cmos5l_dfrbp_1_6.RESET_B VGND VGND sg13_lv_nmos ad=37.8f pd=0.6u as=0.1701p ps=1.65u w=0.42u l=0.13u
X944 a_1484_6126# sg13cmos5l_buf_1_58.A VGND VGND sg13_lv_nmos ad=0.187p pd=1.78u as=0.14875p ps=1.16u w=0.55u l=0.13u
X945 a_5446_2813# sg13cmos5l_dfrbp_1_6.RESET_B VGND VGND sg13_lv_nmos ad=37.8f pd=0.6u as=0.1701p ps=1.65u w=0.42u l=0.13u
X946 a_15884_3102# sg13cmos5l_buf_1_5.X VPWR VPWR sg13_lv_pmos ad=0.2856p pd=2.36u as=0.2114p ps=1.54u w=0.84u l=0.13u
X947 a_4559_7630# sg13cmos5l_dlhr_1_9.D VGND VGND sg13_lv_nmos ad=0.187p pd=1.78u as=0.15055p ps=1.17u w=0.55u l=0.13u
X948 a_6372_4968# a_6346_4873# VGND VGND sg13_lv_nmos ad=0.2516p pd=2.16u as=0.1626p ps=1.415u w=0.74u l=0.13u
X949 sg13cmos5l_a22oi_1_2.B1 sg13cmos5l_nand2_1_1.B VGND VGND sg13_lv_nmos ad=0.1406p pd=1.12u as=0.2516p ps=2.16u w=0.74u l=0.13u
X950 a_10783_3876# sg13cmos5l_inv_1_0.A sg13cmos5l_a22oi_1_0.Y VPWR sg13_lv_pmos ad=0.2744p pd=1.61u as=0.2128p ps=1.5u w=1.12u l=0.13u
X951 a_12976_2630# a_12719_2749# a_13138_2826# VGND sg13_lv_nmos ad=0.1428p pd=1.52u as=37.8f ps=0.6u w=0.42u l=0.13u
X952 sg13cmos5l_dfrbp_1_6.RESET_B cks VGND VGND sg13_lv_nmos ad=0.1406p pd=1.12u as=0.2516p ps=2.16u w=0.74u l=0.13u
X953 VPWR sg13cmos5l_dlhr_1_15.Q a_19240_7712# VPWR sg13_lv_pmos ad=0.2114p pd=1.54u as=0.2856p ps=2.36u w=0.84u l=0.13u
X954 VPWR a_8457_7281# a_8390_6924# VPWR sg13_lv_pmos ad=0.2387p pd=1.84u as=0.1008p ps=0.9u w=0.42u l=0.13u
X955 VGND sg13cmos5l_dfrbp_1_6.RESET_B a_13876_7660# VGND sg13_lv_nmos ad=0.1406p pd=1.12u as=77.7f ps=0.95u w=0.74u l=0.13u
X956 VPWR a_5324_1590# sg13cmos5l_buf_1_39.A VPWR sg13_lv_pmos ad=0.2114p pd=1.54u as=0.42p ps=2.99u w=1.12u l=0.13u
X957 VPWR sg13cmos5l_inv_1_1.A a_16264_9224# VPWR sg13_lv_pmos ad=0.2114p pd=1.54u as=0.2856p ps=2.36u w=0.84u l=0.13u
X958 a_3669_6320# sg13cmos5l_dfrbp_1_8.RESET_B VPWR VPWR sg13_lv_pmos ad=0.147p pd=1.54u as=0.1563p ps=1.22u w=0.42u l=0.13u
X959 a_3860_2388# a_3447_2746# a_3792_2388# VPWR sg13_lv_pmos ad=0.191p pd=1.44u as=0.105p ps=1.21u w=1u l=0.13u
X960 VPWR a_10464_2427# sg13cmos5l_dfrbp_1_4.D VPWR sg13_lv_pmos ad=0.3808p pd=2.92u as=0.2408p ps=1.55u w=1.12u l=0.13u
X961 a_14924_1590# sg13cmos5l_buf_1_6.A VGND VGND sg13_lv_nmos ad=0.187p pd=1.78u as=0.14875p ps=1.16u w=0.55u l=0.13u
X962 a_20012_1590# sg13cmos5l_buf_1_0.A VGND VGND sg13_lv_nmos ad=0.187p pd=1.78u as=0.14875p ps=1.16u w=0.55u l=0.13u
X963 VPWR a_8783_7751# a_9040_7894# VPWR sg13_lv_pmos ad=0.2639p pd=1.81u as=79.8f ps=0.8u w=0.42u l=0.13u
X964 a_5132_9150# sg13cmos5l_buf_1_44.X VGND VGND sg13_lv_nmos ad=0.187p pd=1.78u as=0.14875p ps=1.16u w=0.55u l=0.13u
X965 a_8204_9150# sg13cmos5l_buf_1_45.X VPWR VPWR sg13_lv_pmos ad=0.2856p pd=2.36u as=0.2114p ps=1.54u w=0.84u l=0.13u
X966 d_out[1] a_20008_3900# VGND VGND sg13_lv_nmos ad=0.2886p pd=2.26u as=0.14875p ps=1.16u w=0.74u l=0.13u
X967 sg13cmos5l_buf_1_34.X a_4840_1664# VPWR VPWR sg13_lv_pmos ad=0.42p pd=2.99u as=0.2114p ps=1.54u w=1.12u l=0.13u
X968 sg13cmos5l_dlhr_1_20.Q_N a_10230_4632# VGND VGND sg13_lv_nmos ad=0.2516p pd=2.16u as=0.1491p ps=1.18u w=0.74u l=0.13u
X969 a_5988_8440# a_6507_8447# a_7247_8797# VGND sg13_lv_nmos ad=0.3473p pd=2.71u as=0.12665p ps=1.145u w=0.74u l=0.13u
X970 sg13cmos5l_nor2b_1_0.Y a_12814_4692# VGND VGND sg13_lv_nmos ad=0.1406p pd=1.12u as=0.17255p ps=1.25u w=0.74u l=0.13u
X971 a_4076_7624# a_4349_7636# a_4311_7710# VGND sg13_lv_nmos ad=0.141p pd=1.17u as=47.25f ps=0.645u w=0.42u l=0.13u
X972 VGND a_7689_1626# a_7644_1662# VGND sg13_lv_nmos ad=0.1428p pd=1.52u as=47.25f ps=0.645u w=0.42u l=0.13u
X973 sg13cmos5l_a221oi_1_0.A2 a_7892_3900# VGND VGND sg13_lv_nmos ad=0.2516p pd=2.16u as=0.1406p ps=1.12u w=0.74u l=0.13u
X974 a_17988_3151# a_17700_3456# a_17926_3151# VGND sg13_lv_nmos ad=0.1428p pd=1.52u as=37.8f ps=0.6u w=0.42u l=0.13u
X975 VPWR sg13cmos5l_dfrbp_1_8.RESET_B a_15782_7362# VPWR sg13_lv_pmos ad=0.36237p pd=2.605u as=79.8f ps=0.8u w=0.42u l=0.13u
X976 VPWR sg13cmos5l_dfrbp_1_6.RESET_B a_19593_6162# VPWR sg13_lv_pmos ad=0.2128p pd=1.5u as=0.2128p ps=1.5u w=1.12u l=0.13u
X977 VPWR sg13cmos5l_buf_1_34.A a_4840_1664# VPWR sg13_lv_pmos ad=0.2114p pd=1.54u as=0.2856p ps=2.36u w=0.84u l=0.13u
X978 a_6346_4873# a_6789_4629# a_6086_4650# VGND sg13_lv_nmos ad=79.8f pd=0.8u as=0.1296p ps=1.52u w=0.42u l=0.13u
X979 a_4934_2826# sg13cmos5l_dfrbp_1_6.D VPWR VPWR sg13_lv_pmos ad=79.8f pd=0.8u as=0.1428p ps=1.52u w=0.42u l=0.13u
X980 a_6180_4650# sg13cmos5l_dlhr_1_0.GATE a_6086_4650# VGND sg13_lv_nmos ad=60.89999f pd=0.71u as=0.1428p ps=1.52u w=0.42u l=0.13u
X981 a_10725_7653# sg13cmos5l_dlhr_1_11.GATE VGND VGND sg13_lv_nmos ad=0.2516p pd=2.16u as=1.49685p ps=9.6u w=0.74u l=0.13u
X982 a_7924_1612# a_7508_1948# a_7689_1626# VGND sg13_lv_nmos ad=77.7f pd=0.95u as=0.2516p ps=2.16u w=0.74u l=0.13u
X983 a_7666_8874# sg13cmos5l_dfrbp_1_8.RESET_B VGND VGND sg13_lv_nmos ad=37.8f pd=0.6u as=79.8f ps=0.8u w=0.42u l=0.13u
X984 VPWR sg13cmos5l_dfrbp_1_6.RESET_B a_10665_7281# VPWR sg13_lv_pmos ad=0.2128p pd=1.5u as=0.2128p ps=1.5u w=1.12u l=0.13u
X985 VGND sg13cmos5l_dfrbp_1_16.Q a_3625_7282# VGND sg13_lv_nmos ad=0.15055p pd=1.17u as=0.187p ps=1.78u w=0.55u l=0.13u
X986 a_13324_4696# sg13cmos5l_inv_1_0.A VPWR VPWR sg13_lv_pmos ad=0.1596p pd=1.22u as=0.1596p ps=1.22u w=0.84u l=0.13u
X987 a_10022_7674# a_10827_7796# a_10282_7897# VPWR sg13_lv_pmos ad=0.1428p pd=1.52u as=79.8f ps=0.8u w=0.42u l=0.13u
X988 sg13cmos5l_dlhr_1_6.Q_N a_9558_6144# VGND VGND sg13_lv_nmos ad=0.2516p pd=2.16u as=0.1491p ps=1.18u w=0.74u l=0.13u
X989 a_10484_6924# a_10071_7282# a_10416_6924# VPWR sg13_lv_pmos ad=0.191p pd=1.44u as=0.105p ps=1.21u w=1u l=0.13u
X990 a_19216_3358# a_18959_3215# a_19378_3138# VGND sg13_lv_nmos ad=0.1428p pd=1.52u as=37.8f ps=0.6u w=0.42u l=0.13u
X991 sg13cmos5l_a22oi_1_1.B2 sg13cmos5l_and3_1_0.X VGND VGND sg13_lv_nmos ad=0.2516p pd=2.16u as=0.1406p ps=1.12u w=0.74u l=0.13u
X992 VGND a_17516_9150# pl_sw[8] VGND sg13_lv_nmos ad=0.14875p pd=1.16u as=0.2886p ps=2.26u w=0.74u l=0.13u
X993 VPWR a_13775_6239# a_14612_6460# VPWR sg13_lv_pmos ad=0.2128p pd=1.5u as=0.3864p ps=2.93u w=1.12u l=0.13u
X994 VGND a_6572_1590# sg13cmos5l_buf_1_24.X VGND sg13_lv_nmos ad=0.14875p pd=1.16u as=0.2886p ps=2.26u w=0.74u l=0.13u
X995 VPWR sg13cmos5l_dfrbp_1_8.RESET_B a_6346_4873# VPWR sg13_lv_pmos ad=0.1563p pd=1.22u as=0.147p ps=1.54u w=0.42u l=0.13u
X996 pl_sw[4] a_5800_9224# VGND VGND sg13_lv_nmos ad=0.2886p pd=2.26u as=0.14875p ps=1.16u w=0.74u l=0.13u
X997 a_422_5850# a_1227_5423# a_682_5380# VPWR sg13_lv_pmos ad=0.1428p pd=1.52u as=79.8f ps=0.8u w=0.42u l=0.13u
X998 a_18999_6178# sg13cmos5l_dfrbp_1_8.D VGND VGND sg13_lv_nmos ad=0.2516p pd=2.16u as=0.15055p ps=1.17u w=0.74u l=0.13u
X999 a_11748_2813# a_11460_2392# a_11686_2813# VGND sg13_lv_nmos ad=0.1428p pd=1.52u as=37.8f ps=0.6u w=0.42u l=0.13u
X1000 a_15062_4292# sg13cmos5l_a22oi_1_1.B2 sg13cmos5l_a22oi_1_1.Y VGND sg13_lv_nmos ad=0.13875p pd=1.115u as=0.2664p ps=1.46u w=0.74u l=0.13u
X1001 VPWR sg13cmos5l_or2_1_0.A a_18574_5028# VPWR sg13_lv_pmos ad=0.2226p pd=1.535u as=0.1596p ps=1.22u w=0.84u l=0.13u
X1002 VGND a_9040_7894# a_8689_7751# VGND sg13_lv_nmos ad=79.8f pd=0.8u as=0.1428p ps=1.52u w=0.42u l=0.13u
X1003 a_14986_7897# a_15429_7653# a_15369_8065# VPWR sg13_lv_pmos ad=79.8f pd=0.8u as=63f ps=0.72u w=0.42u l=0.13u
X1004 VGND sg13cmos5l_dfrbp_1_0.RESET_B a_17220_1626# VGND sg13_lv_nmos ad=0.1626p pd=1.415u as=60.89999f ps=0.71u w=0.42u l=0.13u
X1005 VGND sg13cmos5l_buf_1_77.X a_7336_9224# VGND sg13_lv_nmos ad=0.14875p pd=1.16u as=0.187p ps=1.78u w=0.55u l=0.13u
X1006 a_6405_8447# sg13cmos5l_inv_1_8.A VPWR VPWR sg13_lv_pmos ad=0.4088p pd=2.97u as=1.12242p ps=7u w=1.12u l=0.13u
X1007 a_7249_3130# a_6697_3192# VGND VGND sg13_lv_nmos ad=71.99999f pd=0.865u as=2.59257p ps=16.445u w=0.64u l=0.13u
X1008 sg13cmos5l_dlygate4sd2_1_0.X a_1290_3206# VGND VGND sg13_lv_nmos ad=0.2516p pd=2.16u as=0.1405p ps=1.15u w=0.74u l=0.13u
X1009 VGND sg13cmos5l_inv_1_8.A a_2879_6432# VGND sg13_lv_nmos ad=1.88087p pd=11.775u as=0.2516p ps=2.16u w=0.74u l=0.13u
X1010 d_out[0] a_20392_2388# VGND VGND sg13_lv_nmos ad=0.2886p pd=2.26u as=0.14875p ps=1.16u w=0.74u l=0.13u
X1011 VPWR a_18363_4270# sg13cmos5l_or2_1_0.A VPWR sg13_lv_pmos ad=0.2128p pd=1.5u as=0.2128p ps=1.5u w=1.12u l=0.13u
X1012 VGND sg13cmos5l_dfrbp_1_6.RESET_B a_2148_3138# VGND sg13_lv_nmos ad=0.1626p pd=1.415u as=60.89999f ps=0.71u w=0.42u l=0.13u
X1013 sg13cmos5l_buf_8_0.X a_19227_4654# VPWR VPWR sg13_lv_pmos ad=0.2128p pd=1.5u as=0.2128p ps=1.5u w=1.12u l=0.13u
X1014 VPWR a_13072_1846# a_13017_1941# VPWR sg13_lv_pmos ad=1.86162p pd=11.935u as=93.45f ps=0.865u w=0.42u l=0.13u
X1015 VPWR VGND VPWR VPWR sg13_lv_pmos ad=0.34p pd=2.68u as=0 ps=0 w=1u l=1u
X1016 VPWR a_4847_4727# a_5684_4948# VPWR sg13_lv_pmos ad=0.2128p pd=1.5u as=0.3864p ps=2.93u w=1.12u l=0.13u
X1017 a_10613_2758# sg13cmos5l_nand2_1_1.B VGND VGND sg13_lv_nmos ad=0.1406p pd=1.12u as=0.1898p ps=1.36u w=0.74u l=0.13u
X1018 a_11748_2813# a_11979_2399# a_11434_2356# VGND sg13_lv_nmos ad=0.2373p pd=1.97u as=79.8f ps=0.8u w=0.42u l=0.13u
X1019 VGND a_13484_8400# sg13cmos5l_buf_1_5.A VGND sg13_lv_nmos ad=0.14875p pd=1.16u as=0.2886p ps=2.26u w=0.74u l=0.13u
X1020 a_17135_4727# a_16293_4629# a_17041_4727# VGND sg13_lv_nmos ad=0.12665p pd=1.145u as=0.1428p ps=1.52u w=0.42u l=0.13u
X1021 VGND VPWR VGND VGND sg13_lv_nmos ad=0.1428p pd=1.52u as=0 ps=0 w=0.42u l=1u
X1022 a_12516_6480# a_12490_6385# VPWR VPWR sg13_lv_pmos ad=0.34p pd=2.68u as=0.36237p ps=2.605u w=1u l=0.13u
X1023 VGND sg13cmos5l_buf_1_4.A sg13cmos5l_buf_1_110.A VGND sg13_lv_nmos ad=0.2516p pd=2.16u as=0.2516p ps=2.16u w=0.74u l=0.13u
X1024 VGND sg13cmos5l_dlhr_1_2.D a_6697_3192# VGND sg13_lv_nmos ad=0.15055p pd=1.17u as=0.187p ps=1.78u w=0.55u l=0.13u
X1025 a_18363_4270# sg13cmos5l_buf_8_1.A VPWR VPWR sg13_lv_pmos ad=0.2128p pd=1.5u as=0.2128p ps=1.5u w=1.12u l=0.13u
X1026 a_10725_7653# sg13cmos5l_dlhr_1_11.GATE VPWR VPWR sg13_lv_pmos ad=0.4088p pd=2.97u as=1.12242p ps=7u w=1.12u l=0.13u
X1027 VPWR a_16293_4629# a_16395_4772# VPWR sg13_lv_pmos ad=1.28962p pd=8.195u as=0.3864p ps=2.93u w=1.12u l=0.13u
X1028 a_13116_7326# a_12567_7282# a_12980_6924# VGND sg13_lv_nmos ad=47.25f pd=0.645u as=0.141p ps=1.17u w=0.42u l=0.13u
X1029 VGND a_15500_9150# ph_sw[6] VGND sg13_lv_nmos ad=0.14875p pd=1.16u as=0.2886p ps=2.26u w=0.74u l=0.13u
X1030 VPWR a_12567_7282# a_12698_7288# VPWR sg13_lv_pmos ad=1.07253p pd=6.75u as=0.2856p ps=2.36u w=0.84u l=0.13u
X1031 a_15782_7362# a_16587_6935# a_16042_6892# VPWR sg13_lv_pmos ad=0.1428p pd=1.52u as=79.8f ps=0.8u w=0.42u l=0.13u
X1032 VPWR sg13cmos5l_dlhr_1_5.D a_7657_7282# VPWR sg13_lv_pmos ad=1.07253p pd=6.75u as=0.2856p ps=2.36u w=0.84u l=0.13u
X1033 a_10464_2427# sg13cmos5l_nand2_1_1.B a_10427_2736# VGND sg13_lv_nmos ad=0.2176p pd=1.96u as=78.39999f ps=0.885u w=0.64u l=0.13u
X1034 VGND sg13cmos5l_dlhr_1_6.D a_8233_6216# VGND sg13_lv_nmos ad=0.15055p pd=1.17u as=0.187p ps=1.78u w=0.55u l=0.13u
X1035 sg13cmos5l_dfrbp_1_0.Q a_19508_1924# VPWR VPWR sg13_lv_pmos ad=0.3808p pd=2.92u as=0.2128p ps=1.5u w=1.12u l=0.13u
X1036 a_17135_4727# a_16293_4629# a_15876_4968# VPWR sg13_lv_pmos ad=0.2048p pd=1.63u as=0.34p ps=2.68u w=1u l=0.13u
X1037 a_10420_5412# sg13cmos5l_dfrbp_1_20.Q VPWR VPWR sg13_lv_pmos ad=0.2128p pd=1.5u as=0.3808p ps=2.92u w=1.12u l=0.13u
X1038 VGND a_19227_4654# sg13cmos5l_buf_8_0.X VGND sg13_lv_nmos ad=0.1406p pd=1.12u as=0.1406p ps=1.12u w=0.74u l=0.13u
X1039 a_16690_7674# sg13cmos5l_dfrbp_1_6.RESET_B VGND VGND sg13_lv_nmos ad=37.8f pd=0.6u as=79.8f ps=0.8u w=0.42u l=0.13u
X1040 a_1158_3142# a_902_3142# VPWR VPWR sg13_lv_pmos ad=0.34p pd=2.68u as=0.2481p ps=1.56u w=1u l=0.25u
X1041 a_3588_4968# a_3562_4873# VPWR VPWR sg13_lv_pmos ad=0.34p pd=2.68u as=0.36237p ps=2.605u w=1u l=0.13u
X1042 sg13cmos5l_buf_8_2.X a_19227_9190# VGND VGND sg13_lv_nmos ad=0.1406p pd=1.12u as=0.1406p ps=1.12u w=0.74u l=0.13u
X1043 VGND sg13cmos5l_inv_1_6.A a_20008_8436# VGND sg13_lv_nmos ad=0.14875p pd=1.16u as=0.187p ps=1.78u w=0.55u l=0.13u
X1044 sg13cmos5l_dfrbp_1_23.CLK a_14228_9484# VPWR VPWR sg13_lv_pmos ad=0.3808p pd=2.92u as=0.2128p ps=1.5u w=1.12u l=0.13u
X1045 VGND sg13cmos5l_buf_1_24.A sg13cmos5l_buf_1_78.A VGND sg13_lv_nmos ad=0.2516p pd=2.16u as=0.2516p ps=2.16u w=0.74u l=0.13u
X1046 a_7508_1948# a_7095_1642# a_7440_1948# VPWR sg13_lv_pmos ad=0.191p pd=1.44u as=0.105p ps=1.21u w=1u l=0.13u
X1047 VPWR a_7216_6382# a_7161_6477# VPWR sg13_lv_pmos ad=1.07253p pd=6.75u as=93.45f ps=0.865u w=0.42u l=0.13u
X1048 VGND sg13cmos5l_nor2b_1_0.Y a_11054_4292# VGND sg13_lv_nmos ad=0.2516p pd=2.16u as=96.2f ps=1u w=0.74u l=0.13u
X1049 a_19548_6198# a_18999_6178# a_19412_6484# VGND sg13_lv_nmos ad=47.25f pd=0.645u as=0.141p ps=1.17u w=0.42u l=0.13u
X1050 VGND a_4041_2745# a_3996_2790# VGND sg13_lv_nmos ad=0.1428p pd=1.52u as=47.25f ps=0.645u w=0.42u l=0.13u
X1051 sg13cmos5l_dfrbp_1_10.Q a_4436_3436# VPWR VPWR sg13_lv_pmos ad=0.3808p pd=2.92u as=0.2128p ps=1.5u w=1.12u l=0.13u
X1052 VGND a_1006_4167# sg13cmos5l_dlygate4sd3_1_0.X VGND sg13_lv_nmos ad=0.1426p pd=1.16u as=0.2516p ps=2.16u w=0.74u l=0.13u
X1053 VGND sg13cmos5l_buf_1_19.A a_18760_2388# VGND sg13_lv_nmos ad=0.14875p pd=1.16u as=0.187p ps=1.78u w=0.55u l=0.13u
X1054 VGND sg13cmos5l_dfrbp_1_6.RESET_B a_5908_3124# VGND sg13_lv_nmos ad=0.1406p pd=1.12u as=77.7f ps=0.95u w=0.74u l=0.13u
X1055 VPWR sg13cmos5l_buf_1_60.X a_2248_9224# VPWR sg13_lv_pmos ad=0.2114p pd=1.54u as=0.2856p ps=2.36u w=0.84u l=0.13u
X1056 VGND sg13cmos5l_buf_1_98.A a_13768_8436# VGND sg13_lv_nmos ad=0.14875p pd=1.16u as=0.187p ps=1.78u w=0.55u l=0.13u
X1057 VGND a_11072_5347# sg13cmos5l_a221oi_1_1.C1 VGND sg13_lv_nmos ad=0.1371p pd=1.12u as=0.2516p ps=2.16u w=0.74u l=0.13u
X1058 a_14628_8440# a_14602_8404# VGND VGND sg13_lv_nmos ad=0.2516p pd=2.16u as=0.1626p ps=1.415u w=0.74u l=0.13u
X1059 VPWR a_9260_2352# nh_sw[4] VPWR sg13_lv_pmos ad=0.2114p pd=1.54u as=0.42p ps=2.99u w=1.12u l=0.13u
X1060 VPWR a_7312_4142# a_7257_4023# VPWR sg13_lv_pmos ad=1.43437p pd=9.105u as=93.45f ps=0.865u w=0.42u l=0.13u
X1061 VGND a_17135_4727# a_17972_4948# VGND sg13_lv_nmos ad=0.1406p pd=1.12u as=0.2516p ps=2.16u w=0.74u l=0.13u
X1062 a_908_1590# sg13cmos5l_buf_1_32.A VGND VGND sg13_lv_nmos ad=0.187p pd=1.78u as=0.14875p ps=1.16u w=0.55u l=0.13u
X1063 a_7247_8797# a_6405_8447# a_7153_8797# VGND sg13_lv_nmos ad=0.12665p pd=1.145u as=0.1428p ps=1.52u w=0.42u l=0.13u
X1064 a_5700_6480# a_6219_6284# a_6959_6239# VGND sg13_lv_nmos ad=0.3473p pd=2.71u as=0.12665p ps=1.145u w=0.74u l=0.13u
X1065 VPWR sg13cmos5l_dfrbp_1_1.Q sg13cmos5l_inv_1_11.Y VPWR sg13_lv_pmos ad=0.3808p pd=2.92u as=0.3808p ps=2.92u w=1.12u l=0.13u
X1066 a_5770_3868# a_6213_3911# a_6153_3947# VPWR sg13_lv_pmos ad=79.8f pd=0.8u as=63f ps=0.72u w=0.42u l=0.13u
X1067 VGND a_10473_9186# a_10428_9222# VGND sg13_lv_nmos ad=0.1428p pd=1.52u as=47.25f ps=0.645u w=0.42u l=0.13u
X1068 a_524_4614# sg13cmos5l_buf_1_43.A VPWR VPWR sg13_lv_pmos ad=0.2856p pd=2.36u as=0.2114p ps=1.54u w=0.84u l=0.13u
X1069 VPWR sg13cmos5l_buf_1_116.A a_15592_6200# VPWR sg13_lv_pmos ad=0.2114p pd=1.54u as=0.2856p ps=2.36u w=0.84u l=0.13u
X1070 a_15492_2392# a_15466_2356# VGND VGND sg13_lv_nmos ad=0.2516p pd=2.16u as=0.1626p ps=1.415u w=0.74u l=0.13u
X1071 VGND a_18363_4270# sg13cmos5l_or2_1_0.A VGND sg13_lv_nmos ad=0.2516p pd=2.16u as=0.1406p ps=1.12u w=0.74u l=0.13u
X1072 VGND a_3308_5376# sg13cmos5l_buf_1_41.A VGND sg13_lv_nmos ad=0.14875p pd=1.16u as=0.2886p ps=2.26u w=0.74u l=0.13u
X1073 VPWR sg13cmos5l_inv_1_26.Y a_17896_9224# VPWR sg13_lv_pmos ad=0.2114p pd=1.54u as=0.2856p ps=2.36u w=0.84u l=0.13u
X1074 a_6345_8483# a_5988_8440# VPWR VPWR sg13_lv_pmos ad=63f pd=0.72u as=0.1563p ps=1.22u w=0.42u l=0.13u
X1075 VGND a_10220_3102# nl_sw[5] VGND sg13_lv_nmos ad=0.14875p pd=1.16u as=0.2886p ps=2.26u w=0.74u l=0.13u
X1076 VPWR a_7820_9150# sg13cmos5l_buf_1_73.X VPWR sg13_lv_pmos ad=0.2114p pd=1.54u as=0.42p ps=2.99u w=1.12u l=0.13u
X1077 a_16144_8678# sg13cmos5l_dfrbp_1_8.RESET_B VPWR VPWR sg13_lv_pmos ad=79.8f pd=0.8u as=1.12242p ps=7u w=0.42u l=0.13u
X1078 VGND sg13cmos5l_inv_1_0.A sg13cmos5l_inv_1_0.Y VGND sg13_lv_nmos ad=0.2516p pd=2.16u as=0.2516p ps=2.16u w=0.74u l=0.13u
X1079 a_10318_5412# sg13cmos5l_a221oi_1_1.C1 sg13cmos5l_a22oi_1_2.B2 VPWR sg13_lv_pmos ad=0.2128p pd=1.5u as=0.3808p ps=2.92u w=1.12u l=0.13u
X1080 VGND a_9033_6162# a_9558_6144# VGND sg13_lv_nmos ad=0.1491p pd=1.18u as=0.187p ps=1.78u w=0.55u l=0.13u
X1081 VGND sg13cmos5l_buf_8_0.A a_19227_4654# VGND sg13_lv_nmos ad=0.1406p pd=1.12u as=0.2553p ps=2.17u w=0.74u l=0.13u
X1082 a_11556_3904# a_11530_3868# VPWR VPWR sg13_lv_pmos ad=0.34p pd=2.68u as=0.36237p ps=2.605u w=1u l=0.13u
X1083 VGND sg13cmos5l_buf_1_86.A a_20392_6924# VGND sg13_lv_nmos ad=0.14875p pd=1.16u as=0.187p ps=1.78u w=0.55u l=0.13u
X1084 sg13cmos5l_or2_1_0.A a_18363_4270# VGND VGND sg13_lv_nmos ad=0.1406p pd=1.12u as=0.1406p ps=1.12u w=0.74u l=0.13u
X1085 a_7055_4261# a_6213_3911# a_6961_4261# VGND sg13_lv_nmos ad=0.12665p pd=1.145u as=0.1428p ps=1.52u w=0.42u l=0.13u
X1086 sg13cmos5l_buf_8_0.X a_19227_4654# VPWR VPWR sg13_lv_pmos ad=0.2128p pd=1.5u as=0.2128p ps=1.5u w=1.12u l=0.13u
X1087 VPWR a_19227_9190# sg13cmos5l_buf_8_2.X VPWR sg13_lv_pmos ad=0.2128p pd=1.5u as=0.2128p ps=1.5u w=1.12u l=0.13u
X1088 pl_sw[5] a_7336_9224# VPWR VPWR sg13_lv_pmos ad=0.42p pd=2.99u as=0.2114p ps=1.54u w=1.12u l=0.13u
X1089 a_16042_6892# a_16485_6935# a_15782_7362# VGND sg13_lv_nmos ad=79.8f pd=0.8u as=0.1296p ps=1.52u w=0.42u l=0.13u
X1090 VGND sg13cmos5l_dfrbp_1_6.RESET_B a_10900_7312# VGND sg13_lv_nmos ad=0.1406p pd=1.12u as=77.7f ps=0.95u w=0.74u l=0.13u
X1091 a_6647_5459# sg13cmos5l_dfrbp_1_11.Q a_7394_5850# VGND sg13_lv_nmos ad=0.1428p pd=1.52u as=60.89999f ps=0.71u w=0.42u l=0.13u
X1092 a_6647_5459# sg13cmos5l_dfrbp_1_8.RESET_B VPWR VPWR sg13_lv_pmos ad=79.8f pd=0.8u as=0.36237p ps=2.605u w=0.42u l=0.13u
X1093 a_5606_3576# a_5210_3148# a_5492_3460# VPWR sg13_lv_pmos ad=0.1008p pd=0.9u as=0.191p ps=1.44u w=0.42u l=0.13u
X1094 a_3664_4142# a_3407_4261# a_3826_4338# VGND sg13_lv_nmos ad=0.1428p pd=1.52u as=37.8f ps=0.6u w=0.42u l=0.13u
X1095 VGND sg13cmos5l_dlhr_1_11.D a_12361_7282# VGND sg13_lv_nmos ad=0.15055p pd=1.17u as=0.187p ps=1.78u w=0.55u l=0.13u
X1096 a_2727_6380# a_2879_6432# VPWR VPWR sg13_lv_pmos ad=0.3864p pd=2.93u as=1.07253p ps=6.75u w=1.12u l=0.13u
X1097 VPWR sg13cmos5l_dfrbp_1_0.RESET_B a_11530_3868# VPWR sg13_lv_pmos ad=0.1563p pd=1.22u as=0.147p ps=1.54u w=0.42u l=0.13u
X1098 VPWR sg13cmos5l_nor2_1_0.A a_11980_4948# VPWR sg13_lv_pmos ad=0.4032p pd=2.96u as=0.1176p ps=1.33u w=1.12u l=0.13u
X1099 a_5796_8874# sg13cmos5l_dlhr_1_5.GATE a_5702_8874# VGND sg13_lv_nmos ad=60.89999f pd=0.71u as=0.1428p ps=1.52u w=0.42u l=0.13u
X1100 a_9164_1590# sg13cmos5l_buf_1_26.A VGND VGND sg13_lv_nmos ad=0.187p pd=1.78u as=0.14875p ps=1.16u w=0.55u l=0.13u
X1101 a_12230_6162# a_13035_6284# a_12490_6385# VPWR sg13_lv_pmos ad=0.1428p pd=1.52u as=79.8f ps=0.8u w=0.42u l=0.13u
X1102 a_3692_9150# sg13cmos5l_inv_1_17.A VPWR VPWR sg13_lv_pmos ad=0.2856p pd=2.36u as=0.2114p ps=1.54u w=0.84u l=0.13u
X1103 a_7332_7674# sg13cmos5l_dfrbp_1_6.D a_7238_7674# VGND sg13_lv_nmos ad=60.89999f pd=0.71u as=0.1428p ps=1.52u w=0.42u l=0.13u
X1104 sg13cmos5l_buf_1_46.A a_9705_4650# VPWR VPWR sg13_lv_pmos ad=0.3808p pd=2.92u as=0.2128p ps=1.5u w=1.12u l=0.13u
X1105 VPWR sg13cmos5l_dfrbp_1_16.Q a_3625_7282# VPWR sg13_lv_pmos ad=1.07253p pd=6.75u as=0.2856p ps=2.36u w=0.84u l=0.13u
X1106 sg13cmos5l_dlhr_1_11.D a_11567_7751# VGND VGND sg13_lv_nmos ad=0.2849p pd=2.25u as=0.2516p ps=2.16u w=0.74u l=0.13u
X1107 a_17529_7047# a_16587_6935# a_17327_7285# VPWR sg13_lv_pmos ad=93.45f pd=0.865u as=0.2048p ps=1.63u w=0.42u l=0.13u
X1108 a_8988_6198# a_8439_6178# a_8852_6484# VGND sg13_lv_nmos ad=47.25f pd=0.645u as=0.141p ps=1.17u w=0.42u l=0.13u
X1109 sg13cmos5l_buf_1_10.A a_11848_8436# VPWR VPWR sg13_lv_pmos ad=0.42p pd=2.99u as=0.2114p ps=1.54u w=1.12u l=0.13u
X1110 a_19227_4654# sg13cmos5l_buf_8_0.A VPWR VPWR sg13_lv_pmos ad=0.2128p pd=1.5u as=0.2128p ps=1.5u w=1.12u l=0.13u
X1111 sg13cmos5l_dfrbp_1_11.Q a_8468_4948# VPWR VPWR sg13_lv_pmos ad=0.3808p pd=2.92u as=0.2128p ps=1.5u w=1.12u l=0.13u
X1112 VGND sg13cmos5l_dfrbp_1_6.RESET_B a_9940_4636# VGND sg13_lv_nmos ad=0.1406p pd=1.12u as=77.7f ps=0.95u w=0.74u l=0.13u
X1113 a_12742_6175# sg13cmos5l_dfrbp_1_6.RESET_B VGND VGND sg13_lv_nmos ad=37.8f pd=0.6u as=0.1701p ps=1.65u w=0.42u l=0.13u
X1114 VGND sg13cmos5l_buf_8_2.X a_20008_7712# VGND sg13_lv_nmos ad=0.14875p pd=1.16u as=0.187p ps=1.78u w=0.55u l=0.13u
X1115 a_8972_9150# sg13cmos5l_buf_1_77.A VPWR VPWR sg13_lv_pmos ad=0.2856p pd=2.36u as=0.2114p ps=1.54u w=0.84u l=0.13u
X1116 sg13cmos5l_buf_8_2.X a_19227_9190# VGND VGND sg13_lv_nmos ad=0.1406p pd=1.12u as=0.1406p ps=1.12u w=0.74u l=0.13u
X1117 VGND a_12976_2630# a_12625_2749# VGND sg13_lv_nmos ad=79.8f pd=0.8u as=0.1428p ps=1.52u w=0.42u l=0.13u
X1118 a_10473_9186# a_10292_9508# VPWR VPWR sg13_lv_pmos ad=0.2128p pd=1.5u as=0.2387p ps=1.84u w=1.12u l=0.13u
X1119 sg13cmos5l_dlhr_1_1.D a_1967_5773# VPWR VPWR sg13_lv_pmos ad=0.4312p pd=3.01u as=0.2639p ps=1.81u w=1.12u l=0.13u
X1120 VPWR sg13cmos5l_dfrbp_1_8.RESET_B a_14342_8874# VPWR sg13_lv_pmos ad=0.36237p pd=2.605u as=79.8f ps=0.8u w=0.42u l=0.13u
X1121 a_18961_5814# a_18409_5770# VGND VGND sg13_lv_nmos ad=71.99999f pd=0.865u as=1.97045p ps=12.335u w=0.64u l=0.13u
X1122 VPWR sg13cmos5l_dfrbp_1_6.RESET_B a_7498_7897# VPWR sg13_lv_pmos ad=0.1563p pd=1.22u as=0.147p ps=1.54u w=0.42u l=0.13u
X1123 a_7820_9150# sg13cmos5l_buf_1_73.A VPWR VPWR sg13_lv_pmos ad=0.2856p pd=2.36u as=0.2114p ps=1.54u w=0.84u l=0.13u
X1124 a_3308_9150# sg13cmos5l_buf_1_65.X VGND VGND sg13_lv_nmos ad=0.187p pd=1.78u as=0.14875p ps=1.16u w=0.55u l=0.13u
X1125 VPWR a_18860_6888# ph_sw[9] VPWR sg13_lv_pmos ad=0.2114p pd=1.54u as=0.42p ps=2.99u w=1.12u l=0.13u
X1126 VGND a_18928_1846# a_18577_1703# VGND sg13_lv_nmos ad=79.8f pd=0.8u as=0.1428p ps=1.52u w=0.42u l=0.13u
X1127 a_12120_3456# sg13cmos5l_o21ai_1_0.A1 VPWR VPWR sg13_lv_pmos ad=0.2128p pd=1.5u as=0.3808p ps=2.92u w=1.12u l=0.15u
X1128 nl_sw[3] a_4456_1664# VPWR VPWR sg13_lv_pmos ad=0.42p pd=2.99u as=0.2114p ps=1.54u w=1.12u l=0.13u
X1129 VPWR a_12815_4261# a_13652_3900# VPWR sg13_lv_pmos ad=0.2128p pd=1.5u as=0.3864p ps=2.93u w=1.12u l=0.13u
X1130 a_6276_8861# a_5988_8440# a_6214_8861# VGND sg13_lv_nmos ad=0.1428p pd=1.52u as=37.8f ps=0.6u w=0.42u l=0.13u
X1131 VGND sg13cmos5l_inv_1_18.A sg13cmos5l_buf_1_28.A VGND sg13_lv_nmos ad=0.2516p pd=2.16u as=0.2516p ps=2.16u w=0.74u l=0.13u
X1132 VPWR sg13cmos5l_dfrbp_1_6.RESET_B a_8841_5769# VPWR sg13_lv_pmos ad=0.2128p pd=1.5u as=0.2128p ps=1.5u w=1.12u l=0.13u
X1133 VGND a_14889_7281# a_15414_7354# VGND sg13_lv_nmos ad=0.1491p pd=1.18u as=0.187p ps=1.78u w=0.55u l=0.13u
X1134 VPWR sg13cmos5l_dfrbp_1_0.RESET_B a_15206_2826# VPWR sg13_lv_pmos ad=0.36237p pd=2.605u as=79.8f ps=0.8u w=0.42u l=0.13u
X1135 VGND a_13648_9406# a_13297_9263# VGND sg13_lv_nmos ad=79.8f pd=0.8u as=0.1428p ps=1.52u w=0.42u l=0.13u
X1136 a_10620_7326# a_10071_7282# a_10484_6924# VGND sg13_lv_nmos ad=47.25f pd=0.645u as=0.141p ps=1.17u w=0.42u l=0.13u
X1137 a_8588_3864# sg13cmos5l_buf_1_46.A VPWR VPWR sg13_lv_pmos ad=0.2856p pd=2.36u as=0.2114p ps=1.54u w=0.84u l=0.13u
X1138 VGND a_11973_1605# a_12075_1748# VGND sg13_lv_nmos ad=7.01497p pd=46.005u as=0.2516p ps=2.16u w=0.74u l=0.13u
X1139 VGND sg13cmos5l_dfrbp_1_6.RESET_B a_4276_2776# VGND sg13_lv_nmos ad=0.1406p pd=1.12u as=77.7f ps=0.95u w=0.74u l=0.13u
X1140 sg13cmos5l_dlhr_1_3.Q_N a_4566_2818# VPWR VPWR sg13_lv_pmos ad=0.3808p pd=2.92u as=0.1974p ps=1.5u w=1.12u l=0.13u
X1141 VGND sg13cmos5l_buf_1_31.X a_9448_6924# VGND sg13_lv_nmos ad=0.14875p pd=1.16u as=0.187p ps=1.78u w=0.55u l=0.13u
X1142 a_2224_7166# sg13cmos5l_dfrbp_1_6.RESET_B VPWR VPWR sg13_lv_pmos ad=79.8f pd=0.8u as=1.04815p ps=6.595u w=0.42u l=0.13u
X1143 VPWR a_8841_5769# a_8774_5412# VPWR sg13_lv_pmos ad=0.2387p pd=1.84u as=0.1008p ps=0.9u w=0.42u l=0.13u
X1144 a_9189_8447# sg13cmos5l_inv_1_2.A VPWR VPWR sg13_lv_pmos ad=0.4088p pd=2.97u as=1.12242p ps=7u w=1.12u l=0.13u
X1145 a_13520_4696# sg13cmos5l_inv_1_0.A a_13418_4696# VGND sg13_lv_nmos ad=0.1216p pd=1.02u as=0.1216p ps=1.02u w=0.64u l=0.13u
X1146 a_4005_4629# sg13cmos5l_inv_1_8.A VGND VGND sg13_lv_nmos ad=0.2516p pd=2.16u as=2.27517p ps=14.72u w=0.74u l=0.13u
X1147 sg13cmos5l_dfrbp_1_6.RESET_B cks VGND VGND sg13_lv_nmos ad=0.1443p pd=1.13u as=0.1406p ps=1.12u w=0.74u l=0.13u
X1148 VGND sg13cmos5l_buf_1_64.A a_3976_9224# VGND sg13_lv_nmos ad=0.14875p pd=1.16u as=0.187p ps=1.78u w=0.55u l=0.13u
X1149 VGND sg13cmos5l_dfrbp_1_8.RESET_B a_1956_4338# VGND sg13_lv_nmos ad=0.1626p pd=1.415u as=60.89999f ps=0.71u w=0.42u l=0.13u
X1150 a_19227_9190# cks VGND VGND sg13_lv_nmos ad=0.1406p pd=1.12u as=0.1406p ps=1.12u w=0.74u l=0.13u
X1151 a_13258_3361# a_13701_3117# a_12998_3138# VGND sg13_lv_nmos ad=79.8f pd=0.8u as=0.1296p ps=1.52u w=0.42u l=0.13u
X1152 VGND a_8588_2352# nl_sw[4] VGND sg13_lv_nmos ad=0.14875p pd=1.16u as=0.2886p ps=2.26u w=0.74u l=0.13u
X1153 VGND a_13701_3117# a_13803_3260# VGND sg13_lv_nmos ad=2.59257p pd=16.445u as=0.2516p ps=2.16u w=0.74u l=0.13u
X1154 a_8998_8861# sg13cmos5l_dfrbp_1_8.RESET_B VGND VGND sg13_lv_nmos ad=37.8f pd=0.6u as=0.1701p ps=1.65u w=0.42u l=0.13u
X1155 VPWR sg13cmos5l_dlygate4sd3_1_0.X sg13cmos5l_buf_1_43.A VPWR sg13_lv_pmos ad=0.3808p pd=2.92u as=0.3808p ps=2.92u w=1.12u l=0.13u
X1156 VPWR a_19227_9190# sg13cmos5l_buf_8_2.X VPWR sg13_lv_pmos ad=0.2128p pd=1.5u as=0.2128p ps=1.5u w=1.12u l=0.13u
X1157 a_16953_2511# a_16011_2399# a_16751_2749# VPWR sg13_lv_pmos ad=93.45f pd=0.865u as=0.2048p ps=1.63u w=0.42u l=0.13u
X1158 VGND a_5069_5376# sg13cmos5l_dfrbp_1_29.Q_N VGND sg13_lv_nmos ad=0.2516p pd=2.16u as=0.2849p ps=2.25u w=0.74u l=0.13u
X1159 VGND cks sg13cmos5l_dfrbp_1_6.RESET_B VGND sg13_lv_nmos ad=0.1406p pd=1.12u as=0.1406p ps=1.12u w=0.74u l=0.13u
X1160 VPWR a_16677_6141# a_16779_6284# VPWR sg13_lv_pmos ad=1.07253p pd=6.75u as=0.3864p ps=2.93u w=1.12u l=0.13u
X1161 a_1967_7285# a_1125_6935# a_708_6928# VPWR sg13_lv_pmos ad=0.2048p pd=1.63u as=0.34p ps=2.68u w=1u l=0.13u
X1162 sg13cmos5l_dfrbp_1_9.Q a_4244_3900# VPWR VPWR sg13_lv_pmos ad=0.3808p pd=2.92u as=0.2128p ps=1.5u w=1.12u l=0.13u
X1163 a_14820_7674# sg13cmos5l_buf_1_57.X a_14726_7674# VGND sg13_lv_nmos ad=60.89999f pd=0.71u as=0.1428p ps=1.52u w=0.42u l=0.13u
X1164 a_6736_2630# a_6479_2749# a_6898_2826# VGND sg13_lv_nmos ad=0.1428p pd=1.52u as=37.8f ps=0.6u w=0.42u l=0.13u
X1165 a_5799_5499# a_5951_5383# VPWR VPWR sg13_lv_pmos ad=0.3864p pd=2.93u as=1.28962p ps=8.195u w=1.12u l=0.13u
X1166 sg13cmos5l_inv_1_20.Y sg13cmos5l_buf_1_41.A VGND VGND sg13_lv_nmos ad=0.2516p pd=2.16u as=0.2516p ps=2.16u w=0.74u l=0.13u
X1167 VPWR VGND VPWR VPWR sg13_lv_pmos ad=0.19p pd=1.38u as=0 ps=0 w=1u l=1u
X1168 nh_sw[3] a_5704_1664# VGND VGND sg13_lv_nmos ad=0.2886p pd=2.26u as=0.14875p ps=1.16u w=0.74u l=0.13u
X1169 sg13cmos5l_dlhr_1_18.Q_N a_11190_7354# VPWR VPWR sg13_lv_pmos ad=0.3808p pd=2.92u as=0.1974p ps=1.5u w=1.12u l=0.13u
X1170 VGND a_15045_8447# a_15147_8447# VGND sg13_lv_nmos ad=2.92392p pd=18.89u as=0.2516p ps=2.16u w=0.74u l=0.13u
X1171 a_17367_8794# sg13cmos5l_dfrbp_1_22.D VGND VGND sg13_lv_nmos ad=0.2516p pd=2.16u as=0.15055p ps=1.17u w=0.74u l=0.13u
X1172 sg13cmos5l_nand2_1_0.B sg13cmos5l_a221oi_1_0.C1 VPWR VPWR sg13_lv_pmos ad=0.2128p pd=1.5u as=0.2198p ps=1.53u w=1.12u l=0.13u
X1173 sg13cmos5l_dlhr_1_11.GATE a_10868_8436# VPWR VPWR sg13_lv_pmos ad=0.3808p pd=2.92u as=0.2128p ps=1.5u w=1.12u l=0.13u
X1174 VPWR a_11973_1605# a_12075_1748# VPWR sg13_lv_pmos ad=1.86162p pd=11.935u as=0.3864p ps=2.93u w=1.12u l=0.13u
X1175 sg13cmos5l_dfrbp_1_22.Q_N a_17327_7285# VGND VGND sg13_lv_nmos ad=0.2849p pd=2.25u as=0.2516p ps=2.16u w=0.74u l=0.13u
X1176 VPWR a_1463_8741# a_1463_8511# VPWR sg13_lv_pmos ad=1.15047p pd=7.175u as=0.2442p ps=2.06u w=0.66u l=0.13u
X1177 a_2831_7630# sg13cmos5l_dfrbp_1_16.Q_N VGND VGND sg13_lv_nmos ad=0.187p pd=1.78u as=0.15055p ps=1.17u w=0.55u l=0.13u
X1178 a_12980_6924# a_12698_7288# a_12913_7326# VGND sg13_lv_nmos ad=0.141p pd=1.17u as=71.99999f ps=0.865u w=0.64u l=0.13u
X1179 a_18122_2388# sg13cmos5l_nor2_1_1.A VPWR VPWR sg13_lv_pmos ad=0.1176p pd=1.33u as=0.4032p ps=2.96u w=1.12u l=0.13u
X1180 a_2628_3151# a_2340_3456# a_2566_3151# VGND sg13_lv_nmos ad=0.1428p pd=1.52u as=37.8f ps=0.6u w=0.42u l=0.13u
X1181 a_4322_6162# sg13cmos5l_dfrbp_1_8.RESET_B VGND VGND sg13_lv_nmos ad=60.89999f pd=0.71u as=0.1626p ps=1.415u w=0.42u l=0.13u
X1182 sg13cmos5l_buf_1_105.A a_17961_8793# VGND VGND sg13_lv_nmos ad=0.2516p pd=2.16u as=0.1406p ps=1.12u w=0.74u l=0.13u
X1183 a_17327_7285# a_16485_6935# a_16068_6928# VPWR sg13_lv_pmos ad=0.2048p pd=1.63u as=0.34p ps=2.68u w=1u l=0.13u
X1184 a_3826_8874# sg13cmos5l_dfrbp_1_8.RESET_B VGND VGND sg13_lv_nmos ad=37.8f pd=0.6u as=79.8f ps=0.8u w=0.42u l=0.13u
X1185 a_19340_8400# sg13cmos5l_buf_1_107.X VPWR VPWR sg13_lv_pmos ad=0.2856p pd=2.36u as=0.2114p ps=1.54u w=0.84u l=0.13u
X1186 VPWR a_4076_7624# a_3676_7964# VPWR sg13_lv_pmos ad=0.2387p pd=1.84u as=0.2128p ps=1.5u w=1.12u l=0.13u
X1187 frame a_20008_7712# VPWR VPWR sg13_lv_pmos ad=0.42p pd=2.99u as=0.2114p ps=1.54u w=1.12u l=0.13u
X1188 sg13cmos5l_inv_1_29.A a_12404_7972# VGND VGND sg13_lv_nmos ad=0.2516p pd=2.16u as=0.1406p ps=1.12u w=0.74u l=0.13u
X1189 VGND sg13cmos5l_nand2_1_1.B a_10094_2780# VGND sg13_lv_nmos ad=0.2516p pd=2.16u as=96.2f ps=1u w=0.74u l=0.13u
X1190 VGND sg13cmos5l_a221oi_1_0.A2 a_8041_5770# VGND sg13_lv_nmos ad=0.15055p pd=1.17u as=0.187p ps=1.78u w=0.55u l=0.13u
X1191 a_8486_8874# sg13cmos5l_dfrbp_1_18.Q VPWR VPWR sg13_lv_pmos ad=79.8f pd=0.8u as=0.1428p ps=1.52u w=0.42u l=0.13u
X1192 a_16462_4023# a_16204_4338# VPWR VPWR sg13_lv_pmos ad=93.45f pd=0.865u as=1.43437p ps=9.105u w=0.42u l=0.13u
X1193 a_6084_4325# a_6315_3911# a_5770_3868# VGND sg13_lv_nmos ad=0.2373p pd=1.97u as=79.8f ps=0.8u w=0.42u l=0.13u
X1194 a_11973_3911# sg13cmos5l_dfrbp_1_0.CLK VGND VGND sg13_lv_nmos ad=0.2516p pd=2.16u as=2.41737p ps=15.64u w=0.74u l=0.13u
X1195 sg13cmos5l_buf_1_79.X a_9256_9224# VGND VGND sg13_lv_nmos ad=0.2886p pd=2.26u as=0.14875p ps=1.16u w=0.74u l=0.13u
X1196 VPWR VGND VPWR VPWR sg13_lv_pmos ad=0.19p pd=1.38u as=0 ps=0 w=1u l=1u
X1197 VPWR a_13701_3117# a_13803_3260# VPWR sg13_lv_pmos ad=1.43437p pd=9.105u as=0.3864p ps=2.93u w=1.12u l=0.13u
X1198 a_18928_1846# a_18671_1703# a_19090_1626# VGND sg13_lv_nmos ad=0.1428p pd=1.52u as=37.8f ps=0.6u w=0.42u l=0.13u
X1199 a_16940_3102# sg13cmos5l_buf_1_4.X VGND VGND sg13_lv_nmos ad=0.187p pd=1.78u as=0.14875p ps=1.16u w=0.55u l=0.13u
X1200 a_9129_8483# a_8772_8440# VPWR VPWR sg13_lv_pmos ad=63f pd=0.72u as=0.1563p ps=1.22u w=0.42u l=0.13u
X1201 a_7881_8065# a_7524_7992# VPWR VPWR sg13_lv_pmos ad=63f pd=0.72u as=0.1563p ps=1.22u w=0.42u l=0.13u
X1202 VPWR cks a_19227_9190# VPWR sg13_lv_pmos ad=0.2128p pd=1.5u as=0.2128p ps=1.5u w=1.12u l=0.13u
X1203 a_17638_1639# sg13cmos5l_dfrbp_1_0.RESET_B VGND VGND sg13_lv_nmos ad=37.8f pd=0.6u as=0.1701p ps=1.65u w=0.42u l=0.13u
X1204 a_14996_5412# a_14583_5770# a_14928_5412# VPWR sg13_lv_pmos ad=0.191p pd=1.44u as=0.105p ps=1.21u w=1u l=0.13u
X1205 VGND sg13cmos5l_dfrbp_1_8.RESET_B a_5546_5850# VGND sg13_lv_nmos ad=79.8f pd=0.8u as=37.8f ps=0.6u w=0.42u l=0.13u
X1206 VGND a_2732_1590# sg13cmos5l_buf_1_35.A VGND sg13_lv_nmos ad=0.14875p pd=1.16u as=0.2886p ps=2.26u w=0.74u l=0.13u
X1207 a_17595_3947# a_16703_3871# a_17493_3947# VPWR sg13_lv_pmos ad=63f pd=0.72u as=79.8f ps=0.8u w=0.42u l=0.13u
X1208 sg13cmos5l_dlhr_1_9.D a_2804_5412# VPWR VPWR sg13_lv_pmos ad=0.3808p pd=2.92u as=0.2128p ps=1.5u w=1.12u l=0.13u
X1209 VPWR a_4460_9150# sg13cmos5l_buf_1_60.X VPWR sg13_lv_pmos ad=0.2114p pd=1.54u as=0.42p ps=2.99u w=1.12u l=0.13u
X1210 sg13cmos5l_dfrbp_1_17.Q_N a_3407_8797# VGND VGND sg13_lv_nmos ad=0.2849p pd=2.25u as=0.2516p ps=2.16u w=0.74u l=0.13u
X1211 a_16268_1590# sg13cmos5l_buf_1_1.A VPWR VPWR sg13_lv_pmos ad=0.2856p pd=2.36u as=0.2114p ps=1.54u w=0.84u l=0.13u
X1212 VGND a_16271_7751# a_17108_7972# VGND sg13_lv_nmos ad=0.1406p pd=1.12u as=0.2516p ps=2.16u w=0.74u l=0.13u
X1213 a_4041_2745# a_3860_2388# VPWR VPWR sg13_lv_pmos ad=0.2128p pd=1.5u as=0.2387p ps=1.84u w=1.12u l=0.13u
X1214 a_12358_9199# sg13cmos5l_dfrbp_1_8.RESET_B VGND VGND sg13_lv_nmos ad=37.8f pd=0.6u as=0.1701p ps=1.65u w=0.42u l=0.13u
X1215 a_13876_7660# a_13460_7996# a_13641_7674# VGND sg13_lv_nmos ad=77.7f pd=0.95u as=0.2516p ps=2.16u w=0.74u l=0.13u
X1216 VPWR a_18363_4270# sg13cmos5l_or2_1_0.A VPWR sg13_lv_pmos ad=0.3864p pd=2.93u as=0.2128p ps=1.5u w=1.12u l=0.13u
X1217 sg13cmos5l_buf_1_93.X a_14632_9224# VGND VGND sg13_lv_nmos ad=0.2886p pd=2.26u as=0.14875p ps=1.16u w=0.74u l=0.13u
X1218 a_16751_2749# a_15909_2399# a_15492_2392# VPWR sg13_lv_pmos ad=0.2048p pd=1.63u as=0.34p ps=2.68u w=1u l=0.13u
X1219 a_17008_2630# sg13cmos5l_dfrbp_1_0.RESET_B VPWR VPWR sg13_lv_pmos ad=79.8f pd=0.8u as=1.777p ps=11.395u w=0.42u l=0.13u
X1220 nl_sw[2] a_2248_1664# VGND VGND sg13_lv_nmos ad=0.2886p pd=2.26u as=0.14875p ps=1.16u w=0.74u l=0.13u
X1221 a_14458_4270# sg13cmos5l_nand2_1_1.B VGND VGND sg13_lv_nmos ad=0.1406p pd=1.12u as=0.2516p ps=2.16u w=0.74u l=0.13u
X1222 a_11567_7751# a_10725_7653# a_10308_7992# VPWR sg13_lv_pmos ad=0.2048p pd=1.63u as=0.34p ps=2.68u w=1u l=0.13u
X1223 VPWR a_6117_6141# a_6219_6284# VPWR sg13_lv_pmos ad=1.07253p pd=6.75u as=0.3864p ps=2.93u w=1.12u l=0.13u
X1224 VPWR sg13cmos5l_buf_1_62.X a_1864_9224# VPWR sg13_lv_pmos ad=0.2114p pd=1.54u as=0.2856p ps=2.36u w=0.84u l=0.13u
X1225 a_12921_2511# a_11979_2399# a_12719_2749# VPWR sg13_lv_pmos ad=93.45f pd=0.865u as=0.2048p ps=1.63u w=0.42u l=0.13u
X1226 ph_sw[2] a_3976_9224# VPWR VPWR sg13_lv_pmos ad=0.42p pd=2.99u as=0.2114p ps=1.54u w=1.12u l=0.13u
X1227 VPWR a_3664_8678# a_3609_8559# VPWR sg13_lv_pmos ad=1.15047p pd=7.175u as=93.45f ps=0.865u w=0.42u l=0.13u
X1228 sg13cmos5l_buf_1_105.A a_17961_8793# VPWR VPWR sg13_lv_pmos ad=0.3808p pd=2.92u as=0.2128p ps=1.5u w=1.12u l=0.13u
X1229 VGND a_4076_5376# sg13cmos5l_inv_1_17.A VGND sg13_lv_nmos ad=0.14875p pd=1.16u as=0.2886p ps=2.26u w=0.74u l=0.13u
X1230 sg13cmos5l_or2_1_0.A a_18363_4270# VPWR VPWR sg13_lv_pmos ad=0.2128p pd=1.5u as=0.2128p ps=1.5u w=1.12u l=0.13u
X1231 a_5796_3904# a_5770_3868# VPWR VPWR sg13_lv_pmos ad=0.34p pd=2.68u as=0.36237p ps=2.605u w=1u l=0.13u
X1232 VGND sg13cmos5l_dfrbp_1_8.RESET_B a_6998_5837# VGND sg13_lv_nmos ad=0.1701p pd=1.65u as=37.8f ps=0.6u w=0.42u l=0.13u
X1233 sg13cmos5l_buf_1_104.X a_19624_8436# VPWR VPWR sg13_lv_pmos ad=0.42p pd=2.99u as=0.2114p ps=1.54u w=1.12u l=0.13u
X1234 sg13cmos5l_dfrbp_1_7.Q_N a_14543_3215# VPWR VPWR sg13_lv_pmos ad=0.4312p pd=3.01u as=0.2639p ps=1.81u w=1.12u l=0.13u
X1235 VGND a_18345_7674# a_18300_7710# VGND sg13_lv_nmos ad=0.1428p pd=1.52u as=47.25f ps=0.645u w=0.42u l=0.13u
X1236 VPWR VGND VPWR VPWR sg13_lv_pmos ad=0.19p pd=1.38u as=0 ps=0 w=1u l=1u
X1237 VPWR a_6479_2749# a_7316_2388# VPWR sg13_lv_pmos ad=0.2128p pd=1.5u as=0.3864p ps=2.93u w=1.12u l=0.13u
X1238 a_11940_9186# sg13cmos5l_dlhr_1_11.GATE a_11846_9186# VGND sg13_lv_nmos ad=60.89999f pd=0.71u as=0.1428p ps=1.52u w=0.42u l=0.13u
X1239 a_2228_4972# a_1946_4660# a_2161_4642# VGND sg13_lv_nmos ad=0.141p pd=1.17u as=71.99999f ps=0.865u w=0.64u l=0.13u
X1240 VPWR sg13cmos5l_buf_1_2.A a_15784_1664# VPWR sg13_lv_pmos ad=0.2114p pd=1.54u as=0.2856p ps=2.36u w=0.84u l=0.13u
X1241 a_10783_3876# sg13cmos5l_nand2_1_0.A VPWR VPWR sg13_lv_pmos ad=0.2716p pd=1.605u as=0.3808p ps=2.92u w=1.12u l=0.13u
X1242 a_524_4614# sg13cmos5l_buf_1_43.A VGND VGND sg13_lv_nmos ad=0.187p pd=1.78u as=0.14875p ps=1.16u w=0.55u l=0.13u
X1243 VPWR sg13cmos5l_inv_1_5.A a_20392_3900# VPWR sg13_lv_pmos ad=0.2114p pd=1.54u as=0.2856p ps=2.36u w=0.84u l=0.13u
X1244 a_14602_8404# a_15045_8447# a_14342_8874# VGND sg13_lv_nmos ad=79.8f pd=0.8u as=0.1296p ps=1.52u w=0.42u l=0.13u
X1245 sg13cmos5l_dlhr_1_10.Q a_19593_6162# VGND VGND sg13_lv_nmos ad=0.2516p pd=2.16u as=0.1406p ps=1.12u w=0.74u l=0.13u
X1246 VGND a_1967_5773# a_2804_5412# VGND sg13_lv_nmos ad=0.1406p pd=1.12u as=0.2516p ps=2.16u w=0.74u l=0.13u
X1247 VGND a_3664_4142# a_3313_4261# VGND sg13_lv_nmos ad=79.8f pd=0.8u as=0.1428p ps=1.52u w=0.42u l=0.13u
X1248 VGND sg13cmos5l_buf_1_40.A a_1192_1664# VGND sg13_lv_nmos ad=0.14875p pd=1.16u as=0.187p ps=1.78u w=0.55u l=0.13u
X1249 VPWR sg13cmos5l_dfrbp_1_6.RESET_B a_5770_3868# VPWR sg13_lv_pmos ad=0.1563p pd=1.22u as=0.147p ps=1.54u w=0.42u l=0.13u
X1250 VGND a_1125_6935# a_1227_6935# VGND sg13_lv_nmos ad=1.49685p pd=9.6u as=0.2516p ps=2.16u w=0.74u l=0.13u
X1251 VPWR a_1484_6126# sg13cmos5l_buf_1_40.A VPWR sg13_lv_pmos ad=0.2114p pd=1.54u as=0.42p ps=2.99u w=1.12u l=0.13u
X1252 a_6660_4663# a_6372_4968# a_6598_4663# VGND sg13_lv_nmos ad=0.1428p pd=1.52u as=37.8f ps=0.6u w=0.42u l=0.13u
X1253 a_16234_6385# a_16677_6141# a_15974_6162# VGND sg13_lv_nmos ad=79.8f pd=0.8u as=0.1296p ps=1.52u w=0.42u l=0.13u
X1254 VPWR a_13391_9263# a_13648_9406# VPWR sg13_lv_pmos ad=0.2639p pd=1.81u as=79.8f ps=0.8u w=0.42u l=0.13u
X1255 sg13cmos5l_dlhr_1_0.Q_N a_8214_1608# VPWR VPWR sg13_lv_pmos ad=0.3808p pd=2.92u as=0.1974p ps=1.5u w=1.12u l=0.13u
X1256 a_10292_9508# a_10010_9196# a_10225_9178# VGND sg13_lv_nmos ad=0.141p pd=1.17u as=71.99999f ps=0.865u w=0.64u l=0.13u
X1257 sg13cmos5l_dlhr_1_2.Q_N a_8022_3120# VGND VGND sg13_lv_nmos ad=0.2516p pd=2.16u as=0.1491p ps=1.18u w=0.74u l=0.13u
X1258 a_10416_6924# a_9865_7282# VPWR VPWR sg13_lv_pmos ad=0.105p pd=1.21u as=1.07253p ps=6.75u w=1u l=0.13u
X1259 a_14032_6382# sg13cmos5l_dfrbp_1_6.RESET_B VPWR VPWR sg13_lv_pmos ad=79.8f pd=0.8u as=1.04815p ps=6.595u w=0.42u l=0.13u
X1260 VGND sg13cmos5l_dfrbp_1_8.RESET_B a_3926_6175# VGND sg13_lv_nmos ad=0.1701p pd=1.65u as=37.8f ps=0.6u w=0.42u l=0.13u
X1261 VPWR a_3856_3358# a_3801_3453# VPWR sg13_lv_pmos ad=1.43437p pd=9.105u as=93.45f ps=0.865u w=0.42u l=0.13u
X1262 VGND a_8457_7281# a_8412_7326# VGND sg13_lv_nmos ad=0.1428p pd=1.52u as=47.25f ps=0.645u w=0.42u l=0.13u
X1263 a_422_7362# a_1227_6935# a_682_6892# VPWR sg13_lv_pmos ad=0.1428p pd=1.52u as=79.8f ps=0.8u w=0.42u l=0.13u
X1264 VPWR sg13cmos5l_dfrbp_1_6.RESET_B a_7238_7674# VPWR sg13_lv_pmos ad=0.36237p pd=2.605u as=79.8f ps=0.8u w=0.42u l=0.13u
X1265 a_18164_7996# a_17751_7690# a_18096_7996# VPWR sg13_lv_pmos ad=0.191p pd=1.44u as=0.105p ps=1.21u w=1u l=0.13u
X1266 VPWR sg13cmos5l_buf_1_29.A sg13cmos5l_buf_1_77.A VPWR sg13_lv_pmos ad=0.3808p pd=2.92u as=0.3808p ps=2.92u w=1.12u l=0.13u
X1267 VPWR VGND VPWR VPWR sg13_lv_pmos ad=0.34p pd=2.68u as=0 ps=0 w=1u l=1u
X1268 a_5452_5850# a_5069_5376# VPWR VPWR sg13_lv_pmos ad=79.8f pd=0.8u as=0.2639p ps=1.81u w=0.42u l=0.13u
X1269 a_4460_9150# sg13cmos5l_buf_1_60.A VPWR VPWR sg13_lv_pmos ad=0.2856p pd=2.36u as=0.2114p ps=1.54u w=0.84u l=0.13u
X1270 sg13cmos5l_inv_1_20.Y sg13cmos5l_buf_1_41.A VPWR VPWR sg13_lv_pmos ad=0.3808p pd=2.92u as=0.3808p ps=2.92u w=1.12u l=0.13u
X1271 VPWR sg13cmos5l_dfrbp_1_20.Q_N a_9673_9240# VPWR sg13_lv_pmos ad=4.11675p pd=27.17u as=0.2856p ps=2.36u w=0.84u l=0.13u
X1272 a_11877_2399# sg13cmos5l_dfrbp_1_0.CLK VPWR VPWR sg13_lv_pmos ad=0.4088p pd=2.97u as=1.777p ps=11.395u w=1.12u l=0.13u
X1273 VGND sg13cmos5l_dfrbp_1_0.RESET_B a_11364_1626# VGND sg13_lv_nmos ad=0.1626p pd=1.415u as=60.89999f ps=0.71u w=0.42u l=0.13u
X1274 VPWR sg13cmos5l_dfrbp_1_6.RESET_B a_13641_7674# VPWR sg13_lv_pmos ad=0.2128p pd=1.5u as=0.2128p ps=1.5u w=1.12u l=0.13u
X1275 VGND a_14924_1590# nh_sw[6] VGND sg13_lv_nmos ad=0.14875p pd=1.16u as=0.2886p ps=2.26u w=0.74u l=0.13u
X1276 a_2340_3456# a_2859_3260# a_3599_3215# VGND sg13_lv_nmos ad=0.3473p pd=2.71u as=0.12665p ps=1.145u w=0.74u l=0.13u
X1277 VPWR sg13cmos5l_dlhr_1_9.D a_10587_4692# VPWR sg13_lv_pmos ad=0.2198p pd=1.53u as=0.2856p ps=2.36u w=0.84u l=0.13u
X1278 VPWR VGND VPWR VPWR sg13_lv_pmos ad=0.19p pd=1.38u as=0 ps=0 w=1u l=1u
X1279 VGND sg13cmos5l_nor2_1_1.A sg13cmos5l_nor2b_1_1.Y VGND sg13_lv_nmos ad=0.2516p pd=2.16u as=0.1406p ps=1.12u w=0.74u l=0.13u
X1280 VPWR a_12719_2749# a_12976_2630# VPWR sg13_lv_pmos ad=0.2639p pd=1.81u as=79.8f ps=0.8u w=0.42u l=0.13u
X1281 sg13cmos5l_dfrbp_1_18.Q_N a_7247_8797# VPWR VPWR sg13_lv_pmos ad=0.4312p pd=3.01u as=0.2639p ps=1.81u w=1.12u l=0.13u
X1282 VGND sg13cmos5l_or2_1_1.B a_10726_5760# VGND sg13_lv_nmos ad=0.2516p pd=2.16u as=0.1406p ps=1.12u w=0.74u l=0.13u
X1283 sg13cmos5l_dfrbp_1_14.Q_N a_4847_4727# VGND VGND sg13_lv_nmos ad=0.2849p pd=2.25u as=0.2516p ps=2.16u w=0.74u l=0.13u
X1284 a_12716_8400# sg13cmos5l_buf_1_79.X VPWR VPWR sg13_lv_pmos ad=0.2856p pd=2.36u as=0.2114p ps=1.54u w=0.84u l=0.13u
X1285 a_17751_7690# sg13cmos5l_dfrbp_1_22.D VPWR VPWR sg13_lv_pmos ad=0.3234p pd=2.45u as=1.12242p ps=7u w=0.84u l=0.13u
X1286 sg13cmos5l_nor2b_1_1.Y sg13cmos5l_nor2_1_1.A a_14476_2388# VPWR sg13_lv_pmos ad=0.3808p pd=2.92u as=0.1176p ps=1.33u w=1.12u l=0.13u
X1287 VPWR a_7055_4261# a_7892_3900# VPWR sg13_lv_pmos ad=0.2128p pd=1.5u as=0.3864p ps=2.93u w=1.12u l=0.13u
X1288 VPWR a_5132_9150# sg13cmos5l_buf_1_64.A VPWR sg13_lv_pmos ad=0.2114p pd=1.54u as=0.42p ps=2.99u w=1.12u l=0.13u
X1289 sg13cmos5l_inv_1_7.A a_11464_8436# VPWR VPWR sg13_lv_pmos ad=0.42p pd=2.99u as=0.2114p ps=1.54u w=1.12u l=0.13u
X1290 a_6789_4629# sg13cmos5l_inv_1_8.A VGND VGND sg13_lv_nmos ad=0.2516p pd=2.16u as=2.27517p ps=14.72u w=0.74u l=0.13u
X1291 VGND sg13cmos5l_dlhr_1_15.Q a_19240_7712# VGND sg13_lv_nmos ad=0.14875p pd=1.16u as=0.187p ps=1.78u w=0.55u l=0.13u
X1292 sg13cmos5l_buf_1_5.X a_14440_1664# VGND VGND sg13_lv_nmos ad=0.2886p pd=2.26u as=0.14875p ps=1.16u w=0.74u l=0.13u
X1293 VGND sg13cmos5l_dfrbp_1_0.RESET_B a_13092_3138# VGND sg13_lv_nmos ad=0.1626p pd=1.415u as=60.89999f ps=0.71u w=0.42u l=0.13u
X1294 a_1196_8400# sg13cmos5l_buf_1_63.A VPWR VPWR sg13_lv_pmos ad=0.2856p pd=2.36u as=0.2114p ps=1.54u w=0.84u l=0.13u
X1295 VPWR sg13cmos5l_dfrbp_1_6.RESET_B a_9033_6162# VPWR sg13_lv_pmos ad=0.2128p pd=1.5u as=0.2128p ps=1.5u w=1.12u l=0.13u
X1296 a_12022_3134# sg13cmos5l_o21ai_1_0.A2 VGND VGND sg13_lv_nmos ad=0.1406p pd=1.12u as=0.1406p ps=1.12u w=0.74u l=0.15u
X1297 a_18345_7674# a_18164_7996# VPWR VPWR sg13_lv_pmos ad=0.2128p pd=1.5u as=0.2387p ps=1.84u w=1.12u l=0.13u
X1298 VPWR a_8247_5770# a_8378_5776# VPWR sg13_lv_pmos ad=1.28962p pd=8.195u as=0.2856p ps=2.36u w=0.84u l=0.13u
X1299 VPWR a_19628_2352# nh_sw[9] VPWR sg13_lv_pmos ad=0.2114p pd=1.54u as=0.42p ps=2.99u w=1.12u l=0.13u
X1300 VPWR a_19216_3358# a_19161_3453# VPWR sg13_lv_pmos ad=1.43437p pd=9.105u as=93.45f ps=0.865u w=0.42u l=0.13u
X1301 sg13cmos5l_dfrbp_1_6.D a_1672_3176# VPWR VPWR sg13_lv_pmos ad=0.42p pd=2.99u as=0.2114p ps=1.54u w=1.12u l=0.13u
X1302 VPWR sg13cmos5l_buf_1_24.A sg13cmos5l_buf_1_78.A VPWR sg13_lv_pmos ad=0.3808p pd=2.92u as=0.3808p ps=2.92u w=1.12u l=0.13u
X1303 VPWR sg13cmos5l_buf_1_18.A a_18376_2388# VPWR sg13_lv_pmos ad=0.2114p pd=1.54u as=0.2856p ps=2.36u w=0.84u l=0.13u
X1304 VGND sg13cmos5l_dfrbp_1_10.Q_N a_3241_2746# VGND sg13_lv_nmos ad=0.15055p pd=1.17u as=0.187p ps=1.78u w=0.55u l=0.13u
X1305 VPWR a_10031_8797# a_10288_8678# VPWR sg13_lv_pmos ad=0.2639p pd=1.81u as=79.8f ps=0.8u w=0.42u l=0.13u
X1306 a_8660_5412# a_8378_5776# a_8593_5814# VGND sg13_lv_nmos ad=0.141p pd=1.17u as=71.99999f ps=0.865u w=0.64u l=0.13u
X1307 a_5962_8404# a_6405_8447# a_6345_8483# VPWR sg13_lv_pmos ad=79.8f pd=0.8u as=63f ps=0.72u w=0.42u l=0.13u
X1308 a_17700_3456# a_18219_3260# a_18959_3215# VGND sg13_lv_nmos ad=0.3473p pd=2.71u as=0.12665p ps=1.145u w=0.74u l=0.13u
X1309 a_17776_6382# a_17519_6239# a_17938_6162# VGND sg13_lv_nmos ad=0.1428p pd=1.52u as=37.8f ps=0.6u w=0.42u l=0.13u
X1310 VGND sg13cmos5l_buf_1_41.X a_2824_2388# VGND sg13_lv_nmos ad=0.14875p pd=1.16u as=0.187p ps=1.78u w=0.55u l=0.13u
X1311 a_10420_5760# sg13cmos5l_dfrbp_1_16.Q VGND VGND sg13_lv_nmos ad=0.1406p pd=1.12u as=0.1406p ps=1.12u w=0.74u l=0.13u
X1312 sg13cmos5l_dfrbp_1_1.Q a_13652_1924# VPWR VPWR sg13_lv_pmos ad=0.3808p pd=2.92u as=0.2128p ps=1.5u w=1.12u l=0.13u
X1313 VPWR a_11372_3102# nh_sw[5] VPWR sg13_lv_pmos ad=0.2114p pd=1.54u as=0.42p ps=2.99u w=1.12u l=0.13u
X1314 a_4358_6924# a_3962_7288# a_4244_6924# VPWR sg13_lv_pmos ad=0.1008p pd=0.9u as=0.191p ps=1.44u w=0.42u l=0.13u
X1315 VGND VPWR VGND VGND sg13_lv_nmos ad=0.1428p pd=1.52u as=0 ps=0 w=0.42u l=1u
X1316 VGND sg13cmos5l_dfrbp_1_12.Q_N a_8905_4704# VGND sg13_lv_nmos ad=0.15055p pd=1.17u as=0.187p ps=1.78u w=0.55u l=0.13u
X1317 a_8439_6178# sg13cmos5l_dlhr_1_5.GATE VGND VGND sg13_lv_nmos ad=0.2516p pd=2.16u as=0.15055p ps=1.17u w=0.74u l=0.13u
X1318 a_682_6892# a_1125_6935# a_422_7362# VGND sg13_lv_nmos ad=79.8f pd=0.8u as=0.1296p ps=1.52u w=0.42u l=0.13u
X1319 VGND a_8841_5769# a_8796_5814# VGND sg13_lv_nmos ad=0.1428p pd=1.52u as=47.25f ps=0.645u w=0.42u l=0.13u
X1320 a_1956_8874# sg13cmos5l_dfrbp_1_17.D a_1862_8874# VGND sg13_lv_nmos ad=60.89999f pd=0.71u as=0.1428p ps=1.52u w=0.42u l=0.13u
X1321 a_5324_1590# sg13cmos5l_buf_1_34.X VGND VGND sg13_lv_nmos ad=0.187p pd=1.78u as=0.14875p ps=1.16u w=0.55u l=0.13u
X1322 VPWR a_7497_3138# a_7430_3576# VPWR sg13_lv_pmos ad=0.2387p pd=1.84u as=0.1008p ps=0.9u w=0.42u l=0.13u
X1323 VPWR sg13cmos5l_dfrbp_1_10.Q a_10331_3900# VPWR sg13_lv_pmos ad=0.2128p pd=1.5u as=0.2128p ps=1.5u w=1.12u l=0.13u
X1324 VGND VPWR VGND VGND sg13_lv_nmos ad=79.8f pd=0.8u as=0 ps=0 w=0.42u l=1u
X1325 VPWR sg13cmos5l_inv_1_0.A sg13cmos5l_inv_1_0.Y VPWR sg13_lv_pmos ad=0.3808p pd=2.92u as=0.3808p ps=2.92u w=1.12u l=0.13u
X1326 sg13cmos5l_nand2_1_1.A a_15380_3436# VPWR VPWR sg13_lv_pmos ad=0.3808p pd=2.92u as=0.2128p ps=1.5u w=1.12u l=0.13u
X1327 VPWR sg13cmos5l_dfrbp_1_6.RESET_B a_14726_7674# VPWR sg13_lv_pmos ad=0.36237p pd=2.605u as=79.8f ps=0.8u w=0.42u l=0.13u
X1328 sg13cmos5l_a22oi_1_0.B1 sg13cmos5l_nand2_1_0.A VPWR VPWR sg13_lv_pmos ad=0.2128p pd=1.5u as=0.3808p ps=2.92u w=1.12u l=0.13u
X1329 sg13cmos5l_dlhr_1_16.Q_N a_19734_5842# VPWR VPWR sg13_lv_pmos ad=0.3808p pd=2.92u as=0.1974p ps=1.5u w=1.12u l=0.13u
X1330 sg13cmos5l_dlhr_1_10.Q_N a_20118_6144# VGND VGND sg13_lv_nmos ad=0.2516p pd=2.16u as=0.1491p ps=1.18u w=0.74u l=0.13u
X1331 a_2748_6126# a_2879_6432# a_1997_6126# VPWR sg13_lv_pmos ad=0.34p pd=2.68u as=0.2048p ps=1.63u w=1u l=0.13u
X1332 sg13cmos5l_dfrbp_1_5.Q_N a_16751_2749# VPWR VPWR sg13_lv_pmos ad=0.4312p pd=3.01u as=0.2639p ps=1.81u w=1.12u l=0.13u
X1333 a_20012_1590# sg13cmos5l_buf_1_0.A VPWR VPWR sg13_lv_pmos ad=0.2856p pd=2.36u as=0.2114p ps=1.54u w=0.84u l=0.13u
X1334 a_14924_1590# sg13cmos5l_buf_1_6.A VPWR VPWR sg13_lv_pmos ad=0.2856p pd=2.36u as=0.2114p ps=1.54u w=0.84u l=0.13u
X1335 a_11556_3904# a_12075_3911# a_12815_4261# VGND sg13_lv_nmos ad=0.3473p pd=2.71u as=0.12665p ps=1.145u w=0.74u l=0.13u
X1336 a_11072_5347# sg13cmos5l_dlhr_1_15.D VPWR VPWR sg13_lv_pmos ad=0.1596p pd=1.22u as=0.36195p ps=1.84u w=0.84u l=0.13u
X1337 VPWR a_15702_4187# sg13cmos5l_and3_1_0.C VPWR sg13_lv_pmos ad=0.2128p pd=1.5u as=0.3808p ps=2.92u w=1.12u l=0.13u
X1338 a_5132_9150# sg13cmos5l_buf_1_44.X VPWR VPWR sg13_lv_pmos ad=0.2856p pd=2.36u as=0.2114p ps=1.54u w=0.84u l=0.13u
X1339 a_14342_8874# a_15147_8447# a_14602_8404# VPWR sg13_lv_pmos ad=0.1428p pd=1.52u as=79.8f ps=0.8u w=0.42u l=0.13u
X1340 a_4244_6924# a_3962_7288# a_4177_7326# VGND sg13_lv_nmos ad=0.141p pd=1.17u as=71.99999f ps=0.865u w=0.64u l=0.13u
X1341 VPWR a_18999_6178# a_19130_6172# VPWR sg13_lv_pmos ad=1.07253p pd=6.75u as=0.2856p ps=2.36u w=0.84u l=0.13u
X1342 sg13cmos5l_dfrbp_1_8.RESET_B cks VPWR VPWR sg13_lv_pmos ad=0.3808p pd=2.92u as=0.3808p ps=2.92u w=1.12u l=0.13u
X1343 VGND a_3407_4261# a_4244_3900# VGND sg13_lv_nmos ad=0.1406p pd=1.12u as=0.2516p ps=2.16u w=0.74u l=0.13u
X1344 a_2436_8861# a_2148_8440# a_2374_8861# VGND sg13_lv_nmos ad=0.1428p pd=1.52u as=37.8f ps=0.6u w=0.42u l=0.13u
X1345 VPWR sg13cmos5l_dfrbp_1_6.RESET_B a_14889_7281# VPWR sg13_lv_pmos ad=0.2128p pd=1.5u as=0.2128p ps=1.5u w=1.12u l=0.13u
X1346 sg13cmos5l_buf_1_4.X a_16552_1664# VGND VGND sg13_lv_nmos ad=0.2886p pd=2.26u as=0.14875p ps=1.16u w=0.74u l=0.13u
X1347 a_6213_3911# sg13cmos5l_dfrbp_1_11.Q VGND VGND sg13_lv_nmos ad=0.2516p pd=2.16u as=2.41737p ps=15.64u w=0.74u l=0.13u
X1348 a_2160_4972# a_1609_4704# VPWR VPWR sg13_lv_pmos ad=0.105p pd=1.21u as=1.28962p ps=8.195u w=1u l=0.13u
X1349 a_5637_2399# sg13cmos5l_dlhr_1_0.GATE VGND VGND sg13_lv_nmos ad=0.2516p pd=2.16u as=2.59257p ps=16.445u w=0.74u l=0.13u
X1350 VGND sg13cmos5l_dfrbp_1_6.RESET_B a_16068_6162# VGND sg13_lv_nmos ad=0.1626p pd=1.415u as=60.89999f ps=0.71u w=0.42u l=0.13u
X1351 sg13cmos5l_buf_1_111.A a_19240_7712# VPWR VPWR sg13_lv_pmos ad=0.42p pd=2.99u as=0.2114p ps=1.54u w=1.12u l=0.13u
X1352 VPWR cks sg13cmos5l_dfrbp_1_6.RESET_B VPWR sg13_lv_pmos ad=0.3808p pd=2.92u as=0.2184p ps=1.51u w=1.12u l=0.13u
X1353 sg13cmos5l_dlhr_1_0.GATE a_5684_4948# VGND VGND sg13_lv_nmos ad=0.2516p pd=2.16u as=0.1406p ps=1.12u w=0.74u l=0.13u
X1354 VGND sg13cmos5l_buf_1_68.X a_616_9224# VGND sg13_lv_nmos ad=0.14875p pd=1.16u as=0.187p ps=1.78u w=0.55u l=0.13u
X1355 a_14962_3138# sg13cmos5l_dfrbp_1_0.RESET_B VGND VGND sg13_lv_nmos ad=37.8f pd=0.6u as=79.8f ps=0.8u w=0.42u l=0.13u
X1356 sg13cmos5l_dlhr_1_5.D a_6959_6239# VPWR VPWR sg13_lv_pmos ad=0.4312p pd=3.01u as=0.2639p ps=1.81u w=1.12u l=0.13u
X1357 a_4847_4727# a_4005_4629# a_4753_4727# VGND sg13_lv_nmos ad=0.12665p pd=1.145u as=0.1428p ps=1.52u w=0.42u l=0.13u
X1358 a_15206_2826# a_16011_2399# a_15466_2356# VPWR sg13_lv_pmos ad=0.1428p pd=1.52u as=79.8f ps=0.8u w=0.42u l=0.13u
X1359 sg13cmos5l_o21ai_1_0.B1 sg13cmos5l_nand2_1_1.B VPWR VPWR sg13_lv_pmos ad=0.2128p pd=1.5u as=0.3808p ps=2.92u w=1.12u l=0.13u
X1360 a_19164_5814# a_18615_5770# a_19028_5412# VGND sg13_lv_nmos ad=47.25f pd=0.645u as=0.141p ps=1.17u w=0.42u l=0.13u
X1361 sg13cmos5l_or2_1_1.B sg13cmos5l_nor2_1_0.A VGND VGND sg13_lv_nmos ad=0.1406p pd=1.12u as=0.2516p ps=2.16u w=0.74u l=0.13u
X1362 VGND sg13cmos5l_buf_1_110.A a_15784_9224# VGND sg13_lv_nmos ad=0.14875p pd=1.16u as=0.187p ps=1.78u w=0.55u l=0.13u
X1363 VGND a_14900_2352# sg13cmos5l_nand2_1_0.A VGND sg13_lv_nmos ad=0.17255p pd=1.25u as=0.1406p ps=1.12u w=0.74u l=0.13u
X1364 VGND sg13cmos5l_buf_1_7.A a_14056_1664# VGND sg13_lv_nmos ad=0.14875p pd=1.16u as=0.187p ps=1.78u w=0.55u l=0.13u
X1365 VGND sg13cmos5l_buf_1_105.A a_18856_8436# VGND sg13_lv_nmos ad=0.14875p pd=1.16u as=0.187p ps=1.78u w=0.55u l=0.13u
X1366 VPWR sg13cmos5l_buf_1_77.X a_7336_9224# VPWR sg13_lv_pmos ad=0.2114p pd=1.54u as=0.2856p ps=2.36u w=0.84u l=0.13u
X1367 a_1846_7850# a_1948_7964# VGND VGND sg13_lv_nmos ad=0.187p pd=1.78u as=0.1491p ps=1.18u w=0.55u l=0.13u
X1368 a_3771_6553# a_2879_6432# a_3669_6320# VPWR sg13_lv_pmos ad=63f pd=0.72u as=79.8f ps=0.8u w=0.42u l=0.13u
X1369 VGND sg13cmos5l_dfrbp_1_8.RESET_B a_14436_8874# VGND sg13_lv_nmos ad=0.1626p pd=1.415u as=60.89999f ps=0.71u w=0.42u l=0.13u
X1370 sg13cmos5l_dlhr_1_18.Q_N a_11190_7354# VGND VGND sg13_lv_nmos ad=0.2516p pd=2.16u as=0.1491p ps=1.18u w=0.74u l=0.13u
X1371 a_4847_4727# a_4005_4629# a_3588_4968# VPWR sg13_lv_pmos ad=0.2048p pd=1.63u as=0.34p ps=2.68u w=1u l=0.13u
X1372 VGND a_6188_1590# sg13cmos5l_buf_1_25.X VGND sg13_lv_nmos ad=0.14875p pd=1.16u as=0.2886p ps=2.26u w=0.74u l=0.13u
X1373 VGND sg13cmos5l_dlhr_1_1.GATE a_4349_7636# VGND sg13_lv_nmos ad=0.15055p pd=1.17u as=0.2516p ps=2.16u w=0.74u l=0.13u
X1374 sg13cmos5l_dlhr_1_16.Q_N a_19734_5842# VGND VGND sg13_lv_nmos ad=0.2516p pd=2.16u as=0.1491p ps=1.18u w=0.74u l=0.13u
X1375 sg13cmos5l_dfrbp_1_21.Q a_18356_6460# VPWR VPWR sg13_lv_pmos ad=0.3808p pd=2.92u as=0.2128p ps=1.5u w=1.12u l=0.13u
X1376 VGND sg13cmos5l_dfrbp_1_6.RESET_B a_15412_5800# VGND sg13_lv_nmos ad=0.1406p pd=1.12u as=77.7f ps=0.95u w=0.74u l=0.13u
X1377 a_6647_5459# a_5951_5383# a_6741_5459# VGND sg13_lv_nmos ad=0.1296p pd=1.52u as=79.8f ps=0.8u w=0.42u l=0.13u
X1378 VGND a_7052_9150# sg13cmos5l_buf_1_76.X VGND sg13_lv_nmos ad=0.14875p pd=1.16u as=0.2886p ps=2.26u w=0.74u l=0.13u
X1379 VGND a_1878_6337# sg13cmos5l_dlhr_1_1.GATE VGND sg13_lv_nmos ad=0.1406p pd=1.12u as=0.2516p ps=2.16u w=0.74u l=0.13u
X1380 VPWR a_8439_6178# a_8570_6172# VPWR sg13_lv_pmos ad=1.07253p pd=6.75u as=0.2856p ps=2.36u w=0.84u l=0.13u
X1381 a_9823_2780# sg13cmos5l_a22oi_1_2.B1 VGND VGND sg13_lv_nmos ad=0.13875p pd=1.115u as=0.2553p ps=2.17u w=0.74u l=0.13u
X1382 a_14295_7282# sg13cmos5l_dfrbp_1_23.CLK VGND VGND sg13_lv_nmos ad=0.2516p pd=2.16u as=0.15055p ps=1.17u w=0.74u l=0.13u
X1383 a_6741_5459# a_5799_5499# a_6647_5459# VPWR sg13_lv_pmos ad=79.8f pd=0.8u as=0.1428p ps=1.52u w=0.42u l=0.13u
X1384 a_4276_2776# a_3860_2388# a_4041_2745# VGND sg13_lv_nmos ad=77.7f pd=0.95u as=0.2516p ps=2.16u w=0.74u l=0.13u
X1385 VPWR a_18345_7674# a_18870_7656# VPWR sg13_lv_pmos ad=0.1974p pd=1.5u as=0.2856p ps=2.36u w=0.84u l=0.13u
X1386 VGND a_18117_3117# a_18219_3260# VGND sg13_lv_nmos ad=2.59257p pd=16.445u as=0.2516p ps=2.16u w=0.74u l=0.13u
X1387 VGND sg13cmos5l_buf_1_8.A a_10888_1664# VGND sg13_lv_nmos ad=0.14875p pd=1.16u as=0.187p ps=1.78u w=0.55u l=0.13u
X1388 sg13cmos5l_buf_8_0.A a_18480_5028# VPWR VPWR sg13_lv_pmos ad=0.3976p pd=2.95u as=0.2226p ps=1.535u w=1.12u l=0.13u
X1389 a_7941_7653# sg13cmos5l_dfrbp_1_18.Q VGND VGND sg13_lv_nmos ad=0.2516p pd=2.16u as=1.49685p ps=9.6u w=0.74u l=0.13u
X1390 a_8746_8404# a_9189_8447# a_9129_8483# VPWR sg13_lv_pmos ad=79.8f pd=0.8u as=63f ps=0.72u w=0.42u l=0.13u
X1391 sg13cmos5l_dfrbp_1_16.Q_N a_1967_7285# VGND VGND sg13_lv_nmos ad=0.2849p pd=2.25u as=0.2516p ps=2.16u w=0.74u l=0.13u
X1392 sg13cmos5l_dlhr_1_5.Q a_8457_7281# VPWR VPWR sg13_lv_pmos ad=0.3808p pd=2.92u as=0.2128p ps=1.5u w=1.12u l=0.13u
X1393 sg13cmos5l_buf_1_8.A sg13cmos5l_inv_1_7.A VPWR VPWR sg13_lv_pmos ad=0.3808p pd=2.92u as=0.3808p ps=2.92u w=1.12u l=0.13u
X1394 a_8774_5412# a_8378_5776# a_8660_5412# VPWR sg13_lv_pmos ad=0.1008p pd=0.9u as=0.191p ps=1.44u w=0.42u l=0.13u
X1395 sg13cmos5l_buf_1_89.A a_14889_7281# VGND VGND sg13_lv_nmos ad=0.2516p pd=2.16u as=0.1406p ps=1.12u w=0.74u l=0.13u
X1396 VGND a_19593_6162# a_20118_6144# VGND sg13_lv_nmos ad=0.1491p pd=1.18u as=0.187p ps=1.78u w=0.55u l=0.13u
X1397 VGND sg13cmos5l_dfrbp_1_6.RESET_B a_5508_6162# VGND sg13_lv_nmos ad=0.1626p pd=1.415u as=60.89999f ps=0.71u w=0.42u l=0.13u
X1398 VGND a_11877_2399# a_11979_2399# VGND sg13_lv_nmos ad=2.59257p pd=16.445u as=0.2516p ps=2.16u w=0.74u l=0.13u
X1399 a_3599_3215# a_2757_3117# a_3505_3215# VGND sg13_lv_nmos ad=0.12665p pd=1.145u as=0.1428p ps=1.52u w=0.42u l=0.13u
X1400 a_18164_7996# a_17882_7684# a_18097_7666# VGND sg13_lv_nmos ad=0.141p pd=1.17u as=71.99999f ps=0.865u w=0.64u l=0.13u
X1401 VPWR VGND VPWR VPWR sg13_lv_pmos ad=0.34p pd=2.68u as=0 ps=0 w=1u l=1u
X1402 a_10116_7674# sg13cmos5l_buf_1_57.X a_10022_7674# VGND sg13_lv_nmos ad=60.89999f pd=0.71u as=0.1428p ps=1.52u w=0.42u l=0.13u
X1403 VPWR a_17135_4727# a_17972_4948# VPWR sg13_lv_pmos ad=0.2128p pd=1.5u as=0.3864p ps=2.93u w=1.12u l=0.13u
X1404 VPWR cks sg13cmos5l_dfrbp_1_6.RESET_B VPWR sg13_lv_pmos ad=0.2128p pd=1.5u as=0.2128p ps=1.5u w=1.12u l=0.13u
X1405 VPWR a_3407_4261# a_3664_4142# VPWR sg13_lv_pmos ad=0.2639p pd=1.81u as=79.8f ps=0.8u w=0.42u l=0.13u
X1406 a_3562_4873# a_4005_4629# a_3945_5041# VPWR sg13_lv_pmos ad=79.8f pd=0.8u as=63f ps=0.72u w=0.42u l=0.13u
X1407 a_4514_7666# a_4324_7996# a_4076_7624# VGND sg13_lv_nmos ad=71.99999f pd=0.865u as=0.141p ps=1.17u w=0.64u l=0.13u
X1408 sg13cmos5l_dfrbp_1_8.Q_N a_17135_4727# VGND VGND sg13_lv_nmos ad=0.2849p pd=2.25u as=0.2516p ps=2.16u w=0.74u l=0.13u
X1409 VGND sg13cmos5l_inv_1_1.A sg13cmos5l_buf_1_2.A VGND sg13_lv_nmos ad=0.2516p pd=2.16u as=0.2516p ps=2.16u w=0.74u l=0.13u
X1410 VPWR sg13cmos5l_dlhr_1_1.D a_1609_4704# VPWR sg13_lv_pmos ad=1.28962p pd=8.195u as=0.2856p ps=2.36u w=0.84u l=0.13u
X1411 VPWR sg13cmos5l_dfrbp_1_6.RESET_B a_15177_5769# VPWR sg13_lv_pmos ad=0.2128p pd=1.5u as=0.2128p ps=1.5u w=1.12u l=0.13u
X1412 a_17584_7166# a_17327_7285# a_17746_7362# VGND sg13_lv_nmos ad=0.1428p pd=1.52u as=37.8f ps=0.6u w=0.42u l=0.13u
X1413 VGND a_1463_8741# a_1463_8741# VGND sg13_lv_nmos ad=2.92392p pd=18.89u as=0.111p ps=1.34u w=0.3u l=0.13u
X1414 sg13cmos5l_buf_1_30.X a_8680_1664# VGND VGND sg13_lv_nmos ad=0.2886p pd=2.26u as=0.14875p ps=1.16u w=0.74u l=0.13u
X1415 a_13484_8400# sg13cmos5l_dlhr_1_11.Q VPWR VPWR sg13_lv_pmos ad=0.2856p pd=2.36u as=0.2114p ps=1.54u w=0.84u l=0.13u
X1416 VPWR a_5104_4870# a_5049_4965# VPWR sg13_lv_pmos ad=1.28962p pd=8.195u as=93.45f ps=0.865u w=0.42u l=0.13u
X1417 a_7498_7897# a_7941_7653# a_7881_8065# VPWR sg13_lv_pmos ad=79.8f pd=0.8u as=63f ps=0.72u w=0.42u l=0.13u
X1418 a_908_1590# sg13cmos5l_buf_1_32.A VPWR VPWR sg13_lv_pmos ad=0.2856p pd=2.36u as=0.2114p ps=1.54u w=0.84u l=0.13u
X1419 a_11054_4292# sg13cmos5l_nand2_1_0.A sg13cmos5l_a22oi_1_0.Y VGND sg13_lv_nmos ad=96.2f pd=1u as=0.2664p ps=1.46u w=0.74u l=0.13u
X1420 VGND a_4172_1590# sg13cmos5l_buf_1_33.A VGND sg13_lv_nmos ad=0.14875p pd=1.16u as=0.2886p ps=2.26u w=0.74u l=0.13u
X1421 a_1846_7850# a_1948_7964# VPWR VPWR sg13_lv_pmos ad=0.2856p pd=2.36u as=0.1974p ps=1.5u w=0.84u l=0.13u
X1422 VPWR sg13cmos5l_dfrbp_1_6.RESET_B a_10282_7897# VPWR sg13_lv_pmos ad=0.1563p pd=1.22u as=0.147p ps=1.54u w=0.42u l=0.13u
X1423 VPWR a_16572_4261# a_17595_3947# VPWR sg13_lv_pmos ad=0.1563p pd=1.22u as=63f ps=0.72u w=0.42u l=0.13u
X1424 VGND sg13cmos5l_nand2_1_2.B a_1210_4654# VGND sg13_lv_nmos ad=0.2516p pd=2.16u as=0.1406p ps=1.12u w=0.74u l=0.13u
X1425 VGND a_13100_8400# pl_sw[6] VGND sg13_lv_nmos ad=0.14875p pd=1.16u as=0.2886p ps=2.26u w=0.74u l=0.13u
X1426 sg13cmos5l_buf_1_6.A a_12520_3176# VPWR VPWR sg13_lv_pmos ad=0.42p pd=2.99u as=0.2114p ps=1.54u w=1.12u l=0.13u
X1427 ph_sw[0] a_616_9224# VPWR VPWR sg13_lv_pmos ad=0.42p pd=2.99u as=0.2114p ps=1.54u w=1.12u l=0.13u
X1428 sg13cmos5l_buf_1_3.X a_20296_1664# VGND VGND sg13_lv_nmos ad=0.2886p pd=2.26u as=0.14875p ps=1.16u w=0.74u l=0.13u
X1429 nl_sw[6] a_11656_3176# VGND VGND sg13_lv_nmos ad=0.2886p pd=2.26u as=0.14875p ps=1.16u w=0.74u l=0.13u
X1430 a_11782_1639# sg13cmos5l_dfrbp_1_0.RESET_B VGND VGND sg13_lv_nmos ad=37.8f pd=0.6u as=0.1701p ps=1.65u w=0.42u l=0.13u
X1431 sg13cmos5l_and3_1_0.X a_13324_4696# VGND VGND sg13_lv_nmos ad=0.2516p pd=2.16u as=0.1371p ps=1.12u w=0.74u l=0.13u
X1432 VGND a_18999_6178# a_19130_6172# VGND sg13_lv_nmos ad=1.97045p pd=12.335u as=0.2775p ps=2.23u w=0.74u l=0.13u
X1433 VGND sg13cmos5l_dfrbp_1_8.RESET_B a_8580_8874# VGND sg13_lv_nmos ad=0.1626p pd=1.415u as=60.89999f ps=0.71u w=0.42u l=0.13u
X1434 VPWR sg13cmos5l_buf_1_44.X sg13cmos5l_buf_1_38.A VPWR sg13_lv_pmos ad=0.3808p pd=2.92u as=0.3808p ps=2.92u w=1.12u l=0.13u
X1435 VPWR a_3308_9150# sg13cmos5l_inv_1_8.A VPWR sg13_lv_pmos ad=0.2114p pd=1.54u as=0.42p ps=2.99u w=1.12u l=0.13u
X1436 VPWR a_20492_8400# pl_sw[10] VPWR sg13_lv_pmos ad=0.2114p pd=1.54u as=0.42p ps=2.99u w=1.12u l=0.13u
X1437 sg13cmos5l_buf_1_103.A a_15784_9224# VPWR VPWR sg13_lv_pmos ad=0.42p pd=2.99u as=0.2114p ps=1.54u w=1.12u l=0.13u
X1438 sg13cmos5l_dlhr_1_6.D a_7796_6460# VPWR VPWR sg13_lv_pmos ad=0.3808p pd=2.92u as=0.2128p ps=1.5u w=1.12u l=0.13u
X1439 VPWR a_18117_3117# a_18219_3260# VPWR sg13_lv_pmos ad=1.43437p pd=9.105u as=0.3864p ps=2.93u w=1.12u l=0.13u
X1440 a_13593_9501# a_12651_9308# a_13391_9263# VPWR sg13_lv_pmos ad=93.45f pd=0.865u as=0.2048p ps=1.63u w=0.42u l=0.13u
X1441 a_7524_7992# a_8043_7796# a_8783_7751# VGND sg13_lv_nmos ad=0.3473p pd=2.71u as=0.12665p ps=1.145u w=0.74u l=0.13u
X1442 VGND sg13cmos5l_dfrbp_1_6.RESET_B a_7924_1612# VGND sg13_lv_nmos ad=0.1406p pd=1.12u as=77.7f ps=0.95u w=0.74u l=0.13u
X1443 a_5988_8440# a_5962_8404# VPWR VPWR sg13_lv_pmos ad=0.34p pd=2.68u as=0.36237p ps=2.605u w=1u l=0.13u
X1444 sg13cmos5l_buf_1_86.A a_20008_8436# VPWR VPWR sg13_lv_pmos ad=0.42p pd=2.99u as=0.2114p ps=1.54u w=1.12u l=0.13u
X1445 a_7941_7653# sg13cmos5l_dfrbp_1_18.Q VPWR VPWR sg13_lv_pmos ad=0.4088p pd=2.97u as=1.15047p ps=7.175u w=1.12u l=0.13u
X1446 VPWR sg13cmos5l_buf_1_89.A a_15208_6200# VPWR sg13_lv_pmos ad=0.2114p pd=1.54u as=0.2856p ps=2.36u w=0.84u l=0.13u
X1447 sg13cmos5l_dlhr_1_14.Q_N a_14166_7656# VPWR VPWR sg13_lv_pmos ad=0.3808p pd=2.92u as=0.1974p ps=1.5u w=1.12u l=0.13u
X1448 VGND VPWR VGND VGND sg13_lv_nmos ad=0.1428p pd=1.52u as=0 ps=0 w=0.42u l=1u
X1449 a_11556_3904# a_11530_3868# VGND VGND sg13_lv_nmos ad=0.2516p pd=2.16u as=0.1626p ps=1.415u w=0.74u l=0.13u
X1450 VGND a_8457_7281# a_8982_7354# VGND sg13_lv_nmos ad=0.1491p pd=1.18u as=0.187p ps=1.78u w=0.55u l=0.13u
X1451 a_5266_4650# sg13cmos5l_dfrbp_1_8.RESET_B VGND VGND sg13_lv_nmos ad=37.8f pd=0.6u as=79.8f ps=0.8u w=0.42u l=0.13u
X1452 sg13cmos5l_inv_1_3.A a_13768_8436# VPWR VPWR sg13_lv_pmos ad=0.42p pd=2.99u as=0.2114p ps=1.54u w=1.12u l=0.13u
X1453 sg13cmos5l_buf_1_19.X a_18760_2388# VPWR VPWR sg13_lv_pmos ad=0.42p pd=2.99u as=0.2114p ps=1.54u w=1.12u l=0.13u
X1454 sg13cmos5l_a22oi_1_1.B2 sg13cmos5l_and3_1_0.X a_13698_5412# VPWR sg13_lv_pmos ad=0.3808p pd=2.92u as=0.2128p ps=1.5u w=1.12u l=0.13u
X1455 a_7441_1618# a_6889_1680# VGND VGND sg13_lv_nmos ad=71.99999f pd=0.865u as=7.01497p ps=46.005u w=0.64u l=0.13u
X1456 sg13cmos5l_buf_1_65.X a_424_8436# VGND VGND sg13_lv_nmos ad=0.2886p pd=2.26u as=0.14875p ps=1.16u w=0.74u l=0.13u
X1457 VGND a_1846_7850# sg13cmos5l_dlhr_1_8.Q_N VGND sg13_lv_nmos ad=0.1491p pd=1.18u as=0.2516p ps=2.16u w=0.74u l=0.13u
X1458 VGND VPWR VGND VGND sg13_lv_nmos ad=0.1428p pd=1.52u as=0 ps=0 w=0.42u l=1u
X1459 VGND a_17776_6382# a_17425_6239# VGND sg13_lv_nmos ad=79.8f pd=0.8u as=0.1428p ps=1.52u w=0.42u l=0.13u
X1460 a_4425_7281# a_4244_6924# VPWR VPWR sg13_lv_pmos ad=0.2128p pd=1.5u as=0.2387p ps=1.84u w=1.12u l=0.13u
X1461 a_9164_1590# sg13cmos5l_buf_1_26.A VPWR VPWR sg13_lv_pmos ad=0.2856p pd=2.36u as=0.2114p ps=1.54u w=0.84u l=0.13u
X1462 a_9823_2364# sg13cmos5l_a22oi_1_2.B2 sg13cmos5l_dfrbp_1_1.D VPWR sg13_lv_pmos ad=0.2744p pd=1.61u as=0.2128p ps=1.5u w=1.12u l=0.13u
X1463 a_11973_3911# sg13cmos5l_dfrbp_1_0.CLK VPWR VPWR sg13_lv_pmos ad=0.4088p pd=2.97u as=1.38655p ps=8.8u w=1.12u l=0.13u
X1464 a_15012_7992# a_14986_7897# VPWR VPWR sg13_lv_pmos ad=0.34p pd=2.68u as=0.36237p ps=2.605u w=1u l=0.13u
X1465 VGND a_3831_7282# a_3962_7288# VGND sg13_lv_nmos ad=1.49685p pd=9.6u as=0.2775p ps=2.23u w=0.74u l=0.13u
X1466 VPWR sg13cmos5l_dlhr_1_2.D a_6697_3192# VPWR sg13_lv_pmos ad=1.43437p pd=9.105u as=0.2856p ps=2.36u w=0.84u l=0.13u
X1467 a_10331_1924# sg13cmos5l_nor2b_1_0.Y VPWR VPWR sg13_lv_pmos ad=0.3808p pd=2.92u as=0.2128p ps=1.5u w=1.12u l=0.13u
X1468 VGND a_5132_3864# sg13cmos5l_buf_1_44.X VGND sg13_lv_nmos ad=0.14875p pd=1.16u as=0.2886p ps=2.26u w=0.74u l=0.13u
X1469 a_3308_9150# sg13cmos5l_buf_1_65.X VPWR VPWR sg13_lv_pmos ad=0.2856p pd=2.36u as=0.2114p ps=1.54u w=0.84u l=0.13u
X1470 a_10233_8559# a_9291_8447# a_10031_8797# VPWR sg13_lv_pmos ad=93.45f pd=0.865u as=0.2048p ps=1.63u w=0.42u l=0.13u
X1471 sg13cmos5l_dfrbp_1_16.Q a_2804_6924# VGND VGND sg13_lv_nmos ad=0.2516p pd=2.16u as=0.1406p ps=1.12u w=0.74u l=0.13u
X1472 VGND a_8439_6178# a_8570_6172# VGND sg13_lv_nmos ad=1.97045p pd=12.335u as=0.2775p ps=2.23u w=0.74u l=0.13u
X1473 sg13cmos5l_dfrbp_1_25.Q_N a_15887_8797# VGND VGND sg13_lv_nmos ad=0.2849p pd=2.25u as=0.2516p ps=2.16u w=0.74u l=0.13u
X1474 a_708_5416# a_682_5380# VPWR VPWR sg13_lv_pmos ad=0.34p pd=2.68u as=0.36237p ps=2.605u w=1u l=0.13u
X1475 a_7812_7687# a_8043_7796# a_7498_7897# VGND sg13_lv_nmos ad=0.2373p pd=1.97u as=79.8f ps=0.8u w=0.42u l=0.13u
X1476 a_6736_2630# sg13cmos5l_dfrbp_1_6.RESET_B VPWR VPWR sg13_lv_pmos ad=79.8f pd=0.8u as=1.86162p ps=11.935u w=0.42u l=0.13u
X1477 ph_sw[10] a_20392_6924# VPWR VPWR sg13_lv_pmos ad=0.42p pd=2.99u as=0.2114p ps=1.54u w=1.12u l=0.13u
X1478 a_5194_2356# a_5637_2399# a_4934_2826# VGND sg13_lv_nmos ad=79.8f pd=0.8u as=0.1296p ps=1.52u w=0.42u l=0.13u
X1479 VGND sg13cmos5l_buf_1_44.X sg13cmos5l_buf_1_38.A VGND sg13_lv_nmos ad=0.2516p pd=2.16u as=0.2516p ps=2.16u w=0.74u l=0.13u
X1480 a_16164_4663# a_15876_4968# a_16102_4663# VGND sg13_lv_nmos ad=0.1428p pd=1.52u as=37.8f ps=0.6u w=0.42u l=0.13u
X1481 VGND a_16940_3102# nh_sw[8] VGND sg13_lv_nmos ad=0.14875p pd=1.16u as=0.2886p ps=2.26u w=0.74u l=0.13u
X1482 VPWR sg13cmos5l_buf_1_64.A a_3976_9224# VPWR sg13_lv_pmos ad=0.2114p pd=1.54u as=0.2856p ps=2.36u w=0.84u l=0.13u
X1483 a_15369_8065# a_15012_7992# VPWR VPWR sg13_lv_pmos ad=63f pd=0.72u as=0.1563p ps=1.22u w=0.42u l=0.13u
X1484 VPWR sg13cmos5l_dfrbp_1_6.RESET_B a_682_5380# VPWR sg13_lv_pmos ad=0.1563p pd=1.22u as=0.147p ps=1.54u w=0.42u l=0.13u
X1485 VGND a_12933_6141# a_13035_6284# VGND sg13_lv_nmos ad=1.97045p pd=12.335u as=0.2516p ps=2.16u w=0.74u l=0.13u
X1486 VGND a_14543_3215# a_15380_3436# VGND sg13_lv_nmos ad=0.1406p pd=1.12u as=0.2516p ps=2.16u w=0.74u l=0.13u
X1487 VPWR a_1125_6935# a_1227_6935# VPWR sg13_lv_pmos ad=1.07253p pd=6.75u as=0.3864p ps=2.93u w=1.12u l=0.13u
X1488 sg13cmos5l_buf_1_31.X a_424_1664# VPWR VPWR sg13_lv_pmos ad=0.42p pd=2.99u as=0.2114p ps=1.54u w=1.12u l=0.13u
X1489 a_13047_7690# sg13cmos5l_dlhr_1_11.GATE VPWR VPWR sg13_lv_pmos ad=0.3234p pd=2.45u as=1.12242p ps=7u w=0.84u l=0.13u
X1490 a_18096_7996# a_17545_7728# VPWR VPWR sg13_lv_pmos ad=0.105p pd=1.21u as=1.15047p ps=7.175u w=1u l=0.13u
X1491 sg13cmos5l_dfrbp_1_8.D a_18164_6924# VGND VGND sg13_lv_nmos ad=0.2516p pd=2.16u as=0.1406p ps=1.12u w=0.74u l=0.13u
X1492 VPWR a_20204_5376# sg13cmos5l_inv_1_6.A VPWR sg13_lv_pmos ad=0.2114p pd=1.54u as=0.42p ps=2.99u w=1.12u l=0.13u
X1493 a_2638_6477# a_2380_6162# VPWR VPWR sg13_lv_pmos ad=93.45f pd=0.865u as=1.07253p ps=6.75u w=0.42u l=0.13u
X1494 VGND sg13cmos5l_buf_1_104.A a_19624_8436# VGND sg13_lv_nmos ad=0.14875p pd=1.16u as=0.187p ps=1.78u w=0.55u l=0.13u
X1495 VPWR a_20012_2352# nl_sw[10] VPWR sg13_lv_pmos ad=0.2114p pd=1.54u as=0.42p ps=2.99u w=1.12u l=0.13u
X1496 a_2148_3904# a_2122_3868# VGND VGND sg13_lv_nmos ad=0.2516p pd=2.16u as=0.1626p ps=1.415u w=0.74u l=0.13u
X1497 a_3588_4968# a_3562_4873# VGND VGND sg13_lv_nmos ad=0.2516p pd=2.16u as=0.1626p ps=1.415u w=0.74u l=0.13u
X1498 VGND a_2565_3911# a_2667_3911# VGND sg13_lv_nmos ad=2.41737p pd=15.64u as=0.2516p ps=2.16u w=0.74u l=0.13u
X1499 a_14476_2388# a_14254_2444# VPWR VPWR sg13_lv_pmos ad=0.1176p pd=1.33u as=0.2618p ps=1.63u w=1.12u l=0.13u
X1500 VGND sg13cmos5l_buf_1_116.A a_15592_6200# VGND sg13_lv_nmos ad=0.14875p pd=1.16u as=0.187p ps=1.78u w=0.55u l=0.13u
X1501 a_10282_7897# a_10725_7653# a_10022_7674# VGND sg13_lv_nmos ad=79.8f pd=0.8u as=0.1296p ps=1.52u w=0.42u l=0.13u
X1502 VGND a_16748_9150# pl_sw[7] VGND sg13_lv_nmos ad=0.14875p pd=1.16u as=0.2886p ps=2.26u w=0.74u l=0.13u
X1503 a_516_7362# sg13cmos5l_dfrbp_1_6.D a_422_7362# VGND sg13_lv_nmos ad=60.89999f pd=0.71u as=0.1428p ps=1.52u w=0.42u l=0.13u
X1504 sg13cmos5l_dfrbp_1_4.Q_N a_12719_2749# VGND VGND sg13_lv_nmos ad=0.2849p pd=2.25u as=0.2516p ps=2.16u w=0.74u l=0.13u
X1505 a_1580_2352# sg13cmos5l_buf_1_40.X VGND VGND sg13_lv_nmos ad=0.187p pd=1.78u as=0.14875p ps=1.16u w=0.55u l=0.13u
X1506 sg13cmos5l_buf_1_56.A a_9033_6162# VGND VGND sg13_lv_nmos ad=0.2516p pd=2.16u as=0.1406p ps=1.12u w=0.74u l=0.13u
X1507 VGND sg13cmos5l_dfrbp_1_23.Q a_14089_7282# VGND sg13_lv_nmos ad=0.15055p pd=1.17u as=0.187p ps=1.78u w=0.55u l=0.13u
X1508 a_2342_5088# a_1946_4660# a_2228_4972# VPWR sg13_lv_pmos ad=0.1008p pd=0.9u as=0.191p ps=1.44u w=0.42u l=0.13u
X1509 VPWR a_11072_5347# sg13cmos5l_a221oi_1_1.C1 VPWR sg13_lv_pmos ad=0.36195p pd=1.84u as=0.3808p ps=2.92u w=1.12u l=0.13u
X1510 a_8588_2352# sg13cmos5l_buf_1_26.X VPWR VPWR sg13_lv_pmos ad=0.2856p pd=2.36u as=0.2114p ps=1.54u w=0.84u l=0.13u
X1511 sg13cmos5l_nand2_1_1.B a_15357_1816# VPWR VPWR sg13_lv_pmos ad=0.2128p pd=1.5u as=0.3808p ps=2.92u w=1.12u l=0.13u
X1512 a_5674_6385# a_6117_6141# a_5414_6162# VGND sg13_lv_nmos ad=79.8f pd=0.8u as=0.1296p ps=1.52u w=0.42u l=0.13u
X1513 VPWR VGND VPWR VPWR sg13_lv_pmos ad=0.19p pd=1.38u as=0 ps=0 w=1u l=1u
X1514 a_17392_4870# sg13cmos5l_dfrbp_1_8.RESET_B VPWR VPWR sg13_lv_pmos ad=79.8f pd=0.8u as=1.2517p ps=7.955u w=0.42u l=0.13u
X1515 VGND a_8204_2352# sg13cmos5l_buf_1_24.A VGND sg13_lv_nmos ad=0.14875p pd=1.16u as=0.2886p ps=2.26u w=0.74u l=0.13u
X1516 VGND sg13cmos5l_buf_1_74.X a_6568_9224# VGND sg13_lv_nmos ad=0.14875p pd=1.16u as=0.187p ps=1.78u w=0.55u l=0.13u
X1517 a_5628_3174# a_5079_3154# a_5492_3460# VGND sg13_lv_nmos ad=47.25f pd=0.645u as=0.141p ps=1.17u w=0.42u l=0.13u
X1518 VPWR sg13cmos5l_a22oi_1_0.Y sg13cmos5l_dfrbp_1_2.D VPWR sg13_lv_pmos ad=0.3808p pd=2.92u as=0.3808p ps=2.92u w=1.12u l=0.13u
X1519 sg13cmos5l_or2_1_0.A a_18363_4270# VGND VGND sg13_lv_nmos ad=0.1406p pd=1.12u as=0.1406p ps=1.12u w=0.74u l=0.13u
X1520 a_15850_4873# a_16293_4629# a_16233_5041# VPWR sg13_lv_pmos ad=79.8f pd=0.8u as=63f ps=0.72u w=0.42u l=0.13u
X1521 sg13cmos5l_buf_1_57.X a_9448_6924# VPWR VPWR sg13_lv_pmos ad=0.42p pd=2.99u as=0.2114p ps=1.54u w=1.12u l=0.13u
X1522 sg13cmos5l_buf_1_78.X a_6184_9224# VGND VGND sg13_lv_nmos ad=0.2886p pd=2.26u as=0.14875p ps=1.16u w=0.74u l=0.13u
X1523 sg13cmos5l_nor2_1_1.A a_17588_2388# VGND VGND sg13_lv_nmos ad=0.2516p pd=2.16u as=0.1406p ps=1.12u w=0.74u l=0.13u
X1524 a_11270_1626# a_12075_1748# a_11530_1849# VPWR sg13_lv_pmos ad=0.1428p pd=1.52u as=79.8f ps=0.8u w=0.42u l=0.13u
X1525 VPWR sg13cmos5l_dfrbp_1_6.RESET_B a_10022_7674# VPWR sg13_lv_pmos ad=0.36237p pd=2.605u as=79.8f ps=0.8u w=0.42u l=0.13u
X1526 VPWR a_5637_2399# a_5739_2399# VPWR sg13_lv_pmos ad=1.86162p pd=11.935u as=0.3864p ps=2.93u w=1.12u l=0.13u
X1527 a_11460_2392# a_11979_2399# a_12719_2749# VGND sg13_lv_nmos ad=0.3473p pd=2.71u as=0.12665p ps=1.145u w=0.74u l=0.13u
X1528 nh_sw[10] a_20392_3176# VPWR VPWR sg13_lv_pmos ad=0.42p pd=2.99u as=0.2114p ps=1.54u w=1.12u l=0.13u
X1529 a_16940_3102# sg13cmos5l_buf_1_4.X VPWR VPWR sg13_lv_pmos ad=0.2856p pd=2.36u as=0.2114p ps=1.54u w=0.84u l=0.13u
X1530 a_10094_2780# sg13cmos5l_inv_1_11.Y sg13cmos5l_dfrbp_1_1.D VGND sg13_lv_nmos ad=96.2f pd=1u as=0.2664p ps=1.46u w=0.74u l=0.13u
X1531 VPWR sg13cmos5l_nor2b_1_0.Y a_10783_3876# VPWR sg13_lv_pmos ad=0.3808p pd=2.92u as=0.2744p ps=1.61u w=1.12u l=0.13u
X1532 a_11394_4948# sg13cmos5l_a221oi_1_0.B2 a_11182_4948# VPWR sg13_lv_pmos ad=0.2128p pd=1.5u as=0.2128p ps=1.5u w=1.12u l=0.13u
X1533 a_16751_2749# a_15909_2399# a_16657_2749# VGND sg13_lv_nmos ad=0.12665p pd=1.145u as=0.1428p ps=1.52u w=0.42u l=0.13u
X1534 a_620_2352# sg13cmos5l_buf_1_32.X VGND VGND sg13_lv_nmos ad=0.187p pd=1.78u as=0.14875p ps=1.16u w=0.55u l=0.13u
X1535 a_16144_8678# a_15887_8797# a_16306_8874# VGND sg13_lv_nmos ad=0.1428p pd=1.52u as=37.8f ps=0.6u w=0.42u l=0.13u
X1536 VGND sg13cmos5l_buf_8_1.A a_18363_4270# VGND sg13_lv_nmos ad=0.1406p pd=1.12u as=0.1406p ps=1.12u w=0.74u l=0.13u
X1537 sg13cmos5l_dfrbp_1_27.Q_N a_10031_8797# VPWR VPWR sg13_lv_pmos ad=0.4312p pd=3.01u as=0.2639p ps=1.81u w=1.12u l=0.13u
X1538 a_3396_4650# sg13cmos5l_dfrbp_1_9.Q a_3302_4650# VGND sg13_lv_nmos ad=60.89999f pd=0.71u as=0.1428p ps=1.52u w=0.42u l=0.13u
X1539 VGND sg13cmos5l_buf_1_10.A sg13cmos5l_inv_1_28.Y VGND sg13_lv_nmos ad=0.2516p pd=2.16u as=0.2516p ps=2.16u w=0.74u l=0.13u
X1540 sg13cmos5l_dlhr_1_11.Q a_13161_7281# VPWR VPWR sg13_lv_pmos ad=0.3808p pd=2.92u as=0.2128p ps=1.5u w=1.12u l=0.13u
X1541 VGND a_1196_8400# sg13cmos5l_buf_1_63.X VGND sg13_lv_nmos ad=0.14875p pd=1.16u as=0.2886p ps=2.26u w=0.74u l=0.13u
X1542 a_2224_5654# sg13cmos5l_dfrbp_1_6.RESET_B VPWR VPWR sg13_lv_pmos ad=79.8f pd=0.8u as=1.28962p ps=8.195u w=0.42u l=0.13u
X1543 sg13cmos5l_nand2_1_2.B sg13cmos5l_nor2_1_2.A VGND VGND sg13_lv_nmos ad=0.1406p pd=1.12u as=0.2516p ps=2.16u w=0.74u l=0.13u
X1544 VPWR sg13cmos5l_inv_1_0.Y a_11182_4948# VPWR sg13_lv_pmos ad=0.3808p pd=2.92u as=0.2128p ps=1.5u w=1.12u l=0.13u
X1545 a_10406_9624# a_10010_9196# a_10292_9508# VPWR sg13_lv_pmos ad=0.1008p pd=0.9u as=0.191p ps=1.44u w=0.42u l=0.13u
X1546 sg13cmos5l_dfrbp_1_22.D a_16724_8436# VGND VGND sg13_lv_nmos ad=0.2516p pd=2.16u as=0.1406p ps=1.12u w=0.74u l=0.13u
X1547 sg13cmos5l_dlhr_1_12.D a_16271_7751# VGND VGND sg13_lv_nmos ad=0.2849p pd=2.25u as=0.2516p ps=2.16u w=0.74u l=0.13u
X1548 a_2314_3361# a_2757_3117# a_2054_3138# VGND sg13_lv_nmos ad=79.8f pd=0.8u as=0.1296p ps=1.52u w=0.42u l=0.13u
X1549 VPWR sg13cmos5l_dfrbp_1_8.RESET_B a_3562_4873# VPWR sg13_lv_pmos ad=0.1563p pd=1.22u as=0.147p ps=1.54u w=0.42u l=0.13u
X1550 VPWR a_15045_8447# a_15147_8447# VPWR sg13_lv_pmos ad=1.15047p pd=7.175u as=0.3864p ps=2.93u w=1.12u l=0.13u
X1551 VPWR a_4005_4629# a_4107_4772# VPWR sg13_lv_pmos ad=1.28962p pd=8.195u as=0.3864p ps=2.93u w=1.12u l=0.13u
X1552 a_16356_7349# a_16068_6928# a_16294_7349# VGND sg13_lv_nmos ad=0.1428p pd=1.52u as=37.8f ps=0.6u w=0.42u l=0.13u
X1553 sg13cmos5l_dfrbp_1_23.Q_N a_13775_6239# VPWR VPWR sg13_lv_pmos ad=0.4312p pd=3.01u as=0.2639p ps=1.81u w=1.12u l=0.13u
X1554 a_12933_6141# sg13cmos5l_dfrbp_1_23.CLK VPWR VPWR sg13_lv_pmos ad=0.4088p pd=2.97u as=1.04815p ps=6.595u w=1.12u l=0.13u
X1555 a_7216_6382# a_6959_6239# a_7378_6162# VGND sg13_lv_nmos ad=0.1428p pd=1.52u as=37.8f ps=0.6u w=0.42u l=0.13u
X1556 VPWR a_2748_6126# a_3771_6553# VPWR sg13_lv_pmos ad=0.1563p pd=1.22u as=63f ps=0.72u w=0.42u l=0.13u
X1557 a_5796_3904# a_5770_3868# VGND VGND sg13_lv_nmos ad=0.2516p pd=2.16u as=0.1626p ps=1.415u w=0.74u l=0.13u
X1558 a_5926_6175# sg13cmos5l_dfrbp_1_6.RESET_B VGND VGND sg13_lv_nmos ad=37.8f pd=0.6u as=0.1701p ps=1.65u w=0.42u l=0.13u
X1559 a_5220_2392# a_5194_2356# VGND VGND sg13_lv_nmos ad=0.2516p pd=2.16u as=0.1626p ps=1.415u w=0.74u l=0.13u
X1560 a_13072_4142# sg13cmos5l_dfrbp_1_0.RESET_B VPWR VPWR sg13_lv_pmos ad=79.8f pd=0.8u as=1.38655p ps=8.8u w=0.42u l=0.13u
X1561 a_12216_5728# sg13cmos5l_dfrbp_1_21.Q VGND VGND sg13_lv_nmos ad=0.1045p pd=0.93u as=0.1469p ps=1.155u w=0.55u l=0.13u
X1562 VGND a_17829_1605# a_17931_1748# VGND sg13_lv_nmos ad=7.01497p pd=46.005u as=0.2516p ps=2.16u w=0.74u l=0.13u
X1563 VGND a_13072_1846# a_12721_1703# VGND sg13_lv_nmos ad=79.8f pd=0.8u as=0.1428p ps=1.52u w=0.42u l=0.13u
X1564 VGND a_18860_9150# ph_sw[8] VGND sg13_lv_nmos ad=0.14875p pd=1.16u as=0.2886p ps=2.26u w=0.74u l=0.13u
X1565 sg13cmos5l_buf_1_95.X a_12232_8436# VGND VGND sg13_lv_nmos ad=0.2886p pd=2.26u as=0.14875p ps=1.16u w=0.74u l=0.13u
X1566 VPWR sg13cmos5l_buf_1_40.A a_1192_1664# VPWR sg13_lv_pmos ad=0.2114p pd=1.54u as=0.2856p ps=2.36u w=0.84u l=0.13u
X1567 VPWR a_17584_7166# a_17529_7047# VPWR sg13_lv_pmos ad=1.07253p pd=6.75u as=93.45f ps=0.865u w=0.42u l=0.13u
X1568 VPWR a_3212_1590# sg13cmos5l_buf_1_41.X VPWR sg13_lv_pmos ad=0.2114p pd=1.54u as=0.42p ps=2.99u w=1.12u l=0.13u
X1569 a_14822_6924# a_14426_7288# a_14708_6924# VPWR sg13_lv_pmos ad=0.1008p pd=0.9u as=0.191p ps=1.44u w=0.42u l=0.13u
X1570 sg13cmos5l_buf_1_4.A a_15592_6200# VPWR VPWR sg13_lv_pmos ad=0.42p pd=2.99u as=0.2114p ps=1.54u w=1.12u l=0.13u
X1571 VPWR a_7247_8797# a_8084_8436# VPWR sg13_lv_pmos ad=0.2128p pd=1.5u as=0.3864p ps=2.93u w=1.12u l=0.13u
X1572 a_9660_4686# a_9111_4666# a_9524_4972# VGND sg13_lv_nmos ad=47.25f pd=0.645u as=0.141p ps=1.17u w=0.42u l=0.13u
X1573 a_6213_3911# sg13cmos5l_dfrbp_1_11.Q VPWR VPWR sg13_lv_pmos ad=0.4088p pd=2.97u as=1.43437p ps=9.105u w=1.12u l=0.13u
X1574 VPWR VGND VPWR VPWR sg13_lv_pmos ad=0.34p pd=2.68u as=0 ps=0 w=1u l=1u
X1575 a_17399_3947# sg13cmos5l_dfrbp_1_6.D a_18146_4338# VGND sg13_lv_nmos ad=0.1428p pd=1.52u as=60.89999f ps=0.71u w=0.42u l=0.13u
X1576 a_17674_3361# a_18117_3117# a_17414_3138# VGND sg13_lv_nmos ad=79.8f pd=0.8u as=0.1296p ps=1.52u w=0.42u l=0.13u
X1577 sg13cmos5l_dfrbp_1_14.Q_N a_4847_4727# VPWR VPWR sg13_lv_pmos ad=0.4312p pd=3.01u as=0.2639p ps=1.81u w=1.12u l=0.13u
X1578 sg13cmos5l_buf_1_87.A a_18376_9224# VGND VGND sg13_lv_nmos ad=0.2886p pd=2.26u as=0.14875p ps=1.16u w=0.74u l=0.13u
X1579 VPWR sg13cmos5l_nand2_1_1.A a_20008_3900# VPWR sg13_lv_pmos ad=0.2114p pd=1.54u as=0.2856p ps=2.36u w=0.84u l=0.13u
X1580 a_7622_2064# a_7226_1636# a_7508_1948# VPWR sg13_lv_pmos ad=0.1008p pd=0.9u as=0.191p ps=1.44u w=0.42u l=0.13u
X1581 a_12420_9199# a_12651_9308# a_12106_9409# VGND sg13_lv_nmos ad=0.2373p pd=1.97u as=79.8f ps=0.8u w=0.42u l=0.13u
X1582 VPWR sg13cmos5l_inv_1_5.A sg13cmos5l_a22oi_1_1.A1 VPWR sg13_lv_pmos ad=0.3808p pd=2.92u as=0.3808p ps=2.92u w=1.12u l=0.13u
X1583 VGND sg13cmos5l_a22oi_1_0.Y sg13cmos5l_dfrbp_1_2.D VGND sg13_lv_nmos ad=0.2516p pd=2.16u as=0.2516p ps=2.16u w=0.74u l=0.13u
X1584 a_10433_1652# sg13cmos5l_dlhr_1_0.D sg13cmos5l_a22oi_1_2.B1 VGND sg13_lv_nmos ad=0.1406p pd=1.12u as=0.1406p ps=1.12u w=0.74u l=0.13u
X1585 a_3308_5376# sg13cmos5l_dlhr_1_1.Q VPWR VPWR sg13_lv_pmos ad=0.2856p pd=2.36u as=0.2114p ps=1.54u w=0.84u l=0.13u
X1586 ph_sw[4] a_6568_9224# VPWR VPWR sg13_lv_pmos ad=0.42p pd=2.99u as=0.2114p ps=1.54u w=1.12u l=0.13u
X1587 VGND cks sg13cmos5l_dfrbp_1_6.RESET_B VGND sg13_lv_nmos ad=0.1406p pd=1.12u as=0.1406p ps=1.12u w=0.74u l=0.13u
X1588 a_12106_9409# a_12549_9165# a_12489_9577# VPWR sg13_lv_pmos ad=79.8f pd=0.8u as=63f ps=0.72u w=0.42u l=0.13u
X1589 a_12719_2749# a_11877_2399# a_12625_2749# VGND sg13_lv_nmos ad=0.12665p pd=1.145u as=0.1428p ps=1.52u w=0.42u l=0.13u
X1590 a_15780_2813# a_15492_2392# a_15718_2813# VGND sg13_lv_nmos ad=0.1428p pd=1.52u as=37.8f ps=0.6u w=0.42u l=0.13u
X1591 a_2224_7166# a_1967_7285# a_2386_7362# VGND sg13_lv_nmos ad=0.1428p pd=1.52u as=37.8f ps=0.6u w=0.42u l=0.13u
X1592 a_14708_6924# a_14426_7288# a_14641_7326# VGND sg13_lv_nmos ad=0.141p pd=1.17u as=71.99999f ps=0.865u w=0.64u l=0.13u
X1593 a_9879_9202# sg13cmos5l_dfrbp_1_18.Q VPWR VPWR sg13_lv_pmos ad=0.3234p pd=2.45u as=4.11675p ps=27.17u w=0.84u l=0.13u
X1594 VGND sg13cmos5l_dfrbp_1_6.RESET_B a_12324_6162# VGND sg13_lv_nmos ad=0.1626p pd=1.415u as=60.89999f ps=0.71u w=0.42u l=0.13u
X1595 VPWR a_13641_7674# a_14166_7656# VPWR sg13_lv_pmos ad=0.1974p pd=1.5u as=0.2856p ps=2.36u w=0.84u l=0.13u
X1596 VPWR sg13cmos5l_inv_1_1.A sg13cmos5l_buf_1_2.A VPWR sg13_lv_pmos ad=0.3808p pd=2.92u as=0.3808p ps=2.92u w=1.12u l=0.13u
X1597 VPWR sg13cmos5l_dfrbp_1_1.Q a_20392_2388# VPWR sg13_lv_pmos ad=0.2114p pd=1.54u as=0.2856p ps=2.36u w=0.84u l=0.13u
X1598 sg13cmos5l_dfrbp_1_0.D sg13cmos5l_dfrbp_1_0.Q a_18122_2388# VPWR sg13_lv_pmos ad=0.3808p pd=2.92u as=0.1176p ps=1.33u w=1.12u l=0.13u
X1599 VGND sg13cmos5l_inv_1_0.A sg13cmos5l_nor2b_1_0.Y VGND sg13_lv_nmos ad=0.2516p pd=2.16u as=0.1406p ps=1.12u w=0.74u l=0.13u
X1600 VPWR a_17829_1605# a_17931_1748# VPWR sg13_lv_pmos ad=1.86162p pd=11.935u as=0.3864p ps=2.93u w=1.12u l=0.13u
X1601 VPWR a_4425_7281# a_4950_7354# VPWR sg13_lv_pmos ad=0.1974p pd=1.5u as=0.2856p ps=2.36u w=0.84u l=0.13u
X1602 a_14745_3453# a_13803_3260# a_14543_3215# VPWR sg13_lv_pmos ad=93.45f pd=0.865u as=0.2048p ps=1.63u w=0.42u l=0.13u
X1603 sg13cmos5l_inv_1_26.Y sg13cmos5l_buf_1_19.A VGND VGND sg13_lv_nmos ad=0.2516p pd=2.16u as=0.2516p ps=2.16u w=0.74u l=0.13u
X1604 VGND VPWR VGND VGND sg13_lv_nmos ad=0.1428p pd=1.52u as=0 ps=0 w=0.42u l=1u
X1605 sg13cmos5l_dlhr_1_10.Q a_19593_6162# VPWR VPWR sg13_lv_pmos ad=0.3808p pd=2.92u as=0.2128p ps=1.5u w=1.12u l=0.13u
X1606 a_11372_3102# sg13cmos5l_buf_1_9.A VGND VGND sg13_lv_nmos ad=0.187p pd=1.78u as=0.14875p ps=1.16u w=0.55u l=0.13u
X1607 VPWR sg13cmos5l_dfrbp_1_8.RESET_B a_11846_9186# VPWR sg13_lv_pmos ad=0.36237p pd=2.605u as=79.8f ps=0.8u w=0.42u l=0.13u
X1608 a_16572_4261# a_16703_3871# a_15821_3864# VPWR sg13_lv_pmos ad=0.34p pd=2.68u as=0.2048p ps=1.63u w=1u l=0.13u
X1609 VPWR sg13cmos5l_dfrbp_1_23.Q a_14089_7282# VPWR sg13_lv_pmos ad=1.07253p pd=6.75u as=0.2856p ps=2.36u w=0.84u l=0.13u
X1610 VGND a_16268_3102# nl_sw[8] VGND sg13_lv_nmos ad=0.14875p pd=1.16u as=0.2886p ps=2.26u w=0.74u l=0.13u
X1611 VPWR sg13cmos5l_dfrbp_1_6.RESET_B a_4934_2826# VPWR sg13_lv_pmos ad=0.36237p pd=2.605u as=79.8f ps=0.8u w=0.42u l=0.13u
X1612 a_11270_4338# sg13cmos5l_dfrbp_1_2.D VPWR VPWR sg13_lv_pmos ad=79.8f pd=0.8u as=0.1428p ps=1.52u w=0.42u l=0.13u
X1613 a_13393_7666# a_12841_7728# VGND VGND sg13_lv_nmos ad=71.99999f pd=0.865u as=1.49685p ps=9.6u w=0.64u l=0.13u
X1614 VPWR sg13cmos5l_buf_1_10.A sg13cmos5l_inv_1_28.Y VPWR sg13_lv_pmos ad=0.3808p pd=2.92u as=0.3808p ps=2.92u w=1.12u l=0.13u
X1615 VGND sg13cmos5l_dfrbp_1_1.Q sg13cmos5l_inv_1_11.Y VGND sg13_lv_nmos ad=0.2516p pd=2.16u as=0.2516p ps=2.16u w=0.74u l=0.13u
X1616 a_12567_7282# sg13cmos5l_dlhr_1_11.GATE VGND VGND sg13_lv_nmos ad=0.2516p pd=2.16u as=0.15055p ps=1.17u w=0.74u l=0.13u
X1617 sg13cmos5l_buf_8_0.X a_19227_4654# VGND VGND sg13_lv_nmos ad=0.1406p pd=1.12u as=0.1406p ps=1.12u w=0.74u l=0.13u
X1618 VPWR a_3676_7964# sg13cmos5l_dlhr_1_9.Q VPWR sg13_lv_pmos ad=0.2128p pd=1.5u as=0.3808p ps=2.92u w=1.12u l=0.13u
X1619 sg13cmos5l_dfrbp_1_10.Q_N a_3599_3215# VPWR VPWR sg13_lv_pmos ad=0.4312p pd=3.01u as=0.2639p ps=1.81u w=1.12u l=0.13u
X1620 VPWR a_6903_3154# a_7034_3148# VPWR sg13_lv_pmos ad=1.43437p pd=9.105u as=0.2856p ps=2.36u w=0.84u l=0.13u
X1621 VPWR sg13cmos5l_and3_1_0.C a_13324_4696# VPWR sg13_lv_pmos ad=0.36195p pd=1.84u as=0.1596p ps=1.22u w=0.84u l=0.13u
X1622 nh_sw[2] a_3688_1664# VPWR VPWR sg13_lv_pmos ad=0.42p pd=2.99u as=0.2114p ps=1.54u w=1.12u l=0.13u
X1623 a_5324_1590# sg13cmos5l_buf_1_34.X VPWR VPWR sg13_lv_pmos ad=0.2856p pd=2.36u as=0.2114p ps=1.54u w=0.84u l=0.13u
X1624 a_13641_3529# a_13284_3456# VPWR VPWR sg13_lv_pmos ad=63f pd=0.72u as=0.1563p ps=1.22u w=0.42u l=0.13u
X1625 VPWR a_15177_5769# a_15110_5412# VPWR sg13_lv_pmos ad=0.2387p pd=1.84u as=0.1008p ps=0.9u w=0.42u l=0.13u
X1626 a_10596_7687# a_10308_7992# a_10534_7687# VGND sg13_lv_nmos ad=0.1428p pd=1.52u as=37.8f ps=0.6u w=0.42u l=0.13u
X1627 sg13cmos5l_dlhr_1_11.Q a_13161_7281# VGND VGND sg13_lv_nmos ad=0.2516p pd=2.16u as=0.1406p ps=1.12u w=0.74u l=0.13u
X1628 VGND a_1125_5423# a_1227_5423# VGND sg13_lv_nmos ad=1.97045p pd=12.335u as=0.2516p ps=2.16u w=0.74u l=0.13u
X1629 VPWR sg13cmos5l_buf_1_97.A a_11848_8436# VPWR sg13_lv_pmos ad=0.2114p pd=1.54u as=0.2856p ps=2.36u w=0.84u l=0.13u
X1630 sg13cmos5l_dfrbp_1_23.Q a_14612_6460# VPWR VPWR sg13_lv_pmos ad=0.3808p pd=2.92u as=0.2128p ps=1.5u w=1.12u l=0.13u
X1631 VPWR sg13cmos5l_dfrbp_1_6.RESET_B a_2409_4650# VPWR sg13_lv_pmos ad=0.2128p pd=1.5u as=0.2128p ps=1.5u w=1.12u l=0.13u
X1632 sg13cmos5l_dfrbp_1_0.Q_N a_18671_1703# VPWR VPWR sg13_lv_pmos ad=0.4312p pd=3.01u as=0.2639p ps=1.81u w=1.12u l=0.13u
X1633 a_2786_7666# a_2596_7996# a_2348_7624# VGND sg13_lv_nmos ad=71.99999f pd=0.865u as=0.141p ps=1.17u w=0.64u l=0.13u
X1634 sg13cmos5l_dfrbp_1_24.Q_N a_13391_9263# VPWR VPWR sg13_lv_pmos ad=0.4312p pd=3.01u as=0.2639p ps=1.81u w=1.12u l=0.13u
X1635 a_5069_5376# a_5799_5499# a_5820_5773# VGND sg13_lv_nmos ad=0.12665p pd=1.145u as=0.3473p ps=2.71u w=0.74u l=0.13u
X1636 a_9202_7674# sg13cmos5l_dfrbp_1_6.RESET_B VGND VGND sg13_lv_nmos ad=37.8f pd=0.6u as=79.8f ps=0.8u w=0.42u l=0.13u
X1637 VPWR a_11567_7751# a_12404_7972# VPWR sg13_lv_pmos ad=0.2128p pd=1.5u as=0.3864p ps=2.93u w=1.12u l=0.13u
X1638 a_13792_5760# sg13cmos5l_or2_1_1.B sg13cmos5l_a22oi_1_1.B2 VGND sg13_lv_nmos ad=0.1406p pd=1.12u as=0.2516p ps=2.16u w=0.74u l=0.13u
X1639 VGND a_620_7638# pl_sw[0] VGND sg13_lv_nmos ad=0.14875p pd=1.16u as=0.2886p ps=2.26u w=0.74u l=0.13u
X1640 a_8972_3864# sg13cmos5l_buf_1_45.A VPWR VPWR sg13_lv_pmos ad=0.2856p pd=2.36u as=0.2114p ps=1.54u w=0.84u l=0.13u
X1641 VGND sg13cmos5l_inv_1_5.A sg13cmos5l_a22oi_1_1.A1 VGND sg13_lv_nmos ad=0.2516p pd=2.16u as=0.2516p ps=2.16u w=0.74u l=0.13u
X1642 VPWR sg13cmos5l_dlhr_1_10.Q a_19528_6924# VPWR sg13_lv_pmos ad=0.2114p pd=1.54u as=0.2856p ps=2.36u w=0.84u l=0.13u
X1643 sg13cmos5l_a22oi_1_1.Y sg13cmos5l_a22oi_1_1.A1 a_14814_4292# VGND sg13_lv_nmos ad=0.2664p pd=1.46u as=96.2f ps=1u w=0.74u l=0.13u
X1644 sg13cmos5l_or2_1_0.A a_18363_4270# VPWR VPWR sg13_lv_pmos ad=0.2128p pd=1.5u as=0.2128p ps=1.5u w=1.12u l=0.13u
X1645 VPWR a_19227_4654# sg13cmos5l_buf_8_0.X VPWR sg13_lv_pmos ad=0.2128p pd=1.5u as=0.2128p ps=1.5u w=1.12u l=0.13u
X1646 a_13072_1846# sg13cmos5l_dfrbp_1_0.RESET_B VPWR VPWR sg13_lv_pmos ad=79.8f pd=0.8u as=1.777p ps=11.395u w=0.42u l=0.13u
X1647 sg13cmos5l_dlhr_1_0.GATE a_5684_4948# VPWR VPWR sg13_lv_pmos ad=0.3808p pd=2.92u as=0.2128p ps=1.5u w=1.12u l=0.13u
X1648 a_15429_7653# sg13cmos5l_dfrbp_1_22.D VGND VGND sg13_lv_nmos ad=0.2516p pd=2.16u as=1.49685p ps=9.6u w=0.74u l=0.13u
X1649 sg13cmos5l_dfrbp_1_4.D a_10464_2427# a_10613_2758# VGND sg13_lv_nmos ad=0.2516p pd=2.16u as=0.1406p ps=1.12u w=0.74u l=0.13u
X1650 a_10031_8797# a_9189_8447# a_8772_8440# VPWR sg13_lv_pmos ad=0.2048p pd=1.63u as=0.34p ps=2.68u w=1u l=0.13u
X1651 VPWR sg13cmos5l_buf_8_1.A a_18363_4270# VPWR sg13_lv_pmos ad=0.2128p pd=1.5u as=0.2128p ps=1.5u w=1.12u l=0.13u
X1652 a_5796_3904# a_6315_3911# a_7055_4261# VGND sg13_lv_nmos ad=0.3473p pd=2.71u as=0.12665p ps=1.145u w=0.74u l=0.13u
X1653 a_11488_4676# sg13cmos5l_a221oi_1_0.B1 sg13cmos5l_o21ai_1_0.A1 VGND sg13_lv_nmos ad=0.1406p pd=1.12u as=0.2516p ps=2.16u w=0.74u l=0.13u
X1654 VGND a_1997_6126# sg13cmos5l_dfrbp_1_15.Q_N VGND sg13_lv_nmos ad=0.2516p pd=2.16u as=0.2849p ps=2.25u w=0.74u l=0.13u
X1655 VGND a_7820_2352# sg13cmos5l_inv_1_14.A VGND sg13_lv_nmos ad=0.14875p pd=1.16u as=0.2886p ps=2.26u w=0.74u l=0.13u
X1656 VPWR a_6741_5459# a_5820_5773# VPWR sg13_lv_pmos ad=0.36237p pd=2.605u as=0.34p ps=2.68u w=1u l=0.13u
X1657 VPWR sg13cmos5l_buf_1_68.X a_616_9224# VPWR sg13_lv_pmos ad=0.2114p pd=1.54u as=0.2856p ps=2.36u w=0.84u l=0.13u
X1658 VGND a_16144_8678# a_15793_8797# VGND sg13_lv_nmos ad=79.8f pd=0.8u as=0.1428p ps=1.52u w=0.42u l=0.13u
X1659 a_10308_7992# a_10282_7897# VPWR VPWR sg13_lv_pmos ad=0.34p pd=2.68u as=0.36237p ps=2.605u w=1u l=0.13u
X1660 VGND sg13cmos5l_buf_1_25.X a_4456_1664# VGND sg13_lv_nmos ad=0.14875p pd=1.16u as=0.187p ps=1.78u w=0.55u l=0.13u
X1661 a_15590_4650# sg13cmos5l_dfrbp_1_8.D VPWR VPWR sg13_lv_pmos ad=79.8f pd=0.8u as=0.1428p ps=1.52u w=0.42u l=0.13u
X1662 VPWR a_6789_4629# a_6891_4772# VPWR sg13_lv_pmos ad=1.28962p pd=8.195u as=0.3864p ps=2.93u w=1.12u l=0.13u
X1663 a_7504_8678# sg13cmos5l_dfrbp_1_8.RESET_B VPWR VPWR sg13_lv_pmos ad=79.8f pd=0.8u as=1.12242p ps=7u w=0.42u l=0.13u
X1664 a_650_3900# sg13cmos5l_nor2_1_2.A VPWR VPWR sg13_lv_pmos ad=0.1176p pd=1.33u as=0.4032p ps=2.96u w=1.12u l=0.13u
X1665 VGND a_10665_7281# a_11190_7354# VGND sg13_lv_nmos ad=0.1491p pd=1.18u as=0.187p ps=1.78u w=0.55u l=0.13u
X1666 a_11824_7894# sg13cmos5l_dfrbp_1_6.RESET_B VPWR VPWR sg13_lv_pmos ad=79.8f pd=0.8u as=1.12242p ps=7u w=0.42u l=0.13u
X1667 VPWR sg13cmos5l_buf_1_110.A a_15784_9224# VPWR sg13_lv_pmos ad=0.2114p pd=1.54u as=0.2856p ps=2.36u w=0.84u l=0.13u
X1668 a_11182_4676# sg13cmos5l_a221oi_1_0.A2 VGND VGND sg13_lv_nmos ad=0.1406p pd=1.12u as=0.2516p ps=2.16u w=0.74u l=0.13u
X1669 VGND a_19209_5769# a_19734_5842# VGND sg13_lv_nmos ad=0.1491p pd=1.18u as=0.187p ps=1.78u w=0.55u l=0.13u
X1670 sg13cmos5l_buf_1_107.X a_17896_9224# VPWR VPWR sg13_lv_pmos ad=0.42p pd=2.99u as=0.2114p ps=1.54u w=1.12u l=0.13u
X1671 VGND a_8972_9150# sg13cmos5l_buf_1_77.X VGND sg13_lv_nmos ad=0.14875p pd=1.16u as=0.2886p ps=2.26u w=0.74u l=0.13u
X1672 VPWR sg13cmos5l_buf_1_7.A a_14056_1664# VPWR sg13_lv_pmos ad=0.2114p pd=1.54u as=0.2856p ps=2.36u w=0.84u l=0.13u
X1673 VGND a_11824_7894# a_11473_7751# VGND sg13_lv_nmos ad=79.8f pd=0.8u as=0.1428p ps=1.52u w=0.42u l=0.13u
X1674 VGND sg13cmos5l_dlhr_1_15.D a_17545_7728# VGND sg13_lv_nmos ad=0.15055p pd=1.17u as=0.187p ps=1.78u w=0.55u l=0.13u
X1675 VGND sg13cmos5l_dfrbp_1_6.RESET_B a_16298_4338# VGND sg13_lv_nmos ad=79.8f pd=0.8u as=37.8f ps=0.6u w=0.42u l=0.13u
X1676 VPWR sg13cmos5l_or2_1_1.B a_10420_5412# VPWR sg13_lv_pmos ad=0.3808p pd=2.92u as=0.2128p ps=1.5u w=1.12u l=0.13u
X1677 sg13cmos5l_buf_8_0.X a_19227_4654# VGND VGND sg13_lv_nmos ad=0.1406p pd=1.12u as=0.1406p ps=1.12u w=0.74u l=0.13u
X1678 VGND a_19227_9190# sg13cmos5l_buf_8_2.X VGND sg13_lv_nmos ad=0.1406p pd=1.12u as=0.1406p ps=1.12u w=0.74u l=0.13u
X1679 VGND a_17367_8794# a_17498_8800# VGND sg13_lv_nmos ad=2.92392p pd=18.89u as=0.2775p ps=2.23u w=0.74u l=0.13u
X1680 VGND a_10412_6126# sg13cmos5l_buf_1_29.A VGND sg13_lv_nmos ad=0.14875p pd=1.16u as=0.2886p ps=2.26u w=0.74u l=0.13u
X1681 a_4950_5699# a_5069_5376# VPWR VPWR sg13_lv_pmos ad=0.3864p pd=2.93u as=0.2128p ps=1.5u w=1.12u l=0.13u
X1682 a_7216_6382# sg13cmos5l_dfrbp_1_6.RESET_B VPWR VPWR sg13_lv_pmos ad=79.8f pd=0.8u as=1.04815p ps=6.595u w=0.42u l=0.13u
X1683 VPWR a_16528_7894# a_16473_7989# VPWR sg13_lv_pmos ad=1.15047p pd=7.175u as=93.45f ps=0.865u w=0.42u l=0.13u
X1684 VPWR VGND VPWR VPWR sg13_lv_pmos ad=0.19p pd=1.38u as=0 ps=0 w=1u l=1u
X1685 a_11268_5760# sg13cmos5l_dlhr_1_15.D VGND VGND sg13_lv_nmos ad=0.1216p pd=1.02u as=0.1371p ps=1.12u w=0.64u l=0.13u
X1686 sg13cmos5l_inv_1_2.A a_8488_9224# VGND VGND sg13_lv_nmos ad=0.2886p pd=2.26u as=0.14875p ps=1.16u w=0.74u l=0.13u
X1687 a_7312_4142# sg13cmos5l_dfrbp_1_6.RESET_B VPWR VPWR sg13_lv_pmos ad=79.8f pd=0.8u as=1.38655p ps=8.8u w=0.42u l=0.13u
X1688 sg13cmos5l_o21ai_1_0.Y sg13cmos5l_o21ai_1_0.A2 a_12120_3456# VPWR sg13_lv_pmos ad=0.2128p pd=1.5u as=0.2128p ps=1.5u w=1.12u l=0.15u
X1689 sg13cmos5l_buf_8_1.A a_17972_4948# VGND VGND sg13_lv_nmos ad=0.2516p pd=2.16u as=0.1406p ps=1.12u w=0.74u l=0.13u
X1690 sg13cmos5l_inv_1_26.Y sg13cmos5l_buf_1_19.A VPWR VPWR sg13_lv_pmos ad=0.3808p pd=2.92u as=0.3808p ps=2.92u w=1.12u l=0.13u
X1691 a_6479_2749# a_5637_2399# a_5220_2392# VPWR sg13_lv_pmos ad=0.2048p pd=1.63u as=0.34p ps=2.68u w=1u l=0.13u
X1692 sg13cmos5l_buf_8_0.A a_18480_5028# VGND VGND sg13_lv_nmos ad=0.2516p pd=2.16u as=0.1469p ps=1.155u w=0.74u l=0.13u
X1693 VGND sg13cmos5l_nor2_1_0.A sg13cmos5l_a221oi_1_0.C1 VGND sg13_lv_nmos ad=0.2516p pd=2.16u as=0.1406p ps=1.12u w=0.74u l=0.13u
X1694 VGND a_17008_2630# a_16657_2749# VGND sg13_lv_nmos ad=79.8f pd=0.8u as=0.1428p ps=1.52u w=0.42u l=0.13u
X1695 sg13cmos5l_buf_1_8.X a_10888_1664# VPWR VPWR sg13_lv_pmos ad=0.42p pd=2.99u as=0.2114p ps=1.54u w=1.12u l=0.13u
X1696 a_11844_4325# a_12075_3911# a_11530_3868# VGND sg13_lv_nmos ad=0.2373p pd=1.97u as=79.8f ps=0.8u w=0.42u l=0.13u
X1697 a_5510_4338# a_6315_3911# a_5770_3868# VPWR sg13_lv_pmos ad=0.1428p pd=1.52u as=79.8f ps=0.8u w=0.42u l=0.13u
X1698 a_10708_9172# a_10292_9508# a_10473_9186# VGND sg13_lv_nmos ad=77.7f pd=0.95u as=0.2516p ps=2.16u w=0.74u l=0.13u
X1699 a_2565_8447# sg13cmos5l_inv_1_8.A VGND VGND sg13_lv_nmos ad=0.2516p pd=2.16u as=2.71505p ps=17.54u w=0.74u l=0.13u
X1700 a_15012_7992# a_15531_7796# a_16271_7751# VGND sg13_lv_nmos ad=0.3473p pd=2.71u as=0.12665p ps=1.145u w=0.74u l=0.13u
X1701 VPWR sg13cmos5l_inv_1_8.A sg13cmos5l_inv_1_8.Y VPWR sg13_lv_pmos ad=0.3808p pd=2.92u as=0.3808p ps=2.92u w=1.12u l=0.13u
X1702 VGND a_9705_4650# a_10230_4632# VGND sg13_lv_nmos ad=0.1491p pd=1.18u as=0.187p ps=1.78u w=0.55u l=0.13u
X1703 sg13cmos5l_buf_1_94.X a_15016_9224# VGND VGND sg13_lv_nmos ad=0.2886p pd=2.26u as=0.14875p ps=1.16u w=0.74u l=0.13u
X1704 VPWR a_3692_9150# sg13cmos5l_buf_1_62.X VPWR sg13_lv_pmos ad=0.2114p pd=1.54u as=0.42p ps=2.99u w=1.12u l=0.13u
X1705 VGND a_6380_7638# pl_sw[3] VGND sg13_lv_nmos ad=0.14875p pd=1.16u as=0.2886p ps=2.26u w=0.74u l=0.13u
X1706 a_19244_2352# sg13cmos5l_buf_1_18.X VGND VGND sg13_lv_nmos ad=0.187p pd=1.78u as=0.14875p ps=1.16u w=0.55u l=0.13u
X1707 a_15429_7653# sg13cmos5l_dfrbp_1_22.D VPWR VPWR sg13_lv_pmos ad=0.4088p pd=2.97u as=1.12242p ps=7u w=1.12u l=0.13u
X1708 VPWR a_15887_8797# a_16144_8678# VPWR sg13_lv_pmos ad=0.2639p pd=1.81u as=79.8f ps=0.8u w=0.42u l=0.13u
X1709 VPWR sg13cmos5l_dfrbp_1_6.RESET_B a_7689_1626# VPWR sg13_lv_pmos ad=0.2128p pd=1.5u as=0.2128p ps=1.5u w=1.12u l=0.13u
X1710 VPWR sg13cmos5l_buf_1_8.A a_10888_1664# VPWR sg13_lv_pmos ad=0.2114p pd=1.54u as=0.2856p ps=2.36u w=0.84u l=0.13u
X1711 a_10420_5412# sg13cmos5l_dfrbp_1_16.Q a_10318_5412# VPWR sg13_lv_pmos ad=0.2128p pd=1.5u as=0.2128p ps=1.5u w=1.12u l=0.13u
X1712 a_1006_4167# a_1121_4166# VPWR VPWR sg13_lv_pmos ad=0.34p pd=2.68u as=0.2254p ps=1.53u w=1u l=0.5u
X1713 a_19227_4654# sg13cmos5l_buf_8_0.A VGND VGND sg13_lv_nmos ad=0.1406p pd=1.12u as=0.1406p ps=1.12u w=0.74u l=0.13u
X1714 VGND a_18345_7674# a_18870_7656# VGND sg13_lv_nmos ad=0.1491p pd=1.18u as=0.187p ps=1.78u w=0.55u l=0.13u
X1715 VGND a_18959_3215# a_19796_3436# VGND sg13_lv_nmos ad=0.1406p pd=1.12u as=0.2516p ps=2.16u w=0.74u l=0.13u
X1716 sg13cmos5l_dfrbp_1_8.Q_N a_17135_4727# VPWR VPWR sg13_lv_pmos ad=0.4312p pd=3.01u as=0.2639p ps=1.81u w=1.12u l=0.13u
X1717 VGND a_18363_4270# sg13cmos5l_or2_1_0.A VGND sg13_lv_nmos ad=0.1406p pd=1.12u as=0.1406p ps=1.12u w=0.74u l=0.13u
X1718 a_17386_1849# a_17829_1605# a_17769_2017# VPWR sg13_lv_pmos ad=79.8f pd=0.8u as=63f ps=0.72u w=0.42u l=0.13u
X1719 VPWR a_19227_4654# sg13cmos5l_buf_8_0.X VPWR sg13_lv_pmos ad=0.2128p pd=1.5u as=0.2128p ps=1.5u w=1.12u l=0.13u
X1720 a_8247_5770# sg13cmos5l_dfrbp_1_11.Q VGND VGND sg13_lv_nmos ad=0.2516p pd=2.16u as=0.15055p ps=1.17u w=0.74u l=0.13u
X1721 sg13cmos5l_buf_8_2.X a_19227_9190# VPWR VPWR sg13_lv_pmos ad=0.2128p pd=1.5u as=0.2128p ps=1.5u w=1.12u l=0.13u
X1722 VPWR sg13cmos5l_dfrbp_1_6.RESET_B a_682_6892# VPWR sg13_lv_pmos ad=0.1563p pd=1.22u as=0.147p ps=1.54u w=0.42u l=0.13u
X1723 a_3793_2790# a_3241_2746# VGND VGND sg13_lv_nmos ad=71.99999f pd=0.865u as=2.59257p ps=16.445u w=0.64u l=0.13u
X1724 a_16356_7349# a_16587_6935# a_16042_6892# VGND sg13_lv_nmos ad=0.2373p pd=1.97u as=79.8f ps=0.8u w=0.42u l=0.13u
X1725 VPWR sg13cmos5l_dfrbp_1_11.Q a_6647_5459# VPWR sg13_lv_pmos ad=0.1428p pd=1.52u as=79.8f ps=0.8u w=0.42u l=0.13u
X1726 sg13cmos5l_dfrbp_1_9.Q_N a_3407_4261# VPWR VPWR sg13_lv_pmos ad=0.4312p pd=3.01u as=0.2639p ps=1.81u w=1.12u l=0.13u
X1727 sg13cmos5l_buf_1_45.A a_8841_5769# VGND VGND sg13_lv_nmos ad=0.2516p pd=2.16u as=0.1406p ps=1.12u w=0.74u l=0.13u
X1728 a_4076_5376# sg13cmos5l_dlhr_1_9.Q VPWR VPWR sg13_lv_pmos ad=0.2856p pd=2.36u as=0.2114p ps=1.54u w=0.84u l=0.13u
X1729 VGND a_2224_7166# a_1873_7285# VGND sg13_lv_nmos ad=79.8f pd=0.8u as=0.1428p ps=1.52u w=0.42u l=0.13u
X1730 VPWR VGND VPWR VPWR sg13_lv_pmos ad=0.34p pd=2.68u as=0 ps=0 w=1u l=1u
X1731 a_5702_8874# sg13cmos5l_dlhr_1_5.GATE VPWR VPWR sg13_lv_pmos ad=79.8f pd=0.8u as=0.1428p ps=1.52u w=0.42u l=0.13u
X1732 a_3996_2790# a_3447_2746# a_3860_2388# VGND sg13_lv_nmos ad=47.25f pd=0.645u as=0.141p ps=1.17u w=0.42u l=0.13u
X1733 a_9111_4666# sg13cmos5l_dfrbp_1_11.Q VPWR VPWR sg13_lv_pmos ad=0.3234p pd=2.45u as=1.2517p ps=7.955u w=0.84u l=0.13u
X1734 a_4660_7312# a_4244_6924# a_4425_7281# VGND sg13_lv_nmos ad=77.7f pd=0.95u as=0.2516p ps=2.16u w=0.74u l=0.13u
X1735 sg13cmos5l_a221oi_1_0.B2 sg13cmos5l_nor2b_1_0.Y VGND VGND sg13_lv_nmos ad=0.1406p pd=1.12u as=0.2516p ps=2.16u w=0.74u l=0.13u
X1736 VGND sg13cmos5l_dfrbp_1_0.RESET_B a_11364_4338# VGND sg13_lv_nmos ad=0.1626p pd=1.415u as=60.89999f ps=0.71u w=0.42u l=0.13u
X1737 a_15466_2356# a_15909_2399# a_15849_2435# VPWR sg13_lv_pmos ad=79.8f pd=0.8u as=63f ps=0.72u w=0.42u l=0.13u
X1738 a_7732_3124# a_7316_3460# a_7497_3138# VGND sg13_lv_nmos ad=77.7f pd=0.95u as=0.2516p ps=2.16u w=0.74u l=0.13u
X1739 VGND a_15177_5769# a_15702_5842# VGND sg13_lv_nmos ad=0.1491p pd=1.18u as=0.187p ps=1.78u w=0.55u l=0.13u
X1740 a_10288_8678# a_10031_8797# a_10450_8874# VGND sg13_lv_nmos ad=0.1428p pd=1.52u as=37.8f ps=0.6u w=0.42u l=0.13u
X1741 VGND a_19227_9190# sg13cmos5l_buf_8_2.X VGND sg13_lv_nmos ad=0.1406p pd=1.12u as=0.1406p ps=1.12u w=0.74u l=0.13u
X1742 a_13138_2826# sg13cmos5l_dfrbp_1_0.RESET_B VGND VGND sg13_lv_nmos ad=37.8f pd=0.6u as=79.8f ps=0.8u w=0.42u l=0.13u
X1743 VPWR a_2565_3911# a_2667_3911# VPWR sg13_lv_pmos ad=1.43437p pd=9.105u as=0.3864p ps=2.93u w=1.12u l=0.13u
X1744 a_12549_9165# sg13cmos5l_inv_1_2.A VGND VGND sg13_lv_nmos ad=0.2516p pd=2.16u as=2.71505p ps=17.54u w=0.74u l=0.13u
X1745 VPWR sg13cmos5l_dfrbp_1_6.RESET_B a_10473_9186# VPWR sg13_lv_pmos ad=0.2128p pd=1.5u as=0.2128p ps=1.5u w=1.12u l=0.13u
X1746 VGND a_5079_3154# a_5210_3148# VGND sg13_lv_nmos ad=2.59257p pd=16.445u as=0.2775p ps=2.23u w=0.74u l=0.13u
X1747 a_2228_4972# a_1815_4666# a_2160_4972# VPWR sg13_lv_pmos ad=0.191p pd=1.44u as=0.105p ps=1.21u w=1u l=0.13u
X1748 a_5510_4338# sg13cmos5l_dfrbp_1_6.D VPWR VPWR sg13_lv_pmos ad=79.8f pd=0.8u as=0.1428p ps=1.52u w=0.42u l=0.13u
X1749 a_10534_7687# sg13cmos5l_dfrbp_1_6.RESET_B VGND VGND sg13_lv_nmos ad=37.8f pd=0.6u as=0.1701p ps=1.65u w=0.42u l=0.13u
X1750 VGND a_14295_7282# a_14426_7288# VGND sg13_lv_nmos ad=1.49685p pd=9.6u as=0.2775p ps=2.23u w=0.74u l=0.13u
X1751 VPWR a_7863_7282# a_7994_7288# VPWR sg13_lv_pmos ad=1.07253p pd=6.75u as=0.2856p ps=2.36u w=0.84u l=0.13u
X1752 sg13cmos5l_inv_1_0.A a_13652_3900# VPWR VPWR sg13_lv_pmos ad=0.3808p pd=2.92u as=0.2128p ps=1.5u w=1.12u l=0.13u
X1753 a_3562_4873# a_4005_4629# a_3302_4650# VGND sg13_lv_nmos ad=79.8f pd=0.8u as=0.1296p ps=1.52u w=0.42u l=0.13u
X1754 sg13cmos5l_buf_1_45.A a_8841_5769# VPWR VPWR sg13_lv_pmos ad=0.3808p pd=2.92u as=0.2128p ps=1.5u w=1.12u l=0.13u
X1755 VGND a_16293_4629# a_16395_4772# VGND sg13_lv_nmos ad=2.41737p pd=15.64u as=0.2516p ps=2.16u w=0.74u l=0.13u
X1756 a_8772_8440# a_8746_8404# VGND VGND sg13_lv_nmos ad=0.2516p pd=2.16u as=0.1626p ps=1.415u w=0.74u l=0.13u
X1757 a_12132_9504# a_12106_9409# VPWR VPWR sg13_lv_pmos ad=0.34p pd=2.68u as=0.36237p ps=2.605u w=1u l=0.13u
X1758 a_13810_9186# sg13cmos5l_dfrbp_1_8.RESET_B VGND VGND sg13_lv_nmos ad=37.8f pd=0.6u as=79.8f ps=0.8u w=0.42u l=0.13u
X1759 VPWR sg13cmos5l_buf_8_0.A a_19227_4654# VPWR sg13_lv_pmos ad=0.2128p pd=1.5u as=0.2128p ps=1.5u w=1.12u l=0.13u
X1760 a_1815_4666# sg13cmos5l_dlhr_1_1.GATE VPWR VPWR sg13_lv_pmos ad=0.3234p pd=2.45u as=1.2517p ps=7.955u w=0.84u l=0.13u
X1761 VPWR a_3407_8797# a_4244_8436# VPWR sg13_lv_pmos ad=0.2128p pd=1.5u as=0.3864p ps=2.93u w=1.12u l=0.13u
X1762 a_14814_3876# sg13cmos5l_a22oi_1_1.B1 sg13cmos5l_a22oi_1_1.Y VPWR sg13_lv_pmos ad=0.2716p pd=1.605u as=0.2128p ps=1.5u w=1.12u l=0.13u
X1763 VGND a_15884_3102# nh_sw[7] VGND sg13_lv_nmos ad=0.14875p pd=1.16u as=0.2886p ps=2.26u w=0.74u l=0.13u
X1764 VGND a_6405_8447# a_6507_8447# VGND sg13_lv_nmos ad=2.92392p pd=18.89u as=0.2516p ps=2.16u w=0.74u l=0.13u
X1765 a_3574_7850# a_3676_7964# VGND VGND sg13_lv_nmos ad=0.187p pd=1.78u as=0.1491p ps=1.18u w=0.55u l=0.13u
X1766 VPWR a_1967_7285# a_2224_7166# VPWR sg13_lv_pmos ad=0.2639p pd=1.81u as=79.8f ps=0.8u w=0.42u l=0.13u
X1767 VPWR sg13cmos5l_nor2_1_0.A a_12814_4692# VPWR sg13_lv_pmos ad=0.2618p pd=1.63u as=0.2856p ps=2.36u w=0.84u l=0.13u
X1768 a_17926_3151# sg13cmos5l_dfrbp_1_0.RESET_B VGND VGND sg13_lv_nmos ad=37.8f pd=0.6u as=0.1701p ps=1.65u w=0.42u l=0.13u
X1769 VGND sg13cmos5l_and3_1_0.C a_13520_4696# VGND sg13_lv_nmos ad=0.1371p pd=1.12u as=0.1216p ps=1.02u w=0.64u l=0.13u
X1770 a_10789_4654# sg13cmos5l_a221oi_1_0.C1 VGND VGND sg13_lv_nmos ad=0.1406p pd=1.12u as=0.14505p ps=1.15u w=0.74u l=0.13u
X1771 sg13cmos5l_dlhr_1_2.D a_6479_2749# VPWR VPWR sg13_lv_pmos ad=0.4312p pd=3.01u as=0.2639p ps=1.81u w=1.12u l=0.13u
X1772 a_13100_8400# sg13cmos5l_buf_1_90.X VPWR VPWR sg13_lv_pmos ad=0.2856p pd=2.36u as=0.2114p ps=1.54u w=0.84u l=0.13u
X1773 sg13cmos5l_nor2_1_2.A sg13cmos5l_inv_1_9.Y VGND VGND sg13_lv_nmos ad=0.2516p pd=2.16u as=0.2516p ps=2.16u w=0.74u l=0.13u
X1774 a_13572_3151# a_13803_3260# a_13258_3361# VGND sg13_lv_nmos ad=0.2373p pd=1.97u as=79.8f ps=0.8u w=0.42u l=0.13u
X1775 a_11530_1849# a_11973_1605# a_11270_1626# VGND sg13_lv_nmos ad=79.8f pd=0.8u as=0.1296p ps=1.52u w=0.42u l=0.13u
X1776 a_14032_6382# a_13775_6239# a_14194_6162# VGND sg13_lv_nmos ad=0.1428p pd=1.52u as=37.8f ps=0.6u w=0.42u l=0.13u
X1777 a_10464_2427# sg13cmos5l_nor2_1_0.A VPWR VPWR sg13_lv_pmos ad=0.1596p pd=1.22u as=0.4536p ps=2.76u w=0.84u l=0.13u
X1778 VGND a_3856_3358# a_3505_3215# VGND sg13_lv_nmos ad=79.8f pd=0.8u as=0.1428p ps=1.52u w=0.42u l=0.13u
X1779 a_3876_4663# a_3588_4968# a_3814_4663# VGND sg13_lv_nmos ad=0.1428p pd=1.52u as=37.8f ps=0.6u w=0.42u l=0.13u
X1780 a_6998_5837# a_5820_5773# a_6602_5692# VGND sg13_lv_nmos ad=37.8f pd=0.6u as=0.1428p ps=1.52u w=0.42u l=0.13u
X1781 sg13cmos5l_dlhr_1_1.D a_1967_5773# VGND VGND sg13_lv_nmos ad=0.2849p pd=2.25u as=0.2516p ps=2.16u w=0.74u l=0.13u
X1782 VGND VPWR VGND VGND sg13_lv_nmos ad=0.1428p pd=1.52u as=0 ps=0 w=0.42u l=1u
X1783 a_10417_7326# a_9865_7282# VGND VGND sg13_lv_nmos ad=71.99999f pd=0.865u as=1.49685p ps=9.6u w=0.64u l=0.13u
X1784 VPWR sg13cmos5l_nand2_1_0.A sg13cmos5l_o21ai_1_0.A2 VPWR sg13_lv_pmos ad=0.3808p pd=2.92u as=0.2128p ps=1.5u w=1.12u l=0.13u
X1785 VGND a_1484_9150# sg13cmos5l_buf_1_68.X VGND sg13_lv_nmos ad=0.14875p pd=1.16u as=0.2886p ps=2.26u w=0.74u l=0.13u
X1786 VGND sg13cmos5l_buf_1_40.A sg13cmos5l_buf_1_63.A VGND sg13_lv_nmos ad=0.2516p pd=2.16u as=0.2516p ps=2.16u w=0.74u l=0.13u
X1787 VPWR a_13161_7281# a_13094_6924# VPWR sg13_lv_pmos ad=0.2387p pd=1.84u as=0.1008p ps=0.9u w=0.42u l=0.13u
X1788 VPWR sg13cmos5l_nand2_1_1.B a_9823_2364# VPWR sg13_lv_pmos ad=0.3808p pd=2.92u as=0.2744p ps=1.61u w=1.12u l=0.13u
X1789 a_14858_2388# sg13cmos5l_dfrbp_1_0.Q sg13cmos5l_nand2_1_0.A VPWR sg13_lv_pmos ad=0.1176p pd=1.33u as=0.3808p ps=2.92u w=1.12u l=0.13u
X1790 VGND cks a_19227_9190# VGND sg13_lv_nmos ad=0.1406p pd=1.12u as=0.1406p ps=1.12u w=0.74u l=0.13u
X1791 a_16068_6928# a_16042_6892# VGND VGND sg13_lv_nmos ad=0.2516p pd=2.16u as=0.1626p ps=1.415u w=0.74u l=0.13u
X1792 VPWR a_19593_6162# a_19526_6600# VPWR sg13_lv_pmos ad=0.2387p pd=1.84u as=0.1008p ps=0.9u w=0.42u l=0.13u
X1793 pl_sw[1] a_1000_9224# VGND VGND sg13_lv_nmos ad=0.2886p pd=2.26u as=0.14875p ps=1.16u w=0.74u l=0.13u
X1794 VGND sg13cmos5l_buf_1_29.A sg13cmos5l_buf_1_77.A VGND sg13_lv_nmos ad=0.2516p pd=2.16u as=0.2516p ps=2.16u w=0.74u l=0.13u
X1795 a_3447_2746# sg13cmos5l_dfrbp_1_9.Q VGND VGND sg13_lv_nmos ad=0.2516p pd=2.16u as=0.15055p ps=1.17u w=0.74u l=0.13u
X1796 a_18480_5028# sg13cmos5l_dfrbp_1_0.D VGND VGND sg13_lv_nmos ad=0.1045p pd=0.93u as=0.187p ps=1.78u w=0.55u l=0.13u
X1797 a_17516_9150# sg13cmos5l_buf_1_103.A VGND VGND sg13_lv_nmos ad=0.187p pd=1.78u as=0.14875p ps=1.16u w=0.55u l=0.13u
X1798 a_11434_2356# a_11877_2399# a_11817_2435# VPWR sg13_lv_pmos ad=79.8f pd=0.8u as=63f ps=0.72u w=0.42u l=0.13u
X1799 VPWR a_10587_4692# sg13cmos5l_nand2_1_0.B VPWR sg13_lv_pmos ad=0.3808p pd=2.92u as=0.2128p ps=1.5u w=1.12u l=0.13u
X1800 VGND a_19216_3358# a_18865_3215# VGND sg13_lv_nmos ad=79.8f pd=0.8u as=0.1428p ps=1.52u w=0.42u l=0.13u
X1801 a_7497_3138# a_7316_3460# VPWR VPWR sg13_lv_pmos ad=0.2128p pd=1.5u as=0.2387p ps=1.84u w=1.12u l=0.13u
X1802 a_11270_1626# sg13cmos5l_dfrbp_1_1.D VPWR VPWR sg13_lv_pmos ad=79.8f pd=0.8u as=0.1428p ps=1.52u w=0.42u l=0.13u
X1803 sg13cmos5l_dlhr_1_1.Q_N a_2934_4632# VPWR VPWR sg13_lv_pmos ad=0.3808p pd=2.92u as=0.1974p ps=1.5u w=1.12u l=0.13u
X1804 sg13cmos5l_dfrbp_1_12.Q_N a_7055_4261# VPWR VPWR sg13_lv_pmos ad=0.4312p pd=3.01u as=0.2639p ps=1.81u w=1.12u l=0.13u
X1805 a_2727_6380# a_2879_6432# VGND VGND sg13_lv_nmos ad=0.2516p pd=2.16u as=1.97045p ps=12.335u w=0.74u l=0.13u
X1806 a_5425_3130# a_4873_3192# VGND VGND sg13_lv_nmos ad=71.99999f pd=0.865u as=2.59257p ps=16.445u w=0.64u l=0.13u
X1807 a_2148_8440# a_2667_8447# a_3407_8797# VGND sg13_lv_nmos ad=0.3473p pd=2.71u as=0.12665p ps=1.145u w=0.74u l=0.13u
X1808 a_3574_7850# a_3676_7964# VPWR VPWR sg13_lv_pmos ad=0.2856p pd=2.36u as=0.1974p ps=1.5u w=0.84u l=0.13u
X1809 VGND sg13cmos5l_buf_1_31.X a_1672_3176# VGND sg13_lv_nmos ad=0.14875p pd=1.16u as=0.187p ps=1.78u w=0.55u l=0.13u
X1810 ph_sw[1] a_1864_9224# VPWR VPWR sg13_lv_pmos ad=0.42p pd=2.99u as=0.2114p ps=1.54u w=1.12u l=0.13u
X1811 VPWR sg13cmos5l_dfrbp_1_8.RESET_B a_8486_8874# VPWR sg13_lv_pmos ad=0.36237p pd=2.605u as=79.8f ps=0.8u w=0.42u l=0.13u
X1812 VGND a_4652_6126# sg13cmos5l_inv_1_19.A VGND sg13_lv_nmos ad=0.14875p pd=1.16u as=0.2886p ps=2.26u w=0.74u l=0.13u
X1813 a_18278_8112# a_17882_7684# a_18164_7996# VPWR sg13_lv_pmos ad=0.1008p pd=0.9u as=0.191p ps=1.44u w=0.42u l=0.13u
X1814 a_7055_4261# a_6213_3911# a_5796_3904# VPWR sg13_lv_pmos ad=0.2048p pd=1.63u as=0.34p ps=2.68u w=1u l=0.13u
X1815 a_12998_3138# sg13cmos5l_o21ai_1_0.Y VPWR VPWR sg13_lv_pmos ad=79.8f pd=0.8u as=0.1428p ps=1.52u w=0.42u l=0.13u
X1816 a_5962_8404# a_6405_8447# a_5702_8874# VGND sg13_lv_nmos ad=79.8f pd=0.8u as=0.1296p ps=1.52u w=0.42u l=0.13u
X1817 sg13cmos5l_buf_1_2.X a_15784_1664# VGND VGND sg13_lv_nmos ad=0.2886p pd=2.26u as=0.14875p ps=1.16u w=0.74u l=0.13u
X1818 sg13cmos5l_buf_8_2.X a_19227_9190# VPWR VPWR sg13_lv_pmos ad=0.2128p pd=1.5u as=0.2128p ps=1.5u w=1.12u l=0.13u
X1819 VPWR a_17961_8793# a_18486_8866# VPWR sg13_lv_pmos ad=0.1974p pd=1.5u as=0.2856p ps=2.36u w=0.84u l=0.13u
X1820 a_5710_5850# a_5452_5850# VGND VGND sg13_lv_nmos ad=0.1428p pd=1.52u as=79.8f ps=0.8u w=0.42u l=0.13u
X1821 VPWR a_9111_4666# a_9242_4660# VPWR sg13_lv_pmos ad=1.28962p pd=8.195u as=0.2856p ps=2.36u w=0.84u l=0.13u
X1822 sg13cmos5l_dlhr_1_15.D a_17108_7972# VGND VGND sg13_lv_nmos ad=0.2516p pd=2.16u as=0.1406p ps=1.12u w=0.74u l=0.13u
X1823 VPWR sg13cmos5l_dfrbp_1_6.RESET_B a_4041_2745# VPWR sg13_lv_pmos ad=0.2128p pd=1.5u as=0.2128p ps=1.5u w=1.12u l=0.13u
X1824 a_19344_6484# a_18793_6216# VPWR VPWR sg13_lv_pmos ad=0.105p pd=1.21u as=1.07253p ps=6.75u w=1u l=0.13u
X1825 a_15909_2399# sg13cmos5l_dfrbp_1_0.CLK VPWR VPWR sg13_lv_pmos ad=0.4088p pd=2.97u as=1.777p ps=11.395u w=1.12u l=0.13u
X1826 VGND a_1948_7964# sg13cmos5l_buf_1_58.A VGND sg13_lv_nmos ad=0.1406p pd=1.12u as=0.2516p ps=2.16u w=0.74u l=0.13u
X1827 a_13258_3361# a_13701_3117# a_13641_3529# VPWR sg13_lv_pmos ad=79.8f pd=0.8u as=63f ps=0.72u w=0.42u l=0.13u
X1828 VPWR VGND VPWR VPWR sg13_lv_pmos ad=0.34p pd=2.68u as=0 ps=0 w=1u l=1u
X1829 VPWR a_16751_2749# a_17008_2630# VPWR sg13_lv_pmos ad=0.2639p pd=1.81u as=79.8f ps=0.8u w=0.42u l=0.13u
X1830 sg13cmos5l_dfrbp_1_6.RESET_B cks VPWR VPWR sg13_lv_pmos ad=0.2128p pd=1.5u as=0.3808p ps=2.92u w=1.12u l=0.13u
X1831 sg13cmos5l_o21ai_1_0.B1 sg13cmos5l_nand2_1_1.A a_14458_4270# VGND sg13_lv_nmos ad=0.2516p pd=2.16u as=0.1406p ps=1.12u w=0.74u l=0.13u
X1832 a_5132_3864# sg13cmos5l_buf_1_44.A VPWR VPWR sg13_lv_pmos ad=0.2856p pd=2.36u as=0.2114p ps=1.54u w=0.84u l=0.13u
X1833 VGND sg13cmos5l_dfrbp_1_8.RESET_B a_6180_4650# VGND sg13_lv_nmos ad=0.1626p pd=1.415u as=60.89999f ps=0.71u w=0.42u l=0.13u
X1834 a_15500_9150# sg13cmos5l_buf_1_95.X VGND VGND sg13_lv_nmos ad=0.187p pd=1.78u as=0.14875p ps=1.16u w=0.55u l=0.13u
X1835 a_14844_7326# a_14295_7282# a_14708_6924# VGND sg13_lv_nmos ad=47.25f pd=0.645u as=0.141p ps=1.17u w=0.42u l=0.13u
X1836 a_3856_3358# a_3599_3215# a_4018_3138# VGND sg13_lv_nmos ad=0.1428p pd=1.52u as=37.8f ps=0.6u w=0.42u l=0.13u
X1837 VPWR a_18363_4270# sg13cmos5l_or2_1_0.A VPWR sg13_lv_pmos ad=0.2128p pd=1.5u as=0.2128p ps=1.5u w=1.12u l=0.13u
X1838 VGND a_3574_7850# sg13cmos5l_dlhr_1_9.Q_N VGND sg13_lv_nmos ad=0.1491p pd=1.18u as=0.2516p ps=2.16u w=0.74u l=0.13u
X1839 a_18580_7660# a_18164_7996# a_18345_7674# VGND sg13_lv_nmos ad=77.7f pd=0.95u as=0.2516p ps=2.16u w=0.74u l=0.13u
X1840 sg13cmos5l_dfrbp_1_1.Q_N a_12815_1703# VPWR VPWR sg13_lv_pmos ad=0.4312p pd=3.01u as=0.2639p ps=1.81u w=1.12u l=0.13u
X1841 VGND sg13cmos5l_dfrbp_1_10.Q a_4873_3192# VGND sg13_lv_nmos ad=0.15055p pd=1.17u as=0.187p ps=1.78u w=0.55u l=0.13u
X1842 a_13977_6477# a_13035_6284# a_13775_6239# VPWR sg13_lv_pmos ad=93.45f pd=0.865u as=0.2048p ps=1.63u w=0.42u l=0.13u
X1843 sg13cmos5l_dlhr_1_0.D a_7316_2388# VPWR VPWR sg13_lv_pmos ad=0.3808p pd=2.92u as=0.2128p ps=1.5u w=1.12u l=0.13u
X1844 VPWR cks sg13cmos5l_dfrbp_1_0.RESET_B VPWR sg13_lv_pmos ad=0.3808p pd=2.92u as=0.3808p ps=2.92u w=1.12u l=0.13u
X1845 a_11268_2826# sg13cmos5l_dfrbp_1_4.D a_11174_2826# VGND sg13_lv_nmos ad=60.89999f pd=0.71u as=0.1428p ps=1.52u w=0.42u l=0.13u
X1846 a_16271_7751# a_15429_7653# a_15012_7992# VPWR sg13_lv_pmos ad=0.2048p pd=1.63u as=0.34p ps=2.68u w=1u l=0.13u
X1847 VGND sg13cmos5l_dfrbp_1_6.RESET_B a_5028_2826# VGND sg13_lv_nmos ad=0.1626p pd=1.415u as=60.89999f ps=0.71u w=0.42u l=0.13u
X1848 VGND sg13cmos5l_buf_1_89.A a_15208_6200# VGND sg13_lv_nmos ad=0.14875p pd=1.16u as=0.187p ps=1.78u w=0.55u l=0.13u
X1849 VPWR sg13cmos5l_buf_1_74.X a_6568_9224# VPWR sg13_lv_pmos ad=0.2114p pd=1.54u as=0.2856p ps=2.36u w=0.84u l=0.13u
X1850 sg13cmos5l_o21ai_1_0.Y sg13cmos5l_o21ai_1_0.B1 a_12022_3134# VGND sg13_lv_nmos ad=0.2516p pd=2.16u as=0.1406p ps=1.12u w=0.74u l=0.15u
X1851 a_14916_8861# a_15147_8447# a_14602_8404# VGND sg13_lv_nmos ad=0.2373p pd=1.97u as=79.8f ps=0.8u w=0.42u l=0.13u
X1852 VGND VPWR VGND VGND sg13_lv_nmos ad=0.1428p pd=1.52u as=0 ps=0 w=0.42u l=1u
X1853 sg13cmos5l_dlhr_1_9.D a_2804_5412# VGND VGND sg13_lv_nmos ad=0.2516p pd=2.16u as=0.1406p ps=1.12u w=0.74u l=0.13u
X1854 sg13cmos5l_dlhr_1_14.Q_N a_14166_7656# VGND VGND sg13_lv_nmos ad=0.2516p pd=2.16u as=0.1491p ps=1.18u w=0.74u l=0.13u
X1855 a_17712_8436# a_17161_8794# VPWR VPWR sg13_lv_pmos ad=0.105p pd=1.21u as=1.15047p ps=7.175u w=1u l=0.13u
X1856 a_3664_8678# sg13cmos5l_dfrbp_1_8.RESET_B VPWR VPWR sg13_lv_pmos ad=79.8f pd=0.8u as=1.12242p ps=7u w=0.42u l=0.13u
X1857 a_16548_6175# a_16779_6284# a_16234_6385# VGND sg13_lv_nmos ad=0.2373p pd=1.97u as=79.8f ps=0.8u w=0.42u l=0.13u
X1858 a_8390_6924# a_7994_7288# a_8276_6924# VPWR sg13_lv_pmos ad=0.1008p pd=0.9u as=0.191p ps=1.44u w=0.42u l=0.13u
X1859 VPWR sg13cmos5l_dlhr_1_11.D a_12361_7282# VPWR sg13_lv_pmos ad=1.07253p pd=6.75u as=0.2856p ps=2.36u w=0.84u l=0.13u
X1860 a_3856_3358# sg13cmos5l_dfrbp_1_6.RESET_B VPWR VPWR sg13_lv_pmos ad=79.8f pd=0.8u as=1.38655p ps=8.8u w=0.42u l=0.13u
X1861 VGND a_9260_2352# nh_sw[4] VGND sg13_lv_nmos ad=0.14875p pd=1.16u as=0.2886p ps=2.26u w=0.74u l=0.13u
X1862 nh_sw[1] a_2824_2388# VPWR VPWR sg13_lv_pmos ad=0.42p pd=2.99u as=0.2114p ps=1.54u w=1.12u l=0.13u
X1863 VGND sg13cmos5l_dfrbp_1_6.RESET_B a_5604_4338# VGND sg13_lv_nmos ad=0.1626p pd=1.415u as=60.89999f ps=0.71u w=0.42u l=0.13u
X1864 VGND a_16677_6141# a_16779_6284# VGND sg13_lv_nmos ad=1.97045p pd=12.335u as=0.2516p ps=2.16u w=0.74u l=0.13u
X1865 VPWR a_10665_7281# a_10598_6924# VPWR sg13_lv_pmos ad=0.2387p pd=1.84u as=0.1008p ps=0.9u w=0.42u l=0.13u
X1866 VGND sg13cmos5l_dfrbp_1_8.RESET_B a_15684_4650# VGND sg13_lv_nmos ad=0.1626p pd=1.415u as=60.89999f ps=0.71u w=0.42u l=0.13u
X1867 VPWR sg13cmos5l_dfrbp_1_8.RESET_B a_5452_5850# VPWR sg13_lv_pmos ad=1.2517p pd=7.955u as=79.8f ps=0.8u w=0.42u l=0.13u
X1868 a_7644_1662# a_7095_1642# a_7508_1948# VGND sg13_lv_nmos ad=47.25f pd=0.645u as=0.141p ps=1.17u w=0.42u l=0.13u
X1869 a_3826_4338# sg13cmos5l_dfrbp_1_8.RESET_B VGND VGND sg13_lv_nmos ad=37.8f pd=0.6u as=79.8f ps=0.8u w=0.42u l=0.13u
X1870 a_8784_6484# a_8233_6216# VPWR VPWR sg13_lv_pmos ad=0.105p pd=1.21u as=1.07253p ps=6.75u w=1u l=0.13u
X1871 sg13cmos5l_inv_1_9.Y cks VGND VGND sg13_lv_nmos ad=0.2516p pd=2.16u as=0.2516p ps=2.16u w=0.74u l=0.13u
X1872 a_8204_2352# sg13cmos5l_dlhr_1_2.Q VPWR VPWR sg13_lv_pmos ad=0.2856p pd=2.36u as=0.2114p ps=1.54u w=0.84u l=0.13u
X1873 VGND a_9189_8447# a_9291_8447# VGND sg13_lv_nmos ad=2.92392p pd=18.89u as=0.2516p ps=2.16u w=0.74u l=0.13u
X1874 a_9457_4642# a_8905_4704# VGND VGND sg13_lv_nmos ad=71.99999f pd=0.865u as=2.41737p ps=15.64u w=0.64u l=0.13u
X1875 a_16089_8559# a_15147_8447# a_15887_8797# VPWR sg13_lv_pmos ad=93.45f pd=0.865u as=0.2048p ps=1.63u w=0.42u l=0.13u
X1876 a_15850_4873# a_16293_4629# a_15590_4650# VGND sg13_lv_nmos ad=79.8f pd=0.8u as=0.1296p ps=1.52u w=0.42u l=0.13u
X1877 a_8276_6924# a_7994_7288# a_8209_7326# VGND sg13_lv_nmos ad=0.141p pd=1.17u as=71.99999f ps=0.865u w=0.64u l=0.13u
X1878 sg13cmos5l_buf_1_56.A a_9033_6162# VPWR VPWR sg13_lv_pmos ad=0.3808p pd=2.92u as=0.2128p ps=1.5u w=1.12u l=0.13u
X1879 a_6214_8861# sg13cmos5l_dfrbp_1_8.RESET_B VGND VGND sg13_lv_nmos ad=37.8f pd=0.6u as=0.1701p ps=1.65u w=0.42u l=0.13u
X1880 VPWR sg13cmos5l_dfrbp_1_6.RESET_B a_18345_7674# VPWR sg13_lv_pmos ad=0.2128p pd=1.5u as=0.2128p ps=1.5u w=1.12u l=0.13u
X1881 VPWR a_14889_7281# a_15414_7354# VPWR sg13_lv_pmos ad=0.1974p pd=1.5u as=0.2856p ps=2.36u w=0.84u l=0.13u
X1882 a_19216_3358# sg13cmos5l_dfrbp_1_0.RESET_B VPWR VPWR sg13_lv_pmos ad=79.8f pd=0.8u as=1.38655p ps=8.8u w=0.42u l=0.13u
X1883 a_3212_1590# sg13cmos5l_buf_1_41.A VGND VGND sg13_lv_nmos ad=0.187p pd=1.78u as=0.14875p ps=1.16u w=0.55u l=0.13u
X1884 a_10618_3142# sg13cmos5l_nand2_1_0.A VGND VGND sg13_lv_nmos ad=0.1406p pd=1.12u as=0.2516p ps=2.16u w=0.74u l=0.13u
X1885 sg13cmos5l_buf_1_26.A sg13cmos5l_buf_1_45.X VPWR VPWR sg13_lv_pmos ad=0.3808p pd=2.92u as=0.3808p ps=2.92u w=1.12u l=0.13u
X1886 a_3407_8797# a_2565_8447# a_3313_8797# VGND sg13_lv_nmos ad=0.12665p pd=1.145u as=0.1428p ps=1.52u w=0.42u l=0.13u
X1887 VGND a_18671_1703# a_19508_1924# VGND sg13_lv_nmos ad=0.1406p pd=1.12u as=0.2516p ps=2.16u w=0.74u l=0.13u
X1888 VGND a_10288_8678# a_9937_8797# VGND sg13_lv_nmos ad=79.8f pd=0.8u as=0.1428p ps=1.52u w=0.42u l=0.13u
X1889 a_5702_8874# a_6507_8447# a_5962_8404# VPWR sg13_lv_pmos ad=0.1428p pd=1.52u as=79.8f ps=0.8u w=0.42u l=0.13u
X1890 a_516_5850# sg13cmos5l_dfrbp_1_6.D a_422_5850# VGND sg13_lv_nmos ad=60.89999f pd=0.71u as=0.1428p ps=1.52u w=0.42u l=0.13u
X1891 VGND a_13391_9263# a_14228_9484# VGND sg13_lv_nmos ad=0.1406p pd=1.12u as=0.2516p ps=2.16u w=0.74u l=0.13u
X1892 a_2505_8483# a_2148_8440# VPWR VPWR sg13_lv_pmos ad=63f pd=0.72u as=0.1563p ps=1.22u w=0.42u l=0.13u
X1893 VGND a_3599_3215# a_4436_3436# VGND sg13_lv_nmos ad=0.1406p pd=1.12u as=0.2516p ps=2.16u w=0.74u l=0.13u
X1894 VPWR sg13cmos5l_dfrbp_1_8.RESET_B a_15850_4873# VPWR sg13_lv_pmos ad=0.1563p pd=1.22u as=0.147p ps=1.54u w=0.42u l=0.13u
X1895 sg13cmos5l_a22oi_1_2.B2 sg13cmos5l_a221oi_1_0.C1 a_10420_5760# VGND sg13_lv_nmos ad=0.2516p pd=2.16u as=0.1406p ps=1.12u w=0.74u l=0.13u
X1896 VGND sg13cmos5l_inv_1_8.A a_5951_5383# VGND sg13_lv_nmos ad=1.88087p pd=11.775u as=0.2516p ps=2.16u w=0.74u l=0.13u
X1897 VGND a_18860_6888# ph_sw[9] VGND sg13_lv_nmos ad=0.14875p pd=1.16u as=0.2886p ps=2.26u w=0.74u l=0.13u
X1898 VGND a_14032_6382# a_13681_6239# VGND sg13_lv_nmos ad=79.8f pd=0.8u as=0.1428p ps=1.52u w=0.42u l=0.13u
X1899 a_6086_4650# a_6891_4772# a_6346_4873# VPWR sg13_lv_pmos ad=0.1428p pd=1.52u as=79.8f ps=0.8u w=0.42u l=0.13u
X1900 VGND a_12815_4261# a_13652_3900# VGND sg13_lv_nmos ad=0.1406p pd=1.12u as=0.2516p ps=2.16u w=0.74u l=0.13u
X1901 a_996_7349# a_1227_6935# a_682_6892# VGND sg13_lv_nmos ad=0.2373p pd=1.97u as=79.8f ps=0.8u w=0.42u l=0.13u
X1902 a_8588_3864# sg13cmos5l_buf_1_46.A VGND VGND sg13_lv_nmos ad=0.187p pd=1.78u as=0.14875p ps=1.16u w=0.55u l=0.13u
X1903 sg13cmos5l_buf_1_10.A a_11848_8436# VGND VGND sg13_lv_nmos ad=0.2886p pd=2.26u as=0.14875p ps=1.16u w=0.74u l=0.13u
X1904 sg13cmos5l_dlhr_1_21.Q_N a_10998_9168# VPWR VPWR sg13_lv_pmos ad=0.3808p pd=2.92u as=0.1974p ps=1.5u w=1.12u l=0.13u
X1905 sg13cmos5l_buf_1_18.A sg13cmos5l_buf_1_111.A VGND VGND sg13_lv_nmos ad=0.2516p pd=2.16u as=0.2516p ps=2.16u w=0.74u l=0.13u
X1906 VGND a_9111_4666# a_9242_4660# VGND sg13_lv_nmos ad=2.41737p pd=15.64u as=0.2775p ps=2.23u w=0.74u l=0.13u
X1907 a_1862_8874# sg13cmos5l_dfrbp_1_17.D VPWR VPWR sg13_lv_pmos ad=79.8f pd=0.8u as=0.1428p ps=1.52u w=0.42u l=0.13u
X1908 a_8746_8404# a_9189_8447# a_8486_8874# VGND sg13_lv_nmos ad=79.8f pd=0.8u as=0.1296p ps=1.52u w=0.42u l=0.13u
X1909 a_10331_3900# sg13cmos5l_a221oi_1_0.C1 VPWR VPWR sg13_lv_pmos ad=0.3808p pd=2.92u as=0.2128p ps=1.5u w=1.12u l=0.13u
X1910 sg13cmos5l_inv_1_1.A a_15208_6200# VPWR VPWR sg13_lv_pmos ad=0.42p pd=2.99u as=0.2114p ps=1.54u w=1.12u l=0.13u
X1911 sg13cmos5l_dfrbp_1_21.Q_N a_17519_6239# VPWR VPWR sg13_lv_pmos ad=0.4312p pd=3.01u as=0.2639p ps=1.81u w=1.12u l=0.13u
X1912 VGND a_6117_6141# a_6219_6284# VGND sg13_lv_nmos ad=1.97045p pd=12.335u as=0.2516p ps=2.16u w=0.74u l=0.13u
X1913 VPWR sg13cmos5l_nor2_1_0.A sg13cmos5l_a22oi_1_0.B1 VPWR sg13_lv_pmos ad=0.3808p pd=2.92u as=0.2128p ps=1.5u w=1.12u l=0.13u
X1914 VPWR sg13cmos5l_inv_1_0.A a_11072_5347# VPWR sg13_lv_pmos ad=0.1596p pd=1.22u as=0.1596p ps=1.22u w=0.84u l=0.13u
X1915 VGND a_13641_7674# a_14166_7656# VGND sg13_lv_nmos ad=0.1491p pd=1.18u as=0.187p ps=1.78u w=0.55u l=0.13u
X1916 a_5220_2392# a_5194_2356# VPWR VPWR sg13_lv_pmos ad=0.34p pd=2.68u as=0.36237p ps=2.605u w=1u l=0.13u
X1917 a_7095_1642# sg13cmos5l_dlhr_1_0.GATE VPWR VPWR sg13_lv_pmos ad=0.3234p pd=2.45u as=1.777p ps=11.395u w=0.84u l=0.13u
X1918 a_20492_8400# sg13cmos5l_buf_1_104.X VPWR VPWR sg13_lv_pmos ad=0.2856p pd=2.36u as=0.2114p ps=1.54u w=0.84u l=0.13u
X1919 VGND sg13cmos5l_dfrbp_1_6.RESET_B a_19444_5800# VGND sg13_lv_nmos ad=0.1406p pd=1.12u as=77.7f ps=0.95u w=0.74u l=0.13u
X1920 a_1997_6126# a_2727_6380# a_2638_6477# VPWR sg13_lv_pmos ad=0.2048p pd=1.63u as=93.45f ps=0.865u w=0.42u l=0.13u
X1921 a_11844_4325# a_11556_3904# a_11782_4325# VGND sg13_lv_nmos ad=0.1428p pd=1.52u as=37.8f ps=0.6u w=0.42u l=0.13u
X1922 sg13cmos5l_dfrbp_1_9.Q a_4244_3900# VGND VGND sg13_lv_nmos ad=0.2516p pd=2.16u as=0.1406p ps=1.12u w=0.74u l=0.13u
X1923 sg13cmos5l_buf_1_89.A a_14889_7281# VPWR VPWR sg13_lv_pmos ad=0.3808p pd=2.92u as=0.2128p ps=1.5u w=1.12u l=0.13u
X1924 a_11372_3102# sg13cmos5l_buf_1_9.A VPWR VPWR sg13_lv_pmos ad=0.2856p pd=2.36u as=0.2114p ps=1.54u w=0.84u l=0.13u
X1925 VGND sg13cmos5l_buf_1_10.A a_12520_3176# VGND sg13_lv_nmos ad=0.14875p pd=1.16u as=0.187p ps=1.78u w=0.55u l=0.13u
X1926 VGND a_7888_4870# a_7537_4727# VGND sg13_lv_nmos ad=79.8f pd=0.8u as=0.1428p ps=1.52u w=0.42u l=0.13u
X1927 a_2169_7047# a_1227_6935# a_1967_7285# VPWR sg13_lv_pmos ad=93.45f pd=0.865u as=0.2048p ps=1.63u w=0.42u l=0.13u
X1928 a_14640_6924# a_14089_7282# VPWR VPWR sg13_lv_pmos ad=0.105p pd=1.21u as=1.07253p ps=6.75u w=1u l=0.13u
X1929 VGND sg13cmos5l_dfrbp_1_8.RESET_B a_5796_8874# VGND sg13_lv_nmos ad=0.1626p pd=1.415u as=60.89999f ps=0.71u w=0.42u l=0.13u
X1930 a_11567_7751# a_10725_7653# a_11473_7751# VGND sg13_lv_nmos ad=0.12665p pd=1.145u as=0.1428p ps=1.52u w=0.42u l=0.13u
X1931 VPWR sg13cmos5l_inv_1_18.A sg13cmos5l_buf_1_28.A VPWR sg13_lv_pmos ad=0.3808p pd=2.92u as=0.3808p ps=2.92u w=1.12u l=0.13u
X1932 sg13cmos5l_dlhr_1_3.Q_N a_4566_2818# VGND VGND sg13_lv_nmos ad=0.2516p pd=2.16u as=0.1491p ps=1.18u w=0.74u l=0.13u
X1933 VGND a_6736_2630# a_6385_2749# VGND sg13_lv_nmos ad=79.8f pd=0.8u as=0.1428p ps=1.52u w=0.42u l=0.13u
X1934 sg13cmos5l_dlhr_1_2.Q_N a_8022_3120# VPWR VPWR sg13_lv_pmos ad=0.3808p pd=2.92u as=0.1974p ps=1.5u w=1.12u l=0.13u
X1935 a_15045_8447# sg13cmos5l_inv_1_2.A VGND VGND sg13_lv_nmos ad=0.2516p pd=2.16u as=2.71505p ps=17.54u w=0.74u l=0.13u
X1936 VGND a_15909_2399# a_16011_2399# VGND sg13_lv_nmos ad=2.59257p pd=16.445u as=0.2516p ps=2.16u w=0.74u l=0.13u
X1937 a_12873_6553# a_12516_6480# VPWR VPWR sg13_lv_pmos ad=63f pd=0.72u as=0.1563p ps=1.22u w=0.42u l=0.13u
X1938 VPWR VGND VPWR VPWR sg13_lv_pmos ad=0.34p pd=2.68u as=0 ps=0 w=1u l=1u
X1939 a_9823_2364# sg13cmos5l_inv_1_11.Y VPWR VPWR sg13_lv_pmos ad=0.2716p pd=1.605u as=0.3808p ps=2.92u w=1.12u l=0.13u
X1940 a_10428_9222# a_9879_9202# a_10292_9508# VGND sg13_lv_nmos ad=47.25f pd=0.645u as=0.141p ps=1.17u w=0.42u l=0.13u
X1941 VPWR sg13cmos5l_nand2_1_1.A sg13cmos5l_o21ai_1_0.B1 VPWR sg13_lv_pmos ad=0.3808p pd=2.92u as=0.2128p ps=1.5u w=1.12u l=0.13u
X1942 VGND a_3669_6320# a_2748_6126# VGND sg13_lv_nmos ad=0.1626p pd=1.415u as=0.2516p ps=2.16u w=0.74u l=0.13u
X1943 VPWR VGND VPWR VPWR sg13_lv_pmos ad=0.19p pd=1.38u as=0 ps=0 w=1u l=1u
X1944 VPWR VGND VPWR VPWR sg13_lv_pmos ad=0.19p pd=1.38u as=0 ps=0 w=1u l=1u
X1945 sg13cmos5l_buf_1_28.X a_9448_1664# VPWR VPWR sg13_lv_pmos ad=0.42p pd=2.99u as=0.2114p ps=1.54u w=1.12u l=0.13u
X1946 VPWR sg13cmos5l_dfrbp_1_8.RESET_B a_12106_9409# VPWR sg13_lv_pmos ad=0.1563p pd=1.22u as=0.147p ps=1.54u w=0.42u l=0.13u
X1947 a_14583_5770# sg13cmos5l_dfrbp_1_23.CLK VGND VGND sg13_lv_nmos ad=0.2516p pd=2.16u as=0.15055p ps=1.17u w=0.74u l=0.13u
X1948 sg13cmos5l_dlhr_1_11.GATE a_10868_8436# VGND VGND sg13_lv_nmos ad=0.2516p pd=2.16u as=0.1406p ps=1.12u w=0.74u l=0.13u
X1949 VGND a_7497_3138# a_8022_3120# VGND sg13_lv_nmos ad=0.1491p pd=1.18u as=0.187p ps=1.78u w=0.55u l=0.13u
X1950 a_5546_5850# a_5069_5376# a_5452_5850# VGND sg13_lv_nmos ad=37.8f pd=0.6u as=0.1428p ps=1.52u w=0.42u l=0.13u
X1951 VGND a_12567_7282# a_12698_7288# VGND sg13_lv_nmos ad=1.49685p pd=9.6u as=0.2775p ps=2.23u w=0.74u l=0.13u
X1952 a_3669_6320# a_2727_6380# a_3530_6320# VGND sg13_lv_nmos ad=79.8f pd=0.8u as=0.2373p ps=1.97u w=0.42u l=0.13u
X1953 VPWR sg13cmos5l_dfrbp_1_0.Q a_14254_2444# VPWR sg13_lv_pmos ad=0.2618p pd=1.63u as=0.2856p ps=2.36u w=0.84u l=0.13u
X1954 a_1956_4338# sg13cmos5l_dlhr_1_1.GATE a_1862_4338# VGND sg13_lv_nmos ad=60.89999f pd=0.71u as=0.1428p ps=1.52u w=0.42u l=0.13u
X1955 a_1878_6337# a_1997_6126# VGND VGND sg13_lv_nmos ad=0.2516p pd=2.16u as=0.1406p ps=1.12u w=0.74u l=0.13u
X1956 a_14814_4292# sg13cmos5l_nand2_1_1.B VGND VGND sg13_lv_nmos ad=96.2f pd=1u as=0.2516p ps=2.16u w=0.74u l=0.13u
X1957 sg13cmos5l_buf_1_116.A a_15177_5769# VGND VGND sg13_lv_nmos ad=0.2516p pd=2.16u as=0.1406p ps=1.12u w=0.74u l=0.13u
X1958 a_12516_6480# a_12490_6385# VGND VGND sg13_lv_nmos ad=0.2516p pd=2.16u as=0.1626p ps=1.415u w=0.74u l=0.13u
X1959 a_19340_8400# sg13cmos5l_buf_1_107.X VGND VGND sg13_lv_nmos ad=0.187p pd=1.78u as=0.14875p ps=1.16u w=0.55u l=0.13u
X1960 VGND sg13cmos5l_dfrbp_1_6.RESET_B a_2644_4636# VGND sg13_lv_nmos ad=0.1406p pd=1.12u as=77.7f ps=0.95u w=0.74u l=0.13u
X1961 a_7812_7687# a_7524_7992# a_7750_7687# VGND sg13_lv_nmos ad=0.1428p pd=1.52u as=37.8f ps=0.6u w=0.42u l=0.13u
X1962 a_2224_5654# a_1967_5773# a_2386_5850# VGND sg13_lv_nmos ad=0.1428p pd=1.52u as=37.8f ps=0.6u w=0.42u l=0.13u
X1963 VPWR a_17751_7690# a_17882_7684# VPWR sg13_lv_pmos ad=1.15047p pd=7.175u as=0.2856p ps=2.36u w=0.84u l=0.13u
X1964 VPWR sg13cmos5l_dfrbp_1_6.RESET_B a_19209_5769# VPWR sg13_lv_pmos ad=0.2128p pd=1.5u as=0.2128p ps=1.5u w=1.12u l=0.13u
X1965 a_6843_5459# a_5951_5383# a_6741_5459# VPWR sg13_lv_pmos ad=63f pd=0.72u as=79.8f ps=0.8u w=0.42u l=0.13u
X1966 VPWR sg13cmos5l_buf_1_40.A sg13cmos5l_buf_1_63.A VPWR sg13_lv_pmos ad=0.3808p pd=2.92u as=0.3808p ps=2.92u w=1.12u l=0.13u
X1967 VPWR sg13cmos5l_inv_1_2.A sg13cmos5l_dfrbp_1_0.CLK VPWR sg13_lv_pmos ad=0.3808p pd=2.92u as=0.3808p ps=2.92u w=1.12u l=0.13u
X1968 sg13cmos5l_and3_1_0.X a_13324_4696# VPWR VPWR sg13_lv_pmos ad=0.3808p pd=2.92u as=0.36195p ps=1.84u w=1.12u l=0.13u
X1969 VPWR a_10071_7282# a_10202_7288# VPWR sg13_lv_pmos ad=1.07253p pd=6.75u as=0.2856p ps=2.36u w=0.84u l=0.13u
X1970 a_19028_5412# a_18615_5770# a_18960_5412# VPWR sg13_lv_pmos ad=0.191p pd=1.44u as=0.105p ps=1.21u w=1u l=0.13u
X1971 a_10427_2736# sg13cmos5l_nor2_1_0.A VGND VGND sg13_lv_nmos ad=78.39999f pd=0.885u as=0.2272p ps=1.99u w=0.64u l=0.13u
X1972 VPWR sg13cmos5l_buf_1_25.X a_4456_1664# VPWR sg13_lv_pmos ad=0.2114p pd=1.54u as=0.2856p ps=2.36u w=0.84u l=0.13u
X1973 VPWR a_8783_7751# a_9620_7972# VPWR sg13_lv_pmos ad=0.2128p pd=1.5u as=0.3864p ps=2.93u w=1.12u l=0.13u
X1974 sg13cmos5l_buf_1_9.A a_9832_1664# VPWR VPWR sg13_lv_pmos ad=0.42p pd=2.99u as=0.2114p ps=1.54u w=1.12u l=0.13u
X1975 VGND sg13cmos5l_dfrbp_1_6.RESET_B a_14820_7674# VGND sg13_lv_nmos ad=0.1626p pd=1.415u as=60.89999f ps=0.71u w=0.42u l=0.13u
X1976 VGND sg13cmos5l_inv_1_5.A a_20392_3900# VGND sg13_lv_nmos ad=0.14875p pd=1.16u as=0.187p ps=1.78u w=0.55u l=0.13u
X1977 VPWR a_1125_5423# a_1227_5423# VPWR sg13_lv_pmos ad=1.28962p pd=8.195u as=0.3864p ps=2.93u w=1.12u l=0.13u
X1978 a_2436_4325# a_2148_3904# a_2374_4325# VGND sg13_lv_nmos ad=0.1428p pd=1.52u as=37.8f ps=0.6u w=0.42u l=0.13u
X1979 sg13cmos5l_buf_8_1.A a_17972_4948# VPWR VPWR sg13_lv_pmos ad=0.3808p pd=2.92u as=0.2128p ps=1.5u w=1.12u l=0.13u
X1980 sg13cmos5l_dfrbp_1_6.RESET_B cks VPWR VPWR sg13_lv_pmos ad=0.2184p pd=1.51u as=0.2128p ps=1.5u w=1.12u l=0.13u
X1981 a_3302_4650# a_4107_4772# a_3562_4873# VPWR sg13_lv_pmos ad=0.1428p pd=1.52u as=79.8f ps=0.8u w=0.42u l=0.13u
X1982 VGND a_16268_1590# nl_sw[7] VGND sg13_lv_nmos ad=0.14875p pd=1.16u as=0.2886p ps=2.26u w=0.74u l=0.13u
X1983 a_8457_7281# a_8276_6924# VPWR VPWR sg13_lv_pmos ad=0.2128p pd=1.5u as=0.2387p ps=1.84u w=1.12u l=0.13u
X1984 sg13cmos5l_dfrbp_1_11.Q_N a_7631_4727# VGND VGND sg13_lv_nmos ad=0.2849p pd=2.25u as=0.2516p ps=2.16u w=0.74u l=0.13u
X1985 VGND a_17132_9150# ph_sw[7] VGND sg13_lv_nmos ad=0.14875p pd=1.16u as=0.2886p ps=2.26u w=0.74u l=0.13u
X1986 VGND sg13cmos5l_buf_1_73.X a_5800_9224# VGND sg13_lv_nmos ad=0.14875p pd=1.16u as=0.187p ps=1.78u w=0.55u l=0.13u
X1987 sg13cmos5l_buf_1_104.X a_19624_8436# VGND VGND sg13_lv_nmos ad=0.2886p pd=2.26u as=0.14875p ps=1.16u w=0.74u l=0.13u
X1988 ph_sw[3] a_5416_9224# VGND VGND sg13_lv_nmos ad=0.2886p pd=2.26u as=0.14875p ps=1.16u w=0.74u l=0.13u
X1989 a_3926_6175# a_2748_6126# a_3530_6320# VGND sg13_lv_nmos ad=37.8f pd=0.6u as=0.1428p ps=1.52u w=0.42u l=0.13u
X1990 a_13094_6924# a_12698_7288# a_12980_6924# VPWR sg13_lv_pmos ad=0.1008p pd=0.9u as=0.191p ps=1.44u w=0.42u l=0.13u
X1991 VGND a_6479_2749# a_7316_2388# VGND sg13_lv_nmos ad=0.1406p pd=1.12u as=0.2516p ps=2.16u w=0.74u l=0.13u
X1992 a_9705_4650# a_9524_4972# VPWR VPWR sg13_lv_pmos ad=0.2128p pd=1.5u as=0.2387p ps=1.84u w=1.12u l=0.13u
X1993 VPWR cks sg13cmos5l_dfrbp_1_6.RESET_B VPWR sg13_lv_pmos ad=0.2128p pd=1.5u as=0.2128p ps=1.5u w=1.12u l=0.13u
X1994 a_18873_1941# a_17931_1748# a_18671_1703# VPWR sg13_lv_pmos ad=93.45f pd=0.865u as=0.2048p ps=1.63u w=0.42u l=0.13u
X1995 VPWR a_1402_3864# a_1121_4166# VPWR sg13_lv_pmos ad=0.1523p pd=1.38u as=0.34p ps=2.68u w=1u l=0.5u
X1996 a_13034_5412# sg13cmos5l_nor2_1_0.A sg13cmos5l_or2_1_1.B VPWR sg13_lv_pmos ad=0.1176p pd=1.33u as=0.3808p ps=2.92u w=1.12u l=0.13u
X1997 VGND a_7863_7282# a_7994_7288# VGND sg13_lv_nmos ad=1.49685p pd=9.6u as=0.2775p ps=2.23u w=0.74u l=0.13u
X1998 a_16551_3987# a_16703_3871# VGND VGND sg13_lv_nmos ad=0.2516p pd=2.16u as=2.41737p ps=15.64u w=0.74u l=0.13u
X1999 a_7524_7992# a_7498_7897# VPWR VPWR sg13_lv_pmos ad=0.34p pd=2.68u as=0.36237p ps=2.605u w=1u l=0.13u
X2000 VPWR a_7095_1642# a_7226_1636# VPWR sg13_lv_pmos ad=1.86162p pd=11.935u as=0.2856p ps=2.36u w=0.84u l=0.13u
X2001 a_7820_2352# sg13cmos5l_dlhr_1_0.Q VPWR VPWR sg13_lv_pmos ad=0.2856p pd=2.36u as=0.2114p ps=1.54u w=0.84u l=0.13u
X2002 VGND a_10028_6126# sg13cmos5l_inv_1_18.A VGND sg13_lv_nmos ad=0.14875p pd=1.16u as=0.2886p ps=2.26u w=0.74u l=0.13u
X2003 a_4076_7624# a_4324_7996# a_4282_8112# VPWR sg13_lv_pmos ad=0.191p pd=1.44u as=0.1008p ps=0.9u w=0.42u l=0.13u
X2004 sg13cmos5l_a22oi_1_0.Y sg13cmos5l_inv_1_0.A a_10783_4292# VGND sg13_lv_nmos ad=0.2664p pd=1.46u as=0.13875p ps=1.115u w=0.74u l=0.13u
X2005 VGND VPWR VGND VGND sg13_lv_nmos ad=0.1428p pd=1.52u as=0 ps=0 w=0.42u l=1u
X2006 VPWR sg13cmos5l_dfrbp_1_6.RESET_B a_14986_7897# VPWR sg13_lv_pmos ad=0.1563p pd=1.22u as=0.147p ps=1.54u w=0.42u l=0.13u
X2007 a_2790_7996# a_2621_7636# a_2348_7624# VPWR sg13_lv_pmos ad=0.105p pd=1.21u as=0.191p ps=1.44u w=1u l=0.13u
X2008 VGND a_7055_4261# a_7892_3900# VGND sg13_lv_nmos ad=0.1406p pd=1.12u as=0.2516p ps=2.16u w=0.74u l=0.13u
X2009 a_7312_4142# a_7055_4261# a_7474_4338# VGND sg13_lv_nmos ad=0.1428p pd=1.52u as=37.8f ps=0.6u w=0.42u l=0.13u
X2010 a_17414_3138# sg13cmos5l_a22oi_1_1.Y VPWR VPWR sg13_lv_pmos ad=79.8f pd=0.8u as=0.1428p ps=1.52u w=0.42u l=0.13u
X2011 a_12489_9577# a_12132_9504# VPWR VPWR sg13_lv_pmos ad=63f pd=0.72u as=0.1563p ps=1.22u w=0.42u l=0.13u
X2012 VGND a_13072_4142# a_12721_4261# VGND sg13_lv_nmos ad=79.8f pd=0.8u as=0.1428p ps=1.52u w=0.42u l=0.13u
X2013 a_10412_6126# sg13cmos5l_dlhr_1_5.Q VPWR VPWR sg13_lv_pmos ad=0.2856p pd=2.36u as=0.2114p ps=1.54u w=0.84u l=0.13u
X2014 sg13cmos5l_dlhr_1_4.Q_N a_6198_3120# VGND VGND sg13_lv_nmos ad=0.2516p pd=2.16u as=0.1491p ps=1.18u w=0.74u l=0.13u
X2015 VGND a_12216_5728# sg13cmos5l_a221oi_1_0.B1 VGND sg13_lv_nmos ad=0.1469p pd=1.155u as=0.2516p ps=2.16u w=0.74u l=0.13u
X2016 a_7863_7282# sg13cmos5l_dlhr_1_5.GATE VPWR VPWR sg13_lv_pmos ad=0.3234p pd=2.45u as=1.04815p ps=6.595u w=0.84u l=0.13u
X2017 sg13cmos5l_dfrbp_1_18.Q_N a_7247_8797# VGND VGND sg13_lv_nmos ad=0.2849p pd=2.25u as=0.2516p ps=2.16u w=0.74u l=0.13u
X2018 a_13391_9263# a_12549_9165# a_12132_9504# VPWR sg13_lv_pmos ad=0.2048p pd=1.63u as=0.34p ps=2.68u w=1u l=0.13u
X2019 a_12716_8400# sg13cmos5l_buf_1_79.X VGND VGND sg13_lv_nmos ad=0.187p pd=1.78u as=0.14875p ps=1.16u w=0.55u l=0.13u
X2020 a_15357_1816# sg13cmos5l_dfrbp_1_0.Q VPWR VPWR sg13_lv_pmos ad=0.2856p pd=2.36u as=0.2198p ps=1.53u w=0.84u l=0.13u
X2021 VGND sg13cmos5l_inv_1_2.A sg13cmos5l_dfrbp_1_0.CLK VGND sg13_lv_nmos ad=0.2516p pd=2.16u as=0.2516p ps=2.16u w=0.74u l=0.13u
X2022 a_17938_6162# sg13cmos5l_dfrbp_1_6.RESET_B VGND VGND sg13_lv_nmos ad=37.8f pd=0.6u as=79.8f ps=0.8u w=0.42u l=0.13u
X2023 VGND a_13161_7281# a_13116_7326# VGND sg13_lv_nmos ad=0.1428p pd=1.52u as=47.25f ps=0.645u w=0.42u l=0.13u
X2024 VPWR sg13cmos5l_dfrbp_1_6.RESET_B a_4425_7281# VPWR sg13_lv_pmos ad=0.2128p pd=1.5u as=0.2128p ps=1.5u w=1.12u l=0.13u
X2025 sg13cmos5l_inv_1_7.A a_11464_8436# VGND VGND sg13_lv_nmos ad=0.2886p pd=2.26u as=0.14875p ps=1.16u w=0.74u l=0.13u
X2026 sg13cmos5l_dlhr_1_15.Q_N a_18870_7656# VPWR VPWR sg13_lv_pmos ad=0.3808p pd=2.92u as=0.1974p ps=1.5u w=1.12u l=0.13u
X2027 a_1196_8400# sg13cmos5l_buf_1_63.A VGND VGND sg13_lv_nmos ad=0.187p pd=1.78u as=0.14875p ps=1.16u w=0.55u l=0.13u
X2028 a_13072_1846# a_12815_1703# a_13234_1626# VGND sg13_lv_nmos ad=0.1428p pd=1.52u as=37.8f ps=0.6u w=0.42u l=0.13u
X2029 a_13486_5412# sg13cmos5l_or2_1_1.B a_13698_5412# VPWR sg13_lv_pmos ad=0.2128p pd=1.5u as=0.3808p ps=2.92u w=1.12u l=0.13u
X2030 VPWR a_12719_2749# a_13556_2388# VPWR sg13_lv_pmos ad=0.2128p pd=1.5u as=0.3864p ps=2.93u w=1.12u l=0.13u
X2031 a_4244_6924# a_3831_7282# a_4176_6924# VPWR sg13_lv_pmos ad=0.191p pd=1.44u as=0.105p ps=1.21u w=1u l=0.13u
X2032 VGND sg13cmos5l_buf_1_3.X a_20392_3176# VGND sg13_lv_nmos ad=0.14875p pd=1.16u as=0.187p ps=1.78u w=0.55u l=0.13u
X2033 VGND a_19628_2352# nh_sw[9] VGND sg13_lv_nmos ad=0.14875p pd=1.16u as=0.2886p ps=2.26u w=0.74u l=0.13u
X2034 VPWR a_1158_3142# a_1290_3206# VPWR sg13_lv_pmos ad=0.2245p pd=1.53u as=0.445p ps=2.89u w=1u l=0.25u
X2035 a_2565_8447# sg13cmos5l_inv_1_8.A VPWR VPWR sg13_lv_pmos ad=0.4088p pd=2.97u as=1.12242p ps=7u w=1.12u l=0.13u
X2036 a_14628_8440# a_15147_8447# a_15887_8797# VGND sg13_lv_nmos ad=0.3473p pd=2.71u as=0.12665p ps=1.145u w=0.74u l=0.13u
X2037 VPWR a_1948_7964# sg13cmos5l_buf_1_58.A VPWR sg13_lv_pmos ad=0.2128p pd=1.5u as=0.3808p ps=2.92u w=1.12u l=0.13u
X2038 VGND sg13cmos5l_buf_1_18.A a_18376_2388# VGND sg13_lv_nmos ad=0.14875p pd=1.16u as=0.187p ps=1.78u w=0.55u l=0.13u
X2039 VGND a_8247_5770# a_8378_5776# VGND sg13_lv_nmos ad=1.97045p pd=12.335u as=0.2775p ps=2.23u w=0.74u l=0.13u
X2040 a_3974_2388# a_3578_2752# a_3860_2388# VPWR sg13_lv_pmos ad=0.1008p pd=0.9u as=0.191p ps=1.44u w=0.42u l=0.13u
X2041 VPWR a_2409_4650# a_2934_4632# VPWR sg13_lv_pmos ad=0.1974p pd=1.5u as=0.2856p ps=2.36u w=0.84u l=0.13u
X2042 a_2374_8861# sg13cmos5l_dfrbp_1_8.RESET_B VGND VGND sg13_lv_nmos ad=37.8f pd=0.6u as=0.1701p ps=1.65u w=0.42u l=0.13u
X2043 a_18928_1846# sg13cmos5l_dfrbp_1_0.RESET_B VPWR VPWR sg13_lv_pmos ad=79.8f pd=0.8u as=1.777p ps=11.395u w=0.42u l=0.13u
X2044 VPWR a_17516_9150# pl_sw[8] VPWR sg13_lv_pmos ad=0.2114p pd=1.54u as=0.42p ps=2.99u w=1.12u l=0.13u
X2045 VGND sg13cmos5l_dlhr_1_9.D a_10587_4692# VGND sg13_lv_nmos ad=0.14505p pd=1.15u as=0.187p ps=1.78u w=0.55u l=0.13u
X2046 a_1158_3142# a_902_3142# VGND VGND sg13_lv_nmos ad=0.1428p pd=1.52u as=0.1323p ps=1.05u w=0.42u l=0.18u
X2047 VPWR a_6572_1590# sg13cmos5l_buf_1_24.X VPWR sg13_lv_pmos ad=0.2114p pd=1.54u as=0.42p ps=2.99u w=1.12u l=0.13u
X2048 VPWR a_1580_2352# nh_sw[0] VPWR sg13_lv_pmos ad=0.2114p pd=1.54u as=0.42p ps=2.99u w=1.12u l=0.13u
X2049 VPWR sg13cmos5l_a221oi_1_0.A2 a_8041_5770# VPWR sg13_lv_pmos ad=1.28962p pd=8.195u as=0.2856p ps=2.36u w=0.84u l=0.13u
X2050 a_7833_4965# a_6891_4772# a_7631_4727# VPWR sg13_lv_pmos ad=93.45f pd=0.865u as=0.2048p ps=1.63u w=0.42u l=0.13u
X2051 pl_sw[4] a_5800_9224# VPWR VPWR sg13_lv_pmos ad=0.42p pd=2.99u as=0.2114p ps=1.54u w=1.12u l=0.13u
X2052 VGND a_17751_7690# a_17882_7684# VGND sg13_lv_nmos ad=1.49685p pd=9.6u as=0.2775p ps=2.23u w=0.74u l=0.13u
X2053 a_19828_6148# a_19412_6484# a_19593_6162# VGND sg13_lv_nmos ad=77.7f pd=0.95u as=0.2516p ps=2.16u w=0.74u l=0.13u
X2054 VGND a_15702_4187# sg13cmos5l_and3_1_0.C VGND sg13_lv_nmos ad=0.1406p pd=1.12u as=0.2516p ps=2.16u w=0.74u l=0.13u
X2055 VPWR a_6479_2749# a_6736_2630# VPWR sg13_lv_pmos ad=0.2639p pd=1.81u as=79.8f ps=0.8u w=0.42u l=0.13u
X2056 sg13cmos5l_inv_1_9.Y cks VPWR VPWR sg13_lv_pmos ad=0.3808p pd=2.92u as=0.3808p ps=2.92u w=1.12u l=0.13u
X2057 a_5508_2813# a_5739_2399# a_5194_2356# VGND sg13_lv_nmos ad=0.2373p pd=1.97u as=79.8f ps=0.8u w=0.42u l=0.13u
X2058 VPWR a_9879_9202# a_10010_9196# VPWR sg13_lv_pmos ad=4.11675p pd=27.17u as=0.2856p ps=2.36u w=0.84u l=0.13u
X2059 sg13cmos5l_buf_1_90.X a_11464_9224# VGND VGND sg13_lv_nmos ad=0.2886p pd=2.26u as=0.14875p ps=1.16u w=0.74u l=0.13u
X2060 VPWR VGND VPWR VPWR sg13_lv_pmos ad=0.34p pd=2.68u as=0 ps=0 w=1u l=1u
X2061 a_15492_2392# a_16011_2399# a_16751_2749# VGND sg13_lv_nmos ad=0.3473p pd=2.71u as=0.12665p ps=1.145u w=0.74u l=0.13u
X2062 a_2583_7710# a_1948_7964# VGND VGND sg13_lv_nmos ad=47.25f pd=0.645u as=0.1428p ps=1.52u w=0.42u l=0.13u
X2063 VPWR a_5673_3138# a_5606_3576# VPWR sg13_lv_pmos ad=0.2387p pd=1.84u as=0.1008p ps=0.9u w=0.42u l=0.13u
X2064 sg13cmos5l_dfrbp_1_5.Q_N a_16751_2749# VGND VGND sg13_lv_nmos ad=0.2849p pd=2.25u as=0.2516p ps=2.16u w=0.74u l=0.13u
X2065 a_15439_1630# a_15357_1816# sg13cmos5l_nand2_1_1.B VGND sg13_lv_nmos ad=0.1406p pd=1.12u as=0.333p ps=2.38u w=0.74u l=0.13u
X2066 sg13cmos5l_buf_1_25.A sg13cmos5l_inv_1_14.A VPWR VPWR sg13_lv_pmos ad=0.3808p pd=2.92u as=0.3808p ps=2.92u w=1.12u l=0.13u
X2067 VPWR VGND VPWR VPWR sg13_lv_pmos ad=0.34p pd=2.68u as=0 ps=0 w=1u l=1u
X2068 a_2122_8404# a_2565_8447# a_2505_8483# VPWR sg13_lv_pmos ad=79.8f pd=0.8u as=63f ps=0.72u w=0.42u l=0.13u
X2069 a_10225_9178# a_9673_9240# VGND VGND sg13_lv_nmos ad=71.99999f pd=0.865u as=2.92392p ps=18.89u w=0.64u l=0.13u
X2070 VPWR a_3447_2746# a_3578_2752# VPWR sg13_lv_pmos ad=1.86162p pd=11.935u as=0.2856p ps=2.36u w=0.84u l=0.13u
X2071 VPWR a_620_2352# nl_sw[0] VPWR sg13_lv_pmos ad=0.2114p pd=1.54u as=0.42p ps=2.99u w=1.12u l=0.13u
X2072 a_13596_7710# a_13047_7690# a_13460_7996# VGND sg13_lv_nmos ad=47.25f pd=0.645u as=0.141p ps=1.17u w=0.42u l=0.13u
X2073 VGND sg13cmos5l_dfrbp_1_23.Q_N a_14377_5770# VGND sg13_lv_nmos ad=0.15055p pd=1.17u as=0.187p ps=1.78u w=0.55u l=0.13u
X2074 VGND a_10725_7653# a_10827_7796# VGND sg13_lv_nmos ad=1.49685p pd=9.6u as=0.2516p ps=2.16u w=0.74u l=0.13u
X2075 VGND a_20012_1590# sg13cmos5l_buf_1_0.X VGND sg13_lv_nmos ad=0.14875p pd=1.16u as=0.2886p ps=2.26u w=0.74u l=0.13u
X2076 VGND sg13cmos5l_dfrbp_1_6.RESET_B a_10708_9172# VGND sg13_lv_nmos ad=0.1406p pd=1.12u as=77.7f ps=0.95u w=0.74u l=0.13u
X2077 sg13cmos5l_buf_1_46.A a_9705_4650# VGND VGND sg13_lv_nmos ad=0.2516p pd=2.16u as=0.1406p ps=1.12u w=0.74u l=0.13u
X2078 a_7504_8678# a_7247_8797# a_7666_8874# VGND sg13_lv_nmos ad=0.1428p pd=1.52u as=37.8f ps=0.6u w=0.42u l=0.13u
X2079 VPWR a_15500_9150# ph_sw[6] VPWR sg13_lv_pmos ad=0.2114p pd=1.54u as=0.42p ps=2.99u w=1.12u l=0.13u
X2080 a_2380_6162# a_1997_6126# VPWR VPWR sg13_lv_pmos ad=79.8f pd=0.8u as=0.2639p ps=1.81u w=0.42u l=0.13u
X2081 VGND a_7095_1642# a_7226_1636# VGND sg13_lv_nmos ad=7.01497p pd=46.005u as=0.2775p ps=2.23u w=0.74u l=0.13u
X2082 a_10596_7687# a_10827_7796# a_10282_7897# VGND sg13_lv_nmos ad=0.2373p pd=1.97u as=79.8f ps=0.8u w=0.42u l=0.13u
X2083 VPWR VGND VPWR VPWR sg13_lv_pmos ad=0.34p pd=2.68u as=0 ps=0 w=1u l=1u
X2084 VGND a_5673_3138# a_6198_3120# VGND sg13_lv_nmos ad=0.1491p pd=1.18u as=0.187p ps=1.78u w=0.55u l=0.13u
X2085 VGND a_2224_5654# a_1873_5773# VGND sg13_lv_nmos ad=79.8f pd=0.8u as=0.1428p ps=1.52u w=0.42u l=0.13u
X2086 VGND a_12815_1703# a_13652_1924# VGND sg13_lv_nmos ad=0.1406p pd=1.12u as=0.2516p ps=2.16u w=0.74u l=0.13u
X2087 a_13076_5376# sg13cmos5l_inv_1_0.A VPWR VPWR sg13_lv_pmos ad=0.2856p pd=2.36u as=0.2618p ps=1.63u w=0.84u l=0.13u
X2088 a_17516_9150# sg13cmos5l_buf_1_103.A VPWR VPWR sg13_lv_pmos ad=0.2856p pd=2.36u as=0.2114p ps=1.54u w=0.84u l=0.13u
X2089 sg13cmos5l_buf_1_18.A sg13cmos5l_buf_1_111.A VPWR VPWR sg13_lv_pmos ad=0.3808p pd=2.92u as=0.3808p ps=2.92u w=1.12u l=0.13u
X2090 VPWR a_18615_5770# a_18746_5776# VPWR sg13_lv_pmos ad=1.28962p pd=8.195u as=0.2856p ps=2.36u w=0.84u l=0.13u
X2091 VGND sg13cmos5l_buf_1_30.A sg13cmos5l_buf_1_73.A VGND sg13_lv_nmos ad=0.2516p pd=2.16u as=0.2516p ps=2.16u w=0.74u l=0.13u
X2092 sg13cmos5l_dfrbp_1_20.Q_N a_8783_7751# VGND VGND sg13_lv_nmos ad=0.2849p pd=2.25u as=0.2516p ps=2.16u w=0.74u l=0.13u
X2093 a_422_7362# sg13cmos5l_dfrbp_1_6.D VPWR VPWR sg13_lv_pmos ad=79.8f pd=0.8u as=0.1428p ps=1.52u w=0.42u l=0.13u
X2094 a_15357_1816# sg13cmos5l_dfrbp_1_0.Q VGND VGND sg13_lv_nmos ad=0.187p pd=1.78u as=0.14505p ps=1.15u w=0.55u l=0.13u
X2095 a_7394_5850# sg13cmos5l_dfrbp_1_8.RESET_B VGND VGND sg13_lv_nmos ad=60.89999f pd=0.71u as=0.1626p ps=1.415u w=0.42u l=0.13u
X2096 VPWR sg13cmos5l_nor2_1_1.A sg13cmos5l_nand2_1_1.B VPWR sg13_lv_pmos ad=0.2198p pd=1.53u as=0.2128p ps=1.5u w=1.12u l=0.13u
X2097 a_7248_3460# a_6697_3192# VPWR VPWR sg13_lv_pmos ad=0.105p pd=1.21u as=1.43437p ps=9.105u w=1u l=0.13u
X2098 a_620_7638# sg13cmos5l_buf_1_63.X VPWR VPWR sg13_lv_pmos ad=0.2856p pd=2.36u as=0.2114p ps=1.54u w=0.84u l=0.13u
X2099 a_5988_6175# a_6219_6284# a_5674_6385# VGND sg13_lv_nmos ad=0.2373p pd=1.97u as=79.8f ps=0.8u w=0.42u l=0.13u
X2100 VGND a_20204_5376# sg13cmos5l_inv_1_6.A VGND sg13_lv_nmos ad=0.14875p pd=1.16u as=0.2886p ps=2.26u w=0.74u l=0.13u
X2101 VPWR a_6405_8447# a_6507_8447# VPWR sg13_lv_pmos ad=1.15047p pd=7.175u as=0.3864p ps=2.93u w=1.12u l=0.13u
X2102 a_14986_7897# a_15429_7653# a_14726_7674# VGND sg13_lv_nmos ad=79.8f pd=0.8u as=0.1296p ps=1.52u w=0.42u l=0.13u
X2103 VPWR a_13161_7281# a_13686_7354# VPWR sg13_lv_pmos ad=0.1974p pd=1.5u as=0.2856p ps=2.36u w=0.84u l=0.13u
X2104 VGND VPWR VGND VGND sg13_lv_nmos ad=0.1428p pd=1.52u as=0 ps=0 w=0.42u l=1u
X2105 VPWR sg13cmos5l_inv_1_7.A a_12232_8436# VPWR sg13_lv_pmos ad=0.2114p pd=1.54u as=0.2856p ps=2.36u w=0.84u l=0.13u
X2106 VPWR sg13cmos5l_buf_1_31.X a_1672_3176# VPWR sg13_lv_pmos ad=0.2114p pd=1.54u as=0.2856p ps=2.36u w=0.84u l=0.13u
X2107 a_7888_4870# sg13cmos5l_dfrbp_1_8.RESET_B VPWR VPWR sg13_lv_pmos ad=79.8f pd=0.8u as=1.2517p ps=7.955u w=0.42u l=0.13u
X2108 a_16486_6175# sg13cmos5l_dfrbp_1_6.RESET_B VGND VGND sg13_lv_nmos ad=37.8f pd=0.6u as=0.1701p ps=1.65u w=0.42u l=0.13u
X2109 a_15590_4650# a_16395_4772# a_15850_4873# VPWR sg13_lv_pmos ad=0.1428p pd=1.52u as=79.8f ps=0.8u w=0.42u l=0.13u
X2110 VGND a_10665_7281# a_10620_7326# VGND sg13_lv_nmos ad=0.1428p pd=1.52u as=47.25f ps=0.645u w=0.42u l=0.13u
X2111 a_12230_6162# sg13cmos5l_buf_1_57.X VPWR VPWR sg13_lv_pmos ad=79.8f pd=0.8u as=0.1428p ps=1.52u w=0.42u l=0.13u
X2112 VGND sg13cmos5l_dfrbp_1_8.RESET_B a_2474_6162# VGND sg13_lv_nmos ad=79.8f pd=0.8u as=37.8f ps=0.6u w=0.42u l=0.13u
X2113 sg13cmos5l_o21ai_1_0.A1 sg13cmos5l_a221oi_1_0.C1 a_11394_4948# VPWR sg13_lv_pmos ad=0.3808p pd=2.92u as=0.2128p ps=1.5u w=1.12u l=0.13u
X2114 a_7052_9150# sg13cmos5l_inv_1_14.A VGND VGND sg13_lv_nmos ad=0.187p pd=1.78u as=0.14875p ps=1.16u w=0.55u l=0.13u
X2115 VPWR a_10220_3102# nl_sw[5] VPWR sg13_lv_pmos ad=0.2114p pd=1.54u as=0.42p ps=2.99u w=1.12u l=0.13u
X2116 VGND sg13cmos5l_dfrbp_1_6.RESET_B a_4660_7312# VGND sg13_lv_nmos ad=0.1406p pd=1.12u as=77.7f ps=0.95u w=0.74u l=0.13u
X2117 sg13cmos5l_or2_1_0.A a_18363_4270# VGND VGND sg13_lv_nmos ad=0.1406p pd=1.12u as=0.1406p ps=1.12u w=0.74u l=0.13u
X2118 a_11771_5412# sg13cmos5l_nor2b_1_0.Y sg13cmos5l_a221oi_1_0.B2 VPWR sg13_lv_pmos ad=0.2128p pd=1.5u as=0.3808p ps=2.92u w=1.12u l=0.13u
X2119 VGND sg13cmos5l_dlhr_1_1.D a_1609_4704# VGND sg13_lv_nmos ad=0.15055p pd=1.17u as=0.187p ps=1.78u w=0.55u l=0.13u
X2120 a_15887_8797# a_15045_8447# a_15793_8797# VGND sg13_lv_nmos ad=0.12665p pd=1.145u as=0.1428p ps=1.52u w=0.42u l=0.13u
X2121 sg13cmos5l_buf_1_40.X a_1192_1664# VGND VGND sg13_lv_nmos ad=0.2886p pd=2.26u as=0.14875p ps=1.16u w=0.74u l=0.13u
X2122 VPWR a_10725_7653# a_10827_7796# VPWR sg13_lv_pmos ad=1.15047p pd=7.175u as=0.3864p ps=2.93u w=1.12u l=0.13u
X2123 a_16068_6928# a_16587_6935# a_17327_7285# VGND sg13_lv_nmos ad=0.3473p pd=2.71u as=0.12665p ps=1.145u w=0.74u l=0.13u
X2124 sg13cmos5l_a22oi_1_1.B1 sg13cmos5l_nand2_1_1.B VGND VGND sg13_lv_nmos ad=0.1406p pd=1.12u as=0.2516p ps=2.16u w=0.74u l=0.13u
X2125 VPWR a_8972_3864# sg13cmos5l_buf_1_45.X VPWR sg13_lv_pmos ad=0.2114p pd=1.54u as=0.42p ps=2.99u w=1.12u l=0.13u
X2126 a_2122_3868# a_2565_3911# a_1862_4338# VGND sg13_lv_nmos ad=79.8f pd=0.8u as=0.1296p ps=1.52u w=0.42u l=0.13u
X2127 a_12490_6385# a_12933_6141# a_12873_6553# VPWR sg13_lv_pmos ad=79.8f pd=0.8u as=63f ps=0.72u w=0.42u l=0.13u
X2128 VPWR a_1967_5773# a_2224_5654# VPWR sg13_lv_pmos ad=0.2639p pd=1.81u as=79.8f ps=0.8u w=0.42u l=0.13u
X2129 a_14985_8483# a_14628_8440# VPWR VPWR sg13_lv_pmos ad=63f pd=0.72u as=0.1563p ps=1.22u w=0.42u l=0.13u
X2130 VGND sg13cmos5l_buf_1_29.A a_9832_1664# VGND sg13_lv_nmos ad=0.14875p pd=1.16u as=0.187p ps=1.78u w=0.55u l=0.13u
X2131 VGND sg13cmos5l_or2_1_0.A sg13cmos5l_nand2_1_2.B VGND sg13_lv_nmos ad=0.2516p pd=2.16u as=0.1406p ps=1.12u w=0.74u l=0.13u
X2132 VGND sg13cmos5l_buf_1_39.A a_3688_1664# VGND sg13_lv_nmos ad=0.14875p pd=1.16u as=0.187p ps=1.78u w=0.55u l=0.13u
X2133 a_17769_2017# a_17412_1944# VPWR VPWR sg13_lv_pmos ad=63f pd=0.72u as=0.1563p ps=1.22u w=0.42u l=0.13u
X2134 a_15500_9150# sg13cmos5l_buf_1_95.X VPWR VPWR sg13_lv_pmos ad=0.2856p pd=2.36u as=0.2114p ps=1.54u w=0.84u l=0.13u
X2135 a_2628_3151# a_2859_3260# a_2314_3361# VGND sg13_lv_nmos ad=0.2373p pd=1.97u as=79.8f ps=0.8u w=0.42u l=0.13u
X2136 a_12912_6924# a_12361_7282# VPWR VPWR sg13_lv_pmos ad=0.105p pd=1.21u as=1.07253p ps=6.75u w=1u l=0.13u
X2137 a_17746_7362# sg13cmos5l_dfrbp_1_8.RESET_B VGND VGND sg13_lv_nmos ad=37.8f pd=0.6u as=79.8f ps=0.8u w=0.42u l=0.13u
X2138 sg13cmos5l_buf_1_3.A a_19528_6924# VPWR VPWR sg13_lv_pmos ad=0.42p pd=2.99u as=0.2114p ps=1.54u w=1.12u l=0.13u
X2139 sg13cmos5l_buf_1_44.A a_5673_3138# VPWR VPWR sg13_lv_pmos ad=0.3808p pd=2.92u as=0.2128p ps=1.5u w=1.12u l=0.13u
X2140 sg13cmos5l_buf_1_101.X a_16264_9224# VGND VGND sg13_lv_nmos ad=0.2886p pd=2.26u as=0.14875p ps=1.16u w=0.74u l=0.13u
X2141 a_13510_3151# sg13cmos5l_dfrbp_1_0.RESET_B VGND VGND sg13_lv_nmos ad=37.8f pd=0.6u as=0.1701p ps=1.65u w=0.42u l=0.13u
X2142 a_4652_6126# sg13cmos5l_buf_1_59.A VPWR VPWR sg13_lv_pmos ad=0.2856p pd=2.36u as=0.2114p ps=1.54u w=0.84u l=0.13u
X2143 VGND a_7312_4142# a_6961_4261# VGND sg13_lv_nmos ad=79.8f pd=0.8u as=0.1428p ps=1.52u w=0.42u l=0.13u
X2144 a_16528_7894# a_16271_7751# a_16690_7674# VGND sg13_lv_nmos ad=0.1428p pd=1.52u as=37.8f ps=0.6u w=0.42u l=0.13u
X2145 VGND a_17392_4870# a_17041_4727# VGND sg13_lv_nmos ad=79.8f pd=0.8u as=0.1428p ps=1.52u w=0.42u l=0.13u
X2146 VPWR sg13cmos5l_dfrbp_1_0.RESET_B a_11434_2356# VPWR sg13_lv_pmos ad=0.1563p pd=1.22u as=0.147p ps=1.54u w=0.42u l=0.13u
X2147 VGND sg13cmos5l_or2_1_1.B a_12216_5728# VGND sg13_lv_nmos ad=0.187p pd=1.78u as=0.1045p ps=0.93u w=0.55u l=0.13u
X2148 a_17700_1639# a_17931_1748# a_17386_1849# VGND sg13_lv_nmos ad=0.2373p pd=1.97u as=79.8f ps=0.8u w=0.42u l=0.13u
X2149 a_13234_1626# sg13cmos5l_dfrbp_1_0.RESET_B VGND VGND sg13_lv_nmos ad=37.8f pd=0.6u as=79.8f ps=0.8u w=0.42u l=0.13u
X2150 sg13cmos5l_dlhr_1_11.D a_11567_7751# VPWR VPWR sg13_lv_pmos ad=0.4312p pd=3.01u as=0.2639p ps=1.81u w=1.12u l=0.13u
X2151 VPWR VGND VPWR VPWR sg13_lv_pmos ad=0.34p pd=2.68u as=0 ps=0 w=1u l=1u
X2152 VPWR a_8457_7281# a_8982_7354# VPWR sg13_lv_pmos ad=0.1974p pd=1.5u as=0.2856p ps=2.36u w=0.84u l=0.13u
X2153 VPWR a_14583_5770# a_14714_5776# VPWR sg13_lv_pmos ad=1.28962p pd=8.195u as=0.2856p ps=2.36u w=0.84u l=0.13u
X2154 VPWR sg13cmos5l_dfrbp_1_0.RESET_B a_13258_3361# VPWR sg13_lv_pmos ad=0.1563p pd=1.22u as=0.147p ps=1.54u w=0.42u l=0.13u
X2155 a_12132_9504# a_12106_9409# VGND VGND sg13_lv_nmos ad=0.2516p pd=2.16u as=0.1626p ps=1.415u w=0.74u l=0.13u
X2156 a_6380_7638# sg13cmos5l_buf_1_78.X VPWR VPWR sg13_lv_pmos ad=0.2856p pd=2.36u as=0.2114p ps=1.54u w=0.84u l=0.13u
X2157 a_7430_3576# a_7034_3148# a_7316_3460# VPWR sg13_lv_pmos ad=0.1008p pd=0.9u as=0.191p ps=1.44u w=0.42u l=0.13u
X2158 a_15849_2435# a_15492_2392# VPWR VPWR sg13_lv_pmos ad=63f pd=0.72u as=0.1563p ps=1.22u w=0.42u l=0.13u
X2159 sg13cmos5l_dfrbp_1_18.Q a_8084_8436# VPWR VPWR sg13_lv_pmos ad=0.3808p pd=2.92u as=0.2128p ps=1.5u w=1.12u l=0.13u
X2160 a_4380_7326# a_3831_7282# a_4244_6924# VGND sg13_lv_nmos ad=47.25f pd=0.645u as=0.141p ps=1.17u w=0.42u l=0.13u
X2161 a_13484_8400# sg13cmos5l_dlhr_1_11.Q VGND VGND sg13_lv_nmos ad=0.187p pd=1.78u as=0.14875p ps=1.16u w=0.55u l=0.13u
X2162 VPWR a_5820_5773# a_6843_5459# VPWR sg13_lv_pmos ad=0.1563p pd=1.22u as=63f ps=0.72u w=0.42u l=0.13u
X2163 VGND sg13cmos5l_inv_1_18.A a_9256_9224# VGND sg13_lv_nmos ad=0.14875p pd=1.16u as=0.187p ps=1.78u w=0.55u l=0.13u
X2164 a_17988_3151# a_18219_3260# a_17674_3361# VGND sg13_lv_nmos ad=0.2373p pd=1.97u as=79.8f ps=0.8u w=0.42u l=0.13u
X2165 a_14996_5412# a_14714_5776# a_14929_5814# VGND sg13_lv_nmos ad=0.141p pd=1.17u as=71.99999f ps=0.865u w=0.64u l=0.13u
X2166 VPWR sg13cmos5l_dfrbp_1_15.D a_3575_6553# VPWR sg13_lv_pmos ad=0.1428p pd=1.52u as=79.8f ps=0.8u w=0.42u l=0.13u
X2167 VGND sg13cmos5l_dlhr_1_0.D a_6889_1680# VGND sg13_lv_nmos ad=0.15055p pd=1.17u as=0.187p ps=1.78u w=0.55u l=0.13u
X2168 a_11270_4338# a_12075_3911# a_11530_3868# VPWR sg13_lv_pmos ad=0.1428p pd=1.52u as=79.8f ps=0.8u w=0.42u l=0.13u
X2169 VPWR a_19209_5769# a_19142_5412# VPWR sg13_lv_pmos ad=0.2387p pd=1.84u as=0.1008p ps=0.9u w=0.42u l=0.13u
X2170 VGND a_17519_6239# a_18356_6460# VGND sg13_lv_nmos ad=0.1406p pd=1.12u as=0.2516p ps=2.16u w=0.74u l=0.13u
X2171 a_3609_4023# a_2667_3911# a_3407_4261# VPWR sg13_lv_pmos ad=93.45f pd=0.865u as=0.2048p ps=1.63u w=0.42u l=0.13u
X2172 sg13cmos5l_dfrbp_1_20.Q a_9620_7972# VGND VGND sg13_lv_nmos ad=0.2516p pd=2.16u as=0.1406p ps=1.12u w=0.74u l=0.13u
X2173 a_12567_7282# sg13cmos5l_dlhr_1_11.GATE VPWR VPWR sg13_lv_pmos ad=0.3234p pd=2.45u as=1.07253p ps=6.75u w=0.84u l=0.13u
X2174 VGND sg13cmos5l_nor2b_1_0.Y a_10433_1652# VGND sg13_lv_nmos ad=0.2516p pd=2.16u as=0.1406p ps=1.12u w=0.74u l=0.13u
X2175 VGND a_2757_3117# a_2859_3260# VGND sg13_lv_nmos ad=2.59257p pd=16.445u as=0.2516p ps=2.16u w=0.74u l=0.13u
X2176 VGND sg13cmos5l_inv_1_19.A sg13cmos5l_buf_1_32.A VGND sg13_lv_nmos ad=0.2516p pd=2.16u as=0.2516p ps=2.16u w=0.74u l=0.13u
X2177 VGND a_20492_8400# pl_sw[10] VGND sg13_lv_nmos ad=0.14875p pd=1.16u as=0.2886p ps=2.26u w=0.74u l=0.13u
X2178 sg13cmos5l_dfrbp_1_6.RESET_B cks VGND VGND sg13_lv_nmos ad=0.1406p pd=1.12u as=0.1406p ps=1.12u w=0.74u l=0.13u
X2179 VPWR a_14900_2352# a_14858_2388# VPWR sg13_lv_pmos ad=0.2618p pd=1.63u as=0.1176p ps=1.33u w=1.12u l=0.13u
X2180 VGND sg13cmos5l_inv_1_27.Y a_14632_9224# VGND sg13_lv_nmos ad=0.14875p pd=1.16u as=0.187p ps=1.78u w=0.55u l=0.13u
X2181 a_17721_6477# a_16779_6284# a_17519_6239# VPWR sg13_lv_pmos ad=93.45f pd=0.865u as=0.2048p ps=1.63u w=0.42u l=0.13u
X2182 VGND a_6741_5459# a_5820_5773# VGND sg13_lv_nmos ad=0.1626p pd=1.415u as=0.2516p ps=2.16u w=0.74u l=0.13u
X2183 VPWR a_13047_7690# a_13178_7684# VPWR sg13_lv_pmos ad=1.15047p pd=7.175u as=0.2856p ps=2.36u w=0.84u l=0.13u
X2184 a_14916_8861# a_14628_8440# a_14854_8861# VGND sg13_lv_nmos ad=0.1428p pd=1.52u as=37.8f ps=0.6u w=0.42u l=0.13u
X2185 a_1967_7285# a_1125_6935# a_1873_7285# VGND sg13_lv_nmos ad=0.12665p pd=1.145u as=0.1428p ps=1.52u w=0.42u l=0.13u
X2186 nl_sw[1] a_1864_1664# VGND VGND sg13_lv_nmos ad=0.2886p pd=2.26u as=0.14875p ps=1.16u w=0.74u l=0.13u
X2187 VGND VPWR VGND VGND sg13_lv_nmos ad=79.8f pd=0.8u as=0 ps=0 w=0.42u l=1u
X2188 sg13cmos5l_buf_1_86.A a_20008_8436# VGND VGND sg13_lv_nmos ad=0.2886p pd=2.26u as=0.14875p ps=1.16u w=0.74u l=0.13u
X2189 a_4034_7660# sg13cmos5l_dfrbp_1_6.RESET_B VGND VGND sg13_lv_nmos ad=77.7f pd=0.95u as=0.1406p ps=1.12u w=0.74u l=0.13u
X2190 VPWR sg13cmos5l_dlhr_1_1.GATE a_4349_7636# VPWR sg13_lv_pmos ad=1.15047p pd=7.175u as=0.3234p ps=2.45u w=0.84u l=0.13u
X2191 a_3212_1590# sg13cmos5l_buf_1_41.A VPWR VPWR sg13_lv_pmos ad=0.2856p pd=2.36u as=0.2114p ps=1.54u w=0.84u l=0.13u
X2192 a_1006_4167# a_1121_4166# VGND VGND sg13_lv_nmos ad=0.1428p pd=1.52u as=0.1426p ps=1.16u w=0.42u l=0.5u
X2193 sg13cmos5l_inv_1_3.A a_13768_8436# VGND VGND sg13_lv_nmos ad=0.2886p pd=2.26u as=0.14875p ps=1.16u w=0.74u l=0.13u
X2194 VGND sg13cmos5l_dfrbp_1_0.Q a_14254_2444# VGND sg13_lv_nmos ad=0.17255p pd=1.25u as=0.187p ps=1.78u w=0.55u l=0.13u
X2195 sg13cmos5l_buf_1_19.X a_18760_2388# VGND VGND sg13_lv_nmos ad=0.2886p pd=2.26u as=0.14875p ps=1.16u w=0.74u l=0.13u
X2196 VGND sg13cmos5l_dfrbp_1_6.RESET_B a_10116_7674# VGND sg13_lv_nmos ad=0.1626p pd=1.415u as=60.89999f ps=0.71u w=0.42u l=0.13u
X2197 a_9260_2352# sg13cmos5l_buf_1_30.X VPWR VPWR sg13_lv_pmos ad=0.2856p pd=2.36u as=0.2114p ps=1.54u w=0.84u l=0.13u
X2198 a_2314_3361# a_2757_3117# a_2697_3529# VPWR sg13_lv_pmos ad=79.8f pd=0.8u as=63f ps=0.72u w=0.42u l=0.13u
X2199 VGND sg13cmos5l_dfrbp_1_6.RESET_B a_17750_4325# VGND sg13_lv_nmos ad=0.1701p pd=1.65u as=37.8f ps=0.6u w=0.42u l=0.13u
X2200 VPWR a_10031_8797# a_10868_8436# VPWR sg13_lv_pmos ad=0.2128p pd=1.5u as=0.3864p ps=2.93u w=1.12u l=0.13u
X2201 sg13cmos5l_dlhr_1_7.Q_N a_4950_7354# VPWR VPWR sg13_lv_pmos ad=0.3808p pd=2.92u as=0.1974p ps=1.5u w=1.12u l=0.13u
X2202 a_17126_1626# sg13cmos5l_dfrbp_1_0.D VPWR VPWR sg13_lv_pmos ad=79.8f pd=0.8u as=0.1428p ps=1.52u w=0.42u l=0.13u
X2203 a_3308_5376# sg13cmos5l_dlhr_1_1.Q VGND VGND sg13_lv_nmos ad=0.187p pd=1.78u as=0.14875p ps=1.16u w=0.55u l=0.13u
X2204 a_14900_2352# sg13cmos5l_nor2_1_1.A VPWR VPWR sg13_lv_pmos ad=0.2856p pd=2.36u as=0.2618p ps=1.63u w=0.84u l=0.13u
X2205 VPWR sg13cmos5l_buf_1_34.X sg13cmos5l_buf_1_60.A VPWR sg13_lv_pmos ad=0.3808p pd=2.92u as=0.3808p ps=2.92u w=1.12u l=0.13u
X2206 VGND sg13cmos5l_inv_1_8.A sg13cmos5l_inv_1_8.Y VGND sg13_lv_nmos ad=0.2516p pd=2.16u as=0.2516p ps=2.16u w=0.74u l=0.13u
X2207 a_2054_3138# sg13cmos5l_dfrbp_1_6.D VPWR VPWR sg13_lv_pmos ad=79.8f pd=0.8u as=0.1428p ps=1.52u w=0.42u l=0.13u
X2208 VGND a_19227_4654# sg13cmos5l_buf_8_0.X VGND sg13_lv_nmos ad=0.1406p pd=1.12u as=0.1406p ps=1.12u w=0.74u l=0.13u
X2209 a_3676_7964# sg13cmos5l_dfrbp_1_6.RESET_B VPWR VPWR sg13_lv_pmos ad=0.2128p pd=1.5u as=0.2128p ps=1.5u w=1.12u l=0.13u
X2210 nh_sw[3] a_5704_1664# VPWR VPWR sg13_lv_pmos ad=0.42p pd=2.99u as=0.2114p ps=1.54u w=1.12u l=0.13u
X2211 VGND a_9164_1590# sg13cmos5l_buf_1_26.X VGND sg13_lv_nmos ad=0.14875p pd=1.16u as=0.2886p ps=2.26u w=0.74u l=0.13u
X2212 a_17327_7285# a_16485_6935# a_17233_7285# VGND sg13_lv_nmos ad=0.12665p pd=1.145u as=0.1428p ps=1.52u w=0.42u l=0.13u
X2213 VPWR a_15821_3864# sg13cmos5l_dfrbp_1_6.Q_N VPWR sg13_lv_pmos ad=0.2639p pd=1.81u as=0.4312p ps=3.01u w=1.12u l=0.13u
X2214 ph_sw[10] a_20392_6924# VGND VGND sg13_lv_nmos ad=0.2886p pd=2.26u as=0.14875p ps=1.16u w=0.74u l=0.13u
X2215 sg13cmos5l_dfrbp_1_3.Q_N a_18959_3215# VGND VGND sg13_lv_nmos ad=0.2849p pd=2.25u as=0.2516p ps=2.16u w=0.74u l=0.13u
X2216 VPWR a_2757_3117# a_2859_3260# VPWR sg13_lv_pmos ad=1.43437p pd=9.105u as=0.3864p ps=2.93u w=1.12u l=0.13u
X2217 a_11817_2435# a_11460_2392# VPWR VPWR sg13_lv_pmos ad=63f pd=0.72u as=0.1563p ps=1.22u w=0.42u l=0.13u
X2218 VPWR a_17519_6239# a_17776_6382# VPWR sg13_lv_pmos ad=0.2639p pd=1.81u as=79.8f ps=0.8u w=0.42u l=0.13u
X2219 VPWR sg13cmos5l_dfrbp_1_10.Q a_4873_3192# VPWR sg13_lv_pmos ad=1.43437p pd=9.105u as=0.2856p ps=2.36u w=0.84u l=0.13u
X2220 sg13cmos5l_dlhr_1_1.Q a_2409_4650# VPWR VPWR sg13_lv_pmos ad=0.3808p pd=2.92u as=0.2128p ps=1.5u w=1.12u l=0.13u
X2221 VGND a_6959_6239# a_7796_6460# VGND sg13_lv_nmos ad=0.1406p pd=1.12u as=0.2516p ps=2.16u w=0.74u l=0.13u
X2222 VGND a_7504_8678# a_7153_8797# VGND sg13_lv_nmos ad=79.8f pd=0.8u as=0.1428p ps=1.52u w=0.42u l=0.13u
X2223 a_17674_3361# a_18117_3117# a_18057_3529# VPWR sg13_lv_pmos ad=79.8f pd=0.8u as=63f ps=0.72u w=0.42u l=0.13u
X2224 VGND a_2732_9150# sg13cmos5l_buf_1_61.X VGND sg13_lv_nmos ad=0.14875p pd=1.16u as=0.2886p ps=2.26u w=0.74u l=0.13u
X2225 VPWR a_9189_8447# a_9291_8447# VPWR sg13_lv_pmos ad=1.15047p pd=7.175u as=0.3864p ps=2.93u w=1.12u l=0.13u
X2226 VGND a_4005_4629# a_4107_4772# VGND sg13_lv_nmos ad=2.41737p pd=15.64u as=0.2516p ps=2.16u w=0.74u l=0.13u
X2227 VPWR VGND VPWR VPWR sg13_lv_pmos ad=0.34p pd=2.68u as=0 ps=0 w=1u l=1u
X2228 sg13cmos5l_inv_1_29.A a_12404_7972# VPWR VPWR sg13_lv_pmos ad=0.3808p pd=2.92u as=0.2128p ps=1.5u w=1.12u l=0.13u
X2229 VGND sg13cmos5l_dfrbp_1_23.Q a_13792_5760# VGND sg13_lv_nmos ad=0.1406p pd=1.12u as=0.1406p ps=1.12u w=0.74u l=0.13u
X2230 VGND sg13cmos5l_dfrbp_1_6.RESET_B a_18580_7660# VGND sg13_lv_nmos ad=0.1406p pd=1.12u as=77.7f ps=0.95u w=0.74u l=0.13u
X2231 a_17713_8838# a_17161_8794# VGND VGND sg13_lv_nmos ad=71.99999f pd=0.865u as=2.92392p ps=18.89u w=0.64u l=0.13u
X2232 a_15300_7687# a_15012_7992# a_15238_7687# VGND sg13_lv_nmos ad=0.1428p pd=1.52u as=37.8f ps=0.6u w=0.42u l=0.13u
X2233 a_12933_6141# sg13cmos5l_dfrbp_1_23.CLK VGND VGND sg13_lv_nmos ad=0.2516p pd=2.16u as=1.97045p ps=12.335u w=0.74u l=0.13u
X2234 sg13cmos5l_buf_1_79.X a_9256_9224# VPWR VPWR sg13_lv_pmos ad=0.42p pd=2.99u as=0.2114p ps=1.54u w=1.12u l=0.13u
X2235 VGND sg13cmos5l_inv_1_17.A sg13cmos5l_buf_1_37.A VGND sg13_lv_nmos ad=0.2516p pd=2.16u as=0.2516p ps=2.16u w=0.74u l=0.13u
X2236 pl_sw[2] a_2248_9224# VGND VGND sg13_lv_nmos ad=0.2886p pd=2.26u as=0.14875p ps=1.16u w=0.74u l=0.13u
X2237 VPWR a_9040_7894# a_8985_7989# VPWR sg13_lv_pmos ad=1.15047p pd=7.175u as=93.45f ps=0.865u w=0.42u l=0.13u
X2238 sg13cmos5l_buf_1_1.A a_14056_1664# VGND VGND sg13_lv_nmos ad=0.2886p pd=2.26u as=0.14875p ps=1.16u w=0.74u l=0.13u
X2239 VPWR a_5673_3138# a_6198_3120# VPWR sg13_lv_pmos ad=0.1974p pd=1.5u as=0.2856p ps=2.36u w=0.84u l=0.13u
X2240 a_6660_4663# a_6891_4772# a_6346_4873# VGND sg13_lv_nmos ad=0.2373p pd=1.97u as=79.8f ps=0.8u w=0.42u l=0.13u
X2241 a_6681_2511# a_5739_2399# a_6479_2749# VPWR sg13_lv_pmos ad=93.45f pd=0.865u as=0.2048p ps=1.63u w=0.42u l=0.13u
X2242 VPWR a_2732_1590# sg13cmos5l_buf_1_35.A VPWR sg13_lv_pmos ad=0.2114p pd=1.54u as=0.42p ps=2.99u w=1.12u l=0.13u
X2243 sg13cmos5l_buf_8_0.X a_19227_4654# VPWR VPWR sg13_lv_pmos ad=0.2128p pd=1.5u as=0.2128p ps=1.5u w=1.12u l=0.13u
X2244 a_18574_5028# sg13cmos5l_dfrbp_1_0.D a_18480_5028# VPWR sg13_lv_pmos ad=0.1596p pd=1.22u as=0.2856p ps=2.36u w=0.84u l=0.13u
X2245 a_16551_3987# a_16703_3871# VPWR VPWR sg13_lv_pmos ad=0.3864p pd=2.93u as=1.43437p ps=9.105u w=1.12u l=0.13u
X2246 VPWR sg13cmos5l_buf_1_10.A a_12520_3176# VPWR sg13_lv_pmos ad=0.2114p pd=1.54u as=0.2856p ps=2.36u w=0.84u l=0.13u
X2247 VPWR sg13cmos5l_o21ai_1_0.B1 sg13cmos5l_o21ai_1_0.Y VPWR sg13_lv_pmos ad=0.3808p pd=2.92u as=0.2128p ps=1.5u w=1.12u l=0.15u
X2248 VPWR a_16271_7751# a_17108_7972# VPWR sg13_lv_pmos ad=0.2128p pd=1.5u as=0.3864p ps=2.93u w=1.12u l=0.13u
X2249 VPWR a_19244_2352# nl_sw[9] VPWR sg13_lv_pmos ad=0.2114p pd=1.54u as=0.42p ps=2.99u w=1.12u l=0.13u
X2250 VGND a_908_1590# sg13cmos5l_buf_1_32.X VGND sg13_lv_nmos ad=0.14875p pd=1.16u as=0.2886p ps=2.26u w=0.74u l=0.13u
X2251 VGND VPWR VGND VGND sg13_lv_nmos ad=79.8f pd=0.8u as=0 ps=0 w=0.42u l=1u
X2252 a_17780_8436# a_17367_8794# a_17712_8436# VPWR sg13_lv_pmos ad=0.191p pd=1.44u as=0.105p ps=1.21u w=1u l=0.13u
X2253 a_15876_7362# sg13cmos5l_dfrbp_1_22.D a_15782_7362# VGND sg13_lv_nmos ad=60.89999f pd=0.71u as=0.1428p ps=1.52u w=0.42u l=0.13u
X2254 a_17916_8838# a_17367_8794# a_17780_8436# VGND sg13_lv_nmos ad=47.25f pd=0.645u as=0.141p ps=1.17u w=0.42u l=0.13u
X2255 sg13cmos5l_buf_1_93.X a_14632_9224# VPWR VPWR sg13_lv_pmos ad=0.42p pd=2.99u as=0.2114p ps=1.54u w=1.12u l=0.13u
X2256 a_2348_7624# a_2596_7996# a_2554_8112# VPWR sg13_lv_pmos ad=0.191p pd=1.44u as=0.1008p ps=0.9u w=0.42u l=0.13u
X2257 VPWR a_9705_4650# a_9638_5088# VPWR sg13_lv_pmos ad=0.2387p pd=1.84u as=0.1008p ps=0.9u w=0.42u l=0.13u
X2258 VPWR sg13cmos5l_inv_1_8.A a_5951_5383# VPWR sg13_lv_pmos ad=1.2517p pd=7.955u as=0.4088p ps=2.97u w=1.12u l=0.13u
X2259 nl_sw[2] a_2248_1664# VPWR VPWR sg13_lv_pmos ad=0.42p pd=2.99u as=0.2114p ps=1.54u w=1.12u l=0.13u
X2260 sg13cmos5l_or2_1_0.A a_18363_4270# VPWR VPWR sg13_lv_pmos ad=0.2128p pd=1.5u as=0.2128p ps=1.5u w=1.12u l=0.13u
X2261 VGND sg13cmos5l_a221oi_1_0.B2 a_11488_4676# VGND sg13_lv_nmos ad=0.1406p pd=1.12u as=0.1406p ps=1.12u w=0.74u l=0.13u
X2262 VGND sg13cmos5l_a22oi_1_1.B1 a_15062_4292# VGND sg13_lv_nmos ad=0.2553p pd=2.17u as=0.13875p ps=1.115u w=0.74u l=0.13u
X2263 VPWR a_14543_3215# a_14800_3358# VPWR sg13_lv_pmos ad=0.2639p pd=1.81u as=79.8f ps=0.8u w=0.42u l=0.13u
X2264 a_18860_6888# sg13cmos5l_buf_1_87.A VPWR VPWR sg13_lv_pmos ad=0.2856p pd=2.36u as=0.2114p ps=1.54u w=0.84u l=0.13u
X2265 a_11364_1626# sg13cmos5l_dfrbp_1_1.D a_11270_1626# VGND sg13_lv_nmos ad=60.89999f pd=0.71u as=0.1428p ps=1.52u w=0.42u l=0.13u
X2266 VGND a_20012_2352# nl_sw[10] VGND sg13_lv_nmos ad=0.14875p pd=1.16u as=0.2886p ps=2.26u w=0.74u l=0.13u
X2267 a_6086_4650# sg13cmos5l_dlhr_1_0.GATE VPWR VPWR sg13_lv_pmos ad=79.8f pd=0.8u as=0.1428p ps=1.52u w=0.42u l=0.13u
X2268 a_16748_9150# sg13cmos5l_buf_1_93.X VGND VGND sg13_lv_nmos ad=0.187p pd=1.78u as=0.14875p ps=1.16u w=0.55u l=0.13u
X2269 a_5988_8440# a_5962_8404# VGND VGND sg13_lv_nmos ad=0.2516p pd=2.16u as=0.1626p ps=1.415u w=0.74u l=0.13u
X2270 VPWR a_7247_8797# a_7504_8678# VPWR sg13_lv_pmos ad=0.2639p pd=1.81u as=79.8f ps=0.8u w=0.42u l=0.13u
X2271 a_682_5380# a_1125_5423# a_422_5850# VGND sg13_lv_nmos ad=79.8f pd=0.8u as=0.1296p ps=1.52u w=0.42u l=0.13u
X2272 sg13cmos5l_o21ai_1_0.A1 sg13cmos5l_inv_1_0.Y a_11182_4676# VGND sg13_lv_nmos ad=0.2516p pd=2.16u as=0.1406p ps=1.12u w=0.74u l=0.13u
X2273 VPWR sg13cmos5l_dfrbp_1_8.RESET_B a_5962_8404# VPWR sg13_lv_pmos ad=0.1563p pd=1.22u as=0.147p ps=1.54u w=0.42u l=0.13u
X2274 a_14726_7674# a_15531_7796# a_14986_7897# VPWR sg13_lv_pmos ad=0.1428p pd=1.52u as=79.8f ps=0.8u w=0.42u l=0.13u
X2275 sg13cmos5l_buf_1_57.X a_9448_6924# VGND VGND sg13_lv_nmos ad=0.2886p pd=2.26u as=0.14875p ps=1.16u w=0.74u l=0.13u
X2276 a_8852_6484# a_8439_6178# a_8784_6484# VPWR sg13_lv_pmos ad=0.191p pd=1.44u as=0.105p ps=1.21u w=1u l=0.13u
X2277 a_4176_6924# a_3625_7282# VPWR VPWR sg13_lv_pmos ad=0.105p pd=1.21u as=1.07253p ps=6.75u w=1u l=0.13u
X2278 a_13092_3138# sg13cmos5l_o21ai_1_0.Y a_12998_3138# VGND sg13_lv_nmos ad=60.89999f pd=0.71u as=0.1428p ps=1.52u w=0.42u l=0.13u
X2279 a_16462_4338# a_16204_4338# VGND VGND sg13_lv_nmos ad=0.1428p pd=1.52u as=79.8f ps=0.8u w=0.42u l=0.13u
X2280 VPWR sg13cmos5l_dlhr_1_12.D a_17161_8794# VPWR sg13_lv_pmos ad=1.15047p pd=7.175u as=0.2856p ps=2.36u w=0.84u l=0.13u
X2281 cko a_20392_7712# VGND VGND sg13_lv_nmos ad=0.2886p pd=2.26u as=0.14875p ps=1.16u w=0.74u l=0.13u
X2282 a_15821_3864# a_16551_3987# a_16462_4023# VPWR sg13_lv_pmos ad=0.2048p pd=1.63u as=93.45f ps=0.865u w=0.42u l=0.13u
X2283 VGND a_19227_4654# sg13cmos5l_buf_8_0.X VGND sg13_lv_nmos ad=0.1406p pd=1.12u as=0.1406p ps=1.12u w=0.74u l=0.13u
X2284 sg13cmos5l_buf_8_2.X a_19227_9190# VGND VGND sg13_lv_nmos ad=0.1406p pd=1.12u as=0.1406p ps=1.12u w=0.74u l=0.13u
X2285 sg13cmos5l_dlhr_1_0.Q_N a_8214_1608# VGND VGND sg13_lv_nmos ad=0.2516p pd=2.16u as=0.1491p ps=1.18u w=0.74u l=0.13u
X2286 a_8783_7751# a_7941_7653# a_8689_7751# VGND sg13_lv_nmos ad=0.12665p pd=1.145u as=0.1428p ps=1.52u w=0.42u l=0.13u
X2287 VPWR sg13cmos5l_dfrbp_1_8.RESET_B a_1862_4338# VPWR sg13_lv_pmos ad=0.36237p pd=2.605u as=79.8f ps=0.8u w=0.42u l=0.13u
X2288 VPWR a_6959_6239# a_7216_6382# VPWR sg13_lv_pmos ad=0.2639p pd=1.81u as=79.8f ps=0.8u w=0.42u l=0.13u
X2289 a_16294_7349# sg13cmos5l_dfrbp_1_8.RESET_B VGND VGND sg13_lv_nmos ad=37.8f pd=0.6u as=0.1701p ps=1.65u w=0.42u l=0.13u
X2290 a_12516_6480# a_13035_6284# a_13775_6239# VGND sg13_lv_nmos ad=0.3473p pd=2.71u as=0.12665p ps=1.145u w=0.74u l=0.13u
X2291 a_16528_7894# sg13cmos5l_dfrbp_1_6.RESET_B VPWR VPWR sg13_lv_pmos ad=79.8f pd=0.8u as=1.12242p ps=7u w=0.42u l=0.13u
X2292 a_8692_7312# a_8276_6924# a_8457_7281# VGND sg13_lv_nmos ad=77.7f pd=0.95u as=0.2516p ps=2.16u w=0.74u l=0.13u
X2293 a_8588_2352# sg13cmos5l_buf_1_26.X VGND VGND sg13_lv_nmos ad=0.187p pd=1.78u as=0.14875p ps=1.16u w=0.55u l=0.13u
X2294 VGND a_11973_3911# a_12075_3911# VGND sg13_lv_nmos ad=2.41737p pd=15.64u as=0.2516p ps=2.16u w=0.74u l=0.13u
X2295 VGND a_13047_7690# a_13178_7684# VGND sg13_lv_nmos ad=1.49685p pd=9.6u as=0.2775p ps=2.23u w=0.74u l=0.13u
X2296 a_11370_5760# sg13cmos5l_inv_1_0.A a_11268_5760# VGND sg13_lv_nmos ad=0.1216p pd=1.02u as=0.1216p ps=1.02u w=0.64u l=0.13u
X2297 a_5637_2399# sg13cmos5l_dlhr_1_0.GATE VPWR VPWR sg13_lv_pmos ad=0.4088p pd=2.97u as=1.777p ps=11.395u w=1.12u l=0.13u
X2298 sg13cmos5l_dfrbp_1_2.Q_N a_12815_4261# VPWR VPWR sg13_lv_pmos ad=0.4312p pd=3.01u as=0.2639p ps=1.81u w=1.12u l=0.13u
X2299 a_13486_5760# sg13cmos5l_nor2b_1_0.Y VGND VGND sg13_lv_nmos ad=0.1406p pd=1.12u as=0.2516p ps=2.16u w=0.74u l=0.13u
X2300 a_17170_2826# sg13cmos5l_dfrbp_1_0.RESET_B VGND VGND sg13_lv_nmos ad=37.8f pd=0.6u as=79.8f ps=0.8u w=0.42u l=0.13u
X2301 VGND sg13cmos5l_dfrbp_1_20.Q a_9865_7282# VGND sg13_lv_nmos ad=0.15055p pd=1.17u as=0.187p ps=1.78u w=0.55u l=0.13u
X2302 VPWR a_14924_1590# nh_sw[6] VPWR sg13_lv_pmos ad=0.2114p pd=1.54u as=0.42p ps=2.99u w=1.12u l=0.13u
X2303 a_10318_5412# sg13cmos5l_a221oi_1_0.C1 a_10420_5412# VPWR sg13_lv_pmos ad=0.3808p pd=2.92u as=0.2128p ps=1.5u w=1.12u l=0.13u
X2304 sg13cmos5l_inv_1_5.A a_19796_3436# VGND VGND sg13_lv_nmos ad=0.2516p pd=2.16u as=0.1406p ps=1.12u w=0.74u l=0.13u
X2305 sg13cmos5l_dfrbp_1_27.Q_N a_10031_8797# VGND VGND sg13_lv_nmos ad=0.2849p pd=2.25u as=0.2516p ps=2.16u w=0.74u l=0.13u
X2306 a_5079_3154# sg13cmos5l_dfrbp_1_9.Q VGND VGND sg13_lv_nmos ad=0.2516p pd=2.16u as=0.15055p ps=1.17u w=0.74u l=0.13u
X2307 a_17399_3947# sg13cmos5l_dfrbp_1_6.RESET_B VPWR VPWR sg13_lv_pmos ad=79.8f pd=0.8u as=0.36237p ps=2.605u w=0.42u l=0.13u
X2308 sg13cmos5l_dfrbp_1_11.Q_N a_7631_4727# VPWR VPWR sg13_lv_pmos ad=0.4312p pd=3.01u as=0.2639p ps=1.81u w=1.12u l=0.13u
X2309 a_15045_8447# sg13cmos5l_inv_1_2.A VPWR VPWR sg13_lv_pmos ad=0.4088p pd=2.97u as=1.12242p ps=7u w=1.12u l=0.13u
X2310 VGND a_14583_5770# a_14714_5776# VGND sg13_lv_nmos ad=1.97045p pd=12.335u as=0.2775p ps=2.23u w=0.74u l=0.13u
X2311 a_4950_5699# a_5069_5376# VGND VGND sg13_lv_nmos ad=0.2516p pd=2.16u as=0.1406p ps=1.12u w=0.74u l=0.13u
X2312 VPWR a_19227_9190# sg13cmos5l_buf_8_2.X VPWR sg13_lv_pmos ad=0.3864p pd=2.93u as=0.2128p ps=1.5u w=1.12u l=0.13u
X2313 sg13cmos5l_dlhr_1_20.Q_N a_10230_4632# VPWR VPWR sg13_lv_pmos ad=0.3808p pd=2.92u as=0.1974p ps=1.5u w=1.12u l=0.13u
X2314 VGND sg13cmos5l_inv_1_6.A sg13cmos5l_buf_1_0.A VGND sg13_lv_nmos ad=0.2516p pd=2.16u as=0.2516p ps=2.16u w=0.74u l=0.13u
X2315 VPWR a_16144_8678# a_16089_8559# VPWR sg13_lv_pmos ad=1.15047p pd=7.175u as=93.45f ps=0.865u w=0.42u l=0.13u
X2316 sg13cmos5l_buf_1_5.X a_14440_1664# VPWR VPWR sg13_lv_pmos ad=0.42p pd=2.99u as=0.2114p ps=1.54u w=1.12u l=0.13u
X2317 a_14854_8861# sg13cmos5l_dfrbp_1_8.RESET_B VGND VGND sg13_lv_nmos ad=37.8f pd=0.6u as=0.1701p ps=1.65u w=0.42u l=0.13u
X2318 VPWR sg13cmos5l_buf_1_30.A sg13cmos5l_buf_1_73.A VPWR sg13_lv_pmos ad=0.3808p pd=2.92u as=0.3808p ps=2.92u w=1.12u l=0.13u
X2319 a_2169_5535# a_1227_5423# a_1967_5773# VPWR sg13_lv_pmos ad=93.45f pd=0.865u as=0.2048p ps=1.63u w=0.42u l=0.13u
X2320 sg13cmos5l_dlhr_1_21.Q_N a_10998_9168# VGND VGND sg13_lv_nmos ad=0.2516p pd=2.16u as=0.1491p ps=1.18u w=0.74u l=0.13u
X2321 VPWR sg13cmos5l_buf_1_73.X a_5800_9224# VPWR sg13_lv_pmos ad=0.2114p pd=1.54u as=0.2856p ps=2.36u w=0.84u l=0.13u
X2322 VPWR sg13cmos5l_dfrbp_1_23.Q_N a_14377_5770# VPWR sg13_lv_pmos ad=1.28962p pd=8.195u as=0.2856p ps=2.36u w=0.84u l=0.13u
X2323 VGND sg13cmos5l_dfrbp_1_6.RESET_B a_516_7362# VGND sg13_lv_nmos ad=0.1626p pd=1.415u as=60.89999f ps=0.71u w=0.42u l=0.13u
X2324 a_17829_1605# sg13cmos5l_dfrbp_1_0.CLK VGND VGND sg13_lv_nmos ad=0.2516p pd=2.16u as=5.84582p ps=38.34u w=0.74u l=0.13u
X2325 VGND a_7216_6382# a_6865_6239# VGND sg13_lv_nmos ad=79.8f pd=0.8u as=0.1428p ps=1.52u w=0.42u l=0.13u
X2326 VGND sg13cmos5l_buf_8_0.A a_19227_4654# VGND sg13_lv_nmos ad=0.1406p pd=1.12u as=0.1406p ps=1.12u w=0.74u l=0.13u
X2327 VPWR sg13cmos5l_dfrbp_1_8.RESET_B a_5702_8874# VPWR sg13_lv_pmos ad=0.36237p pd=2.605u as=79.8f ps=0.8u w=0.42u l=0.13u
X2328 a_12804_6175# a_13035_6284# a_12490_6385# VGND sg13_lv_nmos ad=0.2373p pd=1.97u as=79.8f ps=0.8u w=0.42u l=0.13u
X2329 a_18860_9150# sg13cmos5l_buf_1_101.X VGND VGND sg13_lv_nmos ad=0.187p pd=1.78u as=0.14875p ps=1.16u w=0.55u l=0.13u
X2330 VGND a_19209_5769# a_19164_5814# VGND sg13_lv_nmos ad=0.1428p pd=1.52u as=47.25f ps=0.645u w=0.42u l=0.13u
X2331 a_11873_5760# sg13cmos5l_inv_1_29.Y sg13cmos5l_a221oi_1_0.B2 VGND sg13_lv_nmos ad=0.1406p pd=1.12u as=0.1406p ps=1.12u w=0.74u l=0.13u
X2332 VGND sg13cmos5l_nand2_1_1.A a_20008_3900# VGND sg13_lv_nmos ad=0.14875p pd=1.16u as=0.187p ps=1.78u w=0.55u l=0.13u
X2333 a_11980_4948# sg13cmos5l_inv_1_0.A sg13cmos5l_a221oi_1_0.C1 VPWR sg13_lv_pmos ad=0.1176p pd=1.33u as=0.3808p ps=2.92u w=1.12u l=0.13u
X2334 VPWR a_8841_5769# a_9366_5842# VPWR sg13_lv_pmos ad=0.1974p pd=1.5u as=0.2856p ps=2.36u w=0.84u l=0.13u
X2335 VGND a_7497_3138# a_7452_3174# VGND sg13_lv_nmos ad=0.1428p pd=1.52u as=47.25f ps=0.645u w=0.42u l=0.13u
X2336 VGND VPWR VGND VGND sg13_lv_nmos ad=79.8f pd=0.8u as=0 ps=0 w=0.42u l=1u
X2337 sg13cmos5l_buf_1_97.A a_10473_9186# VPWR VPWR sg13_lv_pmos ad=0.3808p pd=2.92u as=0.2128p ps=1.5u w=1.12u l=0.13u
X2338 VPWR a_11877_2399# a_11979_2399# VPWR sg13_lv_pmos ad=1.86162p pd=11.935u as=0.3864p ps=2.93u w=1.12u l=0.13u
X2339 VPWR sg13cmos5l_dlygate4sd2_1_0.A a_902_3142# VPWR sg13_lv_pmos ad=0.2481p pd=1.56u as=0.1428p ps=1.52u w=0.42u l=0.13u
X2340 VGND a_7247_8797# a_8084_8436# VGND sg13_lv_nmos ad=0.1406p pd=1.12u as=0.2516p ps=2.16u w=0.74u l=0.13u
X2341 sg13cmos5l_o21ai_1_0.A2 sg13cmos5l_nand2_1_0.A a_11002_3142# VGND sg13_lv_nmos ad=0.2516p pd=2.16u as=0.1406p ps=1.12u w=0.74u l=0.13u
X2342 a_16260_6480# a_16234_6385# VGND VGND sg13_lv_nmos ad=0.2516p pd=2.16u as=0.1626p ps=1.415u w=0.74u l=0.13u
X2343 a_3876_4663# a_4107_4772# a_3562_4873# VGND sg13_lv_nmos ad=0.2373p pd=1.97u as=79.8f ps=0.8u w=0.42u l=0.13u
X2344 VGND sg13cmos5l_dfrbp_1_8.RESET_B a_3396_4650# VGND sg13_lv_nmos ad=0.1626p pd=1.415u as=60.89999f ps=0.71u w=0.42u l=0.13u
X2345 a_11913_2017# a_11556_1944# VPWR VPWR sg13_lv_pmos ad=63f pd=0.72u as=0.1563p ps=1.22u w=0.42u l=0.13u
X2346 a_4076_5376# sg13cmos5l_dlhr_1_9.Q VGND VGND sg13_lv_nmos ad=0.187p pd=1.78u as=0.14875p ps=1.16u w=0.55u l=0.13u
X2347 VGND a_6789_4629# a_6891_4772# VGND sg13_lv_nmos ad=2.41737p pd=15.64u as=0.2516p ps=2.16u w=0.74u l=0.13u
X2348 VGND a_7689_1626# a_8214_1608# VGND sg13_lv_nmos ad=0.1491p pd=1.18u as=0.187p ps=1.78u w=0.55u l=0.13u
X2349 sg13cmos5l_buf_8_0.X a_19227_4654# VPWR VPWR sg13_lv_pmos ad=0.2128p pd=1.5u as=0.2128p ps=1.5u w=1.12u l=0.13u
X2350 a_9111_4666# sg13cmos5l_dfrbp_1_11.Q VGND VGND sg13_lv_nmos ad=0.2516p pd=2.16u as=0.15055p ps=1.17u w=0.74u l=0.13u
X2351 sg13cmos5l_dfrbp_1_15.D a_4244_8436# VPWR VPWR sg13_lv_pmos ad=0.3808p pd=2.92u as=0.2128p ps=1.5u w=1.12u l=0.13u
X2352 a_17412_1944# a_17931_1748# a_18671_1703# VGND sg13_lv_nmos ad=0.3473p pd=2.71u as=0.12665p ps=1.145u w=0.74u l=0.13u
X2353 d_out[2] a_20392_3900# VPWR VPWR sg13_lv_pmos ad=0.42p pd=2.99u as=0.2114p ps=1.54u w=1.12u l=0.13u
X2354 sg13cmos5l_nand2_1_0.B a_10587_4692# a_10789_4654# VGND sg13_lv_nmos ad=0.333p pd=2.38u as=0.1406p ps=1.12u w=0.74u l=0.13u
X2355 VGND cks sg13cmos5l_dfrbp_1_0.RESET_B VGND sg13_lv_nmos ad=0.2516p pd=2.16u as=0.2516p ps=2.16u w=0.74u l=0.13u
X2356 a_1815_4666# sg13cmos5l_dlhr_1_1.GATE VGND VGND sg13_lv_nmos ad=0.2516p pd=2.16u as=0.15055p ps=1.17u w=0.74u l=0.13u
X2357 a_17829_1605# sg13cmos5l_dfrbp_1_0.CLK VPWR VPWR sg13_lv_pmos ad=0.4088p pd=2.97u as=1.777p ps=11.395u w=1.12u l=0.13u
X2358 a_8592_5412# a_8041_5770# VPWR VPWR sg13_lv_pmos ad=0.105p pd=1.21u as=1.28962p ps=8.195u w=1u l=0.13u
X2359 a_9879_9202# sg13cmos5l_dfrbp_1_18.Q VGND VGND sg13_lv_nmos ad=0.2516p pd=2.16u as=0.15055p ps=1.17u w=0.74u l=0.13u
X2360 a_12132_9504# a_12651_9308# a_13391_9263# VGND sg13_lv_nmos ad=0.3473p pd=2.71u as=0.12665p ps=1.145u w=0.74u l=0.13u
X2361 VPWR sg13cmos5l_buf_1_3.X a_20392_3176# VPWR sg13_lv_pmos ad=0.2114p pd=1.54u as=0.2856p ps=2.36u w=0.84u l=0.13u
X2362 a_10028_6126# sg13cmos5l_buf_1_56.A VPWR VPWR sg13_lv_pmos ad=0.2856p pd=2.36u as=0.2114p ps=1.54u w=0.84u l=0.13u
X2363 VGND VPWR VGND VGND sg13_lv_nmos ad=0.1428p pd=1.52u as=0 ps=0 w=0.42u l=1u
X2364 a_4018_3138# sg13cmos5l_dfrbp_1_6.RESET_B VGND VGND sg13_lv_nmos ad=37.8f pd=0.6u as=79.8f ps=0.8u w=0.42u l=0.13u
X2365 VGND a_8204_9150# sg13cmos5l_buf_1_74.X VGND sg13_lv_nmos ad=0.14875p pd=1.16u as=0.2886p ps=2.26u w=0.74u l=0.13u
X2366 a_1662_8374# a_1463_8511# VGND VGND sg13_lv_nmos ad=0.27427p pd=2.28u as=2.92392p ps=18.89u w=0.795u l=0.13u
X2367 sg13cmos5l_buf_1_4.X a_16552_1664# VPWR VPWR sg13_lv_pmos ad=0.42p pd=2.99u as=0.2114p ps=1.54u w=1.12u l=0.13u
X2368 VGND VPWR VGND VGND sg13_lv_nmos ad=79.8f pd=0.8u as=0 ps=0 w=0.42u l=1u
X2369 a_12549_9165# sg13cmos5l_inv_1_2.A VPWR VPWR sg13_lv_pmos ad=0.4088p pd=2.97u as=4.11675p ps=27.17u w=1.12u l=0.13u
X2370 VPWR a_2224_7166# a_2169_7047# VPWR sg13_lv_pmos ad=1.07253p pd=6.75u as=93.45f ps=0.865u w=0.42u l=0.13u
X2371 VGND a_4559_7630# a_4514_7666# VGND sg13_lv_nmos ad=1.49685p pd=9.6u as=71.99999f ps=0.865u w=0.64u l=0.13u
X2372 VGND sg13cmos5l_dfrbp_1_1.Q a_20392_2388# VGND sg13_lv_nmos ad=0.14875p pd=1.16u as=0.187p ps=1.78u w=0.55u l=0.13u
X2373 a_11824_7894# a_11567_7751# a_11986_7674# VGND sg13_lv_nmos ad=0.1428p pd=1.52u as=37.8f ps=0.6u w=0.42u l=0.13u
X2374 VPWR a_5079_3154# a_5210_3148# VPWR sg13_lv_pmos ad=1.43437p pd=9.105u as=0.2856p ps=2.36u w=0.84u l=0.13u
X2375 a_6572_1590# sg13cmos5l_buf_1_24.A VGND VGND sg13_lv_nmos ad=0.187p pd=1.78u as=0.14875p ps=1.16u w=0.55u l=0.13u
X2376 sg13cmos5l_buf_8_2.X a_19227_9190# VGND VGND sg13_lv_nmos ad=0.1406p pd=1.12u as=0.1406p ps=1.12u w=0.74u l=0.13u
X2377 VGND a_15177_5769# a_15132_5814# VGND sg13_lv_nmos ad=0.1428p pd=1.52u as=47.25f ps=0.645u w=0.42u l=0.13u
X2378 a_14436_8874# sg13cmos5l_dfrbp_1_23.CLK a_14342_8874# VGND sg13_lv_nmos ad=60.89999f pd=0.71u as=0.1428p ps=1.52u w=0.42u l=0.13u
X2379 VPWR VGND VPWR VPWR sg13_lv_pmos ad=0.34p pd=2.68u as=0 ps=0 w=1u l=1u
X2380 sg13cmos5l_dlhr_1_7.Q_N a_4950_7354# VGND VGND sg13_lv_nmos ad=0.2516p pd=2.16u as=0.1491p ps=1.18u w=0.74u l=0.13u
X2381 sg13cmos5l_buf_1_34.A a_4041_2745# VGND VGND sg13_lv_nmos ad=0.2516p pd=2.16u as=0.1406p ps=1.12u w=0.74u l=0.13u
X2382 VPWR sg13cmos5l_dfrbp_1_0.RESET_B a_17674_3361# VPWR sg13_lv_pmos ad=0.1563p pd=1.22u as=0.147p ps=1.54u w=0.42u l=0.13u
X2383 a_11174_2826# a_11979_2399# a_11434_2356# VPWR sg13_lv_pmos ad=0.1428p pd=1.52u as=79.8f ps=0.8u w=0.42u l=0.13u
X2384 VPWR sg13cmos5l_dfrbp_1_6.RESET_B a_7497_3138# VPWR sg13_lv_pmos ad=0.2128p pd=1.5u as=0.2128p ps=1.5u w=1.12u l=0.13u
X2385 VGND a_10473_9186# a_10998_9168# VGND sg13_lv_nmos ad=0.1491p pd=1.18u as=0.187p ps=1.78u w=0.55u l=0.13u
X2386 a_15300_2826# sg13cmos5l_nor2b_1_1.Y a_15206_2826# VGND sg13_lv_nmos ad=60.89999f pd=0.71u as=0.1428p ps=1.52u w=0.42u l=0.13u
X2387 a_19378_3138# sg13cmos5l_dfrbp_1_0.RESET_B VGND VGND sg13_lv_nmos ad=37.8f pd=0.6u as=79.8f ps=0.8u w=0.42u l=0.13u
X2388 a_8972_3864# sg13cmos5l_buf_1_45.A VGND VGND sg13_lv_nmos ad=0.187p pd=1.78u as=0.14875p ps=1.16u w=0.55u l=0.13u
X2389 a_8247_5770# sg13cmos5l_dfrbp_1_11.Q VPWR VPWR sg13_lv_pmos ad=0.3234p pd=2.45u as=1.2517p ps=7.955u w=0.84u l=0.13u
X2390 a_5700_6480# a_5674_6385# VGND VGND sg13_lv_nmos ad=0.2516p pd=2.16u as=0.1626p ps=1.415u w=0.74u l=0.13u
X2391 VGND sg13cmos5l_dlhr_1_10.Q a_19528_6924# VGND sg13_lv_nmos ad=0.14875p pd=1.16u as=0.187p ps=1.78u w=0.55u l=0.13u
X2392 VGND sg13cmos5l_buf_1_97.A a_11848_8436# VGND sg13_lv_nmos ad=0.14875p pd=1.16u as=0.187p ps=1.78u w=0.55u l=0.13u
X2393 a_11686_2813# sg13cmos5l_dfrbp_1_0.RESET_B VGND VGND sg13_lv_nmos ad=37.8f pd=0.6u as=0.1701p ps=1.65u w=0.42u l=0.13u
X2394 VPWR sg13cmos5l_dfrbp_1_20.Q a_9865_7282# VPWR sg13_lv_pmos ad=1.07253p pd=6.75u as=0.2856p ps=2.36u w=0.84u l=0.13u
X2395 a_19628_2352# sg13cmos5l_buf_1_19.X VPWR VPWR sg13_lv_pmos ad=0.2856p pd=2.36u as=0.2114p ps=1.54u w=0.84u l=0.13u
X2396 VPWR a_6188_1590# sg13cmos5l_buf_1_25.X VPWR sg13_lv_pmos ad=0.2114p pd=1.54u as=0.42p ps=2.99u w=1.12u l=0.13u
X2397 VPWR a_1006_4167# sg13cmos5l_dlygate4sd3_1_0.X VPWR sg13_lv_pmos ad=0.2254p pd=1.53u as=0.4256p ps=3u w=1.12u l=0.13u
X2398 a_620_7638# sg13cmos5l_buf_1_63.X VGND VGND sg13_lv_nmos ad=0.187p pd=1.78u as=0.14875p ps=1.16u w=0.55u l=0.13u
X2399 VGND a_5324_1590# sg13cmos5l_buf_1_39.A VGND sg13_lv_nmos ad=0.14875p pd=1.16u as=0.2886p ps=2.26u w=0.74u l=0.13u
X2400 a_5710_5850# a_5951_5383# a_5069_5376# VGND sg13_lv_nmos ad=0.1428p pd=1.52u as=0.12665p ps=1.145u w=0.42u l=0.13u
X2401 sg13cmos5l_dfrbp_1_6.RESET_B cks VGND VGND sg13_lv_nmos ad=0.1406p pd=1.12u as=0.1406p ps=1.12u w=0.74u l=0.13u
X2402 VPWR a_1878_6337# sg13cmos5l_dlhr_1_1.GATE VPWR sg13_lv_pmos ad=0.2128p pd=1.5u as=0.3808p ps=2.92u w=1.12u l=0.13u
X2403 sg13cmos5l_buf_1_18.X a_18376_2388# VPWR VPWR sg13_lv_pmos ad=0.42p pd=2.99u as=0.2114p ps=1.54u w=1.12u l=0.13u
X2404 VPWR a_7052_9150# sg13cmos5l_buf_1_76.X VPWR sg13_lv_pmos ad=0.2114p pd=1.54u as=0.42p ps=2.99u w=1.12u l=0.13u
X2405 a_8852_6484# a_8570_6172# a_8785_6154# VGND sg13_lv_nmos ad=0.141p pd=1.17u as=71.99999f ps=0.865u w=0.64u l=0.13u
X2406 sg13cmos5l_buf_1_26.A sg13cmos5l_buf_1_45.X VGND VGND sg13_lv_nmos ad=0.2516p pd=2.16u as=0.2516p ps=2.16u w=0.74u l=0.13u
X2407 a_13775_6239# a_12933_6141# a_13681_6239# VGND sg13_lv_nmos ad=0.12665p pd=1.145u as=0.1428p ps=1.52u w=0.42u l=0.13u
X2408 VPWR sg13cmos5l_dfrbp_1_0.RESET_B a_12998_3138# VPWR sg13_lv_pmos ad=0.36237p pd=2.605u as=79.8f ps=0.8u w=0.42u l=0.13u
X2409 VGND a_6213_3911# a_6315_3911# VGND sg13_lv_nmos ad=2.41737p pd=15.64u as=0.2516p ps=2.16u w=0.74u l=0.13u
X2410 a_2364_4686# a_1815_4666# a_2228_4972# VGND sg13_lv_nmos ad=47.25f pd=0.645u as=0.141p ps=1.17u w=0.42u l=0.13u
X2411 a_6276_8861# a_6507_8447# a_5962_8404# VGND sg13_lv_nmos ad=0.2373p pd=1.97u as=79.8f ps=0.8u w=0.42u l=0.13u
X2412 VGND sg13cmos5l_dfrbp_1_6.RESET_B a_18196_8824# VGND sg13_lv_nmos ad=0.1406p pd=1.12u as=77.7f ps=0.95u w=0.74u l=0.13u
X2413 VPWR a_19227_9190# sg13cmos5l_buf_8_2.X VPWR sg13_lv_pmos ad=0.2128p pd=1.5u as=0.2128p ps=1.5u w=1.12u l=0.13u
X2414 sg13cmos5l_dlhr_1_12.Q_N a_18486_8866# VPWR VPWR sg13_lv_pmos ad=0.3808p pd=2.92u as=0.1974p ps=1.5u w=1.12u l=0.13u
X2415 sg13cmos5l_buf_1_34.X a_4840_1664# VGND VGND sg13_lv_nmos ad=0.2886p pd=2.26u as=0.14875p ps=1.16u w=0.74u l=0.13u
X2416 sg13cmos5l_buf_1_34.A a_4041_2745# VPWR VPWR sg13_lv_pmos ad=0.3808p pd=2.92u as=0.2128p ps=1.5u w=1.12u l=0.13u
X2417 VPWR VGND VPWR VPWR sg13_lv_pmos ad=0.34p pd=2.68u as=0 ps=0 w=1u l=1u
X2418 a_4518_7996# a_4349_7636# a_4076_7624# VPWR sg13_lv_pmos ad=0.105p pd=1.21u as=0.191p ps=1.44u w=1u l=0.13u
X2419 VGND sg13cmos5l_dfrbp_1_15.D a_2621_7636# VGND sg13_lv_nmos ad=0.15055p pd=1.17u as=0.2516p ps=2.16u w=0.74u l=0.13u
X2420 a_12998_3138# a_13803_3260# a_13258_3361# VPWR sg13_lv_pmos ad=0.1428p pd=1.52u as=79.8f ps=0.8u w=0.42u l=0.13u
X2421 a_6903_3154# sg13cmos5l_dlhr_1_0.GATE VPWR VPWR sg13_lv_pmos ad=0.3234p pd=2.45u as=1.43437p ps=9.105u w=0.84u l=0.13u
X2422 a_14814_3876# sg13cmos5l_nand2_1_1.B VPWR VPWR sg13_lv_pmos ad=0.2744p pd=1.61u as=0.3808p ps=2.92u w=1.12u l=0.13u
X2423 a_996_7349# a_708_6928# a_934_7349# VGND sg13_lv_nmos ad=0.1428p pd=1.52u as=37.8f ps=0.6u w=0.42u l=0.13u
X2424 VPWR cks sg13cmos5l_dfrbp_1_6.RESET_B VPWR sg13_lv_pmos ad=0.2128p pd=1.5u as=0.2128p ps=1.5u w=1.12u l=0.13u
X2425 VGND VPWR VGND VGND sg13_lv_nmos ad=79.8f pd=0.8u as=0 ps=0 w=0.42u l=1u
X2426 a_13775_6239# a_12933_6141# a_12516_6480# VPWR sg13_lv_pmos ad=0.2048p pd=1.63u as=0.34p ps=2.68u w=1u l=0.13u
X2427 VPWR a_2831_7630# a_2790_7996# VPWR sg13_lv_pmos ad=1.15047p pd=7.175u as=0.105p ps=1.21u w=1u l=0.13u
X2428 a_2505_3947# a_2148_3904# VPWR VPWR sg13_lv_pmos ad=63f pd=0.72u as=0.1563p ps=1.22u w=0.42u l=0.13u
X2429 a_16293_4629# sg13cmos5l_inv_1_2.A VPWR VPWR sg13_lv_pmos ad=0.4088p pd=2.97u as=1.28962p ps=8.195u w=1.12u l=0.13u
X2430 VGND sg13cmos5l_nor2_1_0.A a_10613_2758# VGND sg13_lv_nmos ad=0.1898p pd=1.36u as=0.2516p ps=2.16u w=0.74u l=0.13u
X2431 sg13cmos5l_buf_1_30.X a_8680_1664# VPWR VPWR sg13_lv_pmos ad=0.42p pd=2.99u as=0.2114p ps=1.54u w=1.12u l=0.13u
X2432 VPWR cks a_19227_9190# VPWR sg13_lv_pmos ad=0.2128p pd=1.5u as=0.3808p ps=2.92u w=1.12u l=0.13u
X2433 a_10412_6126# sg13cmos5l_dlhr_1_5.Q VGND VGND sg13_lv_nmos ad=0.187p pd=1.78u as=0.14875p ps=1.16u w=0.55u l=0.13u
X2434 a_11174_2826# sg13cmos5l_dfrbp_1_4.D VPWR VPWR sg13_lv_pmos ad=79.8f pd=0.8u as=0.1428p ps=1.52u w=0.42u l=0.13u
X2435 VGND a_13775_6239# a_14612_6460# VGND sg13_lv_nmos ad=0.1406p pd=1.12u as=0.2516p ps=2.16u w=0.74u l=0.13u
X2436 a_2148_8440# a_2122_8404# VPWR VPWR sg13_lv_pmos ad=0.34p pd=2.68u as=0.36237p ps=2.605u w=1u l=0.13u
X2437 VPWR a_4172_1590# sg13cmos5l_buf_1_33.A VPWR sg13_lv_pmos ad=0.2114p pd=1.54u as=0.42p ps=2.99u w=1.12u l=0.13u
X2438 a_7449_8559# a_6507_8447# a_7247_8797# VPWR sg13_lv_pmos ad=93.45f pd=0.865u as=0.2048p ps=1.63u w=0.42u l=0.13u
X2439 a_11769_7989# a_10827_7796# a_11567_7751# VPWR sg13_lv_pmos ad=93.45f pd=0.865u as=0.2048p ps=1.63u w=0.42u l=0.13u
X2440 sg13cmos5l_buf_1_3.X a_20296_1664# VPWR VPWR sg13_lv_pmos ad=0.42p pd=2.99u as=0.2114p ps=1.54u w=1.12u l=0.13u
X2441 a_10220_3102# sg13cmos5l_buf_1_28.X VGND VGND sg13_lv_nmos ad=0.187p pd=1.78u as=0.14875p ps=1.16u w=0.55u l=0.13u
X2442 nl_sw[6] a_11656_3176# VPWR VPWR sg13_lv_pmos ad=0.42p pd=2.99u as=0.2114p ps=1.54u w=1.12u l=0.13u
X2443 sg13cmos5l_buf_1_96.A a_10665_7281# VPWR VPWR sg13_lv_pmos ad=0.3808p pd=2.92u as=0.2128p ps=1.5u w=1.12u l=0.13u
X2444 a_14641_7326# a_14089_7282# VGND VGND sg13_lv_nmos ad=71.99999f pd=0.865u as=1.49685p ps=9.6u w=0.64u l=0.13u
X2445 a_7052_9150# sg13cmos5l_inv_1_14.A VPWR VPWR sg13_lv_pmos ad=0.2856p pd=2.36u as=0.2114p ps=1.54u w=0.84u l=0.13u
X2446 VPWR a_3407_8797# a_3664_8678# VPWR sg13_lv_pmos ad=0.2639p pd=1.81u as=79.8f ps=0.8u w=0.42u l=0.13u
X2447 a_16204_4338# a_15821_3864# VPWR VPWR sg13_lv_pmos ad=79.8f pd=0.8u as=0.2639p ps=1.81u w=0.42u l=0.13u
X2448 VPWR sg13cmos5l_dfrbp_1_8.RESET_B a_2122_8404# VPWR sg13_lv_pmos ad=0.1563p pd=1.22u as=0.147p ps=1.54u w=0.42u l=0.13u
X2449 a_6380_7638# sg13cmos5l_buf_1_78.X VGND VGND sg13_lv_nmos ad=0.187p pd=1.78u as=0.14875p ps=1.16u w=0.55u l=0.13u
X2450 a_14900_2352# sg13cmos5l_nor2_1_1.A VGND VGND sg13_lv_nmos ad=0.187p pd=1.78u as=0.17255p ps=1.25u w=0.55u l=0.13u
X2451 a_7161_6477# a_6219_6284# a_6959_6239# VPWR sg13_lv_pmos ad=93.45f pd=0.865u as=0.2048p ps=1.63u w=0.42u l=0.13u
X2452 sg13cmos5l_dlhr_1_15.Q_N a_18870_7656# VGND VGND sg13_lv_nmos ad=0.2516p pd=2.16u as=0.1491p ps=1.18u w=0.74u l=0.13u
X2453 a_15780_2813# a_16011_2399# a_15466_2356# VGND sg13_lv_nmos ad=0.2373p pd=1.97u as=79.8f ps=0.8u w=0.42u l=0.13u
X2454 a_5710_5535# a_5452_5850# VPWR VPWR sg13_lv_pmos ad=93.45f pd=0.865u as=1.28962p ps=8.195u w=0.42u l=0.13u
X2455 VPWR sg13cmos5l_buf_1_29.A a_9832_1664# VPWR sg13_lv_pmos ad=0.2114p pd=1.54u as=0.2856p ps=2.36u w=0.84u l=0.13u
X2456 VPWR sg13cmos5l_buf_1_39.A a_3688_1664# VPWR sg13_lv_pmos ad=0.2114p pd=1.54u as=0.2856p ps=2.36u w=0.84u l=0.13u
X2457 sg13cmos5l_dfrbp_1_9.Q_N a_3407_4261# VGND VGND sg13_lv_nmos ad=0.2849p pd=2.25u as=0.2516p ps=2.16u w=0.74u l=0.13u
X2458 sg13cmos5l_dlhr_1_12.Q_N a_18486_8866# VGND VGND sg13_lv_nmos ad=0.2516p pd=2.16u as=0.1491p ps=1.18u w=0.74u l=0.13u
X2459 a_16164_4663# a_16395_4772# a_15850_4873# VGND sg13_lv_nmos ad=0.2373p pd=1.97u as=79.8f ps=0.8u w=0.42u l=0.13u
X2460 a_17961_8793# a_17780_8436# VPWR VPWR sg13_lv_pmos ad=0.2128p pd=1.5u as=0.2387p ps=1.84u w=1.12u l=0.13u
X2461 VPWR a_8588_3864# sg13cmos5l_buf_1_30.A VPWR sg13_lv_pmos ad=0.2114p pd=1.54u as=0.42p ps=2.99u w=1.12u l=0.13u
X2462 a_4311_7710# a_3676_7964# VGND VGND sg13_lv_nmos ad=47.25f pd=0.645u as=0.1428p ps=1.52u w=0.42u l=0.13u
X2463 sg13cmos5l_dlhr_1_15.Q a_18345_7674# VPWR VPWR sg13_lv_pmos ad=0.3808p pd=2.92u as=0.2128p ps=1.5u w=1.12u l=0.13u
X2464 VGND sg13cmos5l_buf_1_28.A a_9448_1664# VGND sg13_lv_nmos ad=0.14875p pd=1.16u as=0.187p ps=1.78u w=0.55u l=0.13u
X2465 VPWR a_18959_3215# a_19216_3358# VPWR sg13_lv_pmos ad=0.2639p pd=1.81u as=79.8f ps=0.8u w=0.42u l=0.13u
X2466 sg13cmos5l_a22oi_1_0.B1 sg13cmos5l_nor2_1_0.A a_10618_3142# VGND sg13_lv_nmos ad=0.2516p pd=2.16u as=0.1406p ps=1.12u w=0.74u l=0.13u
X2467 sg13cmos5l_dfrbp_1_0.Q a_19508_1924# VGND VGND sg13_lv_nmos ad=0.2516p pd=2.16u as=0.1406p ps=1.12u w=0.74u l=0.13u
X2468 a_10450_8874# sg13cmos5l_dfrbp_1_8.RESET_B VGND VGND sg13_lv_nmos ad=37.8f pd=0.6u as=79.8f ps=0.8u w=0.42u l=0.13u
X2469 a_2554_8112# a_1948_7964# VPWR VPWR sg13_lv_pmos ad=0.1008p pd=0.9u as=0.2387p ps=1.84u w=0.42u l=0.13u
X2470 a_7498_7897# a_7941_7653# a_7238_7674# VGND sg13_lv_nmos ad=79.8f pd=0.8u as=0.1296p ps=1.52u w=0.42u l=0.13u
X2471 VGND VPWR VGND VGND sg13_lv_nmos ad=79.8f pd=0.8u as=0 ps=0 w=0.42u l=1u
X2472 VPWR a_1846_7850# sg13cmos5l_dlhr_1_8.Q_N VPWR sg13_lv_pmos ad=0.1974p pd=1.5u as=0.3808p ps=2.92u w=1.12u l=0.13u
X2473 VPWR a_13775_6239# a_14032_6382# VPWR sg13_lv_pmos ad=0.2639p pd=1.81u as=79.8f ps=0.8u w=0.42u l=0.13u
X2474 sg13cmos5l_dfrbp_1_23.CLK a_14228_9484# VGND VGND sg13_lv_nmos ad=0.2516p pd=2.16u as=0.1406p ps=1.12u w=0.74u l=0.13u
X2475 a_12358_5388# sg13cmos5l_dfrbp_1_21.Q VPWR VPWR sg13_lv_pmos ad=0.1596p pd=1.22u as=0.2226p ps=1.535u w=0.84u l=0.13u
X2476 a_422_5850# sg13cmos5l_dfrbp_1_6.D VPWR VPWR sg13_lv_pmos ad=79.8f pd=0.8u as=0.1428p ps=1.52u w=0.42u l=0.13u
X2477 VPWR sg13cmos5l_inv_1_18.A a_9256_9224# VPWR sg13_lv_pmos ad=0.2114p pd=1.54u as=0.2856p ps=2.36u w=0.84u l=0.13u
X2478 VGND sg13cmos5l_buf_1_78.A a_6184_9224# VGND sg13_lv_nmos ad=0.14875p pd=1.16u as=0.187p ps=1.78u w=0.55u l=0.13u
X2479 sg13cmos5l_dfrbp_1_10.Q a_4436_3436# VGND VGND sg13_lv_nmos ad=0.2516p pd=2.16u as=0.1406p ps=1.12u w=0.74u l=0.13u
X2480 a_17508_3138# sg13cmos5l_a22oi_1_1.Y a_17414_3138# VGND sg13_lv_nmos ad=60.89999f pd=0.71u as=0.1428p ps=1.52u w=0.42u l=0.13u
X2481 a_16234_6385# a_16677_6141# a_16617_6553# VPWR sg13_lv_pmos ad=79.8f pd=0.8u as=63f ps=0.72u w=0.42u l=0.13u
X2482 a_14194_6162# sg13cmos5l_dfrbp_1_6.RESET_B VGND VGND sg13_lv_nmos ad=37.8f pd=0.6u as=79.8f ps=0.8u w=0.42u l=0.13u
X2483 a_11844_1639# a_11556_1944# a_11782_1639# VGND sg13_lv_nmos ad=0.1428p pd=1.52u as=37.8f ps=0.6u w=0.42u l=0.13u
X2484 VPWR a_13648_9406# a_13593_9501# VPWR sg13_lv_pmos ad=4.11675p pd=27.17u as=93.45f ps=0.865u w=0.42u l=0.13u
X2485 sg13cmos5l_inv_1_0.A a_13652_3900# VGND VGND sg13_lv_nmos ad=0.2516p pd=2.16u as=0.1406p ps=1.12u w=0.74u l=0.13u
X2486 a_3814_4663# sg13cmos5l_dfrbp_1_8.RESET_B VGND VGND sg13_lv_nmos ad=37.8f pd=0.6u as=0.1701p ps=1.65u w=0.42u l=0.13u
X2487 sg13cmos5l_dlhr_1_13.Q_N a_15414_7354# VPWR VPWR sg13_lv_pmos ad=0.3808p pd=2.92u as=0.1974p ps=1.5u w=1.12u l=0.13u
C0 sg13cmos5l_dfrbp_1_10.Q_N a_4018_3138# 0
C1 a_8689_7751# a_8439_6178# 0
C2 sg13cmos5l_buf_1_41.A a_2148_3904# 0.02627f
C3 sg13cmos5l_dfrbp_1_6.RESET_B a_7732_3124# 0.00506f
C4 sg13cmos5l_inv_1_2.A sg13cmos5l_buf_1_93.X 1.11709f
C5 sg13cmos5l_inv_1_8.A a_3302_4650# 0.04485f
C6 a_4436_3436# sg13cmos5l_buf_1_34.A 0
C7 sg13cmos5l_dfrbp_1_10.Q_N a_3860_2388# 0
C8 sg13cmos5l_dlhr_1_9.D sg13cmos5l_or2_1_1.B 0
C9 a_7833_4965# sg13cmos5l_dfrbp_1_12.Q_N 0
C10 sg13cmos5l_a221oi_1_0.C1 sg13cmos5l_nand2_1_0.A 0.11837f
C11 sg13cmos5l_nor2_1_0.A sg13cmos5l_a22oi_1_1.B1 0.06964f
C12 a_20392_2388# a_20288_2474# 0.00624f
C13 sg13cmos5l_buf_1_41.X a_3447_2746# 0
C14 sg13cmos5l_inv_1_20.Y a_1862_8874# 0
C15 a_2248_9224# a_2122_8404# 0
C16 sg13cmos5l_buf_1_65.X a_1662_8374# 0.00171f
C17 sg13cmos5l_dfrbp_1_6.RESET_B sg13cmos5l_a22oi_1_1.B2 0.08241f
C18 sg13cmos5l_inv_1_17.A a_4107_4772# 0.01351f
C19 sg13cmos5l_buf_1_34.X a_3562_4873# 0
C20 sg13cmos5l_dfrbp_1_8.RESET_B sg13cmos5l_dfrbp_1_9.Q_N 0
C21 sg13cmos5l_dfrbp_1_20.Q_N a_10031_8797# 0
C22 sg13cmos5l_dfrbp_1_6.RESET_B a_9638_5088# 0
C23 sg13cmos5l_dlhr_1_7.Q_N a_5069_5376# 0
C24 sg13cmos5l_buf_8_0.X sg13cmos5l_buf_1_3.X 0.00411f
C25 sg13cmos5l_buf_1_18.A a_19161_3453# 0.0019f
C26 sg13cmos5l_inv_1_2.A a_14228_9484# 0.00821f
C27 sg13cmos5l_buf_1_31.X sg13cmos5l_dfrbp_1_1.Q 0
C28 sg13cmos5l_buf_1_8.A nh_sw[6] 0.0659f
C29 a_10998_9168# sg13cmos5l_inv_1_28.Y 0.00617f
C30 a_18671_1703# nl_sw[10] 0.00293f
C31 a_2054_3138# sg13cmos5l_dfrbp_1_10.Q_N 0
C32 a_3599_3215# a_3856_3358# 0.35645f
C33 a_2859_3260# a_2628_3151# 0.15089f
C34 a_2340_3456# a_3505_3215# 0.4858f
C35 sg13cmos5l_buf_1_45.X sg13cmos5l_buf_1_30.A 0.22408f
C36 sg13cmos5l_buf_1_29.A sg13cmos5l_a22oi_1_0.Y 0.02945f
C37 sg13cmos5l_dfrbp_1_16.Q a_7796_6460# 0.00193f
C38 sg13cmos5l_inv_1_2.A a_8486_8874# 0
C39 sg13cmos5l_buf_1_60.X cks 0
C40 sg13cmos5l_buf_1_1.A nh_sw[6] 0.14552f
C41 sg13cmos5l_buf_1_4.A a_15780_2813# 0
C42 a_2748_6126# a_3926_6175# 0.00523f
C43 sg13cmos5l_buf_1_41.A sg13cmos5l_or2_1_0.A 0.02436f
C44 a_1227_6935# sg13cmos5l_inv_1_19.A 0.0475f
C45 sg13cmos5l_dfrbp_1_9.Q sg13cmos5l_buf_1_34.A 0.00363f
C46 sg13cmos5l_dlhr_1_9.D a_5799_5499# 0.00957f
C47 sg13cmos5l_dfrbp_1_6.D a_17972_4948# 0.01203f
C48 a_2748_6126# a_2804_5412# 0
C49 sg13cmos5l_dfrbp_1_6.RESET_B a_12804_6175# 0.00121f
C50 sg13cmos5l_a22oi_1_1.B2 a_14543_3215# 0
C51 a_11460_2392# VPWR 0.09271f
C52 sg13cmos5l_nand2_1_0.A sg13cmos5l_o21ai_1_0.B1 0
C53 a_14726_7674# a_14820_7674# 0.00718f
C54 a_15429_7653# a_15531_7796# 0.66105f
C55 a_14986_7897# a_15300_7687# 0.00659f
C56 sg13cmos5l_buf_1_86.A cko 0.00711f
C57 sg13cmos5l_buf_1_4.X a_16953_2511# 0
C58 sg13cmos5l_buf_1_73.A a_7666_8874# 0
C59 sg13cmos5l_buf_1_63.X a_1088_7806# 0
C60 sg13cmos5l_nand2_1_1.B a_13258_3361# 0
C61 a_12651_9308# sg13cmos5l_dlhr_1_11.Q 0
C62 a_2122_8404# a_2148_8440# 0.43042f
C63 sg13cmos5l_dfrbp_1_8.RESET_B pl_sw[1] 0.00124f
C64 sg13cmos5l_dlhr_1_9.Q a_4176_6924# 0
C65 a_20492_8400# frame 0.00534f
C66 sg13cmos5l_buf_1_26.A a_9164_1590# 0.31694f
C67 sg13cmos5l_buf_1_5.A a_14377_5770# 0.04381f
C68 sg13cmos5l_buf_1_19.A a_19216_3358# 0
C69 sg13cmos5l_buf_1_2.X nh_sw[8] 0
C70 sg13cmos5l_dfrbp_1_11.Q a_7312_4142# 0.02569f
C71 a_11360_9318# a_10725_7653# 0
C72 a_10031_8797# a_10233_8559# 0.00675f
C73 sg13cmos5l_nand2_1_1.B sg13cmos5l_dfrbp_1_0.CLK 0.40194f
C74 a_19624_8436# pl_sw[9] 0
C75 sg13cmos5l_inv_1_17.A a_2879_6432# 0
C76 a_1125_5423# VPWR 0.25188f
C77 sg13cmos5l_dfrbp_1_3.Q_N sg13cmos5l_dfrbp_1_0.Q 0.00364f
C78 sg13cmos5l_buf_1_24.A sg13cmos5l_buf_1_25.A 1.22049f
C79 sg13cmos5l_inv_1_0.Y a_12075_3911# 0.00129f
C80 sg13cmos5l_dlhr_1_9.Q a_4311_7710# 0
C81 sg13cmos5l_buf_1_32.A sg13cmos5l_inv_1_19.A 0.09442f
C82 sg13cmos5l_inv_1_1.A sg13cmos5l_a22oi_1_1.B2 0.07936f
C83 sg13cmos5l_buf_1_110.A a_14583_5770# 0
C84 sg13cmos5l_buf_1_30.A a_8204_2352# 0.02301f
C85 sg13cmos5l_dfrbp_1_18.Q a_10010_9196# 0.00837f
C86 a_12132_9504# a_12716_8400# 0
C87 sg13cmos5l_dfrbp_1_6.RESET_B sg13cmos5l_a221oi_1_0.A2 0.65974f
C88 sg13cmos5l_nor2_1_2.A a_1158_3142# 0.02269f
C89 sg13cmos5l_buf_1_57.X a_15016_6294# 0.00488f
C90 sg13cmos5l_dfrbp_1_21.Q a_18615_5770# 0.01128f
C91 a_13486_5412# sg13cmos5l_and3_1_0.C 0
C92 a_11364_1626# nl_sw[6] 0
C93 a_6889_1680# nh_sw[3] 0
C94 sg13cmos5l_buf_1_0.A a_19161_3453# 0.00157f
C95 a_20488_4782# sg13cmos5l_buf_1_3.X 0
C96 sg13cmos5l_dfrbp_1_16.Q_N a_2727_6380# 0
C97 a_4076_7624# a_3669_6320# 0.00161f
C98 sg13cmos5l_inv_1_29.A a_12361_7282# 0.02425f
C99 sg13cmos5l_buf_1_46.A a_9940_4636# 0.00181f
C100 sg13cmos5l_buf_8_1.A a_16657_2749# 0
C101 sg13cmos5l_dlhr_1_5.GATE a_5312_6294# 0.00199f
C102 a_7497_3138# a_7095_1642# 0.00223f
C103 a_9189_8447# a_9291_8447# 0.6663f
C104 a_8772_8440# a_10288_8678# 0.00159f
C105 sg13cmos5l_dfrbp_1_6.RESET_B a_11567_7751# 0.20502f
C106 sg13cmos5l_a221oi_1_0.B1 a_11372_3102# 0
C107 sg13cmos5l_dfrbp_1_23.CLK a_12913_7326# 0
C108 a_16940_3102# sg13cmos5l_buf_1_4.X 0.33512f
C109 a_18999_6178# a_19412_6484# 0.15652f
C110 a_18486_8866# cks 0.00751f
C111 sg13cmos5l_dlhr_1_1.GATE a_682_6892# 0
C112 sg13cmos5l_buf_1_31.X a_9366_5842# 0.015f
C113 a_19227_9190# sg13cmos5l_buf_1_19.A 0
C114 sg13cmos5l_buf_1_3.A a_20492_8400# 0.04986f
C115 sg13cmos5l_buf_1_41.A a_3578_2752# 0.00403f
C116 a_18860_9150# frame 0
C117 sg13cmos5l_nor2b_1_0.Y a_12704_4782# 0
C118 a_1662_8374# pl_sw[1] 0
C119 sg13cmos5l_nor2_1_2.A a_1006_4167# 0.015f
C120 sg13cmos5l_dfrbp_1_0.D a_17988_3151# 0.02283f
C121 a_8972_3864# VPWR 0.34169f
C122 sg13cmos5l_buf_1_107.X a_18272_9318# 0.01174f
C123 sg13cmos5l_dfrbp_1_6.RESET_B a_14628_8440# 0
C124 sg13cmos5l_dfrbp_1_22.D a_17713_8838# 0
C125 sg13cmos5l_buf_8_1.A a_17399_3947# 0.04671f
C126 sg13cmos5l_a22oi_1_2.B2 sg13cmos5l_a22oi_1_2.B1 0.156f
C127 sg13cmos5l_or2_1_0.A a_17595_3947# 0
C128 sg13cmos5l_inv_1_14.A sg13cmos5l_buf_1_45.A 0
C129 sg13cmos5l_buf_1_58.A a_1873_7285# 0.00314f
C130 sg13cmos5l_dfrbp_1_16.Q a_6213_3911# 0
C131 a_12106_9409# a_12132_9504# 0.43042f
C132 sg13cmos5l_dfrbp_1_8.RESET_B a_11846_9186# 0.08804f
C133 a_1576_1758# nh_sw[1] 0
C134 a_10725_7653# a_10665_7281# 0.02351f
C135 a_10308_7992# a_11190_7354# 0
C136 sg13cmos5l_dlhr_1_5.Q a_10028_6126# 0.00297f
C137 a_2348_7624# a_1997_6126# 0
C138 a_4041_2745# nl_sw[3] 0
C139 sg13cmos5l_buf_1_4.A sg13cmos5l_and3_1_0.C 0.01153f
C140 sg13cmos5l_buf_1_45.X pl_sw[5] 0
C141 sg13cmos5l_buf_1_10.A a_12980_6924# 0
C142 sg13cmos5l_nand2_1_1.A a_17674_3361# 0.00909f
C143 a_15045_8447# pl_sw[8] 0
C144 sg13cmos5l_buf_1_7.A sg13cmos5l_dfrbp_1_1.Q_N 0
C145 a_9448_6924# sg13cmos5l_buf_1_31.X 0.33665f
C146 sg13cmos5l_a221oi_1_0.C1 sg13cmos5l_dfrbp_1_1.Q 0
C147 sg13cmos5l_buf_1_34.X a_4244_8436# 0.00506f
C148 sg13cmos5l_dlhr_1_0.GATE sg13cmos5l_buf_1_26.X 0
C149 sg13cmos5l_buf_1_30.A sg13cmos5l_a22oi_1_2.B2 0
C150 a_18860_9150# sg13cmos5l_buf_1_87.A 0.00143f
C151 sg13cmos5l_buf_1_101.X a_18272_9318# 0.00226f
C152 sg13cmos5l_dfrbp_1_8.RESET_B a_6507_8447# 0.58316f
C153 a_19227_9190# sg13cmos5l_buf_1_107.X 0.02983f
C154 sg13cmos5l_dfrbp_1_6.RESET_B a_2169_7047# 0.00414f
C155 a_1088_7806# a_996_7349# 0
C156 sg13cmos5l_dfrbp_1_20.Q a_10028_6126# 0.00241f
C157 a_5069_5376# a_6647_5459# 0
C158 a_5820_5773# a_6998_5837# 0.00523f
C159 pl_sw[2] a_1484_9150# 0
C160 a_17132_9150# pl_sw[8] 0.12951f
C161 sg13cmos5l_a221oi_1_0.B1 a_10230_4632# 0
C162 a_2831_7630# sg13cmos5l_dlhr_1_9.Q_N 0.1374f
C163 sg13cmos5l_or2_1_0.A sg13cmos5l_buf_1_2.X 0.00434f
C164 sg13cmos5l_inv_1_8.A a_2644_4636# 0
C165 sg13cmos5l_dfrbp_1_8.RESET_B a_3447_2746# 0
C166 a_14426_7288# a_14714_5776# 0
C167 sg13cmos5l_dfrbp_1_23.Q a_14377_5770# 0
C168 a_16395_4772# cks 0.05561f
C169 sg13cmos5l_dfrbp_1_8.D sg13cmos5l_buf_1_116.A 0.00527f
C170 ph_sw[0] a_616_9224# 0.2949f
C171 sg13cmos5l_inv_1_3.A pl_sw[6] 0.00294f
C172 a_908_1590# nh_sw[0] 0.00238f
C173 sg13cmos5l_inv_1_20.Y a_2667_8447# 0.03028f
C174 a_15782_7362# a_16042_6892# 0.87117f
C175 sg13cmos5l_inv_1_17.A a_5104_4870# 0
C176 sg13cmos5l_buf_1_37.A sg13cmos5l_buf_1_35.A 0.06528f
C177 sg13cmos5l_buf_1_32.A sg13cmos5l_buf_1_33.A 0
C178 sg13cmos5l_buf_1_4.A a_16677_6141# 0
C179 a_16748_9150# sg13cmos5l_buf_1_107.X 0
C180 sg13cmos5l_buf_1_101.X a_19227_9190# 0.0128f
C181 a_5416_9224# ph_sw[2] 0.00381f
C182 sg13cmos5l_buf_1_29.A sg13cmos5l_buf_1_26.A 0.00184f
C183 sg13cmos5l_buf_1_7.A sg13cmos5l_buf_1_6.A 0.02379f
C184 a_11460_2392# a_11973_1605# 0
C185 a_11877_2399# a_11556_1944# 0
C186 a_9705_4650# nl_sw[5] 0
C187 sg13cmos5l_dfrbp_1_6.D a_8966_6600# 0
C188 sg13cmos5l_dfrbp_1_8.RESET_B a_6789_4629# 0.06648f
C189 sg13cmos5l_a221oi_1_0.A2 a_11182_4676# 0.00285f
C190 sg13cmos5l_dfrbp_1_0.RESET_B a_14900_2352# 0.00532f
C191 sg13cmos5l_dfrbp_1_6.D a_10202_7288# 0.00717f
C192 a_3856_3358# sg13cmos5l_dfrbp_1_10.Q_N 0.16865f
C193 sg13cmos5l_dfrbp_1_6.RESET_B a_6697_3192# 0
C194 VPWR pl_sw[7] 0.23398f
C195 sg13cmos5l_buf_1_10.A sg13cmos5l_buf_1_57.X 0.054f
C196 a_1196_8400# a_708_6928# 0
C197 sg13cmos5l_dfrbp_1_0.CLK sg13cmos5l_a22oi_1_1.A1 0.08016f
C198 a_18164_6924# pl_sw[9] 0
C199 a_2859_3260# sg13cmos5l_buf_1_41.X 0.00253f
C200 d_out[2] nh_sw[10] 0.0046f
C201 sg13cmos5l_buf_1_29.A sg13cmos5l_buf_1_46.A 0.09487f
C202 a_16748_9150# sg13cmos5l_buf_1_101.X 0.01098f
C203 a_17516_9150# a_17896_9224# 0.07249f
C204 sg13cmos5l_inv_1_2.A a_9060_8861# 0.00258f
C205 sg13cmos5l_o21ai_1_0.B1 sg13cmos5l_dfrbp_1_1.Q 0.00349f
C206 sg13cmos5l_dfrbp_1_16.Q sg13cmos5l_dlhr_1_5.Q 0
C207 sg13cmos5l_dfrbp_1_6.RESET_B sg13cmos5l_buf_1_35.A 0.00533f
C208 sg13cmos5l_dfrbp_1_16.Q sg13cmos5l_inv_1_19.A 0.06007f
C209 a_15784_9224# a_15045_8447# 0
C210 sg13cmos5l_inv_1_1.A a_14628_8440# 0.00219f
C211 sg13cmos5l_o21ai_1_0.A2 a_12120_3456# 0.00543f
C212 a_11656_3176# sg13cmos5l_o21ai_1_0.Y 0
C213 a_2638_6162# a_2804_5412# 0
C214 sg13cmos5l_inv_1_3.A a_13803_3260# 0
C215 a_5702_8874# pl_sw[3] 0.0313f
C216 a_2667_3911# sg13cmos5l_buf_1_37.A 0
C217 sg13cmos5l_buf_1_57.X a_15702_5842# 0.00217f
C218 a_11979_2399# VPWR 0.22685f
C219 a_1967_5773# a_2804_5412# 0.1333f
C220 a_1227_5423# a_1873_5773# 0.00667f
C221 sg13cmos5l_buf_1_64.A sg13cmos5l_buf_1_61.X 0.00579f
C222 a_14583_5770# sg13cmos5l_a22oi_1_1.Y 0
C223 sg13cmos5l_dfrbp_1_18.Q a_10708_9172# 0
C224 sg13cmos5l_dfrbp_1_20.Q sg13cmos5l_dfrbp_1_16.Q 0.0033f
C225 a_15429_7653# a_15300_7687# 0.01562f
C226 a_15012_7992# a_15238_7687# 0.00523f
C227 a_15531_7796# a_16473_7989# 0
C228 sg13cmos5l_buf_1_65.X sg13cmos5l_buf_1_77.X 1.4254f
C229 a_1463_8511# a_1480_7806# 0
C230 a_8084_8436# pl_sw[5] 0
C231 sg13cmos5l_buf_1_31.X a_2732_1590# 0
C232 a_2565_8447# a_3664_8678# 0
C233 a_2148_8440# a_3407_8797# 0.01741f
C234 sg13cmos5l_inv_1_8.A a_2748_6126# 0.09319f
C235 a_10220_3102# sg13cmos5l_buf_1_28.X 0.32442f
C236 sg13cmos5l_buf_1_5.A a_14996_5412# 0
C237 sg13cmos5l_buf_1_90.X a_11824_7894# 0
C238 sg13cmos5l_dfrbp_1_27.Q_N sg13cmos5l_inv_1_7.A 0
C239 a_11464_8436# a_11272_8522# 0.01225f
C240 sg13cmos5l_dfrbp_1_9.Q a_3505_3215# 0.00865f
C241 sg13cmos5l_dfrbp_1_11.Q a_8972_3864# 0.00999f
C242 sg13cmos5l_buf_1_78.X a_5988_8440# 0.01656f
C243 sg13cmos5l_a22oi_1_1.B1 sg13cmos5l_o21ai_1_0.Y 0
C244 sg13cmos5l_inv_1_26.Y a_19528_6924# 0.08423f
C245 sg13cmos5l_dfrbp_1_8.RESET_B a_1815_4666# 0.03077f
C246 a_17776_6382# sg13cmos5l_buf_8_1.A 0
C247 sg13cmos5l_dfrbp_1_6.RESET_B a_2667_3911# 0.0246f
C248 sg13cmos5l_buf_1_3.A nl_sw[9] 0
C249 a_15016_9224# a_15500_9150# 0.03472f
C250 sg13cmos5l_dfrbp_1_6.RESET_B a_11752_6294# 0
C251 a_1125_6935# a_1967_5773# 0
C252 a_13391_9263# a_13484_8400# 0
C253 sg13cmos5l_dfrbp_1_21.Q a_19209_5769# 0
C254 sg13cmos5l_dlhr_1_5.GATE a_6959_6239# 0.03867f
C255 sg13cmos5l_dfrbp_1_22.D a_17894_8436# 0
C256 sg13cmos5l_dlhr_1_9.D sg13cmos5l_dfrbp_1_16.Q 1.88527f
C257 a_7452_3174# VPWR 0
C258 sg13cmos5l_inv_1_0.Y a_11973_3911# 0.00142f
C259 a_10288_8678# a_10031_8797# 0.35645f
C260 sg13cmos5l_dfrbp_1_6.D a_4840_1664# 0.00462f
C261 sg13cmos5l_dfrbp_1_6.RESET_B sg13cmos5l_dlhr_1_11.D 0.02286f
C262 sg13cmos5l_dfrbp_1_29.Q_N sg13cmos5l_buf_1_44.A 0
C263 sg13cmos5l_nor2b_1_0.Y a_10618_3142# 0
C264 sg13cmos5l_dlhr_1_11.GATE sg13cmos5l_buf_1_95.X 0.00163f
C265 sg13cmos5l_dfrbp_1_18.Q sg13cmos5l_dlhr_1_6.Q_N 0
C266 sg13cmos5l_dfrbp_1_23.CLK a_14295_7282# 0.26131f
C267 a_19528_6924# sg13cmos5l_dlhr_1_10.Q 0.32141f
C268 a_18999_6178# a_19548_6198# 0
C269 a_19412_6484# a_19526_6600# 0.00122f
C270 a_10010_9196# cks 0
C271 cks pl_sw[6] 0.00836f
C272 sg13cmos5l_dfrbp_1_18.Q a_10484_6924# 0
C273 ph_sw[3] pl_sw[3] 0.15639f
C274 a_17414_3138# sg13cmos5l_dfrbp_1_0.Q 0
C275 sg13cmos5l_or2_1_0.A nl_sw[5] 0.00282f
C276 sg13cmos5l_nand2_1_2.B a_1290_3206# 0
C277 sg13cmos5l_dfrbp_1_23.CLK sg13cmos5l_nor2_1_0.A 0
C278 sg13cmos5l_dfrbp_1_0.CLK nh_sw[8] 0.02473f
C279 sg13cmos5l_dfrbp_1_6.RESET_B a_15887_8797# 0.00483f
C280 sg13cmos5l_dfrbp_1_20.Q_N pl_sw[5] 0.00295f
C281 sg13cmos5l_dfrbp_1_22.D sg13cmos5l_buf_1_105.A 0
C282 sg13cmos5l_buf_1_3.A a_19616_3986# 0.00457f
C283 a_9456_4972# VPWR 0
C284 sg13cmos5l_dfrbp_1_16.Q a_7892_3900# 0
C285 sg13cmos5l_dfrbp_1_8.RESET_B a_13648_9406# 0.18225f
C286 sg13cmos5l_nand2_1_0.B sg13cmos5l_nand2_1_0.A 0.13288f
C287 sg13cmos5l_buf_1_58.A a_1997_6126# 0.00162f
C288 a_2831_7630# a_2879_6432# 0
C289 a_20008_7712# a_20118_6144# 0
C290 a_10725_7653# a_11560_7010# 0.00434f
C291 sg13cmos5l_buf_1_63.X sg13cmos5l_inv_1_19.A 0.02024f
C292 a_3692_9150# a_3574_7850# 0
C293 a_13297_9263# a_13641_7674# 0
C294 a_4005_4629# sg13cmos5l_inv_1_19.A 0
C295 sg13cmos5l_dfrbp_1_6.D a_17882_7684# 0.00173f
C296 sg13cmos5l_nand2_1_1.A a_18057_3529# 0
C297 sg13cmos5l_buf_1_10.A a_14089_7282# 0
C298 sg13cmos5l_inv_1_0.A a_10789_4654# 0
C299 a_15062_4292# sg13cmos5l_nor2_1_1.A 0
C300 a_7820_9150# sg13cmos5l_inv_1_2.A 0
C301 sg13cmos5l_buf_1_41.A a_2148_3138# 0
C302 sg13cmos5l_nand2_1_2.B a_1402_3864# 0
C303 sg13cmos5l_dfrbp_1_8.RESET_B sg13cmos5l_dfrbp_1_18.Q_N 0.00345f
C304 sg13cmos5l_dfrbp_1_6.RESET_B a_4660_7312# 0.00598f
C305 a_2248_1664# sg13cmos5l_buf_1_39.A 0
C306 sg13cmos5l_buf_1_33.A a_3688_1664# 0.01557f
C307 a_2732_1590# a_3212_1590# 0.00377f
C308 a_5951_5383# a_6741_5459# 0.02241f
C309 a_5799_5499# a_6647_5459# 0.11742f
C310 sg13cmos5l_buf_1_101.X ph_sw[6] 0
C311 sg13cmos5l_dfrbp_1_0.D a_17674_3361# 0.01182f
C312 a_4324_7996# a_4349_7636# 0.65127f
C313 a_4076_7624# a_4559_7630# 0.00161f
C314 sg13cmos5l_inv_1_18.A a_7796_6460# 0
C315 sg13cmos5l_inv_1_8.A a_3814_4663# 0
C316 sg13cmos5l_inv_1_27.Y a_14708_6924# 0.00706f
C317 sg13cmos5l_dfrbp_1_23.Q a_14996_5412# 0
C318 a_13977_6477# VPWR 0
C319 sg13cmos5l_dfrbp_1_0.CLK a_18117_3117# 0.36025f
C320 sg13cmos5l_nand2_1_2.B a_1609_4704# 0.01855f
C321 a_15782_7362# a_16587_6935# 0.11742f
C322 a_12742_6175# sg13cmos5l_dfrbp_1_21.Q 0
C323 sg13cmos5l_buf_1_73.X a_9256_9224# 0
C324 sg13cmos5l_nand2_1_0.A nl_sw[6] 0.02478f
C325 sg13cmos5l_buf_1_79.X a_11272_8522# 0
C326 sg13cmos5l_inv_1_9.Y sg13cmos5l_inv_1_19.A 0
C327 sg13cmos5l_buf_1_6.A a_13556_2388# 0.00539f
C328 a_11979_2399# a_11973_1605# 0.00563f
C329 sg13cmos5l_dfrbp_1_8.RESET_B a_8468_4948# 0
C330 sg13cmos5l_buf_1_7.A a_12815_1703# 0.00151f
C331 a_17132_9150# a_17161_8794# 0
C332 sg13cmos5l_buf_1_104.X VPWR 0.2327f
C333 sg13cmos5l_inv_1_18.A a_8783_7751# 0.01808f
C334 sg13cmos5l_dfrbp_1_6.D sg13cmos5l_dlhr_1_18.Q_N 0.00296f
C335 sg13cmos5l_inv_1_14.A a_6959_6239# 0.0128f
C336 sg13cmos5l_buf_1_37.A nh_sw[1] 0.20686f
C337 sg13cmos5l_buf_1_65.X sg13cmos5l_dfrbp_1_6.RESET_B 0.00352f
C338 a_13100_8400# ph_sw[6] 0
C339 sg13cmos5l_dfrbp_1_6.RESET_B a_5908_3124# 0.0057f
C340 sg13cmos5l_buf_1_19.A a_19130_6172# 0.03664f
C341 sg13cmos5l_dfrbp_1_8.RESET_B a_2859_3260# 0.00401f
C342 a_2628_3151# sg13cmos5l_buf_1_41.X 0
C343 sg13cmos5l_or2_1_0.A a_13258_3361# 0
C344 sg13cmos5l_buf_1_5.A sg13cmos5l_buf_1_7.A 0.48065f
C345 sg13cmos5l_dfrbp_1_6.RESET_B a_5637_2399# 0.08777f
C346 a_18746_5776# sg13cmos5l_buf_8_0.A 0
C347 a_5674_6385# a_5700_6480# 0.43042f
C348 sg13cmos5l_dlhr_1_9.D a_4005_4629# 0.00348f
C349 sg13cmos5l_buf_1_29.A sg13cmos5l_nand2_1_1.B 0
C350 sg13cmos5l_inv_1_1.A a_15887_8797# 0.03747f
C351 a_8378_5776# VPWR 0.35926f
C352 sg13cmos5l_or2_1_0.A sg13cmos5l_dfrbp_1_0.CLK 0.41346f
C353 sg13cmos5l_buf_1_79.X a_8772_8440# 0.02031f
C354 sg13cmos5l_dfrbp_1_15.Q_N sg13cmos5l_inv_1_19.A 0.0043f
C355 sg13cmos5l_dfrbp_1_6.RESET_B a_8905_4704# 0.02828f
C356 sg13cmos5l_buf_1_18.A a_18219_3260# 0.0029f
C357 sg13cmos5l_dfrbp_1_4.Q_N VPWR 0.18009f
C358 a_20118_6144# a_19227_4654# 0.00202f
C359 sg13cmos5l_dfrbp_1_6.RESET_B nh_sw[1] 0
C360 sg13cmos5l_dfrbp_1_11.Q a_7452_3174# 0
C361 a_16271_7751# sg13cmos5l_dlhr_1_15.D 0.00596f
C362 a_16528_7894# a_16177_7751# 0.01017f
C363 sg13cmos5l_inv_1_7.A a_13072_4142# 0
C364 a_10116_7674# VPWR 0
C365 a_10412_6126# a_10318_5412# 0
C366 a_3664_8678# a_3313_8797# 0.01017f
C367 a_2565_8447# sg13cmos5l_dfrbp_1_15.D 0.00827f
C368 a_3407_8797# a_4244_8436# 0.1333f
C369 sg13cmos5l_dfrbp_1_8.RESET_B ph_sw[6] 0.04101f
C370 a_996_7349# sg13cmos5l_inv_1_19.A 0
C371 sg13cmos5l_inv_1_2.A a_16587_6935# 0.08993f
C372 sg13cmos5l_inv_1_8.A a_2638_6162# 0.00418f
C373 a_10071_7282# a_10318_5412# 0
C374 sg13cmos5l_buf_1_31.X sg13cmos5l_a22oi_1_0.B1 0
C375 VPWR sg13cmos5l_buf_1_61.X 0.3413f
C376 a_13768_8436# sg13cmos5l_inv_1_7.A 0
C377 sg13cmos5l_buf_1_96.A a_11272_8522# 0.06321f
C378 sg13cmos5l_buf_1_78.X a_7504_8678# 0
C379 sg13cmos5l_inv_1_8.A a_1967_5773# 0.00194f
C380 sg13cmos5l_inv_1_11.Y a_9823_2780# 0.0202f
C381 a_10220_3102# sg13cmos5l_a22oi_1_2.B1 0
C382 sg13cmos5l_dfrbp_1_16.Q sg13cmos5l_dlhr_1_7.Q_N 0
C383 a_14602_8404# VPWR 0.09577f
C384 sg13cmos5l_buf_1_24.A a_7863_7282# 0
C385 sg13cmos5l_buf_1_87.A a_19240_7712# 0.0033f
C386 a_19136_9318# sg13cmos5l_dlhr_1_15.Q 0
C387 a_11190_7354# sg13cmos5l_inv_1_0.A 0.00256f
C388 sg13cmos5l_buf_1_63.X a_904_7806# 0.05958f
C389 sg13cmos5l_and3_1_0.X a_12998_3138# 0
C390 a_9544_2474# VPWR 0.15164f
C391 sg13cmos5l_nand2_1_0.A a_11174_2826# 0.01359f
C392 a_1484_6126# a_1125_5423# 0.01014f
C393 sg13cmos5l_buf_1_77.X a_6507_8447# 0.004f
C394 a_1463_8741# a_1862_8874# 0
C395 a_708_5416# VPWR 0.07986f
C396 sg13cmos5l_dlhr_1_1.GATE a_4244_6924# 0.01023f
C397 sg13cmos5l_buf_1_3.A a_19240_7712# 0
C398 a_19340_8400# a_19624_8436# 0.13542f
C399 sg13cmos5l_dlhr_1_5.GATE sg13cmos5l_dlhr_1_6.D 0.87355f
C400 a_3962_7288# VPWR 0.35839f
C401 sg13cmos5l_dlhr_1_2.Q a_8214_1608# 0.00224f
C402 sg13cmos5l_dfrbp_1_6.RESET_B a_17414_3138# 0.00266f
C403 a_11464_9224# a_10725_7653# 0
C404 sg13cmos5l_buf_1_2.A sg13cmos5l_nand2_1_1.B 0.00391f
C405 a_10868_8436# sg13cmos5l_dfrbp_1_27.Q_N 0.25039f
C406 sg13cmos5l_dfrbp_1_10.Q a_7689_1626# 0
C407 sg13cmos5l_dlhr_1_5.GATE a_8412_7326# 0
C408 sg13cmos5l_buf_1_57.X sg13cmos5l_nor2b_1_0.Y 0
C409 sg13cmos5l_dlhr_1_0.D a_6572_1590# 0.0046f
C410 a_6479_2749# a_7226_1636# 0
C411 a_7316_2388# a_6889_1680# 0
C412 sg13cmos5l_buf_1_34.X a_5704_1664# 0.00266f
C413 a_20118_6144# a_20488_6294# 0.03916f
C414 sg13cmos5l_nand2_1_0.B sg13cmos5l_dfrbp_1_1.Q 0.00287f
C415 a_18486_8866# pl_sw[9] 0.00586f
C416 sg13cmos5l_nor2_1_2.A a_902_3142# 0
C417 sg13cmos5l_inv_1_14.A a_5770_3868# 0
C418 a_19216_3358# sg13cmos5l_dfrbp_1_0.Q 0
C419 a_3308_9150# sg13cmos5l_buf_1_64.A 0.00158f
C420 sg13cmos5l_buf_1_60.X sg13cmos5l_buf_1_34.X 0.02058f
C421 a_3676_7964# a_4311_7710# 0
C422 sg13cmos5l_nor2_1_1.A a_14476_2388# 0
C423 sg13cmos5l_inv_1_8.A a_4324_7996# 0
C424 a_17780_8436# ph_sw[8] 0
C425 sg13cmos5l_buf_1_96.A a_11370_5760# 0
C426 sg13cmos5l_buf_1_58.A a_2638_6477# 0
C427 a_11567_7751# a_12361_7282# 0
C428 sg13cmos5l_buf_1_0.A a_18219_3260# 0.02624f
C429 sg13cmos5l_inv_1_17.A sg13cmos5l_dfrbp_1_16.Q_N 0
C430 a_9524_4972# a_9660_4686# 0.00404f
C431 a_9705_4650# a_9940_4636# 0.00566f
C432 sg13cmos5l_buf_1_77.A a_8841_5769# 0.00539f
C433 a_10484_6924# cks 0
C434 a_6903_3154# VPWR 0.19128f
C435 sg13cmos5l_dfrbp_1_8.D a_18999_6178# 0.24846f
C436 a_1864_9224# a_2248_9224# 0.00492f
C437 a_16268_3102# a_16940_3102# 0
C438 a_4934_2826# sg13cmos5l_buf_1_24.X 0.00236f
C439 a_8233_6216# a_8378_5776# 0
C440 a_8570_6172# a_8041_5770# 0
C441 sg13cmos5l_dlhr_1_6.D a_8593_5814# 0
C442 sg13cmos5l_dfrbp_1_8.RESET_B a_8998_8861# 0
C443 a_8982_7354# a_8660_5412# 0
C444 a_8457_7281# a_8841_5769# 0
C445 sg13cmos5l_buf_1_5.X cks 0
C446 sg13cmos5l_dfrbp_1_1.Q nl_sw[6] 0.01756f
C447 sg13cmos5l_dfrbp_1_11.Q a_8378_5776# 0.00258f
C448 a_3212_1590# nl_sw[2] 0.00578f
C449 a_1192_1664# VPWR 0.25262f
C450 sg13cmos5l_inv_1_27.Y sg13cmos5l_buf_1_89.A 0
C451 sg13cmos5l_dfrbp_1_0.D a_18057_3529# 0
C452 a_11877_2399# sg13cmos5l_buf_1_8.A 0.00331f
C453 sg13cmos5l_buf_1_77.A sg13cmos5l_dlhr_1_5.Q_N 0.02997f
C454 sg13cmos5l_inv_1_18.A sg13cmos5l_dlhr_1_5.Q 0.02059f
C455 sg13cmos5l_buf_1_45.X a_8208_6924# 0
C456 a_16724_8436# a_17161_8794# 0.00347f
C457 a_10022_7674# sg13cmos5l_buf_1_56.A 0
C458 sg13cmos5l_nor2_1_0.A sg13cmos5l_buf_1_8.X 0.00794f
C459 a_16068_6928# a_17233_7285# 0.4858f
C460 a_904_7806# a_996_7349# 0
C461 a_1846_7850# a_1125_6935# 0.00595f
C462 a_2340_3456# a_3008_1758# 0
C463 a_13556_2388# a_12815_1703# 0.00617f
C464 a_12719_2749# a_13072_1846# 0
C465 a_8457_7281# sg13cmos5l_dlhr_1_5.Q_N 0.00294f
C466 sg13cmos5l_inv_1_29.Y a_11556_3904# 0.00156f
C467 sg13cmos5l_dfrbp_1_21.Q sg13cmos5l_inv_1_0.A 0.02931f
C468 sg13cmos5l_inv_1_18.A sg13cmos5l_dfrbp_1_20.Q 0.05095f
C469 a_14458_4270# sg13cmos5l_o21ai_1_0.B1 0.01489f
C470 sg13cmos5l_inv_1_14.A sg13cmos5l_dlhr_1_6.D 0
C471 sg13cmos5l_dfrbp_1_2.D nl_sw[5] 0
C472 a_18865_3215# VPWR 0.00183f
C473 sg13cmos5l_a221oi_1_0.B1 a_11370_5760# 0
C474 a_424_1664# nh_sw[0] 0
C475 sg13cmos5l_buf_1_19.X nh_sw[9] 0.05611f
C476 a_2621_7636# a_3574_7850# 0
C477 a_2831_7630# a_2790_7996# 0
C478 sg13cmos5l_or2_1_0.A a_13641_3529# 0
C479 a_9620_7972# a_9448_6924# 0
C480 a_2436_4325# VPWR 0.00961f
C481 sg13cmos5l_dfrbp_1_6.RESET_B a_6479_2749# 0.20876f
C482 sg13cmos5l_buf_1_5.A a_13556_2388# 0
C483 sg13cmos5l_inv_1_2.A a_13484_8400# 0.00142f
C484 sg13cmos5l_a221oi_1_1.C1 sg13cmos5l_nand2_1_0.A 0
C485 sg13cmos5l_a221oi_1_0.C1 sg13cmos5l_a22oi_1_0.B1 0.02468f
C486 a_2824_2388# a_3241_2746# 0.00364f
C487 a_6117_6141# a_6219_6284# 0.66105f
C488 a_5414_6162# a_5508_6162# 0.00718f
C489 sg13cmos5l_buf_1_0.X a_20288_2474# 0.05842f
C490 sg13cmos5l_dlhr_1_9.D a_4847_4727# 0.00507f
C491 sg13cmos5l_dfrbp_1_6.RESET_B a_11846_9186# 0
C492 sg13cmos5l_inv_1_20.Y sg13cmos5l_dfrbp_1_17.D 0.0031f
C493 sg13cmos5l_buf_1_60.X a_2122_8404# 0
C494 a_12651_9308# pl_sw[6] 0.00155f
C495 a_14342_8874# sg13cmos5l_buf_1_57.X 0
C496 a_12490_6385# sg13cmos5l_dfrbp_1_21.Q 0
C497 a_3669_6320# sg13cmos5l_inv_1_19.A 0.00421f
C498 sg13cmos5l_dfrbp_1_6.RESET_B a_18300_7710# 0.00211f
C499 sg13cmos5l_dfrbp_1_8.RESET_B a_2436_8861# 0.00946f
C500 sg13cmos5l_buf_1_79.X a_10031_8797# 0.00382f
C501 a_11002_3142# sg13cmos5l_dfrbp_1_4.D 0
C502 sg13cmos5l_dfrbp_1_4.D a_10696_1758# 0
C503 sg13cmos5l_dfrbp_1_6.D a_8570_6172# 0.01226f
C504 sg13cmos5l_dfrbp_1_16.Q a_6647_5459# 0.01957f
C505 sg13cmos5l_buf_1_31.X sg13cmos5l_buf_1_25.A 0.00516f
C506 sg13cmos5l_nor2b_1_1.Y nh_sw[6] 0
C507 sg13cmos5l_buf_1_45.X a_8680_1664# 0
C508 sg13cmos5l_dfrbp_1_6.D a_18368_4782# 0.00403f
C509 sg13cmos5l_buf_1_2.A sg13cmos5l_a22oi_1_1.A1 0.03882f
C510 a_11473_7751# VPWR 0.00111f
C511 sg13cmos5l_dfrbp_1_6.RESET_B a_6507_8447# 0.00456f
C512 sg13cmos5l_dfrbp_1_6.RESET_B a_5492_3460# 0.12878f
C513 sg13cmos5l_dlhr_1_0.GATE a_5796_3904# 0.03337f
C514 sg13cmos5l_inv_1_18.A sg13cmos5l_dlhr_1_9.D 0.02211f
C515 sg13cmos5l_dlhr_1_1.GATE cks 0.00972f
C516 sg13cmos5l_inv_1_8.A a_6117_6141# 0.01809f
C517 sg13cmos5l_dfrbp_1_6.RESET_B a_3447_2746# 0.00387f
C518 sg13cmos5l_or2_1_1.B sg13cmos5l_inv_1_0.A 0.0838f
C519 sg13cmos5l_dlhr_1_6.Q_N a_9524_4972# 0
C520 sg13cmos5l_buf_1_29.A a_9705_4650# 0.07258f
C521 a_13686_7354# a_13681_6239# 0
C522 a_16144_8678# VPWR 0.14717f
C523 sg13cmos5l_inv_1_20.Y ph_sw[0] 0
C524 sg13cmos5l_inv_1_17.A a_4176_6924# 0
C525 a_7941_7653# a_8043_7796# 0.66105f
C526 sg13cmos5l_dfrbp_1_6.RESET_B a_6789_4629# 0
C527 sg13cmos5l_dfrbp_1_11.Q a_6903_3154# 0
C528 sg13cmos5l_buf_1_44.X sg13cmos5l_dfrbp_1_6.D 0.59869f
C529 sg13cmos5l_buf_1_78.A a_6380_7638# 0.16765f
C530 sg13cmos5l_nand2_1_0.A a_11072_2474# 0.00359f
C531 sg13cmos5l_buf_1_10.A sg13cmos5l_dfrbp_1_0.RESET_B 0.02838f
C532 sg13cmos5l_buf_1_4.X nl_sw[8] 0
C533 a_18164_7996# cks 0.00212f
C534 sg13cmos5l_nand2_1_1.B sg13cmos5l_buf_1_6.A 1.271f
C535 a_7336_9224# sg13cmos5l_dfrbp_1_8.RESET_B 0
C536 a_12230_6162# a_12216_5728# 0
C537 sg13cmos5l_buf_1_31.X a_5408_3986# 0
C538 a_2554_8112# sg13cmos5l_inv_1_19.A 0
C539 a_11464_8436# a_11848_8436# 0.00492f
C540 a_10031_8797# sg13cmos5l_buf_1_96.A 0
C541 a_2804_6924# a_3625_7282# 0
C542 a_2224_7166# a_2169_7047# 0.00464f
C543 sg13cmos5l_dfrbp_1_22.D a_17545_7728# 0.03887f
C544 sg13cmos5l_dlhr_1_0.D a_6889_1680# 0.17074f
C545 a_12567_7282# a_12490_6385# 0
C546 sg13cmos5l_buf_1_34.X a_5600_1758# 0.05983f
C547 rdy pl_sw[0] 1.31032f
C548 sg13cmos5l_dfrbp_1_2.D sg13cmos5l_dfrbp_1_0.CLK 0.00225f
C549 sg13cmos5l_inv_1_14.A a_7312_4142# 0.02636f
C550 sg13cmos5l_buf_1_24.A sg13cmos5l_buf_1_26.A 0
C551 sg13cmos5l_buf_1_40.X sg13cmos5l_inv_1_19.A 0.0342f
C552 sg13cmos5l_nor2_1_1.A a_17588_2388# 0.17754f
C553 sg13cmos5l_dfrbp_1_20.Q_N a_10010_9196# 0
C554 sg13cmos5l_inv_1_29.A a_13876_7660# 0
C555 sg13cmos5l_dfrbp_1_6.RESET_B a_1006_4167# 0.00374f
C556 a_12616_5498# a_12704_4782# 0.00273f
C557 sg13cmos5l_dfrbp_1_21.Q_N a_18615_5770# 0.0033f
C558 sg13cmos5l_buf_1_107.X sg13cmos5l_buf_1_19.A 0.00169f
C559 sg13cmos5l_dfrbp_1_6.RESET_B a_18272_9318# 0.00301f
C560 sg13cmos5l_buf_8_0.A a_19161_3453# 0
C561 sg13cmos5l_dlhr_1_11.D a_12361_7282# 0.14142f
C562 a_3308_9150# VPWR 0.24701f
C563 a_15909_2399# cks 0.00809f
C564 sg13cmos5l_dfrbp_1_23.CLK a_14726_7674# 0.00153f
C565 sg13cmos5l_inv_1_0.Y a_11488_4676# 0
C566 a_19227_4654# a_20008_3900# 0.00645f
C567 a_5628_3174# VPWR 0
C568 sg13cmos5l_nor2_1_1.A a_17829_1605# 0.00114f
C569 a_5069_5376# a_5132_3864# 0.00101f
C570 sg13cmos5l_buf_1_87.A pl_sw[8] 0
C571 a_17493_3947# sg13cmos5l_nor2_1_1.A 0
C572 sg13cmos5l_dfrbp_1_18.Q a_8852_6484# 0
C573 sg13cmos5l_dfrbp_1_6.RESET_B a_1815_4666# 0.00407f
C574 a_5220_2392# VPWR 0.08132f
C575 sg13cmos5l_dfrbp_1_8.RESET_B a_10450_8874# 0
C576 sg13cmos5l_dfrbp_1_6.D a_16677_6141# 0.01093f
C577 a_13076_5376# VPWR 0.24541f
C578 a_19209_5769# d_out[2] 0
C579 a_12976_2630# sg13cmos5l_buf_1_8.A 0.0017f
C580 sg13cmos5l_buf_1_103.A a_15429_7653# 0
C581 sg13cmos5l_dfrbp_1_22.D sg13cmos5l_dlhr_1_12.D 0.77522f
C582 a_9111_4666# VPWR 0.2081f
C583 sg13cmos5l_buf_1_90.X a_12132_9504# 0.04592f
C584 sg13cmos5l_dfrbp_1_15.D sg13cmos5l_buf_1_41.A 0.07071f
C585 a_17327_7285# a_18164_6924# 0.1333f
C586 a_17584_7166# a_17233_7285# 0.01017f
C587 sg13cmos5l_buf_1_29.A sg13cmos5l_or2_1_0.A 0.02595f
C588 a_5796_8874# VPWR 0
C589 a_1480_7806# a_1125_6935# 0.0141f
C590 sg13cmos5l_nand2_1_1.A sg13cmos5l_buf_1_4.X 0.02726f
C591 sg13cmos5l_dfrbp_1_6.D a_14295_7282# 0.00324f
C592 sg13cmos5l_dlhr_1_0.GATE sg13cmos5l_dlhr_1_0.Q 0
C593 sg13cmos5l_dfrbp_1_8.RESET_B a_16356_7349# 0
C594 sg13cmos5l_a22oi_1_1.A1 sg13cmos5l_dfrbp_1_6.Q_N 0.00703f
C595 a_12998_3138# a_13572_3151# 0.36169f
C596 sg13cmos5l_buf_1_101.X sg13cmos5l_buf_1_107.X 0.42603f
C597 sg13cmos5l_buf_1_79.X sg13cmos5l_dlhr_1_11.Q 0
C598 sg13cmos5l_inv_1_26.Y sg13cmos5l_buf_1_104.A 0.53529f
C599 sg13cmos5l_buf_1_111.A a_19136_9318# 0
C600 sg13cmos5l_buf_1_93.X pl_sw[8] 0.0029f
C601 a_16293_4629# sg13cmos5l_buf_1_4.X 0.00285f
C602 a_16395_4772# a_16940_3102# 0
C603 a_2831_7630# sg13cmos5l_dfrbp_1_16.Q_N 0.13436f
C604 a_17751_7690# a_18300_7710# 0
C605 sg13cmos5l_inv_1_3.A a_13161_7281# 0.00199f
C606 sg13cmos5l_dfrbp_1_6.RESET_B a_5577_2435# 0
C607 sg13cmos5l_dfrbp_1_8.RESET_B sg13cmos5l_buf_1_41.X 0
C608 sg13cmos5l_dfrbp_1_6.D sg13cmos5l_nor2_1_0.A 0
C609 a_2505_3947# VPWR 0
C610 sg13cmos5l_inv_1_2.A a_15590_4650# 0.00446f
C611 sg13cmos5l_dfrbp_1_0.CLK sg13cmos5l_dfrbp_1_7.Q_N 0.04347f
C612 sg13cmos5l_dlhr_1_9.D sg13cmos5l_dfrbp_1_14.Q_N 0.00256f
C613 a_5700_6480# a_5926_6175# 0.00523f
C614 a_6219_6284# a_7161_6477# 0
C615 a_6117_6141# a_5988_6175# 0.01562f
C616 ph_sw[0] sg13cmos5l_buf_1_68.X 0.40997f
C617 sg13cmos5l_a221oi_1_0.C1 sg13cmos5l_dlhr_1_20.Q_N 0.04479f
C618 sg13cmos5l_buf_1_60.X a_3407_8797# 0.00248f
C619 sg13cmos5l_dfrbp_1_6.D a_18146_4338# 0
C620 sg13cmos5l_dfrbp_1_6.RESET_B a_13648_9406# 0
C621 sg13cmos5l_nand2_1_1.B a_16751_2749# 0
C622 sg13cmos5l_buf_1_5.A a_12404_7972# 0
C623 sg13cmos5l_buf_1_40.X sg13cmos5l_buf_1_33.A 0
C624 a_13775_6239# sg13cmos5l_dfrbp_1_21.Q 0
C625 sg13cmos5l_buf_1_79.X a_11848_8436# 0.00165f
C626 sg13cmos5l_buf_1_76.X ph_sw[2] 0
C627 a_14228_9484# pl_sw[8] 0
C628 a_8488_9224# a_8043_7796# 0
C629 sg13cmos5l_buf_1_77.A a_7524_7992# 0.00835f
C630 a_3308_5376# sg13cmos5l_inv_1_19.A 0.00847f
C631 a_17224_3270# VPWR 0.14298f
C632 a_1862_4338# VPWR 0.94912f
C633 sg13cmos5l_dlhr_1_9.D a_6843_5459# 0
C634 a_12216_5728# a_11771_5412# 0
C635 sg13cmos5l_or2_1_1.B a_10420_5412# 0.00681f
C636 a_9673_9240# a_8772_8440# 0
C637 a_9879_9202# a_9189_8447# 0.00961f
C638 sg13cmos5l_dfrbp_1_6.RESET_B sg13cmos5l_dfrbp_1_18.Q_N 0.00135f
C639 sg13cmos5l_inv_1_7.A a_13284_3456# 0
C640 sg13cmos5l_dlhr_1_0.GATE a_7055_4261# 0
C641 a_1846_7850# a_1948_7964# 0.13715f
C642 a_7941_7653# a_8276_6924# 0.00443f
C643 a_7524_7992# a_8457_7281# 0
C644 a_2859_3260# sg13cmos5l_buf_1_37.A 0
C645 sg13cmos5l_dfrbp_1_6.RESET_B a_3996_2790# 0
C646 sg13cmos5l_buf_1_95.X a_12420_9199# 0.0202f
C647 sg13cmos5l_buf_1_94.X a_17896_9224# 0
C648 a_17516_9150# sg13cmos5l_inv_1_26.Y 0
C649 sg13cmos5l_dfrbp_1_1.Q a_11072_2474# 0
C650 a_14426_7288# sg13cmos5l_dfrbp_1_23.Q_N 0
C651 sg13cmos5l_dfrbp_1_23.Q a_13681_6239# 0.0202f
C652 sg13cmos5l_buf_1_2.A sg13cmos5l_or2_1_0.A 0.0176f
C653 sg13cmos5l_dfrbp_1_22.D VPWR 0.84923f
C654 sg13cmos5l_buf_1_110.A a_15045_8447# 0.01984f
C655 sg13cmos5l_buf_1_8.X sg13cmos5l_o21ai_1_0.Y 0.00247f
C656 sg13cmos5l_dfrbp_1_0.RESET_B a_11686_2813# 0
C657 sg13cmos5l_buf_1_9.A a_10331_1924# 0.01156f
C658 a_3692_9150# ph_sw[1] 0.00152f
C659 sg13cmos5l_buf_1_44.X a_4950_7354# 0.01472f
C660 a_7238_7674# a_7812_7687# 0.36169f
C661 a_8043_7796# a_9040_7894# 0.06778f
C662 sg13cmos5l_dfrbp_1_6.RESET_B a_8468_4948# 0.03474f
C663 sg13cmos5l_nand2_1_0.A a_12625_2749# 0
C664 sg13cmos5l_dfrbp_1_8.RESET_B sg13cmos5l_nor2_1_2.A 0.00282f
C665 VPWR a_616_9224# 0.25471f
C666 a_15784_9224# sg13cmos5l_buf_1_93.X 0.00645f
C667 sg13cmos5l_inv_1_1.A a_16748_9150# 0
C668 sg13cmos5l_nand2_1_1.B a_12815_1703# 0
C669 sg13cmos5l_o21ai_1_0.A1 a_11877_2399# 0.01198f
C670 sg13cmos5l_dfrbp_1_6.RESET_B a_2859_3260# 0.5576f
C671 a_13775_6239# sg13cmos5l_or2_1_1.B 0
C672 sg13cmos5l_inv_1_11.Y sg13cmos5l_buf_1_28.X 0.05555f
C673 sg13cmos5l_buf_1_63.X a_416_7806# 0
C674 sg13cmos5l_dfrbp_1_10.Q a_8576_1758# 0
C675 sg13cmos5l_dfrbp_1_16.Q a_3488_7010# 0.03507f
C676 sg13cmos5l_dlhr_1_0.D a_9448_1664# 0.00328f
C677 a_13161_7281# a_12516_6480# 0
C678 a_12980_6924# a_12933_6141# 0.01135f
C679 sg13cmos5l_buf_1_29.A a_11072_5347# 0
C680 sg13cmos5l_dfrbp_1_11.Q a_9111_4666# 0.23037f
C681 sg13cmos5l_dlhr_1_9.D a_3308_5376# 0.0087f
C682 a_1484_6126# a_708_5416# 0
C683 a_10665_7281# a_11072_5347# 0
C684 sg13cmos5l_inv_1_14.A a_8972_3864# 0.00378f
C685 sg13cmos5l_buf_1_5.A sg13cmos5l_nand2_1_1.B 0.32044f
C686 a_9366_5842# sg13cmos5l_a221oi_1_1.C1 0
C687 a_11782_1639# nh_sw[5] 0
C688 sg13cmos5l_buf_1_65.X a_3016_9318# 0.00207f
C689 sg13cmos5l_dlhr_1_5.GATE a_6998_5837# 0
C690 sg13cmos5l_dfrbp_1_6.D a_1878_6337# 0
C691 sg13cmos5l_dfrbp_1_6.RESET_B sg13cmos5l_inv_1_29.Y 0.00117f
C692 a_20008_3900# a_20392_3900# 0.00492f
C693 sg13cmos5l_dlhr_1_11.GATE sg13cmos5l_buf_1_10.A 0.32939f
C694 a_682_5380# VPWR 0.09696f
C695 sg13cmos5l_dlhr_1_15.D sg13cmos5l_dlhr_1_6.D 0.00201f
C696 sg13cmos5l_buf_1_44.X a_5194_2356# 0
C697 sg13cmos5l_dfrbp_1_6.RESET_B ph_sw[6] 0
C698 a_13161_7281# cks 0
C699 sg13cmos5l_dfrbp_1_0.D a_18122_2388# 0.01307f
C700 sg13cmos5l_dlhr_1_9.Q a_3625_7282# 0.01612f
C701 sg13cmos5l_buf_1_56.A a_11752_6294# 0
C702 a_10412_6126# sg13cmos5l_inv_1_29.Y 0
C703 sg13cmos5l_buf_1_90.X sg13cmos5l_buf_1_93.X 0.00158f
C704 a_9940_4636# sg13cmos5l_dfrbp_1_2.D 0
C705 sg13cmos5l_dfrbp_1_6.RESET_B a_1472_4782# 0
C706 sg13cmos5l_dlhr_1_9.Q sg13cmos5l_dfrbp_1_6.D 0
C707 a_6736_2630# VPWR 0.14988f
C708 sg13cmos5l_dfrbp_1_10.Q VPWR 0.89351f
C709 sg13cmos5l_dfrbp_1_8.RESET_B a_13100_8400# 0.00732f
C710 a_16551_3987# a_17224_3270# 0
C711 a_8588_3864# sg13cmos5l_buf_1_26.X 0
C712 sg13cmos5l_dfrbp_1_6.D a_17721_6477# 0.00148f
C713 sg13cmos5l_buf_1_24.A a_7497_3138# 0
C714 a_6188_1590# nl_sw[3] 0.00162f
C715 a_10433_1652# nh_sw[5] 0
C716 sg13cmos5l_buf_1_44.X a_5702_8874# 0.00102f
C717 sg13cmos5l_and3_1_0.X VPWR 0.4577f
C718 sg13cmos5l_a22oi_1_1.A1 a_16751_2749# 0
C719 a_14254_2444# sg13cmos5l_buf_1_8.A 0.09362f
C720 a_17354_4180# cks 0
C721 sg13cmos5l_buf_1_79.X pl_sw[5] 0.00397f
C722 sg13cmos5l_dlhr_1_1.GATE a_422_7362# 0
C723 sg13cmos5l_inv_1_0.Y VPWR 0.39197f
C724 sg13cmos5l_buf_1_57.X a_12933_6141# 0.01422f
C725 sg13cmos5l_inv_1_8.A a_5408_3986# 0
C726 sg13cmos5l_buf_1_90.X a_14228_9484# 0
C727 sg13cmos5l_nand2_1_0.B sg13cmos5l_a22oi_1_0.B1 0.01361f
C728 sg13cmos5l_buf_1_87.A a_17161_8794# 0
C729 a_4559_7630# sg13cmos5l_dlhr_1_9.D 0.13917f
C730 a_10725_7653# ph_sw[5] 0
C731 a_17233_7285# sg13cmos5l_dfrbp_1_8.D 0
C732 a_6276_8861# VPWR 0.00674f
C733 sg13cmos5l_nor2b_1_0.Y sg13cmos5l_dfrbp_1_0.RESET_B 0.09748f
C734 sg13cmos5l_nor2_1_1.A a_16268_1590# 0
C735 a_14254_2444# sg13cmos5l_buf_1_1.A 0
C736 sg13cmos5l_dfrbp_1_16.Q sg13cmos5l_inv_1_0.A 0
C737 a_5673_3138# VPWR 0.63501f
C738 a_908_1590# VPWR 0.25273f
C739 sg13cmos5l_a22oi_1_1.A1 a_17750_4325# 0
C740 sg13cmos5l_inv_1_26.Y pl_sw[10] 0
C741 sg13cmos5l_a22oi_1_1.Y sg13cmos5l_nor2_1_1.A 0
C742 a_4566_2818# a_4456_1664# 0
C743 a_8488_9224# a_8972_9150# 0.03472f
C744 sg13cmos5l_buf_1_33.A sg13cmos5l_buf_1_39.A 0.21595f
C745 sg13cmos5l_dlhr_1_15.D a_13698_5412# 0.00817f
C746 sg13cmos5l_dfrbp_1_0.D sg13cmos5l_buf_1_4.X 0.02402f
C747 sg13cmos5l_inv_1_3.A a_14426_7288# 0
C748 sg13cmos5l_dlhr_1_15.Q a_18580_7660# 0
C749 a_19227_4654# sg13cmos5l_nand2_1_1.A 0.00736f
C750 sg13cmos5l_or2_1_0.A sg13cmos5l_dfrbp_1_6.Q_N 0.00225f
C751 a_1846_7850# a_708_6928# 0
C752 sg13cmos5l_inv_1_2.A a_17392_4870# 0.00214f
C753 a_6372_4968# VPWR 0.07282f
C754 sg13cmos5l_inv_1_14.A a_6998_5837# 0
C755 a_7216_6382# a_6865_6239# 0.01017f
C756 a_6959_6239# sg13cmos5l_dlhr_1_6.D 0.00411f
C757 sg13cmos5l_dfrbp_1_16.Q a_3664_4142# 0
C758 sg13cmos5l_inv_1_8.Y a_1609_4704# 0
C759 nh_sw[10] nl_sw[10] 0.07697f
C760 VPWR ckc 0.13098f
C761 sg13cmos5l_buf_1_76.X sg13cmos5l_buf_1_78.X 0.00683f
C762 sg13cmos5l_buf_1_77.X a_7336_9224# 0.32217f
C763 sg13cmos5l_buf_1_32.X nl_sw[2] 0
C764 a_8209_7326# a_8276_6924# 0.0018f
C765 sg13cmos5l_dfrbp_1_1.D a_11844_1639# 0
C766 sg13cmos5l_dfrbp_1_6.D a_2161_4642# 0
C767 sg13cmos5l_buf_1_77.A a_8783_7751# 0.03345f
C768 sg13cmos5l_dfrbp_1_8.RESET_B a_15414_7354# 0.00489f
C769 sg13cmos5l_inv_1_1.A ph_sw[6] 0
C770 sg13cmos5l_buf_1_111.A a_16724_8436# 0
C771 a_18959_3215# VPWR 0.27853f
C772 sg13cmos5l_buf_1_44.X ph_sw[3] 0.00174f
C773 a_9673_9240# a_10031_8797# 0
C774 a_10010_9196# a_10288_8678# 0.005f
C775 sg13cmos5l_inv_1_3.A a_13641_7674# 0.03246f
C776 sg13cmos5l_dfrbp_1_6.RESET_B a_19130_6172# 0.00386f
C777 a_2596_7996# a_2831_7630# 0.64635f
C778 a_1846_7850# a_1664_7806# 0.04055f
C779 sg13cmos5l_or2_1_0.A sg13cmos5l_buf_1_6.A 0
C780 sg13cmos5l_inv_1_27.Y a_10665_7281# 0
C781 a_2628_3151# sg13cmos5l_buf_1_37.A 0
C782 a_8783_7751# a_8457_7281# 0
C783 sg13cmos5l_buf_1_5.A sg13cmos5l_a22oi_1_1.A1 0
C784 sg13cmos5l_a221oi_1_0.A2 a_10433_4248# 0
C785 a_5510_4338# a_6213_3911# 0.02431f
C786 sg13cmos5l_dfrbp_1_1.Q a_12625_2749# 0
C787 sg13cmos5l_buf_1_29.A sg13cmos5l_dfrbp_1_2.D 0.0397f
C788 a_6380_7638# cks 0.00279f
C789 a_13072_4142# a_12721_4261# 0.01017f
C790 a_12815_4261# a_13652_3900# 0.1333f
C791 sg13cmos5l_buf_1_9.A a_12075_1748# 0
C792 a_14889_7281# a_14844_7326# 0
C793 sg13cmos5l_buf_1_45.A a_8972_3864# 0.32041f
C794 sg13cmos5l_dfrbp_1_8.RESET_B a_1662_8374# 0.00538f
C795 sg13cmos5l_nor2_1_0.A a_11873_5760# 0
C796 a_3976_9224# ph_sw[2] 0.29415f
C797 sg13cmos5l_dlhr_1_15.Q frame 0
C798 a_19340_8400# sg13cmos5l_buf_1_18.A 0
C799 a_8783_7751# a_8985_7989# 0.00675f
C800 sg13cmos5l_dfrbp_1_1.D a_10331_1924# 0.00431f
C801 sg13cmos5l_dlhr_1_17.Q_N a_9111_4666# 0
C802 a_16751_2749# nh_sw[8] 0.0455f
C803 a_17961_8793# a_18164_6924# 0
C804 sg13cmos5l_dfrbp_1_3.Q_N a_19628_2352# 0
C805 sg13cmos5l_buf_1_65.X pl_sw[2] 0.10561f
C806 sg13cmos5l_dfrbp_1_8.D sg13cmos5l_buf_1_2.X 0
C807 sg13cmos5l_dfrbp_1_11.Q sg13cmos5l_dfrbp_1_10.Q 0
C808 sg13cmos5l_dfrbp_1_11.Q a_6736_2630# 0
C809 sg13cmos5l_dfrbp_1_6.RESET_B a_2628_3151# 0.00454f
C810 sg13cmos5l_inv_1_14.A a_7452_3174# 0
C811 sg13cmos5l_dlhr_1_1.GATE a_2409_4650# 0
C812 a_11270_4338# a_12815_4261# 0
C813 a_11530_3868# a_12075_3911# 0.00999f
C814 sg13cmos5l_nand2_1_1.B a_14814_4292# 0
C815 a_12216_5728# a_11072_5347# 0.0012f
C816 a_9558_6144# a_9705_4650# 0.00288f
C817 a_17412_1944# nh_sw[8] 0.00333f
C818 sg13cmos5l_buf_1_31.X sg13cmos5l_a22oi_1_0.Y 0
C819 a_16617_6553# cks 0
C820 sg13cmos5l_dfrbp_1_16.Q sg13cmos5l_buf_1_59.A 0
C821 sg13cmos5l_inv_1_11.Y sg13cmos5l_a22oi_1_2.B1 0.18013f
C822 sg13cmos5l_dfrbp_1_23.Q a_12230_6162# 0
C823 sg13cmos5l_inv_1_7.A a_12520_4782# 0.00242f
C824 sg13cmos5l_dlhr_1_0.D a_7644_1662# 0.00152f
C825 sg13cmos5l_inv_1_2.A sg13cmos5l_dlhr_1_21.Q_N 0.00775f
C826 sg13cmos5l_buf_1_107.X a_18096_7996# 0
C827 sg13cmos5l_buf_1_87.A sg13cmos5l_dlhr_1_15.Q 0.31482f
C828 sg13cmos5l_buf_1_3.A sg13cmos5l_dfrbp_1_21.Q 0
C829 sg13cmos5l_dfrbp_1_6.RESET_B a_2436_8861# 0
C830 a_6405_8447# ph_sw[4] 0.00174f
C831 sg13cmos5l_dfrbp_1_22.D a_16260_6480# 0
C832 sg13cmos5l_dlhr_1_5.GATE a_8378_5776# 0.00123f
C833 a_13035_6284# sg13cmos5l_nor2_1_0.A 0
C834 cks nh_sw[7] 0
C835 sg13cmos5l_nand2_1_0.A sg13cmos5l_dfrbp_1_4.D 0.01599f
C836 sg13cmos5l_buf_1_57.X a_10230_4632# 0
C837 a_16268_3102# nl_sw[8] 0.28895f
C838 sg13cmos5l_buf_1_30.A sg13cmos5l_inv_1_11.Y 0
C839 a_16264_9224# VPWR 0.25277f
C840 sg13cmos5l_buf_1_63.A a_1862_8874# 0
C841 a_1463_8741# sg13cmos5l_dfrbp_1_17.D 0.00325f
C842 a_3588_4968# a_3407_4261# 0.00962f
C843 a_4005_4629# a_3664_4142# 0
C844 sg13cmos5l_inv_1_0.A sg13cmos5l_a22oi_1_1.Y 0
C845 sg13cmos5l_buf_1_3.A sg13cmos5l_dlhr_1_15.Q 0
C846 a_14426_7288# cks 0
C847 a_2348_7624# sg13cmos5l_inv_1_19.A 0
C848 a_10998_9168# a_10827_7796# 0
C849 sg13cmos5l_inv_1_28.Y a_10725_7653# 0.0021f
C850 a_18117_3117# a_17412_1944# 0
C851 a_6898_2826# VPWR 0
C852 a_17700_3456# a_17829_1605# 0
C853 sg13cmos5l_buf_1_34.X sg13cmos5l_buf_1_24.X 0.07509f
C854 sg13cmos5l_buf_1_19.A sg13cmos5l_dfrbp_1_0.Q 0.01977f
C855 sg13cmos5l_dfrbp_1_11.Q a_6372_4968# 0.04377f
C856 sg13cmos5l_buf_1_34.X sg13cmos5l_dlhr_1_1.GATE 0.02627f
C857 sg13cmos5l_dfrbp_1_8.RESET_B a_15850_4873# 0.34667f
C858 sg13cmos5l_buf_1_24.A a_7248_3460# 0
C859 sg13cmos5l_inv_1_20.Y sg13cmos5l_buf_1_64.A 0
C860 a_13391_9263# VPWR 0.25237f
C861 sg13cmos5l_buf_1_60.X sg13cmos5l_buf_1_60.A 0.00533f
C862 sg13cmos5l_inv_1_3.A sg13cmos5l_nand2_1_0.A 0
C863 a_14377_5770# a_14714_5776# 0.64635f
C864 sg13cmos5l_buf_1_57.X a_15208_6200# 0.00888f
C865 sg13cmos5l_inv_1_8.A a_6961_4261# 0
C866 sg13cmos5l_dfrbp_1_16.Q a_10420_5412# 0.00763f
C867 sg13cmos5l_inv_1_6.A sg13cmos5l_dfrbp_1_8.Q_N 0
C868 a_8041_5770# a_8660_5412# 0.00161f
C869 a_8247_5770# a_8841_5769# 0.09085f
C870 a_6647_5459# a_6843_5459# 0.00806f
C871 a_8378_5776# a_8593_5814# 0.00284f
C872 a_1196_8400# cks 0.04217f
C873 sg13cmos5l_buf_8_0.A a_18219_3260# 0
C874 a_19227_9190# sg13cmos5l_buf_1_86.A 0.00102f
C875 a_13641_7674# cks 0.00654f
C876 sg13cmos5l_buf_1_101.X ph_sw[10] 0
C877 sg13cmos5l_dfrbp_1_16.Q a_9242_4660# 0
C878 sg13cmos5l_buf_1_65.X sg13cmos5l_dlhr_1_9.Q_N 0
C879 sg13cmos5l_inv_1_0.Y a_12814_4692# 0.01045f
C880 sg13cmos5l_a221oi_1_0.B1 a_11270_4338# 0
C881 sg13cmos5l_dlhr_1_20.Q_N sg13cmos5l_nand2_1_0.B 0
C882 sg13cmos5l_or2_1_0.A a_16751_2749# 0
C883 sg13cmos5l_dlhr_1_2.D VPWR 0.2707f
C884 a_1864_9224# sg13cmos5l_buf_1_60.X 0.0388f
C885 sg13cmos5l_dlhr_1_1.Q a_3313_4261# 0
C886 a_1463_8741# ph_sw[0] 0
C887 sg13cmos5l_nand2_1_1.A a_20392_3900# 0
C888 a_14602_8404# a_14536_7806# 0.00568f
C889 sg13cmos5l_buf_1_5.A a_14032_6382# 0.02699f
C890 a_4566_2818# VPWR 0.25587f
C891 a_5220_2392# sg13cmos5l_buf_1_25.X 0.0013f
C892 sg13cmos5l_inv_1_6.A a_20204_5376# 0.29234f
C893 a_6405_8447# sg13cmos5l_buf_1_24.A 0.0064f
C894 a_18860_9150# sg13cmos5l_buf_1_105.A 0.00278f
C895 sg13cmos5l_buf_1_45.X a_8852_6484# 0.00164f
C896 a_8204_9150# ph_sw[4] 0.00207f
C897 a_3860_2388# nh_sw[2] 0
C898 sg13cmos5l_buf_1_77.A sg13cmos5l_dlhr_1_5.Q 0.23965f
C899 a_14628_8440# ph_sw[7] 0
C900 a_7888_4870# VPWR 0.14778f
C901 a_1480_7806# a_708_6928# 0
C902 a_4172_1590# nh_sw[1] 0
C903 a_15016_6294# a_14583_5770# 0.01033f
C904 sg13cmos5l_nor2_1_0.A sg13cmos5l_buf_1_9.A 0.00894f
C905 sg13cmos5l_buf_1_59.A a_4005_4629# 0.00214f
C906 pl_sw[1] pl_sw[2] 0.00119f
C907 sg13cmos5l_nand2_1_1.A a_16268_3102# 0.00742f
C908 sg13cmos5l_dfrbp_1_0.RESET_B a_17988_3151# 0.00469f
C909 sg13cmos5l_dfrbp_1_6.D a_14726_7674# 0.00192f
C910 a_8457_7281# sg13cmos5l_dlhr_1_5.Q 0.28569f
C911 a_2757_3117# VPWR 0.26438f
C912 ph_sw[1] a_1000_9224# 0
C913 sg13cmos5l_buf_1_7.A sg13cmos5l_o21ai_1_0.B1 0.02424f
C914 sg13cmos5l_a22oi_1_1.A1 a_14814_4292# 0.00827f
C915 sg13cmos5l_buf_1_77.A sg13cmos5l_dfrbp_1_20.Q 0.00144f
C916 sg13cmos5l_inv_1_27.Y a_12216_5728# 0
C917 sg13cmos5l_dfrbp_1_6.RESET_B a_10450_8874# 0
C918 sg13cmos5l_buf_1_73.X ph_sw[4] 0.00617f
C919 a_11464_8436# pl_sw[6] 0
C920 sg13cmos5l_inv_1_3.A a_14986_7897# 0
C921 sg13cmos5l_buf_1_18.X nh_sw[9] 0.06299f
C922 sg13cmos5l_inv_1_27.Y a_11560_7010# 0
C923 a_1480_7806# a_1664_7806# 0.11523f
C924 sg13cmos5l_dlhr_1_8.Q_N sg13cmos5l_buf_1_58.A 0.04546f
C925 a_15876_4968# sg13cmos5l_buf_1_2.X 0
C926 a_16293_4629# a_16268_3102# 0
C927 sg13cmos5l_dfrbp_1_20.Q a_8457_7281# 0
C928 sg13cmos5l_dlhr_1_11.Q_N sg13cmos5l_and3_1_0.X 0
C929 sg13cmos5l_dfrbp_1_6.D a_8660_5412# 0
C930 sg13cmos5l_a221oi_1_0.C1 sg13cmos5l_a22oi_1_0.Y 0.06421f
C931 a_6213_3911# a_6084_4325# 0.01562f
C932 a_5796_3904# a_6315_3911# 0.38871f
C933 sg13cmos5l_buf_1_32.A a_3241_2746# 0
C934 sg13cmos5l_buf_1_37.A sg13cmos5l_buf_1_41.X 0.05299f
C935 sg13cmos5l_nor2_1_0.A a_12800_5498# 0.04476f
C936 sg13cmos5l_buf_1_3.X d_out[0] 0.41789f
C937 a_13072_4142# a_13258_3361# 0
C938 sg13cmos5l_o21ai_1_0.A2 a_11460_2392# 0
C939 sg13cmos5l_dfrbp_1_1.D a_12075_1748# 0
C940 sg13cmos5l_buf_1_5.A sg13cmos5l_or2_1_0.A 0.01738f
C941 sg13cmos5l_nor2_1_0.A a_10587_4692# 0
C942 sg13cmos5l_buf_1_31.X sg13cmos5l_buf_1_26.A 0.00214f
C943 sg13cmos5l_a221oi_1_0.A2 sg13cmos5l_o21ai_1_0.A1 0.34366f
C944 sg13cmos5l_dfrbp_1_6.RESET_B a_16356_7349# 0
C945 a_13572_3151# VPWR 0.00854f
C946 sg13cmos5l_buf_1_18.A a_20008_3900# 0
C947 sg13cmos5l_dfrbp_1_9.Q a_4840_1664# 0
C948 a_1210_4654# VPWR 0
C949 sg13cmos5l_dlhr_1_6.D a_13698_5412# 0
C950 sg13cmos5l_inv_1_7.A a_12520_3176# 0.00244f
C951 sg13cmos5l_buf_1_77.A sg13cmos5l_dlhr_1_9.D 0.0034f
C952 a_11530_3868# a_11913_3947# 0.00337f
C953 sg13cmos5l_dfrbp_1_0.CLK a_13072_4142# 0
C954 a_7941_7653# a_7657_7282# 0.01087f
C955 a_7524_7992# a_7994_7288# 0
C956 a_8043_7796# a_7863_7282# 0
C957 a_7238_7674# sg13cmos5l_dlhr_1_5.D 0
C958 a_1290_3206# sg13cmos5l_buf_1_32.A 0
C959 sg13cmos5l_dfrbp_1_6.RESET_B sg13cmos5l_buf_1_41.X 0
C960 a_16486_6175# cks 0
C961 sg13cmos5l_dlygate4sd2_1_0.A VPWR 0.63602f
C962 sg13cmos5l_dfrbp_1_1.Q sg13cmos5l_dfrbp_1_4.D 0
C963 sg13cmos5l_buf_1_31.X sg13cmos5l_buf_1_46.A 0.02101f
C964 a_14426_7288# a_14612_6460# 0.00505f
C965 sg13cmos5l_dfrbp_1_23.Q a_14032_6382# 0.03733f
C966 sg13cmos5l_a22oi_1_1.B1 a_11877_2399# 0
C967 a_9260_2352# sg13cmos5l_dfrbp_1_1.D 0
C968 sg13cmos5l_dlhr_1_9.D a_8457_7281# 0
C969 sg13cmos5l_buf_1_24.A sg13cmos5l_or2_1_0.A 0.03102f
C970 sg13cmos5l_dfrbp_1_6.RESET_B a_2505_8483# 0
C971 a_7247_8797# ph_sw[4] 0
C972 sg13cmos5l_a22oi_1_2.B1 a_8214_1608# 0
C973 a_11530_3868# a_11973_3911# 0.02241f
C974 sg13cmos5l_dfrbp_1_11.Q sg13cmos5l_dlhr_1_2.D 0.00838f
C975 sg13cmos5l_buf_1_73.X sg13cmos5l_buf_1_24.A 0
C976 a_18117_3117# a_18760_2388# 0.00707f
C977 a_18219_3260# a_18376_2388# 0
C978 sg13cmos5l_dfrbp_1_6.D a_1227_5423# 0.02021f
C979 a_17367_8794# a_16068_6928# 0
C980 a_8841_5769# a_8774_5412# 0
C981 sg13cmos5l_inv_1_2.A a_17545_7728# 0
C982 a_1402_3864# sg13cmos5l_buf_1_32.A 0
C983 sg13cmos5l_inv_1_14.A a_6903_3154# 0.00876f
C984 sg13cmos5l_dlhr_1_10.Q a_19734_5842# 0
C985 sg13cmos5l_buf_1_77.X sg13cmos5l_dfrbp_1_8.RESET_B 0.01907f
C986 sg13cmos5l_dfrbp_1_6.RESET_B sg13cmos5l_buf_1_19.A 0.03516f
C987 a_3588_4968# sg13cmos5l_buf_1_38.A 0.00126f
C988 a_12549_9165# sg13cmos5l_buf_1_5.A 0
C989 a_8588_2352# sg13cmos5l_buf_1_28.A 0.11502f
C990 sg13cmos5l_inv_1_18.A sg13cmos5l_inv_1_0.A 0
C991 a_14166_7656# a_13775_6239# 0.00174f
C992 sg13cmos5l_buf_1_58.A sg13cmos5l_inv_1_19.A 1.51089f
C993 sg13cmos5l_buf_1_30.A a_8214_1608# 0.00522f
C994 sg13cmos5l_dfrbp_1_8.D a_16233_5041# 0
C995 a_8439_6178# a_8468_4948# 0
C996 a_18219_3260# a_18928_1846# 0
C997 sg13cmos5l_dfrbp_1_11.Q a_7888_4870# 0.02263f
C998 sg13cmos5l_buf_1_4.A sg13cmos5l_buf_8_1.A 0
C999 sg13cmos5l_dfrbp_1_8.RESET_B a_17135_4727# 0.20025f
C1000 a_516_5850# VPWR 0
C1001 sg13cmos5l_dfrbp_1_6.D a_17529_7047# 0
C1002 a_14714_5776# a_14996_5412# 0.68988f
C1003 a_3302_4650# a_2565_3911# 0
C1004 sg13cmos5l_buf_1_24.A a_7820_2352# 0.13179f
C1005 sg13cmos5l_buf_1_79.X pl_sw[6] 1.17173f
C1006 sg13cmos5l_buf_1_79.X a_10010_9196# 0
C1007 sg13cmos5l_dfrbp_1_22.D ph_sw[9] 0
C1008 sg13cmos5l_dfrbp_1_6.RESET_B sg13cmos5l_nor2_1_2.A 0.00185f
C1009 sg13cmos5l_buf_1_4.X a_15492_2392# 0.02491f
C1010 sg13cmos5l_dfrbp_1_6.RESET_B sg13cmos5l_buf_1_107.X 0
C1011 sg13cmos5l_inv_1_1.A a_16356_7349# 0.00755f
C1012 sg13cmos5l_inv_1_20.Y VPWR 0.44073f
C1013 a_9673_9240# pl_sw[5] 0.00466f
C1014 a_7449_8559# VPWR 0
C1015 sg13cmos5l_a221oi_1_0.B1 a_11844_4325# 0
C1016 a_17961_8793# a_18486_8866# 0.13715f
C1017 a_17780_8436# a_17916_8838# 0.00404f
C1018 sg13cmos5l_buf_1_0.A a_20008_3900# 0
C1019 sg13cmos5l_or2_1_0.A a_18760_2388# 0
C1020 a_18793_6216# VPWR 0.4104f
C1021 a_4076_7624# a_3831_7282# 0
C1022 a_3676_7964# a_3625_7282# 0
C1023 sg13cmos5l_dfrbp_1_23.Q sg13cmos5l_or2_1_0.A 0
C1024 sg13cmos5l_dfrbp_1_10.Q sg13cmos5l_buf_1_25.X 0
C1025 sg13cmos5l_inv_1_2.A sg13cmos5l_dlhr_1_12.D 0.03414f
C1026 sg13cmos5l_dfrbp_1_18.Q a_9448_6924# 0.0056f
C1027 a_16572_4261# sg13cmos5l_buf_1_4.X 0
C1028 sg13cmos5l_a22oi_1_1.Y a_17700_3456# 0.00865f
C1029 sg13cmos5l_buf_1_98.A a_14089_7282# 0
C1030 sg13cmos5l_dfrbp_1_6.RESET_B sg13cmos5l_buf_1_101.X 0
C1031 sg13cmos5l_buf_1_111.A frame 0
C1032 sg13cmos5l_inv_1_2.A a_15821_3864# 0.00417f
C1033 sg13cmos5l_dfrbp_1_12.Q_N VPWR 0.27711f
C1034 a_424_1664# VPWR 0.24969f
C1035 a_15782_7362# VPWR 0.92696f
C1036 a_3588_4968# sg13cmos5l_or2_1_0.A 0
C1037 sg13cmos5l_nor2_1_0.A sg13cmos5l_dfrbp_1_1.D 0
C1038 sg13cmos5l_dfrbp_1_6.D a_16528_7894# 0
C1039 a_5673_3138# sg13cmos5l_buf_1_25.X 0
C1040 a_16042_6892# sg13cmos5l_dfrbp_1_21.Q 0
C1041 a_3801_3453# VPWR 0
C1042 sg13cmos5l_buf_1_24.A a_6729_5041# 0.00131f
C1043 sg13cmos5l_inv_1_0.A a_11394_4948# 0.001f
C1044 a_3241_2746# a_3688_1664# 0
C1045 sg13cmos5l_buf_1_111.A sg13cmos5l_buf_1_87.A 0.13644f
C1046 sg13cmos5l_inv_1_26.Y sg13cmos5l_buf_8_2.X 0.19853f
C1047 sg13cmos5l_dfrbp_1_6.RESET_B a_13100_8400# 0
C1048 sg13cmos5l_buf_1_96.A pl_sw[6] 0
C1049 a_20392_2388# d_out[0] 0.28823f
C1050 sg13cmos5l_inv_1_27.Y a_13686_7354# 0.00673f
C1051 sg13cmos5l_dfrbp_1_8.RESET_B sg13cmos5l_buf_1_37.A 0
C1052 a_2374_8861# VPWR 0
C1053 a_524_4614# sg13cmos5l_inv_1_19.A 0
C1054 a_6315_3911# a_7055_4261# 0.3087f
C1055 a_3407_8797# sg13cmos5l_dlhr_1_1.GATE 0
C1056 sg13cmos5l_a221oi_1_0.C1 sg13cmos5l_buf_1_46.A 0
C1057 sg13cmos5l_a221oi_1_1.C1 sg13cmos5l_dlhr_1_20.Q_N 0
C1058 a_7994_7288# a_7796_6460# 0
C1059 sg13cmos5l_dlhr_1_5.D a_7216_6382# 0.15881f
C1060 sg13cmos5l_buf_1_111.A sg13cmos5l_buf_1_3.A 0.03313f
C1061 sg13cmos5l_dlhr_1_0.GATE a_6697_3192# 0.02854f
C1062 sg13cmos5l_dfrbp_1_0.RESET_B a_17674_3361# 0.33294f
C1063 sg13cmos5l_dlhr_1_5.D a_7336_7010# 0.00121f
C1064 a_7863_7282# a_8276_6924# 0.15652f
C1065 sg13cmos5l_buf_1_30.A a_7378_6162# 0
C1066 sg13cmos5l_o21ai_1_0.A2 a_11979_2399# 0
C1067 sg13cmos5l_dfrbp_1_1.Q cks 0
C1068 a_20488_5498# a_20672_5498# 0.11523f
C1069 sg13cmos5l_buf_1_78.A a_6117_6141# 0
C1070 a_13391_9263# a_13047_7690# 0
C1071 sg13cmos5l_buf_8_2.X sg13cmos5l_dlhr_1_10.Q 0.00575f
C1072 sg13cmos5l_dfrbp_1_6.RESET_B sg13cmos5l_dfrbp_1_8.RESET_B 0.71365f
C1073 sg13cmos5l_inv_1_7.A a_12075_1748# 0
C1074 sg13cmos5l_inv_1_2.A VPWR 1.02051f
C1075 sg13cmos5l_dfrbp_1_0.CLK sg13cmos5l_dfrbp_1_2.Q_N 0
C1076 sg13cmos5l_buf_1_10.A sg13cmos5l_dfrbp_1_20.Q 0
C1077 sg13cmos5l_buf_1_94.X sg13cmos5l_inv_1_26.Y 0
C1078 a_17516_9150# sg13cmos5l_buf_1_103.A 0.32203f
C1079 sg13cmos5l_inv_1_1.A sg13cmos5l_buf_1_101.X 0.0903f
C1080 a_11973_3911# a_12022_3134# 0
C1081 sg13cmos5l_dfrbp_1_23.CLK a_14152_5498# 0
C1082 a_17008_2630# a_16953_2511# 0.00464f
C1083 a_16293_4629# a_16395_4772# 0.66105f
C1084 a_15590_4650# a_15684_4650# 0.00718f
C1085 sg13cmos5l_buf_1_95.X a_15045_8447# 0
C1086 sg13cmos5l_a22oi_1_1.B1 a_12976_2630# 0
C1087 sg13cmos5l_buf_1_31.X sg13cmos5l_nand2_1_1.B 0
C1088 sg13cmos5l_dlhr_1_11.GATE a_10596_7687# 0.0024f
C1089 a_18856_8436# a_18870_7656# 0.0043f
C1090 sg13cmos5l_buf_1_3.A a_20392_6924# 0.0017f
C1091 sg13cmos5l_dfrbp_1_6.D a_5414_6162# 0.33476f
C1092 a_3692_9150# sg13cmos5l_buf_1_61.X 0
C1093 a_2732_9150# sg13cmos5l_buf_1_62.X 0.00877f
C1094 sg13cmos5l_buf_1_31.X a_7497_3138# 0.01269f
C1095 sg13cmos5l_dfrbp_1_8.RESET_B a_10071_7282# 0
C1096 sg13cmos5l_dfrbp_1_6.RESET_B a_15414_7354# 0.0082f
C1097 a_11782_4325# a_11844_4325# 0
C1098 a_17161_8794# a_16587_6935# 0
C1099 a_17367_8794# a_17584_7166# 0
C1100 sg13cmos5l_dfrbp_1_6.D a_1065_5459# 0
C1101 sg13cmos5l_buf_1_45.X sg13cmos5l_nand2_1_0.A 0
C1102 VPWR sg13cmos5l_buf_1_68.X 0.24264f
C1103 a_15500_9150# sg13cmos5l_buf_1_94.X 0.01109f
C1104 sg13cmos5l_buf_1_65.X a_7052_9150# 0.00786f
C1105 sg13cmos5l_buf_1_110.A sg13cmos5l_buf_1_93.X 0.03321f
C1106 sg13cmos5l_inv_1_18.A a_9242_4660# 0.03065f
C1107 sg13cmos5l_inv_1_27.Y sg13cmos5l_buf_1_5.A 0.11716f
C1108 a_4847_4727# a_5132_3864# 0
C1109 a_8772_8440# sg13cmos5l_buf_1_57.X 0
C1110 sg13cmos5l_dfrbp_1_0.RESET_B a_11372_3102# 0.03678f
C1111 a_7498_7897# a_7524_7992# 0.43042f
C1112 sg13cmos5l_dfrbp_1_6.D a_7238_7674# 0.31428f
C1113 sg13cmos5l_inv_1_7.A sg13cmos5l_and3_1_0.C 0
C1114 a_10998_9168# cks 0
C1115 a_13324_4696# a_13418_4696# 0.00571f
C1116 sg13cmos5l_dfrbp_1_11.Q sg13cmos5l_dfrbp_1_12.Q_N 0.6351f
C1117 sg13cmos5l_buf_1_107.X a_17751_7690# 0
C1118 sg13cmos5l_buf_1_18.A sg13cmos5l_nand2_1_1.A 0.08406f
C1119 sg13cmos5l_dfrbp_1_6.RESET_B a_1662_8374# 0
C1120 sg13cmos5l_inv_1_3.A a_15016_9224# 0.33097f
C1121 sg13cmos5l_inv_1_17.A a_3625_7282# 0.02637f
C1122 a_14996_5412# a_15177_5769# 0.40925f
C1123 sg13cmos5l_inv_1_17.A sg13cmos5l_dfrbp_1_6.D 0.42073f
C1124 a_16940_3102# a_17008_2630# 0
C1125 sg13cmos5l_buf_1_4.X a_16011_2399# 0.02767f
C1126 a_6568_9224# a_5988_8440# 0
C1127 sg13cmos5l_inv_1_1.A a_16425_6971# 0
C1128 a_15429_7653# cks 0
C1129 a_9937_8797# VPWR 0
C1130 sg13cmos5l_buf_1_101.X a_17751_7690# 0
C1131 a_4076_7624# a_4425_7281# 0
C1132 a_4324_7996# a_4244_6924# 0
C1133 sg13cmos5l_buf_1_3.A a_19244_2352# 0
C1134 sg13cmos5l_buf_1_31.X a_3407_4261# 0
C1135 sg13cmos5l_dfrbp_1_8.RESET_B sg13cmos5l_inv_1_1.A 0.81837f
C1136 sg13cmos5l_buf_1_3.A d_out[2] 0.03037f
C1137 sg13cmos5l_buf_1_4.X a_16936_1758# 0.0217f
C1138 sg13cmos5l_buf_1_90.X a_13484_8400# 0.03883f
C1139 a_9256_9224# a_9879_9202# 0
C1140 a_12616_5498# sg13cmos5l_dfrbp_1_0.RESET_B 0
C1141 sg13cmos5l_a22oi_1_1.B2 sg13cmos5l_a22oi_1_1.B1 0.17897f
C1142 a_2565_8447# sg13cmos5l_buf_1_62.X 0
C1143 a_9524_4972# sg13cmos5l_dfrbp_1_1.Q 0
C1144 a_16703_3871# sg13cmos5l_buf_1_4.X 0.00292f
C1145 sg13cmos5l_inv_1_9.Y a_1290_3206# 0.00188f
C1146 a_424_8436# cks 0.03749f
C1147 a_14254_2444# sg13cmos5l_nor2b_1_1.Y 0.28295f
C1148 sg13cmos5l_nor2_1_1.A a_14900_2352# 0.32192f
C1149 sg13cmos5l_inv_1_2.A a_16551_3987# 0.00208f
C1150 sg13cmos5l_dlhr_1_1.Q a_2054_3138# 0
C1151 sg13cmos5l_buf_1_3.A a_20012_1590# 0.01546f
C1152 sg13cmos5l_buf_1_4.A sg13cmos5l_dlhr_1_19.Q_N 0.00275f
C1153 sg13cmos5l_buf_1_39.A nh_sw[3] 0
C1154 sg13cmos5l_nand2_1_0.B sg13cmos5l_a22oi_1_0.Y 0.06592f
C1155 sg13cmos5l_inv_1_1.A a_15414_7354# 0.00251f
C1156 a_18580_7660# sg13cmos5l_dfrbp_1_21.Q_N 0
C1157 sg13cmos5l_dfrbp_1_23.CLK sg13cmos5l_inv_1_29.A 0
C1158 sg13cmos5l_inv_1_2.A a_17554_4650# 0
C1159 sg13cmos5l_buf_1_24.A a_6660_4663# 0.01343f
C1160 sg13cmos5l_dlhr_1_1.D a_1760_3986# 0
C1161 a_15884_3102# a_16268_3102# 0.00492f
C1162 a_4566_2818# sg13cmos5l_buf_1_25.X 0
C1163 sg13cmos5l_dfrbp_1_0.RESET_B nh_sw[5] 0.05216f
C1164 sg13cmos5l_inv_1_9.Y a_1402_3864# 0
C1165 sg13cmos5l_dfrbp_1_6.RESET_B a_15850_4873# 0
C1166 sg13cmos5l_inv_1_7.A sg13cmos5l_nor2_1_0.A 0.09319f
C1167 sg13cmos5l_buf_1_101.X a_17498_8800# 0.00156f
C1168 sg13cmos5l_inv_1_27.Y sg13cmos5l_dfrbp_1_23.Q 0.02175f
C1169 a_6315_3911# a_7257_4023# 0
C1170 sg13cmos5l_buf_1_0.A sg13cmos5l_nand2_1_1.A 0.85929f
C1171 a_6961_4261# a_7474_4338# 0
C1172 sg13cmos5l_buf_1_86.A sg13cmos5l_dlhr_1_10.Q_N 0.00144f
C1173 a_18345_7674# a_18164_6924# 0.00512f
C1174 a_18164_7996# a_17327_7285# 0
C1175 sg13cmos5l_inv_1_9.Y a_1609_4704# 0
C1176 sg13cmos5l_dfrbp_1_18.Q a_7941_7653# 0.39187f
C1177 sg13cmos5l_inv_1_7.A a_12841_7728# 0.0019f
C1178 sg13cmos5l_dfrbp_1_1.Q a_18219_3260# 0
C1179 sg13cmos5l_buf_1_44.X sg13cmos5l_dfrbp_1_9.Q 0.00781f
C1180 sg13cmos5l_dlhr_1_1.Q a_2228_4972# 0
C1181 sg13cmos5l_a22oi_1_2.B2 sg13cmos5l_nand2_1_0.A 0
C1182 sg13cmos5l_a221oi_1_0.C1 sg13cmos5l_nand2_1_1.B 0
C1183 sg13cmos5l_dfrbp_1_8.RESET_B a_17751_7690# 0
C1184 sg13cmos5l_buf_1_96.A a_10484_6924# 0.0013f
C1185 sg13cmos5l_nand2_1_1.A a_13803_3260# 0.02735f
C1186 a_7994_7288# sg13cmos5l_dlhr_1_5.Q 0
C1187 a_16042_6892# a_16234_6385# 0
C1188 sg13cmos5l_a22oi_1_2.B1 a_11782_1639# 0
C1189 a_20492_8400# VPWR 0.24952f
C1190 sg13cmos5l_dlhr_1_0.GATE a_5637_2399# 0.37753f
C1191 a_13258_3361# a_13284_3456# 0.43042f
C1192 a_11434_2356# a_11877_2399# 0.02241f
C1193 sg13cmos5l_buf_1_34.X a_3302_4650# 0.0014f
C1194 sg13cmos5l_inv_1_27.Y a_13460_7996# 0
C1195 a_14228_9484# a_14166_7656# 0
C1196 a_12549_9165# ph_sw[5] 0.00172f
C1197 sg13cmos5l_a221oi_1_0.A2 sg13cmos5l_a22oi_1_1.B1 0
C1198 a_5800_9224# a_6184_9224# 0.00492f
C1199 sg13cmos5l_buf_1_44.A a_6213_3911# 0
C1200 sg13cmos5l_dfrbp_1_0.CLK a_13284_3456# 0.07747f
C1201 a_1997_6126# a_2228_4972# 0
C1202 a_20672_4782# VPWR 0.05687f
C1203 sg13cmos5l_dlhr_1_5.GATE a_6372_4968# 0
C1204 sg13cmos5l_nor2_1_0.A sg13cmos5l_a221oi_1_0.B2 0.14413f
C1205 sg13cmos5l_buf_1_64.A ph_sw[2] 1.11949f
C1206 a_17792_9318# VPWR 0.06964f
C1207 sg13cmos5l_dfrbp_1_6.RESET_B a_18096_7996# 0
C1208 sg13cmos5l_dfrbp_1_6.D a_7216_6382# 0.00809f
C1209 a_3962_7288# a_4358_6924# 0.00949f
C1210 sg13cmos5l_a22oi_1_2.B1 a_10433_1652# 0.00709f
C1211 sg13cmos5l_inv_1_3.A a_14458_4270# 0
C1212 a_9366_5842# a_9524_4972# 0
C1213 sg13cmos5l_buf_1_45.A a_9111_4666# 0.03088f
C1214 sg13cmos5l_buf_1_31.X a_7248_3460# 0
C1215 sg13cmos5l_dfrbp_1_6.D a_7336_7010# 0.02078f
C1216 sg13cmos5l_buf_1_87.A sg13cmos5l_dfrbp_1_21.Q_N 0.0036f
C1217 sg13cmos5l_dlhr_1_6.D a_13486_5760# 0.0012f
C1218 a_4753_4727# sg13cmos5l_buf_1_38.A 0
C1219 sg13cmos5l_dfrbp_1_8.RESET_B a_17498_8800# 0
C1220 a_4324_7996# cks 0.00134f
C1221 a_10031_8797# sg13cmos5l_buf_1_57.X 0.00106f
C1222 sg13cmos5l_nand2_1_1.B sg13cmos5l_o21ai_1_0.B1 0.13556f
C1223 sg13cmos5l_inv_1_1.A a_15850_4873# 0.00551f
C1224 sg13cmos5l_inv_1_14.A sg13cmos5l_dfrbp_1_10.Q 1.52547f
C1225 sg13cmos5l_inv_1_14.A a_6736_2630# 0
C1226 a_18860_9150# VPWR 0.2526f
C1227 sg13cmos5l_dfrbp_1_6.D a_7332_7674# 0
C1228 sg13cmos5l_inv_1_2.A a_16260_6480# 0.01533f
C1229 sg13cmos5l_buf_1_28.X sg13cmos5l_buf_1_28.A 0.0062f
C1230 sg13cmos5l_inv_1_11.Y sg13cmos5l_buf_1_30.X 0.00699f
C1231 sg13cmos5l_dfrbp_1_8.RESET_B a_15702_4187# 0.00422f
C1232 sg13cmos5l_buf_1_31.X a_9705_4650# 0.00465f
C1233 sg13cmos5l_dfrbp_1_6.RESET_B a_17712_8436# 0
C1234 sg13cmos5l_inv_1_2.A sg13cmos5l_buf_1_97.A 0.0271f
C1235 sg13cmos5l_buf_1_104.X sg13cmos5l_inv_1_6.A 0.05386f
C1236 sg13cmos5l_buf_1_19.A sg13cmos5l_buf_1_86.A 0
C1237 sg13cmos5l_dfrbp_1_6.D a_996_5837# 0
C1238 sg13cmos5l_buf_1_3.A sg13cmos5l_dfrbp_1_21.Q_N 0
C1239 sg13cmos5l_buf_1_111.A a_19593_6162# 0.00116f
C1240 a_16940_3102# nh_sw[7] 0
C1241 a_6741_5459# a_6315_3911# 0
C1242 sg13cmos5l_a22oi_1_0.B1 sg13cmos5l_dfrbp_1_4.D 0
C1243 sg13cmos5l_dfrbp_1_8.RESET_B a_5452_5850# 0.19122f
C1244 a_7095_1642# a_7508_1948# 0.15652f
C1245 sg13cmos5l_buf_1_5.X nl_sw[8] 0.02919f
C1246 sg13cmos5l_inv_1_14.A a_6276_8861# 0
C1247 a_7052_9150# a_6507_8447# 0
C1248 sg13cmos5l_dfrbp_1_21.Q a_12075_3911# 0
C1249 a_16473_7989# cks 0.00217f
C1250 sg13cmos5l_inv_1_14.A a_5673_3138# 0
C1251 sg13cmos5l_buf_1_57.X a_14640_6924# 0
C1252 sg13cmos5l_buf_1_18.A sg13cmos5l_dfrbp_1_0.D 0.02745f
C1253 a_9879_9202# a_10473_9186# 0.09085f
C1254 a_9673_9240# a_10010_9196# 0.64635f
C1255 sg13cmos5l_dfrbp_1_6.RESET_B a_18196_8824# 0.00295f
C1256 a_12716_8400# VPWR 0.25249f
C1257 a_422_5850# VPWR 0.93002f
C1258 sg13cmos5l_dfrbp_1_16.Q_N a_4660_7312# 0
C1259 a_4559_7630# sg13cmos5l_buf_1_59.A 0
C1260 sg13cmos5l_buf_1_31.X sg13cmos5l_buf_1_38.A 0.02555f
C1261 sg13cmos5l_dfrbp_1_8.D sg13cmos5l_buf_1_2.A 0.01627f
C1262 a_2621_7636# sg13cmos5l_buf_1_61.X 0
C1263 sg13cmos5l_dfrbp_1_25.Q_N a_16528_7894# 0
C1264 a_15887_8797# a_16177_7751# 0
C1265 sg13cmos5l_dfrbp_1_22.D a_16271_7751# 0.03034f
C1266 sg13cmos5l_dfrbp_1_20.Q sg13cmos5l_nor2b_1_0.Y 0
C1267 a_3313_8797# sg13cmos5l_buf_1_62.X 0
C1268 a_3308_9150# a_3692_9150# 0.00492f
C1269 a_19424_7010# a_19412_6484# 0
C1270 a_2436_8861# pl_sw[2] 0
C1271 sg13cmos5l_or2_1_0.A a_1580_2352# 0
C1272 sg13cmos5l_inv_1_14.A a_6372_4968# 0.01509f
C1273 sg13cmos5l_a22oi_1_1.B2 a_13486_5412# 0.45281f
C1274 sg13cmos5l_buf_1_2.X a_15466_2356# 0.01103f
C1275 a_16268_3102# a_15492_2392# 0
C1276 a_5324_1590# a_5704_1664# 0.07249f
C1277 sg13cmos5l_inv_1_17.A a_5194_2356# 0
C1278 sg13cmos5l_a221oi_1_0.B1 a_13036_4948# 0
C1279 a_2409_4650# a_2644_4636# 0.00566f
C1280 a_2228_4972# a_2364_4686# 0.00404f
C1281 sg13cmos5l_dlhr_1_1.Q_N a_3302_4650# 0.04978f
C1282 sg13cmos5l_inv_1_2.A a_13047_7690# 0.00105f
C1283 sg13cmos5l_buf_1_110.A a_16042_6892# 0.00664f
C1284 a_4753_4727# sg13cmos5l_or2_1_0.A 0
C1285 sg13cmos5l_buf_1_77.X sg13cmos5l_dfrbp_1_6.RESET_B 0
C1286 a_8488_9224# sg13cmos5l_dfrbp_1_18.Q 0.00102f
C1287 sg13cmos5l_buf_1_65.X sg13cmos5l_dfrbp_1_16.Q_N 0
C1288 sg13cmos5l_buf_1_46.A sg13cmos5l_nand2_1_0.B 0.00478f
C1289 a_17367_8794# a_17780_8436# 0.15652f
C1290 VPWR nl_sw[9] 0.21079f
C1291 a_12106_9409# VPWR 0.10724f
C1292 sg13cmos5l_buf_1_63.A ph_sw[0] 0
C1293 nl_sw[9] nl_sw[7] 0
C1294 nl_sw[1] nl_sw[2] 0.02482f
C1295 a_3792_2388# sg13cmos5l_buf_1_39.A 0
C1296 sg13cmos5l_dlhr_1_6.D a_8378_5776# 0.00342f
C1297 sg13cmos5l_dfrbp_1_6.D a_5796_3904# 0.00796f
C1298 a_18356_6460# a_18793_6216# 0.00314f
C1299 sg13cmos5l_or2_1_1.B a_12075_3911# 0
C1300 sg13cmos5l_dlhr_1_11.Q a_12980_6924# 0.00142f
C1301 a_16204_4338# sg13cmos5l_buf_1_2.X 0.00187f
C1302 a_14543_3215# sg13cmos5l_dfrbp_1_0.Q 0
C1303 sg13cmos5l_dfrbp_1_6.RESET_B a_17135_4727# 0.06643f
C1304 sg13cmos5l_buf_1_111.A sg13cmos5l_dlhr_1_12.Q_N 0.00108f
C1305 sg13cmos5l_a22oi_1_2.B2 sg13cmos5l_dfrbp_1_1.Q 0.24056f
C1306 sg13cmos5l_dlhr_1_9.D sg13cmos5l_nor2b_1_0.Y 0
C1307 sg13cmos5l_buf_1_73.A ph_sw[4] 0
C1308 sg13cmos5l_inv_1_8.A a_3407_4261# 0.00541f
C1309 a_18870_7656# sg13cmos5l_dfrbp_1_8.D 0
C1310 sg13cmos5l_dfrbp_1_23.Q_N a_14377_5770# 0.13379f
C1311 sg13cmos5l_buf_1_4.A sg13cmos5l_a22oi_1_1.B2 0
C1312 sg13cmos5l_dfrbp_1_18.Q a_9040_7894# 0.01003f
C1313 a_1967_5773# a_2565_3911# 0.0033f
C1314 a_14889_7281# VPWR 0.62191f
C1315 a_2667_8447# sg13cmos5l_dfrbp_1_16.Q 0
C1316 sg13cmos5l_dlhr_1_9.D sg13cmos5l_buf_1_44.A 0
C1317 sg13cmos5l_nand2_1_1.A sg13cmos5l_buf_1_5.X 0.0308f
C1318 a_12716_8400# a_12698_7288# 0
C1319 sg13cmos5l_inv_1_17.A a_3826_4338# 0
C1320 sg13cmos5l_buf_1_31.X sg13cmos5l_or2_1_0.A 1.59475f
C1321 sg13cmos5l_dfrbp_1_6.RESET_B a_7226_1636# 0.006f
C1322 a_16748_9150# ph_sw[7] 0.12453f
C1323 ph_sw[1] sg13cmos5l_buf_1_61.X 0.34792f
C1324 sg13cmos5l_dfrbp_1_0.D sg13cmos5l_buf_1_0.A 0
C1325 a_12815_4261# a_13017_4023# 0.00675f
C1326 sg13cmos5l_a22oi_1_1.A1 sg13cmos5l_o21ai_1_0.B1 0.00836f
C1327 sg13cmos5l_dlhr_1_0.GATE a_6479_2749# 0.04957f
C1328 a_13701_3117# a_13803_3260# 0.66105f
C1329 sg13cmos5l_buf_1_61.X a_1000_9224# 0.32029f
C1330 a_12998_3138# a_13092_3138# 0.00718f
C1331 a_11460_2392# a_11979_2399# 0.38871f
C1332 a_11877_2399# a_11748_2813# 0.01562f
C1333 a_8689_7751# a_9202_7674# 0
C1334 sg13cmos5l_dfrbp_1_20.Q a_10665_8065# 0
C1335 a_18793_6216# ph_sw[9] 0.00118f
C1336 a_19616_3986# VPWR 0.07962f
C1337 sg13cmos5l_dlhr_1_15.D a_13076_5376# 0.0019f
C1338 a_7941_7653# cks 0.00484f
C1339 sg13cmos5l_buf_1_38.A a_3212_1590# 0
C1340 sg13cmos5l_a221oi_1_0.C1 a_11771_5412# 0
C1341 a_1463_8741# VPWR 0.06608f
C1342 sg13cmos5l_a221oi_1_1.C1 sg13cmos5l_a22oi_1_0.Y 0
C1343 a_1760_9318# cks 0
C1344 sg13cmos5l_buf_1_45.A sg13cmos5l_dfrbp_1_10.Q 0
C1345 sg13cmos5l_dfrbp_1_0.CLK a_15380_3436# 0.04709f
C1346 sg13cmos5l_buf_1_18.X a_20288_2474# 0
C1347 a_2748_6126# a_2409_4650# 0
C1348 a_2727_6380# a_2934_4632# 0
C1349 sg13cmos5l_a221oi_1_0.C1 a_9705_4650# 0.00222f
C1350 sg13cmos5l_dlhr_1_11.Q sg13cmos5l_buf_1_57.X 0
C1351 sg13cmos5l_buf_1_10.A a_10308_7992# 0
C1352 a_14089_7282# a_14640_6924# 0
C1353 sg13cmos5l_dlhr_1_5.GATE a_7888_4870# 0
C1354 sg13cmos5l_inv_1_18.A sg13cmos5l_dlhr_1_0.D 0
C1355 a_13681_6239# a_14194_6162# 0
C1356 a_13072_4142# sg13cmos5l_buf_1_6.A 0
C1357 a_7863_7282# a_7657_7282# 0.27787f
C1358 sg13cmos5l_buf_1_8.X a_11877_2399# 0.00199f
C1359 a_3831_7282# sg13cmos5l_inv_1_19.A 0
C1360 a_424_8436# a_422_7362# 0
C1361 sg13cmos5l_dlhr_1_9.D a_8247_5770# 0.0028f
C1362 sg13cmos5l_dfrbp_1_6.D sg13cmos5l_buf_8_1.A 0.35977f
C1363 sg13cmos5l_buf_1_31.X a_7820_2352# 0
C1364 sg13cmos5l_dlhr_1_9.Q sg13cmos5l_dfrbp_1_9.Q 0
C1365 sg13cmos5l_inv_1_7.A sg13cmos5l_o21ai_1_0.Y 0.01421f
C1366 sg13cmos5l_buf_1_73.A sg13cmos5l_buf_1_24.A 0.02477f
C1367 sg13cmos5l_dfrbp_1_8.D sg13cmos5l_dfrbp_1_6.Q_N 0
C1368 VPWR ph_sw[2] 0.27911f
C1369 a_10428_9222# pl_sw[6] 0
C1370 a_1290_3206# sg13cmos5l_buf_1_40.X 0
C1371 sg13cmos5l_inv_1_14.A a_6898_2826# 0
C1372 sg13cmos5l_dfrbp_1_6.RESET_B sg13cmos5l_buf_1_37.A 0.00832f
C1373 sg13cmos5l_inv_1_18.A a_8486_8874# 0.02951f
C1374 sg13cmos5l_dlhr_1_0.GATE a_6789_4629# 0.00218f
C1375 sg13cmos5l_dfrbp_1_23.CLK sg13cmos5l_a22oi_1_1.B2 0.07714f
C1376 sg13cmos5l_dfrbp_1_6.D a_18960_5412# 0
C1377 sg13cmos5l_nand2_1_2.B VPWR 0.35598f
C1378 sg13cmos5l_buf_1_2.A a_15876_4968# 0.00136f
C1379 a_15909_2399# nl_sw[8] 0.01844f
C1380 sg13cmos5l_buf_1_28.A sg13cmos5l_a22oi_1_2.B1 0.00256f
C1381 sg13cmos5l_inv_1_6.A a_18865_3215# 0
C1382 a_17961_8793# a_18164_7996# 0.01024f
C1383 a_18486_8866# a_18345_7674# 0
C1384 sg13cmos5l_buf_1_44.X sg13cmos5l_buf_1_41.A 0
C1385 a_12520_4782# sg13cmos5l_dfrbp_1_0.CLK 0.0063f
C1386 sg13cmos5l_buf_1_30.X a_8214_1608# 0
C1387 a_13234_4338# VPWR 0
C1388 a_18409_5770# a_18746_5776# 0.64635f
C1389 sg13cmos5l_buf_1_31.X a_5424_3460# 0
C1390 sg13cmos5l_dfrbp_1_8.RESET_B a_5951_5383# 0.06722f
C1391 sg13cmos5l_buf_1_34.X a_2748_6126# 0
C1392 a_8214_1608# a_8680_1664# 0.00204f
C1393 sg13cmos5l_buf_1_31.X a_3578_2752# 0
C1394 sg13cmos5l_dlygate4sd2_1_0.X a_1580_2352# 0.00237f
C1395 a_1402_3864# sg13cmos5l_buf_1_40.X 0
C1396 sg13cmos5l_inv_1_14.A sg13cmos5l_dlhr_1_2.D 0.02202f
C1397 sg13cmos5l_buf_1_30.A sg13cmos5l_buf_1_28.A 0
C1398 sg13cmos5l_inv_1_26.Y a_19904_7806# 0
C1399 a_1846_7850# cks 0.00352f
C1400 sg13cmos5l_buf_1_19.A a_17931_1748# 0.00557f
C1401 sg13cmos5l_dfrbp_1_22.D sg13cmos5l_dlhr_1_15.D 0.35244f
C1402 a_11530_3868# VPWR 0.1032f
C1403 sg13cmos5l_dfrbp_1_6.D a_14152_5498# 0
C1404 a_2804_6924# sg13cmos5l_buf_1_41.A 0.03708f
C1405 sg13cmos5l_dlhr_1_6.D a_10420_5760# 0
C1406 sg13cmos5l_dfrbp_1_23.CLK a_12804_6175# 0.00105f
C1407 a_17498_8800# a_17712_8436# 0.01249f
C1408 sg13cmos5l_buf_1_31.X a_11072_5347# 0
C1409 a_2505_8483# pl_sw[2] 0
C1410 a_12132_9504# sg13cmos5l_buf_1_95.X 0.04434f
C1411 sg13cmos5l_dfrbp_1_21.Q a_11973_3911# 0
C1412 sg13cmos5l_dfrbp_1_6.RESET_B a_10412_6126# 0.0028f
C1413 sg13cmos5l_nand2_1_0.A a_10220_3102# 0.02097f
C1414 sg13cmos5l_inv_1_14.A a_7888_4870# 0
C1415 sg13cmos5l_inv_1_3.A a_14377_5770# 0.00263f
C1416 sg13cmos5l_buf_1_31.X a_1672_3176# 0.34491f
C1417 sg13cmos5l_a22oi_1_1.B2 a_15132_5814# 0
C1418 a_3016_9318# sg13cmos5l_dfrbp_1_8.RESET_B 0
C1419 a_7316_3460# sg13cmos5l_buf_1_25.A 0.01014f
C1420 sg13cmos5l_dfrbp_1_6.RESET_B a_10071_7282# 0.05802f
C1421 sg13cmos5l_buf_1_2.X a_15780_2813# 0.02682f
C1422 a_5324_1590# a_5600_1758# 0.00624f
C1423 a_6572_1590# VPWR 0.26103f
C1424 sg13cmos5l_buf_1_25.A a_4934_2826# 0
C1425 sg13cmos5l_dfrbp_1_0.Q a_15206_2826# 0
C1426 a_14714_5776# sg13cmos5l_nand2_1_1.B 0
C1427 a_19227_4654# a_18363_4270# 0.00123f
C1428 a_17161_8794# sg13cmos5l_buf_1_105.A 0
C1429 ph_sw[6] ph_sw[7] 0.28813f
C1430 a_19904_7806# sg13cmos5l_dlhr_1_10.Q 0
C1431 a_5700_6480# a_6346_4873# 0
C1432 a_10331_1924# nl_sw[5] 0.00805f
C1433 sg13cmos5l_a221oi_1_0.C1 sg13cmos5l_or2_1_0.A 0.00112f
C1434 a_11182_4948# sg13cmos5l_dfrbp_1_2.D 0
C1435 sg13cmos5l_nand2_1_0.B sg13cmos5l_nand2_1_1.B 0.0047f
C1436 sg13cmos5l_inv_1_8.A a_6405_8447# 0.35254f
C1437 sg13cmos5l_dfrbp_1_6.D a_1864_1664# 0.00147f
C1438 a_8296_3986# sg13cmos5l_dlhr_1_2.Q_N 0
C1439 a_1760_3986# sg13cmos5l_inv_1_19.A 0.00201f
C1440 sg13cmos5l_buf_1_10.A a_12742_6175# 0
C1441 a_10071_7282# a_10412_6126# 0.00178f
C1442 sg13cmos5l_dfrbp_1_21.Q_N a_19593_6162# 0
C1443 sg13cmos5l_buf_1_97.A a_12716_8400# 0
C1444 sg13cmos5l_dfrbp_1_8.RESET_B a_2224_7166# 0
C1445 sg13cmos5l_dfrbp_1_20.Q_N a_9448_6924# 0
C1446 sg13cmos5l_dlhr_1_11.Q a_14089_7282# 0
C1447 sg13cmos5l_dfrbp_1_0.Q a_16552_1664# 0.01019f
C1448 sg13cmos5l_dfrbp_1_1.Q a_16953_2511# 0
C1449 sg13cmos5l_buf_1_31.X sg13cmos5l_dlygate4sd2_1_0.X 0.13993f
C1450 sg13cmos5l_dfrbp_1_0.RESET_B a_18122_2388# 0
C1451 sg13cmos5l_nand2_1_1.A a_15909_2399# 0
C1452 a_19240_7712# VPWR 0.25349f
C1453 sg13cmos5l_inv_1_8.A sg13cmos5l_buf_1_38.A 0.02111f
C1454 sg13cmos5l_dfrbp_1_23.Q_N a_14996_5412# 0
C1455 a_6602_5692# a_6741_5459# 0.00659f
C1456 sg13cmos5l_inv_1_28.Y sg13cmos5l_inv_1_27.Y 0.02578f
C1457 sg13cmos5l_inv_1_0.A a_13034_5412# 0.00228f
C1458 sg13cmos5l_or2_1_1.B a_11973_3911# 0.00259f
C1459 sg13cmos5l_buf_1_40.A a_1065_6971# 0
C1460 a_13768_8436# a_13686_7354# 0
C1461 a_8209_7326# cks 0
C1462 a_17233_7285# a_16677_6141# 0
C1463 sg13cmos5l_dfrbp_1_6.RESET_B sg13cmos5l_inv_1_1.A 0.44103f
C1464 a_13701_3117# sg13cmos5l_buf_1_5.X 0
C1465 sg13cmos5l_dlhr_1_11.Q a_13178_7684# 0.03111f
C1466 sg13cmos5l_dfrbp_1_0.CLK a_15466_2356# 0.00111f
C1467 a_7312_4142# a_6903_3154# 0.00367f
C1468 a_6315_3911# a_6697_3192# 0.00588f
C1469 sg13cmos5l_dlhr_1_9.D a_8774_5412# 0
C1470 a_3241_2746# sg13cmos5l_buf_1_39.A 0.00951f
C1471 sg13cmos5l_nand2_1_1.B nl_sw[6] 0.02576f
C1472 sg13cmos5l_dfrbp_1_8.RESET_B a_15974_6162# 0.05486f
C1473 sg13cmos5l_inv_1_27.Y a_15531_7796# 0.00105f
C1474 sg13cmos5l_dfrbp_1_20.Q a_10596_7687# 0.00131f
C1475 sg13cmos5l_inv_1_8.A a_2148_3904# 0.11239f
C1476 sg13cmos5l_dlhr_1_15.D sg13cmos5l_and3_1_0.X 0.03935f
C1477 sg13cmos5l_dlhr_1_21.Q_N sg13cmos5l_buf_1_90.X 0.00126f
C1478 sg13cmos5l_dfrbp_1_23.CLK a_14628_8440# 0.0459f
C1479 sg13cmos5l_buf_1_0.X d_out[0] 0
C1480 a_9040_7894# cks 0.00295f
C1481 sg13cmos5l_dlhr_1_15.D a_18097_7666# 0
C1482 sg13cmos5l_dlhr_1_15.D sg13cmos5l_inv_1_0.Y 0.00458f
C1483 sg13cmos5l_or2_1_0.A sg13cmos5l_o21ai_1_0.B1 0.01556f
C1484 a_16395_4772# a_16572_4261# 0
C1485 sg13cmos5l_dfrbp_1_0.CLK a_11844_1639# 0.00105f
C1486 a_2638_6162# a_2409_4650# 0
C1487 sg13cmos5l_dfrbp_1_0.CLK a_16204_4338# 0
C1488 sg13cmos5l_dfrbp_1_1.Q a_16940_3102# 0
C1489 sg13cmos5l_buf_1_10.A a_11824_7894# 0.04213f
C1490 a_1873_5773# a_1815_4666# 0
C1491 a_1967_5773# a_2409_4650# 0.01604f
C1492 a_2224_5654# a_2228_4972# 0
C1493 sg13cmos5l_buf_1_32.A nh_sw[0] 0.04958f
C1494 a_5132_9150# ph_sw[2] 0.01815f
C1495 sg13cmos5l_dfrbp_1_0.RESET_B sg13cmos5l_buf_1_4.X 0.0919f
C1496 sg13cmos5l_dfrbp_1_6.D sg13cmos5l_inv_1_29.A 0.03214f
C1497 a_2314_3361# a_2732_1590# 0
C1498 sg13cmos5l_buf_1_8.X a_12976_2630# 0
C1499 a_16089_8559# VPWR 0
C1500 a_4425_7281# sg13cmos5l_inv_1_19.A 0
C1501 a_8204_9150# a_8043_7796# 0
C1502 sg13cmos5l_buf_1_45.X a_7941_7653# 0.01827f
C1503 a_12520_3176# a_13258_3361# 0.00259f
C1504 a_10613_2758# a_11174_2826# 0
C1505 sg13cmos5l_buf_1_78.X VPWR 0.29585f
C1506 sg13cmos5l_buf_1_18.A a_15492_2392# 0
C1507 sg13cmos5l_buf_1_94.X sg13cmos5l_buf_1_103.A 1.47394f
C1508 a_5132_3864# a_5510_4338# 0.00364f
C1509 sg13cmos5l_inv_1_18.A a_9060_8861# 0.02557f
C1510 sg13cmos5l_dfrbp_1_0.CLK a_12520_3176# 0.0104f
C1511 sg13cmos5l_inv_1_8.A sg13cmos5l_or2_1_0.A 0.25365f
C1512 a_17008_2630# nl_sw[8] 0
C1513 a_14295_7282# a_14708_6924# 0.15652f
C1514 a_13161_7281# a_13094_6924# 0
C1515 sg13cmos5l_buf_1_31.X sg13cmos5l_dfrbp_1_2.D 0
C1516 sg13cmos5l_a221oi_1_0.C1 a_11072_5347# 0.00248f
C1517 sg13cmos5l_dfrbp_1_3.Q_N d_out[1] 0.00135f
C1518 sg13cmos5l_inv_1_8.A sg13cmos5l_buf_1_73.X 0
C1519 a_3308_9150# ph_sw[1] 0.01147f
C1520 sg13cmos5l_a221oi_1_0.A2 a_8588_3864# 0
C1521 sg13cmos5l_dfrbp_1_6.RESET_B a_17751_7690# 0.03104f
C1522 a_13768_8436# sg13cmos5l_buf_1_5.A 0
C1523 sg13cmos5l_buf_1_105.A sg13cmos5l_dlhr_1_15.Q 0.01623f
C1524 a_14714_5776# sg13cmos5l_a22oi_1_1.A1 0
C1525 sg13cmos5l_buf_1_86.A ph_sw[10] 0.04607f
C1526 sg13cmos5l_buf_1_77.A a_10420_5412# 0
C1527 a_7508_1948# a_7441_1618# 0.0018f
C1528 a_8214_1608# sg13cmos5l_dlhr_1_0.Q_N 0.12876f
C1529 a_12022_3134# VPWR 0.01857f
C1530 a_7689_1626# a_7644_1662# 0
C1531 sg13cmos5l_buf_1_95.X sg13cmos5l_buf_1_93.X 0.24315f
C1532 sg13cmos5l_buf_1_31.X sg13cmos5l_buf_1_34.A 0
C1533 sg13cmos5l_buf_1_77.A a_9242_4660# 0
C1534 a_708_5416# a_1125_5423# 0.49014f
C1535 sg13cmos5l_dlhr_1_6.D a_13076_5376# 0.0063f
C1536 sg13cmos5l_dfrbp_1_8.RESET_B pl_sw[2] 0
C1537 a_416_7806# rdy 0
C1538 sg13cmos5l_nand2_1_1.B a_11174_2826# 0.00221f
C1539 sg13cmos5l_dfrbp_1_1.Q a_10220_3102# 0.03902f
C1540 a_1480_7806# cks 0.00231f
C1541 a_15684_4650# VPWR 0
C1542 sg13cmos5l_dlhr_1_6.D a_9111_4666# 0
C1543 a_5988_8440# pl_sw[4] 0
C1544 sg13cmos5l_dfrbp_1_21.Q a_17392_4870# 0.00268f
C1545 sg13cmos5l_and3_1_0.C a_13418_4696# 0
C1546 sg13cmos5l_buf_1_5.A sg13cmos5l_dfrbp_1_8.D 0
C1547 sg13cmos5l_dlhr_1_9.D a_4425_7281# 0.01835f
C1548 sg13cmos5l_nor2b_1_0.Y a_12719_2749# 0
C1549 a_14228_9484# sg13cmos5l_buf_1_95.X 0.01311f
C1550 sg13cmos5l_inv_1_5.A a_20008_3900# 0.0903f
C1551 sg13cmos5l_inv_1_14.A sg13cmos5l_dfrbp_1_12.Q_N 0.0147f
C1552 sg13cmos5l_inv_1_3.A a_14996_5412# 0
C1553 sg13cmos5l_buf_1_31.X a_2148_3138# 0
C1554 sg13cmos5l_a22oi_1_1.B2 a_15110_5412# 0
C1555 sg13cmos5l_dlhr_1_11.GATE a_11272_8522# 0.02768f
C1556 sg13cmos5l_dlhr_1_2.Q_N a_8392_3270# 0.02372f
C1557 sg13cmos5l_inv_1_0.Y sg13cmos5l_o21ai_1_0.A2 0
C1558 sg13cmos5l_dfrbp_1_6.RESET_B a_10620_7326# 0.00121f
C1559 sg13cmos5l_buf_1_2.X a_15849_2435# 0
C1560 a_6889_1680# VPWR 0.41252f
C1561 a_3562_4873# a_3876_4663# 0.00659f
C1562 a_17792_9318# ph_sw[9] 0
C1563 sg13cmos5l_buf_1_74.X a_5988_8440# 0
C1564 sg13cmos5l_dfrbp_1_0.Q a_14858_2388# 0.00498f
C1565 sg13cmos5l_buf_1_57.X a_15124_7312# 0
C1566 sg13cmos5l_dfrbp_1_6.RESET_B a_17498_8800# 0.00612f
C1567 sg13cmos5l_dlhr_1_9.Q sg13cmos5l_buf_1_41.A 0
C1568 a_8084_8436# a_7941_7653# 0.0035f
C1569 a_6959_6239# a_6372_4968# 0
C1570 sg13cmos5l_inv_1_8.A a_7247_8797# 0
C1571 a_10202_7288# sg13cmos5l_buf_1_29.A 0
C1572 sg13cmos5l_dfrbp_1_21.Q_N a_19345_6154# 0
C1573 sg13cmos5l_buf_1_34.X a_4324_7996# 0.03641f
C1574 sg13cmos5l_dlhr_1_12.D pl_sw[8] 0
C1575 sg13cmos5l_buf_1_10.A sg13cmos5l_inv_1_0.A 0.09562f
C1576 a_10417_7326# a_10484_6924# 0.0018f
C1577 a_10202_7288# a_10665_7281# 0.13395f
C1578 a_10071_7282# a_10620_7326# 0
C1579 a_18860_6888# a_18793_6216# 0
C1580 sg13cmos5l_dfrbp_1_0.Q a_15200_1758# 0
C1581 a_18860_9150# ph_sw[9] 0.01404f
C1582 sg13cmos5l_buf_1_104.A cks 0.00111f
C1583 sg13cmos5l_nand2_1_1.A a_17008_2630# 0
C1584 a_13076_5376# a_13698_5412# 0
C1585 a_5079_3154# sg13cmos5l_buf_1_25.A 0
C1586 sg13cmos5l_dfrbp_1_6.RESET_B a_5452_5850# 0.02077f
C1587 a_14543_3215# a_15206_2826# 0
C1588 sg13cmos5l_inv_1_17.A a_4041_2745# 0.00751f
C1589 sg13cmos5l_inv_1_8.A a_6729_5041# 0
C1590 sg13cmos5l_inv_1_20.Y a_3574_7850# 0.00619f
C1591 sg13cmos5l_nor2_1_0.A a_12721_4261# 0.00152f
C1592 sg13cmos5l_dfrbp_1_23.CLK sg13cmos5l_dlhr_1_11.D 0
C1593 sg13cmos5l_dfrbp_1_8.D a_16068_6162# 0
C1594 sg13cmos5l_dfrbp_1_22.Q_N a_17519_6239# 0
C1595 a_17584_7166# a_17425_6239# 0
C1596 sg13cmos5l_dfrbp_1_6.RESET_B a_7924_1612# 0.00381f
C1597 sg13cmos5l_dfrbp_1_8.RESET_B sg13cmos5l_dlhr_1_9.Q_N 0
C1598 sg13cmos5l_buf_1_40.A a_1280_6294# 0.01136f
C1599 a_15884_3102# sg13cmos5l_buf_1_5.X 0.32213f
C1600 a_7892_3900# a_8022_3120# 0
C1601 sg13cmos5l_dfrbp_1_0.CLK a_15780_2813# 0.00404f
C1602 sg13cmos5l_buf_1_10.A a_12490_6385# 0.02648f
C1603 sg13cmos5l_inv_1_8.A a_1672_3176# 0
C1604 a_4276_2776# sg13cmos5l_buf_1_39.A 0
C1605 sg13cmos5l_buf_1_32.A a_1760_1758# 0
C1606 a_12719_2749# a_13138_2826# 0.00176f
C1607 sg13cmos5l_buf_1_45.X a_8488_9224# 0.00511f
C1608 a_2824_2388# VPWR 0.31789f
C1609 sg13cmos5l_inv_1_14.A sg13cmos5l_inv_1_2.A 0
C1610 a_5770_3868# sg13cmos5l_dfrbp_1_10.Q 0
C1611 a_6315_3911# a_5637_2399# 0
C1612 sg13cmos5l_dfrbp_1_18.Q a_7863_7282# 0
C1613 sg13cmos5l_dfrbp_1_8.RESET_B a_17776_6382# 0
C1614 a_17896_9224# a_17780_8436# 0.00473f
C1615 sg13cmos5l_nor2_1_0.A a_13418_4696# 0.01145f
C1616 sg13cmos5l_inv_1_17.A a_2340_3456# 0.01148f
C1617 a_16395_4772# a_16703_3871# 0.0167f
C1618 sg13cmos5l_nor2_1_0.A a_11364_4338# 0
C1619 sg13cmos5l_buf_8_0.A sg13cmos5l_nand2_1_1.A 0.00315f
C1620 sg13cmos5l_buf_1_45.X a_8209_7326# 0.00143f
C1621 a_10725_7653# a_10827_7796# 0.66105f
C1622 a_14612_6460# a_14377_5770# 0
C1623 a_17516_9150# cks 0.00199f
C1624 a_13768_8436# a_13460_7996# 0
C1625 sg13cmos5l_dfrbp_1_0.CLK a_14814_3876# 0.00433f
C1626 a_616_9224# a_1000_9224# 0.00492f
C1627 sg13cmos5l_buf_1_73.X a_8972_9150# 0
C1628 a_7052_9150# a_7336_9224# 0.13542f
C1629 sg13cmos5l_dlhr_1_1.D a_2228_4972# 0.0044f
C1630 sg13cmos5l_a221oi_1_1.C1 sg13cmos5l_nand2_1_1.B 0
C1631 sg13cmos5l_a221oi_1_0.C1 sg13cmos5l_dfrbp_1_2.D 0.01597f
C1632 sg13cmos5l_a22oi_1_2.B2 sg13cmos5l_a22oi_1_0.B1 0
C1633 sg13cmos5l_inv_1_8.A sg13cmos5l_dlygate4sd2_1_0.X 0.01512f
C1634 a_10292_9508# VPWR 0.1047f
C1635 sg13cmos5l_buf_1_103.A a_15793_8797# 0
C1636 sg13cmos5l_buf_1_45.X a_9040_7894# 0
C1637 sg13cmos5l_inv_1_1.A a_17498_8800# 0
C1638 a_5408_3986# a_5079_3154# 0
C1639 a_5770_3868# a_5673_3138# 0
C1640 sg13cmos5l_buf_1_6.A a_13284_3456# 0
C1641 sg13cmos5l_dfrbp_1_4.D a_10707_2388# 0.00663f
C1642 VPWR pl_sw[8] 0.26711f
C1643 nh_sw[7] nl_sw[8] 0.2058f
C1644 sg13cmos5l_buf_1_2.A a_15380_3436# 0.0453f
C1645 sg13cmos5l_inv_1_8.A a_1946_4660# 0.00578f
C1646 a_19796_3436# nl_sw[10] 0.00122f
C1647 a_5800_9224# sg13cmos5l_buf_1_78.A 0.03743f
C1648 sg13cmos5l_buf_1_73.X a_6184_9224# 0.0051f
C1649 sg13cmos5l_buf_1_76.X a_6568_9224# 0.00932f
C1650 a_5416_9224# sg13cmos5l_buf_1_74.X 0
C1651 sg13cmos5l_buf_1_18.A a_16011_2399# 0
C1652 a_18873_1941# nl_sw[9] 0
C1653 sg13cmos5l_inv_1_18.A a_9129_8483# 0
C1654 sg13cmos5l_buf_1_45.X sg13cmos5l_buf_1_25.A 0.00726f
C1655 sg13cmos5l_dfrbp_1_0.CLK a_12075_1748# 0.03964f
C1656 a_15531_7796# a_16068_6928# 0.0073f
C1657 a_6086_4650# a_5796_3904# 0
C1658 a_6346_4873# a_6213_3911# 0
C1659 sg13cmos5l_inv_1_17.A a_2934_4632# 0
C1660 a_9344_7010# VPWR 0.07227f
C1661 a_14032_6382# a_14194_6162# 0.0019f
C1662 sg13cmos5l_dfrbp_1_8.RESET_B a_4107_4772# 0.55145f
C1663 sg13cmos5l_inv_1_3.A sg13cmos5l_buf_1_7.A 0.15183f
C1664 sg13cmos5l_buf_1_8.X a_10427_2736# 0
C1665 a_4425_7281# sg13cmos5l_dlhr_1_7.Q_N 0.00294f
C1666 a_19028_5412# sg13cmos5l_dlhr_1_16.Q 0
C1667 a_19209_5769# a_19444_5800# 0.00566f
C1668 sg13cmos5l_buf_1_45.A sg13cmos5l_dfrbp_1_12.Q_N 0.09637f
C1669 a_15177_5769# sg13cmos5l_a22oi_1_1.A1 0.00216f
C1670 sg13cmos5l_buf_1_0.X a_19508_1924# 0
C1671 a_13092_3138# VPWR 0
C1672 sg13cmos5l_dlhr_1_6.D sg13cmos5l_and3_1_0.X 0
C1673 sg13cmos5l_and3_1_0.C a_13258_3361# 0
C1674 sg13cmos5l_nand2_1_1.B a_11072_2474# 0
C1675 sg13cmos5l_nor2_1_0.A nl_sw[5] 0.03649f
C1676 sg13cmos5l_buf_1_110.A a_15590_4650# 0
C1677 sg13cmos5l_dlhr_1_6.D sg13cmos5l_inv_1_0.Y 0
C1678 sg13cmos5l_dfrbp_1_6.D a_19028_5412# 0
C1679 sg13cmos5l_dlhr_1_5.Q a_10230_4632# 0
C1680 sg13cmos5l_nand2_1_0.B sg13cmos5l_or2_1_0.A 0.03128f
C1681 sg13cmos5l_inv_1_26.Y a_19412_6484# 0.00152f
C1682 sg13cmos5l_dfrbp_1_0.RESET_B sg13cmos5l_a22oi_1_2.B1 0
C1683 sg13cmos5l_dlhr_1_1.GATE a_4076_5376# 0
C1684 sg13cmos5l_buf_1_41.A a_2727_6380# 0.03973f
C1685 sg13cmos5l_inv_1_6.A a_18959_3215# 0
C1686 sg13cmos5l_buf_1_3.A nl_sw[10] 0.03505f
C1687 sg13cmos5l_and3_1_0.C sg13cmos5l_dfrbp_1_0.CLK 0.04158f
C1688 a_17161_8794# a_17545_7728# 0
C1689 a_17498_8800# a_17751_7690# 0.00719f
C1690 sg13cmos5l_buf_1_31.X a_3505_3215# 0.00135f
C1691 sg13cmos5l_dfrbp_1_6.RESET_B a_12361_7282# 0.04193f
C1692 sg13cmos5l_a22oi_1_0.Y sg13cmos5l_dfrbp_1_4.D 0
C1693 sg13cmos5l_inv_1_7.A nh_sw[6] 0
C1694 a_9448_1664# VPWR 0.24913f
C1695 a_15784_9224# VPWR 0.24658f
C1696 a_15357_1816# nl_sw[8] 0.00197f
C1697 sg13cmos5l_inv_1_2.A a_16271_7751# 0.02241f
C1698 sg13cmos5l_buf_1_74.X a_7504_8678# 0
C1699 sg13cmos5l_buf_1_25.A a_8204_2352# 0
C1700 sg13cmos5l_inv_1_9.Y nh_sw[0] 0.00116f
C1701 a_8746_8404# a_7941_7653# 0.00694f
C1702 a_10789_4654# VPWR 0
C1703 a_6959_6239# a_7888_4870# 0
C1704 sg13cmos5l_dfrbp_1_6.D sg13cmos5l_a22oi_1_1.B2 0
C1705 sg13cmos5l_dfrbp_1_6.RESET_B a_16462_4338# 0
C1706 sg13cmos5l_nand2_1_1.A nh_sw[7] 0.69097f
C1707 sg13cmos5l_buf_1_34.X nl_sw[2] 0
C1708 cks pl_sw[10] 0.02298f
C1709 ph_sw[4] pl_sw[3] 0.02826f
C1710 sg13cmos5l_nor2b_1_0.Y a_10464_2427# 0.02286f
C1711 a_10665_7281# sg13cmos5l_dlhr_1_18.Q_N 0.00294f
C1712 a_10484_6924# a_10416_6924# 0
C1713 sg13cmos5l_or2_1_0.A nl_sw[6] 0
C1714 sg13cmos5l_dlhr_1_10.Q a_19412_6484# 0.0021f
C1715 sg13cmos5l_dfrbp_1_0.Q a_17931_1748# 0.01243f
C1716 sg13cmos5l_inv_1_20.Y a_3692_9150# 0
C1717 sg13cmos5l_nand2_1_1.A a_18376_2388# 0
C1718 sg13cmos5l_dfrbp_1_6.RESET_B a_8439_6178# 0
C1719 sg13cmos5l_dfrbp_1_8.RESET_B a_2879_6432# 0.05661f
C1720 sg13cmos5l_and3_1_0.X a_13698_5412# 0.03804f
C1721 sg13cmos5l_dlhr_1_11.GATE a_10031_8797# 0.0022f
C1722 a_6903_3154# a_7452_3174# 0
C1723 sg13cmos5l_dfrbp_1_6.RESET_B a_5951_5383# 0.01336f
C1724 sg13cmos5l_buf_1_25.X a_6572_1590# 0.00234f
C1725 a_5324_1590# sg13cmos5l_buf_1_24.X 0.00191f
C1726 a_15884_3102# a_15909_2399# 0.00501f
C1727 sg13cmos5l_buf_1_5.X a_15492_2392# 0
C1728 a_8041_5770# sg13cmos5l_a221oi_1_0.A2 0.15606f
C1729 sg13cmos5l_buf_1_107.X ph_sw[7] 0
C1730 sg13cmos5l_inv_1_8.A a_6660_4663# 0
C1731 a_15702_4187# a_15206_2826# 0
C1732 a_17161_8794# sg13cmos5l_dlhr_1_12.D 0.17565f
C1733 sg13cmos5l_dfrbp_1_0.D a_17008_2630# 0
C1734 sg13cmos5l_dfrbp_1_15.D a_3575_6553# 0.30131f
C1735 sg13cmos5l_dlhr_1_9.D a_10230_4632# 0.05385f
C1736 sg13cmos5l_dfrbp_1_8.D a_17425_6239# 0.02387f
C1737 sg13cmos5l_buf_1_90.X VPWR 0.39545f
C1738 sg13cmos5l_dfrbp_1_18.Q a_10725_7653# 0
C1739 a_10473_9186# a_10282_7897# 0
C1740 a_10010_9196# sg13cmos5l_buf_1_57.X 0
C1741 sg13cmos5l_buf_1_63.X ph_sw[0] 0.00744f
C1742 sg13cmos5l_nor2_1_0.A a_13258_3361# 0.03621f
C1743 sg13cmos5l_nand2_1_1.A sg13cmos5l_inv_1_5.A 0.26606f
C1744 a_7892_3900# sg13cmos5l_dlhr_1_2.Q 0.00107f
C1745 sg13cmos5l_buf_1_10.A a_13775_6239# 0
C1746 a_14543_3215# a_15200_1758# 0
C1747 a_7312_4142# sg13cmos5l_dfrbp_1_10.Q 0
C1748 sg13cmos5l_inv_1_28.Y sg13cmos5l_dfrbp_1_27.Q_N 0
C1749 a_16144_8678# pl_sw[7] 0
C1750 a_6315_3911# a_6479_2749# 0.00214f
C1751 sg13cmos5l_dfrbp_1_0.Q a_13652_1924# 0
C1752 sg13cmos5l_dfrbp_1_6.D a_12804_6175# 0
C1753 sg13cmos5l_inv_1_26.Y a_18856_8436# -0
C1754 sg13cmos5l_buf_1_111.A sg13cmos5l_buf_1_105.A 0.02456f
C1755 sg13cmos5l_buf_1_101.X ph_sw[7] 0.00694f
C1756 sg13cmos5l_dfrbp_1_0.D a_17126_1626# 0.30994f
C1757 a_3016_9318# sg13cmos5l_dfrbp_1_6.RESET_B 0
C1758 sg13cmos5l_a221oi_1_0.B1 sg13cmos5l_nand2_1_0.A 0.00159f
C1759 sg13cmos5l_nor2_1_0.A sg13cmos5l_dfrbp_1_0.CLK 1.21306f
C1760 a_17135_4727# a_17399_3947# 0
C1761 a_10308_7992# a_10596_7687# 0.4806f
C1762 a_12216_5728# a_12520_4782# 0
C1763 sg13cmos5l_inv_1_8.A a_1956_8874# 0
C1764 sg13cmos5l_dlhr_1_2.D nl_sw[4] 0
C1765 sg13cmos5l_dfrbp_1_20.Q_N a_9040_7894# 0.15881f
C1766 sg13cmos5l_buf_1_2.A a_15466_2356# 0.05625f
C1767 a_7863_7282# cks 0
C1768 sg13cmos5l_dlhr_1_9.D a_6346_4873# 0.00468f
C1769 a_1125_5423# a_1862_4338# 0
C1770 a_3599_3215# nl_sw[2] 0
C1771 sg13cmos5l_inv_1_17.A a_2565_8447# 0.00159f
C1772 sg13cmos5l_a22oi_1_2.B2 sg13cmos5l_dlhr_1_20.Q_N 0.0055f
C1773 sg13cmos5l_dfrbp_1_0.D sg13cmos5l_buf_8_0.A 0.01133f
C1774 sg13cmos5l_buf_1_24.A pl_sw[3] 0
C1775 a_12998_3138# a_13072_1846# 0
C1776 a_13284_3456# a_12815_1703# 0
C1777 sg13cmos5l_dfrbp_1_6.RESET_B a_2224_7166# 0.18856f
C1778 a_5069_5376# a_5820_5773# 0.01741f
C1779 a_4950_5699# a_4736_5498# 0.03121f
C1780 a_18345_7674# a_18164_7996# 0.40925f
C1781 a_17545_7728# sg13cmos5l_dlhr_1_15.Q 0
C1782 sg13cmos5l_inv_1_8.A a_2342_5088# 0
C1783 sg13cmos5l_dfrbp_1_6.D sg13cmos5l_a221oi_1_0.A2 0
C1784 sg13cmos5l_inv_1_0.A sg13cmos5l_nor2b_1_0.Y 1.83737f
C1785 a_14342_8874# a_15045_8447# 0.02431f
C1786 sg13cmos5l_buf_1_2.A a_16204_4338# 0.00233f
C1787 sg13cmos5l_buf_1_63.A VPWR 0.43462f
C1788 a_4244_8436# a_4076_7624# 0
C1789 a_3407_8797# a_4324_7996# 0.00225f
C1790 a_2436_8861# sg13cmos5l_dfrbp_1_16.Q_N 0
C1791 sg13cmos5l_buf_1_18.A sg13cmos5l_dfrbp_1_5.Q_N 0
C1792 a_20392_7712# cko 0.29037f
C1793 sg13cmos5l_dfrbp_1_0.CLK a_14440_1664# 0
C1794 sg13cmos5l_dlhr_1_15.D a_15782_7362# 0
C1795 sg13cmos5l_a221oi_1_1.C1 a_9705_4650# 0.00739f
C1796 sg13cmos5l_buf_1_5.A a_13284_3456# 0.03693f
C1797 a_6789_4629# a_6315_3911# 0.01586f
C1798 a_6372_4968# a_7312_4142# 0
C1799 a_11190_7354# VPWR 0.25304f
C1800 sg13cmos5l_inv_1_17.A sg13cmos5l_dfrbp_1_9.Q 0.21205f
C1801 a_12721_4261# sg13cmos5l_o21ai_1_0.Y 0
C1802 sg13cmos5l_dfrbp_1_6.D a_11567_7751# 0
C1803 sg13cmos5l_dfrbp_1_0.RESET_B a_16268_3102# 0.12545f
C1804 sg13cmos5l_dfrbp_1_8.RESET_B a_5104_4870# 0.18231f
C1805 sg13cmos5l_buf_1_18.A a_18671_1703# 0
C1806 sg13cmos5l_dfrbp_1_6.RESET_B nh_sw[4] 0
C1807 a_18746_5776# sg13cmos5l_a22oi_1_1.A1 0.00107f
C1808 a_17161_8794# VPWR 0.41086f
C1809 a_10888_1664# a_11270_1626# 0
C1810 sg13cmos5l_buf_1_18.A a_18363_4270# 0.02466f
C1811 sg13cmos5l_buf_1_40.A a_1580_2352# 0.00645f
C1812 sg13cmos5l_dfrbp_1_6.RESET_B a_15974_6162# 0.10546f
C1813 a_15062_4292# VPWR 0
C1814 a_10292_9508# sg13cmos5l_buf_1_97.A 0.00208f
C1815 sg13cmos5l_dfrbp_1_8.RESET_B ph_sw[7] 0
C1816 sg13cmos5l_nand2_1_1.B a_12625_2749# 0.00156f
C1817 sg13cmos5l_buf_1_57.X a_9660_4686# 0
C1818 sg13cmos5l_buf_1_77.A a_8486_8874# 0.04759f
C1819 a_15177_5769# sg13cmos5l_or2_1_0.A 0
C1820 a_12549_9165# a_13297_9263# 0.01058f
C1821 a_3664_4142# sg13cmos5l_buf_1_44.A 0
C1822 sg13cmos5l_inv_1_8.Y VPWR 0.51984f
C1823 a_12815_4261# sg13cmos5l_dfrbp_1_1.Q 0
C1824 sg13cmos5l_dfrbp_1_0.RESET_B a_13652_3900# 0.01113f
C1825 a_5069_5376# VPWR 0.27057f
C1826 sg13cmos5l_buf_1_28.A sg13cmos5l_buf_1_30.X 0.44067f
C1827 sg13cmos5l_buf_1_41.A a_3530_6320# 0.00391f
C1828 a_19216_3358# d_out[1] 0
C1829 a_8486_8874# a_8457_7281# 0
C1830 a_9260_2352# a_9164_1590# 0
C1831 sg13cmos5l_buf_1_5.A a_13324_4696# 0
C1832 sg13cmos5l_buf_1_79.X a_10998_9168# 0
C1833 a_682_5380# a_1125_5423# 0.02241f
C1834 sg13cmos5l_dfrbp_1_6.RESET_B a_13396_7312# 0.00411f
C1835 sg13cmos5l_a221oi_1_0.A2 a_10024_5498# 0
C1836 a_7644_1662# VPWR 0
C1837 sg13cmos5l_inv_1_2.A sg13cmos5l_dlhr_1_15.D 0.32226f
C1838 sg13cmos5l_buf_1_58.A a_1609_4704# 0
C1839 sg13cmos5l_dfrbp_1_0.Q a_19628_2352# 0.04099f
C1840 sg13cmos5l_buf_1_34.X sg13cmos5l_buf_1_25.A 0.01837f
C1841 a_7052_9150# sg13cmos5l_dfrbp_1_8.RESET_B 0
C1842 sg13cmos5l_dlhr_1_11.GATE sg13cmos5l_dlhr_1_11.Q 0.00647f
C1843 a_8772_8440# a_8783_7751# 0
C1844 sg13cmos5l_dfrbp_1_0.RESET_B a_11270_4338# 0.11086f
C1845 sg13cmos5l_dlhr_1_6.D a_7888_4870# 0
C1846 sg13cmos5l_buf_1_24.A a_7508_1948# 0.00197f
C1847 a_15492_2392# a_15909_2399# 0.49014f
C1848 sg13cmos5l_dfrbp_1_6.RESET_B a_17399_3947# 0.09089f
C1849 sg13cmos5l_buf_1_40.A sg13cmos5l_buf_1_31.X 0.15245f
C1850 sg13cmos5l_dlhr_1_18.Q_N a_11560_7010# 0.02372f
C1851 a_17988_3151# sg13cmos5l_nor2_1_1.A 0
C1852 sg13cmos5l_dlhr_1_10.Q a_19548_6198# 0
C1853 a_13701_3117# nh_sw[7] 0
C1854 sg13cmos5l_buf_1_104.A pl_sw[9] 0
C1855 sg13cmos5l_dfrbp_1_6.RESET_B sg13cmos5l_buf_1_56.A 0.01197f
C1856 sg13cmos5l_a22oi_1_0.B1 a_10220_3102# 0.00875f
C1857 sg13cmos5l_dlhr_1_11.GATE a_11848_8436# 0.03242f
C1858 a_8022_3120# a_8392_3270# 0.03916f
C1859 a_2054_3138# sg13cmos5l_inv_1_19.A 0.00484f
C1860 sg13cmos5l_buf_1_25.X a_6889_1680# 0
C1861 a_15206_2826# a_15200_1758# 0
C1862 sg13cmos5l_buf_1_5.X a_16011_2399# 0
C1863 a_9832_1664# nh_sw[4] 0
C1864 a_16572_4261# a_15909_2399# 0
C1865 sg13cmos5l_buf_1_0.A a_18671_1703# 0.02573f
C1866 sg13cmos5l_dfrbp_1_0.Q sg13cmos5l_buf_1_8.A 0.0324f
C1867 sg13cmos5l_buf_1_0.A a_18363_4270# 0.05137f
C1868 sg13cmos5l_dfrbp_1_21.Q VPWR 0.73569f
C1869 sg13cmos5l_dfrbp_1_0.D a_18376_2388# 0.07564f
C1870 sg13cmos5l_inv_1_1.A a_15974_6162# 0.02326f
C1871 sg13cmos5l_dlhr_1_6.D a_9268_6148# 0
C1872 sg13cmos5l_buf_1_56.A a_10412_6126# 0.03707f
C1873 a_9033_6162# sg13cmos5l_dlhr_1_6.Q_N 0.00294f
C1874 a_8570_6172# sg13cmos5l_buf_1_29.A 0
C1875 sg13cmos5l_dfrbp_1_6.D sg13cmos5l_buf_1_35.A 0.00504f
C1876 sg13cmos5l_nand2_1_0.B sg13cmos5l_dfrbp_1_2.D 0.04888f
C1877 sg13cmos5l_nor2_1_0.A a_13641_3529# 0.00102f
C1878 a_8296_3986# sg13cmos5l_dlhr_1_2.Q 0.00238f
C1879 sg13cmos5l_dfrbp_1_0.CLK sg13cmos5l_buf_1_18.X 0.03693f
C1880 a_18164_6924# a_18568_7010# 0.0303f
C1881 a_9865_7282# a_10028_6126# 0
C1882 a_10071_7282# sg13cmos5l_buf_1_56.A 0.00348f
C1883 a_6598_4663# sg13cmos5l_buf_1_25.A 0
C1884 a_8972_3864# sg13cmos5l_dfrbp_1_10.Q 0
C1885 sg13cmos5l_buf_1_79.X a_9448_6924# 0
C1886 sg13cmos5l_buf_1_34.X a_5408_3986# 0
C1887 sg13cmos5l_dfrbp_1_0.Q sg13cmos5l_buf_1_1.A 1.86736f
C1888 sg13cmos5l_dfrbp_1_1.Q nl_sw[8] 0.01988f
C1889 sg13cmos5l_dfrbp_1_0.D a_18928_1846# 0
C1890 a_16204_4338# sg13cmos5l_dfrbp_1_6.Q_N 0.15881f
C1891 a_15821_3864# a_16298_4338# 0.00176f
C1892 a_13076_5376# a_13486_5760# 0
C1893 sg13cmos5l_dfrbp_1_0.D sg13cmos5l_inv_1_5.A 0
C1894 sg13cmos5l_dlhr_1_15.Q VPWR 0.34214f
C1895 sg13cmos5l_buf_1_6.A a_15466_2356# 0
C1896 a_12896_3270# sg13cmos5l_buf_1_8.A 0
C1897 sg13cmos5l_dfrbp_1_0.CLK a_17700_1639# 0
C1898 sg13cmos5l_inv_1_3.A a_13681_6239# 0.00699f
C1899 sg13cmos5l_buf_1_57.X sg13cmos5l_dlhr_1_6.Q_N 0.0275f
C1900 sg13cmos5l_buf_1_116.A sg13cmos5l_dlhr_1_19.Q_N 0.0038f
C1901 sg13cmos5l_inv_1_8.A a_3664_8678# 0.00691f
C1902 a_17516_9150# pl_sw[9] 0.02993f
C1903 sg13cmos5l_buf_1_57.X a_10484_6924# 0.00264f
C1904 a_10282_7897# a_10665_7281# 0
C1905 a_10725_7653# cks 0.00467f
C1906 sg13cmos5l_inv_1_20.Y a_2621_7636# 0
C1907 sg13cmos5l_buf_1_2.A a_15780_2813# 0.00113f
C1908 a_2228_4972# sg13cmos5l_inv_1_19.A 0
C1909 sg13cmos5l_inv_1_17.A a_3313_8797# 0.00808f
C1910 sg13cmos5l_dfrbp_1_23.Q_N sg13cmos5l_nand2_1_1.B 0
C1911 sg13cmos5l_dfrbp_1_10.Q_N nl_sw[2] 0
C1912 sg13cmos5l_dfrbp_1_15.D a_1125_6935# 0.34552f
C1913 a_3860_2388# sg13cmos5l_buf_1_33.A 0
C1914 a_11530_1849# a_11844_1639# 0.00659f
C1915 sg13cmos5l_dfrbp_1_6.D a_2667_3911# 0
C1916 sg13cmos5l_buf_1_40.A a_1125_6935# 0.01498f
C1917 sg13cmos5l_dfrbp_1_6.D a_11752_6294# 0.0032f
C1918 sg13cmos5l_buf_1_97.A sg13cmos5l_buf_1_90.X 0
C1919 a_524_4614# a_1609_4704# 0
C1920 a_5820_5773# a_5799_5499# 0.38902f
C1921 a_5452_5850# a_5951_5383# 0
C1922 sg13cmos5l_buf_1_29.A a_9260_2352# 0.00689f
C1923 sg13cmos5l_buf_1_73.A a_6219_6284# 0
C1924 sg13cmos5l_or2_1_1.B VPWR 0.77223f
C1925 a_14628_8440# a_15147_8447# 0.38871f
C1926 a_15045_8447# a_14916_8861# 0.01562f
C1927 sg13cmos5l_buf_1_2.A a_14814_3876# 0
C1928 sg13cmos5l_dfrbp_1_15.D a_4349_7636# 0.00529f
C1929 sg13cmos5l_buf_1_45.X a_7863_7282# 0.03538f
C1930 a_17392_4870# sg13cmos5l_a22oi_1_1.Y 0
C1931 sg13cmos5l_or2_1_0.A a_11072_2474# 0
C1932 a_13035_6284# sg13cmos5l_a22oi_1_1.B2 0.00121f
C1933 a_14476_2388# VPWR 0.00736f
C1934 a_12567_7282# VPWR 0.18132f
C1935 a_7631_4727# a_7055_4261# 0
C1936 sg13cmos5l_buf_1_40.X nh_sw[0] 0.45023f
C1937 sg13cmos5l_buf_1_93.X sg13cmos5l_dfrbp_1_24.Q_N 0
C1938 sg13cmos5l_dfrbp_1_8.RESET_B sg13cmos5l_dlhr_1_0.GATE 0.1467f
C1939 sg13cmos5l_dfrbp_1_16.Q a_9865_7282# 0.00189f
C1940 sg13cmos5l_dfrbp_1_6.D sg13cmos5l_dlhr_1_11.D 0
C1941 sg13cmos5l_dfrbp_1_6.RESET_B a_4172_1590# 0.00169f
C1942 sg13cmos5l_buf_1_73.A a_8043_7796# 0
C1943 sg13cmos5l_dfrbp_1_6.RESET_B sg13cmos5l_dlhr_1_9.Q_N 0.01028f
C1944 a_12520_3176# sg13cmos5l_buf_1_6.A 0.28895f
C1945 a_12120_3456# a_12022_3134# 0.00204f
C1946 sg13cmos5l_o21ai_1_0.Y a_13258_3361# 0.00121f
C1947 a_9823_2780# a_9823_2364# 0
C1948 a_10613_2758# sg13cmos5l_dfrbp_1_4.D 0.04203f
C1949 sg13cmos5l_inv_1_8.A sg13cmos5l_buf_1_73.A 0.00159f
C1950 sg13cmos5l_buf_1_44.X a_4950_5699# 0.04506f
C1951 sg13cmos5l_dfrbp_1_6.RESET_B a_17776_6382# 0.21978f
C1952 a_16298_4338# VPWR 0
C1953 a_18746_5776# sg13cmos5l_or2_1_0.A 0
C1954 sg13cmos5l_buf_1_77.A a_9060_8861# 0.01548f
C1955 sg13cmos5l_buf_1_38.A a_4640_3986# 0.01197f
C1956 a_5132_3864# sg13cmos5l_buf_1_44.A 0.31814f
C1957 sg13cmos5l_inv_1_27.Y a_13297_9263# 0
C1958 a_13648_9406# sg13cmos5l_dfrbp_1_23.CLK 0
C1959 a_14228_9484# sg13cmos5l_dfrbp_1_24.Q_N 0.25039f
C1960 a_2565_8447# a_2831_7630# 0.00311f
C1961 a_1862_8874# sg13cmos5l_buf_1_58.A 0.00231f
C1962 sg13cmos5l_dfrbp_1_0.CLK sg13cmos5l_o21ai_1_0.Y 0.01469f
C1963 a_14726_7674# sg13cmos5l_buf_1_89.A 0
C1964 sg13cmos5l_nand2_1_1.A sg13cmos5l_dfrbp_1_1.Q 0
C1965 sg13cmos5l_inv_1_3.A a_14152_8522# 0.03831f
C1966 a_5799_5499# VPWR 0.20766f
C1967 a_13035_6284# a_12804_6175# 0.15089f
C1968 a_12516_6480# a_13681_6239# 0.4858f
C1969 sg13cmos5l_inv_1_20.Y ph_sw[1] 0.2585f
C1970 sg13cmos5l_a221oi_1_1.C1 a_11072_5347# 0.19603f
C1971 sg13cmos5l_buf_1_90.X a_13047_7690# 0.00601f
C1972 sg13cmos5l_buf_1_30.A a_5700_6480# 0
C1973 a_4177_7326# a_4244_6924# 0.0018f
C1974 a_3308_9150# sg13cmos5l_buf_1_61.X 0.00153f
C1975 a_2248_9224# sg13cmos5l_inv_1_19.A 0
C1976 sg13cmos5l_dfrbp_1_21.Q a_17554_4650# 0
C1977 sg13cmos5l_buf_1_97.A a_11190_7354# 0
C1978 sg13cmos5l_buf_1_45.X sg13cmos5l_a22oi_1_0.Y 0
C1979 a_11270_1626# VPWR 0.93835f
C1980 sg13cmos5l_inv_1_3.A sg13cmos5l_buf_1_94.X 0.03128f
C1981 sg13cmos5l_o21ai_1_0.A1 a_10783_3876# 0
C1982 a_16395_4772# sg13cmos5l_dfrbp_1_0.RESET_B 0
C1983 sg13cmos5l_nand2_1_0.A a_13701_3117# 0
C1984 sg13cmos5l_dfrbp_1_0.RESET_B a_11844_4325# 0.00121f
C1985 sg13cmos5l_dfrbp_1_9.Q a_5796_3904# 0
C1986 a_8772_8440# sg13cmos5l_dfrbp_1_20.Q 0
C1987 a_9291_8447# a_9620_7972# 0
C1988 sg13cmos5l_nand2_1_1.B sg13cmos5l_dfrbp_1_4.D 0.07162f
C1989 sg13cmos5l_dfrbp_1_2.D a_11174_2826# 0
C1990 sg13cmos5l_buf_1_25.A a_10220_3102# 0
C1991 sg13cmos5l_dfrbp_1_1.Q sg13cmos5l_inv_1_11.Y 0.14742f
C1992 a_15492_2392# a_17008_2630# 0.00159f
C1993 a_15909_2399# a_16011_2399# 0.6663f
C1994 pl_sw[8] ph_sw[9] 0
C1995 pl_sw[9] pl_sw[10] 0
C1996 sg13cmos5l_and3_1_0.C sg13cmos5l_buf_1_2.A 0.17866f
C1997 a_12567_7282# a_12698_7288# 0.65127f
C1998 a_14632_9224# sg13cmos5l_inv_1_3.A 0.03673f
C1999 a_15884_3102# nh_sw[7] 0.28943f
C2000 sg13cmos5l_o21ai_1_0.A1 a_11556_3904# 0.0537f
C2001 sg13cmos5l_inv_1_17.A sg13cmos5l_buf_1_41.A 0.03572f
C2002 sg13cmos5l_buf_1_29.A sg13cmos5l_nor2_1_0.A 0
C2003 sg13cmos5l_dfrbp_1_20.Q a_11370_5760# 0
C2004 a_9879_9202# ph_sw[5] 0
C2005 sg13cmos5l_buf_1_65.X sg13cmos5l_dfrbp_1_6.D 0
C2006 sg13cmos5l_dlhr_1_2.Q a_8392_3270# 0.00147f
C2007 sg13cmos5l_dfrbp_1_8.RESET_B a_1873_5773# 0
C2008 a_10665_7281# sg13cmos5l_nor2_1_0.A 0
C2009 sg13cmos5l_dfrbp_1_6.D a_5908_3124# 0
C2010 sg13cmos5l_buf_1_78.A a_6405_8447# 0.00106f
C2011 a_16703_3871# a_15909_2399# 0.00232f
C2012 a_16572_4261# a_17008_2630# 0
C2013 sg13cmos5l_dfrbp_1_10.Q a_7452_3174# 0
C2014 sg13cmos5l_inv_1_3.A sg13cmos5l_nand2_1_1.B 0.10768f
C2015 a_1227_6935# VPWR 0.21254f
C2016 sg13cmos5l_buf_1_101.X a_16177_7751# 0
C2017 sg13cmos5l_dlhr_1_1.GATE a_1873_7285# 0
C2018 a_12404_7972# a_12516_6480# 0
C2019 sg13cmos5l_or2_1_0.A a_4640_3986# 0
C2020 sg13cmos5l_dlhr_1_5.D a_6789_4629# 0
C2021 sg13cmos5l_dfrbp_1_8.D sg13cmos5l_dlhr_1_10.Q 0
C2022 a_2148_8440# sg13cmos5l_inv_1_19.A 0.00272f
C2023 sg13cmos5l_dfrbp_1_21.Q a_12814_4692# 0
C2024 a_4460_9150# a_4349_7636# 0.00255f
C2025 a_17674_3361# sg13cmos5l_nor2_1_1.A 0
C2026 sg13cmos5l_buf_1_18.A sg13cmos5l_dfrbp_1_0.RESET_B 0.0129f
C2027 sg13cmos5l_buf_8_2.X cks 0.00479f
C2028 a_16572_4261# a_17354_4180# 0.4806f
C2029 sg13cmos5l_dfrbp_1_6.D nh_sw[1] 0.00352f
C2030 sg13cmos5l_dfrbp_1_0.D a_18577_1703# 0
C2031 a_7497_3138# a_7316_3460# 0.40925f
C2032 sg13cmos5l_buf_1_6.A a_15780_2813# 0
C2033 sg13cmos5l_inv_1_8.A sg13cmos5l_dfrbp_1_15.D 0.03168f
C2034 sg13cmos5l_dfrbp_1_23.CLK ph_sw[6] 0.00727f
C2035 a_12404_7972# cks 0
C2036 a_9524_4972# sg13cmos5l_buf_1_46.A 0.00215f
C2037 sg13cmos5l_buf_1_60.X a_4076_7624# 0
C2038 sg13cmos5l_inv_1_8.A sg13cmos5l_buf_1_40.A 0.03163f
C2039 a_3562_4873# sg13cmos5l_inv_1_19.A 0
C2040 sg13cmos5l_dlhr_1_3.Q_N a_4934_2826# 0.04978f
C2041 sg13cmos5l_inv_1_2.A sg13cmos5l_dfrbp_1_8.Q_N 0
C2042 a_16234_6385# VPWR 0.09473f
C2043 sg13cmos5l_buf_1_2.A a_15849_2435# 0
C2044 sg13cmos5l_dlhr_1_9.D a_7537_4727# 0.00181f
C2045 a_10224_9508# VPWR 0
C2046 sg13cmos5l_dfrbp_1_8.RESET_B sg13cmos5l_dfrbp_1_16.Q_N 0
C2047 a_16260_6480# sg13cmos5l_dfrbp_1_21.Q 0.00552f
C2048 sg13cmos5l_buf_1_32.A VPWR 0.54261f
C2049 sg13cmos5l_buf_1_40.X a_1760_1758# 0.00181f
C2050 a_14543_3215# sg13cmos5l_buf_1_1.A 0
C2051 sg13cmos5l_buf_1_5.X a_14924_1590# 0
C2052 a_13072_1846# a_13017_1941# 0.00464f
C2053 sg13cmos5l_inv_1_14.A sg13cmos5l_buf_1_78.X 0.14942f
C2054 a_14152_8522# cks 0.00402f
C2055 a_7820_9150# pl_sw[4] 0
C2056 a_14814_3876# sg13cmos5l_buf_1_6.A 0
C2057 sg13cmos5l_buf_1_5.A sg13cmos5l_dlhr_1_18.Q_N 0
C2058 sg13cmos5l_a22oi_1_1.Y a_14800_3358# 0
C2059 sg13cmos5l_inv_1_26.Y a_17780_8436# 0
C2060 sg13cmos5l_dfrbp_1_6.RESET_B a_2879_6432# 0.00856f
C2061 a_15147_8447# a_15887_8797# 0.3087f
C2062 sg13cmos5l_dlhr_1_15.D a_17746_7362# 0
C2063 sg13cmos5l_inv_1_3.A a_12230_6162# 0
C2064 sg13cmos5l_or2_1_1.B a_12814_4692# 0
C2065 a_17588_2388# VPWR 0.35606f
C2066 a_13977_6477# sg13cmos5l_and3_1_0.X 0
C2067 a_12804_6175# a_12800_5498# 0
C2068 ph_sw[1] sg13cmos5l_buf_1_68.X 0.00658f
C2069 sg13cmos5l_buf_1_116.A sg13cmos5l_a22oi_1_1.B2 0
C2070 sg13cmos5l_buf_1_94.X cks 0
C2071 a_8468_4948# a_8588_3864# 0.00275f
C2072 a_16264_9224# pl_sw[7] 0.00274f
C2073 sg13cmos5l_inv_1_7.A sg13cmos5l_inv_1_29.A 0.04782f
C2074 sg13cmos5l_dfrbp_1_12.Q_N a_7312_4142# 0.16426f
C2075 a_616_9224# sg13cmos5l_buf_1_61.X 0.0355f
C2076 sg13cmos5l_buf_1_68.X a_1000_9224# 0.01271f
C2077 a_17751_7690# a_17776_6382# 0
C2078 sg13cmos5l_buf_1_74.X a_7820_9150# 0.1323f
C2079 a_7052_9150# sg13cmos5l_buf_1_77.X 0.00657f
C2080 sg13cmos5l_buf_1_76.X pl_sw[4] 0.17297f
C2081 sg13cmos5l_a221oi_1_1.C1 sg13cmos5l_dfrbp_1_2.D 0
C2082 sg13cmos5l_a22oi_1_2.B2 sg13cmos5l_a22oi_1_0.Y 0.23164f
C2083 sg13cmos5l_dfrbp_1_6.D a_17414_3138# 0
C2084 sg13cmos5l_dfrbp_1_8.RESET_B a_16177_7751# 0.0073f
C2085 a_3856_3358# sg13cmos5l_buf_1_33.A 0
C2086 a_7524_7992# pl_sw[5] 0
C2087 sg13cmos5l_buf_1_44.A a_6198_3120# 0.56969f
C2088 a_13072_4142# sg13cmos5l_o21ai_1_0.B1 0
C2089 sg13cmos5l_buf_1_6.A a_12075_1748# 0
C2090 a_11270_1626# a_11973_1605# 0.02453f
C2091 a_11530_1849# a_12075_1748# 0.00999f
C2092 a_17829_1605# VPWR 0.2437f
C2093 a_17493_3947# VPWR 0.09832f
C2094 sg13cmos5l_buf_1_110.A a_15821_3864# 0
C2095 a_13391_9263# pl_sw[7] 0.00135f
C2096 a_18486_8866# a_18568_7010# 0
C2097 sg13cmos5l_buf_1_73.X sg13cmos5l_buf_1_78.A 0.07723f
C2098 sg13cmos5l_buf_1_76.X sg13cmos5l_buf_1_74.X 0.55628f
C2099 sg13cmos5l_inv_1_7.A a_11877_2399# 0.00332f
C2100 sg13cmos5l_buf_1_77.A a_9129_8483# 0
C2101 sg13cmos5l_buf_1_0.A sg13cmos5l_dfrbp_1_0.RESET_B 0.04104f
C2102 sg13cmos5l_dfrbp_1_15.D a_1948_7964# 0.00801f
C2103 sg13cmos5l_and3_1_0.C sg13cmos5l_dfrbp_1_6.Q_N 0.00138f
C2104 a_10028_6126# VPWR 0.24935f
C2105 sg13cmos5l_dlhr_1_15.D a_14889_7281# 0
C2106 sg13cmos5l_buf_1_45.X sg13cmos5l_buf_1_26.A 0.14948f
C2107 a_18760_2388# sg13cmos5l_buf_1_19.X 0.28784f
C2108 sg13cmos5l_dlhr_1_9.D a_3562_4873# 0.00324f
C2109 sg13cmos5l_inv_1_3.A a_15793_8797# 0
C2110 sg13cmos5l_dfrbp_1_1.Q a_13701_3117# 0.0039f
C2111 a_14032_6382# sg13cmos5l_dfrbp_1_23.Q_N 0.15881f
C2112 a_3692_9150# ph_sw[2] 0.00181f
C2113 sg13cmos5l_buf_1_2.X nh_sw[6] 0
C2114 a_4425_7281# sg13cmos5l_buf_1_59.A 0.29386f
C2115 sg13cmos5l_buf_1_9.A a_10427_2736# 0
C2116 sg13cmos5l_dfrbp_1_0.RESET_B a_13803_3260# 0.56262f
C2117 sg13cmos5l_buf_1_30.A a_7796_6460# 0.0028f
C2118 sg13cmos5l_dfrbp_1_16.Q a_5820_5773# 0.01234f
C2119 sg13cmos5l_inv_1_3.A sg13cmos5l_a22oi_1_1.A1 0
C2120 a_12933_6141# sg13cmos5l_inv_1_0.A 0.01258f
C2121 sg13cmos5l_a221oi_1_0.A2 a_10587_4692# 0.03964f
C2122 sg13cmos5l_dfrbp_1_0.D sg13cmos5l_dfrbp_1_1.Q 0.04312f
C2123 sg13cmos5l_buf_1_30.A a_7520_7010# 0
C2124 sg13cmos5l_buf_1_19.X a_19508_1924# 0
C2125 a_13072_1846# VPWR 0.14795f
C2126 sg13cmos5l_buf_1_45.X sg13cmos5l_buf_1_46.A 0.06327f
C2127 a_15492_2392# nh_sw[7] 0.04595f
C2128 a_10031_8797# sg13cmos5l_dfrbp_1_20.Q 0
C2129 sg13cmos5l_and3_1_0.C sg13cmos5l_buf_1_6.A 0
C2130 sg13cmos5l_dfrbp_1_2.D a_11072_2474# 0
C2131 sg13cmos5l_buf_1_111.A VPWR 0.54637f
C2132 a_3664_4142# a_3313_4261# 0.01017f
C2133 a_3407_4261# a_4244_3900# 0.1333f
C2134 a_16011_2399# a_17008_2630# 0.07046f
C2135 a_682_5380# a_708_5416# 0.43042f
C2136 sg13cmos5l_dfrbp_1_10.Q a_9544_2474# 0.00161f
C2137 sg13cmos5l_dlhr_1_9.Q a_4950_5699# 0
C2138 a_12980_6924# a_13161_7281# 0.40925f
C2139 a_12490_6385# a_12933_6141# 0.02241f
C2140 a_12230_6162# a_12516_6480# 0.50066f
C2141 sg13cmos5l_nor2_1_0.A a_12216_5728# 0.01152f
C2142 a_4460_9150# sg13cmos5l_inv_1_8.A 0
C2143 sg13cmos5l_dfrbp_1_6.RESET_B a_13876_7660# 0.00538f
C2144 sg13cmos5l_dfrbp_1_8.RESET_B a_5508_6162# 0
C2145 a_17700_3456# a_17988_3151# 0.4806f
C2146 sg13cmos5l_a221oi_1_0.A2 a_6086_4650# 0
C2147 a_17008_2630# a_16936_1758# 0.00365f
C2148 a_16751_2749# a_17386_1849# 0.00713f
C2149 sg13cmos5l_buf_1_110.A VPWR 0.563f
C2150 sg13cmos5l_dlhr_1_9.D sg13cmos5l_buf_1_28.X 0
C2151 a_1862_4338# a_2436_4325# 0.36169f
C2152 a_16703_3871# a_17008_2630# 0
C2153 a_17161_8794# ph_sw[9] 0
C2154 sg13cmos5l_dfrbp_1_16.Q VPWR 0.85669f
C2155 sg13cmos5l_inv_1_6.A a_20672_4782# 0
C2156 a_1864_9224# a_1760_9318# 0.00624f
C2157 sg13cmos5l_nor2_1_0.A sg13cmos5l_dfrbp_1_1.Q_N 0
C2158 a_20392_6924# VPWR 0.30888f
C2159 sg13cmos5l_buf_1_104.A a_19340_8400# 0.00165f
C2160 sg13cmos5l_dlhr_1_1.GATE a_1997_6126# 0.00962f
C2161 a_13047_7690# a_12567_7282# 0
C2162 a_1227_6935# a_1967_7285# 0.3087f
C2163 a_17386_1849# a_17412_1944# 0.43042f
C2164 a_16936_1758# a_17126_1626# 0.00201f
C2165 sg13cmos5l_dfrbp_1_6.D a_18300_7710# 0
C2166 a_16551_3987# a_17493_3947# 0.00999f
C2167 a_16703_3871# a_17354_4180# 0.01562f
C2168 a_10464_2427# nh_sw[5] 0.00121f
C2169 a_6507_8447# sg13cmos5l_dfrbp_1_6.D 0.00116f
C2170 a_7504_8678# a_7498_7897# 0.00546f
C2171 a_7497_3138# a_7430_3576# 0
C2172 a_7316_3460# a_7248_3460# 0
C2173 a_3212_1590# a_3008_1758# 0.03376f
C2174 a_15492_2392# a_15357_1816# 0
C2175 sg13cmos5l_dfrbp_1_6.D a_5492_3460# 0.03106f
C2176 a_3688_1664# VPWR 0.25709f
C2177 sg13cmos5l_inv_1_0.A a_11372_3102# 0
C2178 sg13cmos5l_dfrbp_1_10.Q a_6903_3154# 0.0097f
C2179 a_6903_3154# a_6736_2630# 0
C2180 sg13cmos5l_buf_1_57.X a_13161_7281# 0
C2181 sg13cmos5l_dfrbp_1_6.D a_3447_2746# 0.0133f
C2182 a_8204_9150# sg13cmos5l_dfrbp_1_18.Q 0
C2183 sg13cmos5l_inv_1_18.A a_9865_7282# 0.00123f
C2184 sg13cmos5l_nor2b_1_0.Y sg13cmos5l_dlhr_1_0.D 0.19048f
C2185 a_17519_6239# VPWR 0.29287f
C2186 a_5194_2356# a_5637_2399# 0.02241f
C2187 a_2831_7630# sg13cmos5l_buf_1_41.A 0
C2188 a_8439_6178# sg13cmos5l_buf_1_56.A 0
C2189 a_9033_6162# a_8852_6484# 0.40925f
C2190 sg13cmos5l_nor2_1_0.A sg13cmos5l_buf_1_6.A 0.07013f
C2191 sg13cmos5l_buf_1_1.A a_16552_1664# 0.0035f
C2192 sg13cmos5l_buf_1_30.A a_6213_3911# 0.00119f
C2193 a_18356_6460# sg13cmos5l_dfrbp_1_21.Q 0.14226f
C2194 sg13cmos5l_a221oi_1_0.C1 a_10331_3900# 0.08414f
C2195 a_15793_8797# cks 0
C2196 sg13cmos5l_buf_1_5.A a_12913_7326# 0
C2197 sg13cmos5l_dfrbp_1_6.D a_6789_4629# 0
C2198 sg13cmos5l_buf_1_65.X a_5702_8874# 0
C2199 sg13cmos5l_a22oi_1_1.Y a_15821_3864# 0.01356f
C2200 sg13cmos5l_a22oi_1_1.A1 cks 0.02105f
C2201 a_16144_8678# sg13cmos5l_dfrbp_1_22.D 0
C2202 a_15793_8797# a_16306_8874# 0
C2203 a_15887_8797# sg13cmos5l_dfrbp_1_25.Q_N 0.04107f
C2204 sg13cmos5l_inv_1_3.A a_14032_6382# 0.02404f
C2205 sg13cmos5l_buf_1_57.X a_8852_6484# 0
C2206 sg13cmos5l_dlhr_1_0.GATE a_7226_1636# 0.00902f
C2207 a_19244_2352# VPWR 0.25321f
C2208 VPWR d_out[2] 0.2143f
C2209 sg13cmos5l_dfrbp_1_15.D a_708_6928# 0.08578f
C2210 sg13cmos5l_dfrbp_1_12.Q_N a_8972_3864# 0.01575f
C2211 sg13cmos5l_buf_1_86.A a_20288_7010# 0.06101f
C2212 a_1864_9224# a_1846_7850# 0
C2213 sg13cmos5l_inv_1_0.A a_12616_5498# 0
C2214 sg13cmos5l_buf_1_40.A a_708_6928# 0.02f
C2215 a_908_1590# a_1192_1664# 0.13542f
C2216 sg13cmos5l_a22oi_1_2.B2 sg13cmos5l_buf_1_46.A 0.54509f
C2217 sg13cmos5l_inv_1_0.A a_10230_4632# 0
C2218 sg13cmos5l_inv_1_1.A ph_sw[7] 0
C2219 sg13cmos5l_dfrbp_1_8.RESET_B a_2596_7996# 0.01656f
C2220 sg13cmos5l_buf_1_6.A a_14440_1664# 0.00242f
C2221 a_11973_1605# a_13072_1846# 0
C2222 a_12075_1748# a_12815_1703# 0.3087f
C2223 a_16234_6385# a_16260_6480# 0.43042f
C2224 a_20012_1590# VPWR 0.25015f
C2225 a_6372_4968# a_6903_3154# 0
C2226 sg13cmos5l_buf_1_38.A a_4934_2826# 0
C2227 a_4640_3986# sg13cmos5l_buf_1_34.A 0
C2228 a_10224_9508# sg13cmos5l_buf_1_97.A 0
C2229 a_5702_8874# a_5962_8404# 0.87117f
C2230 sg13cmos5l_inv_1_7.A a_12976_2630# 0.01468f
C2231 sg13cmos5l_buf_1_63.X VPWR 0.30272f
C2232 sg13cmos5l_dfrbp_1_15.D a_1664_7806# 0
C2233 a_14166_7656# VPWR 0.25174f
C2234 sg13cmos5l_buf_8_0.X cko 0.06464f
C2235 sg13cmos5l_or2_1_0.A sg13cmos5l_dfrbp_1_4.D 0
C2236 sg13cmos5l_buf_1_3.A a_19444_5800# 0.00131f
C2237 a_4005_4629# VPWR 0.24378f
C2238 a_11272_8522# a_10308_7992# 0
C2239 sg13cmos5l_buf_1_40.A a_1664_7806# 0
C2240 sg13cmos5l_dlhr_1_11.GATE pl_sw[6] 0.10166f
C2241 sg13cmos5l_nand2_1_0.A a_15492_2392# 0
C2242 sg13cmos5l_dfrbp_1_16.Q a_8233_6216# 0
C2243 sg13cmos5l_inv_1_0.A nh_sw[5] 0
C2244 sg13cmos5l_buf_1_28.X a_9823_2364# 0.00685f
C2245 sg13cmos5l_dfrbp_1_0.RESET_B sg13cmos5l_buf_1_5.X 1.44114f
C2246 sg13cmos5l_dlhr_1_15.Q ph_sw[9] 0.24159f
C2247 sg13cmos5l_dfrbp_1_6.D a_1815_4666# 0.02204f
C2248 sg13cmos5l_dfrbp_1_16.Q sg13cmos5l_dfrbp_1_11.Q 0.04398f
C2249 sg13cmos5l_buf_1_93.X a_14342_8874# 0
C2250 sg13cmos5l_dfrbp_1_6.RESET_B a_2790_7996# 0
C2251 sg13cmos5l_buf_1_30.A sg13cmos5l_dlhr_1_5.Q 0
C2252 sg13cmos5l_buf_1_19.X sg13cmos5l_dfrbp_1_0.Q_N 0
C2253 sg13cmos5l_dfrbp_1_18.Q a_7247_8797# 0.00143f
C2254 a_16268_1590# nl_sw[7] 0.28895f
C2255 sg13cmos5l_buf_1_65.X ph_sw[3] 0.0076f
C2256 a_16268_1590# VPWR 0.25074f
C2257 sg13cmos5l_buf_1_40.A sg13cmos5l_buf_1_32.X 0.0182f
C2258 sg13cmos5l_a22oi_1_1.Y VPWR 0.40817f
C2259 sg13cmos5l_buf_1_45.X sg13cmos5l_nand2_1_1.B 0
C2260 sg13cmos5l_inv_1_3.A sg13cmos5l_or2_1_0.A 0
C2261 a_4244_3900# sg13cmos5l_buf_1_38.A 0.01104f
C2262 a_11530_3868# sg13cmos5l_o21ai_1_0.A2 0
C2263 sg13cmos5l_inv_1_9.Y VPWR 0.51664f
C2264 a_17008_2630# sg13cmos5l_dfrbp_1_5.Q_N 0.15881f
C2265 sg13cmos5l_a22oi_1_1.B1 a_10783_3876# 0.00642f
C2266 a_14228_9484# a_14342_8874# 0
C2267 sg13cmos5l_buf_1_19.A d_out[1] 0
C2268 a_9189_8447# a_10022_7674# 0
C2269 a_13686_7354# a_14295_7282# 0
C2270 a_12933_6141# a_13775_6239# 0.00437f
C2271 a_12516_6480# a_14032_6382# 0.00294f
C2272 sg13cmos5l_dfrbp_1_8.D a_16164_4663# 0.00506f
C2273 sg13cmos5l_dfrbp_1_6.RESET_B a_14820_7674# 0
C2274 sg13cmos5l_dfrbp_1_8.RESET_B a_6865_6239# 0.01857f
C2275 a_6405_8447# cks 0.01294f
C2276 a_18959_3215# a_18865_3215# 0.32273f
C2277 sg13cmos5l_dfrbp_1_6.RESET_B sg13cmos5l_dlhr_1_0.GATE 0.79874f
C2278 sg13cmos5l_buf_1_5.A sg13cmos5l_and3_1_0.C 0.03035f
C2279 sg13cmos5l_buf_1_26.X a_9164_1590# 0.28793f
C2280 sg13cmos5l_a221oi_1_0.A2 a_7631_4727# 0.03578f
C2281 a_8041_5770# a_8468_4948# 0
C2282 cks nh_sw[8] 0.03225f
C2283 sg13cmos5l_dfrbp_1_8.RESET_B a_8982_7354# 0.00252f
C2284 sg13cmos5l_buf_1_44.X sg13cmos5l_buf_1_24.A 0
C2285 sg13cmos5l_or2_1_0.A a_7316_3460# 0.00159f
C2286 sg13cmos5l_dfrbp_1_8.RESET_B a_17041_4727# 0
C2287 a_1862_4338# a_2505_3947# 0.00806f
C2288 a_16271_7751# pl_sw[8] 0
C2289 a_2565_3911# a_3407_4261# 0.0032f
C2290 sg13cmos5l_nand2_1_0.A a_10618_3142# 0
C2291 sg13cmos5l_dfrbp_1_0.CLK nh_sw[6] 0
C2292 sg13cmos5l_buf_1_24.A a_9260_2352# 0
C2293 sg13cmos5l_a22oi_1_1.B1 a_11556_3904# 0.01131f
C2294 sg13cmos5l_inv_1_7.A sg13cmos5l_a22oi_1_1.B2 0
C2295 sg13cmos5l_dfrbp_1_6.RESET_B a_9076_5800# 0.00417f
C2296 a_18999_6178# a_19028_5412# 0
C2297 sg13cmos5l_dfrbp_1_15.Q_N VPWR 0.18369f
C2298 a_13178_7684# a_13161_7281# 0.00183f
C2299 a_1967_7285# sg13cmos5l_dfrbp_1_16.Q 0.00256f
C2300 a_1873_7285# a_2386_7362# 0
C2301 sg13cmos5l_dlhr_1_1.GATE a_2638_6477# 0
C2302 a_17126_1626# a_18671_1703# 0
C2303 sg13cmos5l_o21ai_1_0.A1 a_11182_4676# 0.01729f
C2304 a_1227_6935# a_1484_6126# 0
C2305 sg13cmos5l_a22oi_1_0.Y a_10220_3102# 0
C2306 a_1402_3864# a_1760_3986# 0.00404f
C2307 sg13cmos5l_buf_8_2.X pl_sw[9] 0
C2308 sg13cmos5l_dlhr_1_9.D sg13cmos5l_buf_1_30.A 0.04286f
C2309 sg13cmos5l_dlhr_1_5.GATE a_5069_5376# 0.00591f
C2310 a_17674_3361# a_17700_3456# 0.43042f
C2311 a_996_7349# VPWR 0.00753f
C2312 a_3496_1758# nl_sw[2] 0.00133f
C2313 sg13cmos5l_dfrbp_1_10.Q a_5628_3174# 0
C2314 sg13cmos5l_or2_1_0.A a_620_2352# 0
C2315 sg13cmos5l_buf_1_57.X a_14426_7288# 0.04018f
C2316 sg13cmos5l_dfrbp_1_0.Q sg13cmos5l_nor2b_1_1.Y 0.43086f
C2317 a_1609_4704# a_1760_3986# 0
C2318 sg13cmos5l_dfrbp_1_6.D a_3996_2790# 0
C2319 sg13cmos5l_inv_1_2.A pl_sw[7] 0
C2320 sg13cmos5l_buf_8_0.A a_18363_4270# 0.0255f
C2321 sg13cmos5l_buf_8_1.A a_17595_3947# 0
C2322 a_5220_2392# a_6736_2630# 0.00159f
C2323 a_5637_2399# a_5739_2399# 0.6663f
C2324 sg13cmos5l_dfrbp_1_21.Q_N VPWR 0.28544f
C2325 sg13cmos5l_dfrbp_1_10.Q a_5220_2392# 0.00406f
C2326 sg13cmos5l_dlhr_1_21.Q_N sg13cmos5l_buf_1_95.X 0
C2327 sg13cmos5l_or2_1_0.A a_4244_3900# 0.00161f
C2328 sg13cmos5l_nor2_1_0.A a_12815_1703# 0
C2329 sg13cmos5l_inv_1_7.A a_12804_6175# 0
C2330 sg13cmos5l_buf_1_30.A a_7892_3900# 0.00929f
C2331 sg13cmos5l_buf_1_1.A a_15200_1758# 0.00197f
C2332 a_5069_5376# a_5684_4948# 0
C2333 sg13cmos5l_buf_1_5.A a_14295_7282# 0.05609f
C2334 sg13cmos5l_a22oi_1_1.A1 a_18219_3260# 0
C2335 a_9111_4666# sg13cmos5l_dfrbp_1_10.Q 0
C2336 sg13cmos5l_a22oi_1_1.Y a_16551_3987# 0.03168f
C2337 a_13076_5376# sg13cmos5l_and3_1_0.X 0
C2338 a_8204_9150# cks 0
C2339 a_5673_3138# a_5628_3174# 0
C2340 a_5492_3460# a_5425_3130# 0.0018f
C2341 sg13cmos5l_buf_1_5.A sg13cmos5l_nor2_1_0.A 0
C2342 sg13cmos5l_buf_1_57.X a_13641_7674# 0
C2343 sg13cmos5l_dfrbp_1_6.RESET_B a_1873_5773# 0.0015f
C2344 sg13cmos5l_inv_1_27.Y sg13cmos5l_dfrbp_1_23.Q_N 0
C2345 sg13cmos5l_dlhr_1_4.Q_N a_6697_3192# 0.078f
C2346 sg13cmos5l_dlhr_1_2.D a_6903_3154# 0.00217f
C2347 sg13cmos5l_dfrbp_1_6.D a_2859_3260# 0.0056f
C2348 sg13cmos5l_buf_1_8.A a_11556_1944# 0.00962f
C2349 sg13cmos5l_a221oi_1_0.B1 sg13cmos5l_dlhr_1_20.Q_N 0
C2350 a_10420_5412# a_10230_4632# 0
C2351 sg13cmos5l_buf_1_94.X pl_sw[9] 0.0041f
C2352 a_5673_3138# a_5220_2392# 0
C2353 a_5210_3148# a_5637_2399# 0.00211f
C2354 sg13cmos5l_inv_1_8.A pl_sw[3] 0.0167f
C2355 a_7537_4727# a_8050_4650# 0
C2356 a_9705_4650# a_9524_4972# 0.40925f
C2357 ph_sw[1] ph_sw[2] 0.00731f
C2358 a_20672_6294# cko 0
C2359 a_16425_6971# sg13cmos5l_buf_1_4.A 0
C2360 sg13cmos5l_or2_1_0.A cks 0.02828f
C2361 sg13cmos5l_buf_1_5.A a_12841_7728# 0.02071f
C2362 sg13cmos5l_buf_1_44.X a_3588_4968# 0.00871f
C2363 sg13cmos5l_dfrbp_1_8.RESET_B a_6315_3911# 0.00517f
C2364 a_16260_6480# a_17519_6239# 0.01741f
C2365 a_11556_1944# sg13cmos5l_buf_1_1.A 0
C2366 sg13cmos5l_buf_1_73.X cks 0
C2367 sg13cmos5l_a22oi_1_2.B2 sg13cmos5l_nand2_1_1.B 1.00238f
C2368 sg13cmos5l_or2_1_1.B a_10783_4292# 0
C2369 sg13cmos5l_o21ai_1_0.B1 a_13284_3456# 0.01907f
C2370 sg13cmos5l_dfrbp_1_1.Q a_15492_2392# 0.00406f
C2371 sg13cmos5l_dfrbp_1_6.D sg13cmos5l_inv_1_29.Y 0.00441f
C2372 sg13cmos5l_dfrbp_1_8.RESET_B sg13cmos5l_buf_1_4.A 0.46032f
C2373 sg13cmos5l_inv_1_7.A sg13cmos5l_a221oi_1_0.A2 0
C2374 sg13cmos5l_dfrbp_1_16.Q sg13cmos5l_dlhr_1_17.Q_N 0.00626f
C2375 sg13cmos5l_buf_1_18.X d_out[0] 0
C2376 a_5702_8874# a_6507_8447# 0.11742f
C2377 sg13cmos5l_buf_1_29.A sg13cmos5l_buf_1_26.X 0
C2378 sg13cmos5l_dfrbp_1_0.RESET_B a_15909_2399# 0.0542f
C2379 sg13cmos5l_inv_1_7.A a_14254_2444# 0.0088f
C2380 sg13cmos5l_buf_1_73.A a_7657_7282# 0
C2381 a_4847_4727# VPWR 0.25901f
C2382 sg13cmos5l_buf_1_5.A a_14440_1664# 0.32815f
C2383 sg13cmos5l_inv_1_7.A a_11567_7751# 0.01005f
C2384 a_12232_8436# sg13cmos5l_inv_1_29.A 0
C2385 sg13cmos5l_dfrbp_1_0.RESET_B a_12721_1703# 0
C2386 a_2340_3456# sg13cmos5l_buf_1_35.A 0
C2387 sg13cmos5l_dfrbp_1_6.D a_1472_4782# 0
C2388 sg13cmos5l_inv_1_14.A a_7644_1662# 0
C2389 a_16264_9224# a_16144_8678# 0
C2390 a_15876_4968# a_16164_4663# 0.4806f
C2391 sg13cmos5l_dfrbp_1_6.RESET_B sg13cmos5l_dfrbp_1_16.Q_N 0.27122f
C2392 sg13cmos5l_dfrbp_1_0.RESET_B a_13017_4023# 0.00343f
C2393 a_5132_3864# a_4873_3192# 0
C2394 sg13cmos5l_a22oi_1_2.B1 a_9823_2364# 0.07357f
C2395 sg13cmos5l_o21ai_1_0.A2 a_12022_3134# 0.09253f
C2396 sg13cmos5l_o21ai_1_0.Y sg13cmos5l_buf_1_6.A 0.05443f
C2397 sg13cmos5l_a22oi_1_1.B1 sg13cmos5l_dfrbp_1_0.Q 0
C2398 a_708_5416# sg13cmos5l_dlygate4sd2_1_0.A 0
C2399 sg13cmos5l_dfrbp_1_18.Q a_8580_8874# 0
C2400 sg13cmos5l_inv_1_6.A a_19240_7712# 0
C2401 a_2224_5654# a_2169_5535# 0.00464f
C2402 sg13cmos5l_inv_1_18.A VPWR 0.88232f
C2403 a_12549_9165# cks 0
C2404 sg13cmos5l_buf_1_10.A a_12075_3911# 0.02901f
C2405 sg13cmos5l_dfrbp_1_17.D sg13cmos5l_buf_1_58.A 0.025f
C2406 a_16751_2749# sg13cmos5l_buf_1_18.X 0
C2407 sg13cmos5l_buf_1_31.X a_4840_1664# 0
C2408 sg13cmos5l_inv_1_27.Y a_14854_8861# 0
C2409 sg13cmos5l_dfrbp_1_1.Q a_10618_3142# 0
C2410 a_14295_7282# sg13cmos5l_dfrbp_1_23.Q 0.00631f
C2411 a_14089_7282# a_14426_7288# 0.64635f
C2412 sg13cmos5l_a221oi_1_0.A2 sg13cmos5l_a221oi_1_0.B2 0
C2413 a_7247_8797# cks 0.01528f
C2414 sg13cmos5l_dfrbp_1_22.D a_18097_7666# 0
C2415 sg13cmos5l_a22oi_1_1.B1 a_12896_3270# 0
C2416 sg13cmos5l_dfrbp_1_6.RESET_B a_16177_7751# 0
C2417 sg13cmos5l_inv_1_20.Y sg13cmos5l_buf_1_61.X 0.03987f
C2418 sg13cmos5l_buf_1_60.X sg13cmos5l_inv_1_19.A 0.01379f
C2419 a_6568_9224# VPWR 0.24792f
C2420 sg13cmos5l_a221oi_1_0.A2 sg13cmos5l_dfrbp_1_11.Q_N 0.00497f
C2421 a_8378_5776# sg13cmos5l_dfrbp_1_12.Q_N 0
C2422 a_14377_5770# sg13cmos5l_nand2_1_1.A 0
C2423 a_2667_3911# a_2340_3456# 0
C2424 sg13cmos5l_or2_1_0.A a_7430_3576# 0
C2425 sg13cmos5l_inv_1_28.Y sg13cmos5l_dlhr_1_18.Q_N 0.0694f
C2426 sg13cmos5l_buf_1_18.X a_17412_1944# 0
C2427 sg13cmos5l_dfrbp_1_8.RESET_B sg13cmos5l_dfrbp_1_23.CLK 0.17065f
C2428 sg13cmos5l_dlhr_1_15.D pl_sw[8] 0.00187f
C2429 a_2565_3911# sg13cmos5l_buf_1_38.A 0
C2430 a_18363_4270# a_18376_2388# 0
C2431 sg13cmos5l_nor2_1_1.A a_18122_2388# 0
C2432 a_422_5850# a_1125_5423# 0.02431f
C2433 sg13cmos5l_buf_1_25.A sg13cmos5l_inv_1_11.Y 0
C2434 sg13cmos5l_buf_1_26.A a_10220_3102# 0
C2435 sg13cmos5l_dfrbp_1_2.D sg13cmos5l_dfrbp_1_4.D 0
C2436 a_1862_4338# ckc 0
C2437 a_3669_6320# VPWR 0.09569f
C2438 sg13cmos5l_dlygate4sd2_1_0.A a_1192_1664# 0
C2439 sg13cmos5l_dlhr_1_1.GATE a_2474_6162# 0
C2440 a_13641_7674# a_14089_7282# 0
C2441 a_18671_1703# a_18928_1846# 0.35645f
C2442 sg13cmos5l_buf_1_18.A a_18480_5028# 0
C2443 a_17412_1944# a_17700_1639# 0.4806f
C2444 a_9524_4972# sg13cmos5l_or2_1_0.A 0
C2445 a_1121_4166# a_1158_3142# 0.00159f
C2446 sg13cmos5l_dlhr_1_1.GATE a_2224_5654# 0.00124f
C2447 a_10202_7288# sg13cmos5l_a221oi_1_0.C1 0
C2448 a_14924_1590# nh_sw[7] 0
C2449 sg13cmos5l_inv_1_27.Y sg13cmos5l_inv_1_3.A 0.1265f
C2450 a_2148_3904# a_2565_3911# 0.49014f
C2451 a_18363_4270# sg13cmos5l_inv_1_5.A 0.00936f
C2452 sg13cmos5l_nand2_1_0.B a_10331_3900# 0.0021f
C2453 a_17161_8794# a_16271_7751# 0
C2454 sg13cmos5l_dfrbp_1_23.CLK a_15414_7354# 0
C2455 a_17414_3138# a_17508_3138# 0.00718f
C2456 a_18117_3117# a_18219_3260# 0.66105f
C2457 sg13cmos5l_dlhr_1_5.GATE a_5799_5499# 0.00303f
C2458 sg13cmos5l_buf_1_46.A a_10220_3102# 0
C2459 sg13cmos5l_or2_1_0.A a_5079_3154# 0
C2460 sg13cmos5l_dfrbp_1_6.D a_19130_6172# 0
C2461 a_5416_9224# a_5600_8522# 0.00278f
C2462 sg13cmos5l_dfrbp_1_8.D a_15177_5769# 0.00617f
C2463 a_2934_4632# a_2667_3911# 0
C2464 sg13cmos5l_inv_1_26.Y a_17882_7684# 0
C2465 a_5739_2399# a_6479_2749# 0.3087f
C2466 a_5194_2356# a_5577_2435# 0.00337f
C2467 a_5637_2399# a_6385_2749# 0.01058f
C2468 a_11394_4948# VPWR 0.19547f
C2469 sg13cmos5l_dfrbp_1_10.Q a_6736_2630# 0
C2470 a_12841_7728# a_13460_7996# 0.00161f
C2471 a_13178_7684# a_13641_7674# 0.13395f
C2472 sg13cmos5l_buf_1_34.X sg13cmos5l_dlhr_1_3.Q_N 0.00963f
C2473 a_1006_4167# a_1121_4166# 0.67711f
C2474 sg13cmos5l_buf_1_1.A a_17931_1748# 0
C2475 sg13cmos5l_buf_1_30.A a_8296_3986# 0.02654f
C2476 sg13cmos5l_buf_1_64.A a_4559_7630# 0
C2477 a_5799_5499# a_5684_4948# 0.00478f
C2478 sg13cmos5l_buf_1_4.A a_15850_4873# 0.0125f
C2479 a_15793_8797# pl_sw[9] 0
C2480 sg13cmos5l_buf_1_4.X sg13cmos5l_nor2_1_1.A 0.0226f
C2481 sg13cmos5l_buf_1_111.A ph_sw[9] 0.07387f
C2482 sg13cmos5l_a22oi_1_1.Y a_16462_4023# 0
C2483 sg13cmos5l_dfrbp_1_6.RESET_B a_5508_6162# 0
C2484 sg13cmos5l_dfrbp_1_6.D a_15876_7362# 0
C2485 sg13cmos5l_buf_1_98.A a_13775_6239# 0
C2486 a_6184_9224# pl_sw[3] 0.05366f
C2487 sg13cmos5l_buf_1_57.X a_14986_7897# 0
C2488 a_15887_8797# ph_sw[8] 0
C2489 sg13cmos5l_inv_1_1.A a_16177_7751# 0.01756f
C2490 a_6198_3120# sg13cmos5l_dlhr_1_2.Q 0
C2491 a_14800_3358# a_14900_2352# 0
C2492 a_14543_3215# sg13cmos5l_nor2b_1_1.Y 0.00893f
C2493 a_3688_1664# sg13cmos5l_buf_1_25.X 0
C2494 sg13cmos5l_buf_1_39.A a_4456_1664# 0.00903f
C2495 sg13cmos5l_buf_1_8.A a_13652_1924# 0.00539f
C2496 sg13cmos5l_dfrbp_1_6.D a_2628_3151# 0.00377f
C2497 sg13cmos5l_buf_1_33.A a_5704_1664# 0
C2498 sg13cmos5l_and3_1_0.X sg13cmos5l_inv_1_0.Y 0
C2499 sg13cmos5l_dfrbp_1_10.Q a_5673_3138# 0.0221f
C2500 a_2554_8112# VPWR 0.0045f
C2501 sg13cmos5l_inv_1_18.A a_8233_6216# 0
C2502 sg13cmos5l_or2_1_0.A a_2565_3911# 0.00788f
C2503 a_4076_7624# sg13cmos5l_dlhr_1_1.GATE 0
C2504 a_4324_7996# a_4518_7996# 0.01249f
C2505 sg13cmos5l_or2_1_0.A a_18219_3260# 0.0067f
C2506 sg13cmos5l_dlhr_1_2.D a_5220_2392# 0
C2507 sg13cmos5l_dlhr_1_4.Q_N a_5637_2399# 0
C2508 sg13cmos5l_inv_1_18.A sg13cmos5l_dfrbp_1_11.Q 0
C2509 a_15147_8447# ph_sw[6] 0
C2510 sg13cmos5l_buf_1_34.A a_4934_2826# 0
C2511 a_3860_2388# a_3792_2388# 0
C2512 sg13cmos5l_dlhr_1_15.Q a_18860_6888# 0.00355f
C2513 a_18164_7996# a_18568_7010# 0.00173f
C2514 sg13cmos5l_dfrbp_1_6.RESET_B a_4311_7710# 0
C2515 a_13652_1924# sg13cmos5l_buf_1_1.A 0
C2516 a_14924_1590# a_15357_1816# 0.00349f
C2517 a_16677_6141# a_17425_6239# 0.01058f
C2518 a_17519_6239# a_18356_6460# 0.1333f
C2519 a_16260_6480# sg13cmos5l_dfrbp_1_21.Q_N 0
C2520 sg13cmos5l_buf_1_40.X VPWR 0.30347f
C2521 sg13cmos5l_dlhr_1_1.Q a_3302_4650# 0.0024f
C2522 sg13cmos5l_inv_1_2.A a_14602_8404# 0.00239f
C2523 a_8204_9150# sg13cmos5l_buf_1_45.X 0.34002f
C2524 sg13cmos5l_buf_1_34.X a_3407_4261# 0.00295f
C2525 sg13cmos5l_dfrbp_1_1.Q a_16011_2399# 0.00703f
C2526 a_18480_5028# sg13cmos5l_buf_1_0.A 0.00243f
C2527 a_6372_4968# sg13cmos5l_dfrbp_1_10.Q 0
C2528 sg13cmos5l_dfrbp_1_15.D a_682_6892# 0
C2529 a_5988_8440# a_7153_8797# 0.4858f
C2530 sg13cmos5l_dfrbp_1_0.RESET_B a_17008_2630# 0.17964f
C2531 sg13cmos5l_buf_1_40.A a_682_6892# 0.00763f
C2532 a_5210_3148# a_5492_3460# 0.68988f
C2533 sg13cmos5l_buf_1_18.A nh_sw[10] 0
C2534 sg13cmos5l_dfrbp_1_14.Q_N VPWR 0.17778f
C2535 sg13cmos5l_buf_1_45.X sg13cmos5l_or2_1_0.A 0.37521f
C2536 sg13cmos5l_inv_1_7.A sg13cmos5l_dlhr_1_11.D 0.01193f
C2537 sg13cmos5l_dfrbp_1_6.RESET_B sg13cmos5l_a22oi_1_1.B1 0.00175f
C2538 sg13cmos5l_buf_1_68.X sg13cmos5l_buf_1_61.X 0.55267f
C2539 sg13cmos5l_dfrbp_1_1.Q a_16936_1758# 0
C2540 sg13cmos5l_inv_1_0.A a_11370_5760# 0.00306f
C2541 sg13cmos5l_buf_1_78.A sg13cmos5l_buf_1_73.A 0.02576f
C2542 sg13cmos5l_buf_1_73.X sg13cmos5l_buf_1_45.X 0
C2543 a_19209_5769# a_19227_4654# 0.02458f
C2544 sg13cmos5l_dfrbp_1_0.RESET_B a_17126_1626# 0.12744f
C2545 sg13cmos5l_a22oi_1_2.B2 a_9705_4650# 0.01002f
C2546 a_17135_4727# a_17041_4727# 0.32273f
C2547 a_12815_4261# sg13cmos5l_buf_1_7.A 0
C2548 sg13cmos5l_o21ai_1_0.Y a_12815_1703# 0
C2549 a_5312_6294# a_5069_5376# 0.00416f
C2550 sg13cmos5l_dfrbp_1_18.Q a_9291_8447# 0.02509f
C2551 sg13cmos5l_buf_8_1.A sg13cmos5l_dfrbp_1_0.CLK 0
C2552 sg13cmos5l_dlhr_1_1.D a_2169_5535# 0
C2553 sg13cmos5l_inv_1_27.Y cks 0.01911f
C2554 sg13cmos5l_buf_1_30.A a_6647_5459# 0.03231f
C2555 a_12520_4782# sg13cmos5l_o21ai_1_0.B1 0
C2556 sg13cmos5l_buf_8_0.A sg13cmos5l_dfrbp_1_0.RESET_B 0
C2557 a_18760_2388# sg13cmos5l_buf_1_18.X 0.13454f
C2558 a_11752_6294# sg13cmos5l_a221oi_1_0.B2 0
C2559 sg13cmos5l_inv_1_29.Y a_11873_5760# 0.01214f
C2560 sg13cmos5l_buf_1_5.A sg13cmos5l_o21ai_1_0.Y 0
C2561 sg13cmos5l_dlhr_1_9.Q a_3588_4968# 0
C2562 a_7336_9224# sg13cmos5l_dfrbp_1_6.D 0
C2563 a_11464_8436# a_10725_7653# 0.00144f
C2564 a_6346_4873# a_6891_4772# 0.00999f
C2565 a_6086_4650# a_6789_4629# 0.02453f
C2566 sg13cmos5l_a22oi_1_1.B1 a_14543_3215# 0.00986f
C2567 sg13cmos5l_buf_1_28.X a_10464_2427# 0.00261f
C2568 sg13cmos5l_dfrbp_1_6.RESET_B a_2596_7996# 0.04881f
C2569 a_3407_4261# a_3599_3215# 0.02016f
C2570 a_3664_4142# a_3856_3358# 0
C2571 sg13cmos5l_dfrbp_1_6.RESET_B a_5604_4338# 0
C2572 a_20012_2352# a_20012_1590# 0.00833f
C2573 sg13cmos5l_buf_1_10.A a_11973_3911# 0.03368f
C2574 sg13cmos5l_or2_1_0.A a_8204_2352# 0
C2575 sg13cmos5l_dfrbp_1_8.RESET_B a_6602_5692# 0.00758f
C2576 sg13cmos5l_dlhr_1_10.Q_N sg13cmos5l_dlhr_1_16.Q 0.00156f
C2577 sg13cmos5l_buf_1_45.X a_7247_8797# 0.00529f
C2578 a_8204_9150# a_8084_8436# 0.00275f
C2579 a_15702_5842# a_15590_4650# 0
C2580 a_15177_5769# a_15876_4968# 0
C2581 sg13cmos5l_buf_1_4.A sg13cmos5l_dfrbp_1_0.Q 0.02126f
C2582 a_5674_6385# VPWR 0.09446f
C2583 sg13cmos5l_buf_1_25.A a_6681_2511# 0
C2584 sg13cmos5l_dlhr_1_15.D a_11190_7354# 0
C2585 a_18671_1703# a_18577_1703# 0.32273f
C2586 sg13cmos5l_inv_1_18.A sg13cmos5l_buf_1_97.A 0.0033f
C2587 a_3308_5376# VPWR 0.35197f
C2588 a_20492_8400# sg13cmos5l_buf_1_104.X 0.3209f
C2589 a_2122_3868# a_2054_3138# 0
C2590 sg13cmos5l_dfrbp_1_16.Q a_2380_6162# 0
C2591 sg13cmos5l_buf_1_25.A a_8214_1608# 0
C2592 sg13cmos5l_dlhr_1_1.GATE sg13cmos5l_dlhr_1_1.D 0.81914f
C2593 sg13cmos5l_buf_1_0.A nh_sw[10] 0
C2594 a_17161_8794# sg13cmos5l_dlhr_1_15.D 0.00376f
C2595 sg13cmos5l_dfrbp_1_8.RESET_B sg13cmos5l_dlhr_1_5.D 0
C2596 sg13cmos5l_or2_1_0.A a_5606_3576# 0
C2597 sg13cmos5l_dlygate4sd3_1_0.X a_1290_3206# 0
C2598 sg13cmos5l_buf_1_18.A a_19142_5412# 0
C2599 sg13cmos5l_dlhr_1_15.D a_15062_4292# 0
C2600 sg13cmos5l_buf_1_2.A nh_sw[6] 0
C2601 sg13cmos5l_buf_1_30.A a_8392_3270# 0.01801f
C2602 sg13cmos5l_buf_1_95.X VPWR 0.32258f
C2603 sg13cmos5l_nand2_1_1.B a_10220_3102# 0.05397f
C2604 sg13cmos5l_dlhr_1_2.Q sg13cmos5l_dlhr_1_0.D 0
C2605 sg13cmos5l_dfrbp_1_8.D a_18746_5776# 0.0303f
C2606 sg13cmos5l_dfrbp_1_9.Q a_2667_3911# 0.02983f
C2607 a_13047_7690# a_13596_7710# 0
C2608 a_13641_7674# sg13cmos5l_dlhr_1_14.Q_N 0.00294f
C2609 a_7820_2352# a_8204_2352# 0.00492f
C2610 a_6479_2749# a_6385_2749# 0.32273f
C2611 a_6736_2630# a_6898_2826# 0.0019f
C2612 sg13cmos5l_nor2b_1_1.Y a_15206_2826# 0.29352f
C2613 a_5951_5383# sg13cmos5l_dlhr_1_0.GATE 0.00507f
C2614 sg13cmos5l_nor2b_1_0.Y a_12075_3911# 0.01561f
C2615 sg13cmos5l_o21ai_1_0.A1 a_11980_4948# 0
C2616 a_934_7349# VPWR 0
C2617 sg13cmos5l_inv_1_18.A sg13cmos5l_dlhr_1_17.Q_N 0.00218f
C2618 a_2732_9150# sg13cmos5l_buf_1_65.X 0.00764f
C2619 sg13cmos5l_inv_1_20.Y a_3308_9150# 0.0352f
C2620 a_11846_9186# a_11940_9186# 0.00718f
C2621 sg13cmos5l_a22oi_1_2.B2 sg13cmos5l_or2_1_0.A 0.03009f
C2622 a_12549_9165# a_12651_9308# 0.66105f
C2623 a_1402_3864# sg13cmos5l_dlygate4sd3_1_0.X 0
C2624 sg13cmos5l_dfrbp_1_6.RESET_B a_6865_6239# 0
C2625 sg13cmos5l_dfrbp_1_6.D a_16356_7349# 0.00163f
C2626 a_8852_6484# a_8841_5769# 0.00682f
C2627 a_9033_6162# a_9366_5842# 0.0072f
C2628 a_2409_4650# a_2148_3904# 0.01049f
C2629 a_2228_4972# a_2122_3868# 0
C2630 sg13cmos5l_dfrbp_1_6.RESET_B a_8982_7354# 0.021f
C2631 sg13cmos5l_buf_1_57.X a_15429_7653# 0
C2632 sg13cmos5l_or2_1_0.A a_2314_3361# 0.00374f
C2633 sg13cmos5l_dfrbp_1_6.RESET_B a_17041_4727# 0.00151f
C2634 sg13cmos5l_buf_1_33.A a_5600_1758# 0
C2635 sg13cmos5l_buf_1_39.A VPWR 0.32609f
C2636 a_4559_7630# VPWR 0.47858f
C2637 a_12420_9199# pl_sw[6] 0
C2638 a_5324_1590# nl_sw[2] 0
C2639 sg13cmos5l_dfrbp_1_10.Q sg13cmos5l_dlhr_1_2.D 0.00844f
C2640 sg13cmos5l_dlhr_1_2.D a_6736_2630# 0.17445f
C2641 sg13cmos5l_buf_1_73.A sg13cmos5l_dfrbp_1_18.Q 0
C2642 sg13cmos5l_dfrbp_1_6.D sg13cmos5l_buf_1_41.X 0.00261f
C2643 sg13cmos5l_dfrbp_1_10.Q a_4566_2818# 0
C2644 ph_sw[0] rdy 0
C2645 sg13cmos5l_dfrbp_1_6.RESET_B a_7812_7687# 0.00873f
C2646 sg13cmos5l_buf_1_79.X a_10725_7653# 0
C2647 sg13cmos5l_dlhr_1_5.GATE sg13cmos5l_dfrbp_1_16.Q 0.0866f
C2648 sg13cmos5l_dfrbp_1_6.RESET_B sg13cmos5l_dlhr_1_16.Q_N 0.01106f
C2649 sg13cmos5l_dlhr_1_5.Q_N a_8852_6484# 0
C2650 a_9448_6924# a_9033_6162# 0.0067f
C2651 sg13cmos5l_buf_1_44.X a_4753_4727# 0.01002f
C2652 sg13cmos5l_dfrbp_1_0.RESET_B nh_sw[7] 0.17f
C2653 a_16548_6175# a_16486_6175# 0
C2654 a_18356_6460# sg13cmos5l_dfrbp_1_21.Q_N 0.28195f
C2655 sg13cmos5l_dlhr_1_0.D nh_sw[5] 0.02311f
C2656 sg13cmos5l_dlhr_1_1.Q a_2644_4636# 0
C2657 sg13cmos5l_inv_1_2.A a_16144_8678# 0.01073f
C2658 sg13cmos5l_dfrbp_1_15.D a_4034_7660# 0
C2659 sg13cmos5l_a22oi_1_1.A1 a_16940_3102# 0
C2660 sg13cmos5l_buf_1_34.X sg13cmos5l_buf_1_38.A 0.21007f
C2661 a_8982_7354# a_10071_7282# 0
C2662 sg13cmos5l_dfrbp_1_1.Q sg13cmos5l_dfrbp_1_5.Q_N 0.00325f
C2663 a_7247_8797# a_8084_8436# 0.1333f
C2664 a_7504_8678# a_7153_8797# 0.01017f
C2665 sg13cmos5l_dfrbp_1_0.RESET_B a_18376_2388# 0
C2666 sg13cmos5l_inv_1_27.Y a_14612_6460# 0
C2667 sg13cmos5l_buf_1_19.A sg13cmos5l_dfrbp_1_6.D 0.05239f
C2668 sg13cmos5l_dfrbp_1_10.Q a_2757_3117# 0
C2669 sg13cmos5l_dfrbp_1_1.Q a_18671_1703# 0.00823f
C2670 sg13cmos5l_dlhr_1_15.D sg13cmos5l_dfrbp_1_21.Q 1.66798f
C2671 sg13cmos5l_buf_1_57.X a_9448_6924# 0.28903f
C2672 sg13cmos5l_dfrbp_1_16.Q a_5684_4948# 0
C2673 sg13cmos5l_dfrbp_1_12.Q_N a_9111_4666# 0.01153f
C2674 a_2409_4650# sg13cmos5l_or2_1_0.A 0
C2675 a_3578_2752# a_3793_2790# 0.00284f
C2676 a_3447_2746# a_4041_2745# 0.09085f
C2677 a_3241_2746# a_3860_2388# 0.00161f
C2678 sg13cmos5l_dfrbp_1_0.RESET_B a_18928_1846# 0.18223f
C2679 sg13cmos5l_buf_1_65.X a_2565_8447# 0.00393f
C2680 sg13cmos5l_nand2_1_1.A sg13cmos5l_buf_1_7.A 0
C2681 sg13cmos5l_dfrbp_1_0.RESET_B sg13cmos5l_inv_1_5.A 0
C2682 sg13cmos5l_dfrbp_1_18.Q sg13cmos5l_dfrbp_1_27.Q_N 0
C2683 sg13cmos5l_dfrbp_1_8.RESET_B a_15592_6200# 0
C2684 a_6372_4968# sg13cmos5l_dlhr_1_2.D 0
C2685 sg13cmos5l_o21ai_1_0.B1 a_12520_3176# 0.00832f
C2686 sg13cmos5l_buf_1_44.X sg13cmos5l_buf_1_31.X 0
C2687 sg13cmos5l_dfrbp_1_21.Q_N ph_sw[9] 0.00247f
C2688 sg13cmos5l_dfrbp_1_16.Q a_8593_5814# 0
C2689 a_16953_2511# nh_sw[8] 0.00176f
C2690 sg13cmos5l_nor2_1_0.A a_11182_4948# 0.01362f
C2691 sg13cmos5l_dlhr_1_11.GATE a_13161_7281# 0.00125f
C2692 sg13cmos5l_dfrbp_1_6.D sg13cmos5l_nor2_1_2.A 0.00462f
C2693 a_14900_2352# VPWR 0.27844f
C2694 sg13cmos5l_buf_1_10.A a_12998_3138# 0.00218f
C2695 sg13cmos5l_dfrbp_1_0.CLK a_11877_2399# 0.39043f
C2696 a_12232_8436# a_11567_7751# 0.0051f
C2697 a_11848_8436# a_11824_7894# 0
C2698 sg13cmos5l_buf_1_96.A a_10725_7653# 0.0328f
C2699 a_2340_3456# a_3447_2746# 0
C2700 sg13cmos5l_dfrbp_1_1.Q a_14924_1590# 0.00165f
C2701 a_6789_4629# a_7631_4727# 0.00437f
C2702 a_6372_4968# a_7888_4870# 0.00294f
C2703 sg13cmos5l_dfrbp_1_1.Q_N nh_sw[6] 0.01065f
C2704 a_9291_8447# cks 0.01927f
C2705 sg13cmos5l_dfrbp_1_0.RESET_B a_15357_1816# 0.00629f
C2706 a_15414_7354# a_15592_6200# 0
C2707 sg13cmos5l_buf_1_38.A a_3599_3215# 0.01649f
C2708 sg13cmos5l_a22oi_1_1.B1 a_15702_4187# 0
C2709 a_3407_4261# sg13cmos5l_dfrbp_1_10.Q_N 0.00141f
C2710 sg13cmos5l_dfrbp_1_6.RESET_B a_6315_3911# 0.55135f
C2711 a_2748_6126# sg13cmos5l_dlhr_1_1.Q 0
C2712 sg13cmos5l_buf_1_18.X sg13cmos5l_dfrbp_1_0.Q_N 0
C2713 a_11072_5347# sg13cmos5l_a22oi_1_2.B2 0
C2714 sg13cmos5l_dfrbp_1_6.RESET_B sg13cmos5l_buf_1_4.A 0.14195f
C2715 sg13cmos5l_inv_1_14.A sg13cmos5l_dfrbp_1_16.Q 0.01596f
C2716 sg13cmos5l_buf_1_34.X sg13cmos5l_or2_1_0.A 0.01736f
C2717 sg13cmos5l_dlhr_1_15.D sg13cmos5l_or2_1_1.B 2.31524f
C2718 sg13cmos5l_dfrbp_1_8.RESET_B a_8041_5770# 0.00101f
C2719 sg13cmos5l_buf_1_45.X sg13cmos5l_dfrbp_1_2.D 0
C2720 sg13cmos5l_buf_1_34.X sg13cmos5l_buf_1_73.X 0
C2721 sg13cmos5l_buf_1_45.X a_8580_8874# 0
C2722 a_1672_3176# a_2314_3361# 0.00308f
C2723 a_11556_3904# sg13cmos5l_buf_1_8.X 0
C2724 a_14726_7674# sg13cmos5l_dfrbp_1_23.Q 0
C2725 sg13cmos5l_dfrbp_1_9.Q nh_sw[1] 0
C2726 sg13cmos5l_buf_1_43.A VPWR 0.49112f
C2727 a_20296_1664# a_20672_1758# 0.03376f
C2728 a_16068_6928# cks 0.01472f
C2729 sg13cmos5l_dlhr_1_5.GATE a_4005_4629# 0
C2730 sg13cmos5l_dlhr_1_0.D a_9823_2780# 0
C2731 sg13cmos5l_dfrbp_1_16.Q a_4652_6126# 0
C2732 a_16940_3102# nh_sw[8] 0.28895f
C2733 sg13cmos5l_buf_1_6.A nh_sw[6] 0.013f
C2734 a_11530_1849# nh_sw[6] 0
C2735 sg13cmos5l_inv_1_28.Y a_12841_7728# 0
C2736 sg13cmos5l_dfrbp_1_15.Q_N a_2380_6162# 0.15881f
C2737 a_1997_6126# a_2748_6126# 0.01741f
C2738 a_422_5850# a_708_5416# 0.50066f
C2739 sg13cmos5l_buf_1_31.X nl_sw[0] 0.39908f
C2740 sg13cmos5l_dfrbp_1_22.D a_15782_7362# 0.30226f
C2741 sg13cmos5l_dlygate4sd2_1_0.A a_908_1590# 0
C2742 sg13cmos5l_a22oi_1_0.B1 a_10618_3142# 0.01489f
C2743 sg13cmos5l_dfrbp_1_8.D a_19164_5814# 0
C2744 a_11846_9186# sg13cmos5l_inv_1_7.A 0
C2745 sg13cmos5l_dfrbp_1_9.Q sg13cmos5l_dfrbp_1_9.Q_N 0.0109f
C2746 sg13cmos5l_buf_1_24.A sg13cmos5l_buf_1_26.X 0
C2747 sg13cmos5l_dfrbp_1_8.RESET_B a_14436_8874# 0
C2748 a_14166_7656# a_14536_7806# 0.03916f
C2749 a_1121_4166# a_902_3142# 0.00884f
C2750 a_8588_2352# sg13cmos5l_dlhr_1_0.D 0
C2751 a_3664_8678# cks 0.01038f
C2752 a_4107_4772# a_5104_4870# 0.06778f
C2753 a_3302_4650# a_3876_4663# 0.36169f
C2754 sg13cmos5l_nor2b_1_1.Y a_14858_2388# 0
C2755 sg13cmos5l_dlhr_1_9.Q a_3575_6553# 0.03474f
C2756 sg13cmos5l_buf_1_44.X a_4349_7636# 0.00242f
C2757 sg13cmos5l_nor2b_1_0.Y a_11913_3947# 0
C2758 a_6598_4663# sg13cmos5l_or2_1_0.A 0
C2759 sg13cmos5l_a22oi_1_0.Y a_11782_4325# 0
C2760 sg13cmos5l_buf_1_25.A a_5324_1590# 0
C2761 a_12651_9308# sg13cmos5l_inv_1_27.Y 0
C2762 a_7644_1662# nl_sw[4] 0
C2763 sg13cmos5l_a22oi_1_0.Y sg13cmos5l_inv_1_11.Y 0.00244f
C2764 sg13cmos5l_dfrbp_1_6.D a_16425_6971# 0
C2765 sg13cmos5l_buf_1_4.X a_17700_3456# 0
C2766 sg13cmos5l_dlygate4sd2_1_0.A ckc 0
C2767 sg13cmos5l_or2_1_0.A a_3599_3215# 0.00137f
C2768 a_9705_4650# a_10220_3102# 0
C2769 sg13cmos5l_dfrbp_1_8.RESET_B a_3625_7282# 0.00344f
C2770 sg13cmos5l_nand2_1_0.A sg13cmos5l_dfrbp_1_0.RESET_B 0.04678f
C2771 a_18856_8436# cks 0.01195f
C2772 sg13cmos5l_nor2b_1_1.Y a_15200_1758# 0.00138f
C2773 sg13cmos5l_buf_1_30.A a_7034_3148# 0
C2774 sg13cmos5l_buf_1_18.A a_18615_5770# 0
C2775 sg13cmos5l_buf_1_31.X sg13cmos5l_nor2_1_0.A 0.00236f
C2776 sg13cmos5l_dfrbp_1_8.RESET_B sg13cmos5l_dfrbp_1_6.D 0.45088f
C2777 a_18272_9318# ph_sw[8] 0
C2778 sg13cmos5l_dfrbp_1_6.RESET_B sg13cmos5l_dfrbp_1_23.CLK 0.85829f
C2779 sg13cmos5l_buf_1_34.X a_5424_3460# 0
C2780 sg13cmos5l_dlhr_1_2.D a_6898_2826# 0
C2781 sg13cmos5l_nor2b_1_0.Y a_11973_3911# 0.01935f
C2782 sg13cmos5l_inv_1_1.A sg13cmos5l_buf_1_4.A 0.01237f
C2783 a_3574_7850# sg13cmos5l_dfrbp_1_16.Q 0
C2784 sg13cmos5l_dfrbp_1_16.Q_N a_2224_7166# 0.1649f
C2785 sg13cmos5l_buf_1_79.X a_12404_7972# 0
C2786 VPWR nl_sw[10] 0.2173f
C2787 sg13cmos5l_buf_1_97.A sg13cmos5l_buf_1_95.X 0
C2788 sg13cmos5l_dfrbp_1_15.D a_4244_6924# 0.03538f
C2789 nl_sw[2] nh_sw[2] 0.2919f
C2790 sg13cmos5l_dlhr_1_5.Q sg13cmos5l_dlhr_1_6.Q_N 0.00429f
C2791 a_11190_7354# sg13cmos5l_dlhr_1_6.D 0
C2792 a_1463_8741# sg13cmos5l_buf_1_61.X 0
C2793 sg13cmos5l_inv_1_2.A sg13cmos5l_dfrbp_1_22.D 0.66203f
C2794 sg13cmos5l_dlhr_1_5.Q a_10484_6924# 0
C2795 a_19227_9190# ph_sw[8] 0.00189f
C2796 sg13cmos5l_dfrbp_1_12.Q_N sg13cmos5l_dfrbp_1_10.Q 0
C2797 sg13cmos5l_dfrbp_1_6.D a_15414_7354# 0.00602f
C2798 sg13cmos5l_buf_1_73.A cks 0.1602f
C2799 sg13cmos5l_buf_1_110.A a_16271_7751# 0
C2800 sg13cmos5l_dfrbp_1_20.Q sg13cmos5l_dlhr_1_6.Q_N 0
C2801 a_2348_7624# VPWR 0.11984f
C2802 sg13cmos5l_a221oi_1_0.B1 sg13cmos5l_buf_1_46.A 0
C2803 a_16160_9318# a_15887_8797# 0
C2804 a_1609_4704# a_2228_4972# 0.00161f
C2805 a_1946_4660# a_2409_4650# 0.13395f
C2806 sg13cmos5l_dfrbp_1_10.Q a_3801_3453# 0
C2807 sg13cmos5l_dlhr_1_8.Q_N sg13cmos5l_dlhr_1_1.GATE 0
C2808 sg13cmos5l_or2_1_0.A a_16940_3102# 0.00422f
C2809 a_5510_4338# VPWR 0.93552f
C2810 sg13cmos5l_dfrbp_1_20.Q a_10484_6924# 0.04197f
C2811 a_4041_2745# a_3996_2790# 0
C2812 sg13cmos5l_dfrbp_1_0.RESET_B a_18577_1703# 0
C2813 sg13cmos5l_buf_1_41.A a_2667_3911# 0.01842f
C2814 a_4652_6126# a_4005_4629# 0
C2815 ph_sw[2] sg13cmos5l_buf_1_61.X 0
C2816 sg13cmos5l_buf_1_65.X a_3313_8797# 0
C2817 a_16748_9150# ph_sw[8] 0.00504f
C2818 sg13cmos5l_dfrbp_1_6.RESET_B a_15132_5814# 0.00203f
C2819 sg13cmos5l_a22oi_1_2.B2 sg13cmos5l_dfrbp_1_2.D 0.07039f
C2820 sg13cmos5l_buf_1_7.A a_13701_3117# 0.05205f
C2821 sg13cmos5l_buf_1_10.A a_9865_7282# 0
C2822 sg13cmos5l_o21ai_1_0.B1 a_12075_1748# 0
C2823 a_424_1664# a_908_1590# 0.03472f
C2824 sg13cmos5l_dfrbp_1_16.Q sg13cmos5l_buf_1_45.A 0.01032f
C2825 sg13cmos5l_buf_1_68.X a_616_9224# 0.32466f
C2826 sg13cmos5l_buf_1_95.X a_13047_7690# 0
C2827 sg13cmos5l_dfrbp_1_0.CLK a_12976_2630# 0.00351f
C2828 a_3599_3215# a_3578_2752# 0
C2829 a_12232_8436# sg13cmos5l_dlhr_1_11.D 0
C2830 a_11072_5347# a_11268_5760# 0.00343f
C2831 a_18615_5770# sg13cmos5l_buf_1_0.A 0
C2832 sg13cmos5l_dfrbp_1_27.Q_N cks 0.00343f
C2833 sg13cmos5l_inv_1_1.A sg13cmos5l_dfrbp_1_23.CLK 0
C2834 a_6891_4772# a_7537_4727# 0.00667f
C2835 a_6372_4968# sg13cmos5l_dfrbp_1_12.Q_N 0.00341f
C2836 a_7631_4727# a_8468_4948# 0.1333f
C2837 sg13cmos5l_o21ai_1_0.A1 sg13cmos5l_buf_1_8.A 0
C2838 sg13cmos5l_inv_1_8.A sg13cmos5l_buf_1_62.X 0.0062f
C2839 sg13cmos5l_buf_1_2.A sg13cmos5l_buf_8_1.A 0
C2840 a_3664_8678# a_3609_8559# 0.00464f
C2841 sg13cmos5l_buf_1_38.A sg13cmos5l_dfrbp_1_10.Q_N 0.18142f
C2842 sg13cmos5l_dfrbp_1_6.RESET_B a_8588_3864# 0.04135f
C2843 sg13cmos5l_dfrbp_1_8.RESET_B a_2374_4325# 0
C2844 sg13cmos5l_buf_1_30.X a_9823_2364# 0
C2845 a_2638_6162# sg13cmos5l_dlhr_1_1.Q 0
C2846 a_708_5416# sg13cmos5l_nand2_1_2.B 0
C2847 sg13cmos5l_dlhr_1_11.GATE a_13641_7674# 0
C2848 sg13cmos5l_inv_1_6.A sg13cmos5l_dlhr_1_15.Q 0
C2849 a_1967_5773# sg13cmos5l_dlhr_1_1.Q 0.00433f
C2850 sg13cmos5l_buf_1_77.A VPWR 0.51401f
C2851 VPWR pl_sw[4] 0.3311f
C2852 sg13cmos5l_or2_1_0.A a_10220_3102# 0.00334f
C2853 sg13cmos5l_buf_1_40.A a_620_2352# 0
C2854 a_18409_5770# sg13cmos5l_dfrbp_1_0.D 0.00207f
C2855 sg13cmos5l_and3_1_0.C sg13cmos5l_o21ai_1_0.B1 0.01192f
C2856 a_2340_3456# a_2859_3260# 0.38902f
C2857 a_2054_3138# a_2697_3529# 0.00806f
C2858 a_17584_7166# cks 0
C2859 a_8457_7281# VPWR 0.62261f
C2860 sg13cmos5l_dlhr_1_5.GATE a_4847_4727# 0
C2861 sg13cmos5l_inv_1_8.A sg13cmos5l_buf_1_44.X 0.04821f
C2862 sg13cmos5l_dlhr_1_6.D sg13cmos5l_dfrbp_1_21.Q 0.13349f
C2863 a_12815_1703# nh_sw[6] 0.01502f
C2864 sg13cmos5l_dlhr_1_1.GATE sg13cmos5l_inv_1_19.A 1.21233f
C2865 sg13cmos5l_buf_1_4.A a_15206_2826# 0
C2866 sg13cmos5l_dfrbp_1_9.Q a_5492_3460# 0
C2867 a_2727_6380# a_3575_6553# 0.11742f
C2868 sg13cmos5l_buf_1_24.A a_5414_6162# 0.0015f
C2869 a_1997_6126# a_2638_6162# 0.32273f
C2870 sg13cmos5l_buf_1_74.X VPWR 0.2916f
C2871 sg13cmos5l_dfrbp_1_21.Q sg13cmos5l_dfrbp_1_8.Q_N 0.00129f
C2872 a_20008_3900# a_20200_3270# 0.00183f
C2873 sg13cmos5l_dfrbp_1_9.Q a_3447_2746# 0.25249f
C2874 sg13cmos5l_nor2_1_0.A sg13cmos5l_a221oi_1_0.C1 0.53581f
C2875 a_1997_6126# a_1967_5773# 0.0078f
C2876 a_8985_7989# VPWR 0
C2877 sg13cmos5l_inv_1_1.A a_15132_5814# 0
C2878 sg13cmos5l_dfrbp_1_8.RESET_B a_15147_8447# 0.56735f
C2879 sg13cmos5l_inv_1_3.A a_13768_8436# 0.29913f
C2880 sg13cmos5l_buf_1_26.A sg13cmos5l_inv_1_11.Y 0
C2881 sg13cmos5l_nand2_1_0.B a_12520_3176# 0
C2882 a_14986_7897# a_15012_7992# 0.43042f
C2883 sg13cmos5l_nand2_1_1.B a_12815_4261# 0
C2884 sg13cmos5l_buf_1_4.A a_16552_1664# 0.32699f
C2885 sg13cmos5l_buf_1_5.A nh_sw[6] 0.00752f
C2886 sg13cmos5l_inv_1_18.A sg13cmos5l_dlhr_1_5.GATE 0
C2887 sg13cmos5l_dfrbp_1_15.D cks 0.68568f
C2888 a_11844_1639# nl_sw[6] 0.01841f
C2889 sg13cmos5l_buf_1_4.A a_15702_4187# 0.00344f
C2890 a_4847_4727# a_5684_4948# 0.1333f
C2891 sg13cmos5l_dfrbp_1_0.RESET_B sg13cmos5l_dfrbp_1_1.Q 0.52761f
C2892 sg13cmos5l_a22oi_1_1.B2 sg13cmos5l_dfrbp_1_0.CLK 0.00161f
C2893 sg13cmos5l_buf_1_40.A cks 0.16241f
C2894 sg13cmos5l_dlhr_1_2.Q_N a_7689_1626# 0
C2895 a_10202_7288# sg13cmos5l_a221oi_1_1.C1 0
C2896 sg13cmos5l_nor2b_1_0.Y a_12998_3138# 0
C2897 a_424_8436# pl_sw[0] 0.04269f
C2898 sg13cmos5l_dfrbp_1_11.Q a_5510_4338# 0
C2899 a_1948_7964# sg13cmos5l_buf_1_62.X 0
C2900 a_2934_4632# a_2859_3260# 0
C2901 sg13cmos5l_or2_1_0.A sg13cmos5l_dfrbp_1_10.Q_N 0.00164f
C2902 sg13cmos5l_buf_1_46.A sg13cmos5l_inv_1_11.Y 0
C2903 a_1125_6935# a_1878_6337# 0.00528f
C2904 sg13cmos5l_buf_1_18.A a_19209_5769# 0.08296f
C2905 sg13cmos5l_buf_1_76.X a_5600_8522# 0
C2906 sg13cmos5l_dlygate4sd2_1_0.A a_2757_3117# 0
C2907 sg13cmos5l_inv_1_3.A sg13cmos5l_dfrbp_1_8.D 0
C2908 a_13034_5412# VPWR 0.00704f
C2909 sg13cmos5l_dlhr_1_6.D sg13cmos5l_or2_1_1.B 0.32551f
C2910 sg13cmos5l_inv_1_0.A a_13652_3900# 0.13635f
C2911 pl_sw[7] pl_sw[8] 0.09373f
C2912 sg13cmos5l_buf_1_34.X sg13cmos5l_buf_1_34.A 0.15755f
C2913 sg13cmos5l_dfrbp_1_21.Q a_13698_5412# 0.00183f
C2914 a_12520_3176# nl_sw[6] 0
C2915 sg13cmos5l_nor2_1_2.A a_1121_4166# 0.05035f
C2916 a_5704_1664# nh_sw[3] 0.28895f
C2917 sg13cmos5l_dlhr_1_1.GATE sg13cmos5l_dlhr_1_9.D 0.92972f
C2918 sg13cmos5l_inv_1_29.A a_10665_7281# 0
C2919 a_12567_7282# sg13cmos5l_dlhr_1_6.D 0
C2920 a_10427_2736# nl_sw[5] 0
C2921 sg13cmos5l_nor2_1_0.A sg13cmos5l_o21ai_1_0.B1 0.11411f
C2922 a_3016_9318# a_2596_7996# 0
C2923 sg13cmos5l_dlhr_1_5.GATE a_3669_6320# 0
C2924 sg13cmos5l_nand2_1_1.A a_20392_3176# 0
C2925 sg13cmos5l_buf_1_41.A nh_sw[1] 0.07064f
C2926 sg13cmos5l_dfrbp_1_6.D a_18096_7996# 0
C2927 a_18860_6888# sg13cmos5l_dfrbp_1_21.Q_N 0.00879f
C2928 a_10010_9196# a_10308_7992# 0
C2929 a_10473_9186# a_10022_7674# 0
C2930 a_8486_8874# a_8772_8440# 0.50066f
C2931 sg13cmos5l_a22oi_1_1.A1 a_20008_3900# 0.01712f
C2932 sg13cmos5l_buf_1_78.A pl_sw[3] 1.36714f
C2933 sg13cmos5l_inv_1_0.A a_11270_4338# 0.01056f
C2934 sg13cmos5l_dfrbp_1_6.RESET_B sg13cmos5l_dlhr_1_5.D 0.08622f
C2935 a_5988_8440# sg13cmos5l_buf_1_30.A 0
C2936 sg13cmos5l_buf_1_110.A sg13cmos5l_dlhr_1_15.D 0.00577f
C2937 sg13cmos5l_buf_1_39.A sg13cmos5l_buf_1_25.X 0.97492f
C2938 a_2409_4650# a_2342_5088# 0
C2939 a_2228_4972# a_2160_4972# 0
C2940 sg13cmos5l_buf_1_58.A VPWR 0.47057f
C2941 sg13cmos5l_dlhr_1_15.D sg13cmos5l_dfrbp_1_16.Q 0
C2942 sg13cmos5l_dfrbp_1_20.Q a_10598_6924# 0.00157f
C2943 sg13cmos5l_dfrbp_1_16.Q_N sg13cmos5l_dlhr_1_9.Q_N 0.00254f
C2944 a_4349_7636# sg13cmos5l_dlhr_1_9.Q 0.00622f
C2945 sg13cmos5l_buf_1_77.A a_8233_6216# 0.00168f
C2946 a_6084_4325# VPWR 0.0087f
C2947 sg13cmos5l_buf_8_1.A sg13cmos5l_dfrbp_1_6.Q_N 0
C2948 a_15016_6294# VPWR 0.13455f
C2949 a_2348_7624# a_1967_7285# 0.00689f
C2950 a_1846_7850# a_1873_7285# 0
C2951 sg13cmos5l_buf_1_77.A sg13cmos5l_dfrbp_1_11.Q 0
C2952 sg13cmos5l_dlygate4sd2_1_0.A a_1210_4654# 0.01834f
C2953 a_1948_7964# a_2583_7710# 0
C2954 sg13cmos5l_dfrbp_1_6.RESET_B a_15110_5412# 0
C2955 a_8457_7281# a_8233_6216# 0
C2956 a_8276_6924# a_8570_6172# 0
C2957 sg13cmos5l_inv_1_14.A sg13cmos5l_inv_1_18.A 0.02638f
C2958 sg13cmos5l_buf_1_73.A sg13cmos5l_buf_1_45.X 0.32008f
C2959 sg13cmos5l_nand2_1_1.B nl_sw[8] 0
C2960 a_13701_3117# a_13556_2388# 0.01002f
C2961 sg13cmos5l_o21ai_1_0.B1 a_14440_1664# 0
C2962 a_18480_5028# sg13cmos5l_buf_8_0.A 0.16549f
C2963 sg13cmos5l_or2_1_1.B a_13698_5412# 0.01272f
C2964 sg13cmos5l_dfrbp_1_8.RESET_B a_5702_8874# 0.09709f
C2965 a_8783_7751# a_8852_6484# 0.00153f
C2966 sg13cmos5l_dfrbp_1_6.RESET_B a_7249_3130# 0
C2967 a_9040_7894# a_9033_6162# 0
C2968 sg13cmos5l_inv_1_2.A a_16264_9224# 0
C2969 a_15784_9224# pl_sw[7] 0
C2970 sg13cmos5l_dfrbp_1_10.Q_N a_3578_2752# 0
C2971 sg13cmos5l_dfrbp_1_0.CLK a_14254_2444# 0
C2972 a_3599_3215# sg13cmos5l_buf_1_34.A 0
C2973 sg13cmos5l_dlhr_1_15.D a_17519_6239# 0.00561f
C2974 a_6568_9224# sg13cmos5l_inv_1_14.A 0.00352f
C2975 a_13768_8436# cks 0.00873f
C2976 a_8468_4948# sg13cmos5l_dfrbp_1_11.Q_N 0.25039f
C2977 a_6660_4663# a_6598_4663# 0
C2978 a_7888_4870# sg13cmos5l_dfrbp_1_12.Q_N 0.00355f
C2979 sg13cmos5l_dfrbp_1_15.D a_3609_8559# 0
C2980 a_2248_9224# a_1862_8874# 0
C2981 sg13cmos5l_inv_1_17.A a_3588_4968# 0.02689f
C2982 a_12815_4261# sg13cmos5l_a22oi_1_1.A1 0
C2983 sg13cmos5l_dfrbp_1_8.RESET_B a_3826_4338# 0
C2984 sg13cmos5l_dfrbp_1_20.Q_N a_9291_8447# 0.05882f
C2985 a_4460_9150# cks 0
C2986 a_20008_7712# frame 0.28818f
C2987 a_9620_7972# a_10282_7897# 0.00293f
C2988 sg13cmos5l_inv_1_2.A a_13391_9263# 0.01737f
C2989 a_1125_5423# sg13cmos5l_inv_1_8.Y 0
C2990 a_5132_9150# sg13cmos5l_buf_1_74.X 0
C2991 a_2340_3456# a_2628_3151# 0.4806f
C2992 a_18870_7656# cko 0
C2993 a_1672_3176# sg13cmos5l_dfrbp_1_10.Q_N 0
C2994 sg13cmos5l_inv_1_29.Y sg13cmos5l_a221oi_1_0.B2 0.12143f
C2995 sg13cmos5l_buf_1_77.X sg13cmos5l_dfrbp_1_6.D 0
C2996 sg13cmos5l_dfrbp_1_8.D cks 0.02724f
C2997 sg13cmos5l_dfrbp_1_16.Q a_6959_6239# 0.00289f
C2998 sg13cmos5l_dfrbp_1_8.RESET_B a_1121_4166# 0
C2999 a_15784_1664# nh_sw[6] 0
C3000 a_3308_9150# ph_sw[2] 0
C3001 sg13cmos5l_dfrbp_1_24.Q_N VPWR 0.17778f
C3002 sg13cmos5l_buf_1_24.A a_7216_6382# 0
C3003 a_3575_6553# a_3530_6320# 0.36169f
C3004 a_3669_6320# a_4652_6126# 0.00346f
C3005 sg13cmos5l_dfrbp_1_16.Q a_4358_6924# 0
C3006 sg13cmos5l_dfrbp_1_9.Q a_3996_2790# 0
C3007 sg13cmos5l_dfrbp_1_22.D a_17746_7362# 0
C3008 sg13cmos5l_dfrbp_1_6.D a_17135_4727# 0.0029f
C3009 a_2727_6380# a_2804_5412# 0
C3010 sg13cmos5l_buf_1_18.A sg13cmos5l_nor2_1_1.A 0
C3011 sg13cmos5l_dfrbp_1_6.RESET_B a_15592_6200# 0.01004f
C3012 a_524_4614# VPWR 0.31533f
C3013 sg13cmos5l_inv_1_1.A a_15110_5412# 0
C3014 sg13cmos5l_buf_1_57.X a_14377_5770# 0
C3015 a_11268_2826# VPWR 0
C3016 sg13cmos5l_dfrbp_1_8.RESET_B ph_sw[3] 0.00229f
C3017 a_14726_7674# a_15531_7796# 0.11742f
C3018 a_15012_7992# a_15429_7653# 0.48921f
C3019 sg13cmos5l_nand2_1_1.B sg13cmos5l_nand2_1_1.A 0.79564f
C3020 sg13cmos5l_buf_1_4.A a_16462_4338# 0.01494f
C3021 sg13cmos5l_buf_1_73.A a_8084_8436# 0.01962f
C3022 a_5684_4948# sg13cmos5l_dfrbp_1_14.Q_N 0.25039f
C3023 a_3876_4663# a_3814_4663# 0
C3024 sg13cmos5l_buf_1_25.A sg13cmos5l_buf_1_28.A 0.00424f
C3025 sg13cmos5l_buf_1_28.X sg13cmos5l_dlhr_1_0.D 0.01798f
C3026 a_422_5850# a_682_5380# 0.87117f
C3027 a_1862_8874# a_2148_8440# 0.50066f
C3028 sg13cmos5l_buf_1_10.A VPWR 1.07781f
C3029 sg13cmos5l_buf_1_3.A a_20008_7712# 0.0168f
C3030 sg13cmos5l_dlhr_1_1.GATE sg13cmos5l_dlhr_1_7.Q_N 0
C3031 sg13cmos5l_buf_1_26.A a_8214_1608# 0
C3032 a_9291_8447# a_10233_8559# 0
C3033 sg13cmos5l_dfrbp_1_9.Q a_2859_3260# 0.03043f
C3034 sg13cmos5l_dfrbp_1_11.Q a_6084_4325# 0
C3035 a_12616_5498# a_12075_3911# 0
C3036 sg13cmos5l_dfrbp_1_22.D a_14889_7281# 0.00165f
C3037 a_2596_7996# pl_sw[2] 0
C3038 a_18856_8436# pl_sw[9] 0.00921f
C3039 sg13cmos5l_dlhr_1_15.D sg13cmos5l_a22oi_1_1.Y 0.00254f
C3040 sg13cmos5l_nand2_1_1.B sg13cmos5l_inv_1_11.Y 0.12132f
C3041 sg13cmos5l_dfrbp_1_2.D a_10220_3102# 0
C3042 a_15702_5842# VPWR 0.25092f
C3043 sg13cmos5l_inv_1_29.A a_12216_5728# 0
C3044 sg13cmos5l_dfrbp_1_18.Q a_9879_9202# 0.25246f
C3045 sg13cmos5l_inv_1_8.A sg13cmos5l_dlhr_1_9.Q 0
C3046 a_11846_9186# a_12232_8436# 0
C3047 sg13cmos5l_dfrbp_1_6.RESET_B a_8041_5770# 0.00197f
C3048 sg13cmos5l_dfrbp_1_21.Q a_15412_5800# 0
C3049 a_8660_5412# a_8796_5814# 0.00404f
C3050 a_8841_5769# a_9366_5842# 0.13715f
C3051 a_12075_1748# nl_sw[6] 0.01347f
C3052 sg13cmos5l_buf_1_87.A a_19624_8436# 0
C3053 sg13cmos5l_inv_1_29.A a_11560_7010# 0
C3054 a_19227_4654# a_19796_3436# 0.00243f
C3055 sg13cmos5l_dfrbp_1_16.Q_N a_2879_6432# 0
C3056 a_4076_7624# a_2748_6126# 0
C3057 a_3676_7964# a_3575_6553# 0
C3058 sg13cmos5l_nor2b_1_1.Y sg13cmos5l_buf_1_8.A 0.00496f
C3059 sg13cmos5l_buf_1_46.A a_9457_4642# 0
C3060 sg13cmos5l_dlhr_1_5.GATE a_5674_6385# 0.03786f
C3061 sg13cmos5l_buf_1_77.A sg13cmos5l_dlhr_1_17.Q_N 0.1866f
C3062 sg13cmos5l_inv_1_18.A sg13cmos5l_buf_1_45.A 1.30221f
C3063 sg13cmos5l_nand2_1_1.A a_20200_3270# 0
C3064 sg13cmos5l_buf_8_1.A a_16751_2749# 0
C3065 a_6903_3154# a_6889_1680# 0.00162f
C3066 a_8772_8440# a_9060_8861# 0.4806f
C3067 a_8746_8404# a_9291_8447# 0.00999f
C3068 a_8486_8874# a_10031_8797# 0
C3069 a_11824_7894# pl_sw[6] 0
C3070 sg13cmos5l_dfrbp_1_23.CLK a_12361_7282# 0.00141f
C3071 sg13cmos5l_nor2b_1_0.Y a_10888_1664# 0.02066f
C3072 a_5637_2399# a_6188_1590# 0
C3073 a_18999_6178# a_19130_6172# 0.65127f
C3074 sg13cmos5l_inv_1_0.A a_11844_4325# 0.0042f
C3075 a_17780_8436# cks 0.01626f
C3076 sg13cmos5l_nor2b_1_1.Y sg13cmos5l_buf_1_1.A 0
C3077 sg13cmos5l_buf_1_41.A a_3447_2746# 0.00495f
C3078 sg13cmos5l_buf_1_3.A a_19624_8436# 0
C3079 sg13cmos5l_buf_1_111.A sg13cmos5l_inv_1_6.A 0
C3080 a_19227_9190# a_20008_8436# 0.00645f
C3081 a_6153_3947# VPWR 0
C3082 sg13cmos5l_buf_1_73.A sg13cmos5l_dfrbp_1_20.Q_N 0
C3083 sg13cmos5l_dfrbp_1_6.D sg13cmos5l_buf_1_37.A 0.00662f
C3084 a_16144_8678# a_16089_8559# 0.00464f
C3085 sg13cmos5l_or2_1_0.A a_20008_3900# 0
C3086 a_2621_7636# sg13cmos5l_dfrbp_1_16.Q 0.00108f
C3087 sg13cmos5l_buf_1_58.A a_1967_7285# 0.00233f
C3088 sg13cmos5l_inv_1_1.A a_15592_6200# 0.13634f
C3089 sg13cmos5l_inv_1_14.A a_6843_5459# 0
C3090 sg13cmos5l_dlhr_1_6.D a_10028_6126# 0.00676f
C3091 a_1948_7964# a_1878_6337# 0
C3092 a_1846_7850# a_1997_6126# 0
C3093 a_10022_7674# a_10665_7281# 0
C3094 a_10308_7992# a_10484_6924# 0
C3095 sg13cmos5l_dfrbp_1_6.RESET_B sg13cmos5l_dlhr_1_16.Q 0.04266f
C3096 sg13cmos5l_dlhr_1_5.Q a_8852_6484# 0.03044f
C3097 sg13cmos5l_buf_1_24.A a_5796_3904# 0.0191f
C3098 sg13cmos5l_dlhr_1_1.D a_2644_4636# 0
C3099 sg13cmos5l_buf_1_10.A a_12698_7288# 0.00121f
C3100 sg13cmos5l_dlhr_1_5.Q_N a_9448_6924# 0.0698f
C3101 sg13cmos5l_buf_1_30.A a_6891_4772# 0.03201f
C3102 a_422_5850# ckc 0
C3103 a_13803_3260# sg13cmos5l_nor2_1_1.A 0
C3104 sg13cmos5l_buf_1_34.X a_3664_8678# 0
C3105 sg13cmos5l_buf_1_3.A a_19227_4654# 0.05717f
C3106 sg13cmos5l_a221oi_1_0.B1 a_11771_5412# 0.08989f
C3107 a_18376_9224# a_18272_9318# 0.00624f
C3108 sg13cmos5l_dfrbp_1_6.RESET_B a_3625_7282# 0.00137f
C3109 a_11656_3176# sg13cmos5l_buf_1_8.A 0
C3110 sg13cmos5l_dfrbp_1_8.RESET_B a_5210_3148# 0
C3111 a_10998_9168# sg13cmos5l_dlhr_1_11.GATE 0
C3112 sg13cmos5l_a221oi_1_0.B1 a_9705_4650# 0
C3113 sg13cmos5l_dfrbp_1_6.RESET_B sg13cmos5l_dfrbp_1_6.D 6.33589f
C3114 sg13cmos5l_inv_1_8.A a_2161_4642# 0
C3115 sg13cmos5l_inv_1_6.A a_20392_6924# 0.00316f
C3116 sg13cmos5l_dfrbp_1_15.D a_422_7362# 0
C3117 sg13cmos5l_dlhr_1_15.D sg13cmos5l_dfrbp_1_21.Q_N 0
C3118 a_14426_7288# a_14583_5770# 0
C3119 a_14295_7282# a_14714_5776# 0
C3120 sg13cmos5l_dfrbp_1_23.Q a_13792_5760# 0
C3121 a_19142_5412# sg13cmos5l_buf_8_0.A 0
C3122 sg13cmos5l_buf_1_40.A a_422_7362# 0.0216f
C3123 a_15876_4968# cks 0.01411f
C3124 a_20012_2352# nl_sw[10] 0.28818f
C3125 sg13cmos5l_nand2_1_1.A sg13cmos5l_a22oi_1_1.A1 0.44274f
C3126 sg13cmos5l_buf_1_4.A a_15974_6162# 0.05006f
C3127 sg13cmos5l_dlhr_1_13.Q_N a_15876_7362# 0
C3128 sg13cmos5l_buf_1_93.X a_13810_9186# 0
C3129 sg13cmos5l_dfrbp_1_8.RESET_B sg13cmos5l_buf_1_116.A 0.02999f
C3130 sg13cmos5l_o21ai_1_0.B1 sg13cmos5l_o21ai_1_0.Y 0.23402f
C3131 sg13cmos5l_buf_1_6.A a_11877_2399# 0
C3132 sg13cmos5l_dfrbp_1_8.RESET_B a_6086_4650# 0.0982f
C3133 sg13cmos5l_dfrbp_1_6.D a_10412_6126# 0.00581f
C3134 a_11434_2356# a_11556_1944# 0
C3135 sg13cmos5l_a221oi_1_0.A2 a_9940_4636# 0.00116f
C3136 sg13cmos5l_buf_1_18.A a_19378_3138# 0.00115f
C3137 sg13cmos5l_nor2_1_0.A sg13cmos5l_nand2_1_0.B 0.31725f
C3138 VPWR rdy 0.14425f
C3139 sg13cmos5l_dfrbp_1_6.D a_10071_7282# 0.00269f
C3140 nl_sw[8] nh_sw[8] 0.06378f
C3141 sg13cmos5l_buf_1_32.X nl_sw[0] 0.0087f
C3142 a_16293_4629# sg13cmos5l_a22oi_1_1.A1 0.00117f
C3143 sg13cmos5l_or2_1_0.A a_12815_4261# 0.00505f
C3144 sg13cmos5l_buf_1_31.X sg13cmos5l_buf_1_26.X 0
C3145 a_2148_3138# sg13cmos5l_dfrbp_1_10.Q_N 0
C3146 a_3599_3215# a_3505_3215# 0.32273f
C3147 sg13cmos5l_buf_1_79.X a_12549_9165# 0.00652f
C3148 sg13cmos5l_buf_1_10.A a_11973_1605# 0
C3149 a_2340_3456# sg13cmos5l_buf_1_41.X 0
C3150 sg13cmos5l_dfrbp_1_16.Q sg13cmos5l_dlhr_1_6.D 0.10425f
C3151 a_682_5380# sg13cmos5l_nand2_1_2.B 0
C3152 sg13cmos5l_buf_1_65.X a_9256_9224# 0
C3153 sg13cmos5l_buf_1_29.A a_9638_5088# 0.00168f
C3154 sg13cmos5l_buf_1_4.A a_16657_2749# 0.00596f
C3155 sg13cmos5l_dlhr_1_9.D a_8852_6484# 0
C3156 a_15414_7354# sg13cmos5l_buf_1_116.A 0
C3157 a_2474_6162# a_2638_6162# 0
C3158 a_3530_6320# a_3926_6175# 0
C3159 sg13cmos5l_inv_1_3.A a_13284_3456# 0
C3160 a_13484_8400# sg13cmos5l_buf_1_98.A 0.00406f
C3161 sg13cmos5l_buf_1_79.X a_7247_8797# 0
C3162 a_9544_2474# a_9448_1664# 0.00705f
C3163 sg13cmos5l_buf_1_57.X a_14996_5412# 0.00276f
C3164 sg13cmos5l_dfrbp_1_0.Q nh_sw[9] 0.16174f
C3165 a_11686_2813# VPWR 0
C3166 a_2224_5654# a_1967_5773# 0.35645f
C3167 sg13cmos5l_dfrbp_1_18.Q a_10225_9178# 0
C3168 sg13cmos5l_inv_1_6.A d_out[2] 0
C3169 a_14726_7674# a_15300_7687# 0.36169f
C3170 a_15531_7796# a_16528_7894# 0.06778f
C3171 sg13cmos5l_dfrbp_1_6.RESET_B a_10024_5498# 0.0025f
C3172 sg13cmos5l_nor2_1_0.A nl_sw[6] 0.00677f
C3173 sg13cmos5l_buf_1_60.A sg13cmos5l_buf_1_73.X 0
C3174 a_7504_8678# pl_sw[5] 0
C3175 sg13cmos5l_buf_1_4.A a_17399_3947# 0
C3176 a_16690_7674# cks 0.00169f
C3177 a_11556_3904# sg13cmos5l_buf_1_9.A 0
C3178 sg13cmos5l_nand2_1_1.B a_13701_3117# 0.0101f
C3179 a_7994_7288# VPWR 0.35906f
C3180 sg13cmos5l_inv_1_2.A a_15782_7362# 0
C3181 a_2148_8440# a_2667_8447# 0.38871f
C3182 a_2565_8447# a_2436_8861# 0.01562f
C3183 sg13cmos5l_inv_1_8.A a_2727_6380# 0.01679f
C3184 a_8392_3270# sg13cmos5l_dlhr_1_0.Q_N 0
C3185 sg13cmos5l_buf_1_5.A a_14152_5498# 0.00887f
C3186 sg13cmos5l_dlhr_1_0.D sg13cmos5l_a22oi_1_2.B1 0.87819f
C3187 sg13cmos5l_inv_1_1.A sg13cmos5l_dfrbp_1_6.D 1.09014f
C3188 sg13cmos5l_dfrbp_1_9.Q a_2628_3151# 0
C3189 sg13cmos5l_buf_1_10.A a_12814_4692# 0.00756f
C3190 sg13cmos5l_inv_1_17.A a_3575_6553# 0.02223f
C3191 a_19616_3986# a_18959_3215# 0.00442f
C3192 sg13cmos5l_dfrbp_1_6.RESET_B a_2374_4325# 0
C3193 a_10071_7282# a_10024_5498# 0
C3194 sg13cmos5l_buf_1_60.X a_5416_9224# 0
C3195 a_14928_5412# VPWR 0
C3196 a_1227_6935# a_1125_5423# 0
C3197 sg13cmos5l_buf_1_30.A sg13cmos5l_dlhr_1_0.D 0.01927f
C3198 sg13cmos5l_buf_1_24.A sg13cmos5l_dlhr_1_0.Q 0.12074f
C3199 a_620_7638# cks 0.03951f
C3200 sg13cmos5l_inv_1_3.A a_13324_4696# 0.0027f
C3201 sg13cmos5l_a22oi_1_1.B2 sg13cmos5l_buf_1_2.A 0.03617f
C3202 sg13cmos5l_and3_1_0.X a_13520_4696# 0.00157f
C3203 a_15177_5769# sg13cmos5l_and3_1_0.C 0
C3204 sg13cmos5l_a221oi_1_0.B1 sg13cmos5l_or2_1_0.A 0
C3205 sg13cmos5l_inv_1_0.A a_13803_3260# 0
C3206 a_4559_7630# a_4652_6126# 0
C3207 sg13cmos5l_buf_1_0.A a_19378_3138# 0
C3208 sg13cmos5l_nand2_1_1.A nh_sw[8] 0.01127f
C3209 sg13cmos5l_buf_1_40.A a_2409_4650# 0
C3210 cks pl_sw[3] 0.02026f
C3211 sg13cmos5l_inv_1_0.Y a_13520_4696# 0
C3212 sg13cmos5l_a22oi_1_1.B1 a_10433_4248# 0.00778f
C3213 a_12800_5498# a_11556_3904# 0
C3214 a_12616_5498# a_11973_3911# 0
C3215 sg13cmos5l_buf_1_34.X nl_sw[3] 0.00304f
C3216 sg13cmos5l_dlhr_1_5.GATE a_6057_6553# 0
C3217 sg13cmos5l_or2_1_0.A nl_sw[8] 0.0029f
C3218 a_8022_3120# a_7689_1626# 0.00135f
C3219 a_7316_3460# a_7508_1948# 0
C3220 sg13cmos5l_dlhr_1_2.Q_N VPWR 0.2907f
C3221 a_708_6928# a_1878_6337# 0
C3222 sg13cmos5l_dfrbp_1_6.RESET_B a_10534_7687# 0
C3223 a_9291_8447# a_10288_8678# 0.07046f
C3224 sg13cmos5l_dlhr_1_9.D a_6380_7638# 0
C3225 sg13cmos5l_dfrbp_1_23.CLK a_13396_7312# 0
C3226 a_6736_2630# a_6572_1590# 0
C3227 sg13cmos5l_nand2_1_2.B ckc 0.05783f
C3228 a_19130_6172# a_19526_6600# 0.00949f
C3229 sg13cmos5l_buf_1_29.A sg13cmos5l_a221oi_1_0.A2 0.02092f
C3230 sg13cmos5l_dfrbp_1_18.Q a_10202_7288# 0
C3231 sg13cmos5l_buf_1_97.A sg13cmos5l_buf_1_10.A 0.03102f
C3232 a_9705_4650# sg13cmos5l_inv_1_11.Y 0
C3233 a_9879_9202# cks 0
C3234 sg13cmos5l_buf_1_107.X ph_sw[8] 0.00989f
C3235 a_20204_5376# d_out[2] 0.00139f
C3236 a_12976_2630# a_12921_2511# 0.00464f
C3237 sg13cmos5l_dfrbp_1_22.D a_16089_8559# 0
C3238 sg13cmos5l_dfrbp_1_6.RESET_B a_15147_8447# 0.00276f
C3239 sg13cmos5l_buf_1_3.A a_20392_3900# 0
C3240 sg13cmos5l_dfrbp_1_8.RESET_B a_11940_9186# 0
C3241 sg13cmos5l_dfrbp_1_16.Q a_7312_4142# 0
C3242 sg13cmos5l_dfrbp_1_21.Q a_13486_5760# 0
C3243 a_16160_9318# ph_sw[6] 0
C3244 a_2596_7996# a_2879_6432# 0
C3245 sg13cmos5l_buf_1_58.A a_1484_6126# 0.32081f
C3246 a_2348_7624# a_2380_6162# 0
C3247 a_20008_7712# a_19593_6162# 0.00206f
C3248 sg13cmos5l_buf_1_24.A a_7055_4261# 0.00167f
C3249 sg13cmos5l_buf_1_63.X a_1000_9224# 0.0032f
C3250 a_1196_8400# sg13cmos5l_inv_1_19.A 0.01241f
C3251 a_1463_8511# a_1484_9150# 0
C3252 sg13cmos5l_buf_1_63.A sg13cmos5l_buf_1_61.X 0
C3253 a_16144_8678# pl_sw[8] 0
C3254 a_13297_9263# a_12841_7728# 0
C3255 sg13cmos5l_buf_1_5.X sg13cmos5l_nor2_1_1.A 0.15761f
C3256 sg13cmos5l_buf_1_10.A sg13cmos5l_dlhr_1_11.Q_N 0
C3257 sg13cmos5l_nand2_1_1.A a_18117_3117# 0.02515f
C3258 sg13cmos5l_dfrbp_1_6.D a_17751_7690# 0.00211f
C3259 sg13cmos5l_buf_1_96.A a_11072_5347# 0
C3260 sg13cmos5l_buf_1_34.X sg13cmos5l_dfrbp_1_15.D 0.47667f
C3261 sg13cmos5l_buf_1_101.X ph_sw[8] 0.24932f
C3262 sg13cmos5l_nor2b_1_0.Y VPWR 1.23276f
C3263 sg13cmos5l_buf_1_41.A a_2859_3260# 0.03437f
C3264 sg13cmos5l_dfrbp_1_6.RESET_B a_4950_7354# 0.00785f
C3265 sg13cmos5l_dfrbp_1_8.RESET_B a_7666_8874# 0
C3266 sg13cmos5l_inv_1_17.A a_1580_2352# 0
C3267 a_2248_1664# a_2732_1590# 0.03472f
C3268 a_5951_5383# a_6602_5692# 0.01562f
C3269 sg13cmos5l_inv_1_8.A a_5049_4965# 0.00109f
C3270 sg13cmos5l_inv_1_18.A a_6959_6239# 0
C3271 a_4076_7624# a_4324_7996# 0.68988f
C3272 a_3676_7964# a_4349_7636# 0.09085f
C3273 sg13cmos5l_buf_1_58.A a_2306_7660# 0
C3274 sg13cmos5l_buf_1_38.A a_3496_1758# 0
C3275 sg13cmos5l_dlhr_1_15.D a_11394_4948# 0.00117f
C3276 sg13cmos5l_buf_1_44.A VPWR 0.39252f
C3277 sg13cmos5l_dfrbp_1_23.Q a_14152_5498# 0.00225f
C3278 sg13cmos5l_dfrbp_1_0.CLK a_17414_3138# 0.00257f
C3279 sg13cmos5l_buf_1_5.A sg13cmos5l_inv_1_29.A 0.9176f
C3280 a_16068_6928# a_16485_6935# 0.49014f
C3281 a_7994_7288# a_8233_6216# 0
C3282 a_12516_6480# a_13324_4696# 0
C3283 a_12520_3176# a_12625_2749# 0
C3284 sg13cmos5l_buf_1_6.A a_12976_2630# 0.0048f
C3285 sg13cmos5l_dfrbp_1_8.RESET_B a_7631_4727# 0.20052f
C3286 a_7994_7288# sg13cmos5l_dfrbp_1_11.Q 0
C3287 a_12216_5728# sg13cmos5l_a22oi_1_1.B2 0
C3288 sg13cmos5l_or2_1_1.B a_13486_5760# 0
C3289 sg13cmos5l_or2_1_0.A sg13cmos5l_nand2_1_1.A 0.31518f
C3290 sg13cmos5l_dfrbp_1_0.D sg13cmos5l_a22oi_1_1.A1 0.02086f
C3291 a_20392_7712# ph_sw[10] 0.01081f
C3292 sg13cmos5l_inv_1_6.A sg13cmos5l_dfrbp_1_21.Q_N 0
C3293 a_3505_3215# sg13cmos5l_dfrbp_1_10.Q_N 0.01014f
C3294 sg13cmos5l_buf_1_19.A a_18999_6178# 0.0447f
C3295 sg13cmos5l_dfrbp_1_8.RESET_B a_2340_3456# 0.00103f
C3296 sg13cmos5l_buf_1_79.X sg13cmos5l_inv_1_27.Y 0
C3297 sg13cmos5l_dfrbp_1_6.RESET_B a_5194_2356# 0.33128f
C3298 sg13cmos5l_buf_1_45.X a_10331_3900# 0
C3299 a_11072_5347# sg13cmos5l_a221oi_1_0.B1 0.00332f
C3300 a_18615_5770# sg13cmos5l_buf_8_0.A 0
C3301 sg13cmos5l_inv_1_2.A a_9937_8797# 0
C3302 sg13cmos5l_dlhr_1_9.D a_3302_4650# 0.00919f
C3303 a_16293_4629# sg13cmos5l_or2_1_0.A 0
C3304 sg13cmos5l_inv_1_1.A a_15147_8447# 0.00225f
C3305 a_8247_5770# VPWR 0.18127f
C3306 sg13cmos5l_buf_1_8.X a_11556_1944# 0
C3307 a_708_5416# sg13cmos5l_inv_1_8.Y 0
C3308 a_422_5850# sg13cmos5l_dlygate4sd2_1_0.A 0
C3309 sg13cmos5l_buf_1_79.X a_8580_8874# 0
C3310 a_1096_6294# sg13cmos5l_inv_1_19.A 0.00562f
C3311 sg13cmos5l_inv_1_17.A sg13cmos5l_buf_1_31.X 0.02673f
C3312 a_19593_6162# a_19227_4654# 0.00927f
C3313 a_13138_2826# VPWR 0
C3314 sg13cmos5l_buf_1_18.A a_17700_3456# 0.00551f
C3315 a_1967_5773# sg13cmos5l_dlhr_1_1.D 0.04896f
C3316 sg13cmos5l_dfrbp_1_11.Q sg13cmos5l_dlhr_1_2.Q_N 0
C3317 sg13cmos5l_or2_1_0.A sg13cmos5l_inv_1_11.Y 0.00245f
C3318 sg13cmos5l_dfrbp_1_6.D a_5452_5850# 0.05286f
C3319 a_19161_3453# sg13cmos5l_buf_1_19.X 0
C3320 sg13cmos5l_dfrbp_1_6.RESET_B a_5702_8874# 0.00766f
C3321 a_10665_8065# VPWR 0
C3322 sg13cmos5l_nand2_1_1.B a_15884_3102# 0
C3323 sg13cmos5l_inv_1_8.A a_3530_6320# 0
C3324 a_2122_8404# sg13cmos5l_dfrbp_1_15.D 0
C3325 a_3664_8678# a_3407_8797# 0.35645f
C3326 sg13cmos5l_buf_1_78.X a_6276_8861# 0.01946f
C3327 a_20296_1664# d_out[1] 0
C3328 a_13100_8400# sg13cmos5l_inv_1_7.A 0.00112f
C3329 sg13cmos5l_dfrbp_1_8.RESET_B a_2934_4632# 0.00334f
C3330 sg13cmos5l_inv_1_8.A a_1227_5423# 0
C3331 sg13cmos5l_inv_1_17.A a_3926_6175# 0
C3332 a_14342_8874# VPWR 0.928f
C3333 sg13cmos5l_inv_1_18.A nl_sw[4] 0
C3334 sg13cmos5l_nor2_1_0.A sg13cmos5l_a221oi_1_1.C1 0.01784f
C3335 sg13cmos5l_a22oi_1_1.B2 sg13cmos5l_buf_1_6.A 0
C3336 sg13cmos5l_dfrbp_1_6.RESET_B a_13035_6284# 0.55788f
C3337 sg13cmos5l_dfrbp_1_20.Q sg13cmos5l_nand2_1_0.A 0.00157f
C3338 a_422_5850# a_516_5850# 0.00718f
C3339 sg13cmos5l_inv_1_0.Y a_12022_3134# 0
C3340 sg13cmos5l_o21ai_1_0.A1 a_11656_3176# 0.04536f
C3341 sg13cmos5l_nand2_1_0.B sg13cmos5l_o21ai_1_0.Y 0
C3342 sg13cmos5l_buf_1_4.A sg13cmos5l_buf_1_1.A 0.13767f
C3343 sg13cmos5l_inv_1_27.Y sg13cmos5l_buf_1_96.A 0
C3344 a_4460_9150# sg13cmos5l_buf_1_34.X 0.00994f
C3345 sg13cmos5l_buf_1_77.A sg13cmos5l_dlhr_1_5.GATE 0.01353f
C3346 a_3831_7282# VPWR 0.18106f
C3347 a_18856_8436# a_19340_8400# 0.03472f
C3348 sg13cmos5l_dlhr_1_5.GATE a_5926_6175# 0
C3349 sg13cmos5l_dlhr_1_1.GATE a_3488_7010# 0.00157f
C3350 sg13cmos5l_dlhr_1_2.Q a_7689_1626# 0.0032f
C3351 sg13cmos5l_dfrbp_1_6.RESET_B a_1121_4166# 0.00302f
C3352 sg13cmos5l_dfrbp_1_11.Q sg13cmos5l_buf_1_44.A 0
C3353 a_10288_8678# sg13cmos5l_dfrbp_1_27.Q_N 0.15881f
C3354 a_7498_7897# VPWR 0.09583f
C3355 sg13cmos5l_dlhr_1_5.GATE a_8457_7281# 0.00134f
C3356 a_6479_2749# a_7095_1642# 0.01005f
C3357 a_17780_8436# pl_sw[9] 0.01091f
C3358 sg13cmos5l_dfrbp_1_8.RESET_B sg13cmos5l_inv_1_7.A 0.03851f
C3359 sg13cmos5l_inv_1_14.A a_5510_4338# 0
C3360 sg13cmos5l_dfrbp_1_0.D nh_sw[8] 0.03742f
C3361 sg13cmos5l_nand2_1_0.B a_11054_4292# 0
C3362 sg13cmos5l_o21ai_1_0.A1 sg13cmos5l_a22oi_1_1.B1 0.74606f
C3363 sg13cmos5l_nor2_1_1.A a_15909_2399# 0.01968f
C3364 sg13cmos5l_inv_1_8.A a_3676_7964# 0
C3365 sg13cmos5l_inv_1_29.A a_13460_7996# 0
C3366 a_13596_7710# sg13cmos5l_dlhr_1_6.D 0
C3367 sg13cmos5l_o21ai_1_0.Y nl_sw[6] 0.01928f
C3368 sg13cmos5l_dfrbp_1_16.Q a_8972_3864# 0
C3369 sg13cmos5l_buf_1_24.X nh_sw[3] 0.03731f
C3370 sg13cmos5l_buf_1_87.A a_18486_8866# 0.01758f
C3371 a_11567_7751# a_11560_7010# 0
C3372 sg13cmos5l_buf_1_58.A a_2380_6162# 0
C3373 sg13cmos5l_buf_1_0.A a_17700_3456# 0.02724f
C3374 sg13cmos5l_dlhr_1_9.D sg13cmos5l_nand2_1_0.A 0.00389f
C3375 sg13cmos5l_inv_1_17.A a_3212_1590# 0.00206f
C3376 sg13cmos5l_buf_8_0.X sg13cmos5l_dlhr_1_10.Q_N 0.02409f
C3377 sg13cmos5l_buf_1_24.A a_7257_4023# 0
C3378 sg13cmos5l_nor2_1_0.A a_11072_2474# 0
C3379 sg13cmos5l_dfrbp_1_22.D pl_sw[8] 0
C3380 sg13cmos5l_inv_1_17.A a_4349_7636# 0
C3381 sg13cmos5l_nand2_1_1.A sg13cmos5l_buf_1_3.X 0
C3382 sg13cmos5l_buf_1_44.X a_4640_3986# 0.03465f
C3383 a_10202_7288# cks 0
C3384 sg13cmos5l_inv_1_0.A a_13036_4948# 0.0043f
C3385 sg13cmos5l_dfrbp_1_1.Q nh_sw[10] 0
C3386 a_14543_3215# a_14962_3138# 0.00176f
C3387 a_8439_6178# a_8041_5770# 0.0067f
C3388 a_8233_6216# a_8247_5770# 0.01055f
C3389 sg13cmos5l_buf_1_86.A sg13cmos5l_dlhr_1_16.Q 0.00161f
C3390 a_3578_2752# a_3496_1758# 0
C3391 a_4934_2826# a_4840_1664# 0
C3392 a_2732_9150# sg13cmos5l_dfrbp_1_8.RESET_B 0
C3393 sg13cmos5l_buf_1_41.A a_2628_3151# 0.00443f
C3394 sg13cmos5l_dfrbp_1_8.RESET_B a_9189_8447# 0.06255f
C3395 a_8276_6924# a_8660_5412# 0
C3396 a_2248_1664# nl_sw[2] 0.28943f
C3397 sg13cmos5l_nor2b_1_0.Y a_12814_4692# 0.28487f
C3398 sg13cmos5l_dfrbp_1_11.Q a_8247_5770# 0.23167f
C3399 sg13cmos5l_dfrbp_1_0.D a_18117_3117# 0.02254f
C3400 sg13cmos5l_inv_1_18.A sg13cmos5l_dlhr_1_6.D 0.2388f
C3401 sg13cmos5l_inv_1_27.Y a_13094_6924# 0
C3402 a_11434_2356# sg13cmos5l_buf_1_8.A 0.00452f
C3403 sg13cmos5l_dfrbp_1_0.CLK a_19216_3358# 0
C3404 sg13cmos5l_nand2_1_2.B a_1210_4654# 0.00116f
C3405 a_8774_5412# VPWR 0.00418f
C3406 a_16068_6928# a_17327_7285# 0.01741f
C3407 a_16485_6935# a_17584_7166# 0
C3408 sg13cmos5l_inv_1_14.A pl_sw[4] 0.00109f
C3409 a_424_9318# pl_sw[0] 0.00582f
C3410 sg13cmos5l_buf_1_6.A a_14254_2444# 0.00825f
C3411 sg13cmos5l_dfrbp_1_8.RESET_B sg13cmos5l_dfrbp_1_11.Q_N 0
C3412 a_12976_2630# a_12815_1703# 0
C3413 a_12625_2749# a_12075_1748# 0
C3414 sg13cmos5l_nand2_1_2.B sg13cmos5l_dlygate4sd2_1_0.A 0.49566f
C3415 sg13cmos5l_dfrbp_1_8.RESET_B sg13cmos5l_dlhr_1_13.Q_N 0.00154f
C3416 a_18409_5770# a_18363_4270# 0.00292f
C3417 sg13cmos5l_dfrbp_1_6.D a_12361_7282# 0.00329f
C3418 a_17988_3151# VPWR 0.01074f
C3419 a_10282_7897# a_10827_7796# 0.00999f
C3420 sg13cmos5l_buf_1_110.A pl_sw[7] 0
C3421 sg13cmos5l_or2_1_0.A a_13701_3117# 0.0014f
C3422 a_2596_7996# a_2790_7996# 0.01249f
C3423 a_2348_7624# a_3574_7850# 0
C3424 a_8783_7751# a_9448_6924# 0.00653f
C3425 sg13cmos5l_dfrbp_1_6.RESET_B a_5739_2399# 0.57837f
C3426 a_13686_7354# sg13cmos5l_a22oi_1_1.B2 0
C3427 a_1760_3986# VPWR 0.08078f
C3428 sg13cmos5l_buf_1_74.X sg13cmos5l_inv_1_14.A 0.00458f
C3429 sg13cmos5l_inv_1_2.A a_12716_8400# 0
C3430 a_19209_5769# sg13cmos5l_buf_8_0.A 0.00358f
C3431 a_5700_6480# a_6117_6141# 0.48921f
C3432 a_5414_6162# a_6219_6284# 0.11742f
C3433 sg13cmos5l_buf_1_60.X a_1862_8874# 0.00172f
C3434 a_12132_9504# pl_sw[6] 0.02986f
C3435 sg13cmos5l_inv_1_1.A sg13cmos5l_dfrbp_1_25.Q_N 0.00884f
C3436 a_15784_9224# sg13cmos5l_dfrbp_1_22.D 0
C3437 sg13cmos5l_dfrbp_1_0.D sg13cmos5l_or2_1_0.A 0.59977f
C3438 sg13cmos5l_nand2_1_1.B a_15492_2392# 0.01716f
C3439 a_15414_7354# sg13cmos5l_dlhr_1_13.Q_N 0.12876f
C3440 a_15592_6200# a_15974_6162# 0
C3441 sg13cmos5l_buf_1_79.X a_9291_8447# 0.0135f
C3442 sg13cmos5l_dfrbp_1_8.RESET_B a_2565_8447# 0.06761f
C3443 a_416_2474# nl_sw[0] 0.01136f
C3444 a_2748_6126# sg13cmos5l_inv_1_19.A 0.01051f
C3445 sg13cmos5l_buf_1_19.A sg13cmos5l_buf_8_0.X 0
C3446 sg13cmos5l_dfrbp_1_6.D a_8439_6178# 0.00554f
C3447 a_10464_2427# a_10696_1758# 0
C3448 sg13cmos5l_buf_1_18.A a_19796_3436# 0.00198f
C3449 sg13cmos5l_buf_1_24.A a_6741_5459# 0.03497f
C3450 sg13cmos5l_dfrbp_1_6.D a_5951_5383# 0
C3451 sg13cmos5l_dfrbp_1_8.D a_16940_3102# 0
C3452 a_1125_5423# sg13cmos5l_inv_1_9.Y 0
C3453 sg13cmos5l_buf_1_44.X sg13cmos5l_buf_1_78.A 0.02066f
C3454 a_10596_7687# VPWR 0.00734f
C3455 sg13cmos5l_buf_1_29.A a_10318_5412# 0
C3456 sg13cmos5l_dfrbp_1_6.RESET_B a_5210_3148# 0.00649f
C3457 sg13cmos5l_buf_1_10.A a_12120_3456# 0.00185f
C3458 a_3407_8797# sg13cmos5l_dfrbp_1_15.D 0.00925f
C3459 a_4244_8436# sg13cmos5l_dfrbp_1_17.Q_N 0.25039f
C3460 sg13cmos5l_inv_1_8.A a_5414_6162# 0.04419f
C3461 a_20672_1758# d_out[1] 0
C3462 sg13cmos5l_buf_1_78.X a_6345_8483# 0
C3463 sg13cmos5l_inv_1_20.Y ph_sw[2] 0
C3464 sg13cmos5l_dfrbp_1_8.RESET_B sg13cmos5l_dfrbp_1_9.Q 0.48515f
C3465 sg13cmos5l_inv_1_2.A a_12106_9409# 0
C3466 a_14916_8861# VPWR 0.00674f
C3467 sg13cmos5l_buf_1_9.A a_9832_1664# 0.2886f
C3468 sg13cmos5l_inv_1_7.A a_11556_3904# 0.00368f
C3469 a_2248_9224# ph_sw[0] 0
C3470 sg13cmos5l_dfrbp_1_6.RESET_B a_6086_4650# 0.00243f
C3471 sg13cmos5l_dfrbp_1_6.RESET_B sg13cmos5l_buf_1_116.A 0.05247f
C3472 a_7238_7674# a_8043_7796# 0.11742f
C3473 a_7524_7992# a_7941_7653# 0.48921f
C3474 sg13cmos5l_buf_1_57.X sg13cmos5l_buf_1_46.A 0
C3475 sg13cmos5l_nand2_1_1.B a_10618_3142# 0
C3476 sg13cmos5l_nand2_1_1.B a_10433_1652# 0
C3477 a_17882_7684# cks 0.00511f
C3478 sg13cmos5l_buf_1_26.A sg13cmos5l_buf_1_28.A 0.13361f
C3479 sg13cmos5l_buf_1_3.A sg13cmos5l_buf_1_18.A 3.37731f
C3480 sg13cmos5l_dfrbp_1_17.D a_2148_8440# 0.00317f
C3481 a_4425_7281# VPWR 0.62571f
C3482 sg13cmos5l_buf_1_5.A sg13cmos5l_a22oi_1_1.B2 0.20463f
C3483 sg13cmos5l_dlhr_1_1.GATE sg13cmos5l_buf_1_59.A 0.07371f
C3484 sg13cmos5l_inv_1_17.A sg13cmos5l_inv_1_8.A 0.0654f
C3485 sg13cmos5l_dfrbp_1_10.Q a_9448_1664# 0
C3486 sg13cmos5l_dlhr_1_9.D a_2748_6126# 0
C3487 sg13cmos5l_dlhr_1_10.Q_N a_20672_6294# 0.00194f
C3488 sg13cmos5l_inv_1_14.A a_6084_4325# 0
C3489 sg13cmos5l_dlhr_1_9.D sg13cmos5l_dfrbp_1_1.Q 0
C3490 sg13cmos5l_dfrbp_1_11.Q a_8774_5412# 0
C3491 sg13cmos5l_nor2_1_1.A a_17008_2630# 0.01552f
C3492 sg13cmos5l_dlhr_1_11.D a_12216_5728# 0
C3493 sg13cmos5l_dfrbp_1_20.Q_N a_9879_9202# 0.00139f
C3494 sg13cmos5l_buf_1_57.X a_13681_6239# 0.00309f
C3495 sg13cmos5l_inv_1_29.A a_13393_7666# 0
C3496 sg13cmos5l_inv_1_29.A ph_sw[5] 0.00319f
C3497 sg13cmos5l_buf_1_0.A a_19796_3436# 0
C3498 sg13cmos5l_inv_1_0.Y a_10789_4654# 0
C3499 sg13cmos5l_a221oi_1_0.B2 a_11556_3904# 0
C3500 sg13cmos5l_nor2_1_0.A a_12625_2749# 0
C3501 sg13cmos5l_dlhr_1_2.D a_6889_1680# 0
C3502 sg13cmos5l_buf_1_77.A sg13cmos5l_buf_1_45.A 0.00348f
C3503 a_8022_3120# VPWR 0.25754f
C3504 sg13cmos5l_nor2_1_1.A a_17126_1626# 0
C3505 a_4076_5376# sg13cmos5l_buf_1_38.A 0
C3506 sg13cmos5l_buf_1_5.X a_17700_3456# 0
C3507 a_5028_2826# VPWR 0
C3508 sg13cmos5l_dfrbp_1_8.RESET_B a_10868_8436# 0.0065f
C3509 sg13cmos5l_dfrbp_1_6.D a_15974_6162# 0.01662f
C3510 sg13cmos5l_buf_1_41.A sg13cmos5l_buf_1_41.X 0.51943f
C3511 a_10888_1664# nh_sw[5] 0.01811f
C3512 sg13cmos5l_buf_1_111.A sg13cmos5l_buf_1_104.X 0
C3513 sg13cmos5l_a22oi_1_1.A1 a_15492_2392# 0
C3514 a_16204_4338# cks 0
C3515 a_11748_2813# sg13cmos5l_buf_1_8.A 0
C3516 a_1463_8741# sg13cmos5l_buf_1_68.X 0
C3517 sg13cmos5l_buf_1_73.A sg13cmos5l_buf_1_79.X 0
C3518 sg13cmos5l_dfrbp_1_22.D a_17161_8794# 0.1735f
C3519 sg13cmos5l_inv_1_1.A sg13cmos5l_buf_1_116.A 0.72152f
C3520 sg13cmos5l_dfrbp_1_21.Q a_13076_5376# 0.01242f
C3521 sg13cmos5l_dfrbp_1_18.Q a_10282_7897# 0.00247f
C3522 a_17584_7166# a_17327_7285# 0.35645f
C3523 a_19240_7712# a_18793_6216# 0
C3524 sg13cmos5l_dfrbp_1_20.Q a_9366_5842# 0
C3525 a_16485_6935# sg13cmos5l_dfrbp_1_8.D 0.00526f
C3526 a_7820_9150# pl_sw[5] 0.00275f
C3527 sg13cmos5l_dlhr_1_5.Q a_9448_6924# 0
C3528 sg13cmos5l_nand2_1_1.A sg13cmos5l_dfrbp_1_7.Q_N 0.00534f
C3529 sg13cmos5l_a22oi_1_1.A1 a_16572_4261# 0.02697f
C3530 sg13cmos5l_buf_1_3.A sg13cmos5l_buf_1_0.A 0.14523f
C3531 sg13cmos5l_buf_1_101.X a_16160_9318# 0
C3532 a_18376_9224# sg13cmos5l_buf_1_107.X 0.0736f
C3533 sg13cmos5l_buf_1_34.X pl_sw[3] 0
C3534 sg13cmos5l_buf_1_8.X sg13cmos5l_buf_1_8.A 0.26684f
C3535 sg13cmos5l_buf_1_57.X a_12404_7972# 0
C3536 a_16264_9224# pl_sw[8] 0.00632f
C3537 sg13cmos5l_or2_1_0.A a_15884_3102# 0.00388f
C3538 a_2596_7996# sg13cmos5l_dfrbp_1_16.Q_N 0.00139f
C3539 a_15876_4968# a_16940_3102# 0
C3540 a_3313_4261# VPWR 0.00134f
C3541 sg13cmos5l_buf_1_44.A sg13cmos5l_buf_1_25.X 0
C3542 sg13cmos5l_dfrbp_1_20.Q a_9448_6924# 0.02532f
C3543 sg13cmos5l_buf_1_104.X a_20392_6924# 0
C3544 sg13cmos5l_dfrbp_1_23.Q sg13cmos5l_a22oi_1_1.B2 0.63001f
C3545 sg13cmos5l_dfrbp_1_6.RESET_B a_6385_2749# 0.00838f
C3546 sg13cmos5l_buf_1_76.X pl_sw[5] 0
C3547 sg13cmos5l_buf_1_5.A a_14254_2444# 0.04233f
C3548 sg13cmos5l_inv_1_7.A sg13cmos5l_dfrbp_1_0.Q 0.02916f
C3549 a_12933_6141# VPWR 0.24615f
C3550 sg13cmos5l_dfrbp_1_6.D a_17399_3947# 0.29516f
C3551 a_6219_6284# a_7216_6382# 0.06778f
C3552 a_5414_6162# a_5988_6175# 0.36169f
C3553 sg13cmos5l_buf_1_60.X a_2667_8447# 0.00103f
C3554 sg13cmos5l_buf_1_5.A a_11567_7751# 0.01083f
C3555 sg13cmos5l_nand2_1_1.B a_16011_2399# 0
C3556 sg13cmos5l_buf_1_32.A a_1192_1664# 0.01224f
C3557 a_18376_9224# sg13cmos5l_buf_1_101.X 0.01283f
C3558 sg13cmos5l_dfrbp_1_8.RESET_B a_3313_8797# 0.00561f
C3559 sg13cmos5l_buf_1_79.X sg13cmos5l_dfrbp_1_27.Q_N 0.0023f
C3560 a_2638_6162# sg13cmos5l_inv_1_19.A 0.00158f
C3561 sg13cmos5l_dfrbp_1_6.D sg13cmos5l_buf_1_56.A 0.33481f
C3562 sg13cmos5l_dfrbp_1_16.Q a_8378_5776# 0.02018f
C3563 a_1967_5773# sg13cmos5l_inv_1_19.A 0.03862f
C3564 a_8488_9224# a_7524_7992# 0
C3565 a_13391_9263# pl_sw[8] 0
C3566 sg13cmos5l_dlhr_1_9.D a_9366_5842# 0.00206f
C3567 sg13cmos5l_buf_1_24.A sg13cmos5l_a221oi_1_0.A2 0
C3568 a_17674_3361# VPWR 0.11066f
C3569 sg13cmos5l_or2_1_1.B a_13076_5376# 0.28822f
C3570 sg13cmos5l_dfrbp_1_6.RESET_B a_7666_8874# 0
C3571 a_7941_7653# a_7796_6460# 0
C3572 sg13cmos5l_inv_1_7.A a_12896_3270# 0
C3573 sg13cmos5l_dfrbp_1_6.RESET_B sg13cmos5l_dlhr_1_4.Q_N 0.00446f
C3574 sg13cmos5l_dlhr_1_0.GATE a_6315_3911# 0.01328f
C3575 sg13cmos5l_inv_1_8.A a_7216_6382# 0
C3576 a_2340_3456# sg13cmos5l_buf_1_37.A 0.00114f
C3577 a_2757_3117# a_2824_2388# 0.01066f
C3578 sg13cmos5l_dfrbp_1_6.RESET_B a_4041_2745# 0.45084f
C3579 a_682_5380# sg13cmos5l_inv_1_8.Y 0.00125f
C3580 sg13cmos5l_dfrbp_1_1.Q a_9823_2364# 0
C3581 a_14295_7282# sg13cmos5l_dfrbp_1_23.Q_N 0
C3582 sg13cmos5l_dfrbp_1_23.Q a_12804_6175# 0
C3583 sg13cmos5l_dfrbp_1_0.RESET_B sg13cmos5l_buf_1_7.A 0.03652f
C3584 sg13cmos5l_buf_1_110.A a_14602_8404# 0
C3585 a_13161_7281# sg13cmos5l_inv_1_0.A 0
C3586 a_7941_7653# a_8783_7751# 0.00437f
C3587 a_13484_8400# sg13cmos5l_dlhr_1_11.Q 0.32674f
C3588 a_7524_7992# a_9040_7894# 0.00294f
C3589 sg13cmos5l_dfrbp_1_22.D sg13cmos5l_dfrbp_1_21.Q 0
C3590 sg13cmos5l_dfrbp_1_6.RESET_B a_7631_4727# 0.00395f
C3591 sg13cmos5l_dfrbp_1_1.D a_9832_1664# 0.04599f
C3592 a_15492_2392# nh_sw[8] 0.01046f
C3593 sg13cmos5l_dfrbp_1_11.Q a_8022_3120# 0
C3594 sg13cmos5l_a22oi_1_1.B2 a_14814_4292# 0.00126f
C3595 a_18219_3260# sg13cmos5l_buf_1_19.X 0.00137f
C3596 sg13cmos5l_inv_1_18.A a_8972_3864# 0.00683f
C3597 sg13cmos5l_nand2_1_0.A a_12719_2749# 0.00854f
C3598 a_15784_9224# a_16264_9224# 0.00377f
C3599 sg13cmos5l_o21ai_1_0.A1 a_11434_2356# 0
C3600 a_20288_7010# sg13cmos5l_dlhr_1_16.Q 0
C3601 sg13cmos5l_dfrbp_1_0.Q a_20288_2474# 0
C3602 sg13cmos5l_dfrbp_1_6.RESET_B a_2340_3456# 0.49662f
C3603 sg13cmos5l_buf_1_31.X a_1864_1664# 0
C3604 sg13cmos5l_dlhr_1_0.D sg13cmos5l_buf_1_30.X 0.8581f
C3605 sg13cmos5l_buf_1_31.X a_7055_4261# 0
C3606 sg13cmos5l_inv_1_28.Y sg13cmos5l_inv_1_29.A 0.00148f
C3607 sg13cmos5l_dfrbp_1_22.D sg13cmos5l_dlhr_1_15.Q 0.00247f
C3608 sg13cmos5l_dfrbp_1_27.Q_N sg13cmos5l_buf_1_96.A 0
C3609 sg13cmos5l_buf_1_97.A a_10596_7687# 0
C3610 sg13cmos5l_dfrbp_1_16.Q a_3962_7288# 0.00111f
C3611 sg13cmos5l_dlhr_1_0.D a_8680_1664# 0.00633f
C3612 sg13cmos5l_buf_1_56.A a_10024_5498# 0
C3613 sg13cmos5l_nor2_1_1.A nh_sw[7] 0.55478f
C3614 sg13cmos5l_dlhr_1_9.D a_1967_5773# 0.00331f
C3615 a_11372_3102# VPWR 0.26065f
C3616 a_10202_7288# sg13cmos5l_a22oi_1_2.B2 0
C3617 sg13cmos5l_buf_1_60.X sg13cmos5l_buf_1_76.X 0
C3618 a_8660_5412# sg13cmos5l_a221oi_1_1.C1 0
C3619 sg13cmos5l_buf_1_77.A sg13cmos5l_dlhr_1_15.D 0
C3620 sg13cmos5l_nor2_1_1.A a_18376_2388# 0
C3621 sg13cmos5l_dfrbp_1_6.RESET_B ph_sw[8] 0
C3622 sg13cmos5l_inv_1_3.A sg13cmos5l_and3_1_0.C 0.02367f
C3623 sg13cmos5l_buf_1_44.X a_4934_2826# 0
C3624 a_18486_8866# sg13cmos5l_dlhr_1_12.Q_N 0.12876f
C3625 sg13cmos5l_dlhr_1_2.Q VPWR 0.36408f
C3626 sg13cmos5l_dfrbp_1_6.D a_4172_1590# 0
C3627 sg13cmos5l_dlhr_1_5.GATE a_7994_7288# 0.01121f
C3628 sg13cmos5l_nor2b_1_0.Y a_12120_3456# 0
C3629 sg13cmos5l_dlhr_1_9.Q a_4034_7660# 0.00237f
C3630 sg13cmos5l_dfrbp_1_6.RESET_B a_2934_4632# 0.00828f
C3631 sg13cmos5l_inv_1_8.Y ckc 0.02863f
C3632 a_5508_2813# VPWR 0.00787f
C3633 sg13cmos5l_dlhr_1_21.Q_N a_11272_8522# 0
C3634 sg13cmos5l_dfrbp_1_8.RESET_B a_12232_8436# 0.02567f
C3635 a_5820_5773# a_6346_4873# 0
C3636 sg13cmos5l_a22oi_1_0.Y sg13cmos5l_dfrbp_1_0.RESET_B 0
C3637 sg13cmos5l_dfrbp_1_8.RESET_B sg13cmos5l_buf_1_41.A 0.07121f
C3638 sg13cmos5l_dfrbp_1_6.D a_17776_6382# 0.01101f
C3639 sg13cmos5l_buf_1_24.A a_6697_3192# 0.04522f
C3640 a_12616_5498# VPWR 0.12261f
C3641 a_11817_2435# sg13cmos5l_buf_1_8.A 0
C3642 sg13cmos5l_a22oi_1_1.A1 a_16011_2399# 0
C3643 sg13cmos5l_inv_1_8.A a_2831_7630# 0
C3644 a_1760_9318# sg13cmos5l_dlhr_1_8.Q_N 0
C3645 sg13cmos5l_inv_1_8.A a_5796_3904# 0.00561f
C3646 sg13cmos5l_buf_1_57.X a_12230_6162# 0.30662f
C3647 a_10230_4632# VPWR 0.25004f
C3648 sg13cmos5l_dfrbp_1_21.Q sg13cmos5l_and3_1_0.X 0.03137f
C3649 sg13cmos5l_buf_1_90.X a_13391_9263# 0.00137f
C3650 a_4324_7996# sg13cmos5l_dlhr_1_9.D 0
C3651 sg13cmos5l_inv_1_26.Y cko 0
C3652 a_18164_6924# sg13cmos5l_dfrbp_1_22.Q_N 0.25039f
C3653 a_17327_7285# sg13cmos5l_dfrbp_1_8.D 0.00164f
C3654 sg13cmos5l_buf_1_18.A a_19593_6162# 0.00356f
C3655 sg13cmos5l_nor2b_1_0.Y a_10783_4292# 0
C3656 a_5600_8522# VPWR 0.08167f
C3657 sg13cmos5l_buf_1_63.X sg13cmos5l_buf_1_61.X 0.00684f
C3658 sg13cmos5l_nor2_1_0.A sg13cmos5l_dfrbp_1_4.D 0.00453f
C3659 a_6198_3120# sg13cmos5l_buf_1_24.X 0
C3660 a_3505_3215# a_3496_1758# 0
C3661 sg13cmos5l_buf_1_44.X a_4244_3900# 0.00579f
C3662 sg13cmos5l_or2_1_0.A a_15492_2392# 0
C3663 a_4873_3192# VPWR 0.42341f
C3664 sg13cmos5l_dfrbp_1_16.Q a_10420_5760# 0.00106f
C3665 sg13cmos5l_nor2_1_1.A a_15357_1816# 0.32658f
C3666 cks sg13cmos5l_buf_1_62.X 0
C3667 sg13cmos5l_dfrbp_1_8.RESET_B a_17233_7285# 0
C3668 sg13cmos5l_a22oi_1_1.A1 a_16703_3871# 0.01302f
C3669 a_14543_3215# a_14745_3453# 0.00675f
C3670 a_13803_3260# a_14449_3215# 0.00667f
C3671 sg13cmos5l_dfrbp_1_6.RESET_B sg13cmos5l_inv_1_7.A 0.04433f
C3672 sg13cmos5l_dlhr_1_15.D a_13034_5412# 0.00101f
C3673 sg13cmos5l_buf_1_33.A a_2732_1590# 0.01332f
C3674 sg13cmos5l_inv_1_3.A a_14295_7282# 0.00282f
C3675 nh_sw[0] comp_p 0
C3676 a_10282_7897# cks 0.0045f
C3677 VPWR nh_sw[5] 0.32216f
C3678 nl_sw[6] nh_sw[6] 0.0956f
C3679 sg13cmos5l_or2_1_0.A a_16572_4261# 0.00585f
C3680 a_15208_6200# VPWR 0.25636f
C3681 a_18574_5028# sg13cmos5l_a22oi_1_1.A1 0
C3682 a_6346_4873# VPWR 0.09572f
C3683 sg13cmos5l_inv_1_2.A a_15684_4650# 0
C3684 sg13cmos5l_buf_1_60.X sg13cmos5l_dfrbp_1_17.Q_N 0.00147f
C3685 sg13cmos5l_inv_1_1.A ph_sw[8] 0
C3686 sg13cmos5l_buf_1_5.A sg13cmos5l_dlhr_1_11.D 0.04361f
C3687 sg13cmos5l_inv_1_3.A sg13cmos5l_nor2_1_0.A 0
C3688 sg13cmos5l_buf_1_38.A nh_sw[2] 0.00446f
C3689 sg13cmos5l_buf_1_44.X cks 0.18437f
C3690 a_12516_6480# sg13cmos5l_and3_1_0.C 0
C3691 a_12933_6141# a_12814_4692# 0
C3692 sg13cmos5l_dfrbp_1_6.D a_4107_4772# 0
C3693 sg13cmos5l_dfrbp_1_8.RESET_B a_14708_6924# 0
C3694 a_650_3900# VPWR 0.00846f
C3695 a_18057_3529# VPWR 0
C3696 sg13cmos5l_dfrbp_1_6.RESET_B a_9189_8447# 0
C3697 a_2732_9150# sg13cmos5l_dfrbp_1_6.RESET_B 0
C3698 sg13cmos5l_or2_1_1.B sg13cmos5l_and3_1_0.X 0.0801f
C3699 a_9673_9240# a_9291_8447# 0.00626f
C3700 a_9879_9202# a_10288_8678# 0.00159f
C3701 sg13cmos5l_buf_1_86.A a_20392_7712# 0.03707f
C3702 sg13cmos5l_buf_8_0.X ph_sw[10] 0.32283f
C3703 sg13cmos5l_dfrbp_1_6.RESET_B a_18999_6178# 0.01895f
C3704 sg13cmos5l_or2_1_1.B sg13cmos5l_inv_1_0.Y 0
C3705 a_2348_7624# a_2621_7636# 0.15652f
C3706 a_1846_7850# sg13cmos5l_dlhr_1_8.Q_N 0.12876f
C3707 sg13cmos5l_dlygate4sd3_1_0.X VPWR 0.40507f
C3708 a_16177_7751# sg13cmos5l_buf_1_4.A 0
C3709 a_620_2352# nl_sw[0] 0.28823f
C3710 a_5510_4338# a_5770_3868# 0.87117f
C3711 sg13cmos5l_dfrbp_1_1.Q a_12719_2749# 0.00691f
C3712 sg13cmos5l_and3_1_0.C cks 0
C3713 a_1760_9318# sg13cmos5l_inv_1_19.A 0.05991f
C3714 sg13cmos5l_buf_1_110.A a_16144_8678# 0.00472f
C3715 a_13072_4142# a_12815_4261# 0.35645f
C3716 sg13cmos5l_dfrbp_1_0.RESET_B a_13556_2388# 0
C3717 sg13cmos5l_buf_1_9.A a_11556_1944# 0.00958f
C3718 sg13cmos5l_dlhr_1_1.GATE a_1402_3864# 0.01517f
C3719 sg13cmos5l_buf_1_65.X ph_sw[4] 0.00729f
C3720 a_422_5850# sg13cmos5l_nand2_1_2.B 0
C3721 a_17931_1748# nh_sw[9] 0
C3722 a_708_5416# sg13cmos5l_inv_1_9.Y 0
C3723 a_8783_7751# a_9040_7894# 0.35645f
C3724 a_8043_7796# a_8689_7751# 0.00667f
C3725 sg13cmos5l_dfrbp_1_6.RESET_B sg13cmos5l_dfrbp_1_11.Q_N 0.00144f
C3726 sg13cmos5l_dfrbp_1_11.Q sg13cmos5l_dlhr_1_2.Q 0.0021f
C3727 a_16011_2399# nh_sw[8] 0.01512f
C3728 sg13cmos5l_dfrbp_1_6.RESET_B sg13cmos5l_dlhr_1_13.Q_N 0.00265f
C3729 sg13cmos5l_nand2_1_0.A sg13cmos5l_nor2_1_1.A 0.3048f
C3730 a_17780_8436# a_17327_7285# 0.00154f
C3731 sg13cmos5l_o21ai_1_0.A1 a_11748_2813# 0
C3732 a_20008_3900# sg13cmos5l_buf_1_0.X 0.00111f
C3733 sg13cmos5l_nand2_1_1.B a_14924_1590# 0.06593f
C3734 sg13cmos5l_inv_1_18.A a_9456_4972# 0
C3735 sg13cmos5l_dlhr_1_1.GATE a_1609_4704# 0.04528f
C3736 sg13cmos5l_inv_1_14.A sg13cmos5l_dlhr_1_2.Q_N 0.00526f
C3737 sg13cmos5l_dfrbp_1_6.RESET_B a_4436_3436# 0
C3738 a_5684_4948# sg13cmos5l_buf_1_44.A 0.00199f
C3739 a_11270_4338# a_12075_3911# 0.11742f
C3740 a_16936_1758# nh_sw[8] 0.01107f
C3741 sg13cmos5l_buf_1_4.A sg13cmos5l_nor2b_1_1.Y 0
C3742 sg13cmos5l_dlhr_1_9.D a_6117_6141# 0
C3743 a_16677_6141# cks 0.00677f
C3744 sg13cmos5l_dfrbp_1_3.Q_N a_19508_1924# 0
C3745 a_16703_3871# nh_sw[8] 0
C3746 a_8588_2352# a_8576_1758# 0.00304f
C3747 sg13cmos5l_dlhr_1_0.D sg13cmos5l_dlhr_1_0.Q_N 0.00817f
C3748 sg13cmos5l_buf_1_98.A VPWR 0.43404f
C3749 sg13cmos5l_dfrbp_1_6.RESET_B a_2565_8447# 0.0011f
C3750 sg13cmos5l_dlhr_1_5.GATE a_8247_5770# 0.00791f
C3751 a_12516_6480# sg13cmos5l_nor2_1_0.A 0.00229f
C3752 a_9823_2780# VPWR 0
C3753 a_3609_8559# sg13cmos5l_buf_1_62.X 0
C3754 sg13cmos5l_o21ai_1_0.A1 sg13cmos5l_buf_1_8.X 0.02606f
C3755 sg13cmos5l_nand2_1_0.A a_10464_2427# 0
C3756 a_17414_3138# a_16751_2749# 0
C3757 sg13cmos5l_buf_1_57.X a_9705_4650# 0
C3758 a_4460_9150# sg13cmos5l_buf_1_60.A 0.42668f
C3759 sg13cmos5l_inv_1_9.Y a_1192_1664# 0.00125f
C3760 a_18568_7010# a_18409_5770# 0
C3761 sg13cmos5l_buf_1_3.A a_18164_7996# 0
C3762 sg13cmos5l_buf_1_105.A a_19624_8436# 0
C3763 a_14295_7282# cks 0
C3764 a_13047_7690# a_12933_6141# 0
C3765 sg13cmos5l_dlhr_1_9.Q a_4244_6924# 0.02502f
C3766 sg13cmos5l_buf_1_29.A sg13cmos5l_inv_1_29.Y 0
C3767 a_1846_7850# sg13cmos5l_inv_1_19.A 0.00161f
C3768 a_10998_9168# a_10308_7992# 0
C3769 sg13cmos5l_inv_1_28.Y a_10022_7674# 0
C3770 sg13cmos5l_dlhr_1_0.D sg13cmos5l_buf_1_24.X 0
C3771 sg13cmos5l_dfrbp_1_6.RESET_B sg13cmos5l_dfrbp_1_9.Q 0.02669f
C3772 sg13cmos5l_buf_1_34.X a_4840_1664# 0.28934f
C3773 a_8588_2352# VPWR 0.25201f
C3774 sg13cmos5l_buf_1_34.X a_4282_8112# 0
C3775 a_5951_5383# a_6086_4650# 0
C3776 sg13cmos5l_dfrbp_1_11.Q a_6346_4873# 0
C3777 sg13cmos5l_buf_1_65.X sg13cmos5l_buf_1_24.A 0
C3778 sg13cmos5l_inv_1_2.A a_10292_9508# 0.0105f
C3779 sg13cmos5l_inv_1_14.A sg13cmos5l_buf_1_44.A 0.00348f
C3780 sg13cmos5l_buf_1_60.X a_3976_9224# 0.00909f
C3781 sg13cmos5l_buf_1_9.A nh_sw[4] 0
C3782 a_11973_1605# nh_sw[5] 0
C3783 a_12489_9577# VPWR 0
C3784 sg13cmos5l_buf_1_44.X a_5079_3154# 0.00208f
C3785 sg13cmos5l_buf_1_24.A a_5637_2399# 0
C3786 sg13cmos5l_inv_1_2.A pl_sw[8] 0
C3787 a_14583_5770# a_14377_5770# 0.2777f
C3788 a_17498_8800# ph_sw[8] 0
C3789 sg13cmos5l_dlhr_1_11.D a_13460_7996# 0
C3790 sg13cmos5l_inv_1_8.A a_7055_4261# 0
C3791 sg13cmos5l_buf_1_57.X a_14032_6382# 0.011f
C3792 a_8247_5770# a_8593_5814# 0.00722f
C3793 a_12841_7728# cks 0.00463f
C3794 sg13cmos5l_buf_1_10.A sg13cmos5l_dlhr_1_15.D 0.02111f
C3795 sg13cmos5l_buf_8_0.A a_17700_3456# 0
C3796 a_11567_7751# ph_sw[5] -0
C3797 sg13cmos5l_buf_1_18.A a_19345_6154# 0.00168f
C3798 sg13cmos5l_dlhr_1_9.D sg13cmos5l_a22oi_1_0.B1 0
C3799 sg13cmos5l_dfrbp_1_16.Q a_9111_4666# 0
C3800 a_7153_8797# VPWR 0
C3801 sg13cmos5l_or2_1_0.A a_16011_2399# 0
C3802 a_4018_3138# VPWR 0
C3803 sg13cmos5l_dlhr_1_1.Q a_3407_4261# 0
C3804 a_6213_3911# sg13cmos5l_buf_1_25.A 0
C3805 a_14342_8874# a_14536_7806# 0
C3806 sg13cmos5l_a22oi_1_1.A1 a_18363_4270# 0.035f
C3807 sg13cmos5l_buf_1_34.A a_5324_1590# 0
C3808 sg13cmos5l_buf_1_5.X a_14449_3215# 0.0035f
C3809 a_3860_2388# VPWR 0.1116f
C3810 sg13cmos5l_dlhr_1_5.GATE a_7498_7897# 0
C3811 sg13cmos5l_dlhr_1_15.D a_15702_5842# 0.00513f
C3812 sg13cmos5l_buf_1_4.A sg13cmos5l_a22oi_1_1.B1 0
C3813 sg13cmos5l_buf_1_33.A nl_sw[2] 0.81624f
C3814 sg13cmos5l_buf_1_77.A sg13cmos5l_dlhr_1_6.D 0.08328f
C3815 sg13cmos5l_buf_1_45.X a_8570_6172# 0.00417f
C3816 sg13cmos5l_buf_1_19.A sg13cmos5l_dfrbp_1_0.CLK 0.4547f
C3817 a_3578_2752# nh_sw[2] 0
C3818 sg13cmos5l_buf_1_77.A a_8412_7326# 0
C3819 pl_sw[2] ph_sw[3] 0
C3820 sg13cmos5l_or2_1_0.A a_16703_3871# 0.00276f
C3821 a_20672_6294# ph_sw[10] 0
C3822 a_6180_4650# VPWR 0
C3823 a_11464_9224# a_11846_9186# 0
C3824 sg13cmos5l_inv_1_8.Y a_1210_4654# 0
C3825 a_8457_7281# sg13cmos5l_dlhr_1_6.D 0
C3826 sg13cmos5l_inv_1_0.A sg13cmos5l_nand2_1_0.A 0.19049f
C3827 sg13cmos5l_dlhr_1_0.GATE a_7249_3130# 0
C3828 a_8457_7281# a_8412_7326# 0
C3829 sg13cmos5l_dfrbp_1_6.D a_5104_4870# 0.02905f
C3830 a_2054_3138# VPWR 0.96068f
C3831 sg13cmos5l_inv_1_8.Y sg13cmos5l_dlygate4sd2_1_0.A 0.66209f
C3832 sg13cmos5l_or2_1_0.A a_18574_5028# 0
C3833 sg13cmos5l_buf_1_111.A sg13cmos5l_dfrbp_1_22.D 0
C3834 sg13cmos5l_dfrbp_1_8.RESET_B sg13cmos5l_buf_1_89.A 0.00147f
C3835 sg13cmos5l_o21ai_1_0.B1 a_11877_2399# 0.01159f
C3836 sg13cmos5l_inv_1_18.A a_9544_2474# 0.00228f
C3837 sg13cmos5l_dfrbp_1_6.RESET_B a_10868_8436# 0.02124f
C3838 sg13cmos5l_dfrbp_1_6.RESET_B a_19526_6600# 0
C3839 sg13cmos5l_inv_1_2.A a_15784_9224# 0
C3840 sg13cmos5l_buf_1_95.X pl_sw[7] 0
C3841 a_19628_2352# nh_sw[9] 0.28807f
C3842 a_15850_4873# sg13cmos5l_buf_1_2.X 0
C3843 a_2621_7636# sg13cmos5l_buf_1_58.A 0
C3844 sg13cmos5l_dlhr_1_8.Q_N a_1480_7806# 0.00937f
C3845 sg13cmos5l_buf_1_32.A a_908_1590# 0.33003f
C3846 a_5796_3904# a_6022_4325# 0.00523f
C3847 a_5770_3868# a_6084_4325# 0.00659f
C3848 sg13cmos5l_dfrbp_1_1.Q sg13cmos5l_nor2_1_1.A 0.40691f
C3849 sg13cmos5l_buf_1_110.A sg13cmos5l_dfrbp_1_22.D 0.76004f
C3850 sg13cmos5l_buf_1_65.X a_1463_8511# 0
C3851 a_12815_4261# sg13cmos5l_dfrbp_1_2.Q_N 0.04107f
C3852 a_15414_7354# sg13cmos5l_buf_1_89.A 0.57319f
C3853 sg13cmos5l_dfrbp_1_6.RESET_B sg13cmos5l_buf_8_0.X 0.011f
C3854 a_11656_3176# a_11434_2356# 0
C3855 sg13cmos5l_dfrbp_1_1.D a_11556_1944# 0.0079f
C3856 sg13cmos5l_a221oi_1_0.A2 a_11182_4948# 0.00545f
C3857 sg13cmos5l_dfrbp_1_5.Q_N nh_sw[8] 0.00289f
C3858 sg13cmos5l_nor2_1_0.A a_9524_4972# 0
C3859 sg13cmos5l_dfrbp_1_6.RESET_B a_14822_6924# 0.00103f
C3860 sg13cmos5l_buf_1_34.X a_4736_5498# 0.00403f
C3861 sg13cmos5l_or2_1_0.A sg13cmos5l_buf_1_28.A 0
C3862 a_2228_4972# VPWR 0.12755f
C3863 sg13cmos5l_inv_1_26.Y a_19028_5412# 0
C3864 sg13cmos5l_buf_1_10.A sg13cmos5l_o21ai_1_0.A2 0.00104f
C3865 sg13cmos5l_dfrbp_1_23.CLK sg13cmos5l_a22oi_1_1.B1 0
C3866 a_11556_3904# a_12721_4261# 0.4858f
C3867 a_11844_4325# a_12075_3911# 0.15089f
C3868 a_11270_4338# a_11913_3947# 0.00806f
C3869 sg13cmos5l_dlhr_1_9.Q cks 0
C3870 a_7524_7992# a_7863_7282# 0
C3871 sg13cmos5l_dlhr_1_0.D a_10696_1758# 0.00239f
C3872 sg13cmos5l_dfrbp_1_23.Q a_12324_6162# 0
C3873 a_14295_7282# a_14612_6460# 0.00222f
C3874 a_14426_7288# a_13775_6239# 0
C3875 sg13cmos5l_dfrbp_1_1.Q a_10464_2427# 0
C3876 sg13cmos5l_buf_1_31.X a_9638_5088# 0
C3877 sg13cmos5l_inv_1_2.A sg13cmos5l_buf_1_90.X 2.02036f
C3878 a_3962_7288# a_3669_6320# 0
C3879 a_11054_4292# sg13cmos5l_dfrbp_1_4.D 0
C3880 sg13cmos5l_buf_1_60.X ph_sw[0] 0
C3881 sg13cmos5l_dlhr_1_11.GATE a_10725_7653# 0.39806f
C3882 a_6507_8447# ph_sw[4] 0
C3883 sg13cmos5l_dfrbp_1_22.D a_17519_6239# 0
C3884 sg13cmos5l_a22oi_1_2.B1 a_7689_1626# 0
C3885 sg13cmos5l_dfrbp_1_8.D sg13cmos5l_nand2_1_1.A 0
C3886 a_11270_4338# a_11973_3911# 0.02431f
C3887 a_17700_3456# a_18376_2388# 0
C3888 a_8660_5412# a_8592_5412# 0
C3889 a_424_8436# a_416_7806# 0
C3890 sg13cmos5l_inv_1_29.Y a_12216_5728# 0.00376f
C3891 a_19528_6924# a_19209_5769# 0
C3892 a_11272_8522# VPWR 0.1362f
C3893 sg13cmos5l_buf_1_58.A ph_sw[1] 0.00206f
C3894 a_13641_7674# a_13775_6239# 0.00151f
C3895 a_8439_6178# a_7631_4727# 0
C3896 sg13cmos5l_dfrbp_1_8.D a_16293_4629# 0.01954f
C3897 a_1480_7806# sg13cmos5l_inv_1_19.A 0.01635f
C3898 sg13cmos5l_inv_1_28.Y a_11567_7751# 0.03604f
C3899 a_18117_3117# a_18671_1703# 0
C3900 a_17700_3456# a_18928_1846# 0
C3901 a_18363_4270# a_18117_3117# 0.01659f
C3902 sg13cmos5l_dfrbp_1_8.RESET_B a_16233_5041# 0
C3903 sg13cmos5l_dfrbp_1_16.Q sg13cmos5l_dfrbp_1_10.Q 0.00185f
C3904 sg13cmos5l_buf_1_79.X a_9879_9202# 0
C3905 a_14583_5770# a_14996_5412# 0.15652f
C3906 sg13cmos5l_buf_1_24.A a_6479_2749# 0.03456f
C3907 sg13cmos5l_nand2_1_1.B sg13cmos5l_dfrbp_1_0.RESET_B 0.23438f
C3908 sg13cmos5l_dlhr_1_11.D ph_sw[5] 0
C3909 a_2248_9224# VPWR 0.267f
C3910 a_8772_8440# VPWR 0.07289f
C3911 a_17780_8436# a_17961_8793# 0.40925f
C3912 sg13cmos5l_dlhr_1_9.D sg13cmos5l_dlhr_1_20.Q_N 0.06224f
C3913 a_8439_6178# a_8988_6198# 0
C3914 a_3676_7964# a_4034_7660# 0.00566f
C3915 sg13cmos5l_dlhr_1_5.GATE a_4425_7281# 0.001f
C3916 a_15045_8447# a_15429_7653# 0.00967f
C3917 sg13cmos5l_dfrbp_1_22.D a_14166_7656# 0
C3918 a_5508_2813# sg13cmos5l_buf_1_25.X 0
C3919 sg13cmos5l_buf_1_44.X a_5266_4650# 0
C3920 a_8785_6154# sg13cmos5l_dfrbp_1_11.Q 0
C3921 sg13cmos5l_dfrbp_1_21.Q a_18793_6216# 0.11754f
C3922 sg13cmos5l_inv_1_2.A a_17161_8794# 0.0013f
C3923 sg13cmos5l_buf_1_98.A sg13cmos5l_dlhr_1_11.Q_N 0
C3924 sg13cmos5l_a22oi_1_1.Y a_17224_3270# 0.07751f
C3925 a_6507_8447# sg13cmos5l_buf_1_24.A 0.00116f
C3926 sg13cmos5l_buf_1_2.X sg13cmos5l_dfrbp_1_0.Q 0.01959f
C3927 sg13cmos5l_buf_1_31.X sg13cmos5l_a221oi_1_0.A2 0.01708f
C3928 sg13cmos5l_dlhr_1_15.D a_14928_5412# 0
C3929 a_1463_8511# pl_sw[1] 0
C3930 sg13cmos5l_inv_1_0.A sg13cmos5l_dfrbp_1_1.Q 0.00263f
C3931 sg13cmos5l_buf_1_41.A sg13cmos5l_buf_1_37.A 0
C3932 a_11370_5760# VPWR 0
C3933 sg13cmos5l_inv_1_2.A a_15062_4292# 0
C3934 sg13cmos5l_buf_1_63.A sg13cmos5l_buf_1_68.X 0
C3935 sg13cmos5l_buf_1_63.X a_616_9224# 0.00428f
C3936 sg13cmos5l_buf_1_34.A nh_sw[2] 0
C3937 a_10420_5412# sg13cmos5l_nand2_1_0.A 0
C3938 sg13cmos5l_buf_1_78.X ph_sw[2] 0
C3939 sg13cmos5l_or2_1_0.A a_18363_4270# 1.10567f
C3940 sg13cmos5l_buf_1_94.X a_15012_7992# 0
C3941 a_7537_4727# VPWR 0
C3942 a_18122_2388# VPWR 0.00795f
C3943 sg13cmos5l_dlhr_1_1.Q a_2148_3904# 0
C3944 a_18860_9150# pl_sw[8] 0
C3945 sg13cmos5l_dlhr_1_15.Q a_18793_6216# 0.00381f
C3946 sg13cmos5l_inv_1_7.A a_12361_7282# 0.00197f
C3947 sg13cmos5l_dfrbp_1_6.D a_14820_7674# 0
C3948 a_3856_3358# VPWR 0.1569f
C3949 sg13cmos5l_inv_1_17.A a_4640_3986# 0
C3950 sg13cmos5l_buf_1_24.A a_6789_4629# 0.00507f
C3951 sg13cmos5l_dfrbp_1_6.D sg13cmos5l_dlhr_1_0.GATE 0
C3952 sg13cmos5l_buf_1_64.A a_4244_8436# 0
C3953 sg13cmos5l_o21ai_1_0.B1 a_12976_2630# 0
C3954 sg13cmos5l_buf_1_3.A sg13cmos5l_buf_8_0.A 0.00303f
C3955 sg13cmos5l_buf_1_6.A a_13510_3151# 0
C3956 a_6117_6141# a_6647_5459# 0
C3957 sg13cmos5l_buf_1_60.A pl_sw[3] 0
C3958 a_12420_9199# a_12358_9199# 0
C3959 a_17896_9224# a_18272_9318# 0.03376f
C3960 a_13484_8400# pl_sw[6] 0
C3961 sg13cmos5l_dfrbp_1_6.RESET_B sg13cmos5l_buf_1_41.A 0.20359f
C3962 sg13cmos5l_inv_1_3.A a_14726_7674# 0
C3963 sg13cmos5l_buf_1_9.A sg13cmos5l_buf_1_8.A 0.16998f
C3964 sg13cmos5l_inv_1_27.Y a_12980_6924# 0.0093f
C3965 a_2148_8440# VPWR 0.09292f
C3966 a_2667_8447# sg13cmos5l_dlhr_1_1.GATE 0
C3967 a_5770_3868# a_6153_3947# 0.00337f
C3968 a_6213_3911# a_6961_4261# 0.01058f
C3969 a_7863_7282# a_7796_6460# 0.0049f
C3970 sg13cmos5l_buf_1_40.X a_1192_1664# 0.28823f
C3971 sg13cmos5l_buf_1_10.A sg13cmos5l_dlhr_1_6.D 0.06328f
C3972 sg13cmos5l_inv_1_1.A a_16160_9318# 0.06036f
C3973 sg13cmos5l_inv_1_8.A a_6741_5459# 0.00144f
C3974 a_12815_4261# a_13284_3456# 0
C3975 sg13cmos5l_dlhr_1_15.D sg13cmos5l_nor2b_1_0.Y 0.06385f
C3976 a_11656_3176# a_11748_2813# 0
C3977 a_7657_7282# a_7336_7010# 0.00794f
C3978 a_4005_4629# sg13cmos5l_dfrbp_1_10.Q 0
C3979 sg13cmos5l_dlhr_1_1.Q sg13cmos5l_or2_1_0.A 0
C3980 sg13cmos5l_buf_1_78.A a_5414_6162# 0
C3981 sg13cmos5l_dfrbp_1_6.RESET_B a_17233_7285# 0
C3982 a_416_3986# VPWR 0.07207f
C3983 sg13cmos5l_buf_1_4.X VPWR 0.34565f
C3984 sg13cmos5l_buf_1_4.X nl_sw[7] 0
C3985 a_12549_9165# a_13178_7684# 0
C3986 a_3562_4873# VPWR 0.09669f
C3987 sg13cmos5l_buf_1_34.X sg13cmos5l_buf_1_62.X 0
C3988 sg13cmos5l_inv_1_7.A a_11556_1944# 0
C3989 a_10473_9186# sg13cmos5l_dfrbp_1_8.RESET_B 0
C3990 a_682_5380# sg13cmos5l_inv_1_9.Y 0
C3991 a_17638_1639# nh_sw[8] 0
C3992 a_18409_5770# a_18480_5028# 0
C3993 sg13cmos5l_inv_1_2.A sg13cmos5l_dfrbp_1_21.Q 0.0254f
C3994 sg13cmos5l_dfrbp_1_23.CLK a_13486_5412# 0
C3995 a_15850_4873# a_16233_5041# 0.00337f
C3996 a_15876_4968# a_16293_4629# 0.48921f
C3997 a_15590_4650# a_16395_4772# 0.11742f
C3998 a_15016_9224# a_15045_8447# 0.01042f
C3999 a_15500_9150# a_14628_8440# 0
C4000 sg13cmos5l_buf_1_8.X a_11656_3176# 0.33098f
C4001 sg13cmos5l_dfrbp_1_0.RESET_B sg13cmos5l_a22oi_1_1.A1 0
C4002 a_4425_7281# a_4652_6126# 0
C4003 sg13cmos5l_inv_1_28.Y a_11752_6294# 0.00191f
C4004 sg13cmos5l_inv_1_27.Y sg13cmos5l_buf_1_57.X 0.68261f
C4005 a_18856_8436# a_18345_7674# 0
C4006 sg13cmos5l_dlhr_1_11.GATE a_12404_7972# 0.05674f
C4007 sg13cmos5l_a22oi_1_2.B1 a_10888_1664# 0.00222f
C4008 sg13cmos5l_a22oi_1_1.B2 sg13cmos5l_o21ai_1_0.B1 0.00147f
C4009 sg13cmos5l_buf_1_31.X a_6697_3192# 0.01442f
C4010 a_11973_3911# a_11844_4325# 0.01562f
C4011 a_11556_3904# sg13cmos5l_dfrbp_1_0.CLK 0.07037f
C4012 sg13cmos5l_dfrbp_1_6.RESET_B a_14708_6924# 0.14538f
C4013 a_18219_3260# sg13cmos5l_buf_1_18.X 0
C4014 a_18959_3215# a_19244_2352# 0
C4015 sg13cmos5l_dfrbp_1_6.D a_1873_5773# 0
C4016 sg13cmos5l_nor2_1_0.A sg13cmos5l_a22oi_1_2.B2 0
C4017 sg13cmos5l_buf_1_34.X sg13cmos5l_buf_1_44.X 0.4181f
C4018 a_13324_4696# a_12815_4261# 0.00628f
C4019 sg13cmos5l_buf_1_110.A a_16264_9224# 0
C4020 sg13cmos5l_inv_1_18.A a_9111_4666# 0.01914f
C4021 sg13cmos5l_inv_1_14.A a_8022_3120# 0.00938f
C4022 a_3876_4663# a_3407_4261# 0
C4023 sg13cmos5l_buf_1_31.X sg13cmos5l_buf_1_35.A 0
C4024 a_11464_9224# ph_sw[6] 0
C4025 sg13cmos5l_dfrbp_1_8.D sg13cmos5l_dfrbp_1_0.D 0.01339f
C4026 sg13cmos5l_a22oi_1_1.B1 sg13cmos5l_buf_1_8.X 0
C4027 sg13cmos5l_dfrbp_1_11.Q a_7537_4727# 0.00865f
C4028 sg13cmos5l_inv_1_5.A a_19796_3436# 0.14493f
C4029 a_2732_9150# a_3016_9318# 0.01225f
C4030 sg13cmos5l_a221oi_1_0.A2 sg13cmos5l_a221oi_1_0.C1 0.17251f
C4031 sg13cmos5l_buf_1_28.X VPWR 0.33498f
C4032 sg13cmos5l_buf_1_24.A a_5577_2435# 0
C4033 a_14929_5814# a_14996_5412# 0.0018f
C4034 sg13cmos5l_inv_1_17.A a_4034_7660# 0
C4035 sg13cmos5l_dlygate4sd2_1_0.A sg13cmos5l_buf_1_32.A 0
C4036 a_6572_1590# a_6889_1680# 0.09293f
C4037 a_14726_7674# cks 0
C4038 a_11877_2399# nl_sw[6] 0.01446f
C4039 a_10031_8797# VPWR 0.24896f
C4040 a_19344_6484# VPWR 0
C4041 sg13cmos5l_dfrbp_1_16.Q_N a_3625_7282# 0
C4042 a_3676_7964# a_4244_6924# 0
C4043 a_18486_8866# sg13cmos5l_buf_1_105.A 0.63205f
C4044 sg13cmos5l_buf_1_31.X a_2667_3911# 0
C4045 sg13cmos5l_dfrbp_1_6.RESET_B sg13cmos5l_buf_1_2.X 0.00178f
C4046 sg13cmos5l_nor2b_1_0.Y sg13cmos5l_o21ai_1_0.A2 0.06913f
C4047 a_8296_3986# sg13cmos5l_buf_1_25.A 0
C4048 a_15887_8797# a_15531_7796# 0.00842f
C4049 sg13cmos5l_inv_1_9.Y ckc 0.02258f
C4050 a_11771_5412# sg13cmos5l_dfrbp_1_0.RESET_B 0
C4051 sg13cmos5l_buf_1_97.A a_11272_8522# 0.00576f
C4052 sg13cmos5l_buf_1_90.X a_12716_8400# 0
C4053 a_16551_3987# sg13cmos5l_buf_1_4.X 0
C4054 sg13cmos5l_buf_1_58.A a_1125_5423# 0
C4055 a_5324_1590# nl_sw[3] 0.00185f
C4056 sg13cmos5l_inv_1_2.A a_16298_4338# 0
C4057 a_20008_7712# VPWR 0.25602f
C4058 sg13cmos5l_buf_1_94.X a_17108_7972# 0
C4059 sg13cmos5l_buf_1_3.A sg13cmos5l_inv_1_5.A 0.24326f
C4060 sg13cmos5l_a221oi_1_0.B1 a_13324_4696# 0
C4061 a_14640_6924# VPWR 0
C4062 sg13cmos5l_dfrbp_1_16.Q a_7888_4870# 0
C4063 sg13cmos5l_dfrbp_1_0.RESET_B nh_sw[8] 0.14782f
C4064 sg13cmos5l_dfrbp_1_6.D a_16177_7751# 0
C4065 a_3016_9318# a_2565_8447# 0.00161f
C4066 sg13cmos5l_o21ai_1_0.B1 a_14254_2444# 0
C4067 sg13cmos5l_buf_1_98.A a_13574_8112# 0
C4068 a_4041_2745# a_4172_1590# 0
C4069 sg13cmos5l_buf_1_77.X a_9256_9224# 0.00267f
C4070 sg13cmos5l_buf_1_97.A a_8772_8440# 0
C4071 sg13cmos5l_buf_1_101.X a_17367_8794# 0.0046f
C4072 sg13cmos5l_buf_1_90.X a_12106_9409# 0.00778f
C4073 a_11360_9318# sg13cmos5l_dfrbp_1_8.RESET_B 0
C4074 sg13cmos5l_inv_1_27.Y a_14089_7282# 0.01367f
C4075 sg13cmos5l_dfrbp_1_1.D sg13cmos5l_buf_1_8.A 0.00552f
C4076 a_4244_8436# VPWR 0.35579f
C4077 a_7052_9150# ph_sw[3] 0
C4078 sg13cmos5l_dfrbp_1_15.D a_4518_7996# 0
C4079 a_7055_4261# a_7474_4338# 0.00176f
C4080 sg13cmos5l_buf_1_5.A ph_sw[6] 0
C4081 a_17882_7684# a_17327_7285# 0.0073f
C4082 sg13cmos5l_dfrbp_1_18.Q a_7238_7674# 0
C4083 sg13cmos5l_dfrbp_1_0.CLK sg13cmos5l_dfrbp_1_0.Q 0.30138f
C4084 sg13cmos5l_dfrbp_1_1.Q a_17700_3456# 0
C4085 a_7994_7288# sg13cmos5l_dlhr_1_6.D 0.0019f
C4086 sg13cmos5l_nand2_1_1.A a_13284_3456# 0.01503f
C4087 sg13cmos5l_buf_1_96.A a_10202_7288# 0
C4088 sg13cmos5l_dfrbp_1_0.RESET_B a_18117_3117# 0.05236f
C4089 sg13cmos5l_inv_1_8.A sg13cmos5l_a221oi_1_0.A2 0
C4090 a_1227_5423# cks 0.00135f
C4091 a_15782_7362# a_16234_6385# 0
C4092 sg13cmos5l_dfrbp_1_6.RESET_B a_6188_1590# 0
C4093 a_4847_4727# sg13cmos5l_dfrbp_1_10.Q 0
C4094 sg13cmos5l_dlhr_1_5.GATE a_5600_8522# 0.07047f
C4095 a_19624_8436# VPWR 0.24872f
C4096 sg13cmos5l_dlhr_1_0.GATE a_5194_2356# 0.00192f
C4097 a_11174_2826# a_11877_2399# 0.02431f
C4098 sg13cmos5l_buf_1_32.A a_424_1664# 0
C4099 sg13cmos5l_dlhr_1_11.GATE a_12230_6162# 0
C4100 a_13391_9263# a_14166_7656# 0
C4101 a_13648_9406# a_13460_7996# 0
C4102 a_14228_9484# a_13641_7674# 0
C4103 sg13cmos5l_buf_1_86.A sg13cmos5l_buf_8_0.X 0.70392f
C4104 a_9620_7972# a_10022_7674# 0
C4105 a_11846_9186# ph_sw[5] 0.00173f
C4106 sg13cmos5l_inv_1_7.A a_13652_1924# 0
C4107 sg13cmos5l_dfrbp_1_20.Q a_7863_7282# 0
C4108 sg13cmos5l_buf_1_10.A a_11460_2392# 0.00155f
C4109 sg13cmos5l_buf_1_44.A a_5770_3868# 0.02717f
C4110 sg13cmos5l_dfrbp_1_0.CLK a_12896_3270# 0.00109f
C4111 a_1997_6126# a_1946_4660# 0.00205f
C4112 a_15876_4968# sg13cmos5l_dfrbp_1_0.D 0
C4113 a_16395_4772# a_17392_4870# 0.06778f
C4114 sg13cmos5l_inv_1_18.A sg13cmos5l_dfrbp_1_10.Q 0.02549f
C4115 sg13cmos5l_dlhr_1_5.GATE a_6346_4873# 0
C4116 a_19227_4654# VPWR 1.2268f
C4117 a_422_5850# sg13cmos5l_inv_1_8.Y 0.00109f
C4118 a_708_5416# sg13cmos5l_buf_1_43.A 0.00111f
C4119 sg13cmos5l_a221oi_1_0.C1 a_10726_5760# 0
C4120 sg13cmos5l_nor2_1_0.A a_11268_5760# 0.01004f
C4121 sg13cmos5l_buf_1_19.A a_18870_7656# 0.00409f
C4122 sg13cmos5l_a22oi_1_2.B1 a_8576_1758# 0
C4123 a_3625_7282# a_4176_6924# 0
C4124 sg13cmos5l_dfrbp_1_6.D a_5508_6162# 0
C4125 a_18746_5776# a_18960_5412# 0.01249f
C4126 a_9366_5842# a_9242_4660# 0
C4127 sg13cmos5l_dfrbp_1_8.RESET_B a_10665_7281# 0
C4128 sg13cmos5l_dfrbp_1_6.RESET_B sg13cmos5l_buf_1_89.A 0.19075f
C4129 sg13cmos5l_buf_1_30.A a_5820_5773# 0.0453f
C4130 sg13cmos5l_buf_1_31.X a_5637_2399# 0
C4131 sg13cmos5l_or2_1_0.A sg13cmos5l_dfrbp_1_0.RESET_B 0.29877f
C4132 a_2732_9150# pl_sw[2] 0.00355f
C4133 sg13cmos5l_inv_1_14.A sg13cmos5l_dlhr_1_2.Q 0.06356f
C4134 a_3876_4663# sg13cmos5l_buf_1_38.A 0
C4135 sg13cmos5l_dfrbp_1_8.RESET_B a_17367_8794# 0
C4136 a_3676_7964# cks 0
C4137 a_10288_8678# a_10282_7897# 0.00546f
C4138 a_9291_8447# sg13cmos5l_buf_1_57.X 0.00115f
C4139 sg13cmos5l_a22oi_1_1.B2 a_16164_4663# 0
C4140 sg13cmos5l_buf_1_30.A a_8576_1758# 0.05939f
C4141 a_5684_4948# a_6346_4873# 0.00293f
C4142 sg13cmos5l_inv_1_2.A a_16234_6385# 0.00665f
C4143 a_11752_6294# sg13cmos5l_a221oi_1_0.C1 0
C4144 sg13cmos5l_buf_1_31.X a_8905_4704# 0.00436f
C4145 sg13cmos5l_inv_1_2.A a_10224_9508# 0
C4146 sg13cmos5l_dlhr_1_11.Q VPWR 0.39187f
C4147 sg13cmos5l_dlhr_1_9.D a_7863_7282# 0
C4148 a_20008_8436# sg13cmos5l_buf_1_86.A 0.28823f
C4149 sg13cmos5l_buf_1_31.X nh_sw[1] 0
C4150 sg13cmos5l_buf_1_107.X a_18870_7656# 0
C4151 a_14449_3215# nh_sw[7] 0
C4152 sg13cmos5l_inv_1_17.A a_4244_6924# 0
C4153 a_15177_5769# sg13cmos5l_dlhr_1_19.Q_N 0.00294f
C4154 sg13cmos5l_dlhr_1_6.D sg13cmos5l_nor2b_1_0.Y 0.16539f
C4155 sg13cmos5l_dfrbp_1_20.Q sg13cmos5l_a22oi_1_0.Y 0
C4156 sg13cmos5l_a22oi_1_2.B1 VPWR 0.21651f
C4157 sg13cmos5l_dfrbp_1_8.RESET_B a_4950_5699# 0.00885f
C4158 sg13cmos5l_o21ai_1_0.A1 sg13cmos5l_buf_1_9.A 0.00483f
C4159 sg13cmos5l_a22oi_1_0.B1 a_10464_2427# 0.00191f
C4160 a_8392_3270# sg13cmos5l_buf_1_25.A 0
C4161 a_7095_1642# a_7226_1636# 0.65127f
C4162 a_16528_7894# cks 0.03228f
C4163 sg13cmos5l_buf_1_57.X a_16068_6928# 0
C4164 a_9879_9202# a_9673_9240# 0.27532f
C4165 a_12976_2630# nl_sw[6] 0
C4166 a_11848_8436# VPWR 0.25241f
C4167 sg13cmos5l_buf_1_63.A a_1463_8741# 0.0394f
C4168 a_1196_8400# a_1862_8874# 0
C4169 a_20488_6294# VPWR 0.12228f
C4170 sg13cmos5l_buf_1_101.X a_18870_7656# 0
C4171 a_18860_9150# sg13cmos5l_dlhr_1_15.Q 0
C4172 a_2348_7624# sg13cmos5l_buf_1_61.X 0
C4173 sg13cmos5l_buf_1_30.A VPWR 0.77021f
C4174 sg13cmos5l_inv_1_20.Y sg13cmos5l_dfrbp_1_16.Q 0.05936f
C4175 a_3407_8797# sg13cmos5l_buf_1_62.X 0
C4176 sg13cmos5l_buf_1_34.X sg13cmos5l_dlhr_1_9.Q 0.17589f
C4177 a_19424_7010# a_19130_6172# 0
C4178 sg13cmos5l_dfrbp_1_8.RESET_B sg13cmos5l_buf_1_2.A 0.00216f
C4179 sg13cmos5l_buf_1_60.X sg13cmos5l_buf_1_64.A 0.00848f
C4180 a_2565_8447# pl_sw[2] 0
C4181 sg13cmos5l_inv_1_14.A a_6346_4873# 0.01861f
C4182 sg13cmos5l_inv_1_2.A a_17493_3947# 0
C4183 sg13cmos5l_a22oi_1_1.B2 a_14714_5776# 0.05421f
C4184 sg13cmos5l_inv_1_17.A a_4934_2826# 0
C4185 sg13cmos5l_buf_1_2.X a_15206_2826# 0.03173f
C4186 VPWR comp_p 0.09903f
C4187 a_18164_6924# VPWR 0.35485f
C4188 nh_sw[2] nl_sw[3] 0.75823f
C4189 nl_sw[2] nh_sw[3] 0
C4190 sg13cmos5l_inv_1_1.A sg13cmos5l_buf_1_89.A 0.14308f
C4191 sg13cmos5l_buf_1_110.A a_15782_7362# 0.04717f
C4192 sg13cmos5l_buf_1_77.X a_10473_9186# 0
C4193 sg13cmos5l_dlhr_1_9.D sg13cmos5l_a22oi_1_0.Y 0
C4194 sg13cmos5l_dfrbp_1_16.Q sg13cmos5l_dfrbp_1_12.Q_N 0
C4195 sg13cmos5l_buf_1_65.X a_4349_7636# 0
C4196 sg13cmos5l_inv_1_0.Y a_11394_4948# 0
C4197 a_10587_4692# sg13cmos5l_o21ai_1_0.A1 0.00102f
C4198 sg13cmos5l_buf_1_77.A a_8378_5776# 0
C4199 sg13cmos5l_buf_1_45.X a_8660_5412# 0.00707f
C4200 a_9832_1664# nl_sw[5] 0.00571f
C4201 sg13cmos5l_dfrbp_1_24.Q_N pl_sw[7] 0
C4202 a_5220_2392# sg13cmos5l_buf_1_39.A 0.00367f
C4203 sg13cmos5l_nor2b_1_0.Y a_13698_5412# 0.00207f
C4204 sg13cmos5l_dfrbp_1_6.D a_5604_4338# 0
C4205 sg13cmos5l_dlhr_1_6.D a_8247_5770# 0.01022f
C4206 sg13cmos5l_buf_1_97.A a_10031_8797# 0.00966f
C4207 a_15821_3864# a_16268_3102# 0.0027f
C4208 sg13cmos5l_dlhr_1_11.Q a_12698_7288# 0
C4209 a_8457_7281# a_8378_5776# 0
C4210 a_8841_5769# sg13cmos5l_or2_1_0.A 0
C4211 sg13cmos5l_dfrbp_1_6.RESET_B sg13cmos5l_dfrbp_1_0.CLK 0
C4212 a_11072_5347# sg13cmos5l_dfrbp_1_0.RESET_B 0
C4213 a_7336_9224# ph_sw[4] 0
C4214 a_18345_7674# sg13cmos5l_dfrbp_1_8.D 0
C4215 sg13cmos5l_inv_1_8.A a_2667_3911# 0.02317f
C4216 a_3212_1590# nh_sw[1] 0.0103f
C4217 a_14194_6162# sg13cmos5l_a22oi_1_1.B2 0
C4218 sg13cmos5l_inv_1_9.Y a_1210_4654# 0
C4219 sg13cmos5l_inv_1_28.Y a_11846_9186# 0.00655f
C4220 sg13cmos5l_nor2_1_0.A a_10220_3102# 0.00224f
C4221 sg13cmos5l_dfrbp_1_1.Q a_19796_3436# 0.00177f
C4222 sg13cmos5l_inv_1_7.A sg13cmos5l_buf_1_8.A 0.09269f
C4223 sg13cmos5l_inv_1_0.A sg13cmos5l_a22oi_1_0.B1 0.15648f
C4224 a_12716_8400# a_12567_7282# 0.00248f
C4225 sg13cmos5l_buf_1_96.A sg13cmos5l_dlhr_1_18.Q_N 0.05668f
C4226 sg13cmos5l_nand2_1_1.A a_15380_3436# 0.13612f
C4227 a_14889_7281# sg13cmos5l_dfrbp_1_21.Q 0
C4228 a_1065_5459# cks 0
C4229 a_16485_6935# a_16677_6141# 0
C4230 sg13cmos5l_inv_1_17.A a_4244_3900# 0.01176f
C4231 sg13cmos5l_dfrbp_1_6.RESET_B a_7095_1642# 0
C4232 sg13cmos5l_inv_1_8.Y sg13cmos5l_nand2_1_2.B 0.59444f
C4233 sg13cmos5l_inv_1_9.Y sg13cmos5l_dlygate4sd2_1_0.A 0.90341f
C4234 sg13cmos5l_inv_1_1.A a_17916_8838# 0
C4235 sg13cmos5l_dlhr_1_0.GATE a_5739_2399# 0.03061f
C4236 a_12998_3138# a_13803_3260# 0.11742f
C4237 a_12075_3911# a_13017_4023# 0
C4238 a_13284_3456# a_13701_3117# 0.48921f
C4239 a_11434_2356# a_11748_2813# 0.00659f
C4240 a_11460_2392# a_11686_2813# 0.00523f
C4241 sg13cmos5l_inv_1_27.Y sg13cmos5l_dlhr_1_14.Q_N 0.00383f
C4242 a_20392_3900# VPWR 0.25062f
C4243 sg13cmos5l_inv_1_2.A sg13cmos5l_buf_1_110.A 0.15344f
C4244 a_7238_7674# cks 0.00424f
C4245 sg13cmos5l_a221oi_1_0.C1 a_10318_5412# 0.02815f
C4246 sg13cmos5l_buf_1_10.A a_11979_2399# 0
C4247 sg13cmos5l_dfrbp_1_0.CLK a_14543_3215# 0.02434f
C4248 sg13cmos5l_buf_1_18.X a_16953_2511# 0
C4249 sg13cmos5l_a221oi_1_0.C1 a_8905_4704# 0
C4250 a_2879_6432# a_2934_4632# 0
C4251 a_17972_4948# sg13cmos5l_dfrbp_1_0.D 0.00266f
C4252 sg13cmos5l_buf_1_45.X sg13cmos5l_buf_1_26.X 0
C4253 a_15592_6200# sg13cmos5l_buf_1_4.A 0.28859f
C4254 sg13cmos5l_inv_1_17.A cks 0.02226f
C4255 sg13cmos5l_buf_1_30.A a_8233_6216# 0
C4256 sg13cmos5l_buf_1_8.X a_11434_2356# 0.00715f
C4257 a_4425_7281# a_4358_6924# 0
C4258 sg13cmos5l_a22oi_1_2.B1 a_11973_1605# 0
C4259 sg13cmos5l_dlhr_1_16.Q sg13cmos5l_dlhr_1_16.Q_N 0.03562f
C4260 a_19345_6154# sg13cmos5l_buf_8_0.A 0
C4261 sg13cmos5l_a221oi_1_0.A2 sg13cmos5l_nand2_1_0.B 0.08831f
C4262 VPWR pl_sw[5] 0.27028f
C4263 sg13cmos5l_dfrbp_1_6.D a_8982_7354# 0.00322f
C4264 sg13cmos5l_buf_1_30.A sg13cmos5l_dfrbp_1_11.Q 2.05983f
C4265 sg13cmos5l_dlhr_1_9.D a_5710_5535# 0
C4266 sg13cmos5l_buf_1_3.A sg13cmos5l_dfrbp_1_1.Q 0.20683f
C4267 a_16268_3102# VPWR 0.25891f
C4268 a_20288_2474# a_20296_1664# 0
C4269 a_20392_3176# nh_sw[10] 0.28822f
C4270 sg13cmos5l_buf_1_31.X a_6479_2749# 0
C4271 sg13cmos5l_dfrbp_1_8.D a_16572_4261# 0.00444f
C4272 a_9879_9202# a_10428_9222# 0
C4273 sg13cmos5l_dlhr_1_21.Q_N pl_sw[6] 0.00166f
C4274 sg13cmos5l_dlhr_1_15.D a_12933_6141# 0
C4275 sg13cmos5l_inv_1_14.A a_8588_2352# 0
C4276 sg13cmos5l_dlhr_1_0.GATE a_6086_4650# 0.35871f
C4277 sg13cmos5l_dfrbp_1_8.RESET_B sg13cmos5l_dfrbp_1_6.Q_N 0.00242f
C4278 sg13cmos5l_buf_1_2.A a_15850_4873# 0
C4279 sg13cmos5l_dlhr_1_5.GATE a_8785_6154# 0
C4280 a_17961_8793# a_17882_7684# 0
C4281 sg13cmos5l_buf_1_30.X a_7689_1626# 0
C4282 a_13652_3900# VPWR 0.35827f
C4283 sg13cmos5l_buf_1_31.X a_5492_3460# 0.00511f
C4284 a_18615_5770# a_18409_5770# 0.27787f
C4285 sg13cmos5l_dfrbp_1_8.RESET_B a_5710_5850# 0.00393f
C4286 sg13cmos5l_inv_1_14.A a_7153_8797# 0.00797f
C4287 sg13cmos5l_buf_1_31.X a_3447_2746# 0
C4288 a_10473_9186# sg13cmos5l_dfrbp_1_6.RESET_B 0.45337f
C4289 sg13cmos5l_buf_1_65.X a_8043_7796# 0
C4290 sg13cmos5l_buf_1_77.A a_10420_5760# 0
C4291 sg13cmos5l_buf_1_10.A a_13486_5760# 0
C4292 sg13cmos5l_buf_1_65.X sg13cmos5l_inv_1_8.A 0.01043f
C4293 sg13cmos5l_buf_1_58.A sg13cmos5l_buf_1_61.X 0
C4294 sg13cmos5l_buf_1_19.A a_17412_1944# 0
C4295 sg13cmos5l_dfrbp_1_22.D a_15238_7687# 0
C4296 a_11270_4338# VPWR 0.93992f
C4297 sg13cmos5l_buf_1_31.X a_6789_4629# 0
C4298 sg13cmos5l_nor2b_1_0.Y a_11460_2392# 0
C4299 sg13cmos5l_buf_1_25.A nh_sw[3] 0.00123f
C4300 sg13cmos5l_nand2_1_1.A sg13cmos5l_buf_1_19.X 0
C4301 sg13cmos5l_a22oi_1_1.B2 a_15177_5769# 0.00522f
C4302 sg13cmos5l_buf_1_31.X a_1158_3142# 0.00314f
C4303 sg13cmos5l_dfrbp_1_2.D sg13cmos5l_dfrbp_1_0.RESET_B 0.12963f
C4304 ph_sw[7] ph_sw[8] 0.46911f
C4305 sg13cmos5l_dfrbp_1_6.RESET_B a_8390_6924# 0
C4306 a_7034_3148# sg13cmos5l_buf_1_25.A 0.00795f
C4307 a_5704_1664# VPWR 0.25379f
C4308 sg13cmos5l_inv_1_2.A a_14166_7656# 0
C4309 sg13cmos5l_dfrbp_1_9.Q a_4107_4772# 0.00185f
C4310 a_3562_4873# a_3945_5041# 0.00337f
C4311 sg13cmos5l_inv_1_18.A a_9268_6148# 0
C4312 sg13cmos5l_inv_1_8.A a_8905_4704# 0
C4313 sg13cmos5l_buf_1_60.X VPWR 0.29283f
C4314 a_14583_5770# sg13cmos5l_nand2_1_1.B 0
C4315 sg13cmos5l_buf_1_58.A a_708_5416# 0
C4316 sg13cmos5l_dlhr_1_9.D sg13cmos5l_buf_1_46.A 0.00645f
C4317 sg13cmos5l_buf_8_0.X a_20288_7010# 0
C4318 sg13cmos5l_inv_1_8.A a_5962_8404# 0.03472f
C4319 sg13cmos5l_dlhr_1_11.GATE a_12549_9165# 0
C4320 sg13cmos5l_dfrbp_1_10.Q sg13cmos5l_buf_1_39.A 0
C4321 sg13cmos5l_dlhr_1_16.Q d_out[1] 0
C4322 a_17519_6239# a_17938_6162# 0.00176f
C4323 sg13cmos5l_dfrbp_1_21.Q_N a_18793_6216# 0.1449f
C4324 sg13cmos5l_buf_1_97.A a_11848_8436# 0.31536f
C4325 sg13cmos5l_dfrbp_1_18.Q a_8692_7312# 0
C4326 sg13cmos5l_dlhr_1_11.Q sg13cmos5l_dlhr_1_11.Q_N 0.0038f
C4327 sg13cmos5l_dfrbp_1_6.D sg13cmos5l_buf_1_4.A 0.00142f
C4328 sg13cmos5l_buf_1_31.X a_1006_4167# 0
C4329 sg13cmos5l_inv_1_17.A a_3609_8559# 0.00178f
C4330 sg13cmos5l_buf_1_111.A a_20492_8400# 0
C4331 sg13cmos5l_nand2_1_1.A a_15466_2356# 0
C4332 sg13cmos5l_inv_1_2.A sg13cmos5l_a22oi_1_1.Y 0.00721f
C4333 sg13cmos5l_buf_1_63.X sg13cmos5l_buf_1_68.X 0
C4334 sg13cmos5l_buf_1_93.X a_15429_7653# 0
C4335 a_424_9318# a_416_7806# 0.00104f
C4336 a_10827_7796# sg13cmos5l_inv_1_29.A 0
C4337 sg13cmos5l_inv_1_8.A sg13cmos5l_dfrbp_1_9.Q_N 0.00219f
C4338 sg13cmos5l_dfrbp_1_23.Q_N a_14152_5498# 0.03166f
C4339 sg13cmos5l_dlhr_1_1.D a_2148_3904# 0
C4340 sg13cmos5l_dfrbp_1_18.Q a_8689_7751# 0.01076f
C4341 sg13cmos5l_buf_1_79.X a_10282_7897# 0
C4342 sg13cmos5l_dfrbp_1_15.D a_1873_7285# 0.00612f
C4343 sg13cmos5l_buf_1_31.X a_1815_4666# 0
C4344 sg13cmos5l_buf_1_65.X a_1948_7964# 0
C4345 a_12216_5728# a_11556_3904# 0
C4346 sg13cmos5l_dfrbp_1_15.D a_2786_7666# 0
C4347 a_7336_7010# cks 0
C4348 a_13484_8400# a_13161_7281# 0
C4349 a_17327_7285# a_16677_6141# 0
C4350 a_17584_7166# a_16779_6284# 0.00237f
C4351 sg13cmos5l_inv_1_0.A sg13cmos5l_dlhr_1_20.Q_N 0
C4352 sg13cmos5l_dfrbp_1_0.CLK a_15206_2826# 0.00597f
C4353 sg13cmos5l_dlhr_1_11.Q a_13047_7690# 0.00941f
C4354 a_13803_3260# a_14800_3358# 0.06778f
C4355 sg13cmos5l_nand2_1_1.A a_16204_4338# 0
C4356 sg13cmos5l_buf_1_34.X a_5049_4965# 0.00107f
C4357 sg13cmos5l_dlhr_1_0.GATE a_6385_2749# 0.00612f
C4358 a_11877_2399# a_12625_2749# 0.01058f
C4359 a_11434_2356# a_11817_2435# 0.00337f
C4360 sg13cmos5l_inv_1_26.Y a_18272_9318# 0.00121f
C4361 a_17896_9224# sg13cmos5l_buf_1_107.X 0.28859f
C4362 sg13cmos5l_inv_1_27.Y a_15012_7992# 0.00583f
C4363 sg13cmos5l_dfrbp_1_6.RESET_B a_9940_4636# 0.0037f
C4364 sg13cmos5l_dlhr_1_15.D a_12616_5498# 0
C4365 sg13cmos5l_inv_1_8.A a_1956_4338# 0
C4366 a_11464_9224# sg13cmos5l_dfrbp_1_8.RESET_B 0
C4367 sg13cmos5l_dfrbp_1_23.CLK a_14436_8874# 0
C4368 a_15784_9224# pl_sw[8] 0.01555f
C4369 a_18164_7996# a_18278_8112# 0.00122f
C4370 a_20492_8400# a_20392_6924# 0
C4371 sg13cmos5l_buf_1_19.A a_19424_7010# 0.0361f
C4372 sg13cmos5l_dlhr_1_15.Q a_19240_7712# 0.3142f
C4373 a_3407_8797# sg13cmos5l_dlhr_1_9.Q 0.00341f
C4374 a_16293_4629# a_16204_4338# 0.00979f
C4375 a_18480_5028# sg13cmos5l_a22oi_1_1.A1 0.00467f
C4376 sg13cmos5l_buf_1_2.A sg13cmos5l_dfrbp_1_0.Q 0.14637f
C4377 sg13cmos5l_inv_1_17.A a_2565_3911# 0
C4378 a_2879_6432# sg13cmos5l_dfrbp_1_9.Q 0.00136f
C4379 sg13cmos5l_dfrbp_1_1.Q a_14449_3215# 0
C4380 sg13cmos5l_dfrbp_1_0.CLK a_15702_4187# 0
C4381 a_2224_5654# a_1946_4660# 0
C4382 a_1967_5773# a_1609_4704# 0
C4383 sg13cmos5l_dlhr_1_0.GATE sg13cmos5l_dlhr_1_4.Q_N 0.01469f
C4384 sg13cmos5l_inv_1_26.Y a_19227_9190# 0.00609f
C4385 a_17896_9224# sg13cmos5l_buf_1_101.X 0.01307f
C4386 sg13cmos5l_buf_1_111.A a_18860_9150# 0
C4387 sg13cmos5l_buf_1_8.X a_11748_2813# 0.00153f
C4388 sg13cmos5l_dfrbp_1_0.RESET_B sg13cmos5l_dfrbp_1_7.Q_N 0.00348f
C4389 sg13cmos5l_dlhr_1_1.D sg13cmos5l_or2_1_0.A 0
C4390 a_17588_2388# nl_sw[9] 0
C4391 sg13cmos5l_buf_1_103.A a_14628_8440# 0
C4392 sg13cmos5l_buf_1_45.X a_7238_7674# 0.01493f
C4393 a_18486_8866# VPWR 0.25027f
C4394 sg13cmos5l_dlhr_1_0.GATE a_4041_2745# 0
C4395 sg13cmos5l_dfrbp_1_8.RESET_B a_13686_7354# 0
C4396 sg13cmos5l_dfrbp_1_23.CLK sg13cmos5l_dfrbp_1_6.D 0.05585f
C4397 sg13cmos5l_buf_1_87.A a_19528_6924# 0
C4398 sg13cmos5l_buf_1_107.X a_19424_7010# 0
C4399 sg13cmos5l_buf_1_60.A sg13cmos5l_buf_1_62.X 0
C4400 a_10292_9508# sg13cmos5l_buf_1_90.X 0
C4401 sg13cmos5l_dfrbp_1_6.RESET_B a_11360_9318# 0
C4402 sg13cmos5l_dfrbp_1_8.D a_16703_3871# 0.00215f
C4403 a_682_5380# sg13cmos5l_buf_1_43.A 0.00184f
C4404 sg13cmos5l_buf_1_65.X a_8972_9150# 0
C4405 a_17132_9150# a_17516_9150# 0.00492f
C4406 a_17829_1605# nl_sw[9] 0.01118f
C4407 a_11556_3904# sg13cmos5l_buf_1_6.A 0
C4408 a_15780_2813# nl_sw[8] 0
C4409 sg13cmos5l_buf_1_73.X a_7524_7992# 0
C4410 sg13cmos5l_buf_1_9.A a_11656_3176# 0.00165f
C4411 a_11372_3102# sg13cmos5l_o21ai_1_0.A2 0.00817f
C4412 a_12980_6924# a_12912_6924# 0
C4413 sg13cmos5l_dfrbp_1_8.D a_18574_5028# 0.00175f
C4414 a_13100_8400# sg13cmos5l_buf_1_5.A 0.12545f
C4415 a_8041_5770# a_8588_3864# 0
C4416 sg13cmos5l_buf_1_3.A a_19528_6924# 0.29202f
C4417 sg13cmos5l_buf_1_105.A a_18164_7996# 0.00193f
C4418 a_1864_9224# sg13cmos5l_buf_1_62.X 0.31962f
C4419 a_18746_5776# a_19028_5412# 0.68988f
C4420 sg13cmos5l_buf_1_19.A a_18760_2388# 0.32205f
C4421 sg13cmos5l_dfrbp_1_8.RESET_B ph_sw[4] 0
C4422 a_7689_1626# sg13cmos5l_dlhr_1_0.Q_N 0.00294f
C4423 a_7226_1636# a_7441_1618# 0.00284f
C4424 a_7508_1948# a_7622_2064# 0.00122f
C4425 sg13cmos5l_buf_1_65.X a_6184_9224# 0.00443f
C4426 sg13cmos5l_buf_1_60.A sg13cmos5l_buf_1_44.X 0
C4427 sg13cmos5l_and3_1_0.C a_12815_4261# 0.01559f
C4428 a_15016_9224# sg13cmos5l_buf_1_93.X 0.12678f
C4429 sg13cmos5l_inv_1_18.A sg13cmos5l_dfrbp_1_12.Q_N 0
C4430 sg13cmos5l_buf_1_77.A a_9111_4666# 0
C4431 sg13cmos5l_buf_1_57.X sg13cmos5l_dfrbp_1_8.D 0.00215f
C4432 sg13cmos5l_inv_1_28.Y ph_sw[6] 0
C4433 a_2831_7630# cks 0.00222f
C4434 a_16395_4772# VPWR 0.21063f
C4435 a_11844_4325# VPWR 0.01159f
C4436 sg13cmos5l_inv_1_7.A sg13cmos5l_o21ai_1_0.A1 0
C4437 sg13cmos5l_buf_1_31.X a_8468_4948# 0
C4438 sg13cmos5l_nor2b_1_0.Y a_11979_2399# 0
C4439 a_20672_4782# d_out[2] 0.00478f
C4440 sg13cmos5l_a221oi_1_0.A2 sg13cmos5l_a221oi_1_1.C1 0.00223f
C4441 sg13cmos5l_buf_1_60.X a_5132_9150# 0
C4442 a_13391_9263# sg13cmos5l_buf_1_95.X 0.0189f
C4443 sg13cmos5l_inv_1_3.A a_14152_5498# 0.01157f
C4444 sg13cmos5l_inv_1_14.A a_7537_4727# 0
C4445 sg13cmos5l_buf_1_43.A a_908_1590# 0.00129f
C4446 sg13cmos5l_dfrbp_1_6.RESET_B sg13cmos5l_buf_1_29.A 0.06961f
C4447 a_17399_3947# a_17595_3947# 0.00806f
C4448 sg13cmos5l_buf_1_31.X a_2859_3260# 0.03303f
C4449 sg13cmos5l_dfrbp_1_6.RESET_B a_10665_7281# 0.48267f
C4450 sg13cmos5l_dfrbp_1_8.RESET_B sg13cmos5l_buf_1_5.A 0.00651f
C4451 a_6560_3270# sg13cmos5l_buf_1_25.A 0
C4452 a_6184_9224# a_5962_8404# 0
C4453 a_5600_1758# VPWR 0.06993f
C4454 sg13cmos5l_dfrbp_1_9.Q a_5104_4870# 0
C4455 a_19136_9318# pl_sw[10] 0
C4456 sg13cmos5l_buf_1_41.A a_4172_1590# 0
C4457 sg13cmos5l_dfrbp_1_6.RESET_B a_17367_8794# 0.00268f
C4458 sg13cmos5l_dlhr_1_6.D a_12933_6141# 0.02271f
C4459 a_10412_6126# sg13cmos5l_buf_1_29.A 0.28943f
C4460 sg13cmos5l_dlhr_1_11.GATE sg13cmos5l_inv_1_27.Y 0.0044f
C4461 sg13cmos5l_inv_1_8.A a_6507_8447# 0.02023f
C4462 sg13cmos5l_buf_1_79.X a_12841_7728# 0.00132f
C4463 sg13cmos5l_buf_1_65.X a_708_6928# 0
C4464 a_10071_7282# sg13cmos5l_buf_1_29.A 0
C4465 sg13cmos5l_buf_1_43.A ckc 0.52106f
C4466 sg13cmos5l_dfrbp_1_21.Q_N a_17938_6162# 0
C4467 sg13cmos5l_dlhr_1_9.D sg13cmos5l_nand2_1_1.B 0
C4468 a_17161_8794# pl_sw[8] 0
C4469 sg13cmos5l_buf_1_34.X a_3676_7964# 0.00404f
C4470 sg13cmos5l_buf_1_5.A a_15414_7354# 0
C4471 sg13cmos5l_dfrbp_1_0.Q sg13cmos5l_dfrbp_1_1.Q_N 0
C4472 a_10071_7282# a_10665_7281# 0.09085f
C4473 a_9865_7282# a_10484_6924# 0.00161f
C4474 a_10202_7288# a_10417_7326# 0.00284f
C4475 sg13cmos5l_o21ai_1_0.A2 nh_sw[5] 0.08382f
C4476 sg13cmos5l_dfrbp_1_8.RESET_B sg13cmos5l_buf_1_24.A 0.11466f
C4477 sg13cmos5l_inv_1_18.A sg13cmos5l_inv_1_2.A 0.02667f
C4478 a_13076_5376# a_13034_5412# 0
C4479 sg13cmos5l_buf_1_18.A VPWR 0.73995f
C4480 sg13cmos5l_dlhr_1_1.D a_1672_3176# 0
C4481 sg13cmos5l_dfrbp_1_6.RESET_B a_4950_5699# 0
C4482 sg13cmos5l_inv_1_17.A a_3793_2790# 0.00119f
C4483 sg13cmos5l_dfrbp_1_20.Q a_12230_6162# 0
C4484 sg13cmos5l_dlhr_1_2.Q nl_sw[4] 0.03081f
C4485 sg13cmos5l_a221oi_1_0.B2 sg13cmos5l_o21ai_1_0.A1 0.25556f
C4486 sg13cmos5l_a221oi_1_0.B1 sg13cmos5l_and3_1_0.C 0
C4487 rdy sg13cmos5l_buf_1_61.X 0
C4488 sg13cmos5l_inv_1_8.A a_6789_4629# 0.35508f
C4489 sg13cmos5l_buf_1_110.A a_14889_7281# 0.00309f
C4490 sg13cmos5l_nor2_1_0.A a_12815_4261# 0.03592f
C4491 sg13cmos5l_dfrbp_1_15.D a_1997_6126# 0
C4492 a_18164_6924# a_18356_6460# 0
C4493 sg13cmos5l_dfrbp_1_8.D a_16779_6284# 0.02098f
C4494 sg13cmos5l_buf_8_1.A cks 0.03503f
C4495 a_1864_1664# nl_sw[1] 0.28895f
C4496 sg13cmos5l_buf_1_7.A sg13cmos5l_nor2_1_1.A 0
C4497 sg13cmos5l_dlhr_1_11.Q a_13574_8112# 0.00156f
C4498 a_7892_3900# a_7497_3138# 0.00543f
C4499 a_7055_4261# a_7316_3460# 0.01097f
C4500 a_14800_3358# sg13cmos5l_buf_1_5.X 0.03733f
C4501 a_15380_3436# a_15884_3102# 0.03266f
C4502 a_12719_2749# a_13556_2388# 0.1333f
C4503 a_12976_2630# a_12625_2749# 0.01017f
C4504 a_4566_2818# sg13cmos5l_buf_1_39.A 0.00344f
C4505 sg13cmos5l_inv_1_8.A a_1158_3142# 0
C4506 a_3241_2746# nl_sw[2] 0
C4507 sg13cmos5l_nor2b_1_0.Y a_13486_5760# 0.00158f
C4508 sg13cmos5l_dfrbp_1_6.RESET_B sg13cmos5l_buf_1_2.A 0.00793f
C4509 sg13cmos5l_buf_1_6.A sg13cmos5l_dfrbp_1_0.Q 0.56256f
C4510 sg13cmos5l_buf_1_96.A sg13cmos5l_nor2_1_0.A 0.00752f
C4511 sg13cmos5l_dfrbp_1_8.RESET_B a_16068_6162# 0
C4512 a_7994_7288# a_8378_5776# 0
C4513 a_7657_7282# sg13cmos5l_a221oi_1_0.A2 0.00146f
C4514 a_1125_5423# a_1760_3986# 0
C4515 sg13cmos5l_buf_1_45.X a_7216_6382# 0
C4516 a_8689_7751# cks 0.00114f
C4517 sg13cmos5l_inv_1_17.A a_2314_3361# 0
C4518 a_15876_4968# a_16703_3871# 0.00112f
C4519 sg13cmos5l_buf_1_29.A a_9832_1664# 0.32034f
C4520 a_10308_7992# a_10725_7653# 0.48921f
C4521 a_10022_7674# a_10827_7796# 0.11742f
C4522 a_12933_6141# a_13698_5412# 0
C4523 a_13775_6239# a_14377_5770# 0
C4524 sg13cmos5l_dfrbp_1_0.CLK a_16462_4338# 0
C4525 sg13cmos5l_buf_1_10.A a_11473_7751# 0.00267f
C4526 a_13484_8400# a_13641_7674# 0
C4527 sg13cmos5l_dlhr_1_1.D a_1946_4660# 0.00507f
C4528 a_2859_3260# a_3212_1590# 0
C4529 sg13cmos5l_inv_1_8.A a_1006_4167# 0.00839f
C4530 a_19244_2352# nl_sw[9] 0.28845f
C4531 a_10010_9196# VPWR 0.35608f
C4532 VPWR pl_sw[6] 0.38028f
C4533 a_5510_4338# a_5673_3138# 0
C4534 nl_sw[5] nh_sw[4] 0.10621f
C4535 a_15500_9150# ph_sw[6] 0.29561f
C4536 sg13cmos5l_buf_1_103.A a_15887_8797# 0
C4537 sg13cmos5l_inv_1_1.A a_17367_8794# 0
C4538 sg13cmos5l_or2_1_0.A a_18480_5028# 0.25288f
C4539 sg13cmos5l_buf_1_6.A a_12896_3270# 0.01139f
C4540 a_18164_6924# ph_sw[9] 0
C4541 a_10464_2427# a_10707_2388# 0.00104f
C4542 sg13cmos5l_inv_1_3.A sg13cmos5l_inv_1_29.A 0
C4543 sg13cmos5l_dfrbp_1_8.D a_18363_4270# 0
C4544 sg13cmos5l_buf_1_2.A a_14543_3215# 0.00368f
C4545 sg13cmos5l_inv_1_8.A a_1815_4666# 0.00804f
C4546 sg13cmos5l_buf_1_57.X a_15876_4968# 0
C4547 a_18959_3215# nl_sw[10] 0
C4548 a_5132_3864# a_5408_3986# 0.00624f
C4549 sg13cmos5l_buf_1_38.A a_6213_3911# 0
C4550 a_15429_7653# a_16042_6892# 0
C4551 a_15012_7992# a_16068_6928# 0
C4552 sg13cmos5l_dfrbp_1_0.CLK a_11556_1944# 0.07552f
C4553 a_8208_6924# VPWR 0
C4554 a_4244_8436# sg13cmos5l_dlhr_1_5.GATE 0
C4555 sg13cmos5l_buf_1_0.A VPWR 0.54791f
C4556 sg13cmos5l_a221oi_1_1.C1 a_10726_5760# 0
C4557 sg13cmos5l_nor2_1_0.A sg13cmos5l_a221oi_1_0.B1 0.9458f
C4558 a_422_5850# sg13cmos5l_inv_1_9.Y 0
C4559 sg13cmos5l_dfrbp_1_8.RESET_B a_13460_7996# 0
C4560 sg13cmos5l_dfrbp_1_8.RESET_B a_1463_8511# 0.00883f
C4561 sg13cmos5l_buf_1_8.X a_10094_2780# 0
C4562 sg13cmos5l_dfrbp_1_8.RESET_B a_3588_4968# 0.50839f
C4563 a_19209_5769# a_19734_5842# 0.13715f
C4564 a_19028_5412# a_19164_5814# 0.00404f
C4565 sg13cmos5l_dfrbp_1_0.Q d_out[0] 0
C4566 sg13cmos5l_dfrbp_1_6.D sg13cmos5l_dlhr_1_5.D 0.11715f
C4567 a_13803_3260# VPWR 0.22571f
C4568 a_8680_1664# a_8576_1758# 0.00624f
C4569 sg13cmos5l_and3_1_0.C sg13cmos5l_nand2_1_1.A 0.02277f
C4570 sg13cmos5l_dlhr_1_6.D a_12616_5498# 0
C4571 sg13cmos5l_buf_1_40.A pl_sw[0] 0
C4572 sg13cmos5l_nand2_1_1.B a_9823_2364# 0.00338f
C4573 sg13cmos5l_inv_1_1.A sg13cmos5l_buf_1_2.A 0.15672f
C4574 sg13cmos5l_dlhr_1_6.D a_10230_4632# 0
C4575 sg13cmos5l_inv_1_11.Y a_9260_2352# 0.01937f
C4576 sg13cmos5l_inv_1_29.Y sg13cmos5l_a221oi_1_0.C1 0
C4577 sg13cmos5l_dlhr_1_5.Q a_9705_4650# 0
C4578 a_12520_4782# a_12704_4782# 0.11523f
C4579 sg13cmos5l_inv_1_26.Y a_19130_6172# 0.00117f
C4580 sg13cmos5l_dfrbp_1_6.RESET_B a_12216_5728# 0.00176f
C4581 sg13cmos5l_buf_1_41.A a_2879_6432# 0.05331f
C4582 a_17367_8794# a_17751_7690# 0.00202f
C4583 sg13cmos5l_buf_1_30.X VPWR 0.3217f
C4584 sg13cmos5l_buf_1_31.X a_2628_3151# 0.00529f
C4585 sg13cmos5l_dfrbp_1_6.RESET_B a_11560_7010# 0.00639f
C4586 a_8392_3270# sg13cmos5l_buf_1_26.A 0.00355f
C4587 a_12698_7288# pl_sw[6] 0
C4588 sg13cmos5l_a22oi_1_0.Y a_10464_2427# 0
C4589 sg13cmos5l_buf_1_45.X a_5796_3904# 0
C4590 sg13cmos5l_dfrbp_1_9.Q sg13cmos5l_dlhr_1_0.GATE 0
C4591 sg13cmos5l_inv_1_17.A sg13cmos5l_buf_1_34.X 0.18914f
C4592 sg13cmos5l_buf_1_74.X a_6276_8861# 0
C4593 a_8680_1664# VPWR 0.2581f
C4594 sg13cmos5l_buf_1_25.A a_7316_2388# 0
C4595 sg13cmos5l_dfrbp_1_0.Q a_16751_2749# 0
C4596 sg13cmos5l_buf_1_63.X a_1463_8741# 0
C4597 sg13cmos5l_inv_1_0.A sg13cmos5l_buf_1_7.A 0.15884f
C4598 a_8486_8874# a_7941_7653# 0
C4599 sg13cmos5l_buf_1_111.A a_19240_7712# 0.32718f
C4600 a_1463_8511# a_1662_8374# 0.16626f
C4601 a_1196_8400# sg13cmos5l_dfrbp_1_17.D 0.01375f
C4602 sg13cmos5l_inv_1_29.A a_12516_6480# 0.00354f
C4603 sg13cmos5l_buf_1_10.A a_13076_5376# 0.00235f
C4604 sg13cmos5l_inv_1_8.A sg13cmos5l_dfrbp_1_18.Q_N 0
C4605 sg13cmos5l_or2_1_0.A a_6213_3911# 0.00826f
C4606 a_16677_6141# a_16293_4629# 0.0041f
C4607 sg13cmos5l_buf_1_31.X a_902_3142# 0.00261f
C4608 sg13cmos5l_dfrbp_1_23.CLK a_13035_6284# 0.03934f
C4609 a_10665_7281# a_10620_7326# 0
C4610 a_10202_7288# a_10416_6924# 0.01249f
C4611 a_19528_6924# a_19593_6162# 0.00156f
C4612 sg13cmos5l_dlhr_1_10.Q a_19130_6172# 0.00206f
C4613 sg13cmos5l_dfrbp_1_0.Q a_17412_1944# 0.00667f
C4614 sg13cmos5l_buf_1_5.X a_15300_2826# 0
C4615 a_15884_3102# a_15466_2356# 0
C4616 a_6198_3120# sg13cmos5l_buf_1_25.A 0.00138f
C4617 sg13cmos5l_dfrbp_1_6.RESET_B a_5710_5850# 0.01582f
C4618 a_4840_1664# a_5324_1590# 0.03472f
C4619 sg13cmos5l_buf_1_25.X a_5704_1664# 0.01726f
C4620 a_8247_5770# a_8378_5776# 0.65127f
C4621 sg13cmos5l_buf_8_1.A a_18219_3260# 0.00179f
C4622 sg13cmos5l_inv_1_29.A cks 0
C4623 sg13cmos5l_inv_1_8.A a_8468_4948# 0
C4624 a_2148_3904# sg13cmos5l_inv_1_19.A 0.01365f
C4625 a_8588_2352# nl_sw[4] 0.28823f
C4626 a_17367_8794# a_17498_8800# 0.65127f
C4627 sg13cmos5l_nor2_1_0.A sg13cmos5l_nand2_1_1.A 0
C4628 sg13cmos5l_dfrbp_1_8.D a_16548_6175# 0.00158f
C4629 sg13cmos5l_dlhr_1_9.D a_9705_4650# 0.01329f
C4630 a_1196_8400# ph_sw[0] 0
C4631 a_9879_9202# sg13cmos5l_buf_1_57.X 0.00157f
C4632 sg13cmos5l_dfrbp_1_18.Q a_10022_7674# 0.01051f
C4633 sg13cmos5l_dfrbp_1_0.CLK a_16657_2749# 0.00489f
C4634 sg13cmos5l_buf_1_2.X sg13cmos5l_buf_1_1.A 0.01489f
C4635 sg13cmos5l_inv_1_8.A a_2859_3260# 0.0012f
C4636 a_13556_2388# sg13cmos5l_nor2_1_1.A 0
C4637 sg13cmos5l_dlhr_1_5.GATE sg13cmos5l_buf_1_30.A 0.0531f
C4638 sg13cmos5l_dfrbp_1_6.D a_15592_6200# 0.00194f
C4639 a_15821_3864# sg13cmos5l_buf_1_5.X 0.0049f
C4640 sg13cmos5l_dfrbp_1_8.RESET_B a_17425_6239# 0
C4641 a_6315_3911# a_5739_2399# 0
C4642 sg13cmos5l_dfrbp_1_0.Q a_12815_1703# 0
C4643 sg13cmos5l_dfrbp_1_0.D a_17386_1849# 0.01879f
C4644 sg13cmos5l_inv_1_17.A a_3599_3215# 0.02999f
C4645 sg13cmos5l_buf_1_77.X ph_sw[4] 0.15894f
C4646 sg13cmos5l_buf_1_45.X a_8692_7312# 0
C4647 a_10725_7653# a_11824_7894# 0
C4648 a_10827_7796# a_11567_7751# 0.3087f
C4649 sg13cmos5l_dfrbp_1_0.CLK a_17931_1748# 0.02977f
C4650 sg13cmos5l_or2_1_1.B a_10789_4654# 0
C4651 sg13cmos5l_dfrbp_1_23.Q_N sg13cmos5l_a22oi_1_1.B2 0.02236f
C4652 sg13cmos5l_nor2_1_0.A sg13cmos5l_inv_1_11.Y 0
C4653 sg13cmos5l_dlhr_1_9.D sg13cmos5l_buf_1_38.A 0
C4654 sg13cmos5l_inv_1_0.A sg13cmos5l_a22oi_1_0.Y 0.33176f
C4655 sg13cmos5l_inv_1_7.A sg13cmos5l_nor2b_1_1.Y 0
C4656 sg13cmos5l_buf_1_5.A sg13cmos5l_dfrbp_1_0.Q 0.38246f
C4657 a_13100_8400# ph_sw[5] 0
C4658 sg13cmos5l_nand2_1_1.A a_14440_1664# 0
C4659 sg13cmos5l_buf_1_2.A a_15206_2826# 0.0433f
C4660 sg13cmos5l_inv_1_9.Y sg13cmos5l_nand2_1_2.B 0.01395f
C4661 sg13cmos5l_buf_1_43.A sg13cmos5l_dlygate4sd2_1_0.A 0.00933f
C4662 sg13cmos5l_dfrbp_1_0.D a_18368_4782# 0.06527f
C4663 sg13cmos5l_buf_1_110.A a_16089_8559# 0.00157f
C4664 sg13cmos5l_buf_1_6.A a_14543_3215# 0
C4665 sg13cmos5l_or2_1_0.A sg13cmos5l_inv_1_19.A 0.02568f
C4666 a_12896_3270# a_12815_1703# 0
C4667 sg13cmos5l_inv_1_2.A sg13cmos5l_buf_1_95.X 0.39172f
C4668 sg13cmos5l_inv_1_8.A a_1472_4782# 0
C4669 a_17882_7684# a_18345_7674# 0.13395f
C4670 a_17545_7728# a_18164_7996# 0.00161f
C4671 sg13cmos5l_buf_1_38.A sg13cmos5l_buf_1_33.A 0.01691f
C4672 sg13cmos5l_dlhr_1_9.D a_2148_3904# 0
C4673 sg13cmos5l_buf_1_18.A a_17170_2826# 0
C4674 a_19090_1626# nl_sw[9] 0.0012f
C4675 sg13cmos5l_a221oi_1_1.C1 a_10318_5412# 0.00529f
C4676 a_14342_8874# a_14602_8404# 0.87117f
C4677 a_3407_8797# a_3676_7964# 0.0133f
C4678 a_2565_8447# sg13cmos5l_dfrbp_1_16.Q_N 0.00431f
C4679 sg13cmos5l_buf_1_2.A a_15702_4187# 0.01206f
C4680 a_1580_2352# sg13cmos5l_buf_1_41.X 0
C4681 sg13cmos5l_buf_1_32.A a_2824_2388# 0
C4682 sg13cmos5l_dfrbp_1_0.CLK a_13652_1924# 0
C4683 a_17108_7972# a_16068_6928# 0
C4684 a_16528_7894# a_16485_6935# 0.01067f
C4685 a_15531_7796# a_16356_7349# 0
C4686 sg13cmos5l_dlhr_1_6.Q_N VPWR 0.25185f
C4687 a_10484_6924# VPWR 0.10515f
C4688 sg13cmos5l_buf_1_116.A sg13cmos5l_buf_1_4.A 0.0619f
C4689 sg13cmos5l_dfrbp_1_22.D a_15702_5842# 0.00117f
C4690 sg13cmos5l_dfrbp_1_8.RESET_B a_3396_4650# 0
C4691 a_12815_4261# sg13cmos5l_o21ai_1_0.Y 0
C4692 sg13cmos5l_buf_1_9.A a_11434_2356# 0.03029f
C4693 sg13cmos5l_dfrbp_1_8.RESET_B ph_sw[5] 0.02335f
C4694 a_18615_5770# sg13cmos5l_a22oi_1_1.A1 0
C4695 a_10888_1664# a_10696_1758# 0.01225f
C4696 sg13cmos5l_dlhr_1_0.Q_N a_8576_1758# 0.01282f
C4697 sg13cmos5l_buf_1_5.X VPWR 0.40317f
C4698 sg13cmos5l_buf_1_5.X nl_sw[7] 0
C4699 sg13cmos5l_buf_1_3.X nh_sw[10] 0.32895f
C4700 a_682_5380# a_524_4614# 0
C4701 a_516_5850# sg13cmos5l_buf_1_43.A 0
C4702 a_10292_9508# a_10224_9508# 0
C4703 a_10473_9186# a_10406_9624# 0
C4704 a_10010_9196# sg13cmos5l_buf_1_97.A 0.00158f
C4705 sg13cmos5l_inv_1_14.A sg13cmos5l_buf_1_30.A 0.43294f
C4706 sg13cmos5l_buf_1_97.A pl_sw[6] 0.00127f
C4707 sg13cmos5l_and3_1_0.C a_13701_3117# 0
C4708 sg13cmos5l_nand2_1_1.B a_12719_2749# 0
C4709 sg13cmos5l_buf_1_57.X a_13324_4696# 0
C4710 a_8488_9224# a_8486_8874# 0
C4711 a_12549_9165# a_12420_9199# 0.01562f
C4712 a_12132_9504# a_12358_9199# 0.00523f
C4713 a_12651_9308# a_13593_9501# 0
C4714 a_3664_4142# a_3609_4023# 0.00464f
C4715 a_1862_8874# a_1846_7850# 0
C4716 a_12075_3911# sg13cmos5l_dfrbp_1_1.Q 0
C4717 sg13cmos5l_dfrbp_1_0.RESET_B a_13072_4142# 0.17663f
C4718 a_2169_5535# VPWR 0
C4719 sg13cmos5l_buf_1_41.A a_3771_6553# 0
C4720 sg13cmos5l_dlhr_1_9.D sg13cmos5l_or2_1_0.A 0
C4721 a_3831_7282# a_3962_7288# 0.65127f
C4722 sg13cmos5l_dlhr_1_12.D a_18164_7996# 0
C4723 sg13cmos5l_dfrbp_1_6.RESET_B a_16751_2749# 0.00689f
C4724 sg13cmos5l_buf_1_8.A nl_sw[5] 0
C4725 sg13cmos5l_dfrbp_1_6.RESET_B a_13686_7354# 0.02325f
C4726 sg13cmos5l_buf_1_45.X a_7055_4261# 0.00198f
C4727 sg13cmos5l_inv_1_7.A sg13cmos5l_a22oi_1_1.B1 0.01912f
C4728 sg13cmos5l_dlhr_1_0.Q_N VPWR 0.25915f
C4729 a_8378_5776# a_8774_5412# 0.00949f
C4730 sg13cmos5l_buf_1_31.X sg13cmos5l_buf_1_41.X 0
C4731 sg13cmos5l_nor2_1_2.A a_1580_2352# 0.00101f
C4732 sg13cmos5l_buf_1_25.A sg13cmos5l_dlhr_1_0.D 0.00122f
C4733 sg13cmos5l_dfrbp_1_0.Q a_18760_2388# 0.00585f
C4734 a_18486_8866# ph_sw[9] 0.01952f
C4735 a_8204_2352# sg13cmos5l_dlhr_1_0.Q 0.03448f
C4736 a_13036_4948# VPWR 0.00704f
C4737 a_11190_7354# sg13cmos5l_or2_1_1.B 0
C4738 a_6959_6239# a_7537_4727# 0
C4739 sg13cmos5l_buf_1_24.A a_7226_1636# 0.00181f
C4740 sg13cmos5l_buf_1_43.A a_424_1664# 0.00151f
C4741 sg13cmos5l_buf_1_104.A frame 0.04204f
C4742 sg13cmos5l_or2_1_0.A a_7892_3900# 0.0062f
C4743 sg13cmos5l_dfrbp_1_6.RESET_B a_17750_4325# 0
C4744 a_15466_2356# a_15492_2392# 0.43042f
C4745 sg13cmos5l_buf_1_10.A sg13cmos5l_inv_1_0.Y 0.00348f
C4746 sg13cmos5l_nand2_1_0.A a_11973_3911# 0
C4747 a_11190_7354# a_12567_7282# 0
C4748 sg13cmos5l_dfrbp_1_0.Q a_19508_1924# 0.13922f
C4749 a_13047_7690# pl_sw[6] 0
C4750 sg13cmos5l_dfrbp_1_6.RESET_B a_9558_6144# 0
C4751 sg13cmos5l_dfrbp_1_8.RESET_B a_3575_6553# 0.08669f
C4752 sg13cmos5l_nand2_1_1.A sg13cmos5l_buf_1_18.X 0
C4753 sg13cmos5l_inv_1_3.A sg13cmos5l_a22oi_1_1.B2 0.04887f
C4754 sg13cmos5l_inv_1_27.Y a_14583_5770# 0
C4755 a_11460_2392# nh_sw[5] 0.01536f
C4756 sg13cmos5l_dfrbp_1_8.D sg13cmos5l_dfrbp_1_0.RESET_B 0
C4757 sg13cmos5l_dlhr_1_11.GATE sg13cmos5l_dfrbp_1_27.Q_N 0
C4758 a_15884_3102# a_15780_2813# 0
C4759 a_1672_3176# sg13cmos5l_inv_1_19.A 0.01311f
C4760 sg13cmos5l_buf_1_25.X a_5600_1758# 0.00261f
C4761 sg13cmos5l_buf_1_24.X VPWR 0.33517f
C4762 a_9164_1590# nh_sw[4] 0.04958f
C4763 sg13cmos5l_buf_1_65.X a_682_6892# 0
C4764 sg13cmos5l_buf_1_77.A a_9268_6148# 0.00127f
C4765 sg13cmos5l_dlhr_1_1.GATE VPWR 1.02328f
C4766 a_15821_3864# a_15909_2399# 0.01135f
C4767 a_16204_4338# a_15492_2392# 0
C4768 sg13cmos5l_dfrbp_1_20.Q a_11072_5347# 0
C4769 a_524_4614# ckc 0.28895f
C4770 sg13cmos5l_buf_1_87.A sg13cmos5l_buf_1_104.A 0
C4771 a_10827_7796# a_11752_6294# 0
C4772 a_8439_6178# sg13cmos5l_buf_1_29.A 0
C4773 a_9033_6162# a_8966_6600# 0
C4774 a_8852_6484# a_8784_6484# 0
C4775 sg13cmos5l_dlhr_1_6.D a_8785_6154# 0
C4776 a_4840_1664# nh_sw[2] 0
C4777 sg13cmos5l_nor2_1_0.A a_13701_3117# 0.00777f
C4778 a_17327_7285# a_17529_7047# 0.00675f
C4779 a_18164_6924# a_18860_6888# 0.00695f
C4780 a_11844_1639# a_11782_1639# 0
C4781 sg13cmos5l_buf_1_40.A a_2224_5654# 0
C4782 sg13cmos5l_dfrbp_1_0.Q a_15784_1664# 0.02228f
C4783 sg13cmos5l_buf_1_31.X sg13cmos5l_nor2_1_2.A 0.01458f
C4784 rdy a_616_9224# 0.00421f
C4785 a_15702_4187# sg13cmos5l_dfrbp_1_6.Q_N 0.25039f
C4786 a_16204_4338# a_16572_4261# 0.00294f
C4787 sg13cmos5l_inv_1_26.Y sg13cmos5l_buf_1_19.A 0.64624f
C4788 sg13cmos5l_dlygate4sd2_1_0.X sg13cmos5l_inv_1_19.A 0.10546f
C4789 sg13cmos5l_dfrbp_1_0.D a_17220_1626# 0
C4790 sg13cmos5l_dfrbp_1_6.D a_10024_5498# 0
C4791 sg13cmos5l_inv_1_17.A sg13cmos5l_dfrbp_1_10.Q_N 0.04162f
C4792 sg13cmos5l_buf_1_3.A sg13cmos5l_buf_1_104.A 0.24328f
C4793 sg13cmos5l_dfrbp_1_6.RESET_B sg13cmos5l_buf_1_5.A 0.53354f
C4794 a_18164_7996# VPWR 0.10932f
C4795 sg13cmos5l_dfrbp_1_0.D a_18146_4338# 0
C4796 a_11567_7751# a_11769_7989# 0.00675f
C4797 sg13cmos5l_inv_1_3.A a_12804_6175# 0
C4798 sg13cmos5l_buf_1_6.A a_15206_2826# 0.00126f
C4799 sg13cmos5l_inv_1_8.A a_2436_8861# 0.00311f
C4800 a_10022_7674# cks 0.00771f
C4801 sg13cmos5l_buf_1_111.A pl_sw[8] 0
C4802 sg13cmos5l_buf_1_57.X a_10202_7288# 0.02461f
C4803 sg13cmos5l_inv_1_8.A a_902_3142# 0.00498f
C4804 sg13cmos5l_inv_1_14.A pl_sw[5] 0.00219f
C4805 sg13cmos5l_inv_1_20.Y a_2348_7624# 0
C4806 a_1946_4660# sg13cmos5l_inv_1_19.A 0.03095f
C4807 sg13cmos5l_dlhr_1_9.D a_6729_5041# 0
C4808 sg13cmos5l_inv_1_17.A a_3407_8797# 0.03893f
C4809 sg13cmos5l_inv_1_0.A sg13cmos5l_buf_1_46.A 0
C4810 sg13cmos5l_buf_1_41.X a_3212_1590# 0.28823f
C4811 sg13cmos5l_dfrbp_1_0.CLK sg13cmos5l_buf_1_8.A 0.02837f
C4812 a_3578_2752# sg13cmos5l_buf_1_33.A 0.00105f
C4813 a_13701_3117# a_14440_1664# 0
C4814 a_13803_3260# a_14056_1664# 0
C4815 sg13cmos5l_dlhr_1_9.D a_11072_5347# 0
C4816 sg13cmos5l_dfrbp_1_6.D a_2374_4325# 0
C4817 a_6568_9224# ph_sw[2] 0
C4818 sg13cmos5l_buf_1_103.A a_18272_9318# 0
C4819 sg13cmos5l_inv_1_26.Y sg13cmos5l_buf_1_107.X 0.71485f
C4820 sg13cmos5l_nor2b_1_0.Y a_13076_5376# 0.01006f
C4821 sg13cmos5l_dfrbp_1_6.RESET_B a_1065_6971# 0
C4822 sg13cmos5l_buf_1_44.A a_5220_2392# 0
C4823 sg13cmos5l_buf_1_5.A a_10071_7282# 0
C4824 a_5069_5376# a_5799_5499# 0.3087f
C4825 a_5452_5850# a_5710_5850# 0.01017f
C4826 sg13cmos5l_inv_1_28.Y sg13cmos5l_dfrbp_1_8.RESET_B 0.01875f
C4827 sg13cmos5l_buf_1_97.A a_10708_9172# 0
C4828 sg13cmos5l_dfrbp_1_6.RESET_B sg13cmos5l_buf_1_24.A 0.3045f
C4829 sg13cmos5l_buf_1_110.A pl_sw[8] 0.02528f
C4830 sg13cmos5l_buf_1_19.A sg13cmos5l_dlhr_1_10.Q 0.02005f
C4831 sg13cmos5l_buf_1_30.A sg13cmos5l_buf_1_45.A 0
C4832 sg13cmos5l_buf_1_18.A a_20012_2352# 0
C4833 sg13cmos5l_buf_1_2.A a_16462_4338# 0
C4834 sg13cmos5l_dfrbp_1_15.D a_4076_7624# 0.00589f
C4835 a_14602_8404# a_14916_8861# 0.00659f
C4836 a_14628_8440# a_14854_8861# 0.00523f
C4837 sg13cmos5l_buf_1_3.A a_20488_5498# 0
C4838 sg13cmos5l_dfrbp_1_0.CLK sg13cmos5l_buf_1_1.A 0
C4839 sg13cmos5l_buf_1_5.A a_14543_3215# 0.00154f
C4840 sg13cmos5l_dfrbp_1_21.Q sg13cmos5l_or2_1_1.B 1.50101f
C4841 a_12516_6480# sg13cmos5l_a22oi_1_1.B2 0.0014f
C4842 a_15909_2399# VPWR 0.25484f
C4843 a_15909_2399# nl_sw[7] 0
C4844 a_20392_2388# nh_sw[10] 0.00513f
C4845 sg13cmos5l_buf_1_63.A a_1227_6935# 0
C4846 a_10598_6924# VPWR 0.0042f
C4847 a_6660_4663# a_6213_3911# 0
C4848 sg13cmos5l_inv_1_26.Y sg13cmos5l_buf_1_101.X 0.06483f
C4849 sg13cmos5l_dfrbp_1_8.RESET_B a_15531_7796# 0.02715f
C4850 sg13cmos5l_dfrbp_1_8.RESET_B a_4753_4727# 0
C4851 sg13cmos5l_nand2_1_1.A sg13cmos5l_o21ai_1_0.Y 0.00168f
C4852 sg13cmos5l_buf_1_94.X a_15045_8447# 0.00166f
C4853 a_19209_5769# sg13cmos5l_a22oi_1_1.A1 0
C4854 sg13cmos5l_buf_1_73.A a_7524_7992# 0.01465f
C4855 a_10464_2427# a_10613_2758# 0.3658f
C4856 a_10331_1924# a_10433_1652# 0
C4857 a_12721_1703# VPWR 0.0014f
C4858 sg13cmos5l_dfrbp_1_6.RESET_B a_16068_6162# 0
C4859 sg13cmos5l_buf_1_86.A a_18870_7656# 0
C4860 a_13017_4023# VPWR 0
C4861 sg13cmos5l_nand2_1_1.B sg13cmos5l_nor2_1_1.A 0.18847f
C4862 sg13cmos5l_buf_1_93.X a_17516_9150# 0.00154f
C4863 a_16748_9150# sg13cmos5l_buf_1_103.A 0.00445f
C4864 a_17132_9150# sg13cmos5l_buf_1_94.X 0.32566f
C4865 a_18615_5770# sg13cmos5l_or2_1_0.A 0
C4866 a_13391_9263# sg13cmos5l_dfrbp_1_24.Q_N 0.04107f
C4867 a_13648_9406# a_13297_9263# 0.01017f
C4868 a_15500_9150# sg13cmos5l_buf_1_101.X 0
C4869 a_2565_8447# a_2596_7996# 0
C4870 a_2148_8440# a_2621_7636# 0
C4871 sg13cmos5l_buf_1_29.A nh_sw[4] 0
C4872 sg13cmos5l_inv_1_3.A a_14628_8440# 0.03033f
C4873 sg13cmos5l_dfrbp_1_0.RESET_B sg13cmos5l_dfrbp_1_2.Q_N 0.00127f
C4874 sg13cmos5l_inv_1_1.A sg13cmos5l_buf_1_5.A 0
C4875 sg13cmos5l_buf_1_9.A sg13cmos5l_buf_1_8.X 0.12532f
C4876 a_12516_6480# a_12804_6175# 0.4806f
C4877 a_2248_9224# ph_sw[1] 0.13485f
C4878 sg13cmos5l_inv_1_27.Y sg13cmos5l_dfrbp_1_20.Q 0
C4879 a_3831_7282# a_4380_7326# 0
C4880 a_3962_7288# a_4425_7281# 0.13395f
C4881 sg13cmos5l_dfrbp_1_6.RESET_B sg13cmos5l_dfrbp_1_23.Q 0.10225f
C4882 a_620_7638# pl_sw[0] 0.28823f
C4883 sg13cmos5l_dfrbp_1_8.RESET_B sg13cmos5l_buf_1_31.X 0
C4884 sg13cmos5l_buf_1_45.X a_7257_4023# 0
C4885 a_11002_3142# VPWR 0
C4886 sg13cmos5l_buf_1_65.X sg13cmos5l_buf_1_78.A 0.01907f
C4887 a_10696_1758# VPWR 0.131f
C4888 sg13cmos5l_buf_1_110.A a_15784_9224# 0.33894f
C4889 a_15876_4968# sg13cmos5l_dfrbp_1_0.RESET_B 0
C4890 a_11973_3911# sg13cmos5l_dfrbp_1_1.Q 0
C4891 sg13cmos5l_dfrbp_1_20.Q sg13cmos5l_dfrbp_1_2.D 0
C4892 sg13cmos5l_dlhr_1_6.D a_11370_5760# 0
C4893 a_9291_8447# a_8783_7751# 0
C4894 sg13cmos5l_buf_1_95.X a_12716_8400# 0
C4895 pl_sw[10] frame 0.64699f
C4896 sg13cmos5l_nand2_1_1.B a_10464_2427# 0.51212f
C4897 sg13cmos5l_or2_1_0.A a_8296_3986# 0.00115f
C4898 a_15492_2392# a_15780_2813# 0.4806f
C4899 a_15466_2356# a_16011_2399# 0.00999f
C4900 a_15206_2826# a_16751_2749# 0
C4901 a_17425_6239# a_17135_4727# 0
C4902 a_12814_4692# a_13036_4948# 0
C4903 sg13cmos5l_buf_1_0.A a_20012_2352# 0
C4904 a_14800_3358# nh_sw[7] 0
C4905 sg13cmos5l_dfrbp_1_0.Q sg13cmos5l_dfrbp_1_0.Q_N 0
C4906 sg13cmos5l_dfrbp_1_6.RESET_B a_13460_7996# 0.11159f
C4907 sg13cmos5l_o21ai_1_0.A1 a_11364_4338# 0
C4908 sg13cmos5l_dfrbp_1_6.RESET_B a_3588_4968# 0
C4909 sg13cmos5l_dfrbp_1_8.RESET_B a_2804_5412# 0
C4910 sg13cmos5l_dfrbp_1_6.D a_5425_3130# 0.00198f
C4911 sg13cmos5l_buf_1_78.A a_5962_8404# 0.02028f
C4912 sg13cmos5l_dfrbp_1_10.Q sg13cmos5l_dlhr_1_2.Q_N 0.00527f
C4913 sg13cmos5l_buf_1_87.A pl_sw[10] 0
C4914 a_16204_4338# a_16011_2399# 0
C4915 sg13cmos5l_buf_1_0.A a_18873_1941# 0.00385f
C4916 a_16551_3987# a_15909_2399# 0
C4917 sg13cmos5l_buf_1_31.X a_424_3270# 0
C4918 sg13cmos5l_dfrbp_1_6.D a_5194_2356# 0
C4919 a_17896_9224# a_17751_7690# 0
C4920 sg13cmos5l_dfrbp_1_0.D sg13cmos5l_buf_1_18.X 0
C4921 a_12404_7972# a_12490_6385# 0
C4922 sg13cmos5l_dlhr_1_1.GATE a_1967_7285# 0.01414f
C4923 sg13cmos5l_dfrbp_1_16.Q_N sg13cmos5l_buf_1_41.A 0.02943f
C4924 sg13cmos5l_buf_1_28.X nl_sw[4] 0
C4925 sg13cmos5l_buf_1_56.A sg13cmos5l_buf_1_29.A 0.03615f
C4926 a_12106_9409# sg13cmos5l_buf_1_95.X 0.02774f
C4927 sg13cmos5l_dfrbp_1_8.RESET_B a_15500_9150# 0
C4928 a_2148_8440# ph_sw[1] 0
C4929 sg13cmos5l_dfrbp_1_15.D sg13cmos5l_dlhr_1_1.D 0
C4930 sg13cmos5l_dfrbp_1_8.D a_18568_7010# 0.02368f
C4931 sg13cmos5l_dlhr_1_9.D sg13cmos5l_dfrbp_1_2.D 0
C4932 a_4460_9150# a_4076_7624# 0
C4933 a_1956_8874# sg13cmos5l_inv_1_19.A 0
C4934 sg13cmos5l_buf_1_40.A sg13cmos5l_dlhr_1_1.D 0.15124f
C4935 sg13cmos5l_inv_1_8.A sg13cmos5l_buf_1_41.X 0.00163f
C4936 sg13cmos5l_buf_1_3.A pl_sw[10] 0.54279f
C4937 a_16204_4338# a_16703_3871# 0
C4938 sg13cmos5l_dfrbp_1_0.D a_17700_1639# 0.00867f
C4939 sg13cmos5l_buf_1_77.A sg13cmos5l_inv_1_2.A 0.05477f
C4940 sg13cmos5l_dfrbp_1_8.RESET_B a_1125_6935# 0
C4941 a_6697_3192# a_7316_3460# 0.00161f
C4942 a_7034_3148# a_7497_3138# 0.13395f
C4943 sg13cmos5l_inv_1_1.A sg13cmos5l_dfrbp_1_23.Q 0
C4944 a_11567_7751# cks 0
C4945 sg13cmos5l_buf_8_1.A a_16940_3102# 0.0034f
C4946 sg13cmos5l_buf_1_60.X a_3574_7850# 0
C4947 sg13cmos5l_nor2b_1_0.Y sg13cmos5l_dfrbp_1_10.Q 0.00758f
C4948 a_9242_4660# sg13cmos5l_buf_1_46.A 0
C4949 a_9524_4972# a_9638_5088# 0.00122f
C4950 sg13cmos5l_inv_1_2.A a_16102_4663# 0
C4951 sg13cmos5l_buf_1_35.A nl_sw[1] 0.03626f
C4952 sg13cmos5l_dfrbp_1_8.RESET_B a_4349_7636# 0
C4953 sg13cmos5l_buf_1_6.A a_15200_1758# 0.05958f
C4954 sg13cmos5l_buf_1_34.A sg13cmos5l_buf_1_33.A 0
C4955 a_1580_2352# a_1576_1758# 0.00705f
C4956 sg13cmos5l_a22oi_1_1.A1 sg13cmos5l_nor2_1_1.A 0.00201f
C4957 a_11973_1605# a_12721_1703# 0.01058f
C4958 a_16234_6385# sg13cmos5l_dfrbp_1_21.Q 0
C4959 sg13cmos5l_inv_1_0.A sg13cmos5l_nand2_1_1.B 0
C4960 sg13cmos5l_nor2b_1_0.Y sg13cmos5l_and3_1_0.X 0.07408f
C4961 sg13cmos5l_buf_1_74.X sg13cmos5l_inv_1_2.A 0.00117f
C4962 a_6568_9224# sg13cmos5l_buf_1_78.X 0.12255f
C4963 sg13cmos5l_buf_1_44.A sg13cmos5l_dfrbp_1_10.Q 0.00722f
C4964 a_14628_8440# cks 0.01626f
C4965 sg13cmos5l_dfrbp_1_6.D a_13035_6284# 0.01209f
C4966 a_5710_5850# a_5951_5383# 0.01058f
C4967 sg13cmos5l_nor2_1_0.A a_12704_4782# 0.04929f
C4968 sg13cmos5l_nor2b_1_0.Y sg13cmos5l_inv_1_0.Y 0.0398f
C4969 a_2732_1590# nh_sw[0] 0
C4970 sg13cmos5l_buf_1_73.A a_7796_6460# 0
C4971 sg13cmos5l_dfrbp_1_6.RESET_B a_1280_6294# 0.0072f
C4972 sg13cmos5l_buf_1_111.A a_17161_8794# 0
C4973 a_17896_9224# a_17498_8800# 0
C4974 sg13cmos5l_buf_1_103.A ph_sw[6] 0.00695f
C4975 a_15045_8447# a_15793_8797# 0.01058f
C4976 sg13cmos5l_buf_1_73.A a_7520_7010# 0
C4977 sg13cmos5l_dlhr_1_0.GATE a_6188_1590# 0.00649f
C4978 a_14602_8404# a_14985_8483# 0.00337f
C4979 a_17108_7972# sg13cmos5l_dfrbp_1_8.D 0
C4980 sg13cmos5l_dlhr_1_15.D a_18164_6924# 0.00107f
C4981 a_14612_6460# sg13cmos5l_a22oi_1_1.B2 0
C4982 a_17008_2630# VPWR 0.15065f
C4983 a_524_4614# sg13cmos5l_dlygate4sd2_1_0.A 0
C4984 a_13161_7281# VPWR 0.62021f
C4985 sg13cmos5l_dfrbp_1_6.D a_1121_4166# 0
C4986 sg13cmos5l_dfrbp_1_8.RESET_B a_15300_7687# 0.00285f
C4987 sg13cmos5l_buf_1_87.A a_18409_5770# 0
C4988 sg13cmos5l_inv_1_8.A sg13cmos5l_nor2_1_2.A 0.32849f
C4989 a_1662_8374# a_1125_6935# 0
C4990 sg13cmos5l_buf_1_73.A a_8783_7751# 0
C4991 sg13cmos5l_buf_1_44.A a_5673_3138# 0.2822f
C4992 sg13cmos5l_buf_1_94.X a_16724_8436# 0
C4993 sg13cmos5l_dfrbp_1_23.CLK sg13cmos5l_inv_1_7.A 0
C4994 sg13cmos5l_o21ai_1_0.Y a_13701_3117# 0
C4995 sg13cmos5l_buf_1_6.A a_11556_1944# 0
C4996 a_11530_1849# a_11556_1944# 0.43042f
C4997 sg13cmos5l_buf_1_65.X sg13cmos5l_dfrbp_1_18.Q 0.01371f
C4998 a_17126_1626# VPWR 0.93077f
C4999 sg13cmos5l_buf_1_44.X sg13cmos5l_dfrbp_1_29.Q_N 0.03835f
C5000 sg13cmos5l_dfrbp_1_6.RESET_B a_17425_6239# 0.01171f
C5001 sg13cmos5l_inv_1_6.A a_20008_7712# 0.04889f
C5002 a_17354_4180# VPWR 0.00842f
C5003 a_20288_2474# d_out[1] 0
C5004 sg13cmos5l_inv_1_7.A a_11434_2356# 0
C5005 a_5416_9224# a_5800_9224# 0.00492f
C5006 sg13cmos5l_dfrbp_1_21.Q a_17493_3947# 0
C5007 a_19209_5769# sg13cmos5l_or2_1_0.A 0
C5008 a_8852_6484# VPWR 0.10799f
C5009 sg13cmos5l_and3_1_0.C a_16572_4261# 0
C5010 sg13cmos5l_buf_1_31.X a_1576_1758# 0
C5011 sg13cmos5l_inv_1_3.A a_15887_8797# 0
C5012 sg13cmos5l_buf_1_40.A a_1088_7806# 0.03553f
C5013 sg13cmos5l_dfrbp_1_1.Q a_12998_3138# 0.01035f
C5014 sg13cmos5l_buf_8_0.A VPWR 0.53852f
C5015 sg13cmos5l_buf_1_116.A a_15592_6200# 0.33093f
C5016 a_13775_6239# a_13681_6239# 0.32273f
C5017 a_422_5850# sg13cmos5l_buf_1_43.A 0.00201f
C5018 sg13cmos5l_dfrbp_1_0.RESET_B a_13284_3456# 0.4975f
C5019 sg13cmos5l_buf_1_30.A a_6959_6239# 0.02447f
C5020 a_4425_7281# a_4380_7326# 0
C5021 sg13cmos5l_buf_1_9.A a_10094_2780# 0
C5022 sg13cmos5l_buf_1_8.X sg13cmos5l_dfrbp_1_1.D 0.07353f
C5023 a_12230_6162# sg13cmos5l_inv_1_0.A 0
C5024 sg13cmos5l_dfrbp_1_16.Q a_5069_5376# 0.00804f
C5025 sg13cmos5l_a221oi_1_0.A2 a_9524_4972# 0.00493f
C5026 sg13cmos5l_or2_1_0.A a_8392_3270# 0
C5027 sg13cmos5l_buf_1_24.A a_5452_5850# 0
C5028 sg13cmos5l_buf_1_19.X a_18671_1703# 0.00144f
C5029 a_11364_1626# VPWR 0
C5030 sg13cmos5l_nand2_1_0.A a_14800_3358# 0
C5031 a_17972_4948# sg13cmos5l_dfrbp_1_0.RESET_B 0.00209f
C5032 a_18363_4270# sg13cmos5l_buf_1_19.X 0.00203f
C5033 a_15300_2826# nh_sw[7] 0
C5034 a_4559_7630# ph_sw[2] 0
C5035 a_9291_8447# sg13cmos5l_dfrbp_1_20.Q 0
C5036 sg13cmos5l_buf_1_24.A a_7924_1612# 0
C5037 a_3664_4142# a_3407_4261# 0.35645f
C5038 sg13cmos5l_inv_1_11.Y sg13cmos5l_buf_1_26.X 0
C5039 a_15780_2813# a_16011_2399# 0.15089f
C5040 sg13cmos5l_inv_1_29.Y sg13cmos5l_a221oi_1_1.C1 0
C5041 sg13cmos5l_nor2_1_1.A nh_sw[8] 0.02506f
C5042 a_19624_8436# sg13cmos5l_inv_1_6.A 0.03259f
C5043 sg13cmos5l_dlhr_1_9.Q a_4076_5376# 0.33093f
C5044 a_12698_7288# a_13161_7281# 0.13395f
C5045 a_12567_7282# a_13116_7326# 0
C5046 a_12913_7326# a_12980_6924# 0.0018f
C5047 a_12490_6385# a_12230_6162# 0.87117f
C5048 sg13cmos5l_o21ai_1_0.A1 sg13cmos5l_dfrbp_1_0.CLK 0.00252f
C5049 sg13cmos5l_dlhr_1_5.GATE a_8208_6924# 0
C5050 sg13cmos5l_dfrbp_1_23.CLK sg13cmos5l_dlhr_1_13.Q_N 0
C5051 sg13cmos5l_dfrbp_1_8.RESET_B a_6219_6284# 0.03089f
C5052 a_15821_3864# nh_sw[7] 0.00161f
C5053 sg13cmos5l_dfrbp_1_6.RESET_B ph_sw[5] 0.00128f
C5054 sg13cmos5l_buf_8_0.X sg13cmos5l_dlhr_1_16.Q_N 0
C5055 sg13cmos5l_inv_1_17.A sg13cmos5l_buf_1_60.A 0
C5056 sg13cmos5l_buf_1_78.A a_6507_8447# 0
C5057 a_1862_4338# a_1760_3986# 0
C5058 a_13324_4696# sg13cmos5l_dfrbp_1_0.RESET_B 0.00205f
C5059 sg13cmos5l_nand2_1_0.A a_10888_1664# 0
C5060 a_16551_3987# a_17008_2630# 0
C5061 sg13cmos5l_inv_1_0.A sg13cmos5l_a22oi_1_1.A1 0
C5062 sg13cmos5l_buf_1_63.X sg13cmos5l_buf_1_63.A 0.01748f
C5063 a_2386_7362# VPWR 0.00121f
C5064 sg13cmos5l_buf_1_111.A sg13cmos5l_dlhr_1_15.Q 0.00327f
C5065 sg13cmos5l_inv_1_26.Y a_18096_7996# 0
C5066 sg13cmos5l_buf_1_110.A sg13cmos5l_dfrbp_1_21.Q 0.30592f
C5067 sg13cmos5l_dlhr_1_11.D a_12516_6480# 0
C5068 sg13cmos5l_inv_1_6.A a_19227_4654# 0.07722f
C5069 sg13cmos5l_buf_1_29.A sg13cmos5l_buf_1_8.A 0
C5070 sg13cmos5l_dfrbp_1_8.RESET_B a_8043_7796# 0.01f
C5071 a_6380_7638# VPWR 0.28055f
C5072 sg13cmos5l_dlhr_1_1.GATE a_1484_6126# 0.11447f
C5073 sg13cmos5l_dlhr_1_5.D a_7631_4727# 0
C5074 sg13cmos5l_a22oi_1_2.B1 nl_sw[4] 0
C5075 sg13cmos5l_inv_1_8.A sg13cmos5l_dfrbp_1_8.RESET_B 6.33205f
C5076 sg13cmos5l_inv_1_18.A a_10292_9508# 0
C5077 a_18117_3117# sg13cmos5l_nor2_1_1.A 0.00111f
C5078 sg13cmos5l_dlhr_1_15.D a_13652_3900# 0
C5079 sg13cmos5l_buf_1_60.X a_3692_9150# 0.00604f
C5080 a_16551_3987# a_17354_4180# 0.15089f
C5081 sg13cmos5l_buf_1_98.A a_13977_6477# 0
C5082 a_7034_3148# a_7248_3460# 0.01249f
C5083 sg13cmos5l_buf_1_2.X sg13cmos5l_nor2b_1_1.Y 0
C5084 sg13cmos5l_buf_1_39.A a_6572_1590# 0
C5085 sg13cmos5l_buf_1_25.X sg13cmos5l_buf_1_24.X 0.09063f
C5086 sg13cmos5l_dfrbp_1_6.D a_5210_3148# 0.07738f
C5087 sg13cmos5l_buf_1_30.A nl_sw[4] 0.10806f
C5088 sg13cmos5l_dlhr_1_9.Q a_4518_7996# 0
C5089 sg13cmos5l_dlhr_1_11.D cks 0
C5090 sg13cmos5l_inv_1_26.Y ph_sw[10] 0
C5091 a_15782_7362# a_15702_5842# 0
C5092 sg13cmos5l_inv_1_18.A a_9344_7010# 0.00403f
C5093 sg13cmos5l_buf_1_45.X sg13cmos5l_a221oi_1_0.A2 0.03748f
C5094 a_4934_2826# a_5637_2399# 0.02431f
C5095 a_8233_6216# a_8852_6484# 0.00161f
C5096 a_8570_6172# a_9033_6162# 0.13395f
C5097 sg13cmos5l_inv_1_2.A sg13cmos5l_dfrbp_1_24.Q_N 0.00519f
C5098 sg13cmos5l_nor2_1_0.A a_10618_3142# 0.00375f
C5099 a_17519_6239# sg13cmos5l_dfrbp_1_21.Q 0.00156f
C5100 sg13cmos5l_buf_1_30.A a_5770_3868# 0
C5101 a_8852_6484# sg13cmos5l_dfrbp_1_11.Q 0
C5102 a_13072_1846# a_13234_1626# 0.0019f
C5103 a_13652_1924# sg13cmos5l_dfrbp_1_1.Q_N 0.25039f
C5104 a_4950_5699# a_4107_4772# 0.00478f
C5105 sg13cmos5l_a221oi_1_0.C1 a_11556_3904# 0.00141f
C5106 sg13cmos5l_buf_1_5.A a_12361_7282# 0.02949f
C5107 a_15887_8797# cks 0.01285f
C5108 sg13cmos5l_dfrbp_1_6.D sg13cmos5l_buf_1_116.A 0.00105f
C5109 VPWR nh_sw[7] 0.17179f
C5110 nh_sw[0] nl_sw[2] 0
C5111 nh_sw[1] nl_sw[1] 0.08836f
C5112 nl_sw[9] nl_sw[10] 0
C5113 sg13cmos5l_inv_1_26.Y a_18196_8824# 0
C5114 sg13cmos5l_dfrbp_1_6.RESET_B a_3575_6553# 0
C5115 sg13cmos5l_a22oi_1_1.Y a_15062_4292# 0.00248f
C5116 nl_sw[8] nh_sw[6] 0
C5117 nh_sw[7] nl_sw[7] 0.0691f
C5118 sg13cmos5l_inv_1_8.A a_424_3270# 0.03921f
C5119 sg13cmos5l_dlhr_1_0.GATE a_7095_1642# 0.24033f
C5120 a_15887_8797# a_16306_8874# 0.00176f
C5121 sg13cmos5l_or2_1_0.A sg13cmos5l_nor2_1_1.A 0
C5122 sg13cmos5l_buf_1_57.X a_8570_6172# 0
C5123 sg13cmos5l_inv_1_6.A a_20488_6294# 0.00198f
C5124 sg13cmos5l_dfrbp_1_16.Q sg13cmos5l_or2_1_1.B 0.01278f
C5125 a_18376_2388# VPWR 0.25305f
C5126 a_1760_9318# sg13cmos5l_dfrbp_1_17.D 0
C5127 sg13cmos5l_inv_1_8.A a_1662_8374# 0
C5128 a_14426_7288# VPWR 0.35891f
C5129 a_18164_7996# a_18356_6460# 0.00245f
C5130 sg13cmos5l_dlhr_1_10.Q ph_sw[10] 0
C5131 sg13cmos5l_inv_1_0.A a_11771_5412# 0
C5132 a_20204_5376# a_19227_4654# 0.00745f
C5133 sg13cmos5l_inv_1_0.A a_9705_4650# 0
C5134 sg13cmos5l_buf_1_43.A sg13cmos5l_nand2_1_2.B 0.01115f
C5135 sg13cmos5l_inv_1_9.Y sg13cmos5l_inv_1_8.Y 0.59927f
C5136 sg13cmos5l_dfrbp_1_8.RESET_B a_1948_7964# 0.02132f
C5137 sg13cmos5l_buf_1_6.A a_13652_1924# 0
C5138 sg13cmos5l_dlhr_1_11.Q sg13cmos5l_dlhr_1_6.D 0.00363f
C5139 a_18928_1846# VPWR 0.14753f
C5140 a_11556_1944# a_12815_1703# 0.01741f
C5141 a_10282_7897# sg13cmos5l_buf_1_57.X 0
C5142 sg13cmos5l_buf_8_0.X d_out[1] 0.00118f
C5143 sg13cmos5l_inv_1_5.A VPWR 0.77603f
C5144 a_10998_9168# sg13cmos5l_dlhr_1_21.Q_N 0.12876f
C5145 sg13cmos5l_buf_1_63.A a_996_7349# 0
C5146 sg13cmos5l_buf_1_2.A sg13cmos5l_buf_1_1.A 0.0196f
C5147 sg13cmos5l_inv_1_7.A a_11748_2813# 0
C5148 a_1196_8400# VPWR 0.26947f
C5149 a_13641_7674# VPWR 0.62457f
C5150 sg13cmos5l_or2_1_0.A a_10464_2427# 0
C5151 sg13cmos5l_dfrbp_1_15.D sg13cmos5l_dlhr_1_8.Q_N 0.00302f
C5152 sg13cmos5l_and3_1_0.C a_16703_3871# 0
C5153 a_3302_4650# VPWR 0.92696f
C5154 sg13cmos5l_buf_1_40.X a_2824_2388# 0
C5155 sg13cmos5l_buf_1_3.A a_19734_5842# 0.01392f
C5156 a_12933_6141# a_13076_5376# 0.01444f
C5157 sg13cmos5l_buf_1_40.A sg13cmos5l_dlhr_1_8.Q_N 0.00767f
C5158 a_11556_3904# sg13cmos5l_o21ai_1_0.B1 0
C5159 sg13cmos5l_dfrbp_1_1.Q a_14800_3358# 0
C5160 sg13cmos5l_nand2_1_0.A a_15300_2826# 0
C5161 sg13cmos5l_inv_1_14.A sg13cmos5l_buf_1_30.X 0
C5162 a_1760_9318# ph_sw[0] 0
C5163 sg13cmos5l_buf_1_65.X cks 0.04159f
C5164 a_18164_7996# ph_sw[9] 0.00242f
C5165 sg13cmos5l_dfrbp_1_0.RESET_B a_15380_3436# 0.01994f
C5166 sg13cmos5l_buf_1_30.A sg13cmos5l_dlhr_1_6.D 0.012f
C5167 sg13cmos5l_inv_1_14.A a_8680_1664# 0
C5168 sg13cmos5l_dfrbp_1_16.Q a_5799_5499# 0.0187f
C5169 sg13cmos5l_buf_1_24.A a_5951_5383# 0.01181f
C5170 a_15357_1816# VPWR 0.26606f
C5171 a_15357_1816# nl_sw[7] 0.00126f
C5172 a_12132_9504# a_12404_7972# 0
C5173 sg13cmos5l_inv_1_7.A sg13cmos5l_buf_1_8.X 0.00185f
C5174 sg13cmos5l_dfrbp_1_6.RESET_B sg13cmos5l_inv_1_28.Y 0.04366f
C5175 sg13cmos5l_buf_1_57.X sg13cmos5l_and3_1_0.C 0
C5176 sg13cmos5l_dfrbp_1_21.Q sg13cmos5l_a22oi_1_1.Y 0
C5177 a_4244_3900# sg13cmos5l_dfrbp_1_9.Q_N 0.25039f
C5178 sg13cmos5l_dfrbp_1_17.D a_1846_7850# 0.003f
C5179 a_17008_2630# a_17170_2826# 0.0019f
C5180 a_16751_2749# a_16657_2749# 0.32273f
C5181 a_8972_9150# sg13cmos5l_dfrbp_1_8.RESET_B 0.00873f
C5182 sg13cmos5l_a22oi_1_1.B1 a_12721_4261# 0
C5183 sg13cmos5l_dfrbp_1_1.Q a_10888_1664# 0
C5184 a_9260_2352# sg13cmos5l_buf_1_28.A 0.03353f
C5185 a_13161_7281# sg13cmos5l_dlhr_1_11.Q_N 0.00294f
C5186 sg13cmos5l_dfrbp_1_8.D a_18480_5028# 0
C5187 a_1760_3986# ckc 0
C5188 a_12230_6162# a_13775_6239# 0
C5189 a_15439_1630# nh_sw[7] 0.0038f
C5190 sg13cmos5l_dfrbp_1_8.RESET_B a_5988_6175# 0.00221f
C5191 sg13cmos5l_dfrbp_1_6.RESET_B a_15531_7796# 0.55308f
C5192 a_5962_8404# cks 0.01804f
C5193 a_19796_3436# a_20392_3176# 0.00307f
C5194 a_19216_3358# a_19161_3453# 0.00464f
C5195 a_8041_5770# a_7631_4727# 0.00405f
C5196 sg13cmos5l_or2_1_0.A a_7034_3148# 0.00431f
C5197 sg13cmos5l_dfrbp_1_8.RESET_B a_8276_6924# 0
C5198 sg13cmos5l_dfrbp_1_8.RESET_B a_16164_4663# 0
C5199 sg13cmos5l_dfrbp_1_5.Q_N a_17386_1849# 0
C5200 sg13cmos5l_a221oi_1_0.A2 sg13cmos5l_a22oi_1_2.B2 0.02494f
C5201 sg13cmos5l_buf_1_31.X sg13cmos5l_buf_1_37.A 0
C5202 sg13cmos5l_nor2_1_2.A sg13cmos5l_buf_1_32.X 0
C5203 a_12520_4782# sg13cmos5l_dfrbp_1_0.RESET_B 0
C5204 a_2565_3911# a_2667_3911# 0.6663f
C5205 a_2148_3904# a_3664_4142# 0.00159f
C5206 sg13cmos5l_buf_1_26.A sg13cmos5l_dlhr_1_0.D 0.05953f
C5207 a_6184_9224# sg13cmos5l_dfrbp_1_8.RESET_B 0.00324f
C5208 sg13cmos5l_dfrbp_1_6.RESET_B a_8796_5814# 0
C5209 sg13cmos5l_buf_1_57.X a_16677_6141# 0
C5210 a_20488_4782# d_out[1] 0
C5211 a_19130_6172# a_18746_5776# 0
C5212 sg13cmos5l_buf_8_2.X frame 0.16276f
C5213 a_1096_6294# VPWR 0.13776f
C5214 sg13cmos5l_dfrbp_1_8.RESET_B a_9620_7972# 0
C5215 sg13cmos5l_dlhr_1_1.GATE a_2380_6162# 0.00273f
C5216 a_1227_6935# sg13cmos5l_dfrbp_1_16.Q 0
C5217 a_1967_7285# a_2386_7362# 0.00176f
C5218 a_12841_7728# a_12980_6924# 0.00985f
C5219 a_13047_7690# a_13161_7281# 0.01984f
C5220 sg13cmos5l_dfrbp_1_15.D sg13cmos5l_inv_1_19.A 0.09089f
C5221 sg13cmos5l_inv_1_17.A a_3496_1758# 0.00163f
C5222 a_17412_1944# a_17931_1748# 0.38902f
C5223 a_17126_1626# a_17769_2017# 0.00806f
C5224 sg13cmos5l_inv_1_0.A sg13cmos5l_or2_1_0.A 0.00384f
C5225 sg13cmos5l_buf_1_40.A sg13cmos5l_inv_1_19.A 1.29049f
C5226 sg13cmos5l_dfrbp_1_6.RESET_B sg13cmos5l_buf_1_31.X 0.14518f
C5227 sg13cmos5l_dfrbp_1_6.D sg13cmos5l_dlhr_1_4.Q_N 0
C5228 sg13cmos5l_buf_1_39.A a_6889_1680# 0
C5229 sg13cmos5l_buf_1_8.A sg13cmos5l_dfrbp_1_1.Q_N 0.00378f
C5230 sg13cmos5l_dfrbp_1_10.Q a_8022_3120# 0.00414f
C5231 sg13cmos5l_nand2_1_0.A VPWR 0.98116f
C5232 sg13cmos5l_buf_1_57.X a_14295_7282# 0.02543f
C5233 a_7316_3460# a_6479_2749# 0
C5234 a_7497_3138# a_7316_2388# 0.00512f
C5235 sg13cmos5l_dlhr_1_15.D a_16395_4772# 0.00634f
C5236 sg13cmos5l_buf_1_3.A a_20392_3176# 0.0059f
C5237 sg13cmos5l_dfrbp_1_6.D a_4041_2745# 0.01073f
C5238 sg13cmos5l_buf_1_87.A sg13cmos5l_buf_8_2.X 0
C5239 sg13cmos5l_buf_8_1.A a_20008_3900# 0
C5240 a_18368_4782# a_18363_4270# 0
C5241 sg13cmos5l_buf_1_110.A a_16234_6385# 0
C5242 a_5194_2356# a_5739_2399# 0.00999f
C5243 a_5220_2392# a_5508_2813# 0.4806f
C5244 a_4934_2826# a_6479_2749# 0
C5245 a_9558_6144# sg13cmos5l_buf_1_56.A 0.57228f
C5246 sg13cmos5l_or2_1_0.A a_3664_4142# 0
C5247 sg13cmos5l_buf_1_24.A nh_sw[4] 0
C5248 sg13cmos5l_buf_1_31.X a_10412_6126# 0
C5249 sg13cmos5l_buf_1_57.X sg13cmos5l_nor2_1_0.A 0
C5250 sg13cmos5l_buf_1_1.A sg13cmos5l_dfrbp_1_1.Q_N 0
C5251 a_5069_5376# a_4847_4727# 0.01738f
C5252 a_4950_5699# a_5104_4870# 0
C5253 a_15357_1816# a_15439_1630# 0.01126f
C5254 sg13cmos5l_buf_1_30.A a_7312_4142# 0.00948f
C5255 sg13cmos5l_dfrbp_1_21.Q_N sg13cmos5l_dfrbp_1_21.Q 0.05154f
C5256 sg13cmos5l_a22oi_1_1.A1 a_17700_3456# 0
C5257 sg13cmos5l_dfrbp_1_8.RESET_B a_708_6928# 0
C5258 sg13cmos5l_buf_1_5.A a_13396_7312# 0.00165f
C5259 sg13cmos5l_buf_1_31.X a_10071_7282# 0
C5260 a_9448_6924# a_9865_7282# 0.00364f
C5261 sg13cmos5l_dfrbp_1_6.D a_7631_4727# 0
C5262 sg13cmos5l_dfrbp_1_6.RESET_B sg13cmos5l_inv_1_26.Y 0.00336f
C5263 rdy sg13cmos5l_buf_1_68.X 0.00182f
C5264 sg13cmos5l_buf_1_33.A nl_sw[3] 0
C5265 sg13cmos5l_dfrbp_1_0.RESET_B sg13cmos5l_buf_1_19.X 0.00302f
C5266 sg13cmos5l_o21ai_1_0.B1 sg13cmos5l_dfrbp_1_0.Q 0
C5267 sg13cmos5l_buf_1_3.A sg13cmos5l_buf_8_2.X 0.33183f
C5268 sg13cmos5l_dfrbp_1_6.RESET_B a_2804_5412# 0.03243f
C5269 sg13cmos5l_inv_1_1.A a_15531_7796# 0.02844f
C5270 pl_sw[1] cks 0
C5271 a_5210_3148# a_5425_3130# 0.00284f
C5272 ph_sw[2] pl_sw[4] 0
C5273 sg13cmos5l_buf_1_8.A a_11530_1849# 0.00475f
C5274 sg13cmos5l_buf_1_6.A sg13cmos5l_buf_1_8.A 0.00569f
C5275 sg13cmos5l_dfrbp_1_6.D a_2340_3456# 0.03059f
C5276 a_5210_3148# a_5194_2356# 0
C5277 a_5079_3154# a_5637_2399# 0
C5278 sg13cmos5l_dlhr_1_15.Q sg13cmos5l_dfrbp_1_21.Q_N 0
C5279 sg13cmos5l_a22oi_1_1.B1 nl_sw[5] 0
C5280 a_9242_4660# a_9705_4650# 0.13395f
C5281 a_8905_4704# a_9524_4972# 0.00161f
C5282 sg13cmos5l_buf_1_60.X a_2621_7636# 0
C5283 sg13cmos5l_dlhr_1_5.GATE sg13cmos5l_dlhr_1_1.GATE 0.00514f
C5284 sg13cmos5l_dfrbp_1_15.D sg13cmos5l_dlhr_1_9.D 0
C5285 sg13cmos5l_dfrbp_1_6.RESET_B a_15500_9150# 0.00283f
C5286 sg13cmos5l_buf_1_40.A sg13cmos5l_dlhr_1_9.D 0
C5287 sg13cmos5l_buf_1_6.A sg13cmos5l_buf_1_1.A 0.02772f
C5288 sg13cmos5l_buf_1_37.A a_3212_1590# 0.00483f
C5289 sg13cmos5l_dfrbp_1_0.CLK sg13cmos5l_nor2b_1_1.Y 0
C5290 a_15974_6162# a_16068_6162# 0.00718f
C5291 a_16677_6141# a_16779_6284# 0.66105f
C5292 a_12815_1703# a_13652_1924# 0.1333f
C5293 a_18577_1703# VPWR 0
C5294 sg13cmos5l_buf_1_103.A sg13cmos5l_buf_1_107.X 0
C5295 sg13cmos5l_buf_1_94.X sg13cmos5l_buf_1_87.A 0
C5296 sg13cmos5l_buf_1_74.X ph_sw[2] 0.00192f
C5297 sg13cmos5l_o21ai_1_0.B1 a_12896_3270# 0.00148f
C5298 a_6789_4629# a_7316_3460# 0
C5299 sg13cmos5l_buf_1_38.A a_3792_2388# 0
C5300 sg13cmos5l_buf_1_95.X pl_sw[8] 0
C5301 a_5988_8440# a_6405_8447# 0.49014f
C5302 sg13cmos5l_dfrbp_1_6.RESET_B sg13cmos5l_dlhr_1_10.Q 0.02974f
C5303 sg13cmos5l_dfrbp_1_0.RESET_B a_15466_2356# 0.32072f
C5304 sg13cmos5l_dfrbp_1_6.RESET_B a_1125_6935# 0.05503f
C5305 a_14986_7897# VPWR 0.09412f
C5306 a_2644_4636# VPWR 0
C5307 a_12933_6141# sg13cmos5l_and3_1_0.X 0
C5308 sg13cmos5l_buf_1_40.A sg13cmos5l_buf_1_33.A 0
C5309 a_1662_8374# a_708_6928# 0
C5310 sg13cmos5l_dfrbp_1_16.Q a_10028_6126# 0
C5311 sg13cmos5l_buf_1_103.A sg13cmos5l_buf_1_101.X 1.41648f
C5312 a_20296_1664# d_out[0] 0.01408f
C5313 a_2314_3361# sg13cmos5l_buf_1_35.A 0
C5314 a_14889_7281# a_15016_6294# 0
C5315 sg13cmos5l_dfrbp_1_0.RESET_B a_11844_1639# 0
C5316 sg13cmos5l_dfrbp_1_6.RESET_B a_3212_1590# 0
C5317 sg13cmos5l_dfrbp_1_6.RESET_B a_4349_7636# 0.05796f
C5318 a_15850_4873# a_16164_4663# 0.00659f
C5319 sg13cmos5l_dfrbp_1_0.RESET_B a_16204_4338# 0
C5320 a_11072_5347# sg13cmos5l_inv_1_0.A 0.22179f
C5321 sg13cmos5l_a22oi_1_2.B2 a_10726_5760# 0.01675f
C5322 a_3664_4142# a_3578_2752# 0
C5323 sg13cmos5l_inv_1_27.Y a_11824_7894# 0
C5324 sg13cmos5l_buf_1_40.A a_904_7806# 0.0022f
C5325 a_620_7638# a_1088_7806# 0.00114f
C5326 a_422_5850# a_524_4614# 0
C5327 sg13cmos5l_buf_1_65.X sg13cmos5l_buf_1_45.X 0.15537f
C5328 sg13cmos5l_inv_1_1.A sg13cmos5l_inv_1_26.Y 0
C5329 sg13cmos5l_buf_1_93.X sg13cmos5l_buf_1_94.X 0.11064f
C5330 a_5132_3864# sg13cmos5l_buf_1_38.A 0.00151f
C5331 a_1662_8374# a_1664_7806# 0.00462f
C5332 a_11844_4325# sg13cmos5l_o21ai_1_0.A2 0
C5333 sg13cmos5l_dfrbp_1_0.CLK a_11656_3176# 0
C5334 a_18300_7710# cks 0
C5335 sg13cmos5l_inv_1_27.Y a_15045_8447# 0
C5336 a_14228_9484# a_14152_8522# 0
C5337 a_9291_8447# a_10308_7992# 0
C5338 a_10288_8678# a_10022_7674# 0
C5339 a_14295_7282# a_14089_7282# 0.2777f
C5340 a_17700_3456# nh_sw[8] 0
C5341 a_13775_6239# a_14032_6382# 0.35645f
C5342 a_13701_3117# nh_sw[6] 0
C5343 sg13cmos5l_buf_1_60.X ph_sw[1] 0.04174f
C5344 a_6507_8447# cks 0.01926f
C5345 sg13cmos5l_dfrbp_1_6.RESET_B a_15300_7687# 0.00602f
C5346 sg13cmos5l_a22oi_1_1.B1 a_13258_3361# 0
C5347 sg13cmos5l_dfrbp_1_0.RESET_B a_12520_3176# 0.00675f
C5348 a_19796_3436# a_20200_3270# 0.0303f
C5349 a_1864_9224# a_1484_9150# 0.07249f
C5350 a_2248_9224# sg13cmos5l_buf_1_61.X 0.01248f
C5351 sg13cmos5l_buf_1_60.X a_1000_9224# 0
C5352 a_13698_5412# a_13652_3900# 0
C5353 a_8247_5770# sg13cmos5l_dfrbp_1_12.Q_N 0
C5354 sg13cmos5l_a221oi_1_0.A2 a_6598_4663# 0
C5355 sg13cmos5l_or2_1_0.A a_6560_3270# 0
C5356 sg13cmos5l_dfrbp_1_6.RESET_B sg13cmos5l_a221oi_1_0.C1 0
C5357 sg13cmos5l_inv_1_7.A sg13cmos5l_dfrbp_1_6.D 0.02536f
C5358 a_18760_2388# a_17931_1748# 0
C5359 sg13cmos5l_dfrbp_1_8.RESET_B a_13297_9263# 0
C5360 a_14228_9484# sg13cmos5l_buf_1_94.X 0
C5361 sg13cmos5l_buf_1_95.X a_15784_9224# 0.00164f
C5362 a_14632_9224# sg13cmos5l_buf_1_93.X 0.28859f
C5363 a_2122_3868# sg13cmos5l_buf_1_38.A 0
C5364 sg13cmos5l_nand2_1_0.B a_10783_3876# 0.00474f
C5365 sg13cmos5l_nand2_1_0.A a_11973_1605# 0
C5366 sg13cmos5l_buf_1_45.X a_8905_4704# 0.0011f
C5367 sg13cmos5l_buf_1_4.A sg13cmos5l_buf_1_2.X 0.09225f
C5368 sg13cmos5l_dfrbp_1_2.D a_10464_2427# 0
C5369 sg13cmos5l_a22oi_1_1.B1 sg13cmos5l_dfrbp_1_0.CLK 0.20545f
C5370 a_19412_6484# a_19209_5769# 0.01685f
C5371 a_19593_6162# a_19734_5842# 0
C5372 a_2748_6126# VPWR 0.07585f
C5373 sg13cmos5l_dlhr_1_1.GATE a_4652_6126# 0.00323f
C5374 a_10412_6126# sg13cmos5l_a221oi_1_0.C1 0.00107f
C5375 sg13cmos5l_dfrbp_1_1.Q VPWR 1.2461f
C5376 sg13cmos5l_dfrbp_1_1.Q nl_sw[7] 0.00255f
C5377 a_10071_7282# sg13cmos5l_a221oi_1_0.C1 0.00112f
C5378 sg13cmos5l_nand2_1_0.B a_11556_3904# 0.00321f
C5379 sg13cmos5l_inv_1_20.Y a_3831_7282# 0
C5380 a_2122_3868# a_2148_3904# 0.43042f
C5381 sg13cmos5l_dfrbp_1_8.RESET_B sg13cmos5l_buf_1_103.A 0.00232f
C5382 a_14228_9484# a_14632_9224# 0.00464f
C5383 a_13648_9406# sg13cmos5l_inv_1_3.A 0
C5384 sg13cmos5l_dfrbp_1_23.CLK a_14708_6924# 0.00591f
C5385 a_18146_4338# a_18363_4270# 0
C5386 sg13cmos5l_dlhr_1_5.GATE a_5546_5850# 0
C5387 a_17414_3138# a_18219_3260# 0.11742f
C5388 a_17700_3456# a_18117_3117# 0.48921f
C5389 sg13cmos5l_inv_1_9.Y sg13cmos5l_buf_1_32.A 0.00646f
C5390 sg13cmos5l_nand2_1_1.B sg13cmos5l_dlhr_1_0.D 0.12504f
C5391 sg13cmos5l_inv_1_0.Y a_11372_3102# 0
C5392 sg13cmos5l_dfrbp_1_6.D a_18999_6178# 0
C5393 sg13cmos5l_buf_1_73.X a_5988_8440# 0.00946f
C5394 sg13cmos5l_dfrbp_1_10.Q sg13cmos5l_dlhr_1_2.Q 0.01946f
C5395 a_996_7349# a_1227_6935# 0.15089f
C5396 a_7497_3138# sg13cmos5l_dlhr_1_0.D 0
C5397 sg13cmos5l_buf_1_3.A a_20200_3270# 0.0093f
C5398 a_2409_4650# a_2667_3911# 0
C5399 a_2228_4972# a_2436_4325# 0
C5400 a_12841_7728# a_13178_7684# 0.64635f
C5401 a_13047_7690# a_13641_7674# 0.09085f
C5402 sg13cmos5l_dfrbp_1_10.Q a_5508_2813# 0
C5403 sg13cmos5l_inv_1_26.Y a_17751_7690# 0
C5404 a_4934_2826# a_5577_2435# 0.00806f
C5405 pl_sw[0] sg13cmos5l_buf_1_62.X 0
C5406 sg13cmos5l_buf_1_79.X sg13cmos5l_inv_1_29.A 0
C5407 sg13cmos5l_buf_1_90.X sg13cmos5l_buf_1_95.X 0.25455f
C5408 sg13cmos5l_or2_1_0.A a_5132_3864# 0.00595f
C5409 sg13cmos5l_dfrbp_1_8.RESET_B a_15177_5769# 0.00766f
C5410 sg13cmos5l_dfrbp_1_6.D sg13cmos5l_a221oi_1_0.B2 0
C5411 sg13cmos5l_buf_1_1.A a_17412_1944# 0
C5412 a_5069_5376# sg13cmos5l_dfrbp_1_14.Q_N 0
C5413 a_2148_8440# sg13cmos5l_buf_1_61.X 0
C5414 sg13cmos5l_buf_1_30.A a_8972_3864# 0
C5415 sg13cmos5l_buf_1_64.A a_4324_7996# 0
C5416 a_15887_8797# pl_sw[9] 0
C5417 sg13cmos5l_a22oi_1_1.A1 a_19796_3436# 0
C5418 sg13cmos5l_buf_1_65.X a_8084_8436# 0
C5419 a_10230_4632# sg13cmos5l_dfrbp_1_10.Q 0.00671f
C5420 sg13cmos5l_a22oi_1_1.Y a_17493_3947# 0.00826f
C5421 sg13cmos5l_dfrbp_1_6.RESET_B a_6219_6284# 0.55128f
C5422 sg13cmos5l_dfrbp_1_6.D sg13cmos5l_dlhr_1_13.Q_N 0.00495f
C5423 sg13cmos5l_buf_1_34.A nh_sw[3] 0
C5424 a_11556_3904# nl_sw[6] 0
C5425 sg13cmos5l_buf_1_78.X pl_sw[4] 0.00216f
C5426 sg13cmos5l_inv_1_1.A a_15300_7687# 0
C5427 sg13cmos5l_buf_1_8.A a_12815_1703# 0.00842f
C5428 sg13cmos5l_dfrbp_1_6.D a_4436_3436# 0.00495f
C5429 sg13cmos5l_or2_1_0.A a_2122_3868# 0.00957f
C5430 a_3574_7850# sg13cmos5l_dlhr_1_1.GATE 0
C5431 sg13cmos5l_or2_1_0.A a_17700_3456# 0.00444f
C5432 a_4076_7624# a_4282_8112# 0.00122f
C5433 sg13cmos5l_dfrbp_1_10.Q a_4873_3192# 0.26493f
C5434 sg13cmos5l_inv_1_27.Y sg13cmos5l_inv_1_0.A 0
C5435 a_15414_7354# a_15177_5769# 0.00274f
C5436 a_10230_4632# sg13cmos5l_inv_1_0.Y 0
C5437 a_3578_2752# a_3792_2388# 0.01249f
C5438 a_19227_9190# cks 0.52978f
C5439 sg13cmos5l_a221oi_1_0.C1 a_11182_4676# 0
C5440 sg13cmos5l_dfrbp_1_6.RESET_B a_8043_7796# 0.55545f
C5441 a_10998_9168# VPWR 0.2486f
C5442 sg13cmos5l_buf_1_5.A a_13392_7996# 0
C5443 sg13cmos5l_buf_1_19.A a_18746_5776# 0.05015f
C5444 sg13cmos5l_buf_1_77.X a_8972_9150# 0.29729f
C5445 sg13cmos5l_buf_1_74.X sg13cmos5l_buf_1_78.X 0.03701f
C5446 a_16779_6284# a_17721_6477# 0
C5447 a_16260_6480# a_16486_6175# 0.00523f
C5448 a_16677_6141# a_16548_6175# 0.01562f
C5449 a_12815_1703# sg13cmos5l_buf_1_1.A 0
C5450 sg13cmos5l_inv_1_8.A sg13cmos5l_dfrbp_1_6.RESET_B 0.9977f
C5451 a_14440_1664# a_14924_1590# 0.03472f
C5452 sg13cmos5l_buf_1_5.A sg13cmos5l_buf_1_8.A 0
C5453 sg13cmos5l_inv_1_2.A a_14342_8874# 0.0043f
C5454 sg13cmos5l_inv_1_0.A sg13cmos5l_dfrbp_1_2.D 0.03588f
C5455 sg13cmos5l_o21ai_1_0.B1 a_14543_3215# 0
C5456 a_7888_4870# a_8022_3120# 0
C5457 a_6405_8447# a_7504_8678# 0
C5458 a_5988_8440# a_7247_8797# 0.01741f
C5459 sg13cmos5l_inv_1_26.Y a_17498_8800# 0.00158f
C5460 sg13cmos5l_dfrbp_1_0.RESET_B a_15780_2813# 0.00793f
C5461 sg13cmos5l_inv_1_27.Y a_12490_6385# 0
C5462 a_15429_7653# VPWR 0.24492f
C5463 sg13cmos5l_buf_1_110.A a_14166_7656# 0
C5464 a_5079_3154# a_5492_3460# 0.15652f
C5465 sg13cmos5l_buf_8_1.A sg13cmos5l_nand2_1_1.A 0
C5466 sg13cmos5l_buf_1_3.A sg13cmos5l_a22oi_1_1.A1 0.09306f
C5467 a_524_4614# sg13cmos5l_nand2_1_2.B 0.00426f
C5468 sg13cmos5l_buf_1_5.A sg13cmos5l_buf_1_1.A 0.1933f
C5469 sg13cmos5l_a221oi_1_0.A2 a_10220_3102# 0
C5470 a_16748_9150# cks 0
C5471 sg13cmos5l_buf_1_96.A sg13cmos5l_inv_1_29.A 0
C5472 sg13cmos5l_dfrbp_1_16.Q a_4005_4629# 0
C5473 sg13cmos5l_a22oi_1_2.B2 a_10318_5412# 0.21571f
C5474 a_20672_1758# d_out[0] 0.00486f
C5475 sg13cmos5l_dfrbp_1_6.D sg13cmos5l_dfrbp_1_9.Q 0.11119f
C5476 sg13cmos5l_dfrbp_1_0.RESET_B a_17386_1849# 0.35401f
C5477 sg13cmos5l_buf_1_89.A sg13cmos5l_buf_1_4.A 0
C5478 sg13cmos5l_buf_1_93.X a_15793_8797# 0.0032f
C5479 a_17392_4870# a_17337_4965# 0.00464f
C5480 a_17972_4948# a_18480_5028# 0
C5481 a_16293_4629# sg13cmos5l_buf_8_1.A 0.0022f
C5482 sg13cmos5l_inv_1_3.A ph_sw[6] 0.00509f
C5483 a_9366_5842# VPWR 0.24986f
C5484 sg13cmos5l_dfrbp_1_0.RESET_B a_14814_3876# 0
C5485 sg13cmos5l_buf_1_65.X sg13cmos5l_dfrbp_1_20.Q_N 0
C5486 a_424_8436# VPWR 0.24898f
C5487 sg13cmos5l_buf_1_104.X a_20008_7712# 0
C5488 sg13cmos5l_inv_1_6.A sg13cmos5l_buf_1_18.A 0.03931f
C5489 sg13cmos5l_buf_1_38.A a_3241_2746# 0.00262f
C5490 sg13cmos5l_buf_1_110.A sg13cmos5l_a22oi_1_1.Y 0
C5491 a_13648_9406# cks 0
C5492 sg13cmos5l_dlhr_1_11.GATE sg13cmos5l_dlhr_1_18.Q_N 0.00165f
C5493 sg13cmos5l_buf_8_2.X a_19593_6162# 0
C5494 a_5416_9224# sg13cmos5l_buf_1_73.X 0.0388f
C5495 sg13cmos5l_buf_1_76.X a_5800_9224# 0.00997f
C5496 a_18368_4782# sg13cmos5l_dfrbp_1_0.RESET_B 0.00155f
C5497 sg13cmos5l_nand2_1_1.B a_14449_3215# 0.02145f
C5498 sg13cmos5l_dfrbp_1_5.Q_N sg13cmos5l_buf_1_18.X 0
C5499 a_9448_6924# VPWR 0.2572f
C5500 sg13cmos5l_dfrbp_1_1.Q a_11973_1605# 0
C5501 sg13cmos5l_dfrbp_1_18.Q_N cks 0.00343f
C5502 a_6346_4873# a_6372_4968# 0.43042f
C5503 sg13cmos5l_buf_1_28.X a_9544_2474# 0.00387f
C5504 sg13cmos5l_dfrbp_1_0.RESET_B a_12075_1748# 0.55146f
C5505 sg13cmos5l_buf_1_9.A sg13cmos5l_dfrbp_1_1.D 0.42377f
C5506 sg13cmos5l_dfrbp_1_6.RESET_B a_1948_7964# 0.46061f
C5507 a_10406_9624# ph_sw[5] 0
C5508 a_3313_4261# a_2757_3117# 0
C5509 sg13cmos5l_dlygate4sd3_1_0.X a_908_1590# 0
C5510 sg13cmos5l_inv_1_28.Y a_12361_7282# 0
C5511 sg13cmos5l_buf_1_18.X a_18671_1703# 0.00472f
C5512 a_19628_2352# a_19508_1924# 0.00228f
C5513 sg13cmos5l_buf_1_10.A a_11530_3868# 0
C5514 sg13cmos5l_buf_1_34.X a_4660_7312# 0.00121f
C5515 sg13cmos5l_or2_1_0.A a_7316_2388# 0
C5516 sg13cmos5l_inv_1_17.A a_4076_5376# 0.29954f
C5517 sg13cmos5l_inv_1_5.A a_20012_2352# 0
C5518 sg13cmos5l_inv_1_29.A sg13cmos5l_a221oi_1_0.B1 0.00453f
C5519 a_18363_4270# sg13cmos5l_buf_1_18.X 0
C5520 sg13cmos5l_nand2_1_0.A a_14056_1664# 0
C5521 sg13cmos5l_o21ai_1_0.A1 sg13cmos5l_buf_1_6.A 0
C5522 a_2638_6162# VPWR 0.00147f
C5523 sg13cmos5l_dlhr_1_14.Q_N a_14295_7282# 0
C5524 a_18928_1846# a_18873_1941# 0.00464f
C5525 sg13cmos5l_inv_1_18.A a_10224_9508# 0
C5526 sg13cmos5l_dlhr_1_5.GATE a_8852_6484# 0.00127f
C5527 a_1967_5773# VPWR 0.2715f
C5528 a_19624_8436# sg13cmos5l_buf_1_104.X 0.29315f
C5529 sg13cmos5l_dlhr_1_1.GATE a_2386_5850# 0
C5530 sg13cmos5l_buf_1_25.A a_7689_1626# 0
C5531 sg13cmos5l_dlygate4sd3_1_0.X ckc 0
C5532 sg13cmos5l_inv_1_29.Y a_12516_6480# 0
C5533 a_1967_7285# a_2748_6126# 0
C5534 sg13cmos5l_dfrbp_1_23.CLK sg13cmos5l_buf_1_89.A 0
C5535 a_18219_3260# a_19216_3358# 0.06778f
C5536 a_1878_6337# a_1997_6126# 0.1333f
C5537 sg13cmos5l_dfrbp_1_8.RESET_B a_7657_7282# 0
C5538 sg13cmos5l_a22oi_1_0.Y a_12075_3911# 0
C5539 sg13cmos5l_or2_1_0.A a_6198_3120# 0
C5540 sg13cmos5l_buf_8_0.X sg13cmos5l_dlhr_1_16.Q 0.04948f
C5541 sg13cmos5l_buf_1_65.X sg13cmos5l_buf_1_34.X 0.01094f
C5542 a_15016_9224# VPWR 0.24792f
C5543 sg13cmos5l_buf_1_73.X a_7504_8678# 0.00341f
C5544 sg13cmos5l_and3_1_0.C sg13cmos5l_dfrbp_1_0.RESET_B 0.00188f
C5545 sg13cmos5l_dfrbp_1_8.D a_18615_5770# 0.29552f
C5546 a_13641_7674# a_13574_8112# 0
C5547 a_13460_7996# a_13392_7996# 0
C5548 sg13cmos5l_dfrbp_1_10.Q a_8588_2352# 0
C5549 a_5739_2399# a_6385_2749# 0.00667f
C5550 a_7316_2388# a_7820_2352# 0.03266f
C5551 sg13cmos5l_inv_1_6.A sg13cmos5l_buf_1_0.A 0.09031f
C5552 sg13cmos5l_buf_1_34.X a_5637_2399# 0.00148f
C5553 a_620_7638# sg13cmos5l_inv_1_19.A 0
C5554 a_3302_4650# a_3945_5041# 0.00806f
C5555 a_3588_4968# a_4107_4772# 0.38902f
C5556 sg13cmos5l_buf_1_104.A sg13cmos5l_buf_1_105.A 0
C5557 a_19528_6924# VPWR 0.26327f
C5558 sg13cmos5l_buf_1_77.A a_10292_9508# 0
C5559 a_5710_5850# sg13cmos5l_dlhr_1_0.GATE 0
C5560 sg13cmos5l_buf_1_30.X nl_sw[4] 0.02586f
C5561 sg13cmos5l_buf_1_4.A a_16233_5041# 0
C5562 sg13cmos5l_inv_1_17.A a_4518_7996# 0
C5563 sg13cmos5l_buf_1_4.A sg13cmos5l_dfrbp_1_0.CLK 0.33271f
C5564 a_12132_9504# a_12549_9165# 0.48921f
C5565 a_11846_9186# a_12651_9308# 0.11742f
C5566 a_8680_1664# nl_sw[4] 0.01172f
C5567 sg13cmos5l_dfrbp_1_6.D a_14822_6924# 0
C5568 sg13cmos5l_dfrbp_1_6.RESET_B a_5988_6175# 0.00152f
C5569 a_20672_5498# ph_sw[10] 0
C5570 a_9033_6162# a_8660_5412# 0.00635f
C5571 a_8570_6172# a_8841_5769# 0.00745f
C5572 a_1946_4660# a_2122_3868# 0
C5573 cks ph_sw[6] 0
C5574 a_2228_4972# a_1862_4338# 0
C5575 sg13cmos5l_or2_1_0.A a_1290_3206# 0.00412f
C5576 sg13cmos5l_buf_1_57.X a_14726_7674# 0.29958f
C5577 sg13cmos5l_dfrbp_1_6.RESET_B a_8276_6924# 0.12814f
C5578 sg13cmos5l_dlhr_1_2.D sg13cmos5l_dlhr_1_2.Q 0
C5579 sg13cmos5l_buf_1_33.A a_3008_1758# 0.00224f
C5580 a_2732_1590# VPWR 0.2588f
C5581 a_4456_1664# nl_sw[2] 0.00187f
C5582 a_4324_7996# VPWR 0.35964f
C5583 sg13cmos5l_inv_1_26.Y sg13cmos5l_buf_1_86.A 0
C5584 sg13cmos5l_inv_1_18.A a_10028_6126# 0.28922f
C5585 sg13cmos5l_dlhr_1_2.D a_5508_2813# 0
C5586 sg13cmos5l_dfrbp_1_0.CLK d_out[1] 0
C5587 sg13cmos5l_dlhr_1_15.D a_13036_4948# 0
C5588 sg13cmos5l_dfrbp_1_8.RESET_B a_682_6892# 0
C5589 sg13cmos5l_buf_1_77.A a_9344_7010# 0
C5590 a_7216_6382# a_7378_6162# 0.0019f
C5591 sg13cmos5l_dfrbp_1_6.RESET_B a_9620_7972# 0
C5592 a_9879_9202# sg13cmos5l_dfrbp_1_20.Q 0
C5593 sg13cmos5l_buf_1_5.A a_13876_7660# 0
C5594 sg13cmos5l_buf_1_19.A a_19164_5814# 0.00187f
C5595 a_17776_6382# a_17425_6239# 0.01017f
C5596 a_17519_6239# sg13cmos5l_dfrbp_1_21.Q_N 0.04398f
C5597 a_15784_1664# sg13cmos5l_buf_1_1.A 0.01071f
C5598 sg13cmos5l_dfrbp_1_12.Q_N a_8022_3120# 0
C5599 a_7888_4870# sg13cmos5l_dlhr_1_2.Q 0
C5600 sg13cmos5l_inv_1_2.A a_14916_8861# 0.00604f
C5601 sg13cmos5l_buf_1_34.X sg13cmos5l_dfrbp_1_9.Q_N 0.00191f
C5602 sg13cmos5l_or2_1_0.A a_1402_3864# 0.00928f
C5603 a_7504_8678# a_7247_8797# 0.35645f
C5604 sg13cmos5l_a221oi_1_0.B2 a_11873_5760# 0.0067f
C5605 a_16473_7989# VPWR 0
C5606 a_7052_9150# ph_sw[4] 0.00276f
C5607 a_5492_3460# a_5606_3576# 0.00122f
C5608 sg13cmos5l_inv_1_27.Y a_13775_6239# 0.00142f
C5609 sg13cmos5l_buf_1_86.A sg13cmos5l_dlhr_1_10.Q 0
C5610 sg13cmos5l_dfrbp_1_16.Q a_4847_4727# 0
C5611 sg13cmos5l_nor2_1_0.A sg13cmos5l_dfrbp_1_0.RESET_B 0.42307f
C5612 sg13cmos5l_buf_1_2.A sg13cmos5l_nor2b_1_1.Y 0
C5613 a_3241_2746# a_3578_2752# 0.64635f
C5614 a_3447_2746# a_3793_2790# 0.00722f
C5615 sg13cmos5l_buf_1_43.A sg13cmos5l_inv_1_8.Y 0.11034f
C5616 a_2879_6432# a_3588_4968# 0
C5617 a_3308_9150# a_2148_8440# 0
C5618 sg13cmos5l_buf_1_65.X a_2122_8404# 0
C5619 sg13cmos5l_dfrbp_1_0.D sg13cmos5l_buf_8_1.A 0.2126f
C5620 sg13cmos5l_dfrbp_1_6.RESET_B a_14714_5776# 0.01766f
C5621 a_13072_4142# a_12719_2749# 0
C5622 a_12815_4261# a_12976_2630# 0
C5623 sg13cmos5l_buf_1_3.A sg13cmos5l_or2_1_0.A 0.00439f
C5624 sg13cmos5l_dfrbp_1_8.RESET_B a_4640_3986# 0
C5625 a_6117_6141# a_5820_5773# 0.01066f
C5626 sg13cmos5l_dfrbp_1_6.RESET_B a_708_6928# 0.47463f
C5627 sg13cmos5l_dfrbp_1_18.Q a_10450_8874# 0
C5628 a_6346_4873# sg13cmos5l_dlhr_1_2.D 0
C5629 sg13cmos5l_buf_1_38.A a_4276_2776# 0.00129f
C5630 sg13cmos5l_buf_1_29.A sg13cmos5l_a22oi_1_1.B1 0
C5631 a_10998_9168# sg13cmos5l_buf_1_97.A 0.5724f
C5632 sg13cmos5l_buf_1_63.X a_996_7349# 0
C5633 sg13cmos5l_dlhr_1_11.GATE a_12913_7326# 0
C5634 sg13cmos5l_dlhr_1_15.D a_18164_7996# 0
C5635 sg13cmos5l_buf_1_30.A a_8378_5776# 0
C5636 sg13cmos5l_inv_1_18.A sg13cmos5l_dfrbp_1_16.Q 0.04856f
C5637 sg13cmos5l_dlhr_1_15.Q_N cko 0
C5638 sg13cmos5l_buf_1_40.X sg13cmos5l_buf_1_32.A 0.06413f
C5639 a_11464_8436# a_11567_7751# 0
C5640 sg13cmos5l_buf_1_96.A a_10022_7674# 0
C5641 sg13cmos5l_dfrbp_1_1.Q a_14056_1664# 0.12316f
C5642 sg13cmos5l_dfrbp_1_9.Q a_5425_3130# 0
C5643 a_11782_1639# nh_sw[6] 0
C5644 a_6086_4650# a_7631_4727# 0
C5645 sg13cmos5l_inv_1_8.A a_5452_5850# 0
C5646 sg13cmos5l_dfrbp_1_0.RESET_B a_14440_1664# 0
C5647 sg13cmos5l_dfrbp_1_6.RESET_B a_1664_7806# 0
C5648 a_2667_3911# sg13cmos5l_dfrbp_1_10.Q_N 0
C5649 a_620_7638# a_904_7806# 0.01225f
C5650 sg13cmos5l_dfrbp_1_9.Q_N a_3599_3215# 0
C5651 a_3664_4142# a_3505_3215# 0
C5652 sg13cmos5l_a22oi_1_2.B1 a_9544_2474# 0.02904f
C5653 sg13cmos5l_dfrbp_1_6.RESET_B a_6022_4325# 0
C5654 a_2727_6380# sg13cmos5l_dlhr_1_1.Q 0
C5655 sg13cmos5l_or2_1_0.A sg13cmos5l_dlhr_1_0.D 0
C5656 a_14458_4270# VPWR 0
C5657 sg13cmos5l_inv_1_7.A sg13cmos5l_buf_1_9.A 0
C5658 sg13cmos5l_inv_1_14.A a_6380_7638# 0.00108f
C5659 a_424_3270# a_416_2474# 0.00235f
C5660 sg13cmos5l_buf_1_45.X sg13cmos5l_dfrbp_1_18.Q_N 0.00245f
C5661 a_14536_7806# a_14426_7288# 0
C5662 a_1290_3206# a_1672_3176# 0.005f
C5663 a_6117_6141# VPWR 0.25143f
C5664 a_17700_1639# a_17638_1639# 0
C5665 a_13391_9263# sg13cmos5l_buf_1_98.A 0.00441f
C5666 a_2565_3911# a_2859_3260# 0
C5667 sg13cmos5l_dlhr_1_1.GATE a_4358_6924# 0
C5668 sg13cmos5l_buf_1_3.A a_19904_7806# 0.00537f
C5669 sg13cmos5l_dfrbp_1_16.Q a_3669_6320# 0.03245f
C5670 a_1967_7285# a_2638_6162# 0
C5671 sg13cmos5l_buf_1_26.X sg13cmos5l_buf_1_28.A 0.15174f
C5672 sg13cmos5l_dlhr_1_11.GATE a_10282_7897# 0.00287f
C5673 sg13cmos5l_dfrbp_1_8.RESET_B a_10827_7796# 0
C5674 sg13cmos5l_buf_1_41.A a_3625_7282# 0.00445f
C5675 a_19796_3436# sg13cmos5l_buf_1_3.X 0.00465f
C5676 a_1967_7285# a_1967_5773# 0.00599f
C5677 sg13cmos5l_dlhr_1_0.Q a_8214_1608# 0.57296f
C5678 a_1997_6126# a_2727_6380# 0.3087f
C5679 sg13cmos5l_a22oi_1_1.B2 a_12815_4261# 0
C5680 sg13cmos5l_dfrbp_1_6.D sg13cmos5l_buf_1_41.A 0.04437f
C5681 a_15887_8797# a_16485_6935# 0.00495f
C5682 sg13cmos5l_buf_1_2.A sg13cmos5l_a22oi_1_1.B1 0.01153f
C5683 a_7941_7653# VPWR 0.24426f
C5684 a_12549_9165# sg13cmos5l_buf_1_93.X 0
C5685 sg13cmos5l_inv_1_1.A a_14714_5776# 0.00329f
C5686 sg13cmos5l_buf_1_45.X a_8468_4948# 0.02271f
C5687 sg13cmos5l_dlhr_1_1.GATE a_4514_7666# 0
C5688 sg13cmos5l_buf_1_78.A sg13cmos5l_dfrbp_1_8.RESET_B 0.16778f
C5689 sg13cmos5l_dfrbp_1_8.D a_19209_5769# 0
C5690 a_1760_9318# VPWR 0.07064f
C5691 sg13cmos5l_dlygate4sd2_1_0.X a_1290_3206# 0.2885f
C5692 sg13cmos5l_dfrbp_1_9.Q a_3826_4338# 0
C5693 sg13cmos5l_buf_1_34.X a_6479_2749# 0
C5694 a_7820_2352# sg13cmos5l_dlhr_1_0.D 0.00244f
C5695 sg13cmos5l_inv_1_7.A a_12800_5498# 0
C5696 a_9366_5842# sg13cmos5l_dlhr_1_17.Q_N 0.12876f
C5697 a_4005_4629# a_4847_4727# 0.00437f
C5698 a_3588_4968# a_5104_4870# 0.00294f
C5699 a_2436_8861# cks 0
C5700 a_902_3142# cks 0
C5701 sg13cmos5l_nor2b_1_0.Y a_13234_4338# 0.00133f
C5702 sg13cmos5l_nand2_1_0.B a_11182_4676# 0
C5703 sg13cmos5l_buf_1_44.X a_4076_7624# 0
C5704 sg13cmos5l_a22oi_1_0.Y a_11973_3911# 0
C5705 sg13cmos5l_dlhr_1_0.Q_N nl_sw[4] 0.04227f
C5706 a_1609_4704# a_1672_3176# 0
C5707 a_18272_9318# pl_sw[9] 0
C5708 a_12651_9308# a_13648_9406# 0.06778f
C5709 a_12132_9504# sg13cmos5l_inv_1_27.Y 0
C5710 a_1125_6935# a_2224_7166# 0
C5711 sg13cmos5l_buf_1_4.X a_17224_3270# 0.06221f
C5712 a_16940_3102# a_17414_3138# 0.00269f
C5713 sg13cmos5l_dfrbp_1_6.D a_17233_7285# 0.00141f
C5714 a_8852_6484# sg13cmos5l_buf_1_45.A 0
C5715 sg13cmos5l_nand2_1_0.A a_10783_4292# 0.01731f
C5716 sg13cmos5l_or2_1_0.A a_2697_3529# 0
C5717 sg13cmos5l_inv_1_17.A nh_sw[2] 0
C5718 sg13cmos5l_buf_1_30.A a_6903_3154# 0
C5719 sg13cmos5l_nor2b_1_0.Y a_13520_4696# 0.00143f
C5720 sg13cmos5l_dfrbp_1_8.RESET_B a_4034_7660# 0
C5721 a_1402_3864# sg13cmos5l_dlygate4sd2_1_0.X 0.52475f
C5722 VPWR nl_sw[2] 0.14226f
C5723 sg13cmos5l_dlhr_1_2.D a_8588_2352# 0
C5724 nl_sw[3] nh_sw[3] 0.29731f
C5725 sg13cmos5l_a22oi_1_0.B1 VPWR 0.66113f
C5726 sg13cmos5l_buf_1_34.X a_5492_3460# 0
C5727 sg13cmos5l_buf_1_3.A sg13cmos5l_buf_1_3.X 0.18538f
C5728 sg13cmos5l_nor2b_1_0.Y a_11530_3868# 0.00858f
C5729 sg13cmos5l_dlhr_1_6.D sg13cmos5l_dlhr_1_6.Q_N 0.0058f
C5730 sg13cmos5l_buf_1_8.X nl_sw[5] 0
C5731 a_19227_9190# pl_sw[9] 0.00101f
C5732 sg13cmos5l_buf_1_79.X a_11567_7751# 0
C5733 sg13cmos5l_dfrbp_1_6.RESET_B a_20672_5498# 0
C5734 sg13cmos5l_dfrbp_1_15.D a_3488_7010# 0.00138f
C5735 sg13cmos5l_buf_1_31.X sg13cmos5l_buf_1_56.A 0.17566f
C5736 sg13cmos5l_dlhr_1_5.Q a_8966_6600# 0.00138f
C5737 sg13cmos5l_dfrbp_1_12.Q_N sg13cmos5l_dlhr_1_2.Q 0
C5738 sg13cmos5l_dlygate4sd2_1_0.A sg13cmos5l_dlygate4sd3_1_0.X 0.17933f
C5739 a_1609_4704# sg13cmos5l_dlygate4sd2_1_0.X 0
C5740 sg13cmos5l_dfrbp_1_1.Q a_20012_2352# 0.0062f
C5741 sg13cmos5l_dlhr_1_5.Q a_10202_7288# 0.00216f
C5742 sg13cmos5l_dfrbp_1_6.RESET_B sg13cmos5l_buf_1_103.A 0
C5743 a_8084_8436# sg13cmos5l_dfrbp_1_18.Q_N 0.25039f
C5744 sg13cmos5l_dfrbp_1_6.D a_14708_6924# 0.00532f
C5745 sg13cmos5l_dfrbp_1_0.RESET_B sg13cmos5l_buf_1_18.X 0.00732f
C5746 sg13cmos5l_a221oi_1_0.B1 sg13cmos5l_a22oi_1_1.B2 0
C5747 a_7336_9224# cks 0
C5748 sg13cmos5l_buf_1_110.A a_15369_8065# 0
C5749 sg13cmos5l_buf_1_6.A sg13cmos5l_nor2b_1_1.Y 0.12275f
C5750 a_1815_4666# a_2409_4650# 0.09085f
C5751 a_1609_4704# a_1946_4660# 0.64635f
C5752 a_16748_9150# pl_sw[9] 0
C5753 a_1846_7850# VPWR 0.25484f
C5754 sg13cmos5l_dfrbp_1_20.Q a_10202_7288# 0.04177f
C5755 a_2621_7636# sg13cmos5l_dlhr_1_1.GATE 0
C5756 sg13cmos5l_dfrbp_1_10.Q a_3856_3358# 0
C5757 sg13cmos5l_dfrbp_1_1.Q a_18873_1941# 0
C5758 sg13cmos5l_dfrbp_1_0.RESET_B a_17700_1639# 0.00454f
C5759 sg13cmos5l_buf_1_24.A sg13cmos5l_dlhr_1_0.GATE 0.50561f
C5760 sg13cmos5l_a221oi_1_0.C1 a_11980_4948# 0.01294f
C5761 sg13cmos5l_buf_1_65.X a_3407_8797# 0.0017f
C5762 sg13cmos5l_dfrbp_1_6.RESET_B a_15177_5769# 0.46999f
C5763 a_6219_6284# a_5951_5383# 0
C5764 sg13cmos5l_buf_1_7.A a_12998_3138# 0.0053f
C5765 sg13cmos5l_dfrbp_1_16.Q a_6843_5459# 0
C5766 sg13cmos5l_dfrbp_1_10.Q_N nh_sw[1] 0.00236f
C5767 a_7941_7653# a_8233_6216# 0
C5768 a_8043_7796# a_8439_6178# 0
C5769 sg13cmos5l_dlhr_1_9.Q a_3876_4663# 0
C5770 sg13cmos5l_dfrbp_1_0.CLK a_11748_2813# 0.00242f
C5771 sg13cmos5l_buf_1_96.A a_11567_7751# 0.0128f
C5772 a_3599_3215# a_3447_2746# 0
C5773 a_17108_7972# a_16677_6141# 0
C5774 a_6372_4968# a_7537_4727# 0.4858f
C5775 a_6891_4772# a_6660_4663# 0.15089f
C5776 sg13cmos5l_inv_1_8.A a_5951_5383# 0.3838f
C5777 sg13cmos5l_buf_1_89.A a_15592_6200# 0
C5778 sg13cmos5l_dlhr_1_13.Q_N sg13cmos5l_buf_1_116.A 0.00195f
C5779 a_12651_9308# ph_sw[6] 0.03216f
C5780 sg13cmos5l_o21ai_1_0.A2 a_11002_3142# 0.01829f
C5781 sg13cmos5l_a22oi_1_1.B1 sg13cmos5l_dfrbp_1_6.Q_N 0
C5782 sg13cmos5l_dlhr_1_11.GATE a_12841_7728# 0.04007f
C5783 sg13cmos5l_dfrbp_1_18.Q sg13cmos5l_dfrbp_1_8.RESET_B 0.19856f
C5784 a_8488_9224# VPWR 0.24762f
C5785 sg13cmos5l_inv_1_3.A sg13cmos5l_buf_1_101.X 0
C5786 sg13cmos5l_buf_1_45.X a_8998_8861# 0
C5787 sg13cmos5l_buf_1_63.A sg13cmos5l_buf_1_58.A 0
C5788 sg13cmos5l_inv_1_1.A sg13cmos5l_buf_1_103.A 0.06522f
C5789 a_7161_6477# VPWR 0
C5790 a_2054_3138# a_2757_3117# 0.02453f
C5791 a_2314_3361# a_2859_3260# 0.00999f
C5792 a_14820_7674# sg13cmos5l_dfrbp_1_23.Q 0
C5793 sg13cmos5l_dfrbp_1_0.CLK sg13cmos5l_buf_1_8.X 0
C5794 a_16356_7349# cks 0.02633f
C5795 a_17337_4965# VPWR 0
C5796 sg13cmos5l_buf_1_25.A a_8576_1758# 0
C5797 sg13cmos5l_a221oi_1_0.A2 sg13cmos5l_a221oi_1_0.B1 0
C5798 sg13cmos5l_inv_1_8.A a_3016_9318# 0.02118f
C5799 sg13cmos5l_dfrbp_1_9.Q a_5210_3148# 0.0058f
C5800 sg13cmos5l_a22oi_1_1.B1 sg13cmos5l_buf_1_6.A 0
C5801 sg13cmos5l_dfrbp_1_0.RESET_B sg13cmos5l_o21ai_1_0.Y 1.0207f
C5802 a_2727_6380# a_2638_6477# 0
C5803 a_2879_6432# a_3575_6553# 0.02431f
C5804 a_2380_6162# a_2748_6126# 0.00159f
C5805 sg13cmos5l_buf_1_60.X sg13cmos5l_buf_1_61.X 0.03597f
C5806 sg13cmos5l_dfrbp_1_16.Q a_3308_5376# 0.00179f
C5807 sg13cmos5l_a22oi_1_1.B2 sg13cmos5l_nand2_1_1.A 0
C5808 sg13cmos5l_dfrbp_1_6.RESET_B sg13cmos5l_a221oi_1_1.C1 0
C5809 a_1997_6126# a_1227_5423# 0.01103f
C5810 sg13cmos5l_dlhr_1_15.D a_17354_4180# 0
C5811 sg13cmos5l_buf_1_90.X sg13cmos5l_dfrbp_1_24.Q_N 0
C5812 sg13cmos5l_inv_1_27.Y sg13cmos5l_buf_1_93.X 0.0619f
C5813 sg13cmos5l_buf_1_95.X sg13cmos5l_buf_1_110.A 0.12825f
C5814 a_9040_7894# VPWR 0.14601f
C5815 sg13cmos5l_inv_1_1.A a_15177_5769# 0.05522f
C5816 sg13cmos5l_inv_1_3.A a_13100_8400# 0
C5817 sg13cmos5l_nand2_1_1.B a_12075_3911# 0
C5818 sg13cmos5l_dlhr_1_14.Q_N a_14726_7674# 0.02081f
C5819 sg13cmos5l_buf_1_34.X a_5577_2435# 0
C5820 a_416_3986# ckc 0.00251f
C5821 a_4107_4772# a_4753_4727# 0.00667f
C5822 sg13cmos5l_a22oi_1_1.B2 a_16293_4629# 0
C5823 a_2505_8483# cks 0
C5824 sg13cmos5l_buf_1_73.A a_5988_8440# 0.00278f
C5825 sg13cmos5l_nor2_1_2.A a_620_2352# 0.00181f
C5826 sg13cmos5l_dfrbp_1_10.Q sg13cmos5l_buf_1_28.X 0.1091f
C5827 a_10412_6126# sg13cmos5l_a221oi_1_1.C1 0.00109f
C5828 sg13cmos5l_buf_1_25.A VPWR 0.57532f
C5829 a_10071_7282# sg13cmos5l_a221oi_1_1.C1 0.00314f
C5830 a_14228_9484# sg13cmos5l_inv_1_27.Y 0.03566f
C5831 sg13cmos5l_buf_1_3.A a_20392_2388# 0.01174f
C5832 a_2409_4650# a_2859_3260# 0
C5833 sg13cmos5l_dlhr_1_10.Q a_20288_7010# 0
C5834 sg13cmos5l_inv_1_9.Y sg13cmos5l_buf_1_40.X 0
C5835 sg13cmos5l_dfrbp_1_8.RESET_B a_4244_6924# 0
C5836 sg13cmos5l_buf_1_19.A cks 0.01822f
C5837 sg13cmos5l_buf_1_43.A sg13cmos5l_buf_1_32.A 0.00407f
C5838 sg13cmos5l_buf_1_77.A sg13cmos5l_or2_1_1.B 0
C5839 sg13cmos5l_buf_1_76.X a_6405_8447# 0
C5840 sg13cmos5l_dlygate4sd2_1_0.A a_2054_3138# 0
C5841 a_14377_5770# VPWR 0.421f
C5842 sg13cmos5l_inv_1_0.A a_13072_4142# 0.00771f
C5843 sg13cmos5l_dlhr_1_20.Q_N VPWR 0.2625f
C5844 sg13cmos5l_dfrbp_1_21.Q a_13034_5412# 0
C5845 sg13cmos5l_dfrbp_1_8.RESET_B sg13cmos5l_inv_1_3.A 0.99441f
C5846 sg13cmos5l_buf_1_79.X sg13cmos5l_dlhr_1_11.D 0
C5847 sg13cmos5l_buf_1_31.X a_4107_4772# 0
C5848 a_19904_7806# a_19593_6162# 0
C5849 sg13cmos5l_buf_1_4.A sg13cmos5l_buf_1_2.A 0.07022f
C5850 a_10094_2780# nl_sw[5] 0
C5851 sg13cmos5l_dlhr_1_5.GATE a_2748_6126# 0
C5852 sg13cmos5l_nor2_1_2.A cks 0
C5853 a_8486_8874# a_8580_8874# 0.00718f
C5854 sg13cmos5l_buf_1_107.X cks 0.55505f
C5855 a_9879_9202# a_10308_7992# 0
C5856 sg13cmos5l_dfrbp_1_6.D sg13cmos5l_buf_1_89.A 0.03518f
C5857 sg13cmos5l_dfrbp_1_6.RESET_B a_7657_7282# 0.0397f
C5858 sg13cmos5l_buf_1_33.A a_4840_1664# 0
C5859 sg13cmos5l_buf_1_39.A a_3688_1664# 0.32462f
C5860 a_1946_4660# a_2160_4972# 0.01249f
C5861 a_1480_7806# VPWR 0.13119f
C5862 a_4076_7624# sg13cmos5l_dlhr_1_9.Q 0.03734f
C5863 sg13cmos5l_dfrbp_1_20.Q sg13cmos5l_dlhr_1_18.Q_N 0
C5864 sg13cmos5l_buf_8_0.X a_20392_7712# 0.32946f
C5865 a_5408_3986# VPWR 0.07633f
C5866 sg13cmos5l_buf_8_1.A a_16572_4261# 0.09861f
C5867 a_1948_7964# a_2224_7166# 0
C5868 a_4276_2776# sg13cmos5l_buf_1_34.A 0
C5869 sg13cmos5l_dlygate4sd2_1_0.A a_2228_4972# 0
C5870 sg13cmos5l_buf_1_101.X cks 0.09683f
C5871 sg13cmos5l_dfrbp_1_6.RESET_B a_18746_5776# 0.0185f
C5872 a_5988_6175# a_5951_5383# 0
C5873 a_8276_6924# a_8439_6178# 0.0104f
C5874 a_7820_9150# a_8204_9150# 0.00492f
C5875 sg13cmos5l_buf_1_5.A sg13cmos5l_nor2b_1_1.Y 0.10515f
C5876 sg13cmos5l_inv_1_2.A sg13cmos5l_buf_1_98.A 0
C5877 a_12896_3270# a_12625_2749# 0
C5878 sg13cmos5l_buf_1_7.A a_14800_3358# 0
C5879 a_13284_3456# a_12719_2749# 0.00951f
C5880 sg13cmos5l_buf_1_10.A a_11190_7354# 0.00433f
C5881 a_4736_5498# sg13cmos5l_inv_1_19.A 0
C5882 sg13cmos5l_buf_1_103.A a_17498_8800# 0
C5883 a_18480_5028# a_18368_4782# 0.01147f
C5884 sg13cmos5l_or2_1_1.B a_13034_5412# 0.01526f
C5885 sg13cmos5l_buf_1_95.X a_14166_7656# 0
C5886 sg13cmos5l_dfrbp_1_10.Q_N a_5492_3460# 0
C5887 a_524_4614# sg13cmos5l_inv_1_8.Y 0.00138f
C5888 sg13cmos5l_a221oi_1_0.A2 sg13cmos5l_inv_1_11.Y 0
C5889 a_4436_3436# a_4041_2745# 0.00728f
C5890 a_3505_3215# a_3241_2746# 0
C5891 sg13cmos5l_dfrbp_1_10.Q_N a_3447_2746# 0.00197f
C5892 sg13cmos5l_buf_1_73.X a_7820_9150# 0.28859f
C5893 sg13cmos5l_dfrbp_1_6.RESET_B a_682_6892# 0.34054f
C5894 a_13100_8400# cks 0.00982f
C5895 a_7631_4727# sg13cmos5l_dfrbp_1_11.Q_N 0.04107f
C5896 a_7888_4870# a_7537_4727# 0.01017f
C5897 sg13cmos5l_dfrbp_1_15.D a_5988_8440# 0
C5898 a_10783_3876# sg13cmos5l_dfrbp_1_4.D 0
C5899 sg13cmos5l_dfrbp_1_8.RESET_B a_4244_3900# 0
C5900 sg13cmos5l_buf_1_104.A VPWR 0.31563f
C5901 sg13cmos5l_inv_1_8.A pl_sw[2] 0.00152f
C5902 sg13cmos5l_buf_1_65.X sg13cmos5l_buf_1_79.X 0
C5903 sg13cmos5l_dlhr_1_11.GATE a_11986_7674# 0
C5904 a_15177_5769# a_15702_4187# 0.00156f
C5905 sg13cmos5l_dfrbp_1_11.Q sg13cmos5l_buf_1_25.A 0
C5906 sg13cmos5l_buf_1_76.X sg13cmos5l_buf_1_73.X 0.02068f
C5907 sg13cmos5l_dlhr_1_15.D a_14426_7288# 0
C5908 a_2859_3260# a_3599_3215# 0.3087f
C5909 a_2314_3361# a_2628_3151# 0.00659f
C5910 a_2757_3117# a_3856_3358# 0
C5911 sg13cmos5l_inv_1_14.A sg13cmos5l_dfrbp_1_1.Q 0
C5912 a_11752_6294# sg13cmos5l_a221oi_1_0.B1 0
C5913 a_620_7638# a_416_7806# 0.03376f
C5914 a_16425_6971# cks 0
C5915 a_14924_1590# nh_sw[6] 0.28943f
C5916 a_12358_9199# VPWR 0
C5917 sg13cmos5l_dfrbp_1_9.Q sg13cmos5l_dlhr_1_4.Q_N 0
C5918 a_2565_3911# sg13cmos5l_buf_1_41.X 0
C5919 a_3575_6553# a_3771_6553# 0.00806f
C5920 a_2380_6162# a_2638_6162# 0.01017f
C5921 sg13cmos5l_dfrbp_1_8.RESET_B cks 6.13911f
C5922 sg13cmos5l_dfrbp_1_9.Q a_4041_2745# 0
C5923 sg13cmos5l_buf_1_3.A a_19412_6484# 0.0518f
C5924 a_2380_6162# a_1967_5773# 0.00801f
C5925 a_2879_6432# a_2804_5412# 0.00528f
C5926 sg13cmos5l_dfrbp_1_6.RESET_B a_4640_3986# 0
C5927 sg13cmos5l_dlhr_1_9.D a_4736_5498# 0.00282f
C5928 a_20488_5498# VPWR 0.11891f
C5929 sg13cmos5l_buf_1_57.X a_13792_5760# 0
C5930 a_14726_7674# a_15012_7992# 0.50066f
C5931 sg13cmos5l_buf_1_5.A sg13cmos5l_a22oi_1_1.B1 0.02619f
C5932 a_17516_9150# VPWR 0.2516f
C5933 sg13cmos5l_buf_1_4.A sg13cmos5l_dfrbp_1_6.Q_N 0.00395f
C5934 a_4847_4727# sg13cmos5l_dfrbp_1_14.Q_N 0.04107f
C5935 a_5104_4870# a_4753_4727# 0.01017f
C5936 a_7820_9150# a_7247_8797# 0.00648f
C5937 sg13cmos5l_buf_1_73.A a_7504_8678# 0.01629f
C5938 a_1862_8874# a_1956_8874# 0.00718f
C5939 sg13cmos5l_buf_1_26.A a_7689_1626# 0.00114f
C5940 sg13cmos5l_dfrbp_1_10.Q sg13cmos5l_a22oi_1_2.B1 0
C5941 a_15414_7354# cks 0
C5942 sg13cmos5l_dfrbp_1_11.Q a_5408_3986# 0
C5943 sg13cmos5l_buf_1_19.A a_18219_3260# 0.01819f
C5944 sg13cmos5l_nor2b_1_0.Y a_13092_3138# 0
C5945 sg13cmos5l_dfrbp_1_9.Q a_2340_3456# 0.105f
C5946 sg13cmos5l_buf_1_10.A sg13cmos5l_dfrbp_1_21.Q 0.06002f
C5947 a_424_9318# VPWR 0.12063f
C5948 sg13cmos5l_nand2_1_1.B a_11973_3911# 0
C5949 a_1948_7964# pl_sw[2] 0
C5950 a_15147_8447# sg13cmos5l_buf_1_89.A 0
C5951 sg13cmos5l_dlhr_1_1.GATE a_1125_5423# 0.3883f
C5952 sg13cmos5l_buf_1_65.X sg13cmos5l_buf_1_60.A 0.03565f
C5953 a_14996_5412# VPWR 0.10796f
C5954 sg13cmos5l_buf_1_30.A sg13cmos5l_dfrbp_1_10.Q 0.014f
C5955 sg13cmos5l_inv_1_0.A sg13cmos5l_dfrbp_1_2.Q_N 0
C5956 sg13cmos5l_buf_1_4.A sg13cmos5l_buf_1_6.A 0
C5957 sg13cmos5l_inv_1_6.A sg13cmos5l_buf_8_0.A 0.1408f
C5958 a_8660_5412# a_8841_5769# 0.40925f
C5959 sg13cmos5l_dfrbp_1_21.Q a_15702_5842# 0.01135f
C5960 a_11556_1944# nl_sw[6] 0.0302f
C5961 a_1662_8374# cks 0.00223f
C5962 sg13cmos5l_buf_1_87.A a_18856_8436# 0.02862f
C5963 a_19227_4654# a_18959_3215# 0.00722f
C5964 a_708_6928# a_2224_7166# 0.00159f
C5965 a_934_7349# a_996_7349# 0
C5966 a_13161_7281# sg13cmos5l_dlhr_1_6.D 0.00314f
C5967 sg13cmos5l_buf_1_31.X a_5104_4870# 0
C5968 a_11182_4948# sg13cmos5l_o21ai_1_0.A1 0.4524f
C5969 sg13cmos5l_buf_8_1.A a_16011_2399# 0
C5970 sg13cmos5l_nand2_1_1.A sg13cmos5l_dfrbp_1_3.Q_N 0.00281f
C5971 a_1864_9224# sg13cmos5l_buf_1_65.X 0.00794f
C5972 a_2248_9224# sg13cmos5l_inv_1_20.Y 0
C5973 sg13cmos5l_buf_1_60.X a_3308_9150# 0.00353f
C5974 a_8486_8874# a_9291_8447# 0.11742f
C5975 sg13cmos5l_dfrbp_1_6.RESET_B a_10827_7796# 0.56499f
C5976 a_2934_4632# sg13cmos5l_dfrbp_1_9.Q 0.03767f
C5977 sg13cmos5l_buf_1_25.X nl_sw[2] 0
C5978 sg13cmos5l_inv_1_27.Y a_16042_6892# 0
C5979 a_19227_9190# a_19340_8400# 0
C5980 sg13cmos5l_o21ai_1_0.B1 sg13cmos5l_buf_1_8.A 0
C5981 sg13cmos5l_a22oi_1_1.Y a_14900_2352# 0
C5982 a_6961_4261# VPWR 0.00145f
C5983 sg13cmos5l_buf_1_78.A sg13cmos5l_dfrbp_1_6.RESET_B 0
C5984 sg13cmos5l_buf_1_77.X sg13cmos5l_dfrbp_1_18.Q 0
C5985 a_14602_8404# pl_sw[6] 0
C5986 sg13cmos5l_buf_8_1.A a_16703_3871# 0.36318f
C5987 sg13cmos5l_dfrbp_1_0.CLK a_17926_3151# 0
C5988 sg13cmos5l_buf_1_10.A sg13cmos5l_or2_1_1.B 0.06791f
C5989 sg13cmos5l_buf_1_58.A a_1227_6935# 0.015f
C5990 sg13cmos5l_dlhr_1_6.D a_8852_6484# 0.01268f
C5991 sg13cmos5l_dfrbp_1_6.RESET_B a_19164_5814# 0
C5992 a_10308_7992# a_10202_7288# 0.0016f
C5993 sg13cmos5l_dlhr_1_5.Q a_8570_6172# 0.0449f
C5994 sg13cmos5l_dlhr_1_1.D a_2161_4642# 0
C5995 sg13cmos5l_buf_1_10.A a_12567_7282# 0.00425f
C5996 a_13701_3117# a_14254_2444# 0.00575f
C5997 a_13284_3456# sg13cmos5l_nor2_1_1.A 0
C5998 sg13cmos5l_o21ai_1_0.B1 sg13cmos5l_buf_1_1.A 0
C5999 sg13cmos5l_buf_1_7.A a_13017_1941# 0
C6000 sg13cmos5l_buf_1_30.A a_6372_4968# 0.02115f
C6001 sg13cmos5l_inv_1_19.A sg13cmos5l_buf_1_62.X 0.05343f
C6002 sg13cmos5l_dfrbp_1_23.Q sg13cmos5l_a22oi_1_1.B1 0
C6003 sg13cmos5l_buf_1_29.A sg13cmos5l_buf_1_8.X 0
C6004 sg13cmos5l_a221oi_1_0.C1 a_10433_4248# 0.00268f
C6005 sg13cmos5l_dfrbp_1_8.RESET_B a_3609_8559# 0.00343f
C6006 sg13cmos5l_dfrbp_1_8.RESET_B a_5079_3154# 0
C6007 sg13cmos5l_dfrbp_1_6.RESET_B a_4034_7660# 0.00419f
C6008 sg13cmos5l_inv_1_8.A a_4107_4772# 0.04094f
C6009 a_14295_7282# a_14583_5770# 0.00219f
C6010 a_7537_4727# sg13cmos5l_dfrbp_1_12.Q_N 0.00224f
C6011 sg13cmos5l_inv_1_2.A a_11272_8522# 0
C6012 sg13cmos5l_buf_1_43.A sg13cmos5l_inv_1_9.Y 0.01414f
C6013 sg13cmos5l_inv_1_20.Y a_2148_8440# 0.046f
C6014 a_2732_9150# a_2565_8447# 0.01066f
C6015 VPWR pl_sw[10] 0.26656f
C6016 d_out[1] d_out[0] 0.00265f
C6017 a_15500_9150# ph_sw[7] 0.00225f
C6018 sg13cmos5l_dfrbp_1_8.RESET_B a_14612_6460# 0
C6019 sg13cmos5l_dfrbp_1_20.Q a_10282_7897# 0.00287f
C6020 a_11434_2356# a_11530_1849# 0
C6021 sg13cmos5l_buf_1_44.X sg13cmos5l_inv_1_19.A 0
C6022 sg13cmos5l_buf_1_18.A a_18865_3215# 0.00507f
C6023 sg13cmos5l_a221oi_1_0.A2 a_9457_4642# 0
C6024 sg13cmos5l_dfrbp_1_6.D a_8390_6924# 0
C6025 a_20012_1590# nl_sw[10] 0.01448f
C6026 sg13cmos5l_or2_1_0.A a_12075_3911# 0.00908f
C6027 sg13cmos5l_buf_1_77.A sg13cmos5l_dfrbp_1_16.Q 0.16322f
C6028 a_3856_3358# a_3801_3453# 0.00464f
C6029 a_2859_3260# sg13cmos5l_dfrbp_1_10.Q_N 0.00351f
C6030 sg13cmos5l_buf_1_110.A a_16102_4663# 0
C6031 sg13cmos5l_dfrbp_1_8.RESET_B a_2565_3911# 0.0708f
C6032 sg13cmos5l_inv_1_2.A a_8772_8440# 0.09256f
C6033 a_13391_9263# a_13810_9186# 0.00176f
C6034 sg13cmos5l_buf_1_4.A a_16751_2749# 0
C6035 sg13cmos5l_buf_1_24.A a_6865_6239# 0.00169f
C6036 sg13cmos5l_dfrbp_1_16.Q a_8457_7281# 0
C6037 sg13cmos5l_dlhr_1_9.D a_8570_6172# 0
C6038 a_3575_6553# a_4322_6162# 0.00718f
C6039 a_14889_7281# a_15208_6200# 0.00475f
C6040 a_2804_6924# sg13cmos5l_inv_1_19.A 0
C6041 sg13cmos5l_a22oi_1_1.B1 a_14814_4292# 0
C6042 sg13cmos5l_buf_1_30.X a_9544_2474# 0.07311f
C6043 sg13cmos5l_buf_1_3.A a_19548_6198# 0.00176f
C6044 a_2727_6380# sg13cmos5l_dlhr_1_1.D 0
C6045 sg13cmos5l_buf_1_40.A a_1290_3206# 0.03847f
C6046 sg13cmos5l_buf_1_7.A nl_sw[7] 0
C6047 a_1227_5423# a_2224_5654# 0.07046f
C6048 sg13cmos5l_buf_1_7.A VPWR 0.54177f
C6049 a_10707_2388# VPWR 0.00981f
C6050 sg13cmos5l_buf_1_57.X a_14152_5498# 0
C6051 a_15429_7653# a_16271_7751# 0.00437f
C6052 a_15012_7992# a_16528_7894# 0.00294f
C6053 sg13cmos5l_dfrbp_1_6.RESET_B a_8592_5412# 0
C6054 a_1864_9224# pl_sw[1] 0.00398f
C6055 a_11530_3868# a_11372_3102# 0
C6056 a_18096_7996# cks 0
C6057 sg13cmos5l_nand2_1_1.B a_12998_3138# 0.00214f
C6058 a_2248_9224# sg13cmos5l_buf_1_68.X 0
C6059 sg13cmos5l_buf_1_60.X a_616_9224# 0
C6060 sg13cmos5l_buf_1_45.X sg13cmos5l_dfrbp_1_8.RESET_B 0.04859f
C6061 sg13cmos5l_inv_1_8.A a_2879_6432# 0.34827f
C6062 a_7863_7282# VPWR 0.18116f
C6063 a_2148_8440# a_2374_8861# 0.00523f
C6064 a_2122_8404# a_2436_8861# 0.00659f
C6065 a_13391_9263# sg13cmos5l_dlhr_1_11.Q 0
C6066 sg13cmos5l_dfrbp_1_11.Q a_6961_4261# 0.00494f
C6067 a_10868_8436# sg13cmos5l_inv_1_7.A 0
C6068 sg13cmos5l_dfrbp_1_9.Q a_4436_3436# 0.05074f
C6069 sg13cmos5l_inv_1_6.A sg13cmos5l_inv_1_5.A 0.00536f
C6070 sg13cmos5l_buf_1_19.A pl_sw[9] 0.19799f
C6071 a_12800_5498# a_12721_4261# 0
C6072 sg13cmos5l_and3_1_0.X a_13652_3900# 0.00136f
C6073 sg13cmos5l_buf_1_44.X sg13cmos5l_dlhr_1_9.D 0.97259f
C6074 sg13cmos5l_buf_1_40.A a_1402_3864# 0.0574f
C6075 sg13cmos5l_nand2_1_0.A sg13cmos5l_o21ai_1_0.A2 0.49799f
C6076 a_18409_5770# VPWR 0.48203f
C6077 sg13cmos5l_dfrbp_1_18.Q sg13cmos5l_dfrbp_1_6.RESET_B 0.38733f
C6078 a_17712_8436# cks 0
C6079 a_12651_9308# a_13100_8400# 0
C6080 sg13cmos5l_buf_1_90.X a_14342_8874# 0
C6081 cks ph_sw[10] 0
C6082 sg13cmos5l_or2_1_0.A nh_sw[0] 0
C6083 a_7508_1948# nh_sw[3] 0
C6084 sg13cmos5l_dfrbp_1_21.Q a_14928_5412# 0
C6085 a_9366_5842# sg13cmos5l_buf_1_45.A 0.56969f
C6086 sg13cmos5l_buf_1_0.A a_18865_3215# 0.01774f
C6087 sg13cmos5l_inv_1_29.A a_12980_6924# 0
C6088 a_4324_7996# a_4652_6126# 0
C6089 sg13cmos5l_buf_1_31.X sg13cmos5l_dlhr_1_0.GATE 0.02399f
C6090 sg13cmos5l_dfrbp_1_0.RESET_B nh_sw[6] 0.005f
C6091 sg13cmos5l_buf_1_40.A a_1609_4704# 0.01403f
C6092 a_11771_5412# a_11973_3911# 0
C6093 sg13cmos5l_buf_1_25.A sg13cmos5l_buf_1_25.X 0.02991f
C6094 sg13cmos5l_dlhr_1_5.GATE a_6117_6141# 0.36594f
C6095 a_7497_3138# a_7689_1626# 0.00289f
C6096 a_7316_3460# a_7226_1636# 0.00352f
C6097 a_5069_5376# sg13cmos5l_buf_1_44.A 0
C6098 sg13cmos5l_dfrbp_1_23.CLK a_13686_7354# 0.01069f
C6099 sg13cmos5l_dfrbp_1_6.RESET_B a_11769_7989# 0.00343f
C6100 a_8772_8440# a_9937_8797# 0.4858f
C6101 sg13cmos5l_buf_1_107.X pl_sw[9] 0.00796f
C6102 a_9060_8861# a_9291_8447# 0.15089f
C6103 sg13cmos5l_inv_1_0.Y a_11270_4338# 0
C6104 a_5739_2399# a_6188_1590# 0
C6105 a_19593_6162# a_19412_6484# 0.40925f
C6106 a_18793_6216# a_19344_6484# 0
C6107 a_18860_6888# a_19528_6924# 0
C6108 sg13cmos5l_a22oi_1_0.B1 a_10783_4292# 0.00204f
C6109 a_18196_8824# cks 0
C6110 sg13cmos5l_dfrbp_1_18.Q a_10071_7282# 0.23912f
C6111 sg13cmos5l_inv_1_2.A sg13cmos5l_buf_1_4.X 0.00296f
C6112 sg13cmos5l_buf_1_41.A a_4041_2745# 0
C6113 sg13cmos5l_buf_1_30.A sg13cmos5l_dlhr_1_2.D 0
C6114 sg13cmos5l_a22oi_1_0.Y VPWR 0.19123f
C6115 sg13cmos5l_dfrbp_1_0.Q cks 0
C6116 sg13cmos5l_nand2_1_2.B a_650_3900# 0.01411f
C6117 sg13cmos5l_buf_8_1.A a_18363_4270# 0.51032f
C6118 sg13cmos5l_dfrbp_1_22.D a_18486_8866# 0
C6119 sg13cmos5l_dlhr_1_5.GATE a_7941_7653# 0
C6120 sg13cmos5l_buf_1_58.A sg13cmos5l_dfrbp_1_16.Q 0
C6121 a_13641_7674# sg13cmos5l_dlhr_1_6.D 0
C6122 sg13cmos5l_inv_1_1.A sg13cmos5l_dfrbp_1_23.Q_N 0
C6123 sg13cmos5l_buf_1_9.A nl_sw[5] 0.15106f
C6124 a_3496_1758# nh_sw[1] 0.0021f
C6125 a_12106_9409# a_12489_9577# 0.00337f
C6126 sg13cmos5l_dfrbp_1_8.RESET_B a_12651_9308# 0.55134f
C6127 sg13cmos5l_buf_1_101.X pl_sw[9] 0.04838f
C6128 a_1480_7806# a_1484_6126# 0
C6129 sg13cmos5l_dfrbp_1_20.Q sg13cmos5l_nor2_1_0.A 0.00808f
C6130 sg13cmos5l_buf_1_24.A a_6315_3911# 0.03941f
C6131 a_1196_8400# a_1000_9224# 0.00193f
C6132 sg13cmos5l_nand2_1_2.B sg13cmos5l_dlygate4sd3_1_0.X 0.08899f
C6133 sg13cmos5l_dfrbp_1_8.RESET_B a_422_7362# 0
C6134 sg13cmos5l_nand2_1_1.A a_17414_3138# 0.01901f
C6135 a_15380_3436# sg13cmos5l_nor2_1_1.A 0
C6136 sg13cmos5l_buf_1_30.A a_7888_4870# 0
C6137 a_11979_2399# a_12721_1703# 0
C6138 sg13cmos5l_inv_1_0.A a_13324_4696# 0.27398f
C6139 a_20204_5376# sg13cmos5l_inv_1_5.A 0
C6140 a_18376_9224# ph_sw[8] 0.00765f
C6141 sg13cmos5l_or2_1_1.B a_14928_5412# 0
C6142 sg13cmos5l_buf_1_77.X cks 0
C6143 sg13cmos5l_buf_1_41.A a_2340_3456# 0.01712f
C6144 sg13cmos5l_dfrbp_1_8.RESET_B a_8084_8436# 0.00874f
C6145 sg13cmos5l_dfrbp_1_6.RESET_B a_4244_6924# 0.11081f
C6146 sg13cmos5l_buf_1_57.X sg13cmos5l_inv_1_29.A 0.15497f
C6147 sg13cmos5l_dfrbp_1_21.Q sg13cmos5l_nor2b_1_0.Y 0.01986f
C6148 a_3676_7964# a_4076_7624# 0.40925f
C6149 sg13cmos5l_inv_1_8.A a_5104_4870# 0.01339f
C6150 a_3609_4023# VPWR 0
C6151 a_14089_7282# a_14152_5498# 0
C6152 sg13cmos5l_dfrbp_1_23.Q a_13486_5412# 0.00224f
C6153 sg13cmos5l_buf_1_37.A nl_sw[1] 0
C6154 sg13cmos5l_dfrbp_1_0.CLK a_14962_3138# 0
C6155 a_17135_4727# cks 0
C6156 sg13cmos5l_a221oi_1_0.C1 sg13cmos5l_o21ai_1_0.A1 0.30071f
C6157 sg13cmos5l_dfrbp_1_6.RESET_B sg13cmos5l_inv_1_3.A 0.32835f
C6158 sg13cmos5l_inv_1_17.A a_3876_4663# 0.0185f
C6159 a_16042_6892# a_16068_6928# 0.43042f
C6160 sg13cmos5l_buf_1_4.A a_16068_6162# 0
C6161 a_7863_7282# a_8233_6216# 0
C6162 sg13cmos5l_dfrbp_1_6.D sg13cmos5l_buf_1_29.A 0.00402f
C6163 sg13cmos5l_buf_1_7.A a_11973_1605# 0
C6164 a_7863_7282# sg13cmos5l_dfrbp_1_11.Q 0.00155f
C6165 sg13cmos5l_dfrbp_1_23.CLK sg13cmos5l_buf_1_5.A 1.02f
C6166 sg13cmos5l_inv_1_14.A a_6117_6141# 0.00932f
C6167 sg13cmos5l_dfrbp_1_6.D a_10665_7281# 0.00871f
C6168 sg13cmos5l_dlhr_1_9.D sg13cmos5l_nor2_1_0.A 0.00208f
C6169 sg13cmos5l_buf_1_65.X a_9673_9240# 0
C6170 sg13cmos5l_or2_1_0.A a_11913_3947# 0
C6171 a_17392_4870# sg13cmos5l_a22oi_1_1.A1 0.00358f
C6172 a_2628_3151# sg13cmos5l_dfrbp_1_10.Q_N 0.00161f
C6173 sg13cmos5l_dfrbp_1_8.RESET_B a_2314_3361# 0.01027f
C6174 sg13cmos5l_dfrbp_1_6.RESET_B a_7316_3460# 0.10772f
C6175 sg13cmos5l_buf_1_18.X nh_sw[10] 0
C6176 sg13cmos5l_buf_1_41.A a_2934_4632# 0.00472f
C6177 sg13cmos5l_dfrbp_1_6.RESET_B a_4934_2826# 0.10535f
C6178 sg13cmos5l_inv_1_2.A a_10031_8797# 0.00103f
C6179 sg13cmos5l_nand2_1_0.B sg13cmos5l_buf_1_8.A 0.00285f
C6180 sg13cmos5l_dfrbp_1_23.Q sg13cmos5l_buf_1_4.A 0.00276f
C6181 sg13cmos5l_buf_1_89.A sg13cmos5l_buf_1_116.A 0.01422f
C6182 sg13cmos5l_dfrbp_1_8.RESET_B pl_sw[9] 0
C6183 sg13cmos5l_buf_1_8.X sg13cmos5l_buf_1_6.A 0.00247f
C6184 sg13cmos5l_buf_1_8.X a_11530_1849# 0
C6185 a_5710_5535# VPWR 0
C6186 a_9260_2352# a_9823_2364# 0
C6187 sg13cmos5l_or2_1_1.B sg13cmos5l_nor2b_1_0.Y 0.16146f
C6188 sg13cmos5l_inv_1_8.A a_7052_9150# 0
C6189 sg13cmos5l_buf_1_79.X sg13cmos5l_dfrbp_1_18.Q_N 0
C6190 sg13cmos5l_or2_1_0.A a_11973_3911# 0.00508f
C6191 a_5988_8440# pl_sw[3] 0.02524f
C6192 sg13cmos5l_buf_1_44.X sg13cmos5l_dlhr_1_7.Q_N 0.05784f
C6193 a_1878_6337# sg13cmos5l_inv_1_19.A 0.0086f
C6194 sg13cmos5l_buf_1_87.A sg13cmos5l_dfrbp_1_8.D 0.0141f
C6195 a_1967_5773# a_2386_5850# 0.00176f
C6196 a_1227_5423# sg13cmos5l_dlhr_1_1.D 0.00866f
C6197 a_13556_2388# VPWR 0.35685f
C6198 sg13cmos5l_dfrbp_1_20.Q_N sg13cmos5l_dfrbp_1_8.RESET_B 0.03369f
C6199 a_19796_3436# sg13cmos5l_buf_1_0.X 0
C6200 a_16271_7751# a_16473_7989# 0.00675f
C6201 a_15531_7796# a_16177_7751# 0.00667f
C6202 a_10725_7653# VPWR 0.2497f
C6203 sg13cmos5l_o21ai_1_0.A1 sg13cmos5l_o21ai_1_0.B1 0.03089f
C6204 sg13cmos5l_dfrbp_1_0.CLK sg13cmos5l_buf_1_9.A 0
C6205 sg13cmos5l_nand2_1_1.B a_14800_3358# 0.01911f
C6206 a_4847_4727# a_5510_4338# 0
C6207 a_2667_8447# a_3664_8678# 0.07046f
C6208 a_1862_8874# sg13cmos5l_dfrbp_1_15.D 0.00354f
C6209 a_2122_8404# a_2505_8483# 0.00337f
C6210 a_2565_8447# a_3313_8797# 0.01058f
C6211 sg13cmos5l_buf_1_26.A a_8576_1758# 0.00237f
C6212 sg13cmos5l_dfrbp_1_1.Q sg13cmos5l_o21ai_1_0.A2 1.41352f
C6213 sg13cmos5l_dlygate4sd2_1_0.X nh_sw[0] 0.00113f
C6214 sg13cmos5l_dfrbp_1_11.Q sg13cmos5l_a22oi_1_0.Y 0
C6215 sg13cmos5l_dlhr_1_9.Q sg13cmos5l_inv_1_19.A 0.10402f
C6216 sg13cmos5l_buf_1_3.A sg13cmos5l_dfrbp_1_8.D 0
C6217 a_12232_8436# sg13cmos5l_inv_1_7.A 0.32983f
C6218 sg13cmos5l_dfrbp_1_8.RESET_B a_2409_4650# 0
C6219 sg13cmos5l_buf_1_29.A a_10024_5498# 0.05427f
C6220 sg13cmos5l_buf_1_8.A nl_sw[6] 0.02505f
C6221 a_5800_9224# VPWR 0.2471f
C6222 sg13cmos5l_inv_1_3.A sg13cmos5l_inv_1_1.A 0
C6223 sg13cmos5l_dfrbp_1_6.RESET_B a_12516_6480# 0.4714f
C6224 sg13cmos5l_buf_1_110.A a_15702_5842# 0.01997f
C6225 a_19734_5842# VPWR 0.24954f
C6226 a_1125_6935# a_1873_5773# 0
C6227 sg13cmos5l_dfrbp_1_2.D a_12075_3911# 0
C6228 sg13cmos5l_nand2_1_1.B a_10888_1664# 0
C6229 sg13cmos5l_dlhr_1_12.Q_N a_18856_8436# 0.12906f
C6230 sg13cmos5l_dlhr_1_1.GATE a_708_5416# 0.11375f
C6231 sg13cmos5l_dlhr_1_1.GATE a_3962_7288# 0.01116f
C6232 sg13cmos5l_dlhr_1_5.GATE a_7161_6477# 0
C6233 sg13cmos5l_buf_1_3.A sg13cmos5l_buf_1_0.X 0.52696f
C6234 sg13cmos5l_buf_1_26.A VPWR 0.48318f
C6235 a_10288_8678# a_10450_8874# 0.0019f
C6236 a_10031_8797# a_9937_8797# 0.32273f
C6237 sg13cmos5l_dfrbp_1_23.CLK sg13cmos5l_dfrbp_1_23.Q 0.3074f
C6238 a_20118_6144# sg13cmos5l_dlhr_1_10.Q_N 0.12876f
C6239 a_19412_6484# a_19345_6154# 0.0018f
C6240 a_19593_6162# a_19548_6198# 0
C6241 sg13cmos5l_dfrbp_1_6.RESET_B cks 2.79954f
C6242 sg13cmos5l_dfrbp_1_8.RESET_B a_10233_8559# 0.00343f
C6243 a_18219_3260# sg13cmos5l_dfrbp_1_0.Q 0
C6244 sg13cmos5l_nand2_1_0.B a_10433_4248# 0
C6245 sg13cmos5l_nor2_1_1.A a_15466_2356# 0.0271f
C6246 sg13cmos5l_buf_1_79.X ph_sw[6] 0.0034f
C6247 sg13cmos5l_buf_1_34.X sg13cmos5l_dfrbp_1_8.RESET_B 0.07186f
C6248 sg13cmos5l_buf_1_46.A VPWR 0.33057f
C6249 sg13cmos5l_inv_1_29.A a_13178_7684# 0.00136f
C6250 a_4840_1664# nh_sw[3] 0
C6251 pl_sw[0] a_1484_9150# 0
C6252 sg13cmos5l_dlhr_1_9.Q sg13cmos5l_dlhr_1_9.D 0.00175f
C6253 sg13cmos5l_buf_1_87.A a_17780_8436# 0.00125f
C6254 a_2621_7636# a_2748_6126# 0
C6255 sg13cmos5l_buf_1_58.A sg13cmos5l_dfrbp_1_15.Q_N 0.00115f
C6256 sg13cmos5l_inv_1_17.A a_4076_7624# 0.0018f
C6257 a_9111_4666# a_9660_4686# 0
C6258 sg13cmos5l_dfrbp_1_1.D nl_sw[5] 0.2112f
C6259 sg13cmos5l_dfrbp_1_23.CLK a_13460_7996# 0
C6260 sg13cmos5l_dfrbp_1_16.Q_N a_1125_6935# 0
C6261 a_10071_7282# cks 0
C6262 sg13cmos5l_nand2_1_1.A a_19216_3358# 0.00303f
C6263 sg13cmos5l_buf_1_30.A sg13cmos5l_dfrbp_1_12.Q_N 0.39818f
C6264 sg13cmos5l_inv_1_2.A a_13810_9186# 0
C6265 sg13cmos5l_inv_1_0.A a_12520_4782# 0.05069f
C6266 a_16204_4338# sg13cmos5l_nor2_1_1.A 0
C6267 a_3447_2746# a_3496_1758# 0.0064f
C6268 a_5416_9224# pl_sw[3] 0
C6269 sg13cmos5l_buf_1_77.A sg13cmos5l_inv_1_18.A 0.83102f
C6270 sg13cmos5l_dfrbp_1_8.RESET_B a_8746_8404# 0.32235f
C6271 sg13cmos5l_buf_1_58.A a_996_7349# 0
C6272 sg13cmos5l_dfrbp_1_0.D a_17414_3138# 0.02262f
C6273 sg13cmos5l_inv_1_8.A sg13cmos5l_dlhr_1_0.GATE 0.0705f
C6274 a_11174_2826# sg13cmos5l_buf_1_8.A 0.02091f
C6275 sg13cmos5l_dfrbp_1_0.CLK a_17508_3138# 0
C6276 a_13681_6239# VPWR 0
C6277 a_424_1664# comp_p 0.32505f
C6278 a_2565_8447# sg13cmos5l_buf_1_41.A 0
C6279 a_16485_6935# a_16356_7349# 0.01562f
C6280 a_16068_6928# a_16587_6935# 0.38871f
C6281 sg13cmos5l_dfrbp_1_6.D a_12216_5728# 0
C6282 a_6568_9224# pl_sw[4] 0.0011f
C6283 sg13cmos5l_inv_1_2.A sg13cmos5l_dlhr_1_11.Q 0
C6284 a_7820_9150# sg13cmos5l_buf_1_73.A 0.33094f
C6285 sg13cmos5l_buf_1_77.X sg13cmos5l_buf_1_45.X 0.00552f
C6286 sg13cmos5l_buf_1_74.X sg13cmos5l_inv_1_18.A 0
C6287 sg13cmos5l_a22oi_1_1.A1 a_14800_3358# 0
C6288 a_1672_3176# a_1760_1758# 0
C6289 sg13cmos5l_buf_1_7.A a_14056_1664# 0.33699f
C6290 sg13cmos5l_dfrbp_1_8.RESET_B a_6598_4663# 0
C6291 a_12719_2749# a_12075_1748# 0
C6292 sg13cmos5l_inv_1_14.A a_7161_6477# 0
C6293 sg13cmos5l_buf_1_94.X sg13cmos5l_dlhr_1_12.D 0.00978f
C6294 sg13cmos5l_dfrbp_1_6.D a_11560_7010# 0.00257f
C6295 a_20392_3176# VPWR 0.26549f
C6296 sg13cmos5l_buf_1_57.X a_10022_7674# 0.31374f
C6297 a_10282_7897# a_10308_7992# 0.43042f
C6298 sg13cmos5l_dfrbp_1_8.RESET_B a_3599_3215# 0
C6299 sg13cmos5l_inv_1_1.A cks 0.36837f
C6300 a_524_4614# sg13cmos5l_inv_1_9.Y 0.01487f
C6301 a_422_5850# a_416_3986# 0
C6302 a_2348_7624# a_2554_8112# 0.00122f
C6303 sg13cmos5l_or2_1_0.A a_12998_3138# 0.00669f
C6304 sg13cmos5l_dfrbp_1_10.Q_N sg13cmos5l_buf_1_41.X 0
C6305 sg13cmos5l_dfrbp_1_6.RESET_B a_5446_2813# 0
C6306 sg13cmos5l_buf_1_41.A sg13cmos5l_dfrbp_1_9.Q 1.42f
C6307 a_12980_6924# sg13cmos5l_a22oi_1_1.B2 0
C6308 sg13cmos5l_inv_1_2.A a_11848_8436# 0
C6309 sg13cmos5l_buf_1_74.X a_6568_9224# 0.32684f
C6310 a_5674_6385# a_6057_6553# 0.00337f
C6311 a_5414_6162# a_5700_6480# 0.50066f
C6312 sg13cmos5l_inv_1_1.A a_16306_8874# 0.00168f
C6313 sg13cmos5l_nand2_1_1.B a_15300_2826# 0
C6314 sg13cmos5l_buf_8_2.X VPWR 1.56462f
C6315 sg13cmos5l_dfrbp_1_8.RESET_B a_2122_8404# 0.33977f
C6316 sg13cmos5l_buf_1_79.X a_8998_8861# 0
C6317 a_2727_6380# sg13cmos5l_inv_1_19.A 0.00721f
C6318 a_7504_8678# pl_sw[3] 0
C6319 sg13cmos5l_dfrbp_1_6.RESET_B a_9524_4972# 0.12087f
C6320 a_1065_5459# sg13cmos5l_dlhr_1_1.D 0
C6321 a_4950_7354# a_4950_5699# 0
C6322 sg13cmos5l_buf_1_18.A a_18959_3215# 0.02879f
C6323 sg13cmos5l_dfrbp_1_11.Q sg13cmos5l_buf_1_26.A 0
C6324 a_19378_3138# sg13cmos5l_buf_1_19.X 0
C6325 sg13cmos5l_buf_1_24.A a_6602_5692# 0.01583f
C6326 sg13cmos5l_dfrbp_1_6.D a_5710_5850# 0.00188f
C6327 sg13cmos5l_inv_1_7.A a_12721_4261# 0.00103f
C6328 sg13cmos5l_buf_1_31.X sg13cmos5l_a22oi_1_1.B1 0
C6329 sg13cmos5l_buf_8_1.A sg13cmos5l_dfrbp_1_0.RESET_B 0.00125f
C6330 a_12404_7972# VPWR 0.37916f
C6331 sg13cmos5l_and3_1_0.C a_12719_2749# 0
C6332 sg13cmos5l_inv_1_29.Y sg13cmos5l_a221oi_1_0.B1 0.01048f
C6333 sg13cmos5l_inv_1_14.A sg13cmos5l_buf_1_25.A 0.70717f
C6334 sg13cmos5l_dfrbp_1_6.RESET_B a_5079_3154# 0.03324f
C6335 a_2667_8447# sg13cmos5l_dfrbp_1_15.D 0.01018f
C6336 a_3664_8678# sg13cmos5l_dfrbp_1_17.Q_N 0.15881f
C6337 sg13cmos5l_dfrbp_1_0.CLK sg13cmos5l_dfrbp_1_1.D 0
C6338 sg13cmos5l_dfrbp_1_8.RESET_B a_16940_3102# 0
C6339 a_10202_7288# a_10420_5412# 0
C6340 sg13cmos5l_dfrbp_1_8.RESET_B sg13cmos5l_dlhr_1_1.Q_N 0
C6341 sg13cmos5l_buf_8_0.X a_20488_4782# 0.02516f
C6342 sg13cmos5l_dfrbp_1_11.Q sg13cmos5l_buf_1_46.A 0.41815f
C6343 a_14152_8522# VPWR 0.14173f
C6344 a_7238_7674# a_7524_7992# 0.50066f
C6345 sg13cmos5l_dfrbp_1_6.RESET_B a_14612_6460# 0.00273f
C6346 sg13cmos5l_and3_1_0.X a_13803_3260# 0
C6347 sg13cmos5l_buf_1_57.X sg13cmos5l_a22oi_1_1.B2 0.01431f
C6348 a_10613_2758# VPWR 0.00113f
C6349 pl_sw[10] ph_sw[9] 0.10938f
C6350 a_17712_8436# pl_sw[9] 0
C6351 pl_sw[9] ph_sw[10] 0
C6352 sg13cmos5l_nand2_1_0.A a_11460_2392# 0.05789f
C6353 a_1096_6294# a_1125_5423# 0.01112f
C6354 sg13cmos5l_buf_1_57.X a_9638_5088# 0
C6355 sg13cmos5l_buf_1_77.X a_8084_8436# 0
C6356 sg13cmos5l_buf_1_94.X VPWR 0.26278f
C6357 a_17751_7690# cks 0.00402f
C6358 a_1662_8374# a_2122_8404# 0
C6359 a_19340_8400# sg13cmos5l_buf_1_19.A 0.00524f
C6360 sg13cmos5l_dfrbp_1_10.Q sg13cmos5l_buf_1_30.X 0.00177f
C6361 sg13cmos5l_dfrbp_1_6.RESET_B a_2565_3911# 0.03888f
C6362 a_6479_2749# a_6681_2511# 0.00675f
C6363 sg13cmos5l_buf_1_97.A a_10725_7653# 0
C6364 a_7316_2388# a_7508_1948# 0
C6365 a_7820_2352# a_7689_1626# 0
C6366 sg13cmos5l_dfrbp_1_10.Q a_8680_1664# 0
C6367 sg13cmos5l_dlhr_1_9.D a_2727_6380# 0
C6368 sg13cmos5l_dfrbp_1_2.D a_11973_3911# 0
C6369 a_18196_8824# pl_sw[9] 0.00177f
C6370 sg13cmos5l_dlhr_1_15.D a_14458_4270# 0
C6371 a_14632_9224# VPWR 0.24862f
C6372 a_4324_7996# a_4514_7666# 0.00284f
C6373 a_4349_7636# a_4311_7710# 0
C6374 sg13cmos5l_nor2_1_1.A a_15780_2813# 0.00497f
C6375 sg13cmos5l_inv_1_8.A sg13cmos5l_dfrbp_1_16.Q_N 0.00195f
C6376 sg13cmos5l_inv_1_29.A sg13cmos5l_dlhr_1_14.Q_N 0
C6377 sg13cmos5l_buf_1_57.X a_12804_6175# 0.00301f
C6378 a_5988_6175# sg13cmos5l_dlhr_1_0.GATE 0
C6379 a_18356_6460# a_18409_5770# 0
C6380 sg13cmos5l_buf_1_0.A a_18959_3215# 0.02802f
C6381 sg13cmos5l_buf_1_107.X a_19340_8400# 0.32478f
C6382 sg13cmos5l_buf_8_0.X a_20672_6294# 0.00271f
C6383 sg13cmos5l_nand2_1_1.B VPWR 1.77285f
C6384 sg13cmos5l_nand2_1_1.B nl_sw[7] 0
C6385 sg13cmos5l_buf_1_45.X sg13cmos5l_dfrbp_1_6.RESET_B 0.78272f
C6386 sg13cmos5l_nand2_1_0.B sg13cmos5l_o21ai_1_0.A1 0.13352f
C6387 sg13cmos5l_nor2_1_0.A a_12719_2749# 0.00879f
C6388 a_10620_7326# cks 0
C6389 sg13cmos5l_buf_1_60.X sg13cmos5l_inv_1_20.Y 0.03579f
C6390 sg13cmos5l_nor2_1_1.A a_17386_1849# 0
C6391 sg13cmos5l_dfrbp_1_8.D a_19593_6162# 0
C6392 a_7497_3138# VPWR 0.63968f
C6393 sg13cmos5l_dfrbp_1_18.Q a_8439_6178# 0
C6394 a_14814_3876# sg13cmos5l_nor2_1_1.A 0
C6395 sg13cmos5l_buf_1_5.X a_17224_3270# 0
C6396 a_5220_2392# sg13cmos5l_buf_1_24.X 0.00325f
C6397 a_9033_6162# sg13cmos5l_a221oi_1_0.A2 0
C6398 sg13cmos5l_dlhr_1_6.D a_9366_5842# 0
C6399 sg13cmos5l_dlhr_1_3.Q_N VPWR 0.33364f
C6400 sg13cmos5l_dfrbp_1_8.RESET_B a_10288_8678# 0.18274f
C6401 sg13cmos5l_inv_1_2.A pl_sw[5] 0.07385f
C6402 a_17498_8800# cks 0.02045f
C6403 sg13cmos5l_dlhr_1_5.Q a_8660_5412# 0
C6404 sg13cmos5l_inv_1_2.A a_16268_3102# 0
C6405 sg13cmos5l_dfrbp_1_16.Q sg13cmos5l_nor2b_1_0.Y 0
C6406 sg13cmos5l_a221oi_1_0.C1 a_11656_3176# 0
C6407 a_16552_1664# cks 0
C6408 sg13cmos5l_dfrbp_1_0.D a_19216_3358# 0
C6409 a_11072_2474# sg13cmos5l_buf_1_8.A 0.00125f
C6410 sg13cmos5l_o21ai_1_0.B1 sg13cmos5l_nor2b_1_1.Y 0
C6411 sg13cmos5l_nand2_1_2.B a_416_3986# 0.00129f
C6412 sg13cmos5l_buf_1_77.X sg13cmos5l_dfrbp_1_20.Q_N 0
C6413 sg13cmos5l_inv_1_1.A a_14612_6460# 0
C6414 sg13cmos5l_dfrbp_1_16.Q sg13cmos5l_buf_1_44.A 0
C6415 a_16587_6935# a_17584_7166# 0.07046f
C6416 a_8982_7354# sg13cmos5l_buf_1_31.X 0.00503f
C6417 sg13cmos5l_o21ai_1_0.A1 nl_sw[6] 0.05906f
C6418 sg13cmos5l_buf_1_103.A ph_sw[7] 0.00637f
C6419 a_19028_5412# a_18363_4270# 0
C6420 sg13cmos5l_dfrbp_1_8.RESET_B a_16485_6935# 0.05264f
C6421 sg13cmos5l_a22oi_1_1.A1 a_15821_3864# 0.01909f
C6422 sg13cmos5l_inv_1_2.A a_13652_3900# 0
C6423 sg13cmos5l_dfrbp_1_6.D a_13686_7354# 0.00264f
C6424 a_20200_3270# VPWR 0.14058f
C6425 sg13cmos5l_a221oi_1_0.C1 sg13cmos5l_a22oi_1_1.B1 0.04159f
C6426 sg13cmos5l_buf_1_29.A sg13cmos5l_buf_1_9.A 0.00148f
C6427 sg13cmos5l_buf_1_57.X a_11567_7751# 0.00333f
C6428 sg13cmos5l_dfrbp_1_8.RESET_B sg13cmos5l_dfrbp_1_10.Q_N 0
C6429 a_1948_7964# sg13cmos5l_dfrbp_1_16.Q_N 0
C6430 sg13cmos5l_or2_1_0.A a_14800_3358# 0
C6431 sg13cmos5l_inv_1_6.A a_19528_6924# 0
C6432 sg13cmos5l_buf_1_38.A a_4456_1664# 0.00576f
C6433 a_3407_4261# VPWR 0.26215f
C6434 sg13cmos5l_dfrbp_1_6.RESET_B a_8204_2352# 0.01108f
C6435 sg13cmos5l_dfrbp_1_0.CLK a_14745_3453# 0
C6436 a_12230_6162# VPWR 0.95116f
C6437 sg13cmos5l_dlhr_1_9.D a_5049_4965# 0
C6438 a_5700_6480# a_7216_6382# 0.00294f
C6439 a_6117_6141# a_6959_6239# 0.00437f
C6440 a_13391_9263# pl_sw[6] 0
C6441 sg13cmos5l_buf_1_60.X a_2374_8861# 0
C6442 a_14628_8440# sg13cmos5l_buf_1_57.X 0
C6443 a_14708_6924# a_14822_6924# 0.00122f
C6444 sg13cmos5l_buf_1_89.A sg13cmos5l_dlhr_1_13.Q_N 0.00186f
C6445 a_12933_6141# sg13cmos5l_dfrbp_1_21.Q 0.00166f
C6446 sg13cmos5l_buf_1_79.X a_10450_8874# 0
C6447 sg13cmos5l_dfrbp_1_8.RESET_B a_3407_8797# 0.21747f
C6448 a_3530_6320# sg13cmos5l_inv_1_19.A 0.00296f
C6449 sg13cmos5l_o21ai_1_0.B1 a_11656_3176# 0
C6450 sg13cmos5l_dfrbp_1_6.RESET_B a_422_7362# 0.11071f
C6451 sg13cmos5l_dfrbp_1_6.D a_9558_6144# 0.0016f
C6452 sg13cmos5l_buf_1_59.A a_4736_5498# 0
C6453 sg13cmos5l_dfrbp_1_16.Q a_8247_5770# 0.01305f
C6454 a_14928_5412# sg13cmos5l_a22oi_1_1.Y 0
C6455 a_1227_5423# sg13cmos5l_inv_1_19.A 0.04623f
C6456 sg13cmos5l_dlhr_1_9.D a_8660_5412# 0.00348f
C6457 sg13cmos5l_dlhr_1_1.GATE a_1862_4338# 0.29732f
C6458 sg13cmos5l_dfrbp_1_6.RESET_B a_8084_8436# 0.00196f
C6459 sg13cmos5l_and3_1_0.C sg13cmos5l_nor2_1_1.A 0
C6460 a_9937_8797# pl_sw[5] 0
C6461 sg13cmos5l_nand2_1_1.B a_15439_1630# 0.00599f
C6462 sg13cmos5l_dfrbp_1_6.RESET_B a_5606_3576# 0
C6463 sg13cmos5l_dlhr_1_0.GATE a_6022_4325# 0
C6464 sg13cmos5l_dfrbp_1_17.Q_N sg13cmos5l_dfrbp_1_15.D 0.00599f
C6465 a_15531_7796# sg13cmos5l_buf_1_4.A 0
C6466 a_2314_3361# sg13cmos5l_buf_1_37.A 0
C6467 sg13cmos5l_dfrbp_1_6.RESET_B a_3793_2790# 0
C6468 a_9256_9224# a_9189_8447# 0.01066f
C6469 sg13cmos5l_dfrbp_1_1.Q a_11460_2392# 0
C6470 sg13cmos5l_dfrbp_1_23.Q a_15592_6200# 0
C6471 sg13cmos5l_buf_1_110.A a_14342_8874# 0.00102f
C6472 a_15793_8797# VPWR 0
C6473 sg13cmos5l_a22oi_1_1.B1 sg13cmos5l_o21ai_1_0.B1 0.00415f
C6474 sg13cmos5l_dfrbp_1_0.RESET_B a_11877_2399# 0.07584f
C6475 sg13cmos5l_inv_1_7.A sg13cmos5l_dfrbp_1_0.CLK 1.1664f
C6476 a_12716_8400# sg13cmos5l_dlhr_1_11.Q 0
C6477 a_1760_3986# sg13cmos5l_buf_1_32.A 0
C6478 a_7238_7674# a_8783_7751# 0
C6479 sg13cmos5l_a22oi_1_1.A1 VPWR 0.54285f
C6480 sg13cmos5l_dfrbp_1_11.Q a_7497_3138# 0
C6481 sg13cmos5l_buf_1_5.A sg13cmos5l_dfrbp_1_6.D 0.02523f
C6482 sg13cmos5l_nand2_1_0.A a_11979_2399# 0.02652f
C6483 sg13cmos5l_dfrbp_1_6.RESET_B sg13cmos5l_a22oi_1_2.B2 0.00131f
C6484 a_17700_3456# sg13cmos5l_buf_1_19.X 0.00221f
C6485 sg13cmos5l_buf_1_64.A sg13cmos5l_buf_1_73.X 0
C6486 sg13cmos5l_o21ai_1_0.A1 a_11174_2826# 0
C6487 sg13cmos5l_nand2_1_1.B a_11973_1605# 0
C6488 sg13cmos5l_dfrbp_1_6.RESET_B a_2314_3361# 0.35403f
C6489 sg13cmos5l_buf_1_60.X sg13cmos5l_buf_1_68.X 0
C6490 sg13cmos5l_dlhr_1_10.Q sg13cmos5l_dlhr_1_16.Q_N 0.00153f
C6491 a_12933_6141# sg13cmos5l_or2_1_1.B 0.00959f
C6492 a_4107_4772# a_4640_3986# 0
C6493 sg13cmos5l_buf_1_31.X a_6315_3911# 0
C6494 sg13cmos5l_dfrbp_1_22.D a_18164_7996# 0
C6495 sg13cmos5l_dfrbp_1_16.Q a_3831_7282# 0.00573f
C6496 sg13cmos5l_dlhr_1_0.D a_7508_1948# 0.06224f
C6497 a_10412_6126# sg13cmos5l_a22oi_1_2.B2 0
C6498 sg13cmos5l_buf_1_19.A a_20008_3900# 0
C6499 sg13cmos5l_dfrbp_1_6.RESET_B pl_sw[9] 0.0037f
C6500 sg13cmos5l_dlhr_1_9.D a_1227_5423# 0
C6501 sg13cmos5l_inv_1_14.A a_6961_4261# 0.00782f
C6502 a_10071_7282# sg13cmos5l_a22oi_1_2.B2 0
C6503 sg13cmos5l_a22oi_1_0.B1 sg13cmos5l_o21ai_1_0.A2 0.01179f
C6504 sg13cmos5l_buf_1_24.A sg13cmos5l_dfrbp_1_6.D 0.02753f
C6505 sg13cmos5l_nor2_1_1.A a_15849_2435# 0
C6506 sg13cmos5l_dfrbp_1_20.Q_N sg13cmos5l_dfrbp_1_6.RESET_B 0
C6507 sg13cmos5l_buf_1_90.X sg13cmos5l_buf_1_98.A 0
C6508 sg13cmos5l_buf_1_86.A cks 0
C6509 a_4244_8436# ph_sw[2] 0
C6510 sg13cmos5l_dlhr_1_11.D a_12980_6924# 0
C6511 sg13cmos5l_dlhr_1_15.D a_17337_4965# 0.00104f
C6512 a_12361_7282# cks 0
C6513 a_19227_4654# a_19616_3986# 0.00343f
C6514 sg13cmos5l_nor2_1_0.A sg13cmos5l_nor2_1_1.A 0
C6515 a_7248_3460# VPWR 0
C6516 sg13cmos5l_dfrbp_1_18.Q sg13cmos5l_buf_1_56.A 0
C6517 sg13cmos5l_dlhr_1_5.GATE a_7863_7282# 0.23944f
C6518 sg13cmos5l_dfrbp_1_10.Q sg13cmos5l_buf_1_24.X 0
C6519 sg13cmos5l_dfrbp_1_6.RESET_B a_2409_4650# 0.5149f
C6520 a_3974_2388# VPWR 0.00439f
C6521 sg13cmos5l_dfrbp_1_8.RESET_B a_11464_8436# 0.00764f
C6522 sg13cmos5l_a22oi_1_0.Y a_10783_4292# 0.00559f
C6523 a_14602_8404# a_14426_7288# 0
C6524 a_16940_3102# sg13cmos5l_dfrbp_1_0.Q 0
C6525 a_11771_5412# VPWR 0.27867f
C6526 a_16462_4338# cks 0.01545f
C6527 sg13cmos5l_inv_1_8.Y a_650_3900# 0
C6528 a_12404_7972# a_13047_7690# 0
C6529 sg13cmos5l_dfrbp_1_16.Q_N a_708_6928# 0
C6530 sg13cmos5l_buf_1_57.X a_11752_6294# 0.00688f
C6531 sg13cmos5l_inv_1_8.A a_5604_4338# 0
C6532 a_9705_4650# VPWR 0.63514f
C6533 sg13cmos5l_dfrbp_1_21.Q a_12616_5498# 0.00526f
C6534 sg13cmos5l_a22oi_1_2.B2 a_9832_1664# 0.00713f
C6535 a_3676_7964# sg13cmos5l_dlhr_1_9.D 0
C6536 a_17584_7166# sg13cmos5l_dfrbp_1_22.Q_N 0.15881f
C6537 a_16587_6935# sg13cmos5l_dfrbp_1_8.D 0
C6538 sg13cmos5l_buf_1_18.A a_18793_6216# 0.01391f
C6539 a_1196_8400# sg13cmos5l_buf_1_61.X 0
C6540 sg13cmos5l_inv_1_8.Y sg13cmos5l_dlygate4sd3_1_0.X 0.30182f
C6541 a_6405_8447# VPWR 0.25535f
C6542 sg13cmos5l_nor2_1_0.A a_10464_2427# 0.1346f
C6543 sg13cmos5l_nor2_1_1.A a_14440_1664# 0.00219f
C6544 a_5673_3138# sg13cmos5l_buf_1_24.X 0.00158f
C6545 sg13cmos5l_dfrbp_1_16.Q a_8774_5412# 0
C6546 sg13cmos5l_inv_1_0.A sg13cmos5l_and3_1_0.C 0.44558f
C6547 VPWR nh_sw[8] 0.29555f
C6548 sg13cmos5l_a22oi_1_1.A1 a_16551_3987# 0.00951f
C6549 nh_sw[1] nh_sw[2] 0.07837f
C6550 nh_sw[8] nl_sw[7] 0.11228f
C6551 a_14342_8874# a_14166_7656# 0
C6552 sg13cmos5l_dfrbp_1_8.RESET_B a_17327_7285# 0.20049f
C6553 nh_sw[9] d_out[0] 0
C6554 sg13cmos5l_buf_1_6.A a_14962_3138# 0
C6555 sg13cmos5l_dfrbp_1_6.D sg13cmos5l_dfrbp_1_23.Q 0.02981f
C6556 a_13803_3260# a_13572_3151# 0.15089f
C6557 a_13284_3456# a_14449_3215# 0.4858f
C6558 sg13cmos5l_dfrbp_1_6.RESET_B a_10233_8559# 0
C6559 sg13cmos5l_buf_1_57.X sg13cmos5l_dlhr_1_11.D 0
C6560 a_1864_1664# a_2248_1664# 0.00492f
C6561 sg13cmos5l_dlhr_1_15.D a_14377_5770# 0.0095f
C6562 sg13cmos5l_inv_1_1.A pl_sw[9] 0.01396f
C6563 sg13cmos5l_buf_1_29.A sg13cmos5l_dfrbp_1_1.D 0.09866f
C6564 sg13cmos5l_buf_1_38.A VPWR 0.6392f
C6565 a_19240_7712# a_20008_7712# 0.00136f
C6566 a_18164_7996# a_18097_7666# 0.0018f
C6567 a_18345_7674# a_18300_7710# 0
C6568 sg13cmos5l_buf_1_34.X sg13cmos5l_dfrbp_1_6.RESET_B 1.78543f
C6569 a_17554_4650# sg13cmos5l_a22oi_1_1.A1 0
C6570 a_14032_6382# VPWR 0.14764f
C6571 sg13cmos5l_or2_1_0.A a_15821_3864# 0.00283f
C6572 a_6959_6239# a_7161_6477# 0.00675f
C6573 a_6219_6284# a_6865_6239# 0.00667f
C6574 a_6117_6141# sg13cmos5l_dlhr_1_6.D 0
C6575 sg13cmos5l_inv_1_2.A a_16395_4772# 0.03276f
C6576 sg13cmos5l_buf_1_60.X a_3826_8874# 0
C6577 sg13cmos5l_dlhr_1_1.GATE ckc 0
C6578 a_7520_7010# a_7216_6382# 0
C6579 a_15208_6200# sg13cmos5l_dfrbp_1_21.Q 0
C6580 a_3016_9318# cks 0
C6581 sg13cmos5l_buf_1_79.X a_13100_8400# 0.03562f
C6582 sg13cmos5l_dfrbp_1_6.D a_13460_7996# 0
C6583 sg13cmos5l_o21ai_1_0.Y a_12719_2749# 0
C6584 a_7336_7010# a_7520_7010# 0.11523f
C6585 a_2148_3904# VPWR 0.09714f
C6586 a_18117_3117# VPWR 0.26251f
C6587 sg13cmos5l_or2_1_1.B a_12616_5498# 0.06832f
C6588 a_12216_5728# a_12800_5498# 0.00192f
C6589 sg13cmos5l_dfrbp_1_6.RESET_B a_8746_8404# 0
C6590 sg13cmos5l_inv_1_14.A a_7863_7282# 0
C6591 a_7941_7653# sg13cmos5l_dlhr_1_6.D 0
C6592 a_1948_7964# a_2596_7996# 0.13395f
C6593 sg13cmos5l_buf_1_40.A nh_sw[0] 0.08021f
C6594 a_8043_7796# a_8982_7354# 0
C6595 a_1760_9318# ph_sw[1] 0
C6596 sg13cmos5l_buf_1_95.X sg13cmos5l_dfrbp_1_24.Q_N 0.00925f
C6597 a_2224_7166# cks 0
C6598 sg13cmos5l_dfrbp_1_1.Q a_11979_2399# 0
C6599 a_12075_3911# a_13072_4142# 0.07046f
C6600 sg13cmos5l_dfrbp_1_0.RESET_B a_12976_2630# 0.17677f
C6601 sg13cmos5l_buf_1_9.A a_11530_1849# 0.00374f
C6602 a_17412_1944# nh_sw[9] 0
C6603 sg13cmos5l_dlhr_1_11.GATE sg13cmos5l_inv_1_29.A 0.82473f
C6604 a_8043_7796# a_7812_7687# 0.15089f
C6605 a_7524_7992# a_8689_7751# 0.4858f
C6606 sg13cmos5l_inv_1_17.A sg13cmos5l_inv_1_19.A 0.02823f
C6607 a_8204_9150# VPWR 0.24757f
C6608 sg13cmos5l_buf_1_79.X sg13cmos5l_dfrbp_1_8.RESET_B 3.97909f
C6609 sg13cmos5l_nand2_1_0.A sg13cmos5l_dfrbp_1_4.Q_N 0.00546f
C6610 sg13cmos5l_nor2_1_0.A sg13cmos5l_inv_1_0.A 2.44143f
C6611 a_17751_7690# pl_sw[9] 0
C6612 sg13cmos5l_dfrbp_1_6.RESET_B a_3599_3215# 0.2073f
C6613 sg13cmos5l_nand2_1_1.B a_14056_1664# 0
C6614 a_1125_5423# a_1967_5773# 0.0032f
C6615 sg13cmos5l_dfrbp_1_17.D sg13cmos5l_dfrbp_1_15.D 0
C6616 a_4847_4727# sg13cmos5l_buf_1_44.A 0.00309f
C6617 sg13cmos5l_or2_1_0.A VPWR 3.95843f
C6618 a_9033_6162# a_8905_4704# 0
C6619 a_8852_6484# a_9111_4666# 0
C6620 sg13cmos5l_buf_1_31.X a_8588_3864# 0
C6621 a_13484_8400# a_13768_8436# 0.13542f
C6622 sg13cmos5l_dlhr_1_0.D a_7440_1948# 0
C6623 a_15974_6162# cks 0.05128f
C6624 a_13686_7354# a_13035_6284# 0.0037f
C6625 a_18865_3215# a_18928_1846# 0
C6626 sg13cmos5l_dfrbp_1_16.Q a_4425_7281# 0
C6627 sg13cmos5l_dfrbp_1_11.Q a_9705_4650# 0
C6628 sg13cmos5l_buf_1_73.X VPWR 0.22044f
C6629 a_1096_6294# a_708_5416# 0
C6630 a_9076_5800# sg13cmos5l_a221oi_1_1.C1 0
C6631 sg13cmos5l_dfrbp_1_6.RESET_B a_2122_8404# 0.0022f
C6632 sg13cmos5l_nor2_1_1.A sg13cmos5l_buf_1_18.X 0
C6633 sg13cmos5l_dlhr_1_5.GATE a_5710_5535# 0
C6634 a_12490_6385# sg13cmos5l_nor2_1_0.A 0
C6635 sg13cmos5l_nand2_1_0.B a_11656_3176# 0.00118f
C6636 a_17224_3270# a_17008_2630# 0
C6637 a_3976_9224# a_4460_9150# 0.03472f
C6638 sg13cmos5l_buf_8_2.X ph_sw[9] 0
C6639 a_16657_2749# cks 0
C6640 a_18860_6888# a_18409_5770# 0
C6641 sg13cmos5l_buf_1_105.A a_18856_8436# 0.32115f
C6642 sg13cmos5l_buf_1_3.A a_17882_7684# 0
C6643 sg13cmos5l_nor2_1_1.A a_17700_1639# 0
C6644 sg13cmos5l_buf_1_3.A sg13cmos5l_buf_1_19.X 0.06745f
C6645 sg13cmos5l_dfrbp_1_6.RESET_B a_16940_3102# 0
C6646 sg13cmos5l_buf_1_29.A a_8988_6198# 0
C6647 sg13cmos5l_dfrbp_1_6.RESET_B sg13cmos5l_dlhr_1_1.Q_N 0.00109f
C6648 sg13cmos5l_inv_1_2.A a_10010_9196# 0.0122f
C6649 a_5799_5499# a_6346_4873# 0
C6650 a_7820_2352# VPWR 0.2538f
C6651 sg13cmos5l_dfrbp_1_8.RESET_B sg13cmos5l_buf_1_96.A 0.00123f
C6652 sg13cmos5l_a22oi_1_1.B2 sg13cmos5l_dfrbp_1_0.RESET_B 0.00628f
C6653 sg13cmos5l_inv_1_17.A sg13cmos5l_dlhr_1_9.D 0.03304f
C6654 a_14714_5776# sg13cmos5l_a22oi_1_1.B1 0
C6655 sg13cmos5l_inv_1_2.A pl_sw[6] 0.12941f
C6656 a_17498_8800# pl_sw[9] 0.01138f
C6657 sg13cmos5l_buf_1_40.A ph_sw[0] 0
C6658 sg13cmos5l_dfrbp_1_6.D a_17425_6239# 0
C6659 a_12549_9165# VPWR 0.24613f
C6660 sg13cmos5l_buf_1_44.X a_5988_8440# 0
C6661 a_11270_1626# nh_sw[5] 0.02056f
C6662 sg13cmos5l_nand2_1_0.B sg13cmos5l_a22oi_1_1.B1 0.02813f
C6663 sg13cmos5l_buf_1_24.A a_5194_2356# 0
C6664 sg13cmos5l_buf_1_60.A sg13cmos5l_dfrbp_1_8.RESET_B 0.00305f
C6665 a_17399_3947# cks 0
C6666 a_11824_7894# a_11986_7674# 0.0019f
C6667 a_17516_9150# sg13cmos5l_dlhr_1_15.D 0
C6668 a_17367_8794# ph_sw[8] 0
C6669 a_19904_7806# VPWR 0.07449f
C6670 sg13cmos5l_inv_1_8.A a_6315_3911# 0.0011f
C6671 a_11656_3176# nl_sw[6] 0.28827f
C6672 sg13cmos5l_buf_1_25.A nl_sw[4] 0
C6673 sg13cmos5l_buf_1_107.X a_17961_8793# 0.00279f
C6674 sg13cmos5l_inv_1_17.A sg13cmos5l_buf_1_33.A 0.08227f
C6675 sg13cmos5l_buf_1_19.A sg13cmos5l_nand2_1_1.A 0.60238f
C6676 a_7247_8797# VPWR 0.25205f
C6677 a_5424_3460# VPWR 0
C6678 sg13cmos5l_buf_1_44.X a_5132_3864# 0.36854f
C6679 sg13cmos5l_dlhr_1_1.Q a_2667_3911# 0
C6680 sg13cmos5l_buf_1_94.X ph_sw[9] 0
C6681 a_14800_3358# sg13cmos5l_dfrbp_1_7.Q_N 0.15881f
C6682 sg13cmos5l_a22oi_1_1.A1 a_16462_4023# 0
C6683 sg13cmos5l_buf_1_34.A a_4456_1664# 0.04166f
C6684 sg13cmos5l_buf_1_5.A a_13035_6284# 0
C6685 a_3578_2752# VPWR 0.36388f
C6686 a_1864_9224# sg13cmos5l_dfrbp_1_8.RESET_B 0.01144f
C6687 sg13cmos5l_buf_1_76.X pl_sw[3] 0.03451f
C6688 pl_sw[2] cks 0
C6689 ph_sw[3] ph_sw[4] 0.07097f
C6690 sg13cmos5l_dlhr_1_15.D a_14996_5412# 0.00488f
C6691 sg13cmos5l_buf_1_101.X a_17961_8793# 0
C6692 sg13cmos5l_nor2b_1_0.Y a_11394_4948# 0
C6693 sg13cmos5l_buf_1_45.X a_8439_6178# 0.01045f
C6694 sg13cmos5l_dfrbp_1_4.D sg13cmos5l_buf_1_8.A 0.03591f
C6695 a_3447_2746# nh_sw[2] 0
C6696 sg13cmos5l_a22oi_1_1.B1 nl_sw[6] 0
C6697 sg13cmos5l_or2_1_0.A a_16551_3987# 0.00537f
C6698 sg13cmos5l_buf_1_77.A a_8457_7281# 0.01536f
C6699 sg13cmos5l_dfrbp_1_23.CLK sg13cmos5l_o21ai_1_0.B1 0
C6700 sg13cmos5l_inv_1_8.Y a_2228_4972# 0
C6701 a_11072_5347# VPWR 0.73714f
C6702 sg13cmos5l_dlhr_1_5.Q a_7216_6382# 0
C6703 sg13cmos5l_buf_1_74.X sg13cmos5l_buf_1_77.A 0
C6704 sg13cmos5l_buf_1_74.X pl_sw[4] 0.74207f
C6705 a_11272_8522# a_11190_7354# 0.00121f
C6706 a_1672_3176# VPWR 0.26519f
C6707 sg13cmos5l_dfrbp_1_11.Q sg13cmos5l_or2_1_0.A 0.14812f
C6708 a_18480_5028# sg13cmos5l_buf_8_1.A 0.09336f
C6709 sg13cmos5l_buf_1_77.A a_8985_7989# 0.00178f
C6710 sg13cmos5l_buf_1_3.X VPWR 0.28934f
C6711 a_10473_9186# a_10868_8436# 0.00728f
C6712 a_10292_9508# a_10031_8797# 0.01523f
C6713 a_10010_9196# a_9937_8797# 0
C6714 sg13cmos5l_dfrbp_1_6.RESET_B a_10288_8678# 0.01679f
C6715 sg13cmos5l_dfrbp_1_6.RESET_B a_20118_6144# 0
C6716 a_524_4614# sg13cmos5l_buf_1_43.A 0.33512f
C6717 a_15016_9224# pl_sw[7] 0
C6718 a_2348_7624# sg13cmos5l_buf_1_58.A 0.00176f
C6719 a_5510_4338# a_6084_4325# 0.36169f
C6720 a_5796_3904# a_6213_3911# 0.49014f
C6721 sg13cmos5l_dfrbp_1_1.Q sg13cmos5l_dfrbp_1_4.Q_N 0.00331f
C6722 sg13cmos5l_buf_1_110.A a_14985_8483# 0
C6723 sg13cmos5l_dfrbp_1_0.RESET_B a_14254_2444# 0
C6724 a_996_5837# sg13cmos5l_inv_1_19.A 0
C6725 a_14708_6924# sg13cmos5l_buf_1_89.A 0
C6726 a_14889_7281# a_15124_7312# 0.00566f
C6727 sg13cmos5l_buf_1_9.A a_12815_1703# 0
C6728 sg13cmos5l_dlygate4sd2_1_0.X VPWR 0.41004f
C6729 a_19508_1924# nh_sw[9] 0.02626f
C6730 sg13cmos5l_buf_1_45.A sg13cmos5l_a22oi_1_0.Y 0
C6731 a_8783_7751# a_8689_7751# 0.32273f
C6732 sg13cmos5l_buf_1_19.A sg13cmos5l_dlhr_1_15.Q_N 0.03073f
C6733 sg13cmos5l_dfrbp_1_1.D a_11530_1849# 0
C6734 a_11656_3176# a_11174_2826# 0
C6735 a_17170_2826# nh_sw[8] 0
C6736 sg13cmos5l_dfrbp_1_6.RESET_B a_16485_6935# 0.02372f
C6737 a_20200_3270# a_20012_2352# 0
C6738 a_5132_9150# sg13cmos5l_buf_1_73.X 0.00128f
C6739 sg13cmos5l_buf_1_44.X a_5416_9224# 0.00586f
C6740 sg13cmos5l_dfrbp_1_11.Q a_7820_2352# 0
C6741 sg13cmos5l_dfrbp_1_6.RESET_B sg13cmos5l_dfrbp_1_10.Q_N 0.01457f
C6742 a_1946_4660# VPWR 0.38325f
C6743 sg13cmos5l_inv_1_14.A sg13cmos5l_buf_1_26.A 0.03063f
C6744 sg13cmos5l_dlhr_1_6.D a_14377_5770# 0.00171f
C6745 sg13cmos5l_dfrbp_1_14.Q_N sg13cmos5l_buf_1_44.A 0.00168f
C6746 a_11973_3911# a_13072_4142# 0
C6747 a_11556_3904# a_12815_4261# 0.01741f
C6748 sg13cmos5l_buf_1_56.A a_9524_4972# 0
C6749 sg13cmos5l_buf_1_60.X ph_sw[2] 0.19591f
C6750 a_17776_6382# cks 0
C6751 sg13cmos5l_dfrbp_1_23.Q a_13035_6284# 0.00915f
C6752 a_14295_7282# a_13775_6239# 0.01671f
C6753 sg13cmos5l_dlhr_1_0.D a_10331_1924# 0.03971f
C6754 sg13cmos5l_dlhr_1_1.GATE sg13cmos5l_dlygate4sd2_1_0.A 0
C6755 sg13cmos5l_inv_1_2.A a_10708_9172# 0
C6756 a_12814_4692# sg13cmos5l_or2_1_0.A 0
C6757 sg13cmos5l_buf_1_28.X a_9448_1664# 0.28823f
C6758 a_3831_7282# a_3669_6320# 0
C6759 a_3625_7282# a_3575_6553# 0
C6760 sg13cmos5l_dfrbp_1_6.RESET_B a_3407_8797# 0.00532f
C6761 sg13cmos5l_dlhr_1_11.GATE a_10022_7674# 0.00612f
C6762 sg13cmos5l_dlygate4sd3_1_0.X sg13cmos5l_buf_1_32.A 0.02102f
C6763 sg13cmos5l_inv_1_14.A sg13cmos5l_buf_1_46.A 0
C6764 sg13cmos5l_buf_1_86.A pl_sw[9] 0
C6765 a_11270_4338# a_11530_3868# 0.87117f
C6766 sg13cmos5l_dfrbp_1_8.RESET_B sg13cmos5l_nand2_1_1.A 0
C6767 a_13460_7996# a_13035_6284# 0
C6768 a_2831_7630# sg13cmos5l_inv_1_19.A 0
C6769 sg13cmos5l_dfrbp_1_8.D a_15590_4650# 0.31225f
C6770 sg13cmos5l_buf_1_104.A sg13cmos5l_inv_1_6.A 0.00109f
C6771 sg13cmos5l_buf_1_4.A a_16164_4663# 0.02683f
C6772 sg13cmos5l_dfrbp_1_8.RESET_B a_16293_4629# 0.05259f
C6773 sg13cmos5l_dlhr_1_15.D sg13cmos5l_buf_1_7.A 0
C6774 sg13cmos5l_inv_1_27.Y VPWR 0.61815f
C6775 sg13cmos5l_buf_1_24.A a_5739_2399# 0.00333f
C6776 a_14377_5770# a_13698_5412# 0
C6777 sg13cmos5l_a221oi_1_0.A2 a_8841_5769# 0
C6778 sg13cmos5l_inv_1_0.A sg13cmos5l_o21ai_1_0.Y 0
C6779 a_13392_7996# cks 0
C6780 sg13cmos5l_inv_1_1.A a_16485_6935# 0.0027f
C6781 sg13cmos5l_buf_8_0.A a_18959_3215# 0.00207f
C6782 sg13cmos5l_dfrbp_1_2.D VPWR 0.45133f
C6783 sg13cmos5l_dfrbp_1_16.Q a_10230_4632# 0.00747f
C6784 a_8580_8874# VPWR 0
C6785 sg13cmos5l_inv_1_20.Y sg13cmos5l_dlhr_1_1.GATE 0.01637f
C6786 sg13cmos5l_a221oi_1_0.B1 a_11556_3904# 0
C6787 a_17713_8838# a_17780_8436# 0.0018f
C6788 sg13cmos5l_buf_1_34.A VPWR 0.46784f
C6789 sg13cmos5l_a22oi_1_1.Y a_17674_3361# 0.00732f
C6790 sg13cmos5l_inv_1_2.A sg13cmos5l_buf_1_5.X 0
C6791 sg13cmos5l_dlhr_1_15.D a_18409_5770# 0
C6792 sg13cmos5l_buf_1_19.A sg13cmos5l_dfrbp_1_0.D 0.16284f
C6793 sg13cmos5l_inv_1_28.Y sg13cmos5l_dfrbp_1_6.D 0.00299f
C6794 sg13cmos5l_a221oi_1_0.C1 sg13cmos5l_buf_1_8.X 0
C6795 a_3008_1758# nh_sw[0] 0
C6796 sg13cmos5l_buf_1_45.X sg13cmos5l_buf_1_56.A 0
C6797 sg13cmos5l_buf_1_77.X sg13cmos5l_buf_1_79.X 0
C6798 sg13cmos5l_dfrbp_1_6.D a_1580_2352# 0
C6799 sg13cmos5l_inv_1_8.Y a_416_3986# 0
C6800 sg13cmos5l_inv_1_0.A a_11054_4292# 0.00237f
C6801 sg13cmos5l_buf_1_110.A a_15208_6200# 0
C6802 a_6660_4663# VPWR 0.00674f
C6803 sg13cmos5l_inv_1_7.A a_12216_5728# 0.00189f
C6804 a_20392_2388# VPWR 0.25461f
C6805 a_18870_7656# a_18999_6178# 0
C6806 sg13cmos5l_inv_1_7.A a_12921_2511# 0
C6807 sg13cmos5l_dfrbp_1_16.Q a_6346_4873# 0
C6808 sg13cmos5l_dlhr_1_9.D a_5796_3904# 0
C6809 sg13cmos5l_dfrbp_1_6.D a_15531_7796# 0.00156f
C6810 sg13cmos5l_buf_1_18.A nl_sw[9] 0.00314f
C6811 a_2148_3138# VPWR 0
C6812 a_8692_7312# sg13cmos5l_dlhr_1_5.Q 0
C6813 sg13cmos5l_buf_1_24.A a_6086_4650# 0.0405f
C6814 sg13cmos5l_buf_1_64.A a_3664_8678# 0
C6815 a_1484_9150# sg13cmos5l_inv_1_19.A 0.34009f
C6816 a_12716_8400# pl_sw[6] 0.12518f
C6817 sg13cmos5l_a221oi_1_1.C1 sg13cmos5l_a22oi_1_1.B1 0
C6818 sg13cmos5l_dfrbp_1_6.RESET_B a_11464_8436# 0
C6819 sg13cmos5l_dlhr_1_11.GATE a_12804_6175# 0
C6820 sg13cmos5l_dfrbp_1_6.RESET_B a_19828_6148# 0.00547f
C6821 sg13cmos5l_dfrbp_1_20.Q a_8692_7312# 0
C6822 a_8689_7751# sg13cmos5l_dlhr_1_5.Q 0
C6823 a_16233_5041# sg13cmos5l_buf_1_2.X 0
C6824 sg13cmos5l_buf_1_38.A sg13cmos5l_buf_1_25.X 0.10904f
C6825 sg13cmos5l_inv_1_27.Y a_12698_7288# 0.01429f
C6826 a_1956_8874# VPWR 0
C6827 a_6213_3911# a_7055_4261# 0.0032f
C6828 a_5510_4338# a_6153_3947# 0.00806f
C6829 sg13cmos5l_buf_1_65.X pl_sw[0] 0.46237f
C6830 sg13cmos5l_dfrbp_1_0.CLK sg13cmos5l_buf_1_2.X 0.02403f
C6831 sg13cmos5l_inv_1_3.A ph_sw[7] 0
C6832 a_7863_7282# a_6959_6239# 0
C6833 sg13cmos5l_dfrbp_1_0.Q_N nh_sw[9] 0.05087f
C6834 sg13cmos5l_inv_1_8.A a_6602_5692# 0.00189f
C6835 sg13cmos5l_o21ai_1_0.B1 sg13cmos5l_buf_1_8.X 0
C6836 a_13072_4142# a_12998_3138# 0
C6837 a_12815_4261# a_12896_3270# 0
C6838 sg13cmos5l_dfrbp_1_1.D a_12815_1703# 0
C6839 sg13cmos5l_buf_1_45.A sg13cmos5l_buf_1_46.A 0.0379f
C6840 a_20204_5376# a_20488_5498# 0.01225f
C6841 sg13cmos5l_dfrbp_1_6.D sg13cmos5l_buf_1_31.X 0.38837f
C6842 sg13cmos5l_buf_1_105.A sg13cmos5l_dfrbp_1_8.D 0
C6843 sg13cmos5l_dfrbp_1_6.RESET_B a_17327_7285# 0.02512f
C6844 sg13cmos5l_dfrbp_1_7.Q_N VPWR 0.18346f
C6845 sg13cmos5l_or2_1_1.B a_11370_5760# 0
C6846 a_12216_5728# sg13cmos5l_a221oi_1_0.B2 0
C6847 sg13cmos5l_buf_1_18.A a_19616_3986# 0
C6848 a_12549_9165# a_13047_7690# 0
C6849 a_12132_9504# a_12841_7728# 0
C6850 a_2342_5088# VPWR 0.00711f
C6851 a_9673_9240# sg13cmos5l_dfrbp_1_8.RESET_B 0
C6852 sg13cmos5l_inv_1_7.A sg13cmos5l_buf_1_6.A 0.383f
C6853 a_12106_9409# pl_sw[6] 0.01141f
C6854 a_11560_7010# sg13cmos5l_a221oi_1_0.B2 0
C6855 sg13cmos5l_dfrbp_1_23.Q sg13cmos5l_buf_1_116.A 0
C6856 sg13cmos5l_dfrbp_1_23.CLK a_14714_5776# 0.00622f
C6857 sg13cmos5l_inv_1_18.A a_8022_3120# 0
C6858 a_12719_2749# nh_sw[6] 0
C6859 a_15850_4873# a_16293_4629# 0.02241f
C6860 a_15590_4650# a_15876_4968# 0.50066f
C6861 sg13cmos5l_a22oi_1_1.B1 a_11072_2474# 0
C6862 sg13cmos5l_dfrbp_1_11.Q sg13cmos5l_dfrbp_1_2.D 0.00225f
C6863 sg13cmos5l_dlhr_1_11.GATE a_11567_7751# 0.03444f
C6864 a_1760_3986# sg13cmos5l_buf_1_40.X 0
C6865 sg13cmos5l_a22oi_1_2.B1 a_9448_1664# 0.00459f
C6866 a_708_5416# a_1967_5773# 0.01741f
C6867 a_11530_3868# a_11844_4325# 0.00659f
C6868 a_11556_3904# a_11782_4325# 0.00523f
C6869 sg13cmos5l_dlhr_1_12.D a_16068_6928# 0
C6870 sg13cmos5l_dfrbp_1_6.D a_2804_5412# 0
C6871 sg13cmos5l_inv_1_14.A sg13cmos5l_nand2_1_1.B 0.00211f
C6872 sg13cmos5l_buf_1_0.A nl_sw[9] 0.21465f
C6873 a_17700_3456# sg13cmos5l_buf_1_18.X 0
C6874 sg13cmos5l_buf_1_90.X a_13810_9186# 0
C6875 sg13cmos5l_inv_1_14.A a_7497_3138# 0.07888f
C6876 sg13cmos5l_dfrbp_1_0.Q nl_sw[8] 0.02689f
C6877 sg13cmos5l_dlhr_1_10.Q sg13cmos5l_dlhr_1_16.Q 0.00924f
C6878 sg13cmos5l_inv_1_6.A pl_sw[10] 0
C6879 sg13cmos5l_dlhr_1_0.D a_9260_2352# 0
C6880 a_1864_1664# sg13cmos5l_inv_1_19.A 0.00325f
C6881 a_1096_6294# a_682_5380# 0
C6882 sg13cmos5l_dfrbp_1_8.D a_17392_4870# 0.03273f
C6883 a_18959_3215# a_18928_1846# 0
C6884 a_19216_3358# a_18671_1703# 0.00102f
C6885 sg13cmos5l_dfrbp_1_11.Q a_6660_4663# 0.00166f
C6886 a_17780_8436# a_17894_8436# 0.00122f
C6887 sg13cmos5l_inv_1_5.A a_18959_3215# 0.01282f
C6888 a_18363_4270# a_19216_3358# 0.00631f
C6889 sg13cmos5l_a22oi_1_0.Y sg13cmos5l_o21ai_1_0.A2 0
C6890 sg13cmos5l_buf_1_79.X sg13cmos5l_dfrbp_1_6.RESET_B 0.02108f
C6891 sg13cmos5l_buf_1_24.A a_6385_2749# 0.01273f
C6892 sg13cmos5l_buf_1_90.X sg13cmos5l_dlhr_1_11.Q 0.01162f
C6893 a_13876_7660# cks 0
C6894 sg13cmos5l_inv_1_2.A a_15909_2399# 0
C6895 a_11434_2356# nl_sw[6] 0.0249f
C6896 a_17780_8436# sg13cmos5l_buf_1_105.A 0
C6897 a_17961_8793# a_18196_8824# 0.00566f
C6898 a_9291_8447# VPWR 0.20796f
C6899 a_19412_6484# VPWR 0.10737f
C6900 sg13cmos5l_dfrbp_1_6.D a_3212_1590# 0
C6901 a_8972_3864# sg13cmos5l_buf_1_25.A 0
C6902 sg13cmos5l_dfrbp_1_20.Q_N sg13cmos5l_buf_1_56.A 0
C6903 a_15147_8447# a_15531_7796# 0
C6904 a_16144_8678# a_15429_7653# 0.00485f
C6905 a_15887_8797# a_15012_7992# 0
C6906 sg13cmos5l_dfrbp_1_22.D a_14986_7897# 0.00166f
C6907 a_1862_8874# sg13cmos5l_buf_1_62.X 0
C6908 pl_sw[1] pl_sw[0] 0.03084f
C6909 cks ph_sw[7] 0.00131f
C6910 sg13cmos5l_nand2_1_0.A sg13cmos5l_dfrbp_1_10.Q 0.61789f
C6911 sg13cmos5l_a22oi_1_1.Y a_18057_3529# 0
C6912 sg13cmos5l_buf_1_24.A sg13cmos5l_dlhr_1_4.Q_N 0.00821f
C6913 a_4456_1664# nl_sw[3] 0.28895f
C6914 sg13cmos5l_buf_1_94.X a_16271_7751# 0
C6915 sg13cmos5l_buf_1_57.X sg13cmos5l_inv_1_29.Y 0.02519f
C6916 sg13cmos5l_buf_1_4.A a_15177_5769# 0
C6917 sg13cmos5l_inv_1_0.Y sg13cmos5l_nand2_1_0.A 0
C6918 a_16068_6928# VPWR 0.07256f
C6919 sg13cmos5l_inv_1_29.A sg13cmos5l_dlhr_1_5.Q 0
C6920 sg13cmos5l_dlhr_1_9.D a_7055_4261# 0
C6921 sg13cmos5l_inv_1_9.Y sg13cmos5l_dlygate4sd3_1_0.X 1.37283f
C6922 sg13cmos5l_dfrbp_1_6.D a_15300_7687# 0.00113f
C6923 a_3505_3215# VPWR 0.00112f
C6924 sg13cmos5l_buf_1_64.A sg13cmos5l_dfrbp_1_15.D 0
C6925 a_17896_9224# ph_sw[8] 0.00677f
C6926 sg13cmos5l_nand2_1_1.A sg13cmos5l_dfrbp_1_0.Q 0.00858f
C6927 sg13cmos5l_buf_1_98.A a_14166_7656# 0.56968f
C6928 sg13cmos5l_dfrbp_1_6.D sg13cmos5l_a221oi_1_0.C1 0
C6929 a_3860_2388# a_3688_1664# 0
C6930 a_7052_9150# cks 0
C6931 sg13cmos5l_dfrbp_1_6.RESET_B sg13cmos5l_buf_1_96.A 0.13628f
C6932 a_13297_9263# sg13cmos5l_dfrbp_1_23.CLK 0
C6933 sg13cmos5l_dfrbp_1_20.Q sg13cmos5l_inv_1_29.A 0.02652f
C6934 a_7336_7010# a_6647_5459# 0
C6935 a_1864_1664# sg13cmos5l_buf_1_33.A 0.03566f
C6936 sg13cmos5l_buf_1_35.A a_2248_1664# 0.03249f
C6937 sg13cmos5l_dlhr_1_15.Q a_20008_7712# 0
C6938 a_19240_7712# sg13cmos5l_buf_1_18.A 0.00114f
C6939 a_18870_7656# sg13cmos5l_buf_8_0.X 0
C6940 sg13cmos5l_inv_1_27.Y sg13cmos5l_dlhr_1_11.Q_N 0.00777f
C6941 sg13cmos5l_buf_1_60.A sg13cmos5l_dfrbp_1_6.RESET_B 0.00113f
C6942 a_7312_4142# a_6961_4261# 0.01017f
C6943 sg13cmos5l_nor2_1_0.A sg13cmos5l_dlhr_1_0.D 0.00591f
C6944 a_7055_4261# a_7892_3900# 0.1333f
C6945 a_3664_8678# VPWR 0.14684f
C6946 sg13cmos5l_buf_1_77.A a_7994_7288# 0
C6947 a_17545_7728# a_17584_7166# 0
C6948 a_17751_7690# a_17327_7285# 0.02159f
C6949 a_2122_8404# a_2224_7166# 0
C6950 a_7863_7282# sg13cmos5l_dlhr_1_6.D 0.00606f
C6951 sg13cmos5l_dfrbp_1_16.Q a_8785_6154# 0
C6952 sg13cmos5l_dlhr_1_0.GATE a_7316_3460# 0.00228f
C6953 sg13cmos5l_dfrbp_1_0.RESET_B a_17414_3138# 0.10278f
C6954 a_7863_7282# a_8412_7326# 0
C6955 a_7994_7288# a_8457_7281# 0.13395f
C6956 sg13cmos5l_buf_1_96.A a_10071_7282# 0
C6957 a_18856_8436# VPWR 0.2533f
C6958 sg13cmos5l_dlhr_1_0.GATE a_4934_2826# 0.00209f
C6959 a_11174_2826# a_11434_2356# 0.87117f
C6960 sg13cmos5l_inv_1_27.Y a_13047_7690# 0
C6961 a_13391_9263# a_13641_7674# 0.00588f
C6962 sg13cmos5l_dlhr_1_11.GATE a_11752_6294# 0
C6963 sg13cmos5l_inv_1_7.A a_12815_1703# 0
C6964 sg13cmos5l_or2_1_0.A a_12120_3456# 0
C6965 sg13cmos5l_buf_1_44.A a_5510_4338# 0.04767f
C6966 sg13cmos5l_dfrbp_1_0.CLK a_13258_3361# 0.01112f
C6967 sg13cmos5l_dfrbp_1_23.CLK a_15177_5769# 0
C6968 a_1760_9318# sg13cmos5l_buf_1_61.X 0.00205f
C6969 a_1997_6126# a_1815_4666# 0.00353f
C6970 sg13cmos5l_nor2_1_1.A nh_sw[6] 0
C6971 a_16293_4629# a_17135_4727# 0.00437f
C6972 a_15876_4968# a_17392_4870# 0.00294f
C6973 a_15500_9150# a_15147_8447# 0
C6974 sg13cmos5l_dfrbp_1_6.RESET_B sg13cmos5l_a221oi_1_0.B1 0
C6975 sg13cmos5l_a221oi_1_0.C1 a_10024_5498# 0.00148f
C6976 sg13cmos5l_dlhr_1_11.GATE sg13cmos5l_dlhr_1_11.D 0.73283f
C6977 a_4847_4727# a_4873_3192# 0.00176f
C6978 a_5104_4870# a_5079_3154# 0
C6979 sg13cmos5l_inv_1_7.A sg13cmos5l_buf_1_5.A 0.0251f
C6980 sg13cmos5l_dfrbp_1_6.D a_6219_6284# 0.01174f
C6981 sg13cmos5l_buf_1_19.A a_18345_7674# 0.00219f
C6982 a_8841_5769# a_8905_4704# 0.00656f
C6983 a_9366_5842# a_9111_4666# 0.00584f
C6984 sg13cmos5l_buf_1_73.A VPWR 0.58117f
C6985 a_18793_6216# sg13cmos5l_buf_8_0.A 0
C6986 sg13cmos5l_dfrbp_1_6.RESET_B a_13094_6924# 0
C6987 a_17498_8800# a_17327_7285# 0
C6988 a_17367_8794# a_17233_7285# 0
C6989 sg13cmos5l_buf_1_3.X a_20012_2352# 0
C6990 a_12520_4782# a_12075_3911# 0
C6991 sg13cmos5l_inv_1_14.A a_7248_3460# 0
C6992 a_2790_7996# cks 0
C6993 sg13cmos5l_dfrbp_1_8.RESET_B a_15884_3102# 0
C6994 a_7498_7897# a_7881_8065# 0.00337f
C6995 sg13cmos5l_buf_1_107.X a_18345_7674# 0
C6996 sg13cmos5l_a22oi_1_2.B2 sg13cmos5l_buf_1_8.A 0
C6997 sg13cmos5l_inv_1_8.A sg13cmos5l_dfrbp_1_6.D 0.10454f
C6998 sg13cmos5l_inv_1_17.A a_3488_7010# 0
C6999 a_14714_5776# a_15110_5412# 0.00949f
C7000 a_15177_5769# a_15132_5814# 0
C7001 sg13cmos5l_nand2_1_0.B sg13cmos5l_buf_1_8.X 0
C7002 a_7452_3174# sg13cmos5l_buf_1_25.A 0
C7003 sg13cmos5l_dfrbp_1_8.RESET_B a_4076_5376# 0.03859f
C7004 a_16940_3102# a_16657_2749# 0
C7005 sg13cmos5l_buf_1_64.A a_4460_9150# 0.0087f
C7006 sg13cmos5l_inv_1_14.A a_6405_8447# 0.03959f
C7007 sg13cmos5l_dfrbp_1_10.Q sg13cmos5l_dfrbp_1_1.Q 0.08995f
C7008 a_11748_2813# nl_sw[6] 0.02641f
C7009 sg13cmos5l_dfrbp_1_6.RESET_B a_17961_8793# 0.47387f
C7010 sg13cmos5l_buf_1_101.X a_18345_7674# 0
C7011 sg13cmos5l_dfrbp_1_27.Q_N VPWR 0.17811f
C7012 a_4559_7630# a_4425_7281# 0
C7013 sg13cmos5l_dfrbp_1_16.Q_N a_4244_6924# 0
C7014 sg13cmos5l_dlhr_1_1.GATE a_422_5850# 0
C7015 sg13cmos5l_buf_1_3.A sg13cmos5l_buf_1_18.X 0
C7016 a_1846_7850# sg13cmos5l_buf_1_61.X 0
C7017 sg13cmos5l_dfrbp_1_22.D a_15429_7653# 0.38474f
C7018 a_16724_8436# a_16528_7894# 0
C7019 a_2667_8447# sg13cmos5l_buf_1_62.X 0
C7020 sg13cmos5l_inv_1_0.Y sg13cmos5l_dfrbp_1_1.Q 0
C7021 sg13cmos5l_buf_1_5.A sg13cmos5l_dlhr_1_13.Q_N 0
C7022 a_19424_7010# a_18999_6178# 0.00276f
C7023 VPWR nl_sw[3] 0.11479f
C7024 a_2122_8404# pl_sw[2] 0
C7025 a_13178_7684# ph_sw[6] 0
C7026 sg13cmos5l_inv_1_2.A a_17354_4180# 0.00215f
C7027 a_13486_5760# a_14377_5770# 0
C7028 sg13cmos5l_a22oi_1_1.B2 a_14583_5770# 0.03717f
C7029 sg13cmos5l_buf_1_94.X sg13cmos5l_dlhr_1_15.D 0
C7030 sg13cmos5l_dlhr_1_1.Q a_2859_3260# 0
C7031 sg13cmos5l_buf_1_26.A nl_sw[4] 0.53559f
C7032 sg13cmos5l_buf_1_31.X a_1121_4166# 0
C7033 a_1815_4666# a_2364_4686# 0
C7034 sg13cmos5l_buf_1_8.X nl_sw[6] 0.12342f
C7035 a_17584_7166# VPWR 0.14737f
C7036 sg13cmos5l_dfrbp_1_6.RESET_B sg13cmos5l_nand2_1_1.A 0
C7037 sg13cmos5l_buf_1_77.X a_9673_9240# 0
C7038 sg13cmos5l_inv_1_7.A sg13cmos5l_dfrbp_1_23.Q 0
C7039 sg13cmos5l_buf_1_77.A a_8247_5770# 0.00158f
C7040 a_5028_2826# sg13cmos5l_buf_1_39.A 0
C7041 sg13cmos5l_buf_1_34.A sg13cmos5l_buf_1_25.X 0.03904f
C7042 a_14449_3215# a_14440_1664# 0
C7043 sg13cmos5l_inv_1_6.A a_19734_5842# 0.00659f
C7044 a_424_8436# a_616_9224# 0
C7045 sg13cmos5l_buf_1_97.A a_9291_8447# 0
C7046 sg13cmos5l_dfrbp_1_6.RESET_B a_16293_4629# 0.00898f
C7047 sg13cmos5l_dlhr_1_11.Q a_12567_7282# 0.00111f
C7048 a_13701_3117# sg13cmos5l_dfrbp_1_0.Q 0
C7049 a_8457_7281# a_8247_5770# 0
C7050 a_1192_1664# nl_sw[2] 0
C7051 sg13cmos5l_buf_1_41.X nh_sw[2] 0
C7052 sg13cmos5l_dfrbp_1_15.D VPWR 1.08902f
C7053 sg13cmos5l_a22oi_1_2.B2 a_10433_4248# 0.00144f
C7054 sg13cmos5l_inv_1_8.A a_2374_4325# 0
C7055 sg13cmos5l_dfrbp_1_0.D sg13cmos5l_dfrbp_1_0.Q 0.89528f
C7056 sg13cmos5l_dlhr_1_15.D sg13cmos5l_nand2_1_1.B 0.02441f
C7057 a_2248_1664# nh_sw[1] 0.00104f
C7058 sg13cmos5l_buf_1_40.A VPWR 0.75959f
C7059 sg13cmos5l_dfrbp_1_1.Q a_18959_3215# 0
C7060 sg13cmos5l_inv_1_17.A a_3664_4142# 0.03096f
C7061 sg13cmos5l_nand2_1_1.A a_14543_3215# 0.03666f
C7062 sg13cmos5l_buf_1_96.A a_10620_7326# 0
C7063 sg13cmos5l_dfrbp_1_0.RESET_B a_19216_3358# 0.18227f
C7064 a_3599_3215# a_4172_1590# 0
C7065 sg13cmos5l_dlhr_1_5.GATE a_7247_8797# 0
C7066 sg13cmos5l_dlhr_1_0.GATE a_5446_2813# 0
C7067 a_12998_3138# a_13284_3456# 0.50066f
C7068 a_13258_3361# a_13641_3529# 0.00337f
C7069 sg13cmos5l_buf_1_34.X a_4107_4772# 0.02899f
C7070 a_11174_2826# a_11748_2813# 0.36169f
C7071 sg13cmos5l_inv_1_14.A sg13cmos5l_or2_1_0.A 0.2614f
C7072 sg13cmos5l_dfrbp_1_20.Q a_10022_7674# 0.05451f
C7073 sg13cmos5l_buf_1_2.A sg13cmos5l_buf_1_2.X 0.13653f
C7074 sg13cmos5l_dfrbp_1_16.Q a_3562_4873# 0
C7075 sg13cmos5l_buf_1_73.X sg13cmos5l_inv_1_14.A 0.04506f
C7076 sg13cmos5l_buf_1_44.A a_6084_4325# 0.00223f
C7077 sg13cmos5l_dfrbp_1_0.CLK a_13641_3529# 0
C7078 sg13cmos5l_buf_1_24.A sg13cmos5l_dfrbp_1_9.Q 0
C7079 a_20012_2352# a_20392_2388# 0.07249f
C7080 a_2879_6432# a_2409_4650# 0.00324f
C7081 a_2380_6162# a_1946_4660# 0
C7082 sg13cmos5l_inv_1_18.A a_8588_2352# 0.00541f
C7083 a_4244_6924# a_4176_6924# 0
C7084 sg13cmos5l_buf_1_8.X a_11174_2826# 0.01172f
C7085 sg13cmos5l_dfrbp_1_6.D a_5988_6175# 0
C7086 a_12075_3911# a_12520_3176# 0
C7087 sg13cmos5l_a22oi_1_2.B1 a_11270_1626# 0
C7088 a_19734_5842# a_20204_5376# 0.03379f
C7089 a_19028_5412# a_19142_5412# 0.00122f
C7090 sg13cmos5l_buf_1_45.A a_9705_4650# 0
C7091 sg13cmos5l_dlhr_1_12.D sg13cmos5l_dfrbp_1_8.D 0
C7092 sg13cmos5l_dfrbp_1_6.D a_8276_6924# 0.00424f
C7093 sg13cmos5l_dlhr_1_9.D a_6741_5459# 0.00438f
C7094 sg13cmos5l_buf_1_31.X a_5739_2399# 0
C7095 sg13cmos5l_buf_1_44.X sg13cmos5l_buf_1_76.X 0.10706f
C7096 sg13cmos5l_dfrbp_1_8.D a_15821_3864# 0
C7097 sg13cmos5l_dfrbp_1_16.Q_N cks 0
C7098 a_15531_7796# sg13cmos5l_buf_1_116.A 0
C7099 sg13cmos5l_inv_1_14.A a_7820_2352# 0.2913f
C7100 sg13cmos5l_dlhr_1_6.D sg13cmos5l_buf_1_46.A 0
C7101 a_5104_4870# a_5266_4650# 0.0019f
C7102 sg13cmos5l_dfrbp_1_6.D a_9620_7972# 0
C7103 sg13cmos5l_dfrbp_1_8.RESET_B a_16572_4261# 0
C7104 sg13cmos5l_dlhr_1_1.GATE sg13cmos5l_nand2_1_2.B 0.00265f
C7105 a_15206_2826# nl_sw[8] 0.00169f
C7106 sg13cmos5l_a22oi_1_1.B1 sg13cmos5l_dfrbp_1_4.D 0
C7107 sg13cmos5l_inv_1_11.Y a_9832_1664# 0
C7108 a_12704_4782# a_11556_3904# 0
C7109 a_12520_4782# a_11973_3911# 0
C7110 a_3588_4968# a_4436_3436# 0
C7111 a_4107_4772# a_3599_3215# 0
C7112 a_17961_8793# a_17751_7690# 0.00238f
C7113 a_17780_8436# a_17545_7728# 0.00365f
C7114 sg13cmos5l_buf_1_29.A nl_sw[5] 0
C7115 sg13cmos5l_buf_1_30.X a_6889_1680# 0
C7116 a_13072_4142# VPWR 0.14962f
C7117 a_15177_5769# a_15110_5412# 0
C7118 sg13cmos5l_buf_1_31.X a_5210_3148# 0.01229f
C7119 sg13cmos5l_inv_1_2.A nh_sw[7] 0.00258f
C7120 sg13cmos5l_dfrbp_1_8.RESET_B sg13cmos5l_dfrbp_1_29.Q_N 0.00734f
C7121 a_7689_1626# a_7508_1948# 0.40925f
C7122 a_16552_1664# nl_sw[8] 0.0021f
C7123 sg13cmos5l_inv_1_14.A a_7247_8797# 0.00156f
C7124 sg13cmos5l_dfrbp_1_21.Q a_13652_3900# 0
C7125 sg13cmos5l_nand2_1_1.B sg13cmos5l_o21ai_1_0.A2 0.00897f
C7126 a_16177_7751# cks 0.00405f
C7127 a_9673_9240# sg13cmos5l_dfrbp_1_6.RESET_B 0
C7128 a_10010_9196# a_10292_9508# 0.68988f
C7129 a_11817_2435# nl_sw[6] 0
C7130 sg13cmos5l_inv_1_26.Y a_20392_7712# 0
C7131 sg13cmos5l_buf_1_111.A a_20008_7712# 0.00171f
C7132 a_10292_9508# pl_sw[6] 0
C7133 a_13768_8436# VPWR 0.24781f
C7134 sg13cmos5l_buf_1_65.X a_7524_7992# 0
C7135 sg13cmos5l_dlhr_1_6.D a_13681_6239# 0.00771f
C7136 sg13cmos5l_buf_8_2.X sg13cmos5l_inv_1_6.A 0.36191f
C7137 sg13cmos5l_buf_1_104.A sg13cmos5l_buf_1_104.X 0.10564f
C7138 sg13cmos5l_dfrbp_1_22.D a_16473_7989# 0
C7139 sg13cmos5l_dfrbp_1_6.D a_14714_5776# 0
C7140 sg13cmos5l_inv_1_3.A sg13cmos5l_a22oi_1_1.B1 0.01799f
C7141 a_4460_9150# VPWR 0.24923f
C7142 sg13cmos5l_buf_1_79.X a_12361_7282# 0.0017f
C7143 ph_sw[7] pl_sw[9] 0.01627f
C7144 sg13cmos5l_nor2b_1_0.Y a_11268_2826# 0
C7145 sg13cmos5l_dfrbp_1_6.D a_708_6928# 0.00741f
C7146 a_20288_7010# a_20118_6144# 0.00373f
C7147 sg13cmos5l_dlhr_1_15.D sg13cmos5l_a22oi_1_1.A1 0.01633f
C7148 a_3407_8797# pl_sw[2] 0
C7149 sg13cmos5l_inv_1_14.A a_6729_5041# 0
C7150 sg13cmos5l_a22oi_1_1.B2 a_14929_5814# 0
C7151 sg13cmos5l_dfrbp_1_2.D a_10783_4292# 0
C7152 a_6903_3154# sg13cmos5l_buf_1_25.A 0.01749f
C7153 sg13cmos5l_buf_1_10.A sg13cmos5l_nor2b_1_0.Y 0.12567f
C7154 sg13cmos5l_buf_1_19.A a_18574_5028# 0.0025f
C7155 sg13cmos5l_inv_1_17.A a_3792_2388# 0
C7156 sg13cmos5l_buf_1_24.X a_6572_1590# 0.28784f
C7157 a_3562_4873# a_4005_4629# 0.02241f
C7158 sg13cmos5l_dfrbp_1_9.Q a_3588_4968# 0.00815f
C7159 sg13cmos5l_dfrbp_1_8.D VPWR 1.00508f
C7160 sg13cmos5l_inv_1_2.A a_13641_7674# 0
C7161 a_17367_8794# a_17916_8838# 0
C7162 a_17498_8800# a_17961_8793# 0.13395f
C7163 sg13cmos5l_dlhr_1_12.D a_17780_8436# 0
C7164 sg13cmos5l_buf_1_45.X a_9076_5800# 0
C7165 sg13cmos5l_dlhr_1_9.D a_9638_5088# 0
C7166 sg13cmos5l_inv_1_8.A a_5702_8874# 0.02906f
C7167 sg13cmos5l_dlhr_1_11.GATE a_11846_9186# 0.30057f
C7168 sg13cmos5l_or2_1_1.B a_13652_3900# 0
C7169 sg13cmos5l_dfrbp_1_18.Q a_8982_7354# 0.00342f
C7170 sg13cmos5l_buf_1_97.A sg13cmos5l_dfrbp_1_27.Q_N 0.00223f
C7171 sg13cmos5l_a22oi_1_1.Y sg13cmos5l_buf_1_4.X 0.02074f
C7172 sg13cmos5l_dlhr_1_11.Q a_13116_7326# 0
C7173 sg13cmos5l_dfrbp_1_6.RESET_B sg13cmos5l_dfrbp_1_0.D 0.00252f
C7174 sg13cmos5l_buf_1_45.A sg13cmos5l_or2_1_0.A 0.0093f
C7175 sg13cmos5l_buf_1_111.A a_19624_8436# 0.02218f
C7176 sg13cmos5l_nand2_1_1.A a_15206_2826# 0
C7177 a_1196_8400# sg13cmos5l_buf_1_68.X 0
C7178 a_16264_9224# a_15429_7653# 0
C7179 sg13cmos5l_buf_1_93.X a_14726_7674# 0
C7180 a_8972_3864# sg13cmos5l_a22oi_1_0.Y 0
C7181 a_12404_7972# sg13cmos5l_dlhr_1_6.D 0
C7182 sg13cmos5l_inv_1_8.A a_3826_4338# 0
C7183 sg13cmos5l_buf_8_1.A sg13cmos5l_nor2_1_1.A 0
C7184 a_10308_7992# sg13cmos5l_inv_1_29.A 0
C7185 sg13cmos5l_dlhr_1_1.D a_1956_4338# 0
C7186 sg13cmos5l_buf_1_0.X VPWR 0.29826f
C7187 a_15592_6200# a_15177_5769# 0.01001f
C7188 sg13cmos5l_dfrbp_1_15.D a_1967_7285# 0.02141f
C7189 a_12912_6924# VPWR 0
C7190 sg13cmos5l_dfrbp_1_18.Q a_7812_7687# 0
C7191 sg13cmos5l_dfrbp_1_6.RESET_B a_6681_2511# 0.00343f
C7192 sg13cmos5l_dfrbp_1_20.Q sg13cmos5l_a221oi_1_0.A2 0
C7193 a_12420_9199# a_11567_7751# 0
C7194 sg13cmos5l_inv_1_7.A ph_sw[5] 0.01262f
C7195 sg13cmos5l_buf_1_65.X a_1088_7806# 0
C7196 sg13cmos5l_buf_1_40.A a_1967_7285# 0
C7197 sg13cmos5l_buf_1_96.A a_12361_7282# 0
C7198 a_13100_8400# a_12980_6924# 0
C7199 a_16587_6935# a_16677_6141# 0.00922f
C7200 a_17584_7166# a_16260_6480# 0
C7201 sg13cmos5l_dfrbp_1_6.RESET_B a_8214_1608# 0.00623f
C7202 sg13cmos5l_a22oi_1_2.B2 sg13cmos5l_o21ai_1_0.A1 0
C7203 sg13cmos5l_dlhr_1_0.GATE a_8204_2352# 0
C7204 a_6213_3911# a_6697_3192# 0
C7205 sg13cmos5l_nand2_1_1.A a_15702_4187# 0
C7206 sg13cmos5l_buf_1_6.A sg13cmos5l_buf_1_2.X 0
C7207 sg13cmos5l_o21ai_1_0.Y a_14449_3215# 0
C7208 a_13284_3456# a_14800_3358# 0.00294f
C7209 a_13701_3117# a_14543_3215# 0.00437f
C7210 sg13cmos5l_buf_1_34.X a_5104_4870# 0.002f
C7211 a_11174_2826# a_11817_2435# 0.00806f
C7212 a_11877_2399# a_12719_2749# 0.0032f
C7213 sg13cmos5l_buf_1_64.A pl_sw[3] 0
C7214 sg13cmos5l_inv_1_27.Y a_14536_7806# 0.00455f
C7215 sg13cmos5l_inv_1_8.A a_1121_4166# 0.01408f
C7216 sg13cmos5l_dfrbp_1_6.RESET_B a_9457_4642# 0
C7217 sg13cmos5l_dlhr_1_15.D a_11771_5412# 0.00497f
C7218 a_1227_5423# a_1402_3864# 0
C7219 a_17882_7684# a_18278_8112# 0.00949f
C7220 a_15876_4968# a_15821_3864# 0.00911f
C7221 sg13cmos5l_buf_1_44.A a_6153_3947# 0
C7222 sg13cmos5l_a221oi_1_0.C1 a_10587_4692# 0.37695f
C7223 sg13cmos5l_dfrbp_1_1.Q a_13572_3151# 0.0243f
C7224 sg13cmos5l_dfrbp_1_23.Q a_14822_6924# 0
C7225 sg13cmos5l_inv_1_8.A ph_sw[3] 0
C7226 a_2224_5654# a_1815_4666# 0.00367f
C7227 a_1227_5423# a_1609_4704# 0.00588f
C7228 a_17896_9224# a_18376_9224# 0.00377f
C7229 sg13cmos5l_buf_1_8.X a_11072_2474# 0.00244f
C7230 sg13cmos5l_o21ai_1_0.B1 sg13cmos5l_buf_1_9.A 0
C7231 a_12721_4261# sg13cmos5l_buf_1_6.A 0
C7232 a_7657_7282# sg13cmos5l_dlhr_1_5.D 0.15661f
C7233 sg13cmos5l_dlhr_1_16.Q a_20672_5498# 0
C7234 a_2169_7047# sg13cmos5l_inv_1_19.A 0
C7235 sg13cmos5l_dfrbp_1_8.RESET_B a_12980_6924# 0
C7236 a_17780_8436# VPWR 0.10798f
C7237 sg13cmos5l_a22oi_1_1.B1 cks 0
C7238 sg13cmos5l_dlhr_1_9.D sg13cmos5l_a221oi_1_0.A2 0.2662f
C7239 a_424_9318# sg13cmos5l_buf_1_61.X 0
C7240 a_3976_9224# sg13cmos5l_buf_1_62.X 0
C7241 sg13cmos5l_dfrbp_1_8.D a_16551_3987# 0.00152f
C7242 sg13cmos5l_dfrbp_1_6.RESET_B a_10428_9222# 0
C7243 a_10010_9196# sg13cmos5l_buf_1_90.X 0
C7244 sg13cmos5l_buf_1_90.X pl_sw[6] 0.25776f
C7245 sg13cmos5l_dlhr_1_15.D a_14032_6382# 0
C7246 a_15300_7687# sg13cmos5l_buf_1_116.A 0
C7247 a_17126_1626# nl_sw[9] 0.00317f
C7248 sg13cmos5l_inv_1_18.A a_8772_8440# 0.01205f
C7249 a_11973_3911# a_12520_3176# 0.00457f
C7250 sg13cmos5l_dfrbp_1_8.RESET_B a_16703_3871# 0.00845f
C7251 sg13cmos5l_buf_1_95.X sg13cmos5l_buf_1_98.A 0
C7252 a_13686_7354# a_14708_6924# 0
C7253 a_12698_7288# a_12912_6924# 0.01249f
C7254 sg13cmos5l_a221oi_1_0.A2 a_7892_3900# 0.13325f
C7255 a_19161_3453# d_out[1] 0
C7256 sg13cmos5l_buf_1_2.A sg13cmos5l_dfrbp_1_0.CLK 0.31088f
C7257 a_12232_8436# sg13cmos5l_buf_1_5.A 0
C7258 a_4107_4772# sg13cmos5l_dfrbp_1_10.Q_N 0
C7259 sg13cmos5l_dfrbp_1_2.Q_N VPWR 0.17906f
C7260 sg13cmos5l_buf_1_30.X a_9448_1664# 0.04763f
C7261 sg13cmos5l_buf_1_31.X sg13cmos5l_dlhr_1_4.Q_N 0.00615f
C7262 a_18615_5770# a_19028_5412# 0.15652f
C7263 a_7226_1636# a_7622_2064# 0.00949f
C7264 a_7095_1642# a_7441_1618# 0.00722f
C7265 sg13cmos5l_buf_1_31.X a_4041_2745# 0
C7266 a_4460_9150# a_5132_9150# 0
C7267 a_3976_9224# sg13cmos5l_buf_1_44.X 0
C7268 sg13cmos5l_and3_1_0.C a_12075_3911# 0
C7269 sg13cmos5l_buf_1_104.X pl_sw[10] 0.01286f
C7270 a_18856_8436# ph_sw[9] 0.00256f
C7271 a_2596_7996# cks 0.00463f
C7272 a_15876_4968# VPWR 0.07206f
C7273 sg13cmos5l_dlhr_1_0.D sg13cmos5l_buf_1_26.X 0.00184f
C7274 sg13cmos5l_buf_1_35.A sg13cmos5l_inv_1_19.A 0.00684f
C7275 sg13cmos5l_buf_1_19.A a_18671_1703# 0
C7276 sg13cmos5l_dfrbp_1_8.RESET_B sg13cmos5l_buf_1_57.X 0.17986f
C7277 sg13cmos5l_buf_1_19.A a_18363_4270# 0.04971f
C7278 a_10331_3900# VPWR 0.36013f
C7279 sg13cmos5l_dfrbp_1_6.D a_15177_5769# 0
C7280 sg13cmos5l_buf_1_31.X a_7631_4727# 0
C7281 sg13cmos5l_inv_1_20.Y a_2748_6126# 0
C7282 sg13cmos5l_buf_1_30.A sg13cmos5l_dfrbp_1_16.Q 0.02481f
C7283 sg13cmos5l_dfrbp_1_23.CLK sg13cmos5l_dfrbp_1_23.Q_N 0.73251f
C7284 a_20392_6924# a_20488_6294# 0.00705f
C7285 a_19227_4654# d_out[2] 0.00439f
C7286 a_12489_9577# sg13cmos5l_buf_1_95.X 0
C7287 sg13cmos5l_inv_1_3.A a_13486_5412# 0
C7288 sg13cmos5l_inv_1_14.A a_6660_4663# 0.01883f
C7289 sg13cmos5l_buf_1_31.X a_2340_3456# 0.02446f
C7290 sg13cmos5l_dfrbp_1_6.RESET_B a_10417_7326# 0.00144f
C7291 a_5628_3174# sg13cmos5l_buf_1_25.A 0
C7292 sg13cmos5l_dfrbp_1_9.Q a_3396_4650# 0
C7293 a_6184_9224# a_5702_8874# 0
C7294 a_3008_1758# VPWR 0.074f
C7295 sg13cmos5l_buf_1_57.X a_15414_7354# 0
C7296 sg13cmos5l_buf_1_25.A a_5220_2392# 0.02482f
C7297 sg13cmos5l_dlhr_1_15.D sg13cmos5l_or2_1_0.A 0
C7298 sg13cmos5l_dfrbp_1_0.Q a_15492_2392# 0
C7299 sg13cmos5l_dfrbp_1_20.Q a_10726_5760# 0
C7300 a_6507_8447# a_7524_7992# 0
C7301 a_7504_8678# a_7238_7674# 0
C7302 sg13cmos5l_dlhr_1_6.D a_12230_6162# 0.01212f
C7303 a_6117_6141# a_6372_4968# 0
C7304 sg13cmos5l_inv_1_6.A sg13cmos5l_a22oi_1_1.A1 0.08408f
C7305 sg13cmos5l_dlhr_1_5.Q a_11752_6294# 0
C7306 sg13cmos5l_inv_1_28.Y sg13cmos5l_inv_1_7.A 0.18493f
C7307 sg13cmos5l_dfrbp_1_17.D sg13cmos5l_buf_1_62.X 0.0122f
C7308 sg13cmos5l_dfrbp_1_8.RESET_B a_1873_7285# 0
C7309 sg13cmos5l_a22oi_1_0.B1 sg13cmos5l_dfrbp_1_10.Q 0
C7310 a_9865_7282# a_10202_7288# 0.64635f
C7311 a_10071_7282# a_10417_7326# 0.00722f
C7312 sg13cmos5l_buf_1_5.A a_14708_6924# 0
C7313 sg13cmos5l_buf_1_25.X nl_sw[3] 0.10335f
C7314 sg13cmos5l_buf_1_43.A a_650_3900# 0.00128f
C7315 sg13cmos5l_buf_1_93.X a_16528_7894# 0
C7316 sg13cmos5l_dfrbp_1_20.Q a_11752_6294# 0.00112f
C7317 a_11824_7894# sg13cmos5l_inv_1_29.A 0
C7318 a_6741_5459# a_6647_5459# 0.87117f
C7319 sg13cmos5l_inv_1_17.A a_3241_2746# 0.01362f
C7320 sg13cmos5l_a221oi_1_0.B1 a_11980_4948# 0
C7321 sg13cmos5l_a221oi_1_0.B2 a_11182_4948# 0.00408f
C7322 sg13cmos5l_buf_1_46.A a_8972_3864# 0.03769f
C7323 sg13cmos5l_inv_1_8.A a_6086_4650# 0.05024f
C7324 sg13cmos5l_buf_1_18.A sg13cmos5l_dfrbp_1_21.Q 0
C7325 sg13cmos5l_buf_1_31.X a_2934_4632# 0
C7326 sg13cmos5l_or2_1_1.B a_11844_4325# 0
C7327 sg13cmos5l_nor2_1_0.A a_12075_3911# 0.00534f
C7328 sg13cmos5l_buf_1_43.A sg13cmos5l_dlygate4sd3_1_0.X 0.17009f
C7329 a_12420_9199# sg13cmos5l_dlhr_1_11.D 0
C7330 a_13768_8436# sg13cmos5l_dlhr_1_11.Q_N 0
C7331 sg13cmos5l_nand2_1_1.A a_15200_1758# 0
C7332 a_18164_6924# a_17519_6239# 0.00529f
C7333 sg13cmos5l_dfrbp_1_8.D a_16260_6480# 0.09831f
C7334 sg13cmos5l_dfrbp_1_6.RESET_B a_7622_2064# 0
C7335 a_17327_7285# a_17776_6382# 0.00459f
C7336 a_908_1590# nl_sw[2] 0
C7337 a_7312_4142# a_7497_3138# 0
C7338 sg13cmos5l_dlhr_1_11.Q a_14166_7656# 0
C7339 sg13cmos5l_inv_1_26.Y ph_sw[8] 0.00393f
C7340 a_7055_4261# a_7034_3148# 0
C7341 a_6961_4261# a_6903_3154# 0
C7342 sg13cmos5l_buf_1_40.A a_1484_6126# 0.28928f
C7343 a_3860_2388# sg13cmos5l_buf_1_39.A 0.00359f
C7344 sg13cmos5l_buf_1_34.X sg13cmos5l_dlhr_1_0.GATE 0.0046f
C7345 a_12976_2630# a_12719_2749# 0.35645f
C7346 sg13cmos5l_dfrbp_1_0.CLK a_12921_2511# 0.00107f
C7347 sg13cmos5l_dfrbp_1_6.D sg13cmos5l_a221oi_1_1.C1 0
C7348 sg13cmos5l_dfrbp_1_8.RESET_B a_16779_6284# 0
C7349 sg13cmos5l_dfrbp_1_6.RESET_B a_12704_4782# 0
C7350 a_7994_7288# a_8247_5770# 0.00181f
C7351 a_7657_7282# a_8041_5770# 0
C7352 sg13cmos5l_buf_1_35.A sg13cmos5l_buf_1_33.A 0.05276f
C7353 ph_sw[0] sg13cmos5l_buf_1_62.X 0
C7354 a_10708_9172# sg13cmos5l_buf_1_90.X 0
C7355 a_620_7638# VPWR 0.25717f
C7356 a_7812_7687# cks 0
C7357 sg13cmos5l_dlhr_1_15.Q sg13cmos5l_buf_1_18.A 0
C7358 sg13cmos5l_dfrbp_1_0.D a_16552_1664# 0.00425f
C7359 a_6184_9224# ph_sw[3] 0
C7360 a_16293_4629# a_16462_4338# 0.00116f
C7361 a_17135_4727# a_16572_4261# 0.00911f
C7362 sg13cmos5l_dfrbp_1_15.D a_2306_7660# 0
C7363 sg13cmos5l_dfrbp_1_17.Q_N sg13cmos5l_dlhr_1_9.Q 0.00284f
C7364 a_15876_4968# a_16551_3987# 0
C7365 sg13cmos5l_dfrbp_1_8.Q_N sg13cmos5l_a22oi_1_1.A1 0.00156f
C7366 sg13cmos5l_dfrbp_1_0.CLK sg13cmos5l_dfrbp_1_1.Q_N 0
C7367 a_10022_7674# a_10308_7992# 0.50066f
C7368 a_15500_9150# ph_sw[8] 0
C7369 VPWR pl_sw[3] 0.40215f
C7370 nl_sw[0] nh_sw[0] 0.11424f
C7371 sg13cmos5l_inv_1_28.Y sg13cmos5l_a221oi_1_0.B2 0
C7372 sg13cmos5l_buf_1_41.A a_3588_4968# 0.00271f
C7373 a_2804_5412# a_2934_4632# 0
C7374 sg13cmos5l_dlhr_1_1.D a_1815_4666# 0.00751f
C7375 sg13cmos5l_buf_1_29.A a_9940_4636# 0.00117f
C7376 a_10868_8436# ph_sw[5] 0.00308f
C7377 sg13cmos5l_buf_1_8.X a_12625_2749# 0
C7378 a_2340_3456# a_3212_1590# 0
C7379 a_2757_3117# a_2732_1590# 0.00157f
C7380 sg13cmos5l_inv_1_18.A sg13cmos5l_buf_1_28.X 0.00489f
C7381 sg13cmos5l_dfrbp_1_6.RESET_B a_5324_1590# 0.00586f
C7382 a_9879_9202# VPWR 0.17779f
C7383 sg13cmos5l_dfrbp_1_6.RESET_B a_4518_7996# 0
C7384 sg13cmos5l_buf_1_103.A a_15147_8447# 0
C7385 sg13cmos5l_dfrbp_1_8.RESET_B a_14089_7282# 0
C7386 sg13cmos5l_buf_1_6.A a_13258_3361# 0
C7387 a_12520_3176# a_12998_3138# 0
C7388 sg13cmos5l_buf_1_45.A sg13cmos5l_dfrbp_1_2.D 0
C7389 sg13cmos5l_or2_1_0.A sg13cmos5l_o21ai_1_0.A2 0
C7390 sg13cmos5l_buf_1_57.X a_15850_4873# 0
C7391 sg13cmos5l_inv_1_3.A sg13cmos5l_dfrbp_1_23.CLK 0.42118f
C7392 sg13cmos5l_dlhr_1_0.GATE a_6598_4663# 0
C7393 a_18928_1846# nl_sw[9] 0.05575f
C7394 sg13cmos5l_buf_1_38.A a_5770_3868# 0
C7395 sg13cmos5l_dfrbp_1_0.CLK sg13cmos5l_buf_1_6.A 0.04143f
C7396 sg13cmos5l_dfrbp_1_0.CLK a_11530_1849# 0.00129f
C7397 a_15429_7653# a_15782_7362# 0
C7398 sg13cmos5l_dlhr_1_15.D a_11072_5347# 0.27898f
C7399 sg13cmos5l_dlhr_1_11.GATE ph_sw[6] 0
C7400 sg13cmos5l_buf_1_45.X sg13cmos5l_a22oi_1_1.B1 0
C7401 a_14426_7288# a_14889_7281# 0.13395f
C7402 a_14295_7282# a_14844_7326# 0
C7403 sg13cmos5l_dfrbp_1_23.Q a_14708_6924# 0
C7404 sg13cmos5l_a221oi_1_0.A2 a_8296_3986# 0.02055f
C7405 sg13cmos5l_a221oi_1_1.C1 a_10024_5498# 0.046f
C7406 sg13cmos5l_dfrbp_1_8.RESET_B a_13178_7684# 0
C7407 sg13cmos5l_dfrbp_1_6.RESET_B a_18345_7674# 0.46433f
C7408 sg13cmos5l_buf_1_30.X a_7644_1662# 0
C7409 sg13cmos5l_buf_1_65.X sg13cmos5l_inv_1_19.A 0.0609f
C7410 a_19028_5412# a_19209_5769# 0.40925f
C7411 sg13cmos5l_buf_1_34.X a_4322_6162# 0
C7412 sg13cmos5l_dfrbp_1_6.D a_7657_7282# 0.01233f
C7413 a_13284_3456# VPWR 0.08475f
C7414 a_1864_9224# pl_sw[2] 0
C7415 sg13cmos5l_dlhr_1_6.D a_11771_5412# 0
C7416 a_20392_3900# d_out[2] 0.30987f
C7417 a_17972_4948# VPWR 0.35316f
C7418 sg13cmos5l_nand2_1_1.B a_11460_2392# 0.00764f
C7419 sg13cmos5l_dlhr_1_5.Q a_10318_5412# 0
C7420 sg13cmos5l_dlhr_1_6.D a_9705_4650# 0
C7421 sg13cmos5l_buf_1_4.A cks 0.92621f
C7422 sg13cmos5l_dlhr_1_5.Q a_8905_4704# 0
C7423 sg13cmos5l_dfrbp_1_6.D a_18746_5776# 0.00224f
C7424 sg13cmos5l_and3_1_0.C a_15590_4650# 0
C7425 sg13cmos5l_inv_1_2.A a_10998_9168# 0.006f
C7426 sg13cmos5l_nor2b_1_0.Y a_13138_2826# 0
C7427 sg13cmos5l_inv_1_26.Y a_18999_6178# 0
C7428 a_1096_6294# a_422_5850# 0
C7429 nh_sw[1] sg13cmos5l_inv_1_19.A 0
C7430 sg13cmos5l_inv_1_5.A a_19616_3986# 0.03602f
C7431 sg13cmos5l_and3_1_0.C a_11973_3911# 0
C7432 sg13cmos5l_dfrbp_1_20.Q a_10318_5412# 0
C7433 sg13cmos5l_dfrbp_1_6.RESET_B a_15492_2392# 0
C7434 sg13cmos5l_buf_1_31.X a_4436_3436# 0.0092f
C7435 sg13cmos5l_nand2_1_0.B sg13cmos5l_buf_1_9.A 0.00983f
C7436 sg13cmos5l_dfrbp_1_6.RESET_B a_10416_6924# 0
C7437 sg13cmos5l_dfrbp_1_8.RESET_B sg13cmos5l_dlhr_1_1.Q 0.00337f
C7438 a_7508_1948# VPWR 0.10932f
C7439 sg13cmos5l_dfrbp_1_9.Q a_4753_4727# 0
C7440 sg13cmos5l_buf_1_73.A sg13cmos5l_dlhr_1_5.GATE 0
C7441 sg13cmos5l_dfrbp_1_10.Q sg13cmos5l_buf_1_25.A 0.33249f
C7442 sg13cmos5l_inv_1_2.A a_15429_7653# 0
C7443 sg13cmos5l_buf_1_25.A a_6736_2630# 0.00114f
C7444 sg13cmos5l_dfrbp_1_0.Q a_16011_2399# 0
C7445 a_1196_8400# a_1463_8741# 0.06787f
C7446 sg13cmos5l_dfrbp_1_6.D a_682_6892# 0.00383f
C7447 a_13324_4696# VPWR 0.72538f
C7448 sg13cmos5l_inv_1_29.A a_12490_6385# 0.00474f
C7449 sg13cmos5l_dlhr_1_6.D a_14032_6382# 0
C7450 sg13cmos5l_or2_1_0.A a_5770_3868# 0.00608f
C7451 sg13cmos5l_dfrbp_1_6.RESET_B a_16572_4261# 0.50016f
C7452 a_3976_9224# sg13cmos5l_dlhr_1_9.Q 0
C7453 sg13cmos5l_buf_1_34.X sg13cmos5l_dfrbp_1_16.Q_N 0
C7454 sg13cmos5l_dfrbp_1_23.CLK a_12516_6480# 0.07607f
C7455 sg13cmos5l_buf_1_5.A sg13cmos5l_buf_1_89.A 0
C7456 sg13cmos5l_dfrbp_1_0.Q a_16936_1758# 0.005f
C7457 sg13cmos5l_inv_1_11.Y nh_sw[4] 0
C7458 sg13cmos5l_dlhr_1_20.Q_N sg13cmos5l_dfrbp_1_10.Q 0.00126f
C7459 sg13cmos5l_dfrbp_1_8.RESET_B a_1997_6126# 0.20049f
C7460 sg13cmos5l_and3_1_0.X a_14377_5770# 0.01179f
C7461 a_15884_3102# a_15206_2826# 0
C7462 a_5673_3138# sg13cmos5l_buf_1_25.A 0.00158f
C7463 a_4456_1664# a_4840_1664# 0.00492f
C7464 sg13cmos5l_buf_1_9.A nl_sw[6] 0
C7465 sg13cmos5l_inv_1_6.A sg13cmos5l_or2_1_0.A 0.00319f
C7466 sg13cmos5l_buf_8_1.A a_17700_3456# 0
C7467 a_1956_4338# sg13cmos5l_inv_1_19.A 0
C7468 sg13cmos5l_dlhr_1_9.D a_10318_5412# 0.01089f
C7469 sg13cmos5l_inv_1_8.A a_7631_4727# 0
C7470 sg13cmos5l_buf_1_31.X sg13cmos5l_dfrbp_1_9.Q 0.27084f
C7471 a_7820_2352# nl_sw[4] 0
C7472 a_10587_4692# sg13cmos5l_nand2_1_0.B 0.33025f
C7473 sg13cmos5l_inv_1_0.Y sg13cmos5l_dlhr_1_20.Q_N 0
C7474 sg13cmos5l_nand2_1_1.A a_17931_1748# 0
C7475 sg13cmos5l_dfrbp_1_15.D a_2380_6162# 0
C7476 sg13cmos5l_dlhr_1_9.D a_8905_4704# 0.00477f
C7477 sg13cmos5l_dfrbp_1_8.D a_18356_6460# 0.06578f
C7478 a_18164_6924# sg13cmos5l_dfrbp_1_21.Q_N 0
C7479 sg13cmos5l_dlhr_1_11.Q a_13596_7710# 0.00176f
C7480 sg13cmos5l_dfrbp_1_23.CLK cks 0.02988f
C7481 sg13cmos5l_nand2_1_1.A a_17399_3947# 0
C7482 a_12976_2630# sg13cmos5l_nor2_1_1.A 0
C7483 a_13556_2388# sg13cmos5l_dfrbp_1_4.Q_N 0.25039f
C7484 sg13cmos5l_dfrbp_1_0.CLK a_16751_2749# 0.00999f
C7485 sg13cmos5l_inv_1_8.A a_2340_3456# 0
C7486 sg13cmos5l_buf_1_2.X a_15784_1664# 0.28818f
C7487 sg13cmos5l_buf_1_10.A a_12933_6141# 0.00156f
C7488 sg13cmos5l_dfrbp_1_6.D a_4640_3986# 0
C7489 sg13cmos5l_inv_1_28.Y a_10868_8436# 0
C7490 a_5132_9150# pl_sw[3] 0
C7491 a_6213_3911# a_6479_2749# 0.00204f
C7492 a_5408_3986# sg13cmos5l_dfrbp_1_10.Q 0
C7493 a_6372_4968# sg13cmos5l_buf_1_25.A 0
C7494 sg13cmos5l_a22oi_1_1.Y a_16268_3102# 0
C7495 a_15702_4187# a_15884_3102# 0
C7496 sg13cmos5l_o21ai_1_0.B1 a_14745_3453# 0
C7497 sg13cmos5l_dfrbp_1_8.RESET_B a_16548_6175# 0
C7498 sg13cmos5l_buf_1_111.A a_18486_8866# 0.00388f
C7499 sg13cmos5l_buf_1_65.X a_904_7806# 0
C7500 sg13cmos5l_a22oi_1_2.B2 sg13cmos5l_a22oi_1_1.B1 0.07612f
C7501 sg13cmos5l_nor2_1_0.A a_11973_3911# 0.01913f
C7502 sg13cmos5l_buf_1_45.X a_8982_7354# 0
C7503 a_10308_7992# a_11567_7751# 0.01741f
C7504 a_17135_4727# a_16703_3871# 0.00209f
C7505 sg13cmos5l_dfrbp_1_0.CLK a_17412_1944# 0.07518f
C7506 a_13775_6239# a_14152_5498# 0.00443f
C7507 sg13cmos5l_dlhr_1_15.D sg13cmos5l_dfrbp_1_2.D 0
C7508 sg13cmos5l_buf_1_33.A nh_sw[1] 0.04781f
C7509 pl_sw[1] sg13cmos5l_inv_1_19.A 0.00562f
C7510 sg13cmos5l_buf_1_94.X pl_sw[7] 0.00612f
C7511 sg13cmos5l_buf_1_19.A sg13cmos5l_dfrbp_1_0.RESET_B 0.01553f
C7512 sg13cmos5l_inv_1_14.A sg13cmos5l_buf_1_73.A 0.22312f
C7513 sg13cmos5l_dlhr_1_1.D a_1472_4782# 0.0345f
C7514 a_12232_8436# ph_sw[5] 0
C7515 a_2757_3117# nl_sw[2] 0
C7516 sg13cmos5l_inv_1_17.A a_1862_8874# 0
C7517 a_13652_3900# sg13cmos5l_a22oi_1_1.Y 0
C7518 sg13cmos5l_buf_1_45.X a_7812_7687# 0.01198f
C7519 sg13cmos5l_dfrbp_1_8.D ph_sw[9] 0.08333f
C7520 sg13cmos5l_inv_1_18.A sg13cmos5l_a22oi_1_2.B1 0
C7521 sg13cmos5l_inv_1_6.A a_19904_7806# 0.00108f
C7522 sg13cmos5l_dfrbp_1_6.RESET_B nh_sw[2] 0
C7523 sg13cmos5l_inv_1_2.A a_15016_9224# 0.00149f
C7524 sg13cmos5l_a221oi_1_0.A2 a_8392_3270# 0
C7525 a_14632_9224# pl_sw[7] 0
C7526 sg13cmos5l_dfrbp_1_6.D a_7394_5850# 0
C7527 a_17751_7690# a_18345_7674# 0.09085f
C7528 a_17545_7728# a_17882_7684# 0.64635f
C7529 sg13cmos5l_inv_1_8.A a_2934_4632# 0.02285f
C7530 a_18856_8436# a_18860_6888# 0
C7531 sg13cmos5l_inv_1_7.A sg13cmos5l_o21ai_1_0.B1 0.01391f
C7532 sg13cmos5l_a221oi_1_1.C1 a_11873_5760# 0
C7533 a_18577_1703# nl_sw[9] 0.00778f
C7534 sg13cmos5l_buf_1_18.A a_17588_2388# 0
C7535 sg13cmos5l_a221oi_1_0.C1 sg13cmos5l_a221oi_1_0.B2 0.33972f
C7536 a_8966_6600# VPWR 0.00418f
C7537 a_3664_8678# a_3574_7850# 0
C7538 a_16271_7751# a_16068_6928# 0.00133f
C7539 sg13cmos5l_dfrbp_1_0.CLK a_12815_1703# 0.0047f
C7540 a_20012_2352# sg13cmos5l_buf_1_0.X 0.32979f
C7541 sg13cmos5l_dfrbp_1_8.RESET_B pl_sw[0] 0
C7542 sg13cmos5l_buf_1_73.X a_7750_7687# 0
C7543 a_6789_4629# a_6213_3911# 0.01848f
C7544 sg13cmos5l_dfrbp_1_15.D sg13cmos5l_dlhr_1_5.GATE 0
C7545 sg13cmos5l_buf_1_78.X a_6380_7638# 0.32361f
C7546 sg13cmos5l_inv_1_18.A sg13cmos5l_buf_1_30.A 0
C7547 a_10202_7288# VPWR 0.35836f
C7548 sg13cmos5l_dfrbp_1_23.Q sg13cmos5l_buf_1_89.A 0.00986f
C7549 a_15208_6200# a_15016_6294# 0.01225f
C7550 a_12804_6175# a_12742_6175# 0
C7551 a_12075_3911# sg13cmos5l_o21ai_1_0.Y 0
C7552 sg13cmos5l_dfrbp_1_6.D a_10827_7796# 0
C7553 sg13cmos5l_buf_1_9.A a_11174_2826# 0.01869f
C7554 sg13cmos5l_buf_1_8.X sg13cmos5l_dfrbp_1_4.D 0.06133f
C7555 a_424_9318# a_616_9224# 0.01225f
C7556 sg13cmos5l_a221oi_1_0.A2 a_8050_4650# 0
C7557 a_8378_5776# sg13cmos5l_buf_1_46.A 0
C7558 sg13cmos5l_buf_1_18.A a_17829_1605# 0
C7559 a_15380_3436# VPWR 0.36246f
C7560 sg13cmos5l_buf_1_5.A sg13cmos5l_dfrbp_1_0.CLK 0.22727f
C7561 a_10888_1664# a_10331_1924# 0.0253f
C7562 sg13cmos5l_dfrbp_1_9.Q a_3212_1590# 0
C7563 sg13cmos5l_buf_1_78.A sg13cmos5l_dfrbp_1_6.D 0.00194f
C7564 a_9879_9202# sg13cmos5l_buf_1_97.A 0
C7565 a_10010_9196# a_10224_9508# 0.01249f
C7566 sg13cmos5l_and3_1_0.C a_12998_3138# 0
C7567 sg13cmos5l_nand2_1_1.B a_11979_2399# 0.00566f
C7568 a_11846_9186# a_12420_9199# 0.36169f
C7569 sg13cmos5l_buf_1_26.A a_9544_2474# 0
C7570 a_14986_7897# a_14889_7281# 0
C7571 sg13cmos5l_dlhr_1_1.GATE sg13cmos5l_inv_1_8.Y 0
C7572 sg13cmos5l_buf_1_34.X a_4311_7710# 0
C7573 sg13cmos5l_buf_1_41.A a_3575_6553# 0.00447f
C7574 a_18219_3260# d_out[1] 0
C7575 sg13cmos5l_dlhr_1_12.D a_17882_7684# 0
C7576 sg13cmos5l_dfrbp_1_6.RESET_B a_16011_2399# 0
C7577 sg13cmos5l_dfrbp_1_6.RESET_B a_12980_6924# 0.12898f
C7578 sg13cmos5l_buf_1_45.X a_6315_3911# 0
C7579 a_7440_1948# VPWR 0
C7580 a_8041_5770# a_8592_5412# 0
C7581 sg13cmos5l_buf_1_1.A nl_sw[8] 0.08551f
C7582 a_1662_8374# pl_sw[0] 0
C7583 sg13cmos5l_dfrbp_1_2.D sg13cmos5l_o21ai_1_0.A2 0
C7584 sg13cmos5l_nand2_1_0.B sg13cmos5l_dfrbp_1_1.D 0
C7585 sg13cmos5l_buf_1_25.A a_6898_2826# 0
C7586 a_17780_8436# ph_sw[9] 0
C7587 sg13cmos5l_inv_1_26.Y sg13cmos5l_buf_8_0.X 0
C7588 sg13cmos5l_buf_1_111.A sg13cmos5l_buf_1_18.A 0.11907f
C7589 a_12520_4782# VPWR 0.13314f
C7590 sg13cmos5l_buf_1_10.A a_12616_5498# 0.01773f
C7591 a_10484_6924# sg13cmos5l_or2_1_1.B 0
C7592 a_2732_9150# sg13cmos5l_inv_1_8.A 0.04959f
C7593 sg13cmos5l_buf_1_24.A a_7095_1642# 0
C7594 sg13cmos5l_buf_8_2.X sg13cmos5l_buf_1_104.X 0.34296f
C7595 sg13cmos5l_or2_1_0.A a_7312_4142# 0.00213f
C7596 sg13cmos5l_dfrbp_1_6.RESET_B a_16703_3871# 0.0537f
C7597 a_15206_2826# a_15492_2392# 0.50066f
C7598 sg13cmos5l_dlhr_1_6.D a_11072_5347# 0.00174f
C7599 a_16779_6284# a_17135_4727# 0.00455f
C7600 a_12814_4692# a_13324_4696# 0
C7601 sg13cmos5l_dfrbp_1_23.CLK a_14612_6460# 0.04669f
C7602 sg13cmos5l_dlhr_1_10.Q a_19526_6600# 0
C7603 sg13cmos5l_dfrbp_1_0.Q a_18671_1703# 0.00273f
C7604 sg13cmos5l_dfrbp_1_8.RESET_B a_2638_6477# 0.00343f
C7605 sg13cmos5l_dfrbp_1_6.RESET_B a_9033_6162# 0.47651f
C7606 a_18363_4270# sg13cmos5l_dfrbp_1_0.Q 0
C7607 sg13cmos5l_nand2_1_1.A a_19628_2352# 0
C7608 a_11268_2826# nh_sw[5] 0
C7609 a_7497_3138# a_7452_3174# 0
C7610 a_7316_3460# a_7249_3130# 0.0018f
C7611 sg13cmos5l_dlhr_1_2.D sg13cmos5l_buf_1_25.A 0.02204f
C7612 a_8022_3120# sg13cmos5l_dlhr_1_2.Q_N 0.12876f
C7613 sg13cmos5l_buf_1_5.X a_14476_2388# 0
C7614 sg13cmos5l_buf_1_25.X a_3008_1758# 0
C7615 a_15492_2392# a_16552_1664# 0
C7616 a_4840_1664# VPWR 0.25084f
C7617 sg13cmos5l_dfrbp_1_1.Q nl_sw[9] 0.08435f
C7618 a_8214_1608# nh_sw[4] 0
C7619 a_4282_8112# VPWR 0.00418f
C7620 sg13cmos5l_buf_1_77.A a_8785_6154# 0
C7621 a_15702_4187# a_15492_2392# 0
C7622 sg13cmos5l_dfrbp_1_8.RESET_B sg13cmos5l_dfrbp_1_0.RESET_B 0
C7623 sg13cmos5l_inv_1_8.A sg13cmos5l_dfrbp_1_11.Q_N 0
C7624 sg13cmos5l_buf_1_0.A a_17829_1605# 0.00594f
C7625 sg13cmos5l_dfrbp_1_1.D nl_sw[6] 0.01351f
C7626 sg13cmos5l_dfrbp_1_15.D a_4652_6126# 0.03519f
C7627 sg13cmos5l_buf_8_0.X sg13cmos5l_dlhr_1_10.Q 0
C7628 sg13cmos5l_buf_1_18.A a_20392_6924# 0
C7629 a_8570_6172# a_8784_6484# 0.01249f
C7630 sg13cmos5l_nor2_1_0.A a_12998_3138# 0.05421f
C7631 sg13cmos5l_dfrbp_1_18.Q a_9202_7674# 0
C7632 sg13cmos5l_dfrbp_1_6.RESET_B sg13cmos5l_buf_1_57.X 2.25407f
C7633 sg13cmos5l_inv_1_8.A a_4436_3436# 0.00232f
C7634 sg13cmos5l_dfrbp_1_0.CLK a_18760_2388# 0
C7635 a_16587_6935# a_17529_7047# 0
C7636 a_14254_2444# sg13cmos5l_nor2_1_1.A 0.10102f
C7637 a_8966_6600# sg13cmos5l_dfrbp_1_11.Q 0
C7638 sg13cmos5l_inv_1_18.A pl_sw[5] 0.00298f
C7639 a_14814_3876# a_14800_3358# 0
C7640 a_5796_3904# sg13cmos5l_dlhr_1_0.D 0
C7641 sg13cmos5l_dfrbp_1_6.D sg13cmos5l_dfrbp_1_23.Q_N 0.00468f
C7642 sg13cmos5l_dfrbp_1_0.Q a_14924_1590# 0.0063f
C7643 a_15821_3864# a_16204_4338# 0.35645f
C7644 sg13cmos5l_inv_1_2.A a_14458_4270# 0
C7645 sg13cmos5l_dfrbp_1_0.D a_17931_1748# 0.05513f
C7646 sg13cmos5l_buf_1_43.A a_416_3986# 0.00492f
C7647 sg13cmos5l_dfrbp_1_0.D a_17399_3947# 0.00703f
C7648 a_10725_7653# a_11473_7751# 0.01058f
C7649 a_17882_7684# VPWR 0.35779f
C7650 a_11567_7751# a_11824_7894# 0.35645f
C7651 sg13cmos5l_buf_1_57.X a_10412_6126# 0.00883f
C7652 sg13cmos5l_buf_1_116.A a_15177_5769# 0.30402f
C7653 sg13cmos5l_buf_1_19.X VPWR 0.25884f
C7654 sg13cmos5l_inv_1_8.A a_2565_8447# 0.35671f
C7655 a_18164_7996# sg13cmos5l_dfrbp_1_21.Q 0
C7656 sg13cmos5l_buf_1_57.X a_10071_7282# 0.06187f
C7657 sg13cmos5l_dfrbp_1_6.RESET_B sg13cmos5l_buf_1_28.A 0
C7658 sg13cmos5l_inv_1_0.A sg13cmos5l_a22oi_1_1.B2 0.04294f
C7659 sg13cmos5l_dlhr_1_5.D cks 0
C7660 a_1815_4666# sg13cmos5l_inv_1_19.A 0.02421f
C7661 sg13cmos5l_nand2_1_1.A sg13cmos5l_buf_1_1.A 0
C7662 sg13cmos5l_dlhr_1_9.D a_6789_4629# 0.00523f
C7663 sg13cmos5l_inv_1_17.A a_2667_8447# 0.00565f
C7664 a_3692_9150# a_3664_8678# 0.00625f
C7665 sg13cmos5l_buf_1_3.A sg13cmos5l_buf_8_1.A 0
C7666 a_13284_3456# a_14056_1664# 0
C7667 a_13701_3117# a_13652_1924# 0.00287f
C7668 a_3447_2746# sg13cmos5l_buf_1_33.A 0.00155f
C7669 sg13cmos5l_dfrbp_1_6.RESET_B a_1873_7285# 0
C7670 sg13cmos5l_inv_1_11.Y sg13cmos5l_buf_1_8.A 0
C7671 a_5452_5850# sg13cmos5l_dfrbp_1_29.Q_N 0.15881f
C7672 a_5069_5376# a_5546_5850# 0.00176f
C7673 sg13cmos5l_dfrbp_1_6.RESET_B a_2786_7666# 0.00196f
C7674 a_11464_9224# a_11360_9318# 0.00624f
C7675 sg13cmos5l_dfrbp_1_24.Q_N sg13cmos5l_buf_1_98.A 0
C7676 sg13cmos5l_dfrbp_1_18.Q sg13cmos5l_dfrbp_1_6.D 0
C7677 sg13cmos5l_inv_1_2.A a_7941_7653# 0
C7678 sg13cmos5l_inv_1_8.A sg13cmos5l_dfrbp_1_9.Q 0.06819f
C7679 a_18164_7996# sg13cmos5l_dlhr_1_15.Q 0.00107f
C7680 sg13cmos5l_buf_1_19.A a_18568_7010# 0
C7681 sg13cmos5l_buf_1_18.A a_19244_2352# 0.00407f
C7682 sg13cmos5l_buf_1_18.A d_out[2] 0
C7683 a_14342_8874# a_14916_8861# 0.36169f
C7684 sg13cmos5l_buf_1_2.A sg13cmos5l_dfrbp_1_6.Q_N 0.00336f
C7685 sg13cmos5l_dfrbp_1_15.D a_3574_7850# 0.00304f
C7686 sg13cmos5l_or2_1_0.A a_11460_2392# 0
C7687 a_14628_8440# a_15045_8447# 0.49014f
C7688 a_16177_7751# a_16485_6935# 0
C7689 sg13cmos5l_dlhr_1_15.D a_16068_6928# 0.03372f
C7690 a_15466_2356# VPWR 0.09924f
C7691 sg13cmos5l_a221oi_1_1.C1 a_10587_4692# 0.00107f
C7692 a_6891_4772# a_7055_4261# 0.01364f
C7693 sg13cmos5l_dlhr_1_18.Q_N VPWR 0.26082f
C7694 sg13cmos5l_inv_1_26.Y a_18376_9224# 0
C7695 sg13cmos5l_buf_1_95.X a_13810_9186# 0
C7696 sg13cmos5l_dfrbp_1_8.RESET_B a_15012_7992# 0.05165f
C7697 sg13cmos5l_dfrbp_1_8.RESET_B a_3876_4663# 0.00313f
C7698 sg13cmos5l_buf_1_41.A sg13cmos5l_buf_1_31.X 0.02654f
C7699 sg13cmos5l_buf_1_9.A a_11072_2474# 0
C7700 a_12804_6175# sg13cmos5l_inv_1_0.A 0
C7701 a_7336_9224# a_7524_7992# 0
C7702 sg13cmos5l_buf_1_90.X a_13161_7281# 0
C7703 sg13cmos5l_dfrbp_1_1.D a_11174_2826# 0
C7704 a_10427_2736# a_10464_2427# 0.00968f
C7705 a_11844_1639# VPWR 0.01035f
C7706 sg13cmos5l_inv_1_1.A sg13cmos5l_buf_1_57.X 0.021f
C7707 sg13cmos5l_dfrbp_1_6.RESET_B a_16779_6284# 0.57553f
C7708 sg13cmos5l_inv_1_27.Y sg13cmos5l_dlhr_1_6.D 0
C7709 a_12132_9504# sg13cmos5l_inv_1_29.A 0
C7710 a_16204_4338# VPWR 0.15025f
C7711 a_12933_6141# sg13cmos5l_nor2b_1_0.Y 0
C7712 a_1760_9318# sg13cmos5l_buf_1_68.X 0
C7713 sg13cmos5l_buf_1_64.A sg13cmos5l_buf_1_62.X 0.00162f
C7714 sg13cmos5l_and3_1_0.C a_14800_3358# 0
C7715 sg13cmos5l_buf_1_2.A sg13cmos5l_buf_1_6.A 0
C7716 sg13cmos5l_buf_1_77.A a_8772_8440# 0.04223f
C7717 a_12651_9308# sg13cmos5l_dfrbp_1_23.CLK 0
C7718 a_11973_3911# sg13cmos5l_o21ai_1_0.Y 0
C7719 a_15429_7653# a_14889_7281# 0.01428f
C7720 a_15012_7992# a_15414_7354# 0
C7721 sg13cmos5l_inv_1_3.A a_14436_8874# 0
C7722 sg13cmos5l_buf_1_95.X sg13cmos5l_dlhr_1_11.Q 0
C7723 a_4736_5498# VPWR 0.11857f
C7724 a_12490_6385# a_12804_6175# 0.00659f
C7725 a_8772_8440# a_8457_7281# 0
C7726 a_3962_7288# a_4177_7326# 0.00284f
C7727 a_3831_7282# a_4425_7281# 0.09085f
C7728 a_3625_7282# a_4244_6924# 0.00161f
C7729 sg13cmos5l_buf_1_41.A a_2804_5412# 0.00101f
C7730 sg13cmos5l_dfrbp_1_6.RESET_B sg13cmos5l_dfrbp_1_5.Q_N 0
C7731 a_422_5850# a_1967_5773# 0
C7732 frame cko 0.00144f
C7733 sg13cmos5l_dfrbp_1_18.Q a_10024_5498# 0
C7734 sg13cmos5l_dfrbp_1_8.RESET_B sg13cmos5l_dlhr_1_5.Q_N 0
C7735 sg13cmos5l_dfrbp_1_6.RESET_B a_14089_7282# 0
C7736 sg13cmos5l_buf_1_45.X a_8588_3864# 0.15059f
C7737 sg13cmos5l_a221oi_1_0.A2 sg13cmos5l_inv_1_0.A 0.39809f
C7738 a_10331_1924# VPWR 0.2853f
C7739 sg13cmos5l_buf_1_64.A sg13cmos5l_buf_1_44.X 0.06468f
C7740 a_12520_3176# VPWR 0.29219f
C7741 a_11530_3868# sg13cmos5l_dfrbp_1_1.Q 0
C7742 sg13cmos5l_o21ai_1_0.A1 a_12815_4261# 0
C7743 a_9189_8447# a_9620_7972# 0
C7744 sg13cmos5l_dfrbp_1_0.RESET_B a_11556_3904# 0.49128f
C7745 sg13cmos5l_dlhr_1_0.D sg13cmos5l_dlhr_1_0.Q 0.01065f
C7746 sg13cmos5l_or2_1_0.A a_8972_3864# 0.00974f
C7747 sg13cmos5l_inv_1_3.A sg13cmos5l_dfrbp_1_6.D 0.02497f
C7748 sg13cmos5l_a22oi_1_1.B1 a_10220_3102# 0
C7749 sg13cmos5l_dfrbp_1_6.RESET_B a_18363_4270# 0
C7750 a_15206_2826# a_16011_2399# 0.11742f
C7751 a_12814_4692# a_12520_4782# 0.00581f
C7752 sg13cmos5l_buf_1_0.A a_19244_2352# 0.00535f
C7753 sg13cmos5l_dfrbp_1_6.RESET_B a_13178_7684# 0.01077f
C7754 sg13cmos5l_dlhr_1_11.GATE a_13100_8400# 0
C7755 sg13cmos5l_dlhr_1_2.Q sg13cmos5l_dlhr_1_2.Q_N 0.01124f
C7756 sg13cmos5l_dfrbp_1_8.RESET_B a_2224_5654# 0
C7757 a_16011_2399# a_16552_1664# 0
C7758 sg13cmos5l_buf_1_25.X a_7508_1948# 0
C7759 sg13cmos5l_buf_1_78.A a_5702_8874# 0.02187f
C7760 sg13cmos5l_dfrbp_1_6.D nl_sw[1] 0.00255f
C7761 a_15821_3864# a_15780_2813# 0
C7762 sg13cmos5l_buf_1_0.A a_20012_1590# 0.32505f
C7763 a_9256_9224# ph_sw[5] 0
C7764 sg13cmos5l_buf_1_41.A a_3212_1590# 0.33677f
C7765 sg13cmos5l_dfrbp_1_6.D a_4934_2826# 0.28553f
C7766 sg13cmos5l_dlhr_1_1.GATE a_1227_6935# 0.02403f
C7767 sg13cmos5l_inv_1_1.A a_16779_6284# 0
C7768 sg13cmos5l_buf_1_101.X a_17108_7972# 0
C7769 a_11824_7894# a_11752_6294# 0
C7770 a_11567_7751# a_12490_6385# 0
C7771 a_9558_6144# sg13cmos5l_buf_1_29.A 0.00189f
C7772 a_10028_6126# sg13cmos5l_dlhr_1_6.Q_N 0.00126f
C7773 sg13cmos5l_nor2_1_0.A a_14800_3358# 0
C7774 sg13cmos5l_nor2b_1_0.Y a_11372_3102# 0.00599f
C7775 sg13cmos5l_buf_1_3.A cko 0
C7776 sg13cmos5l_dlhr_1_5.Q sg13cmos5l_inv_1_29.Y 0
C7777 sg13cmos5l_dfrbp_1_8.D a_18860_6888# 0.0023f
C7778 a_16552_1664# a_16936_1758# 0.03269f
C7779 a_12721_1703# a_13234_1626# 0
C7780 sg13cmos5l_a22oi_1_0.Y sg13cmos5l_dfrbp_1_10.Q 0.00298f
C7781 sg13cmos5l_inv_1_7.A nl_sw[6] 0
C7782 sg13cmos5l_dfrbp_1_12.Q_N sg13cmos5l_buf_1_25.A 0.00252f
C7783 a_7055_4261# sg13cmos5l_dlhr_1_0.D 0
C7784 a_16572_4261# a_16462_4338# 0.4858f
C7785 a_16204_4338# a_16551_3987# 0.06778f
C7786 a_8488_9224# sg13cmos5l_inv_1_2.A 0.28928f
C7787 a_6697_3192# a_7034_3148# 0.64635f
C7788 a_6903_3154# a_7497_3138# 0.09085f
C7789 sg13cmos5l_dfrbp_1_6.RESET_B sg13cmos5l_dlhr_1_1.Q 0.07505f
C7790 a_11824_7894# sg13cmos5l_dlhr_1_11.D 0.16137f
C7791 sg13cmos5l_dfrbp_1_20.Q sg13cmos5l_inv_1_29.Y 0.0166f
C7792 a_13701_3117# sg13cmos5l_buf_1_8.A 0.00142f
C7793 sg13cmos5l_a221oi_1_0.B2 sg13cmos5l_nand2_1_0.B 0
C7794 sg13cmos5l_a221oi_1_0.B1 sg13cmos5l_o21ai_1_0.A1 0.18922f
C7795 sg13cmos5l_dfrbp_1_8.RESET_B sg13cmos5l_dlhr_1_11.GATE 0.34407f
C7796 sg13cmos5l_inv_1_8.A a_3313_8797# 0.00111f
C7797 a_9202_7674# cks 0
C7798 sg13cmos5l_buf_1_18.A sg13cmos5l_dfrbp_1_21.Q_N 0
C7799 sg13cmos5l_dfrbp_1_6.D a_620_2352# 0
C7800 a_9242_4660# a_9638_5088# 0.00949f
C7801 a_9111_4666# sg13cmos5l_buf_1_46.A 0.00287f
C7802 sg13cmos5l_buf_1_0.A sg13cmos5l_a22oi_1_1.Y 0
C7803 sg13cmos5l_inv_1_2.A a_17337_4965# 0
C7804 sg13cmos5l_dlhr_1_9.D a_8468_4948# 0.0056f
C7805 sg13cmos5l_dfrbp_1_8.RESET_B a_4076_7624# 0
C7806 sg13cmos5l_inv_1_17.A sg13cmos5l_dfrbp_1_17.Q_N 0.0057f
C7807 sg13cmos5l_buf_1_103.A ph_sw[8] 0.05616f
C7808 a_6961_4261# sg13cmos5l_dlhr_1_2.D 0
C7809 sg13cmos5l_nor2_1_0.A a_10888_1664# 0
C7810 a_13701_3117# sg13cmos5l_buf_1_1.A 0
C7811 a_14543_3215# a_14924_1590# 0
C7812 sg13cmos5l_dlhr_1_1.GATE sg13cmos5l_buf_1_32.A 0
C7813 sg13cmos5l_nor2b_1_0.Y a_12616_5498# 0
C7814 a_11973_1605# a_11844_1639# 0.01562f
C7815 a_11556_1944# a_11782_1639# 0.00523f
C7816 a_12075_1748# a_13017_1941# 0
C7817 sg13cmos5l_buf_1_5.A a_10665_7281# 0
C7818 sg13cmos5l_dfrbp_1_6.D a_12516_6480# 0.00649f
C7819 sg13cmos5l_nor2_1_0.A a_11488_4676# 0
C7820 sg13cmos5l_nor2b_1_0.Y a_10230_4632# 0
C7821 a_17896_9224# a_17367_8794# 0
C7822 sg13cmos5l_dfrbp_1_6.RESET_B a_1997_6126# 0.06213f
C7823 sg13cmos5l_buf_1_73.A a_6959_6239# 0
C7824 sg13cmos5l_dfrbp_1_0.D sg13cmos5l_buf_1_1.A 0
C7825 sg13cmos5l_buf_1_78.A ph_sw[3] 0
C7826 sg13cmos5l_buf_1_45.X sg13cmos5l_dlhr_1_5.D 0
C7827 a_14342_8874# a_14985_8483# 0.00806f
C7828 sg13cmos5l_or2_1_0.A a_11979_2399# 0
C7829 a_15045_8447# a_15887_8797# 0.0032f
C7830 sg13cmos5l_inv_1_6.A a_19412_6484# 0
C7831 sg13cmos5l_dlhr_1_15.D a_17584_7166# 0.0139f
C7832 a_13775_6239# sg13cmos5l_a22oi_1_1.B2 0.0031f
C7833 a_15780_2813# VPWR 0.00819f
C7834 a_1125_5423# sg13cmos5l_dlygate4sd2_1_0.X 0.00202f
C7835 a_17545_7728# a_16677_6141# 0
C7836 sg13cmos5l_dfrbp_1_16.Q a_10484_6924# 0
C7837 sg13cmos5l_dlhr_1_9.D sg13cmos5l_inv_1_29.Y 0
C7838 a_2859_3260# sg13cmos5l_buf_1_33.A 0
C7839 sg13cmos5l_buf_1_94.X a_16144_8678# 0
C7840 sg13cmos5l_buf_1_44.A a_4873_3192# 0
C7841 sg13cmos5l_dfrbp_1_0.RESET_B sg13cmos5l_dfrbp_1_0.Q 0.14275f
C7842 sg13cmos5l_dfrbp_1_6.D cks 0.49525f
C7843 sg13cmos5l_o21ai_1_0.Y a_12998_3138# 0.28986f
C7844 sg13cmos5l_dfrbp_1_1.D a_11072_2474# 0
C7845 sg13cmos5l_nor2b_1_0.Y nh_sw[5] 0.08722f
C7846 a_1125_5423# a_1946_4660# 0
C7847 a_17386_1849# VPWR 0.09822f
C7848 sg13cmos5l_dfrbp_1_6.RESET_B a_16548_6175# 0.005f
C7849 a_14814_3876# VPWR 0.37743f
C7850 sg13cmos5l_inv_1_7.A a_11174_2826# 0
C7851 sg13cmos5l_and3_1_0.C a_15821_3864# 0.00295f
C7852 sg13cmos5l_dfrbp_1_21.Q a_17354_4180# 0
C7853 a_2148_8440# sg13cmos5l_buf_1_58.A 0
C7854 a_2667_8447# a_2831_7630# 0
C7855 a_8570_6172# VPWR 0.35863f
C7856 sg13cmos5l_inv_1_3.A a_15147_8447# 0.00133f
C7857 sg13cmos5l_dfrbp_1_1.Q a_12022_3134# 0.00934f
C7858 a_18368_4782# VPWR 0.07877f
C7859 a_14032_6382# a_13977_6477# 0.00464f
C7860 sg13cmos5l_a221oi_1_0.A2 a_10420_5412# 0
C7861 VPWR sg13cmos5l_buf_1_62.X 0.26571f
C7862 sg13cmos5l_dfrbp_1_0.RESET_B a_12896_3270# 0.00127f
C7863 sg13cmos5l_dfrbp_1_16.Q a_2169_5535# 0
C7864 sg13cmos5l_a221oi_1_0.A2 a_9242_4660# 0.00484f
C7865 a_12075_1748# VPWR 0.24281f
C7866 a_10282_7897# VPWR 0.09629f
C7867 a_17135_4727# sg13cmos5l_dfrbp_1_0.RESET_B 0
C7868 sg13cmos5l_dlhr_1_12.D a_16677_6141# 0
C7869 sg13cmos5l_buf_1_4.A a_16940_3102# 0
C7870 a_4324_7996# ph_sw[2] 0
C7871 a_13161_7281# sg13cmos5l_or2_1_1.B 0
C7872 sg13cmos5l_inv_1_8.A sg13cmos5l_buf_1_41.A 1.47449f
C7873 a_2667_3911# a_3664_4142# 0.07046f
C7874 sg13cmos5l_buf_1_43.A comp_p 0.00349f
C7875 a_15718_2813# a_15780_2813# 0
C7876 a_15492_2392# a_16657_2749# 0.4858f
C7877 sg13cmos5l_buf_1_44.X VPWR 0.95743f
C7878 sg13cmos5l_dfrbp_1_6.RESET_B pl_sw[0] 0.00135f
C7879 a_12567_7282# a_13161_7281# 0.09085f
C7880 a_12361_7282# a_12980_6924# 0.00161f
C7881 a_12698_7288# a_12913_7326# 0.00284f
C7882 sg13cmos5l_o21ai_1_0.A1 a_11782_4325# 0
C7883 sg13cmos5l_dfrbp_1_6.RESET_B sg13cmos5l_dlhr_1_14.Q_N 0.01069f
C7884 sg13cmos5l_dfrbp_1_8.RESET_B a_5700_6480# 0.02042f
C7885 a_17674_3361# a_17988_3151# 0.00659f
C7886 sg13cmos5l_dfrbp_1_6.RESET_B a_2364_4686# 0
C7887 a_6741_5459# a_6891_4772# 0
C7888 a_6647_5459# a_6789_4629# 0
C7889 a_9260_2352# VPWR 0.29433f
C7890 a_10473_9186# ph_sw[5] 0.00975f
C7891 sg13cmos5l_dfrbp_1_8.RESET_B sg13cmos5l_dlhr_1_1.D 0
C7892 sg13cmos5l_buf_1_31.X nl_sw[5] 0
C7893 sg13cmos5l_buf_1_25.X a_7440_1948# 0
C7894 sg13cmos5l_inv_1_17.A a_3976_9224# 0.00586f
C7895 sg13cmos5l_buf_1_78.A a_6214_8861# 0
C7896 sg13cmos5l_dfrbp_1_10.Q sg13cmos5l_buf_1_26.A 0.01535f
C7897 sg13cmos5l_buf_1_0.A a_19090_1626# 0
C7898 sg13cmos5l_dfrbp_1_6.D a_5446_2813# 0
C7899 a_1196_8400# sg13cmos5l_buf_1_63.A 0.32822f
C7900 sg13cmos5l_buf_1_111.A a_18164_7996# 0
C7901 a_2804_6924# VPWR 0.35781f
C7902 sg13cmos5l_dlhr_1_1.GATE sg13cmos5l_dfrbp_1_16.Q 0.35648f
C7903 sg13cmos5l_dlhr_1_11.D a_12490_6385# 0.00109f
C7904 sg13cmos5l_and3_1_0.C VPWR 0.54576f
C7905 a_2583_7710# VPWR 0
C7906 sg13cmos5l_dfrbp_1_8.RESET_B a_7524_7992# 0.00612f
C7907 sg13cmos5l_dfrbp_1_15.D a_4358_6924# 0.00158f
C7908 sg13cmos5l_inv_1_18.A a_10010_9196# 0
C7909 a_2436_8861# sg13cmos5l_inv_1_19.A 0
C7910 sg13cmos5l_buf_1_64.A sg13cmos5l_dlhr_1_9.Q 0.00206f
C7911 sg13cmos5l_a22oi_1_1.A1 a_18865_3215# 0
C7912 sg13cmos5l_dfrbp_1_6.D a_9524_4972# 0
C7913 a_17414_3138# sg13cmos5l_nor2_1_1.A 0
C7914 sg13cmos5l_dlhr_1_15.D a_13072_4142# 0
C7915 sg13cmos5l_buf_1_46.A sg13cmos5l_dfrbp_1_10.Q 0
C7916 a_16572_4261# a_17399_3947# 0.50066f
C7917 a_16462_4338# a_16703_3871# 0.01058f
C7918 a_16204_4338# a_16462_4023# 0.00464f
C7919 a_5637_2399# nh_sw[3] 0
C7920 sg13cmos5l_inv_1_14.A pl_sw[3] 0.01531f
C7921 sg13cmos5l_dfrbp_1_15.D a_4514_7666# 0
C7922 a_6697_3192# a_6560_3270# 0.00973f
C7923 sg13cmos5l_buf_1_39.A a_5704_1664# 0
C7924 sg13cmos5l_buf_1_25.X a_4840_1664# 0.00932f
C7925 sg13cmos5l_buf_1_19.A a_18480_5028# 0.03499f
C7926 sg13cmos5l_dfrbp_1_6.D a_5079_3154# 0.05165f
C7927 sg13cmos5l_a22oi_1_2.B2 sg13cmos5l_buf_1_8.X 0
C7928 a_10534_7687# cks 0
C7929 sg13cmos5l_dlhr_1_13.Q_N a_15177_5769# 0
C7930 sg13cmos5l_inv_1_17.A nh_sw[0] 0
C7931 sg13cmos5l_inv_1_0.Y sg13cmos5l_buf_1_46.A 0
C7932 a_8972_3864# sg13cmos5l_dfrbp_1_2.D 0
C7933 a_16677_6141# VPWR 0.31688f
C7934 sg13cmos5l_buf_1_45.X a_8041_5770# 0.02391f
C7935 sg13cmos5l_inv_1_7.A sg13cmos5l_a221oi_1_1.C1 0
C7936 a_8233_6216# a_8570_6172# 0.64635f
C7937 a_8439_6178# a_9033_6162# 0.09085f
C7938 a_4934_2826# a_5194_2356# 0.87117f
C7939 sg13cmos5l_buf_1_5.A a_12216_5728# 0
C7940 sg13cmos5l_inv_1_2.A a_12358_9199# 0
C7941 VPWR nl_sw[0] 0.18643f
C7942 a_12815_1703# sg13cmos5l_dfrbp_1_1.Q_N 0.04107f
C7943 a_13072_1846# a_12721_1703# 0.01017f
C7944 a_8570_6172# sg13cmos5l_dfrbp_1_11.Q 0
C7945 sg13cmos5l_buf_1_30.A a_5510_4338# 0
C7946 sg13cmos5l_buf_1_7.A a_13572_3151# 0.00246f
C7947 sg13cmos5l_a22oi_1_1.Y sg13cmos5l_buf_1_5.X 0
C7948 a_15147_8447# cks 0.02187f
C7949 sg13cmos5l_dfrbp_1_6.D a_14612_6460# 0.00513f
C7950 sg13cmos5l_inv_1_26.Y a_17916_8838# 0
C7951 a_8378_5776# sg13cmos5l_or2_1_0.A 0
C7952 sg13cmos5l_dfrbp_1_6.RESET_B a_2638_6477# 0.00219f
C7953 sg13cmos5l_inv_1_3.A a_13035_6284# 0.0062f
C7954 a_15887_8797# a_16724_8436# 0.1333f
C7955 a_16144_8678# a_15793_8797# 0.01017f
C7956 sg13cmos5l_buf_1_57.X a_8439_6178# 0
C7957 sg13cmos5l_dlhr_1_15.D sg13cmos5l_dfrbp_1_8.D 1.24726f
C7958 a_13681_6239# sg13cmos5l_and3_1_0.X 0
C7959 a_15849_2435# VPWR 0
C7960 a_14295_7282# VPWR 0.18301f
C7961 sg13cmos5l_dfrbp_1_6.RESET_B sg13cmos5l_dfrbp_1_0.RESET_B 0.03904f
C7962 a_18164_7996# a_17519_6239# 0
C7963 sg13cmos5l_dfrbp_1_6.D a_18219_3260# 0
C7964 sg13cmos5l_dfrbp_1_6.D a_2565_3911# 0
C7965 a_4950_7354# cks 0.00342f
C7966 a_16485_6935# sg13cmos5l_buf_1_4.A 0
C7967 a_14426_7288# sg13cmos5l_dfrbp_1_21.Q 0
C7968 sg13cmos5l_dfrbp_1_8.RESET_B a_1088_7806# 0
C7969 sg13cmos5l_inv_1_0.A a_8905_4704# 0
C7970 sg13cmos5l_buf_1_73.A a_7750_7687# 0
C7971 sg13cmos5l_buf_1_94.X sg13cmos5l_dfrbp_1_22.D 0
C7972 sg13cmos5l_nor2_1_0.A VPWR 2.10437f
C7973 sg13cmos5l_buf_1_6.A a_12815_1703# 0
C7974 a_11270_1626# a_11364_1626# 0.00718f
C7975 a_11973_1605# a_12075_1748# 0.66105f
C7976 sg13cmos5l_inv_1_18.A sg13cmos5l_buf_1_30.X 0.01522f
C7977 a_17220_1626# VPWR 0
C7978 a_4640_3986# a_4041_2745# 0
C7979 sg13cmos5l_buf_1_104.X a_19904_7806# 0
C7980 sg13cmos5l_buf_1_44.X sg13cmos5l_dfrbp_1_11.Q 0
C7981 a_18146_4338# VPWR 0
C7982 a_5132_9150# sg13cmos5l_buf_1_62.X 0
C7983 sg13cmos5l_inv_1_27.Y pl_sw[7] 0
C7984 sg13cmos5l_buf_1_2.A a_15784_1664# 0.32771f
C7985 a_16271_7751# a_16690_7674# 0.00176f
C7986 sg13cmos5l_a221oi_1_1.C1 sg13cmos5l_a221oi_1_0.B2 0
C7987 sg13cmos5l_dfrbp_1_15.D a_2621_7636# 0.26419f
C7988 a_12841_7728# VPWR 0.41036f
C7989 sg13cmos5l_and3_1_0.C a_16551_3987# 0
C7990 a_15300_7687# sg13cmos5l_buf_1_89.A 0
C7991 a_20012_2352# sg13cmos5l_buf_1_19.X 0.03833f
C7992 sg13cmos5l_buf_1_3.A a_19028_5412# 0
C7993 sg13cmos5l_buf_1_5.A sg13cmos5l_buf_1_6.A 0.04466f
C7994 sg13cmos5l_inv_1_3.A sg13cmos5l_dfrbp_1_25.Q_N 0
C7995 sg13cmos5l_buf_1_45.X sg13cmos5l_dfrbp_1_6.D 0.02959f
C7996 sg13cmos5l_dfrbp_1_1.Q a_13092_3138# 0
C7997 sg13cmos5l_dfrbp_1_0.RESET_B a_14543_3215# 0.23117f
C7998 a_17882_7684# ph_sw[9] 0.002f
C7999 a_4660_7312# sg13cmos5l_buf_1_59.A 0
C8000 sg13cmos5l_buf_1_9.A sg13cmos5l_dfrbp_1_4.D 0.0022f
C8001 a_424_9318# sg13cmos5l_buf_1_68.X 0.05895f
C8002 a_708_5416# sg13cmos5l_or2_1_0.A 0
C8003 a_1096_6294# sg13cmos5l_inv_1_8.Y 0
C8004 sg13cmos5l_inv_1_14.A a_7508_1948# 0
C8005 a_11360_9318# ph_sw[5] 0.00181f
C8006 sg13cmos5l_buf_1_24.A a_5710_5850# 0
C8007 a_5132_9150# sg13cmos5l_buf_1_44.X 0.3388f
C8008 a_14440_1664# VPWR 0.25132f
C8009 a_12132_9504# a_11567_7751# 0.00199f
C8010 a_11846_9186# a_11824_7894# 0
C8011 a_14440_1664# nl_sw[7] 0
C8012 a_10473_9186# sg13cmos5l_inv_1_28.Y 0
C8013 sg13cmos5l_buf_1_74.X sg13cmos5l_buf_1_30.A 0
C8014 a_3664_4142# sg13cmos5l_dfrbp_1_9.Q_N 0.15881f
C8015 sg13cmos5l_dlhr_1_1.GATE sg13cmos5l_inv_1_9.Y 0
C8016 a_16011_2399# a_16657_2749# 0.00667f
C8017 sg13cmos5l_nor2b_1_1.Y nl_sw[8] 0
C8018 sg13cmos5l_a22oi_1_1.B1 a_12815_4261# 0.01659f
C8019 a_12230_6162# a_12873_6553# 0.00806f
C8020 a_12516_6480# a_13035_6284# 0.38902f
C8021 a_13161_7281# a_13116_7326# 0
C8022 a_5702_8874# cks 0.0147f
C8023 sg13cmos5l_dfrbp_1_6.RESET_B a_15012_7992# 0.5114f
C8024 sg13cmos5l_dfrbp_1_8.RESET_B a_7796_6460# 0
C8025 a_18117_3117# a_18865_3215# 0.01058f
C8026 sg13cmos5l_a221oi_1_0.A2 a_6891_4772# 0.00297f
C8027 sg13cmos5l_or2_1_0.A a_6903_3154# 0.00137f
C8028 a_16657_2749# a_16936_1758# 0
C8029 a_16751_2749# a_17412_1944# 0
C8030 a_12698_7288# sg13cmos5l_nor2_1_0.A 0
C8031 sg13cmos5l_buf_8_0.X a_20672_5498# 0.00129f
C8032 a_1862_4338# a_3407_4261# 0
C8033 a_2148_3904# a_2436_4325# 0.4806f
C8034 a_2122_3868# a_2667_3911# 0.00999f
C8035 a_16703_3871# a_16657_2749# 0
C8036 sg13cmos5l_buf_1_41.X sg13cmos5l_inv_1_19.A 0
C8037 sg13cmos5l_dfrbp_1_6.RESET_B a_8841_5769# 0.49847f
C8038 sg13cmos5l_buf_1_57.X a_15974_6162# 0.29371f
C8039 a_18999_6178# a_18746_5776# 0.00223f
C8040 a_18793_6216# a_18409_5770# 0
C8041 a_19130_6172# a_18615_5770# 0
C8042 sg13cmos5l_buf_1_104.A a_20492_8400# 0.00342f
C8043 sg13cmos5l_dfrbp_1_8.RESET_B a_8783_7751# 0.02922f
C8044 a_1878_6337# VPWR 0.36057f
C8045 a_12841_7728# a_12698_7288# 0
C8046 sg13cmos5l_dlhr_1_1.GATE sg13cmos5l_dfrbp_1_15.Q_N 0.00549f
C8047 a_2224_7166# a_1873_7285# 0.01017f
C8048 a_1967_7285# a_2804_6924# 0.1333f
C8049 a_17386_1849# a_17769_2017# 0.00337f
C8050 a_17126_1626# a_17829_1605# 0.02453f
C8051 a_2505_8483# sg13cmos5l_inv_1_19.A 0
C8052 sg13cmos5l_dfrbp_1_6.D a_422_7362# 0.30286f
C8053 a_10665_7281# ph_sw[5] 0
C8054 a_17354_4180# a_17493_3947# 0.00659f
C8055 a_16703_3871# a_17399_3947# 0.02453f
C8056 sg13cmos5l_buf_1_28.A nh_sw[4] 0.40335f
C8057 sg13cmos5l_nand2_1_1.B sg13cmos5l_dfrbp_1_10.Q 0.49126f
C8058 a_7153_8797# a_7498_7897# 0
C8059 sg13cmos5l_dfrbp_1_6.RESET_B sg13cmos5l_dlhr_1_5.Q_N 0.03728f
C8060 a_8022_3120# sg13cmos5l_dlhr_1_2.Q 0.59939f
C8061 sg13cmos5l_dlhr_1_2.D sg13cmos5l_buf_1_26.A 0
C8062 sg13cmos5l_buf_1_8.A a_11782_1639# 0
C8063 a_15492_2392# sg13cmos5l_buf_1_1.A 0
C8064 a_15909_2399# a_16268_1590# 0.00401f
C8065 sg13cmos5l_buf_1_39.A a_5600_1758# 0
C8066 sg13cmos5l_dfrbp_1_6.D a_5606_3576# 0
C8067 sg13cmos5l_dlhr_1_9.Q VPWR 0.46863f
C8068 sg13cmos5l_inv_1_18.A sg13cmos5l_dlhr_1_6.Q_N 0.19733f
C8069 sg13cmos5l_a22oi_1_1.Y a_15909_2399# 0
C8070 a_7034_3148# a_6479_2749# 0.0073f
C8071 sg13cmos5l_dfrbp_1_10.Q a_7497_3138# 0.01473f
C8072 sg13cmos5l_dlhr_1_15.D a_15876_4968# 0.00488f
C8073 sg13cmos5l_dfrbp_1_6.D a_3793_2790# 0
C8074 sg13cmos5l_a22oi_1_2.B2 a_10094_2780# 0.00142f
C8075 sg13cmos5l_inv_1_18.A a_10484_6924# 0
C8076 a_17721_6477# VPWR 0
C8077 a_4934_2826# a_5739_2399# 0.11742f
C8078 a_9033_6162# sg13cmos5l_buf_1_56.A 0.28824f
C8079 a_4172_1590# nh_sw[2] 0.00164f
C8080 sg13cmos5l_inv_1_0.Y sg13cmos5l_nand2_1_1.B 0
C8081 sg13cmos5l_or2_1_0.A a_2436_4325# 0
C8082 sg13cmos5l_nor2_1_0.A a_11973_1605# 0
C8083 sg13cmos5l_buf_1_19.A a_19142_5412# 0.00156f
C8084 a_16486_6175# sg13cmos5l_dfrbp_1_21.Q 0
C8085 sg13cmos5l_buf_1_30.A a_6084_4325# 0
C8086 a_14924_1590# a_15200_1758# 0.00624f
C8087 sg13cmos5l_dfrbp_1_25.Q_N cks 0.0238f
C8088 ph_sw[3] cks 0
C8089 pl_sw[4] pl_sw[5] 0.07252f
C8090 sg13cmos5l_buf_1_77.A pl_sw[5] 0
C8091 a_8468_4948# a_8392_3270# 0
C8092 sg13cmos5l_a221oi_1_0.B1 sg13cmos5l_a22oi_1_1.B1 0
C8093 sg13cmos5l_buf_1_5.A a_13686_7354# 0.00425f
C8094 sg13cmos5l_a22oi_1_1.A1 a_17224_3270# 0
C8095 sg13cmos5l_dfrbp_1_6.D a_5266_4650# 0
C8096 a_9448_6924# a_9344_7010# 0.00624f
C8097 sg13cmos5l_buf_1_65.X a_5988_8440# 0
C8098 sg13cmos5l_nand2_1_1.A sg13cmos5l_nor2b_1_1.Y 0
C8099 sg13cmos5l_nor2_1_2.A sg13cmos5l_inv_1_19.A 0
C8100 sg13cmos5l_dfrbp_1_6.RESET_B a_2474_6162# 0
C8101 sg13cmos5l_dlhr_1_0.GATE a_6681_2511# 0
C8102 sg13cmos5l_inv_1_2.A sg13cmos5l_buf_1_7.A 0
C8103 a_10318_5412# a_10420_5412# 0.22838f
C8104 a_18860_9150# sg13cmos5l_buf_1_104.A 0
C8105 a_19227_9190# a_19136_9318# 0.00571f
C8106 a_15793_8797# sg13cmos5l_dfrbp_1_22.D 0
C8107 a_15784_9224# a_15429_7653# 0
C8108 sg13cmos5l_inv_1_1.A a_15012_7992# 0.02742f
C8109 a_5079_3154# a_5425_3130# 0.00722f
C8110 sg13cmos5l_dfrbp_1_6.RESET_B a_2224_5654# 0.21141f
C8111 a_6198_3120# a_6697_3192# 0.00349f
C8112 sg13cmos5l_buf_1_57.X sg13cmos5l_buf_1_56.A 0.17828f
C8113 sg13cmos5l_buf_1_18.X VPWR 0.27364f
C8114 sg13cmos5l_dfrbp_1_6.D a_2314_3361# 0.00989f
C8115 sg13cmos5l_dfrbp_1_12.Q_N sg13cmos5l_a22oi_1_0.Y 0
C8116 sg13cmos5l_buf_1_78.X a_6117_6141# 0
C8117 a_5079_3154# a_5194_2356# 0
C8118 a_5210_3148# a_4934_2826# 0
C8119 a_16164_4663# sg13cmos5l_buf_1_2.X 0
C8120 a_18164_7996# sg13cmos5l_dfrbp_1_21.Q_N 0
C8121 a_14708_6924# a_14714_5776# 0.00129f
C8122 a_14889_7281# a_14377_5770# 0.00171f
C8123 sg13cmos5l_buf_1_74.X pl_sw[5] 0.02979f
C8124 a_9111_4666# a_9705_4650# 0.09085f
C8125 a_8905_4704# a_9242_4660# 0.64635f
C8126 sg13cmos5l_buf_1_95.X pl_sw[6] 0.02583f
C8127 sg13cmos5l_buf_1_37.A a_2248_1664# 0.00207f
C8128 sg13cmos5l_buf_1_41.X sg13cmos5l_buf_1_33.A 0.01283f
C8129 sg13cmos5l_o21ai_1_0.Y a_13017_1941# 0
C8130 sg13cmos5l_dfrbp_1_8.RESET_B a_6213_3911# 0.09437f
C8131 a_17700_1639# VPWR 0.00699f
C8132 a_15974_6162# a_16779_6284# 0.11742f
C8133 a_16260_6480# a_16677_6141# 0.48921f
C8134 a_16234_6385# a_16617_6553# 0.00337f
C8135 a_6372_4968# a_7497_3138# 0
C8136 a_6789_4629# a_7034_3148# 0
C8137 sg13cmos5l_buf_1_103.A a_16160_9318# 0.0146f
C8138 a_17516_9150# a_17792_9318# 0.00624f
C8139 sg13cmos5l_o21ai_1_0.B1 a_13258_3361# 0.01389f
C8140 a_708_5416# sg13cmos5l_dlygate4sd2_1_0.X 0
C8141 sg13cmos5l_inv_1_28.Y a_11360_9318# 0.0595f
C8142 a_10998_9168# sg13cmos5l_buf_1_90.X 0
C8143 sg13cmos5l_nor2_1_0.A a_12814_4692# 0.37131f
C8144 a_15016_9224# pl_sw[8] 0
C8145 a_5962_8404# a_5988_8440# 0.43042f
C8146 sg13cmos5l_dfrbp_1_0.RESET_B a_15206_2826# 0.09294f
C8147 sg13cmos5l_inv_1_6.A sg13cmos5l_dfrbp_1_8.D 0.00163f
C8148 sg13cmos5l_dfrbp_1_6.RESET_B a_18568_7010# 0.02359f
C8149 sg13cmos5l_inv_1_7.A a_12625_2749# 0.00754f
C8150 a_11986_7674# VPWR 0
C8151 sg13cmos5l_or2_1_1.B sg13cmos5l_nand2_1_0.A 0
C8152 a_2161_4642# VPWR 0
C8153 sg13cmos5l_dfrbp_1_6.RESET_B sg13cmos5l_dlhr_1_11.GATE 0.32025f
C8154 a_12516_6480# a_12800_5498# 0.003f
C8155 sg13cmos5l_dfrbp_1_0.CLK sg13cmos5l_o21ai_1_0.B1 2.31555f
C8156 sg13cmos5l_nand2_1_0.A a_14476_2388# 0.00173f
C8157 sg13cmos5l_inv_1_7.A a_10827_7796# 0
C8158 sg13cmos5l_dfrbp_1_16.Q a_8852_6484# 0
C8159 a_12230_6162# sg13cmos5l_inv_1_0.Y 0
C8160 sg13cmos5l_buf_1_103.A a_18376_9224# 0
C8161 sg13cmos5l_dfrbp_1_6.D a_2409_4650# 0.00519f
C8162 sg13cmos5l_dfrbp_1_0.RESET_B a_16552_1664# 0
C8163 sg13cmos5l_dfrbp_1_6.RESET_B a_2248_1664# 0.00245f
C8164 sg13cmos5l_dfrbp_1_6.RESET_B a_4076_7624# 0.12402f
C8165 sg13cmos5l_buf_1_93.X a_14628_8440# 0.00719f
C8166 sg13cmos5l_buf_1_24.A ph_sw[4] 0
C8167 sg13cmos5l_dfrbp_1_0.RESET_B a_15702_4187# 0.00286f
C8168 a_4640_3986# a_4436_3436# 0
C8169 sg13cmos5l_dfrbp_1_1.D sg13cmos5l_dfrbp_1_4.D 0
C8170 sg13cmos5l_a22oi_1_2.B2 a_10024_5498# 0.01166f
C8171 a_12132_9504# sg13cmos5l_dlhr_1_11.D 0
C8172 a_4460_9150# ph_sw[1] 0
C8173 sg13cmos5l_buf_1_10.A sg13cmos5l_dlhr_1_11.Q 0
C8174 a_3664_4142# a_3447_2746# 0
C8175 a_20672_6294# a_20672_5498# 0.00313f
C8176 a_1463_8741# a_1480_7806# 0.00612f
C8177 a_16264_9224# sg13cmos5l_buf_1_94.X 0.00774f
C8178 a_16748_9150# a_17132_9150# 0.00492f
C8179 a_17588_2388# a_18376_2388# 0
C8180 sg13cmos5l_inv_1_27.Y a_14602_8404# 0.02461f
C8181 a_13391_9263# a_14152_8522# 0.01016f
C8182 sg13cmos5l_a22oi_1_1.B1 sg13cmos5l_nand2_1_1.A 0.01844f
C8183 a_13686_7354# sg13cmos5l_dfrbp_1_23.Q 0.02243f
C8184 sg13cmos5l_dfrbp_1_8.D sg13cmos5l_dfrbp_1_8.Q_N 0
C8185 a_12998_3138# nh_sw[6] 0
C8186 a_11848_8436# sg13cmos5l_buf_1_10.A 0.31273f
C8187 sg13cmos5l_dfrbp_1_6.RESET_B a_17108_7972# 0
C8188 a_19216_3358# a_19378_3138# 0.0019f
C8189 a_19796_3436# sg13cmos5l_dfrbp_1_3.Q_N 0.25039f
C8190 sg13cmos5l_a221oi_1_0.A2 a_7833_4965# 0.00135f
C8191 a_20008_3900# d_out[1] 0.28823f
C8192 a_18356_6460# a_18368_4782# 0
C8193 a_13486_5412# a_12815_4261# 0
C8194 sg13cmos5l_dfrbp_1_8.RESET_B sg13cmos5l_dlhr_1_5.Q 0
C8195 sg13cmos5l_o21ai_1_0.Y VPWR 0.4722f
C8196 a_18376_2388# a_17829_1605# 0.00457f
C8197 sg13cmos5l_buf_1_65.X a_5416_9224# 0.0093f
C8198 sg13cmos5l_dfrbp_1_8.RESET_B sg13cmos5l_inv_1_19.A 1.13707f
C8199 a_1862_4338# sg13cmos5l_buf_1_38.A 0
C8200 a_13391_9263# sg13cmos5l_buf_1_94.X 0
C8201 sg13cmos5l_dfrbp_1_8.RESET_B a_12420_9199# 0.00152f
C8202 sg13cmos5l_nand2_1_0.A a_11270_1626# 0.00115f
C8203 sg13cmos5l_dfrbp_1_8.D a_20204_5376# 0
C8204 sg13cmos5l_buf_1_34.X sg13cmos5l_dfrbp_1_6.D 0.5257f
C8205 sg13cmos5l_dfrbp_1_9.Q a_4640_3986# 0.01222f
C8206 a_20492_8400# pl_sw[10] 0.28827f
C8207 a_19130_6172# a_19209_5769# 0
C8208 sg13cmos5l_dfrbp_1_8.RESET_B sg13cmos5l_dfrbp_1_20.Q 0
C8209 sg13cmos5l_dlhr_1_1.GATE a_3669_6320# 0.00271f
C8210 a_13460_7996# a_13686_7354# 0.00718f
C8211 a_2727_6380# VPWR 0.20928f
C8212 a_17829_1605# a_18928_1846# 0
C8213 a_17931_1748# a_18671_1703# 0.3087f
C8214 a_9111_4666# sg13cmos5l_or2_1_0.A 0
C8215 a_2224_7166# a_1997_6126# 0.00529f
C8216 sg13cmos5l_buf_1_25.A a_6572_1590# 0.06069f
C8217 sg13cmos5l_nand2_1_0.B a_11364_4338# 0
C8218 a_1862_4338# a_2148_3904# 0.50066f
C8219 a_17674_3361# a_18057_3529# 0.00337f
C8220 a_17414_3138# a_17700_3456# 0.50066f
C8221 sg13cmos5l_dlhr_1_5.GATE a_4736_5498# 0.01132f
C8222 a_17399_3947# a_18363_4270# 0.04744f
C8223 a_11054_4292# VPWR 0
C8224 a_16011_2399# sg13cmos5l_buf_1_1.A 0
C8225 sg13cmos5l_buf_1_73.X a_5796_8874# 0
C8226 a_6560_3270# a_6479_2749# 0
C8227 sg13cmos5l_a22oi_1_1.Y a_17008_2630# 0
C8228 sg13cmos5l_dfrbp_1_10.Q a_7248_3460# 0
C8229 a_6697_3192# sg13cmos5l_dlhr_1_0.D 0
C8230 sg13cmos5l_buf_1_3.A sg13cmos5l_dfrbp_1_3.Q_N 0.04941f
C8231 a_13047_7690# a_12841_7728# 0.27532f
C8232 sg13cmos5l_or2_1_0.A a_2505_3947# 0
C8233 sg13cmos5l_nor2b_1_0.Y sg13cmos5l_buf_1_28.X 0
C8234 sg13cmos5l_buf_1_31.X sg13cmos5l_buf_1_29.A 1.5756f
C8235 sg13cmos5l_buf_1_1.A a_16936_1758# 0
C8236 a_1662_8374# sg13cmos5l_inv_1_19.A 0.00859f
C8237 sg13cmos5l_buf_1_64.A a_3676_7964# 0
C8238 sg13cmos5l_a22oi_1_1.A1 a_18959_3215# 0
C8239 sg13cmos5l_buf_1_5.A sg13cmos5l_dfrbp_1_23.Q 0.38905f
C8240 a_14449_3215# a_14254_2444# 0
C8241 sg13cmos5l_a22oi_1_1.Y a_17126_1626# 0
C8242 a_11372_3102# nh_sw[5] 0.28827f
C8243 sg13cmos5l_buf_1_65.X a_7504_8678# 0
C8244 a_9705_4650# sg13cmos5l_dfrbp_1_10.Q 0
C8245 sg13cmos5l_dfrbp_1_8.RESET_B sg13cmos5l_dlhr_1_9.D 0.1364f
C8246 a_18860_9150# pl_sw[10] 0.00131f
C8247 sg13cmos5l_a22oi_1_1.Y a_17354_4180# 0
C8248 sg13cmos5l_dfrbp_1_15.D a_1125_5423# 0
C8249 sg13cmos5l_dfrbp_1_6.RESET_B a_5700_6480# 0.49734f
C8250 sg13cmos5l_buf_1_98.A a_12933_6141# 0
C8251 a_8972_9150# a_9256_9224# 0.13542f
C8252 sg13cmos5l_dlhr_1_2.D a_7497_3138# 0
C8253 sg13cmos5l_dfrbp_1_6.RESET_B sg13cmos5l_dlhr_1_1.D 0.39213f
C8254 a_13701_3117# sg13cmos5l_nor2b_1_1.Y 0
C8255 sg13cmos5l_buf_1_40.A a_1125_5423# 0.01647f
C8256 sg13cmos5l_buf_1_8.A a_11913_2017# 0
C8257 sg13cmos5l_dfrbp_1_6.D a_3599_3215# 0.00228f
C8258 sg13cmos5l_or2_1_0.A a_1862_4338# 0.01382f
C8259 sg13cmos5l_inv_1_2.A a_10725_7653# 0
C8260 a_6198_3120# a_5637_2399# 0.00567f
C8261 sg13cmos5l_or2_1_0.A a_17224_3270# 0.00267f
C8262 sg13cmos5l_dlhr_1_15.D a_13324_4696# 0.00711f
C8263 a_14889_7281# a_14996_5412# 0.00197f
C8264 a_9705_4650# sg13cmos5l_inv_1_0.Y 0
C8265 sg13cmos5l_dfrbp_1_12.Q_N sg13cmos5l_buf_1_46.A 0.43052f
C8266 a_15045_8447# ph_sw[6] 0.00172f
C8267 sg13cmos5l_buf_1_18.A nl_sw[10] 0
C8268 a_4566_2818# sg13cmos5l_dlhr_1_3.Q_N 0.12876f
C8269 sg13cmos5l_dfrbp_1_6.RESET_B a_7524_7992# 0.50579f
C8270 sg13cmos5l_buf_1_5.A a_13460_7996# 0.0317f
C8271 a_14056_1664# a_14440_1664# 0.00492f
C8272 sg13cmos5l_buf_1_19.A a_18615_5770# 0.02164f
C8273 sg13cmos5l_dfrbp_1_8.RESET_B a_7892_3900# 0.00285f
C8274 a_15974_6162# a_16548_6175# 0.36169f
C8275 a_16779_6284# a_17776_6382# 0.06778f
C8276 a_2824_2388# nl_sw[2] 0
C8277 sg13cmos5l_buf_1_38.A sg13cmos5l_dfrbp_1_10.Q 0
C8278 a_7888_4870# a_7497_3138# 0
C8279 sg13cmos5l_nand2_1_0.B nl_sw[5] 0
C8280 ph_sw[0] a_1484_9150# 0.00116f
C8281 sg13cmos5l_dlhr_1_6.D sg13cmos5l_dfrbp_1_2.Q_N 0
C8282 a_1864_1664# nh_sw[0] 0.00611f
C8283 sg13cmos5l_inv_1_26.Y a_17367_8794# 0
C8284 a_6405_8447# a_6276_8861# 0.01562f
C8285 a_5988_8440# a_6507_8447# 0.38871f
C8286 a_3241_2746# nh_sw[1] 0.12379f
C8287 a_14726_7674# VPWR 0.92786f
C8288 a_5049_4965# VPWR 0
C8289 a_5079_3154# a_5210_3148# 0.65127f
C8290 a_14032_6382# sg13cmos5l_and3_1_0.X 0.00216f
C8291 sg13cmos5l_dfrbp_1_8.RESET_B a_904_7806# 0.00181f
C8292 sg13cmos5l_inv_1_7.A a_11769_7989# 0
C8293 sg13cmos5l_dfrbp_1_16.Q a_3302_4650# 0
C8294 sg13cmos5l_buf_1_5.A a_14814_4292# 0
C8295 sg13cmos5l_buf_1_4.A nl_sw[8] 0.15862f
C8296 sg13cmos5l_dfrbp_1_0.RESET_B a_16462_4338# 0
C8297 a_16748_9150# a_16724_8436# 0
C8298 sg13cmos5l_buf_1_93.X a_15887_8797# 0.00552f
C8299 a_16293_4629# a_17041_4727# 0.01058f
C8300 a_12075_3911# a_11877_2399# 0
C8301 a_8660_5412# VPWR 0.10835f
C8302 a_4652_6126# a_4736_5498# 0
C8303 sg13cmos5l_o21ai_1_0.Y a_11973_1605# 0
C8304 sg13cmos5l_dfrbp_1_18.Q a_9189_8447# 0.03748f
C8305 a_17108_7972# a_17751_7690# 0
C8306 sg13cmos5l_inv_1_7.A sg13cmos5l_dfrbp_1_4.D 0
C8307 sg13cmos5l_nand2_1_1.B a_13572_3151# 0
C8308 a_682_5380# sg13cmos5l_or2_1_0.A 0.0026f
C8309 a_10868_8436# a_10827_7796# 0
C8310 a_14800_3358# nh_sw[6] 0
C8311 sg13cmos5l_a22oi_1_1.B1 a_13701_3117# 0
C8312 sg13cmos5l_dfrbp_1_0.RESET_B a_11556_1944# 0.48041f
C8313 sg13cmos5l_dfrbp_1_21.Q_N sg13cmos5l_buf_8_0.A 0
C8314 sg13cmos5l_inv_1_29.Y sg13cmos5l_inv_1_0.A 0.00164f
C8315 sg13cmos5l_inv_1_28.Y a_11560_7010# 0.02569f
C8316 sg13cmos5l_dfrbp_1_6.RESET_B a_1088_7806# 0.00185f
C8317 a_11464_9224# ph_sw[5] 0.00464f
C8318 a_3407_4261# a_2757_3117# 0
C8319 a_3664_4142# a_2859_3260# 0.00237f
C8320 sg13cmos5l_buf_1_0.A nl_sw[10] 0.0645f
C8321 a_19244_2352# a_18928_1846# 0
C8322 sg13cmos5l_buf_1_10.A a_11270_4338# 0.00109f
C8323 sg13cmos5l_or2_1_0.A sg13cmos5l_dfrbp_1_10.Q 0.16208f
C8324 sg13cmos5l_buf_1_34.X a_4950_7354# 0
C8325 sg13cmos5l_nand2_1_0.A a_13072_1846# 0
C8326 sg13cmos5l_or2_1_0.A a_6736_2630# 0
C8327 sg13cmos5l_inv_1_5.A d_out[2] 0.0446f
C8328 sg13cmos5l_dfrbp_1_0.Q nh_sw[10] 0
C8329 a_12814_4692# sg13cmos5l_o21ai_1_0.Y 0
C8330 sg13cmos5l_inv_1_3.A sg13cmos5l_inv_1_7.A 0
C8331 a_2148_3904# ckc 0
C8332 a_20118_6144# sg13cmos5l_dlhr_1_16.Q 0.00369f
C8333 sg13cmos5l_and3_1_0.X sg13cmos5l_or2_1_0.A 0
C8334 a_3530_6320# VPWR 0.00701f
C8335 a_17829_1605# a_18577_1703# 0.01058f
C8336 sg13cmos5l_buf_1_29.A sg13cmos5l_a221oi_1_0.C1 0.01092f
C8337 a_18856_8436# sg13cmos5l_buf_1_104.X 0
C8338 a_1862_4338# a_1672_3176# 0
C8339 sg13cmos5l_inv_1_0.Y sg13cmos5l_or2_1_0.A 0
C8340 a_1227_5423# VPWR 0.21136f
C8341 sg13cmos5l_dlhr_1_5.GATE a_8570_6172# 0.00709f
C8342 a_1967_7285# a_2727_6380# 0.00804f
C8343 sg13cmos5l_inv_1_29.Y a_12490_6385# 0
C8344 sg13cmos5l_buf_1_25.A a_6889_1680# 0
C8345 a_10665_7281# sg13cmos5l_a221oi_1_0.C1 0
C8346 sg13cmos5l_nand2_1_0.B sg13cmos5l_dfrbp_1_0.CLK 0
C8347 sg13cmos5l_dfrbp_1_23.CLK a_13094_6924# 0
C8348 sg13cmos5l_dlhr_1_12.D a_16528_7894# 0.15881f
C8349 a_17700_3456# a_19216_3358# 0.00294f
C8350 a_18117_3117# a_18959_3215# 0.00437f
C8351 a_1484_6126# a_1878_6337# 0.00464f
C8352 sg13cmos5l_a22oi_1_1.Y nh_sw[7] 0
C8353 sg13cmos5l_buf_1_26.X VPWR 0.32846f
C8354 sg13cmos5l_or2_1_0.A a_5673_3138# 0.00235f
C8355 sg13cmos5l_buf_1_30.A sg13cmos5l_dlhr_1_2.Q_N 0.02399f
C8356 sg13cmos5l_inv_1_17.A sg13cmos5l_buf_1_64.A 0.10707f
C8357 sg13cmos5l_buf_1_4.A sg13cmos5l_nand2_1_1.A 0.02211f
C8358 sg13cmos5l_buf_1_73.X a_6276_8861# 0.00224f
C8359 sg13cmos5l_dlygate4sd3_1_0.X a_650_3900# 0
C8360 sg13cmos5l_dlhr_1_2.Q a_8588_2352# 0.03278f
C8361 sg13cmos5l_buf_1_34.X a_5425_3130# 0
C8362 sg13cmos5l_inv_1_26.Y a_18870_7656# 0
C8363 a_1196_8400# sg13cmos5l_buf_1_63.X 0.28958f
C8364 a_13641_7674# a_14166_7656# 0.13715f
C8365 sg13cmos5l_dfrbp_1_10.Q a_7820_2352# 0
C8366 a_13178_7684# a_13392_7996# 0.01249f
C8367 a_5637_2399# sg13cmos5l_dlhr_1_0.D 0
C8368 sg13cmos5l_buf_1_34.X a_5194_2356# 0.01732f
C8369 a_6479_2749# a_7316_2388# 0.1333f
C8370 a_3302_4650# a_4005_4629# 0.02453f
C8371 a_1402_3864# a_1956_4338# 0
C8372 sg13cmos5l_dlygate4sd2_1_0.X a_1862_4338# 0.00664f
C8373 a_10789_4654# sg13cmos5l_a22oi_1_0.B1 0
C8374 a_17529_7047# VPWR 0
C8375 sg13cmos5l_nand2_1_1.A d_out[1] 0.00164f
C8376 sg13cmos5l_buf_1_4.A a_16293_4629# 0.00517f
C8377 a_6372_4968# sg13cmos5l_or2_1_0.A 0.00207f
C8378 sg13cmos5l_dfrbp_1_25.Q_N pl_sw[9] 0
C8379 sg13cmos5l_nor2b_1_0.Y sg13cmos5l_a22oi_1_2.B1 0.00613f
C8380 cks ph_sw[8] 0.00209f
C8381 sg13cmos5l_or2_1_0.A ckc 0
C8382 sg13cmos5l_buf_1_65.X a_8486_8874# 0.00122f
C8383 sg13cmos5l_buf_1_44.X sg13cmos5l_dlhr_1_5.GATE 0.24611f
C8384 a_11846_9186# a_12132_9504# 0.50066f
C8385 a_7508_1948# nl_sw[4] 0
C8386 sg13cmos5l_dfrbp_1_6.D a_16485_6935# 0.00878f
C8387 a_8439_6178# a_8841_5769# 0.00312f
C8388 a_8233_6216# a_8660_5412# 0
C8389 sg13cmos5l_dfrbp_1_0.CLK nl_sw[6] 0.13421f
C8390 sg13cmos5l_dfrbp_1_6.RESET_B a_7520_7010# 0.00604f
C8391 a_1946_4660# a_1862_4338# 0
C8392 sg13cmos5l_buf_1_5.X a_14900_2352# 0.00697f
C8393 sg13cmos5l_dfrbp_1_6.RESET_B a_18480_5028# 0.00115f
C8394 sg13cmos5l_inv_1_6.A a_17972_4948# 0
C8395 sg13cmos5l_buf_1_33.A a_1576_1758# 0.00113f
C8396 a_1864_1664# a_1760_1758# 0.00624f
C8397 sg13cmos5l_buf_1_39.A sg13cmos5l_buf_1_24.X 0
C8398 sg13cmos5l_dfrbp_1_6.D sg13cmos5l_dfrbp_1_10.Q_N 0.30759f
C8399 sg13cmos5l_dfrbp_1_11.Q a_8660_5412# 0.00236f
C8400 sg13cmos5l_a22oi_1_2.B2 sg13cmos5l_buf_1_9.A 0.00804f
C8401 a_3676_7964# VPWR 0.6224f
C8402 sg13cmos5l_inv_1_2.A a_12404_7972# 0
C8403 sg13cmos5l_or2_1_0.A a_18959_3215# 0
C8404 a_4559_7630# sg13cmos5l_dlhr_1_1.GATE 0.02681f
C8405 sg13cmos5l_inv_1_18.A a_8852_6484# 0
C8406 sg13cmos5l_dfrbp_1_10.Q a_5424_3460# 0
C8407 sg13cmos5l_buf_1_89.A a_15177_5769# 0.00266f
C8408 sg13cmos5l_dlhr_1_15.D a_12520_4782# 0.00149f
C8409 sg13cmos5l_nor2_1_0.A a_12120_3456# 0.00312f
C8410 sg13cmos5l_dfrbp_1_6.RESET_B a_8783_7751# 0.20245f
C8411 sg13cmos5l_inv_1_7.A a_12516_6480# 0.00431f
C8412 a_3407_8797# a_3625_7282# 0
C8413 sg13cmos5l_buf_1_5.A a_13393_7666# 0.00192f
C8414 a_4244_8436# a_3831_7282# 0
C8415 a_14924_1590# sg13cmos5l_buf_1_1.A 0.01091f
C8416 sg13cmos5l_buf_1_19.A a_19209_5769# 0.01957f
C8417 sg13cmos5l_inv_1_2.A a_14152_8522# 0
C8418 sg13cmos5l_buf_1_5.A ph_sw[5] 0
C8419 sg13cmos5l_dfrbp_1_12.Q_N a_7497_3138# 0
C8420 a_8276_6924# a_8390_6924# 0.00122f
C8421 sg13cmos5l_dfrbp_1_1.Q a_17588_2388# 0.00324f
C8422 a_6507_8447# a_7504_8678# 0.07046f
C8423 sg13cmos5l_dfrbp_1_0.RESET_B a_16657_2749# 0
C8424 a_16528_7894# VPWR 0.14657f
C8425 sg13cmos5l_buf_1_110.A a_14986_7897# 0.00309f
C8426 a_5210_3148# a_5606_3576# 0.00949f
C8427 sg13cmos5l_dfrbp_1_23.CLK sg13cmos5l_nand2_1_1.A 0.00418f
C8428 sg13cmos5l_inv_1_2.A sg13cmos5l_buf_1_94.X 0.00133f
C8429 a_9040_7894# a_9344_7010# 0
C8430 sg13cmos5l_dfrbp_1_1.Q a_17829_1605# 0.01078f
C8431 sg13cmos5l_inv_1_7.A cks 0.48425f
C8432 a_13768_8436# pl_sw[7] 0
C8433 a_3447_2746# a_3241_2746# 0.2777f
C8434 sg13cmos5l_dfrbp_1_0.RESET_B a_17931_1748# 0.55627f
C8435 sg13cmos5l_buf_1_65.X a_1862_8874# 0.00208f
C8436 a_11072_5347# sg13cmos5l_inv_1_0.Y 0
C8437 sg13cmos5l_a22oi_1_2.B2 a_10587_4692# 0
C8438 a_17972_4948# sg13cmos5l_dfrbp_1_8.Q_N 0.25039f
C8439 sg13cmos5l_dfrbp_1_0.RESET_B a_17399_3947# 0.0031f
C8440 sg13cmos5l_dfrbp_1_6.RESET_B a_14583_5770# 0.02012f
C8441 a_12075_3911# a_12976_2630# 0.00118f
C8442 sg13cmos5l_buf_1_38.A a_4566_2818# 0.00298f
C8443 sg13cmos5l_inv_1_28.Y a_11464_9224# 0.33512f
C8444 sg13cmos5l_inv_1_2.A a_14632_9224# 0.00513f
C8445 sg13cmos5l_dlhr_1_11.GATE a_12361_7282# 0.02668f
C8446 sg13cmos5l_dlhr_1_15.D a_17882_7684# 0.00208f
C8447 sg13cmos5l_buf_1_30.A a_8247_5770# 0
C8448 sg13cmos5l_buf_1_34.X ph_sw[3] 0
C8449 sg13cmos5l_dfrbp_1_11.Q sg13cmos5l_buf_1_26.X 0.00155f
C8450 a_20012_2352# sg13cmos5l_buf_1_18.X 0
C8451 sg13cmos5l_inv_1_27.Y sg13cmos5l_dfrbp_1_22.D 0
C8452 sg13cmos5l_dfrbp_1_0.CLK a_11174_2826# 0.00102f
C8453 a_11973_3911# a_11877_2399# 0.00227f
C8454 sg13cmos5l_dfrbp_1_1.Q a_13072_1846# 0
C8455 sg13cmos5l_inv_1_2.A sg13cmos5l_nand2_1_1.B 0
C8456 a_6789_4629# a_6891_4772# 0.66105f
C8457 a_13017_1941# nh_sw[6] 0
C8458 sg13cmos5l_dlhr_1_6.D a_13324_4696# 0
C8459 a_9189_8447# cks 0.01551f
C8460 sg13cmos5l_dfrbp_1_0.RESET_B a_13652_1924# 0
C8461 sg13cmos5l_inv_1_8.A a_4950_5699# 0
C8462 sg13cmos5l_dfrbp_1_9.Q a_4934_2826# 0
C8463 a_4244_3900# a_4436_3436# 0
C8464 sg13cmos5l_buf_1_44.X a_4652_6126# 0
C8465 sg13cmos5l_dfrbp_1_6.RESET_B sg13cmos5l_dlhr_1_8.Q_N 0.00102f
C8466 sg13cmos5l_buf_1_10.A a_11844_4325# 0.00117f
C8467 a_2879_6432# sg13cmos5l_dlhr_1_1.Q 0.00682f
C8468 sg13cmos5l_dfrbp_1_6.RESET_B a_6213_3911# 0.05293f
C8469 sg13cmos5l_dfrbp_1_8.RESET_B a_6647_5459# 0.11223f
C8470 a_12216_5728# sg13cmos5l_a221oi_1_0.C1 0
C8471 a_19828_6148# sg13cmos5l_dlhr_1_16.Q 0
C8472 a_5414_6162# VPWR 0.93776f
C8473 a_1158_3142# a_1290_3206# 0.478f
C8474 a_14536_7806# a_14295_7282# 0
C8475 a_18928_1846# a_19090_1626# 0.0019f
C8476 a_19508_1924# sg13cmos5l_dfrbp_1_0.Q_N 0.25039f
C8477 sg13cmos5l_dlhr_1_1.GATE sg13cmos5l_buf_1_43.A 0
C8478 a_2148_3904# a_2757_3117# 0
C8479 a_2565_3911# a_2340_3456# 0
C8480 a_1065_5459# VPWR 0
C8481 sg13cmos5l_dfrbp_1_16.Q a_2748_6126# 0.03028f
C8482 a_3574_7850# sg13cmos5l_buf_1_62.X 0
C8483 sg13cmos5l_dfrbp_1_8.RESET_B a_10308_7992# 0
C8484 a_18959_3215# sg13cmos5l_buf_1_3.X 0
C8485 a_1997_6126# a_2879_6432# 0.0032f
C8486 sg13cmos5l_dlhr_1_0.Q a_7689_1626# 0.30448f
C8487 sg13cmos5l_or2_1_0.A sg13cmos5l_dlhr_1_2.D 0
C8488 a_16144_8678# a_16068_6928# 0
C8489 sg13cmos5l_dlygate4sd2_1_0.X ckc 0
C8490 a_7238_7674# VPWR 0.92871f
C8491 sg13cmos5l_inv_1_1.A a_14583_5770# 0.0016f
C8492 sg13cmos5l_or2_1_0.A a_4566_2818# 0
C8493 sg13cmos5l_buf_1_30.A a_7498_7897# 0.00281f
C8494 sg13cmos5l_buf_1_45.X a_7631_4727# 0.01176f
C8495 sg13cmos5l_dfrbp_1_8.D a_18961_5814# 0.00143f
C8496 sg13cmos5l_buf_1_37.A sg13cmos5l_inv_1_19.A 0.00135f
C8497 a_1402_3864# a_1158_3142# 0.00562f
C8498 sg13cmos5l_dfrbp_1_9.Q a_4244_3900# 0.14702f
C8499 a_6479_2749# sg13cmos5l_dlhr_1_0.D 0.01247f
C8500 a_13641_7674# a_13596_7710# 0
C8501 a_13460_7996# a_13393_7666# 0.0018f
C8502 a_14166_7656# a_14986_7897# 0.00231f
C8503 sg13cmos5l_buf_1_34.X a_5739_2399# 0.00179f
C8504 a_13698_5412# a_13324_4696# 0
C8505 a_3302_4650# a_4847_4727# 0
C8506 a_2565_8447# cks 0.01561f
C8507 a_19136_9318# sg13cmos5l_buf_1_19.A 0
C8508 sg13cmos5l_buf_1_4.A sg13cmos5l_dfrbp_1_0.D 0
C8509 sg13cmos5l_inv_1_17.A VPWR 1.12692f
C8510 sg13cmos5l_nor2b_1_0.Y a_13652_3900# 0
C8511 sg13cmos5l_a22oi_1_0.Y a_11530_3868# 0
C8512 sg13cmos5l_buf_1_40.A sg13cmos5l_buf_1_61.X 0
C8513 a_12132_9504# a_13648_9406# 0.00294f
C8514 a_12549_9165# a_13391_9263# 0.00437f
C8515 VPWR nh_sw[6] 0.15793f
C8516 nh_sw[6] nl_sw[7] 0.10954f
C8517 sg13cmos5l_inv_1_27.Y sg13cmos5l_and3_1_0.X 0
C8518 sg13cmos5l_buf_1_4.X a_17674_3361# 0.00245f
C8519 sg13cmos5l_dfrbp_1_6.D a_17327_7285# 0.00622f
C8520 sg13cmos5l_buf_1_56.A a_8841_5769# 0
C8521 sg13cmos5l_inv_1_28.Y sg13cmos5l_buf_1_5.A 0
C8522 sg13cmos5l_or2_1_0.A a_2757_3117# 0.00175f
C8523 sg13cmos5l_dfrbp_1_2.D sg13cmos5l_dfrbp_1_10.Q 0.01113f
C8524 sg13cmos5l_dfrbp_1_6.RESET_B sg13cmos5l_dlhr_1_5.Q 0.04773f
C8525 a_2934_4632# a_2565_3911# 0.00114f
C8526 sg13cmos5l_buf_1_57.X a_14820_7674# 0
C8527 sg13cmos5l_dfrbp_1_6.RESET_B sg13cmos5l_inv_1_19.A 1.42074f
C8528 a_1006_4167# a_1402_3864# 0.00874f
C8529 sg13cmos5l_buf_1_45.X a_8988_6198# 0
C8530 sg13cmos5l_buf_1_77.A sg13cmos5l_dlhr_1_6.Q_N 0.00306f
C8531 a_19227_9190# frame 0.02746f
C8532 sg13cmos5l_dlhr_1_2.D a_7820_2352# 0
C8533 sg13cmos5l_buf_1_34.X a_5210_3148# 0.00201f
C8534 sg13cmos5l_buf_1_3.A a_19216_3358# 0.01625f
C8535 sg13cmos5l_a22oi_1_2.B2 sg13cmos5l_dfrbp_1_1.D 0.21262f
C8536 sg13cmos5l_nor2b_1_0.Y a_11270_4338# 0.03741f
C8537 sg13cmos5l_buf_1_107.X a_19136_9318# 0.00139f
C8538 sg13cmos5l_dfrbp_1_10.Q sg13cmos5l_buf_1_34.A 0.00461f
C8539 a_6865_6239# a_7378_6162# 0
C8540 sg13cmos5l_dfrbp_1_15.D a_3962_7288# 0.03696f
C8541 sg13cmos5l_inv_1_0.Y sg13cmos5l_dfrbp_1_2.D 0.0114f
C8542 sg13cmos5l_dfrbp_1_6.RESET_B sg13cmos5l_dfrbp_1_20.Q 0.99671f
C8543 sg13cmos5l_dfrbp_1_6.RESET_B a_19142_5412# 0
C8544 sg13cmos5l_dfrbp_1_15.D a_708_5416# 0
C8545 a_10202_7288# sg13cmos5l_dlhr_1_6.D 0
C8546 sg13cmos5l_buf_1_31.X a_9558_6144# 0.04743f
C8547 sg13cmos5l_dlhr_1_5.Q a_10412_6126# 0.32203f
C8548 sg13cmos5l_inv_1_2.A a_15793_8797# 0.00801f
C8549 sg13cmos5l_dfrbp_1_1.Q a_19244_2352# 0.00161f
C8550 sg13cmos5l_dlhr_1_5.Q a_10071_7282# 0.0045f
C8551 sg13cmos5l_buf_1_40.A a_708_5416# 0.0164f
C8552 sg13cmos5l_dlhr_1_16.Q a_20008_3900# 0
C8553 a_7504_8678# sg13cmos5l_dfrbp_1_18.Q_N 0.15881f
C8554 sg13cmos5l_inv_1_2.A sg13cmos5l_a22oi_1_1.A1 1.77827f
C8555 sg13cmos5l_buf_1_110.A a_15429_7653# 0.04801f
C8556 sg13cmos5l_buf_1_101.X a_19136_9318# 0.06038f
C8557 sg13cmos5l_buf_1_10.A pl_sw[6] 0.00117f
C8558 sg13cmos5l_dfrbp_1_20.Q a_10412_6126# 0.02994f
C8559 a_1815_4666# a_1609_4704# 0.27532f
C8560 a_17516_9150# pl_sw[8] 0.29561f
C8561 a_2348_7624# sg13cmos5l_dlhr_1_1.GATE 0
C8562 sg13cmos5l_dfrbp_1_20.Q a_10071_7282# 0.01618f
C8563 sg13cmos5l_dfrbp_1_16.Q a_3814_4663# 0
C8564 sg13cmos5l_dfrbp_1_1.Q a_20012_1590# 0.00541f
C8565 sg13cmos5l_dfrbp_1_12.Q_N a_9705_4650# 0
C8566 sg13cmos5l_buf_1_45.A a_9260_2352# 0
C8567 sg13cmos5l_dlhr_1_5.GATE sg13cmos5l_dlhr_1_9.Q 0
C8568 sg13cmos5l_buf_1_65.X a_2667_8447# 0.00117f
C8569 sg13cmos5l_dfrbp_1_6.RESET_B a_14929_5814# 0
C8570 a_5700_6480# a_5951_5383# 0.01066f
C8571 a_6117_6141# a_5799_5499# 0
C8572 sg13cmos5l_buf_1_37.A sg13cmos5l_buf_1_33.A 0.02119f
C8573 sg13cmos5l_o21ai_1_0.A2 a_11844_1639# 0
C8574 a_5800_9224# ph_sw[2] 0
C8575 sg13cmos5l_dlygate4sd2_1_0.A sg13cmos5l_or2_1_0.A 0.06797f
C8576 a_17132_9150# sg13cmos5l_buf_1_107.X 0
C8577 sg13cmos5l_buf_1_94.X a_17792_9318# 0
C8578 a_19227_9190# sg13cmos5l_buf_1_3.A 0.04223f
C8579 sg13cmos5l_o21ai_1_0.B1 sg13cmos5l_buf_1_6.A 0.00554f
C8580 sg13cmos5l_dfrbp_1_16.Q a_9366_5842# 0.00705f
C8581 sg13cmos5l_dlhr_1_11.GATE a_13396_7312# 0
C8582 sg13cmos5l_dfrbp_1_6.RESET_B sg13cmos5l_dlhr_1_9.D 0.30089f
C8583 sg13cmos5l_dfrbp_1_0.RESET_B sg13cmos5l_buf_1_8.A 0.05339f
C8584 sg13cmos5l_or2_1_1.B sg13cmos5l_a22oi_1_0.B1 0.00188f
C8585 a_4436_3436# a_5079_3154# 0
C8586 a_7524_7992# a_8439_6178# 0
C8587 sg13cmos5l_buf_1_40.A a_1192_1664# 0.3377f
C8588 a_7498_7897# pl_sw[5] 0
C8589 a_2757_3117# a_3578_2752# 0
C8590 a_2859_3260# a_3241_2746# 0.00626f
C8591 sg13cmos5l_dfrbp_1_1.Q a_16268_1590# 0.00168f
C8592 a_16271_7751# a_16677_6141# 0
C8593 a_15439_1630# nh_sw[6] 0
C8594 sg13cmos5l_inv_1_26.Y a_17896_9224# 0.33412f
C8595 a_6372_4968# a_6660_4663# 0.4806f
C8596 a_17132_9150# sg13cmos5l_buf_1_101.X 0.00896f
C8597 sg13cmos5l_buf_1_94.X a_18860_9150# 0
C8598 sg13cmos5l_buf_1_29.A sg13cmos5l_nand2_1_0.B 0.00121f
C8599 a_10868_8436# cks 0.00928f
C8600 sg13cmos5l_inv_1_8.A a_5710_5850# 0.01685f
C8601 sg13cmos5l_dlhr_1_9.D a_10412_6126# 0
C8602 sg13cmos5l_a22oi_1_1.Y sg13cmos5l_dfrbp_1_1.Q 0
C8603 sg13cmos5l_dfrbp_1_0.RESET_B sg13cmos5l_buf_1_1.A 0
C8604 sg13cmos5l_dfrbp_1_6.RESET_B sg13cmos5l_buf_1_33.A 0
C8605 a_12132_9504# ph_sw[6] 0.00385f
C8606 sg13cmos5l_buf_1_2.A a_16164_4663# 0
C8607 sg13cmos5l_buf_1_44.X a_5312_6294# 0.003f
C8608 sg13cmos5l_buf_1_24.A sg13cmos5l_buf_1_31.X 0.02391f
C8609 sg13cmos5l_o21ai_1_0.A2 a_12520_3176# 0
C8610 a_12120_3456# sg13cmos5l_o21ai_1_0.Y 0.01087f
C8611 a_13768_8436# a_14602_8404# 0.00252f
C8612 a_3692_9150# sg13cmos5l_buf_1_62.X 0.29236f
C8613 sg13cmos5l_inv_1_18.A sg13cmos5l_nand2_1_0.A 0
C8614 a_16748_9150# sg13cmos5l_buf_1_93.X 0.3335f
C8615 sg13cmos5l_buf_1_65.X a_7820_9150# 0.00752f
C8616 sg13cmos5l_buf_1_63.A a_1480_7806# 0.00355f
C8617 a_2314_3361# a_2340_3456# 0.43042f
C8618 a_7216_6382# VPWR 0.14761f
C8619 a_18577_1703# a_19090_1626# 0
C8620 sg13cmos5l_dfrbp_1_6.RESET_B a_904_7806# 0.00655f
C8621 a_7336_7010# VPWR 0.13927f
C8622 sg13cmos5l_inv_1_11.Y sg13cmos5l_buf_1_8.X 0
C8623 a_10220_3102# sg13cmos5l_buf_1_9.A 0
C8624 sg13cmos5l_buf_1_28.X a_11372_3102# 0
C8625 a_11973_1605# nh_sw[6] 0.00101f
C8626 sg13cmos5l_dfrbp_1_9.Q a_5079_3154# 0.23719f
C8627 sg13cmos5l_dfrbp_1_8.RESET_B a_11824_7894# 0
C8628 sg13cmos5l_buf_1_111.A a_19528_6924# 0.00925f
C8629 sg13cmos5l_inv_1_26.Y a_19424_7010# 0.0165f
C8630 a_2380_6162# a_2727_6380# 0.07046f
C8631 sg13cmos5l_dfrbp_1_16.Q a_1967_5773# 0
C8632 sg13cmos5l_dfrbp_1_21.Q a_17337_4965# 0
C8633 sg13cmos5l_buf_1_96.A sg13cmos5l_dfrbp_1_6.D 0.00955f
C8634 sg13cmos5l_inv_1_2.A nh_sw[8] 0
C8635 sg13cmos5l_dfrbp_1_22.D a_16068_6928# 0.01182f
C8636 sg13cmos5l_dfrbp_1_25.Q_N a_16485_6935# 0
C8637 sg13cmos5l_inv_1_17.A a_5132_9150# 0
C8638 sg13cmos5l_buf_1_65.X sg13cmos5l_buf_1_76.X 1.86953f
C8639 sg13cmos5l_dlhr_1_15.D a_14814_3876# 0
C8640 a_15016_9224# sg13cmos5l_buf_1_110.A 0
C8641 a_13648_9406# sg13cmos5l_buf_1_93.X 0
C8642 sg13cmos5l_buf_1_90.X a_12358_9199# 0
C8643 a_7332_7674# VPWR 0
C8644 sg13cmos5l_buf_1_45.X sg13cmos5l_dfrbp_1_11.Q_N 0.05019f
C8645 sg13cmos5l_buf_1_4.A a_15884_3102# 0.00226f
C8646 sg13cmos5l_dfrbp_1_8.RESET_B a_15045_8447# 0.06095f
C8647 a_12651_9308# sg13cmos5l_inv_1_7.A 0
C8648 sg13cmos5l_dlhr_1_2.Q sg13cmos5l_buf_1_28.X 0
C8649 a_996_5837# VPWR 0.00776f
C8650 a_5577_2435# sg13cmos5l_dlhr_1_0.D 0
C8651 sg13cmos5l_a22oi_1_1.B2 a_15590_4650# 0
C8652 a_3588_4968# a_4753_4727# 0.4858f
C8653 a_4107_4772# a_3876_4663# 0.15089f
C8654 a_3313_8797# cks 0
C8655 sg13cmos5l_dlhr_1_9.Q a_4652_6126# 0
C8656 sg13cmos5l_dfrbp_1_12.Q_N sg13cmos5l_or2_1_0.A 0.01555f
C8657 ph_sw[8] pl_sw[9] 0.12921f
C8658 a_13391_9263# sg13cmos5l_inv_1_27.Y 0.00332f
C8659 a_1472_4782# a_1290_3206# 0
C8660 a_19528_6924# a_20392_6924# 0
C8661 sg13cmos5l_dlhr_1_10.Q a_19424_7010# 0.05988f
C8662 sg13cmos5l_dfrbp_1_9.Q a_2565_3911# 0.02712f
C8663 a_424_8436# sg13cmos5l_buf_1_63.X 0.00497f
C8664 a_10230_4632# sg13cmos5l_buf_1_28.X 0
C8665 sg13cmos5l_dfrbp_1_8.RESET_B a_3488_7010# 0.00508f
C8666 a_20008_8436# cks 0
C8667 sg13cmos5l_buf_1_30.A a_8022_3120# 0.00975f
C8668 sg13cmos5l_dlygate4sd2_1_0.A a_1672_3176# 0
C8669 sg13cmos5l_nor2b_1_0.Y a_11844_4325# 0.0239f
C8670 sg13cmos5l_dfrbp_1_22.D a_18856_8436# 0
C8671 sg13cmos5l_dfrbp_1_16.Q_N a_1873_7285# 0.00243f
C8672 sg13cmos5l_buf_1_34.X a_4041_2745# 0.00281f
C8673 sg13cmos5l_dfrbp_1_21.Q a_14377_5770# 0.01215f
C8674 a_11394_4948# sg13cmos5l_nand2_1_0.A 0
C8675 sg13cmos5l_dfrbp_1_16.Q_N a_2786_7666# 0
C8676 sg13cmos5l_dfrbp_1_15.D a_4380_7326# 0.00115f
C8677 sg13cmos5l_buf_1_31.X a_3588_4968# 0
C8678 sg13cmos5l_dfrbp_1_6.D sg13cmos5l_a221oi_1_0.B1 0
C8679 a_1472_4782# a_1402_3864# 0.00413f
C8680 sg13cmos5l_dlhr_1_5.GATE a_2727_6380# 0
C8681 sg13cmos5l_buf_1_28.X nh_sw[5] 0
C8682 a_7247_8797# a_7449_8559# 0.00675f
C8683 sg13cmos5l_dfrbp_1_6.D a_13094_6924# 0
C8684 sg13cmos5l_dlhr_1_11.Q a_12933_6141# 0
C8685 a_12719_2749# sg13cmos5l_dfrbp_1_0.Q 0
C8686 sg13cmos5l_dlygate4sd2_1_0.A sg13cmos5l_dlygate4sd2_1_0.X 0
C8687 a_8204_9150# sg13cmos5l_inv_1_2.A 0
C8688 sg13cmos5l_dfrbp_1_6.RESET_B sg13cmos5l_dlhr_1_7.Q_N 0.00582f
C8689 sg13cmos5l_dfrbp_1_8.RESET_B a_7034_3148# 0
C8690 a_1609_4704# a_1472_4782# 0.00973f
C8691 a_2409_4650# a_2934_4632# 0.13715f
C8692 sg13cmos5l_inv_1_3.A a_14708_6924# 0
C8693 a_2831_7630# VPWR 0.40919f
C8694 sg13cmos5l_buf_1_58.A sg13cmos5l_dlhr_1_1.GATE 0.24317f
C8695 a_3574_7850# sg13cmos5l_dlhr_1_9.Q 0.56997f
C8696 sg13cmos5l_dfrbp_1_20.Q a_10620_7326# 0.00134f
C8697 a_5796_3904# VPWR 0.08142f
C8698 sg13cmos5l_dlhr_1_15.D sg13cmos5l_and3_1_0.C 0.00116f
C8699 sg13cmos5l_buf_8_1.A a_15821_3864# 0
C8700 sg13cmos5l_inv_1_2.A sg13cmos5l_or2_1_0.A 0.00111f
C8701 a_1846_7850# a_1227_6935# 0
C8702 a_4566_2818# sg13cmos5l_buf_1_34.A 0.59289f
C8703 a_7796_6460# a_8439_6178# 0
C8704 sg13cmos5l_dfrbp_1_6.RESET_B a_18615_5770# 0.01631f
C8705 a_7216_6382# sg13cmos5l_dfrbp_1_11.Q 0
C8706 a_3308_5376# a_3302_4650# 0
C8707 sg13cmos5l_buf_1_73.X sg13cmos5l_inv_1_2.A 0
C8708 sg13cmos5l_buf_1_32.A nl_sw[2] 0
C8709 a_6660_4663# sg13cmos5l_dlhr_1_2.D 0
C8710 sg13cmos5l_o21ai_1_0.B1 a_12815_1703# 0
C8711 sg13cmos5l_buf_1_10.A a_10484_6924# 0
C8712 a_12998_3138# a_12976_2630# 0
C8713 a_12896_3270# a_12719_2749# 0
C8714 a_7994_7288# a_8208_6924# 0.01249f
C8715 sg13cmos5l_buf_1_35.A nh_sw[0] 0.0385f
C8716 sg13cmos5l_buf_1_103.A a_17367_8794# 0
C8717 sg13cmos5l_buf_1_101.X a_16724_8436# 0
C8718 sg13cmos5l_buf_1_93.X ph_sw[6] 0.01231f
C8719 a_17516_9150# a_17161_8794# 0
C8720 a_5452_5850# sg13cmos5l_inv_1_19.A 0
C8721 sg13cmos5l_or2_1_1.B a_14377_5770# 0
C8722 sg13cmos5l_buf_1_95.X a_13641_7674# 0
C8723 a_3856_3358# a_4018_3138# 0.0019f
C8724 a_8783_7751# a_8439_6178# 0
C8725 sg13cmos5l_buf_1_96.A a_10534_7687# 0
C8726 sg13cmos5l_dfrbp_1_0.CLK a_12625_2749# 0.00518f
C8727 sg13cmos5l_dlhr_1_15.D a_16677_6141# 0.03059f
C8728 a_3599_3215# a_4041_2745# 0.02105f
C8729 a_3856_3358# a_3860_2388# 0
C8730 sg13cmos5l_buf_1_5.A sg13cmos5l_o21ai_1_0.B1 0.59026f
C8731 sg13cmos5l_inv_1_8.A ph_sw[4] 0
C8732 sg13cmos5l_buf_1_41.A cks 0
C8733 a_12232_8436# cks 0.0076f
C8734 sg13cmos5l_inv_1_18.A sg13cmos5l_dfrbp_1_1.Q 0
C8735 sg13cmos5l_dlhr_1_16.Q sg13cmos5l_nand2_1_1.A 0.00207f
C8736 a_14228_9484# ph_sw[6] 0.0066f
C8737 a_1463_8511# a_1125_6935# 0
C8738 a_10783_3876# a_10464_2427# 0
C8739 sg13cmos5l_buf_1_34.X a_2934_4632# 0
C8740 sg13cmos5l_dfrbp_1_8.RESET_B a_3664_4142# 0.20352f
C8741 sg13cmos5l_dfrbp_1_6.RESET_B a_8296_3986# 0
C8742 sg13cmos5l_o21ai_1_0.A2 a_12075_1748# 0
C8743 sg13cmos5l_dfrbp_1_20.Q_N a_9189_8447# 0.03729f
C8744 sg13cmos5l_dlhr_1_11.GATE a_13392_7996# 0
C8745 a_9823_2364# a_9832_1664# 0
C8746 sg13cmos5l_inv_1_2.A a_12549_9165# 0.3593f
C8747 a_2340_3456# a_3599_3215# 0.01741f
C8748 sg13cmos5l_dfrbp_1_6.D sg13cmos5l_nand2_1_1.A 0
C8749 sg13cmos5l_buf_8_1.A VPWR 0.5949f
C8750 sg13cmos5l_dfrbp_1_16.Q a_6117_6141# 0
C8751 VPWR a_1484_9150# 0.25512f
C8752 a_14056_1664# nh_sw[6] 0.01065f
C8753 a_13593_9501# VPWR 0
C8754 sg13cmos5l_buf_1_4.A a_15492_2392# 0.03701f
C8755 sg13cmos5l_buf_1_24.A a_6219_6284# 0.02067f
C8756 sg13cmos5l_inv_1_11.Y a_10094_2780# 0.00823f
C8757 sg13cmos5l_buf_1_28.X a_9823_2780# 0.00101f
C8758 a_2748_6126# a_3669_6320# 0.43042f
C8759 sg13cmos5l_dlhr_1_15.D sg13cmos5l_nor2_1_0.A 0.135f
C8760 sg13cmos5l_inv_1_28.Y ph_sw[5] 0.04907f
C8761 sg13cmos5l_dfrbp_1_9.Q a_3793_2790# 0
C8762 sg13cmos5l_dlhr_1_9.D a_5452_5850# 0.00197f
C8763 sg13cmos5l_buf_1_3.A a_19130_6172# 0.02039f
C8764 sg13cmos5l_dfrbp_1_22.D a_17584_7166# 0.00214f
C8765 a_1997_6126# a_1873_5773# 0
C8766 a_902_3142# a_1290_3206# 0.00992f
C8767 a_8689_7751# VPWR 0
C8768 a_18960_5412# VPWR 0
C8769 sg13cmos5l_dlhr_1_1.GATE a_524_4614# 0
C8770 a_14900_2352# nh_sw[7] 0.00125f
C8771 a_14986_7897# a_15369_8065# 0.00337f
C8772 a_14536_7806# a_14726_7674# 0.00201f
C8773 sg13cmos5l_dlhr_1_14.Q_N a_14820_7674# 0
C8774 sg13cmos5l_buf_1_40.A a_1862_4338# 0
C8775 a_7336_9224# a_7504_8678# 0.00401f
C8776 a_15177_5769# sg13cmos5l_buf_1_2.A 0
C8777 sg13cmos5l_buf_1_4.A a_16572_4261# 0.00538f
C8778 sg13cmos5l_dfrbp_1_1.Q_N nl_sw[6] 0
C8779 sg13cmos5l_buf_1_28.X a_8588_2352# 0.00165f
C8780 sg13cmos5l_buf_1_29.A sg13cmos5l_a221oi_1_1.C1 0.06703f
C8781 sg13cmos5l_inv_1_8.A sg13cmos5l_buf_1_24.A 0.2719f
C8782 sg13cmos5l_buf_1_26.A a_6889_1680# 0
C8783 sg13cmos5l_buf_1_19.A a_17700_3456# 0.02915f
C8784 a_10665_7281# sg13cmos5l_a221oi_1_1.C1 0
C8785 sg13cmos5l_dfrbp_1_6.D a_3496_1758# 0
C8786 sg13cmos5l_dfrbp_1_11.Q a_5796_3904# 0.07713f
C8787 a_5951_5383# a_6213_3911# 0
C8788 sg13cmos5l_dlhr_1_0.Q VPWR 0.40446f
C8789 a_13076_5376# a_13072_4142# 0
C8790 sg13cmos5l_dfrbp_1_8.RESET_B sg13cmos5l_buf_1_59.A 0.00175f
C8791 sg13cmos5l_nand2_1_1.B a_11530_3868# 0
C8792 sg13cmos5l_buf_1_18.A a_19444_5800# 0.00242f
C8793 sg13cmos5l_buf_1_65.X a_3976_9224# 0.00913f
C8794 sg13cmos5l_buf_1_30.A sg13cmos5l_dlhr_1_2.Q 0.38897f
C8795 sg13cmos5l_o21ai_1_0.A1 sg13cmos5l_dfrbp_1_0.RESET_B 0.3528f
C8796 a_14152_5498# VPWR 0.13694f
C8797 sg13cmos5l_inv_1_0.A a_10783_3876# 0.07484f
C8798 sg13cmos5l_dfrbp_1_6.RESET_B a_6647_5459# 0
C8799 sg13cmos5l_buf_1_6.A nl_sw[6] 0.00775f
C8800 sg13cmos5l_dfrbp_1_21.Q a_14996_5412# 0.01108f
C8801 sg13cmos5l_inv_1_6.A a_18368_4782# 0
C8802 a_8593_5814# a_8660_5412# 0.0018f
C8803 a_11530_1849# nl_sw[6] 0.03479f
C8804 sg13cmos5l_nor2_1_2.A a_2122_3868# 0
C8805 a_10789_4654# sg13cmos5l_a22oi_1_0.Y 0
C8806 sg13cmos5l_dfrbp_1_16.Q_N a_1997_6126# 0
C8807 a_9256_9224# sg13cmos5l_dfrbp_1_18.Q 0.0024f
C8808 a_3692_9150# sg13cmos5l_dlhr_1_9.Q 0
C8809 sg13cmos5l_nand2_1_1.A a_17926_3151# 0
C8810 sg13cmos5l_dlhr_1_5.GATE a_3530_6320# 0
C8811 sg13cmos5l_inv_1_18.A a_9366_5842# 0.05214f
C8812 a_8746_8404# a_9189_8447# 0.02241f
C8813 sg13cmos5l_a22oi_1_1.A1 a_19616_3986# 0.01271f
C8814 a_10473_9186# a_10827_7796# 0
C8815 sg13cmos5l_dfrbp_1_6.RESET_B a_10308_7992# 0.53305f
C8816 sg13cmos5l_nor2_1_1.A sg13cmos5l_dfrbp_1_0.Q 0.78285f
C8817 sg13cmos5l_inv_1_0.A a_11556_3904# 0.01323f
C8818 sg13cmos5l_a22oi_1_2.B1 nh_sw[5] 0
C8819 a_1864_1664# VPWR 0.26549f
C8820 sg13cmos5l_buf_1_35.A a_1760_1758# 0.05983f
C8821 sg13cmos5l_buf_1_2.X cks 0.03315f
C8822 a_3688_1664# nl_sw[2] 0.00578f
C8823 a_2934_4632# sg13cmos5l_dlhr_1_1.Q_N 0.12876f
C8824 sg13cmos5l_buf_1_77.A a_8852_6484# 0.03048f
C8825 sg13cmos5l_inv_1_27.Y a_15782_7362# 0
C8826 sg13cmos5l_buf_1_34.X a_4436_3436# 0.00808f
C8827 a_7055_4261# VPWR 0.26326f
C8828 a_8972_9150# ph_sw[4] 0.00777f
C8829 sg13cmos5l_inv_1_18.A a_9448_6924# 0.02937f
C8830 sg13cmos5l_buf_8_1.A a_16551_3987# 0.02514f
C8831 a_17041_4727# a_16703_3871# 0.00116f
C8832 a_14342_8874# pl_sw[6] 0
C8833 sg13cmos5l_buf_1_40.A a_682_5380# 0.00682f
C8834 a_2621_7636# a_2804_6924# 0.00661f
C8835 a_2831_7630# a_1967_7285# 0.00759f
C8836 a_1480_7806# a_1227_6935# 0
C8837 a_7796_6460# sg13cmos5l_buf_1_56.A 0
C8838 sg13cmos5l_dlhr_1_6.D a_8570_6172# 0.01602f
C8839 sg13cmos5l_nor2_1_0.A sg13cmos5l_o21ai_1_0.A2 0.09436f
C8840 a_2596_7996# a_2786_7666# 0.00284f
C8841 a_2621_7636# a_2583_7710# 0
C8842 a_10308_7992# a_10071_7282# 0.01012f
C8843 sg13cmos5l_dfrbp_1_6.RESET_B a_19209_5769# 0.44987f
C8844 sg13cmos5l_dlhr_1_5.Q a_8439_6178# 0.00671f
C8845 a_8982_7354# a_9033_6162# 0
C8846 a_8457_7281# a_8852_6484# 0
C8847 ph_sw[1] sg13cmos5l_buf_1_62.X 0.05409f
C8848 a_5951_5383# sg13cmos5l_inv_1_19.A 0
C8849 sg13cmos5l_o21ai_1_0.B1 a_14814_4292# 0
C8850 a_1000_9224# sg13cmos5l_buf_1_62.X 0
C8851 a_6184_9224# ph_sw[4] 0
C8852 sg13cmos5l_dfrbp_1_8.RESET_B a_5988_8440# 0.53014f
C8853 sg13cmos5l_or2_1_1.B a_14996_5412# 0
C8854 sg13cmos5l_a221oi_1_0.B1 a_11873_5760# 0
C8855 a_9620_7972# a_9558_6144# 0
C8856 a_8689_7751# a_8233_6216# 0
C8857 a_8783_7751# sg13cmos5l_buf_1_56.A 0
C8858 sg13cmos5l_dlhr_1_10.Q_N frame 0
C8859 sg13cmos5l_buf_1_41.A a_2565_3911# 0.02829f
C8860 sg13cmos5l_dfrbp_1_6.RESET_B a_8392_3270# 0.00445f
C8861 VPWR cko 0.1209f
C8862 sg13cmos5l_inv_1_8.A a_1463_8511# 0
C8863 a_13810_9186# sg13cmos5l_buf_1_98.A 0
C8864 nh_sw[8] nl_sw[9] 0.0977f
C8865 nh_sw[0] nh_sw[1] 0.00427f
C8866 sg13cmos5l_dlhr_1_15.D a_17721_6477# 0.00107f
C8867 sg13cmos5l_buf_1_57.X a_8982_7354# 0
C8868 sg13cmos5l_dfrbp_1_10.Q_N a_4041_2745# 0
C8869 sg13cmos5l_inv_1_8.A a_3588_4968# 0.1206f
C8870 sg13cmos5l_buf_1_10.A a_13017_4023# 0.00107f
C8871 sg13cmos5l_buf_1_41.X a_3241_2746# 0.00478f
C8872 a_2248_9224# a_2148_8440# 0.00636f
C8873 sg13cmos5l_buf_1_65.X sg13cmos5l_dfrbp_1_17.D 0.00169f
C8874 sg13cmos5l_dfrbp_1_8.RESET_B a_5132_3864# 0
C8875 sg13cmos5l_buf_1_34.X sg13cmos5l_dfrbp_1_9.Q 0.32163f
C8876 sg13cmos5l_inv_1_17.A a_3945_5041# 0.00114f
C8877 a_12520_3176# a_11460_2392# 0
C8878 a_11174_2826# a_11530_1849# 0
C8879 sg13cmos5l_inv_1_2.A sg13cmos5l_inv_1_27.Y 0.03213f
C8880 sg13cmos5l_buf_1_40.A a_908_1590# 0.00271f
C8881 sg13cmos5l_dlhr_1_11.Q sg13cmos5l_buf_1_98.A 0.28802f
C8882 a_2340_3456# sg13cmos5l_dfrbp_1_10.Q_N 0.0204f
C8883 a_2757_3117# a_3505_3215# 0.01058f
C8884 a_3599_3215# a_4436_3436# 0.1333f
C8885 sg13cmos5l_inv_1_29.A VPWR 0.83964f
C8886 sg13cmos5l_dfrbp_1_8.RESET_B a_2122_3868# 0.34273f
C8887 sg13cmos5l_nand2_1_0.A a_14900_2352# 0.28373f
C8888 sg13cmos5l_dlhr_1_6.D sg13cmos5l_and3_1_0.C 0.00825f
C8889 sg13cmos5l_inv_1_14.A sg13cmos5l_buf_1_26.X 0
C8890 sg13cmos5l_buf_1_4.A a_16011_2399# 0.01945f
C8891 sg13cmos5l_dlhr_1_9.D a_8439_6178# 0
C8892 sg13cmos5l_buf_1_24.A a_5988_6175# 0
C8893 a_14708_6924# a_14612_6460# 0
C8894 a_422_5850# sg13cmos5l_or2_1_0.A 0
C8895 a_2224_7166# sg13cmos5l_inv_1_19.A 0
C8896 sg13cmos5l_buf_1_40.A ckc 0
C8897 sg13cmos5l_dfrbp_1_22.D sg13cmos5l_dfrbp_1_8.D 0
C8898 sg13cmos5l_a22oi_1_2.B1 a_9823_2780# 0.00278f
C8899 sg13cmos5l_buf_1_3.A sg13cmos5l_dlhr_1_10.Q_N 0
C8900 sg13cmos5l_dlhr_1_9.D a_5951_5383# 0.00463f
C8901 a_2748_6126# a_3308_5376# 0
C8902 sg13cmos5l_dfrbp_1_6.D sg13cmos5l_dfrbp_1_0.D 0.74742f
C8903 sg13cmos5l_buf_1_65.X ph_sw[0] 0.0131f
C8904 sg13cmos5l_a22oi_1_1.B2 a_14800_3358# 0.00102f
C8905 a_11877_2399# VPWR 0.27072f
C8906 a_14726_7674# a_16271_7751# 0
C8907 a_12216_5728# sg13cmos5l_a221oi_1_1.C1 0
C8908 sg13cmos5l_buf_1_4.A a_16703_3871# 0
C8909 sg13cmos5l_nand2_1_1.B a_12022_3134# 0.00228f
C8910 a_11270_4338# a_11372_3102# 0
C8911 sg13cmos5l_inv_1_3.A sg13cmos5l_dfrbp_1_0.CLK 0
C8912 a_1862_8874# a_2436_8861# 0.36169f
C8913 a_2122_8404# a_2565_8447# 0.02241f
C8914 sg13cmos5l_buf_1_26.A a_9448_1664# 0.00164f
C8915 sg13cmos5l_buf_1_5.A a_14714_5776# 0.0021f
C8916 sg13cmos5l_dfrbp_1_11.Q a_7055_4261# 0.04221f
C8917 a_11360_9318# a_10827_7796# 0
C8918 sg13cmos5l_dfrbp_1_9.Q a_3599_3215# 0.02213f
C8919 sg13cmos5l_nand2_1_1.A nh_sw[9] 0
C8920 sg13cmos5l_inv_1_17.A a_2380_6162# 0
C8921 a_20008_8436# pl_sw[9] 0
C8922 a_934_5837# VPWR 0
C8923 sg13cmos5l_buf_1_31.X a_1580_2352# 0.02772f
C8924 sg13cmos5l_dlhr_1_9.Q a_4514_7666# 0
C8925 sg13cmos5l_dlhr_1_19.Q_N VPWR 0.25203f
C8926 sg13cmos5l_buf_1_110.A a_14377_5770# 0
C8927 sg13cmos5l_dfrbp_1_18.Q a_10473_9186# 0.00133f
C8928 a_12132_9504# a_13100_8400# 0
C8929 a_12549_9165# a_12716_8400# 0.01066f
C8930 a_5416_9224# sg13cmos5l_dfrbp_1_8.RESET_B 0.00287f
C8931 sg13cmos5l_buf_1_30.A a_8588_2352# 0.0239f
C8932 sg13cmos5l_nor2_1_2.A a_1290_3206# 0.04773f
C8933 sg13cmos5l_buf_1_57.X sg13cmos5l_buf_1_4.A 0.36867f
C8934 a_8660_5412# sg13cmos5l_buf_1_45.A 0
C8935 a_8841_5769# a_9076_5800# 0.00566f
C8936 sg13cmos5l_dfrbp_1_21.Q a_18409_5770# 0.14623f
C8937 a_12815_1703# nl_sw[6] 0
C8938 a_7226_1636# nh_sw[3] 0
C8939 sg13cmos5l_buf_1_87.A sg13cmos5l_buf_1_19.A 0.33426f
C8940 sg13cmos5l_dfrbp_1_16.Q_N a_2638_6477# 0
C8941 sg13cmos5l_inv_1_29.A a_12698_7288# 0.00274f
C8942 sg13cmos5l_dfrbp_1_16.Q sg13cmos5l_dlhr_1_20.Q_N 0.00253f
C8943 sg13cmos5l_dfrbp_1_6.RESET_B sg13cmos5l_nor2_1_1.A 0
C8944 sg13cmos5l_dlhr_1_5.GATE a_5414_6162# 0.04153f
C8945 a_7034_3148# a_7226_1636# 0
C8946 a_7316_3460# a_7095_1642# 0
C8947 a_8998_8861# a_9060_8861# 0
C8948 a_9189_8447# a_10288_8678# 0
C8949 a_8772_8440# a_10031_8797# 0.01741f
C8950 sg13cmos5l_dfrbp_1_23.CLK a_12980_6924# 0.00448f
C8951 sg13cmos5l_a221oi_1_0.B1 sg13cmos5l_buf_1_9.A 0
C8952 sg13cmos5l_dfrbp_1_6.RESET_B a_11824_7894# 0.18389f
C8953 sg13cmos5l_buf_1_5.A a_14194_6162# 0
C8954 sg13cmos5l_dlhr_1_6.D sg13cmos5l_nor2_1_0.A 0.00573f
C8955 a_19130_6172# a_19593_6162# 0.13395f
C8956 a_18793_6216# a_19412_6484# 0.00161f
C8957 sg13cmos5l_dfrbp_1_18.Q a_8390_6924# 0
C8958 a_17916_8838# cks 0
C8959 sg13cmos5l_dfrbp_1_17.D pl_sw[1] 0
C8960 sg13cmos5l_nor2b_1_0.Y a_13036_4948# 0.01315f
C8961 sg13cmos5l_buf_1_101.X frame 0
C8962 sg13cmos5l_nor2_1_2.A a_1402_3864# 0.00271f
C8963 sg13cmos5l_dlhr_1_1.Q_N sg13cmos5l_dfrbp_1_9.Q 0.07591f
C8964 sg13cmos5l_buf_1_3.A sg13cmos5l_buf_1_19.A 0
C8965 sg13cmos5l_dfrbp_1_0.D a_17926_3151# 0
C8966 a_7257_4023# VPWR 0
C8967 sg13cmos5l_buf_1_107.X sg13cmos5l_buf_1_87.A 0.0193f
C8968 sg13cmos5l_dfrbp_1_6.RESET_B a_15045_8447# 0.01611f
C8969 sg13cmos5l_nand2_1_2.B a_2148_3904# 0
C8970 sg13cmos5l_dlhr_1_5.GATE a_7238_7674# 0
C8971 sg13cmos5l_or2_1_0.A a_19616_3986# 0.00381f
C8972 sg13cmos5l_dfrbp_1_22.D a_17780_8436# 0.00404f
C8973 sg13cmos5l_buf_1_58.A a_2386_7362# 0
C8974 a_1760_1758# nh_sw[1] 0
C8975 a_18376_9224# pl_sw[9] 0.00132f
C8976 sg13cmos5l_dfrbp_1_8.RESET_B a_12132_9504# 0.49692f
C8977 a_12106_9409# a_12549_9165# 0.02241f
C8978 a_10998_9168# sg13cmos5l_buf_1_95.X 0
C8979 a_10827_7796# a_10665_7281# 0
C8980 a_10725_7653# a_11190_7354# 0
C8981 sg13cmos5l_dlhr_1_5.Q sg13cmos5l_buf_1_56.A 0.87755f
C8982 a_4566_2818# nl_sw[3] 0
C8983 sg13cmos5l_nand2_1_1.A a_14962_3138# 0
C8984 sg13cmos5l_buf_1_10.A a_13161_7281# 0
C8985 a_14543_3215# sg13cmos5l_nor2_1_1.A 0.00931f
C8986 sg13cmos5l_inv_1_17.A sg13cmos5l_dlhr_1_5.GATE 0
C8987 sg13cmos5l_buf_1_41.A a_2314_3361# 0.00286f
C8988 sg13cmos5l_buf_1_111.A sg13cmos5l_buf_1_104.A 0.37632f
C8989 sg13cmos5l_dfrbp_1_8.RESET_B a_7504_8678# 0.18845f
C8990 sg13cmos5l_buf_1_101.X sg13cmos5l_buf_1_87.A 0.00956f
C8991 sg13cmos5l_dfrbp_1_6.RESET_B a_3488_7010# 0
C8992 sg13cmos5l_dfrbp_1_20.Q sg13cmos5l_buf_1_56.A 0.01197f
C8993 a_5069_5376# a_5710_5535# 0.00675f
C8994 a_5820_5773# a_6741_5459# 0.43042f
C8995 sg13cmos5l_buf_1_94.X pl_sw[8] 1.79913f
C8996 sg13cmos5l_a221oi_1_0.B1 a_10587_4692# 0
C8997 pl_sw[2] sg13cmos5l_inv_1_19.A 0
C8998 a_3574_7850# a_3676_7964# 0.13715f
C8999 sg13cmos5l_buf_1_44.A sg13cmos5l_buf_1_24.X 0.00216f
C9000 sg13cmos5l_inv_1_8.A a_3396_4650# 0
C9001 sg13cmos5l_dfrbp_1_23.Q a_14714_5776# 0
C9002 sg13cmos5l_dfrbp_1_8.RESET_B a_3241_2746# 0
C9003 ph_sw[0] pl_sw[1] 0.33739f
C9004 sg13cmos5l_dfrbp_1_23.CLK sg13cmos5l_buf_1_57.X 0.33116f
C9005 sg13cmos5l_inv_1_20.Y a_3664_8678# 0.00277f
C9006 sg13cmos5l_a221oi_1_0.C1 a_11182_4948# 0.00518f
C9007 a_15782_7362# a_16068_6928# 0.50066f
C9008 sg13cmos5l_buf_1_4.A a_16779_6284# 0
C9009 sg13cmos5l_dfrbp_1_0.CLK cks 0
C9010 sg13cmos5l_buf_1_101.X sg13cmos5l_buf_1_3.A 0
C9011 sg13cmos5l_buf_1_93.X sg13cmos5l_buf_1_107.X 0.0021f
C9012 sg13cmos5l_buf_1_73.X ph_sw[2] 0
C9013 sg13cmos5l_nand2_1_2.B sg13cmos5l_or2_1_0.A 0.17852f
C9014 a_11877_2399# a_11973_1605# 0.01142f
C9015 sg13cmos5l_dfrbp_1_1.Q a_14900_2352# 0
C9016 sg13cmos5l_dfrbp_1_6.D a_7378_6162# 0
C9017 sg13cmos5l_dfrbp_1_8.RESET_B a_6891_4772# 0.59715f
C9018 a_14632_9224# pl_sw[8] 0
C9019 a_13297_9263# sg13cmos5l_buf_1_5.A 0
C9020 sg13cmos5l_dfrbp_1_6.RESET_B nh_sw[3] 0.00143f
C9021 sg13cmos5l_a221oi_1_0.A2 a_11488_4676# 0
C9022 sg13cmos5l_inv_1_14.A a_5414_6162# 0
C9023 sg13cmos5l_dfrbp_1_0.RESET_B sg13cmos5l_nor2b_1_1.Y 0.12476f
C9024 sg13cmos5l_or2_1_1.B sg13cmos5l_a22oi_1_0.Y 0
C9025 a_2628_3151# a_2566_3151# 0
C9026 a_4436_3436# sg13cmos5l_dfrbp_1_10.Q_N 0.25469f
C9027 sg13cmos5l_dfrbp_1_6.RESET_B a_7034_3148# 0.00576f
C9028 a_1463_8511# a_708_6928# 0
C9029 sg13cmos5l_buf_1_41.A a_2409_4650# 0.00291f
C9030 sg13cmos5l_inv_1_2.A a_9291_8447# 0.01141f
C9031 sg13cmos5l_buf_1_103.A a_17896_9224# 0.00102f
C9032 sg13cmos5l_buf_1_93.X sg13cmos5l_buf_1_101.X 0.2807f
C9033 sg13cmos5l_dlhr_1_9.D sg13cmos5l_buf_1_56.A 0
C9034 sg13cmos5l_buf_1_89.A a_14612_6460# 0.00368f
C9035 sg13cmos5l_dfrbp_1_23.Q a_14194_6162# 0.00167f
C9036 sg13cmos5l_inv_1_1.A a_15045_8447# 0
C9037 a_6741_5459# VPWR 0.09571f
C9038 sg13cmos5l_o21ai_1_0.A2 sg13cmos5l_o21ai_1_0.Y 0.05178f
C9039 a_20296_1664# nh_sw[10] 0
C9040 sg13cmos5l_or2_1_0.A a_11530_3868# 0.00247f
C9041 sg13cmos5l_buf_1_57.X a_15132_5814# 0
C9042 a_2224_5654# a_1873_5773# 0.01017f
C9043 a_12976_2630# VPWR 0.14927f
C9044 sg13cmos5l_dfrbp_1_6.RESET_B sg13cmos5l_inv_1_0.A 0
C9045 sg13cmos5l_dfrbp_1_8.RESET_B a_1402_3864# 0
C9046 sg13cmos5l_inv_1_18.A sg13cmos5l_a22oi_1_0.B1 0
C9047 a_15012_7992# a_16177_7751# 0.4858f
C9048 a_15531_7796# a_15300_7687# 0.15089f
C9049 a_16271_7751# a_16528_7894# 0.35645f
C9050 sg13cmos5l_inv_1_1.A a_17132_9150# 0
C9051 a_15784_9224# sg13cmos5l_buf_1_94.X 0.01051f
C9052 sg13cmos5l_buf_1_73.A a_7449_8559# 0.00153f
C9053 sg13cmos5l_nand2_1_1.B a_13092_3138# 0
C9054 a_10022_7674# VPWR 0.92821f
C9055 sg13cmos5l_buf_1_31.X a_3212_1590# 0
C9056 a_1862_8874# a_2505_8483# 0.00806f
C9057 a_2436_8861# a_2667_8447# 0.15089f
C9058 a_2565_8447# a_3407_8797# 0.0032f
C9059 sg13cmos5l_inv_1_11.Y sg13cmos5l_buf_1_9.A 0.00122f
C9060 sg13cmos5l_inv_1_8.A a_3575_6553# 0
C9061 sg13cmos5l_inv_1_2.A a_16068_6928# 0.09076f
C9062 sg13cmos5l_buf_1_5.A a_15177_5769# 0
C9063 sg13cmos5l_dfrbp_1_11.Q a_7257_4023# 0
C9064 sg13cmos5l_buf_1_78.X a_6405_8447# 0.01427f
C9065 a_11464_8436# sg13cmos5l_inv_1_7.A 0.2887f
C9066 sg13cmos5l_dfrbp_1_0.RESET_B a_11656_3176# 0.04752f
C9067 sg13cmos5l_inv_1_26.Y sg13cmos5l_dlhr_1_10.Q 0.06186f
C9068 sg13cmos5l_dfrbp_1_9.Q sg13cmos5l_dfrbp_1_10.Q_N 0.76427f
C9069 sg13cmos5l_dfrbp_1_22.D a_16690_7674# 0
C9070 sg13cmos5l_dfrbp_1_8.RESET_B a_1609_4704# 0.01225f
C9071 sg13cmos5l_nor2b_1_0.Y a_13017_4023# 0
C9072 sg13cmos5l_dfrbp_1_6.RESET_B a_3664_4142# 0
C9073 a_15016_9224# sg13cmos5l_buf_1_95.X 0.01033f
C9074 sg13cmos5l_dfrbp_1_6.RESET_B a_12490_6385# 0.33955f
C9075 sg13cmos5l_buf_1_34.X sg13cmos5l_buf_1_41.A 0
C9076 a_19028_5412# VPWR 0.10719f
C9077 sg13cmos5l_buf_1_110.A a_14996_5412# 0
C9078 sg13cmos5l_buf_1_90.X a_14152_8522# 0
C9079 a_13648_9406# a_13484_8400# 0
C9080 a_13391_9263# a_13768_8436# 0.00624f
C9081 sg13cmos5l_dfrbp_1_10.Q a_10331_3900# 0.06328f
C9082 sg13cmos5l_dfrbp_1_21.Q a_19734_5842# 0
C9083 sg13cmos5l_dfrbp_1_0.D nh_sw[9] 0
C9084 sg13cmos5l_buf_1_77.X a_5988_8440# 0
C9085 sg13cmos5l_dlhr_1_5.GATE a_7216_6382# 0.01683f
C9086 sg13cmos5l_dlhr_1_1.GATE a_3831_7282# 0.00527f
C9087 sg13cmos5l_a22oi_1_1.B1 sg13cmos5l_dfrbp_1_0.RESET_B 0.03854f
C9088 a_7732_3124# VPWR 0
C9089 sg13cmos5l_buf_1_31.X sg13cmos5l_a221oi_1_0.C1 0
C9090 sg13cmos5l_dfrbp_1_6.D a_5324_1590# 0
C9091 sg13cmos5l_nor2b_1_0.Y a_11002_3142# 0
C9092 sg13cmos5l_dfrbp_1_8.RESET_B sg13cmos5l_buf_1_93.X 0
C9093 a_9291_8447# a_9937_8797# 0.00667f
C9094 sg13cmos5l_dfrbp_1_18.Q sg13cmos5l_buf_1_29.A 0
C9095 sg13cmos5l_dlhr_1_5.GATE a_7336_7010# 0
C9096 sg13cmos5l_dfrbp_1_23.CLK a_14089_7282# 0.05967f
C9097 sg13cmos5l_nor2b_1_0.Y a_10696_1758# 0.05931f
C9098 sg13cmos5l_buf_1_40.A sg13cmos5l_dlygate4sd2_1_0.A 0.08011f
C9099 a_19130_6172# a_19345_6154# 0.00284f
C9100 a_19593_6162# sg13cmos5l_dlhr_1_10.Q_N 0.00294f
C9101 a_10473_9186# cks 0
C9102 sg13cmos5l_dfrbp_1_18.Q a_10665_7281# 0
C9103 a_17700_3456# sg13cmos5l_dfrbp_1_0.Q 0
C9104 sg13cmos5l_dfrbp_1_1.Q nl_sw[10] 0.03029f
C9105 a_620_7638# a_616_9224# 0
C9106 a_20488_5498# d_out[2] 0.00302f
C9107 sg13cmos5l_nor2_1_1.A a_15206_2826# 0.03267f
C9108 sg13cmos5l_a22oi_1_1.B2 VPWR 0.55096f
C9109 sg13cmos5l_inv_1_29.A a_13047_7690# 0.01339f
C9110 a_9638_5088# VPWR 0.00418f
C9111 a_5700_6480# sg13cmos5l_dlhr_1_0.GATE 0
C9112 sg13cmos5l_buf_1_90.X a_14632_9224# 0
C9113 a_2621_7636# a_2727_6380# 0
C9114 sg13cmos5l_inv_1_1.A sg13cmos5l_inv_1_0.A 0
C9115 sg13cmos5l_buf_8_0.X a_20118_6144# 0.00618f
C9116 a_10827_7796# a_11560_7010# 0.00339f
C9117 a_3692_9150# a_3676_7964# 0.00101f
C9118 sg13cmos5l_inv_1_17.A a_3574_7850# 0.0525f
C9119 sg13cmos5l_nor2_1_0.A a_11460_2392# 0
C9120 sg13cmos5l_dfrbp_1_23.CLK a_13178_7684# 0
C9121 sg13cmos5l_dfrbp_1_24.Q_N a_13641_7674# 0
C9122 a_4107_4772# sg13cmos5l_inv_1_19.A 0
C9123 sg13cmos5l_nand2_1_1.A a_17508_3138# 0
C9124 sg13cmos5l_dfrbp_1_6.D a_18345_7674# 0
C9125 a_15793_8797# pl_sw[8] 0
C9126 sg13cmos5l_buf_1_30.A a_7537_4727# 0.00157f
C9127 sg13cmos5l_buf_1_111.A pl_sw[10] 0
C9128 sg13cmos5l_inv_1_0.A a_11182_4676# 0
C9129 sg13cmos5l_buf_1_41.A a_3599_3215# 0
C9130 sg13cmos5l_buf_1_73.A sg13cmos5l_inv_1_2.A 0
C9131 sg13cmos5l_nand2_1_2.B sg13cmos5l_dlygate4sd2_1_0.X 0
C9132 sg13cmos5l_dfrbp_1_8.RESET_B a_8486_8874# 0.10037f
C9133 sg13cmos5l_dfrbp_1_6.RESET_B sg13cmos5l_buf_1_59.A 0.02522f
C9134 a_2732_1590# sg13cmos5l_buf_1_39.A 0
C9135 sg13cmos5l_buf_1_33.A a_4172_1590# 0.29968f
C9136 sg13cmos5l_dfrbp_1_11.Q a_6741_5459# 0
C9137 a_5951_5383# a_6647_5459# 0.02453f
C9138 a_5799_5499# a_5710_5535# 0
C9139 a_4324_7996# a_4559_7630# 0.64635f
C9140 sg13cmos5l_inv_1_27.Y a_14889_7281# 0.00118f
C9141 sg13cmos5l_inv_1_8.A a_4753_4727# 0.00427f
C9142 a_12804_6175# VPWR 0.00674f
C9143 sg13cmos5l_dfrbp_1_0.CLK a_18219_3260# 0.01611f
C9144 sg13cmos5l_dlhr_1_15.D a_17529_7047# 0.00193f
C9145 sg13cmos5l_inv_1_20.Y sg13cmos5l_dfrbp_1_15.D 0.30358f
C9146 a_16068_6928# a_16294_7349# 0.00523f
C9147 a_16042_6892# a_16356_7349# 0.00659f
C9148 a_7336_9224# a_7820_9150# 0.03472f
C9149 sg13cmos5l_buf_1_4.A a_16548_6175# 0.00235f
C9150 a_13681_6239# sg13cmos5l_dfrbp_1_21.Q 0
C9151 sg13cmos5l_buf_1_73.X sg13cmos5l_buf_1_78.X 0.02966f
C9152 sg13cmos5l_buf_1_40.X nl_sw[2] 0
C9153 sg13cmos5l_buf_1_79.X sg13cmos5l_inv_1_7.A 0.01269f
C9154 sg13cmos5l_dfrbp_1_8.RESET_B a_7833_4965# 0.00343f
C9155 sg13cmos5l_buf_1_7.A a_13072_1846# 0
C9156 a_11979_2399# a_12075_1748# 0.00219f
C9157 sg13cmos5l_buf_1_6.A a_12625_2749# 0.00479f
C9158 sg13cmos5l_inv_1_18.A a_9040_7894# 0.0291f
C9159 sg13cmos5l_buf_1_94.X a_17161_8794# 0
C9160 sg13cmos5l_inv_1_14.A a_7216_6382# 0
C9161 sg13cmos5l_dfrbp_1_6.D a_10416_6924# 0
C9162 sg13cmos5l_buf_1_19.A a_19593_6162# 0
C9163 sg13cmos5l_dfrbp_1_6.RESET_B a_6560_3270# 0
C9164 sg13cmos5l_buf_1_76.X a_7336_9224# 0
C9165 sg13cmos5l_dlhr_1_1.GATE a_1760_3986# 0.06897f
C9166 sg13cmos5l_buf_1_41.A sg13cmos5l_dlhr_1_1.Q_N 0.03315f
C9167 sg13cmos5l_inv_1_2.A sg13cmos5l_dfrbp_1_27.Q_N 0
C9168 sg13cmos5l_inv_1_8.A sg13cmos5l_buf_1_31.X 0.0124f
C9169 sg13cmos5l_inv_1_18.A sg13cmos5l_buf_1_25.A 0.03817f
C9170 sg13cmos5l_dlhr_1_9.D a_4107_4772# 0.0076f
C9171 a_5674_6385# a_6117_6141# 0.02241f
C9172 a_5312_6294# a_5414_6162# 0
C9173 a_15784_9224# a_15793_8797# 0
C9174 sg13cmos5l_inv_1_1.A a_16724_8436# 0.00275f
C9175 sg13cmos5l_a221oi_1_0.A2 VPWR 0.59023f
C9176 a_6276_8861# pl_sw[3] 0.01346f
C9177 a_20672_1758# nh_sw[10] 0.00493f
C9178 a_2879_6432# sg13cmos5l_inv_1_19.A 0.00564f
C9179 sg13cmos5l_buf_1_79.X a_9189_8447# 0.00716f
C9180 sg13cmos5l_dfrbp_1_8.RESET_B a_1862_8874# 0.1044f
C9181 sg13cmos5l_dfrbp_1_6.RESET_B a_9242_4660# 0.01971f
C9182 a_14254_2444# VPWR 0.21707f
C9183 a_14996_5412# sg13cmos5l_a22oi_1_1.Y 0
C9184 a_16528_7894# sg13cmos5l_dlhr_1_15.D 0
C9185 sg13cmos5l_a22oi_1_2.B2 nl_sw[5] 0.17029f
C9186 sg13cmos5l_dfrbp_1_6.D sg13cmos5l_dfrbp_1_29.Q_N 0.01568f
C9187 a_18865_3215# sg13cmos5l_buf_1_19.X 0.00204f
C9188 sg13cmos5l_inv_1_7.A a_12815_4261# 0
C9189 a_13161_7281# sg13cmos5l_nor2b_1_0.Y 0
C9190 a_8772_8440# pl_sw[5] 0
C9191 a_11567_7751# VPWR 0.27222f
C9192 a_13681_6239# sg13cmos5l_or2_1_1.B 0
C9193 a_10412_6126# a_10420_5412# 0
C9194 a_3664_8678# a_3826_8874# 0.0019f
C9195 a_3407_8797# a_3313_8797# 0.32273f
C9196 a_4847_4727# a_5408_3986# 0.0029f
C9197 sg13cmos5l_nand2_1_1.B a_15062_4292# 0
C9198 sg13cmos5l_inv_1_2.A a_17584_7166# 0
C9199 a_10071_7282# a_10420_5412# 0
C9200 sg13cmos5l_buf_1_96.A sg13cmos5l_inv_1_7.A 0.06149f
C9201 sg13cmos5l_inv_1_8.A a_2804_5412# 0.00908f
C9202 sg13cmos5l_buf_1_28.X sg13cmos5l_a22oi_1_2.B1 0.02584f
C9203 sg13cmos5l_inv_1_11.Y sg13cmos5l_dfrbp_1_1.D 0.35522f
C9204 sg13cmos5l_dfrbp_1_16.Q a_7863_7282# 0
C9205 a_11360_9318# cks 0
C9206 a_14628_8440# VPWR 0.07327f
C9207 frame ph_sw[10] 0.16712f
C9208 sg13cmos5l_buf_8_2.X sg13cmos5l_dlhr_1_15.Q 0
C9209 sg13cmos5l_buf_1_24.A a_7657_7282# 0
C9210 sg13cmos5l_dfrbp_1_6.RESET_B a_5132_3864# 0.00186f
C9211 sg13cmos5l_dfrbp_1_6.RESET_B a_13775_6239# 0.20099f
C9212 a_10427_2736# VPWR 0
C9213 sg13cmos5l_nand2_1_0.A a_11268_2826# 0
C9214 sg13cmos5l_buf_1_30.A sg13cmos5l_buf_1_28.X 0.00302f
C9215 a_1878_6337# a_1125_5423# 0.00528f
C9216 sg13cmos5l_buf_1_77.X a_7504_8678# 0
C9217 a_1662_8374# a_1862_8874# 0.00835f
C9218 a_2169_7047# VPWR 0
C9219 sg13cmos5l_dlhr_1_1.GATE a_4425_7281# 0.04344f
C9220 a_5739_2399# a_6681_2511# 0
C9221 sg13cmos5l_dfrbp_1_6.RESET_B a_2122_3868# 0.02501f
C9222 sg13cmos5l_dfrbp_1_16.Q_N sg13cmos5l_dlhr_1_1.D 0
C9223 sg13cmos5l_dfrbp_1_6.RESET_B a_17700_3456# 0.00109f
C9224 sg13cmos5l_buf_1_10.A sg13cmos5l_nand2_1_0.A 0
C9225 a_10868_8436# a_11464_8436# 0.00307f
C9226 a_11464_9224# a_10827_7796# 0
C9227 sg13cmos5l_dlhr_1_9.D a_2879_6432# 0
C9228 a_7316_2388# a_7226_1636# 0
C9229 sg13cmos5l_buf_1_34.X a_6188_1590# 0
C9230 a_17916_8838# pl_sw[9] 0.00139f
C9231 sg13cmos5l_dfrbp_1_2.D a_11530_3868# 0
C9232 sg13cmos5l_inv_1_14.A a_5796_3904# 0.04318f
C9233 sg13cmos5l_buf_1_65.X sg13cmos5l_buf_1_64.A 1.31841f
C9234 a_3692_9150# sg13cmos5l_inv_1_17.A 0.34023f
C9235 sg13cmos5l_dfrbp_1_6.D nh_sw[2] 0
C9236 a_4076_7624# a_4311_7710# 0.00404f
C9237 a_682_6892# a_1065_6971# 0.00337f
C9238 sg13cmos5l_nor2_1_1.A a_14858_2388# 0
C9239 sg13cmos5l_inv_1_8.A a_4349_7636# 0
C9240 a_17961_8793# ph_sw[8] 0
C9241 sg13cmos5l_buf_1_57.X a_15592_6200# 0.04124f
C9242 sg13cmos5l_inv_1_7.A sg13cmos5l_a221oi_1_0.B1 0
C9243 a_17519_6239# a_18409_5770# 0
C9244 sg13cmos5l_dfrbp_1_16.Q sg13cmos5l_a22oi_1_0.Y 0
C9245 sg13cmos5l_buf_1_3.A ph_sw[10] 0.379f
C9246 sg13cmos5l_and3_1_0.X a_13324_4696# 0.18685f
C9247 sg13cmos5l_buf_1_40.A sg13cmos5l_buf_1_68.X 0
C9248 sg13cmos5l_buf_1_87.A a_18196_8824# 0
C9249 a_12404_7972# a_12567_7282# 0
C9250 sg13cmos5l_buf_1_26.X nl_sw[4] 0.00219f
C9251 a_9256_9224# sg13cmos5l_dfrbp_1_20.Q_N 0.02344f
C9252 sg13cmos5l_nand2_1_0.B a_11182_4948# 0.00105f
C9253 sg13cmos5l_inv_1_0.Y a_13324_4696# 0
C9254 a_10665_7281# cks 0.0011f
C9255 sg13cmos5l_buf_1_77.A a_9366_5842# 0.00612f
C9256 sg13cmos5l_nor2_1_0.A a_11979_2399# 0
C9257 sg13cmos5l_dfrbp_1_23.CLK sg13cmos5l_dlhr_1_14.Q_N 0.02612f
C9258 sg13cmos5l_nor2_1_1.A a_15200_1758# 0
C9259 sg13cmos5l_dfrbp_1_8.D a_18793_6216# 0.035f
C9260 a_6697_3192# VPWR 0.42519f
C9261 sg13cmos5l_buf_1_60.X a_2248_9224# 0.33114f
C9262 sg13cmos5l_dfrbp_1_21.Q sg13cmos5l_nand2_1_1.B 0
C9263 a_16268_3102# sg13cmos5l_buf_1_4.X 0
C9264 a_5194_2356# a_5324_1590# 0
C9265 sg13cmos5l_dlhr_1_6.D a_8660_5412# 0.00395f
C9266 a_8570_6172# a_8378_5776# 0
C9267 sg13cmos5l_buf_1_41.A sg13cmos5l_dfrbp_1_10.Q_N 0.53235f
C9268 sg13cmos5l_dfrbp_1_8.RESET_B a_9060_8861# 0.00486f
C9269 a_17367_8794# cks 0.01684f
C9270 sg13cmos5l_dfrbp_1_11.Q sg13cmos5l_a221oi_1_0.A2 1.65549f
C9271 sg13cmos5l_buf_1_35.A VPWR 0.44187f
C9272 a_18860_9150# a_18856_8436# 0
C9273 sg13cmos5l_buf_1_39.A nl_sw[2] 0.04074f
C9274 sg13cmos5l_buf_1_4.A sg13cmos5l_dfrbp_1_0.RESET_B 0.22027f
C9275 a_9823_2364# sg13cmos5l_buf_1_8.A 0
C9276 sg13cmos5l_buf_1_45.X a_8390_6924# 0
C9277 sg13cmos5l_buf_1_98.A pl_sw[6] 0
C9278 sg13cmos5l_inv_1_1.A a_13775_6239# 0
C9279 sg13cmos5l_buf_1_3.A sg13cmos5l_dfrbp_1_0.Q 0.00142f
C9280 a_10726_5760# VPWR 0
C9281 a_16356_7349# a_16587_6935# 0.15089f
C9282 a_16042_6892# a_16425_6971# 0.00337f
C9283 a_16485_6935# a_17233_7285# 0.01058f
C9284 sg13cmos5l_dfrbp_1_0.RESET_B d_out[1] 0
C9285 sg13cmos5l_nand2_1_1.A a_14745_3453# 0
C9286 a_1948_7964# a_1125_6935# 0.00643f
C9287 a_8982_7354# sg13cmos5l_dlhr_1_5.Q_N 0.12876f
C9288 a_2757_3117# a_3008_1758# 0
C9289 a_2340_3456# a_3496_1758# 0
C9290 sg13cmos5l_dfrbp_1_6.D a_12980_6924# 0.00267f
C9291 sg13cmos5l_dfrbp_1_8.RESET_B a_16042_6892# 0.35053f
C9292 sg13cmos5l_a22oi_1_1.A1 a_15062_4292# 0.01739f
C9293 sg13cmos5l_buf_1_7.A sg13cmos5l_a22oi_1_1.Y 0
C9294 sg13cmos5l_buf_1_61.X sg13cmos5l_buf_1_62.X 0.96925f
C9295 sg13cmos5l_a221oi_1_0.B1 sg13cmos5l_a221oi_1_0.B2 0.47184f
C9296 sg13cmos5l_dfrbp_1_3.Q_N VPWR 0.18587f
C9297 sg13cmos5l_buf_1_78.A ph_sw[4] 0
C9298 sg13cmos5l_buf_1_19.A a_19345_6154# 0
C9299 a_2831_7630# a_3574_7850# 0.00386f
C9300 a_2667_3911# VPWR 0.21192f
C9301 sg13cmos5l_dfrbp_1_6.RESET_B a_7316_2388# 0.01183f
C9302 sg13cmos5l_inv_1_2.A a_13768_8436# 0.00144f
C9303 a_11752_6294# VPWR 0.1841f
C9304 a_5414_6162# a_6959_6239# 0
C9305 sg13cmos5l_buf_1_2.A cks 0
C9306 sg13cmos5l_dlhr_1_9.D a_5104_4870# 0.00121f
C9307 sg13cmos5l_buf_1_60.X a_2148_8440# 0.0105f
C9308 a_12489_9577# pl_sw[6] 0
C9309 a_15414_7354# a_16042_6892# 0.00361f
C9310 a_12230_6162# sg13cmos5l_dfrbp_1_21.Q 0.002f
C9311 a_3771_6553# sg13cmos5l_inv_1_19.A 0
C9312 sg13cmos5l_dfrbp_1_8.RESET_B a_2667_8447# 0.56494f
C9313 sg13cmos5l_dfrbp_1_6.RESET_B a_18580_7660# 0.00578f
C9314 sg13cmos5l_buf_1_79.X a_10868_8436# 0.00401f
C9315 a_6345_8483# pl_sw[3] 0
C9316 sg13cmos5l_dfrbp_1_16.Q a_5710_5535# 0.00109f
C9317 sg13cmos5l_dfrbp_1_6.D a_9033_6162# 0.0072f
C9318 sg13cmos5l_o21ai_1_0.Y a_11460_2392# 0
C9319 sg13cmos5l_dfrbp_1_6.D a_18574_5028# 0.00197f
C9320 sg13cmos5l_buf_8_0.X a_20008_3900# 0
C9321 a_10031_8797# pl_sw[5] 0
C9322 sg13cmos5l_dlhr_1_11.D VPWR 0.34902f
C9323 sg13cmos5l_dfrbp_1_6.RESET_B a_7504_8678# 0
C9324 sg13cmos5l_dfrbp_1_6.RESET_B a_6198_3120# 0.01458f
C9325 sg13cmos5l_dlhr_1_0.GATE a_6213_3911# 0.01163f
C9326 sg13cmos5l_inv_1_8.A a_6219_6284# 0.0099f
C9327 sg13cmos5l_inv_1_2.A sg13cmos5l_dfrbp_1_8.D 0.30645f
C9328 a_15012_7992# sg13cmos5l_buf_1_4.A 0
C9329 sg13cmos5l_inv_1_14.A sg13cmos5l_dlhr_1_0.Q 0.00167f
C9330 sg13cmos5l_buf_1_29.A a_9524_4972# 0.04965f
C9331 a_10028_6126# sg13cmos5l_buf_1_46.A 0
C9332 sg13cmos5l_dfrbp_1_6.RESET_B a_3241_2746# 0
C9333 sg13cmos5l_dfrbp_1_6.D sg13cmos5l_buf_1_57.X 0.97572f
C9334 sg13cmos5l_buf_1_31.X sg13cmos5l_nand2_1_0.B 0.00119f
C9335 a_15887_8797# VPWR 0.25905f
C9336 sg13cmos5l_dfrbp_1_0.RESET_B a_11434_2356# 0.35085f
C9337 a_9260_2352# a_9544_2474# 0.01225f
C9338 sg13cmos5l_inv_1_3.A sg13cmos5l_buf_1_6.A 0
C9339 sg13cmos5l_dfrbp_1_6.RESET_B a_6891_4772# 0
C9340 sg13cmos5l_buf_1_10.A sg13cmos5l_dfrbp_1_1.Q 0.00203f
C9341 sg13cmos5l_buf_1_78.A sg13cmos5l_buf_1_24.A 0.15907f
C9342 sg13cmos5l_dfrbp_1_11.Q a_6697_3192# 0
C9343 sg13cmos5l_nand2_1_0.A a_11686_2813# 0
C9344 sg13cmos5l_buf_1_77.X a_8486_8874# 0
C9345 sg13cmos5l_dfrbp_1_21.Q sg13cmos5l_a22oi_1_1.A1 0.05016f
C9346 a_18870_7656# cks 0
C9347 sg13cmos5l_buf_1_30.A sg13cmos5l_a22oi_1_2.B1 0
C9348 a_12230_6162# sg13cmos5l_or2_1_1.B 0
C9349 a_7820_9150# sg13cmos5l_dfrbp_1_8.RESET_B 0.00229f
C9350 a_3588_4968# a_4640_3986# 0
C9351 a_2790_7996# sg13cmos5l_inv_1_19.A 0
C9352 a_10868_8436# sg13cmos5l_buf_1_96.A 0.00521f
C9353 sg13cmos5l_buf_1_97.A a_11567_7751# 0
C9354 sg13cmos5l_dfrbp_1_22.D a_17882_7684# 0.00734f
C9355 a_12567_7282# a_12230_6162# 0
C9356 a_12361_7282# a_12490_6385# 0
C9357 sg13cmos5l_dlhr_1_0.D a_7226_1636# 0.06373f
C9358 a_1967_7285# a_2169_7047# 0.00675f
C9359 sg13cmos5l_inv_1_14.A a_7055_4261# 0.02062f
C9360 sg13cmos5l_buf_1_31.X sg13cmos5l_buf_1_32.X 0.70213f
C9361 sg13cmos5l_nor2_1_1.A a_16657_2749# 0.00418f
C9362 sg13cmos5l_dfrbp_1_20.Q_N a_10473_9186# 0
C9363 sg13cmos5l_buf_1_76.X sg13cmos5l_dfrbp_1_8.RESET_B 0.00148f
C9364 sg13cmos5l_dfrbp_1_6.RESET_B a_1402_3864# 0
C9365 sg13cmos5l_dfrbp_1_21.Q_N a_18409_5770# 0.0033f
C9366 sg13cmos5l_dfrbp_1_6.RESET_B sg13cmos5l_buf_1_87.A 0.00437f
C9367 sg13cmos5l_dlhr_1_11.D a_12698_7288# 0
C9368 sg13cmos5l_buf_1_57.X a_10024_5498# 0.0013f
C9369 sg13cmos5l_buf_1_65.X VPWR 0.51736f
C9370 sg13cmos5l_dfrbp_1_16.Q sg13cmos5l_buf_1_46.A 0
C9371 sg13cmos5l_inv_1_0.Y a_12520_4782# 0.00393f
C9372 sg13cmos5l_nor2_1_0.A sg13cmos5l_dfrbp_1_4.Q_N 0.00536f
C9373 a_11560_7010# cks 0
C9374 sg13cmos5l_dlhr_1_9.D sg13cmos5l_o21ai_1_0.A1 0
C9375 sg13cmos5l_dfrbp_1_8.D a_17938_6162# 0
C9376 sg13cmos5l_nor2_1_1.A a_17931_1748# 0
C9377 sg13cmos5l_buf_1_25.A sg13cmos5l_buf_1_39.A 0
C9378 a_5908_3124# VPWR 0
C9379 a_708_6928# a_1125_6935# 0.49014f
C9380 sg13cmos5l_buf_1_5.A sg13cmos5l_dfrbp_1_23.Q_N 0.55022f
C9381 sg13cmos5l_dfrbp_1_10.Q a_4840_1664# 0
C9382 sg13cmos5l_dfrbp_1_6.RESET_B a_1609_4704# 0.00196f
C9383 sg13cmos5l_dfrbp_1_18.Q a_9558_6144# 0
C9384 a_17399_3947# sg13cmos5l_nor2_1_1.A 0
C9385 a_5508_2813# sg13cmos5l_buf_1_24.X 0
C9386 a_5637_2399# VPWR 0.25037f
C9387 sg13cmos5l_dfrbp_1_18.Q ph_sw[4] 0
C9388 a_14602_8404# a_14295_7282# 0
C9389 a_14342_8874# a_14426_7288# 0
C9390 sg13cmos5l_dfrbp_1_6.D a_16779_6284# 0.02385f
C9391 a_14449_3215# sg13cmos5l_dfrbp_1_0.Q 0
C9392 sg13cmos5l_dfrbp_1_6.RESET_B sg13cmos5l_buf_1_3.A 0.32519f
C9393 a_10318_5412# VPWR 0.19479f
C9394 sg13cmos5l_buf_1_45.X sg13cmos5l_buf_1_29.A 0
C9395 a_12719_2749# sg13cmos5l_buf_1_8.A 0.00364f
C9396 a_19734_5842# d_out[2] 0
C9397 a_5194_2356# nh_sw[2] 0
C9398 sg13cmos5l_buf_1_103.A a_15531_7796# 0
C9399 a_8905_4704# VPWR 0.4207f
C9400 a_10220_3102# nl_sw[5] 0.29577f
C9401 sg13cmos5l_dfrbp_1_21.Q a_11771_5412# 0
C9402 sg13cmos5l_buf_1_90.X a_12549_9165# 0.01206f
C9403 VPWR nh_sw[1] 0.19298f
C9404 sg13cmos5l_dlhr_1_15.Q_N a_18999_6178# 0
C9405 a_19240_7712# a_19412_6484# 0
C9406 a_17327_7285# a_17233_7285# 0.32273f
C9407 a_17584_7166# a_17746_7362# 0.0019f
C9408 a_5962_8404# VPWR 0.09423f
C9409 a_1664_7806# a_1125_6935# 0
C9410 sg13cmos5l_buf_1_40.A a_422_5850# 0.01595f
C9411 a_14254_2444# a_14056_1664# 0
C9412 sg13cmos5l_dfrbp_1_6.RESET_B sg13cmos5l_buf_1_93.X 0
C9413 sg13cmos5l_dfrbp_1_8.RESET_B a_16587_6935# 0.55134f
C9414 a_13284_3456# a_13572_3151# 0.4806f
C9415 sg13cmos5l_a22oi_1_1.A1 a_16298_4338# 0
C9416 sg13cmos5l_dfrbp_1_6.D a_14089_7282# 0.00357f
C9417 sg13cmos5l_nor2b_1_0.Y sg13cmos5l_nand2_1_0.A 0.56459f
C9418 sg13cmos5l_buf_1_111.A sg13cmos5l_buf_8_2.X 0.00519f
C9419 a_17882_7684# a_18097_7666# 0.00284f
C9420 sg13cmos5l_inv_1_3.A a_13686_7354# 0.00406f
C9421 a_16395_4772# sg13cmos5l_buf_1_4.X 0
C9422 sg13cmos5l_dfrbp_1_9.Q_N VPWR 0.1808f
C9423 sg13cmos5l_dfrbp_1_6.RESET_B sg13cmos5l_dlhr_1_0.D 0.18487f
C9424 sg13cmos5l_buf_1_18.A a_18122_2388# 0
C9425 sg13cmos5l_dfrbp_1_0.CLK a_16940_3102# 0.00148f
C9426 a_12324_6162# VPWR 0
C9427 sg13cmos5l_inv_1_2.A a_15876_4968# 0.10848f
C9428 sg13cmos5l_dlhr_1_9.D sg13cmos5l_dlhr_1_0.GATE 0.00442f
C9429 a_5700_6480# a_6865_6239# 0.4858f
C9430 a_6959_6239# a_7216_6382# 0.35645f
C9431 a_6219_6284# a_5988_6175# 0.15089f
C9432 sg13cmos5l_buf_1_60.X a_4244_8436# 0.00495f
C9433 sg13cmos5l_a221oi_1_0.C1 sg13cmos5l_nand2_1_0.B 0.07475f
C9434 sg13cmos5l_dfrbp_1_6.D a_18363_4270# 0.03373f
C9435 a_1192_1664# nl_sw[0] 0.00141f
C9436 a_7336_7010# a_6959_6239# 0.00267f
C9437 sg13cmos5l_buf_1_41.X nh_sw[0] 0
C9438 a_14032_6382# sg13cmos5l_dfrbp_1_21.Q 0
C9439 sg13cmos5l_buf_1_79.X a_12232_8436# 0.00395f
C9440 sg13cmos5l_inv_1_8.Y sg13cmos5l_or2_1_0.A 0.37701f
C9441 sg13cmos5l_dfrbp_1_8.RESET_B sg13cmos5l_dfrbp_1_17.Q_N 0.00564f
C9442 a_4322_6162# sg13cmos5l_inv_1_19.A 0
C9443 sg13cmos5l_o21ai_1_0.Y a_11979_2399# 0
C9444 a_5069_5376# sg13cmos5l_or2_1_0.A 0
C9445 sg13cmos5l_buf_1_77.A a_7941_7653# 0.0042f
C9446 sg13cmos5l_inv_1_27.Y pl_sw[8] 0
C9447 a_1873_5773# sg13cmos5l_inv_1_19.A 0.01014f
C9448 a_17414_3138# VPWR 0.95347f
C9449 a_1956_4338# VPWR 0
C9450 a_12216_5728# a_12358_5388# 0.00729f
C9451 sg13cmos5l_or2_1_1.B a_11771_5412# 0.09959f
C9452 a_9673_9240# a_9189_8447# 0
C9453 sg13cmos5l_dfrbp_1_6.RESET_B a_8486_8874# 0
C9454 a_7238_7674# sg13cmos5l_dlhr_1_6.D 0
C9455 sg13cmos5l_inv_1_7.A a_13701_3117# 0.01389f
C9456 a_7941_7653# a_8457_7281# 0
C9457 a_8043_7796# a_8276_6924# 0
C9458 a_2697_3529# sg13cmos5l_buf_1_37.A 0
C9459 sg13cmos5l_inv_1_8.A a_5988_6175# 0.01786f
C9460 sg13cmos5l_dfrbp_1_6.RESET_B a_4276_2776# 0.00495f
C9461 sg13cmos5l_buf_1_95.X a_12358_9199# 0
C9462 sg13cmos5l_buf_1_94.X sg13cmos5l_buf_1_111.A 0
C9463 sg13cmos5l_buf_1_103.A sg13cmos5l_inv_1_26.Y 0.02472f
C9464 sg13cmos5l_dfrbp_1_23.Q sg13cmos5l_dfrbp_1_23.Q_N 0.01749f
C9465 sg13cmos5l_dfrbp_1_0.RESET_B a_11748_2813# 0.00373f
C9466 sg13cmos5l_a221oi_1_0.C1 nl_sw[6] 0
C9467 sg13cmos5l_buf_1_9.A a_10433_1652# 0
C9468 sg13cmos5l_inv_1_8.A a_6184_9224# 0
C9469 sg13cmos5l_inv_1_17.A ph_sw[1] 0
C9470 a_8660_5412# a_8972_3864# 0
C9471 a_7524_7992# a_7812_7687# 0.4806f
C9472 a_3308_9150# sg13cmos5l_buf_1_62.X 0.1309f
C9473 sg13cmos5l_buf_1_18.A sg13cmos5l_buf_1_4.X 0
C9474 VPWR pl_sw[1] 0.32783f
C9475 sg13cmos5l_dfrbp_1_6.D sg13cmos5l_dlhr_1_1.Q 0
C9476 sg13cmos5l_inv_1_18.A sg13cmos5l_a22oi_1_0.Y 0
C9477 a_18959_3215# sg13cmos5l_buf_1_19.X 0.0102f
C9478 sg13cmos5l_inv_1_2.A a_16690_7674# 0
C9479 sg13cmos5l_buf_1_110.A sg13cmos5l_buf_1_94.X 0.01523f
C9480 sg13cmos5l_inv_1_1.A sg13cmos5l_buf_1_93.X 0.03629f
C9481 sg13cmos5l_dlhr_1_11.GATE sg13cmos5l_dfrbp_1_23.CLK 0
C9482 sg13cmos5l_nand2_1_0.B sg13cmos5l_o21ai_1_0.B1 0
C9483 a_15500_9150# sg13cmos5l_buf_1_103.A 0.00192f
C9484 sg13cmos5l_nand2_1_1.B a_13072_1846# 0
C9485 sg13cmos5l_dfrbp_1_6.RESET_B a_2697_3529# 0
C9486 a_1125_5423# a_1227_5423# 0.6663f
C9487 sg13cmos5l_inv_1_3.A sg13cmos5l_buf_1_5.A 0.48016f
C9488 sg13cmos5l_dfrbp_1_17.D a_2505_8483# 0
C9489 a_1463_8741# sg13cmos5l_dfrbp_1_15.D 0
C9490 sg13cmos5l_nor2_1_2.A nh_sw[0] 0.16621f
C9491 sg13cmos5l_dfrbp_1_16.Q_N sg13cmos5l_inv_1_19.A 0
C9492 a_13100_8400# a_13484_8400# 0.00492f
C9493 sg13cmos5l_dfrbp_1_0.RESET_B sg13cmos5l_buf_1_8.X 0.58865f
C9494 a_12980_6924# a_13035_6284# 0
C9495 a_13161_7281# a_12933_6141# 0.01412f
C9496 a_13686_7354# a_12516_6480# 0
C9497 sg13cmos5l_dlhr_1_0.D a_9832_1664# 0.00334f
C9498 sg13cmos5l_buf_1_29.A sg13cmos5l_a22oi_1_2.B2 0.21528f
C9499 sg13cmos5l_dfrbp_1_11.Q a_8905_4704# 0.19685f
C9500 sg13cmos5l_inv_1_14.A a_7257_4023# 0.00241f
C9501 a_10665_7281# sg13cmos5l_a22oi_1_2.B2 0
C9502 a_11190_7354# a_11072_5347# 0
C9503 a_1878_6337# a_708_5416# 0
C9504 sg13cmos5l_buf_8_0.X sg13cmos5l_nand2_1_1.A 0.00379f
C9505 a_8796_5814# sg13cmos5l_a221oi_1_1.C1 0
C9506 sg13cmos5l_buf_1_65.X a_5132_9150# 0.00888f
C9507 sg13cmos5l_dfrbp_1_6.RESET_B a_1862_8874# 0.00253f
C9508 sg13cmos5l_dfrbp_1_6.D a_1997_6126# 0
C9509 sg13cmos5l_dlhr_1_5.GATE a_6741_5459# 0
C9510 sg13cmos5l_buf_1_44.X a_5220_2392# 0
C9511 sg13cmos5l_dfrbp_1_15.D ph_sw[2] 0
C9512 sg13cmos5l_o21ai_1_0.B1 nl_sw[6] 0.00162f
C9513 sg13cmos5l_dlhr_1_15.D sg13cmos5l_buf_8_1.A 0
C9514 sg13cmos5l_dlhr_1_9.Q_N a_3488_7010# 0
C9515 sg13cmos5l_dlhr_1_9.Q a_3962_7288# 0.06632f
C9516 a_13686_7354# cks 0
C9517 sg13cmos5l_buf_1_31.X sg13cmos5l_a221oi_1_1.C1 0
C9518 a_424_8436# rdy 0.32263f
C9519 sg13cmos5l_dfrbp_1_6.RESET_B a_2160_4972# 0
C9520 sg13cmos5l_buf_1_40.A sg13cmos5l_nand2_1_2.B 0.44477f
C9521 a_6479_2749# VPWR 0.26338f
C9522 a_5820_5773# a_6789_4629# 0
C9523 sg13cmos5l_inv_1_2.A a_9879_9202# 0.01767f
C9524 a_14583_5770# sg13cmos5l_a22oi_1_1.B1 0
C9525 sg13cmos5l_dfrbp_1_8.RESET_B a_13484_8400# 0.0088f
C9526 a_17367_8794# pl_sw[9] 0.03005f
C9527 sg13cmos5l_dfrbp_1_6.D a_16548_6175# 0
C9528 sg13cmos5l_dlhr_1_15.D a_18960_5412# 0
C9529 a_620_7638# sg13cmos5l_buf_1_68.X 0.00111f
C9530 a_10696_1758# nh_sw[5] 0.00129f
C9531 a_11002_3142# nh_sw[5] 0
C9532 a_11846_9186# VPWR 0.94635f
C9533 sg13cmos5l_buf_1_24.A a_7316_3460# 0.00134f
C9534 sg13cmos5l_buf_1_44.X a_5796_8874# 0
C9535 a_17750_4325# cks 0
C9536 sg13cmos5l_nor2_1_1.A sg13cmos5l_buf_1_8.A 0
C9537 sg13cmos5l_buf_1_24.A a_4934_2826# 0
C9538 a_3976_9224# sg13cmos5l_dfrbp_1_8.RESET_B 0
C9539 a_1760_9318# sg13cmos5l_buf_1_58.A 0
C9540 sg13cmos5l_buf_1_57.X a_13035_6284# 0.0209f
C9541 sg13cmos5l_inv_1_8.A a_6022_4325# 0
C9542 sg13cmos5l_or2_1_1.B sg13cmos5l_or2_1_0.A 0
C9543 sg13cmos5l_buf_1_90.X sg13cmos5l_inv_1_27.Y 0
C9544 sg13cmos5l_buf_1_87.A a_17498_8800# 0
C9545 a_17792_9318# a_17780_8436# 0
C9546 sg13cmos5l_nor2b_1_0.Y sg13cmos5l_dfrbp_1_1.Q 0.01672f
C9547 a_10827_7796# ph_sw[5] 0
C9548 sg13cmos5l_buf_1_18.A a_19344_6484# 0
C9549 a_6507_8447# VPWR 0.20812f
C9550 ph_sw[4] cks 0
C9551 sg13cmos5l_inv_1_8.A sg13cmos5l_buf_1_32.X 0.00623f
C9552 sg13cmos5l_nor2_1_1.A sg13cmos5l_buf_1_1.A 0.01542f
C9553 a_5492_3460# VPWR 0.11802f
C9554 a_14152_8522# a_14166_7656# 0
C9555 a_14543_3215# a_14449_3215# 0.32273f
C9556 sg13cmos5l_a22oi_1_1.A1 a_17493_3947# 0.0017f
C9557 a_3447_2746# VPWR 0.18792f
C9558 sg13cmos5l_buf_1_73.A sg13cmos5l_buf_1_78.X 0
C9559 a_8488_9224# sg13cmos5l_buf_1_77.A 0.0018f
C9560 sg13cmos5l_dlhr_1_15.D a_14152_5498# 0.00201f
C9561 a_18376_9224# a_17961_8793# 0.01001f
C9562 sg13cmos5l_buf_1_101.X a_17713_8838# 0
C9563 sg13cmos5l_buf_1_18.A a_20008_7712# 0.06723f
C9564 sg13cmos5l_inv_1_3.A sg13cmos5l_dfrbp_1_23.Q 1.188f
C9565 sg13cmos5l_dlhr_1_15.Q a_19904_7806# 0
C9566 a_10464_2427# sg13cmos5l_buf_1_8.A 0.00245f
C9567 a_1948_7964# a_708_6928# 0
C9568 a_6789_4629# VPWR 0.24508f
C9569 sg13cmos5l_inv_1_14.A a_6741_5459# 0.01619f
C9570 a_7216_6382# sg13cmos5l_dlhr_1_6.D 0.00122f
C9571 sg13cmos5l_dfrbp_1_16.Q a_3407_4261# 0
C9572 a_17896_9224# cks 0
C9573 a_616_9224# sg13cmos5l_buf_1_62.X 0
C9574 sg13cmos5l_buf_1_77.X a_7820_9150# 0.00851f
C9575 sg13cmos5l_buf_1_74.X a_8488_9224# 0.0031f
C9576 sg13cmos5l_buf_1_5.A cks 0.05564f
C9577 a_1158_3142# VPWR 0.2033f
C9578 sg13cmos5l_dfrbp_1_1.D a_11782_1639# 0
C9579 sg13cmos5l_dfrbp_1_6.D a_2364_4686# 0
C9580 a_4176_6924# sg13cmos5l_inv_1_19.A 0
C9581 sg13cmos5l_buf_1_77.A a_9040_7894# 0.03411f
C9582 a_19216_3358# VPWR 0.15797f
C9583 a_10031_8797# pl_sw[6] 0
C9584 sg13cmos5l_inv_1_3.A a_13460_7996# 0.00107f
C9585 a_10010_9196# a_10031_8797# 0
C9586 a_9879_9202# a_9937_8797# 0
C9587 a_10473_9186# a_10288_8678# 0
C9588 sg13cmos5l_dfrbp_1_6.RESET_B a_19593_6162# 0.45651f
C9589 a_2566_3151# sg13cmos5l_buf_1_37.A 0
C9590 a_9040_7894# a_8457_7281# 0.00576f
C9591 a_2621_7636# a_2831_7630# 0.2777f
C9592 a_1846_7850# sg13cmos5l_buf_1_58.A 0.60424f
C9593 a_8783_7751# a_8982_7354# 0
C9594 sg13cmos5l_inv_1_27.Y a_11190_7354# 0
C9595 sg13cmos5l_buf_1_76.X sg13cmos5l_buf_1_77.X 0.02189f
C9596 sg13cmos5l_a221oi_1_0.A2 a_10783_4292# 0
C9597 a_5770_3868# a_5796_3904# 0.43042f
C9598 a_5510_4338# a_5408_3986# 0
C9599 a_1065_6971# cks 0
C9600 sg13cmos5l_dfrbp_1_1.Q a_13138_2826# 0
C9601 sg13cmos5l_inv_1_18.A sg13cmos5l_buf_1_26.A 0.04754f
C9602 a_13072_4142# a_13234_4338# 0.0019f
C9603 a_12815_4261# a_12721_4261# 0.32273f
C9604 sg13cmos5l_buf_1_110.A a_15793_8797# 0.0181f
C9605 sg13cmos5l_buf_1_24.A cks 0.00213f
C9606 sg13cmos5l_dfrbp_1_0.RESET_B a_11817_2435# 0
C9607 sg13cmos5l_buf_1_9.A a_11913_2017# 0
C9608 a_1006_4167# VPWR 0.21984f
C9609 sg13cmos5l_nor2_1_0.A a_13076_5376# 0.10239f
C9610 sg13cmos5l_dfrbp_1_8.RESET_B sg13cmos5l_dfrbp_1_17.D 0.17717f
C9611 a_18272_9318# VPWR 0.07364f
C9612 a_4460_9150# ph_sw[2] 0.00952f
C9613 a_18671_1703# nh_sw[9] 0.01523f
C9614 a_9040_7894# a_8985_7989# 0.00464f
C9615 a_19624_8436# sg13cmos5l_buf_1_18.A 0
C9616 sg13cmos5l_dfrbp_1_1.D a_10433_1652# 0.00101f
C9617 sg13cmos5l_buf_1_110.A sg13cmos5l_a22oi_1_1.A1 0
C9618 a_17588_2388# nh_sw[8] 0.00185f
C9619 sg13cmos5l_dfrbp_1_6.RESET_B a_16042_6892# 0
C9620 sg13cmos5l_dfrbp_1_11.Q a_6479_2749# 0
C9621 sg13cmos5l_buf_1_34.X a_4950_5699# 0.00102f
C9622 a_18870_7656# pl_sw[9] 0
C9623 sg13cmos5l_inv_1_18.A sg13cmos5l_buf_1_46.A 0.02105f
C9624 a_1815_4666# VPWR 0.19398f
C9625 sg13cmos5l_dlhr_1_1.GATE a_2228_4972# 0
C9626 sg13cmos5l_dfrbp_1_6.RESET_B a_2566_3151# 0
C9627 sg13cmos5l_inv_1_14.A a_7732_3124# 0.00142f
C9628 sg13cmos5l_dlhr_1_6.D a_13792_5760# 0
C9629 sg13cmos5l_nand2_1_1.B sg13cmos5l_a22oi_1_1.Y 0.07096f
C9630 a_11556_3904# a_12075_3911# 0.38871f
C9631 a_15012_7992# a_15592_6200# 0
C9632 a_9558_6144# a_9524_4972# 0
C9633 sg13cmos5l_buf_1_56.A a_9242_4660# 0
C9634 a_10028_6126# a_9705_4650# 0
C9635 a_17829_1605# nh_sw[8] 0
C9636 sg13cmos5l_a221oi_1_1.C1 sg13cmos5l_a221oi_1_0.C1 0.0759f
C9637 sg13cmos5l_or2_1_1.B a_11072_5347# 0.04779f
C9638 a_19227_9190# VPWR 1.13415f
C9639 sg13cmos5l_buf_1_28.X sg13cmos5l_buf_1_30.X 0.399f
C9640 a_18345_7674# ph_sw[8] 0
C9641 sg13cmos5l_dlhr_1_0.D a_7924_1612# 0.00194f
C9642 sg13cmos5l_dfrbp_1_23.Q a_12516_6480# 0.01531f
C9643 sg13cmos5l_inv_1_7.A a_12704_4782# 0
C9644 a_20200_3270# a_20012_1590# 0
C9645 sg13cmos5l_dfrbp_1_20.Q sg13cmos5l_a22oi_1_1.B1 0
C9646 sg13cmos5l_buf_1_18.A a_19227_4654# 0.05954f
C9647 sg13cmos5l_inv_1_2.A a_10225_9178# 0
C9648 sg13cmos5l_buf_1_86.A frame 0.55588f
C9649 sg13cmos5l_inv_1_0.A sg13cmos5l_buf_1_8.A 0
C9650 a_3831_7282# a_2748_6126# 0
C9651 sg13cmos5l_dfrbp_1_6.RESET_B a_2667_8447# 0.00259f
C9652 sg13cmos5l_dfrbp_1_22.D a_16677_6141# 0
C9653 sg13cmos5l_dlhr_1_5.GATE sg13cmos5l_a221oi_1_0.A2 0
C9654 sg13cmos5l_buf_1_57.X a_12800_5498# 0
C9655 a_12873_6553# sg13cmos5l_nor2_1_0.A 0
C9656 sg13cmos5l_inv_1_29.A sg13cmos5l_dlhr_1_15.D 0
C9657 sg13cmos5l_buf_1_44.X sg13cmos5l_dfrbp_1_10.Q 0.00624f
C9658 sg13cmos5l_buf_1_2.X nl_sw[8] 1.17717f
C9659 a_16748_9150# VPWR 0.24792f
C9660 sg13cmos5l_dfrbp_1_6.D sg13cmos5l_dfrbp_1_0.RESET_B 0.01105f
C9661 sg13cmos5l_buf_1_105.A sg13cmos5l_buf_1_19.A 0.00708f
C9662 a_1662_8374# sg13cmos5l_dfrbp_1_17.D 0.16691f
C9663 a_4005_4629# a_3407_4261# 0.0459f
C9664 a_3588_4968# a_4244_3900# 0
C9665 sg13cmos5l_dfrbp_1_6.RESET_B sg13cmos5l_dlhr_1_12.Q_N 0
C9666 sg13cmos5l_buf_1_41.A a_3496_1758# 0.06247f
C9667 sg13cmos5l_dlhr_1_9.Q a_4380_7326# 0
C9668 sg13cmos5l_dfrbp_1_10.Q a_9260_2352# 0.00268f
C9669 a_13641_7674# a_12933_6141# 0
C9670 sg13cmos5l_buf_1_31.X a_416_2474# 0.0023f
C9671 a_2596_7996# sg13cmos5l_inv_1_19.A 0
C9672 sg13cmos5l_buf_1_31.X a_4640_3986# 0
C9673 sg13cmos5l_inv_1_28.Y a_10827_7796# 0.01017f
C9674 sg13cmos5l_buf_1_87.A sg13cmos5l_buf_1_86.A 0
C9675 a_17700_3456# a_17931_1748# 0
C9676 a_18117_3117# a_17829_1605# 0.00323f
C9677 a_5577_2435# VPWR 0
C9678 sg13cmos5l_dfrbp_1_11.Q a_6789_4629# 0.0421f
C9679 sg13cmos5l_dfrbp_1_18.Q ph_sw[5] 0
C9680 sg13cmos5l_dfrbp_1_8.RESET_B a_15590_4650# 0.11662f
C9681 a_13648_9406# VPWR 0.14669f
C9682 a_11364_1626# nh_sw[5] 0
C9683 sg13cmos5l_buf_1_24.A a_7430_3576# 0
C9684 sg13cmos5l_or2_1_0.A sg13cmos5l_buf_1_32.A 0
C9685 sg13cmos5l_dlhr_1_9.D sg13cmos5l_a22oi_1_1.B1 0.00495f
C9686 sg13cmos5l_a22oi_1_1.A1 d_out[2] 0.00642f
C9687 a_11473_7751# a_11986_7674# 0
C9688 sg13cmos5l_inv_1_27.Y sg13cmos5l_dfrbp_1_21.Q 0
C9689 sg13cmos5l_buf_1_57.X sg13cmos5l_buf_1_116.A 0.02603f
C9690 sg13cmos5l_dfrbp_1_16.Q a_11771_5412# 0
C9691 sg13cmos5l_inv_1_6.A sg13cmos5l_buf_8_1.A 0
C9692 sg13cmos5l_and3_1_0.X sg13cmos5l_and3_1_0.C 0.02036f
C9693 a_8378_5776# a_8660_5412# 0.68988f
C9694 sg13cmos5l_buf_1_3.A sg13cmos5l_buf_1_86.A 0.44316f
C9695 sg13cmos5l_buf_1_107.X sg13cmos5l_buf_1_105.A 0.00732f
C9696 a_1463_8511# cks 0.00645f
C9697 a_682_6892# a_1125_6935# 0.02241f
C9698 a_13460_7996# cks 0.004f
C9699 sg13cmos5l_inv_1_1.A a_16042_6892# 0.02719f
C9700 sg13cmos5l_dfrbp_1_16.Q a_9705_4650# 0
C9701 a_9256_9224# sg13cmos5l_buf_1_79.X 0.28827f
C9702 sg13cmos5l_dlhr_1_0.Q nl_sw[4] 0.04449f
C9703 sg13cmos5l_inv_1_0.Y sg13cmos5l_and3_1_0.C 0
C9704 sg13cmos5l_a221oi_1_0.B1 a_11364_4338# 0
C9705 sg13cmos5l_dfrbp_1_18.Q_N VPWR 0.17778f
C9706 sg13cmos5l_buf_1_5.X sg13cmos5l_buf_1_4.X 0
C9707 a_14628_8440# a_14536_7806# 0
C9708 a_3996_2790# VPWR 0
C9709 a_5637_2399# sg13cmos5l_buf_1_25.X 0.00271f
C9710 sg13cmos5l_dlhr_1_15.D sg13cmos5l_dlhr_1_19.Q_N 0.00546f
C9711 sg13cmos5l_inv_1_2.A a_15380_3436# 0.00109f
C9712 a_1576_1758# nh_sw[0] 0.01107f
C9713 sg13cmos5l_buf_1_0.A a_19227_4654# 0.01557f
C9714 sg13cmos5l_buf_1_101.X sg13cmos5l_buf_1_105.A 0
C9715 a_4041_2745# nh_sw[2] 0
C9716 sg13cmos5l_or2_1_0.A a_17493_3947# 0.00977f
C9717 sg13cmos5l_buf_1_45.X ph_sw[4] 0.00113f
C9718 sg13cmos5l_dlhr_1_11.Q pl_sw[6] 0
C9719 sg13cmos5l_inv_1_14.A sg13cmos5l_a221oi_1_0.A2 0.003f
C9720 a_8468_4948# VPWR 0.35598f
C9721 a_1664_7806# a_708_6928# 0
C9722 sg13cmos5l_buf_1_25.X nh_sw[1] 0.00101f
C9723 sg13cmos5l_buf_1_97.A a_11846_9186# 0
C9724 sg13cmos5l_buf_1_59.A a_4107_4772# 0
C9725 sg13cmos5l_dfrbp_1_0.RESET_B a_17926_3151# 0
C9726 sg13cmos5l_dfrbp_1_6.D a_15012_7992# 0.00365f
C9727 a_8982_7354# sg13cmos5l_dlhr_1_5.Q 0.57259f
C9728 sg13cmos5l_nand2_1_1.A sg13cmos5l_buf_1_2.X 0.02786f
C9729 a_2859_3260# VPWR 0.22445f
C9730 sg13cmos5l_nand2_1_0.B nl_sw[6] 0
C9731 ph_sw[1] a_1484_9150# 0.00226f
C9732 sg13cmos5l_a22oi_1_1.A1 sg13cmos5l_a22oi_1_1.Y 0.88109f
C9733 sg13cmos5l_dfrbp_1_8.Q_N sg13cmos5l_buf_8_1.A 0
C9734 a_17132_9150# ph_sw[7] 0.2906f
C9735 sg13cmos5l_inv_1_27.Y sg13cmos5l_or2_1_1.B 0
C9736 a_1000_9224# a_1484_9150# 0.03472f
C9737 a_11848_8436# pl_sw[6] 0.00197f
C9738 sg13cmos5l_dfrbp_1_6.RESET_B a_19345_6154# 0
C9739 a_908_1590# nl_sw[0] 0.00532f
C9740 sg13cmos5l_inv_1_27.Y a_12567_7282# 0.00628f
C9741 a_1480_7806# sg13cmos5l_buf_1_58.A 0.00408f
C9742 a_16293_4629# sg13cmos5l_buf_1_2.X 0.00305f
C9743 sg13cmos5l_buf_1_38.A a_3688_1664# 0.00297f
C9744 sg13cmos5l_dfrbp_1_20.Q a_8982_7354# 0
C9745 sg13cmos5l_dfrbp_1_6.D a_8841_5769# 0
C9746 sg13cmos5l_nor2_1_0.A sg13cmos5l_dfrbp_1_10.Q 0.00524f
C9747 sg13cmos5l_or2_1_1.B sg13cmos5l_dfrbp_1_2.D 0
C9748 a_5796_3904# a_7312_4142# 0.00159f
C9749 a_6213_3911# a_6315_3911# 0.6663f
C9750 sg13cmos5l_inv_1_29.Y VPWR 0.35908f
C9751 sg13cmos5l_nor2_1_0.A sg13cmos5l_and3_1_0.X 0
C9752 a_12815_4261# a_13258_3361# 0.0052f
C9753 a_12075_3911# a_12896_3270# 0.00262f
C9754 sg13cmos5l_o21ai_1_0.A2 a_11877_2399# 0.01153f
C9755 sg13cmos5l_nor2_1_0.A sg13cmos5l_inv_1_0.Y 0.31859f
C9756 sg13cmos5l_dfrbp_1_6.RESET_B a_16587_6935# 0.00221f
C9757 VPWR ph_sw[6] 0.36616f
C9758 d_out[1] nh_sw[10] 0.01893f
C9759 sg13cmos5l_dfrbp_1_6.D sg13cmos5l_dlhr_1_5.Q_N 0.00352f
C9760 a_1472_4782# VPWR 0.08344f
C9761 sg13cmos5l_dlhr_1_6.D a_14152_5498# 0
C9762 sg13cmos5l_dfrbp_1_0.CLK a_12815_4261# 0
C9763 sg13cmos5l_buf_1_45.X sg13cmos5l_buf_1_24.A 0
C9764 a_1672_3176# sg13cmos5l_buf_1_32.A 0
C9765 a_7524_7992# sg13cmos5l_dlhr_1_5.D 0.00196f
C9766 a_7941_7653# a_7994_7288# 0.0122f
C9767 sg13cmos5l_inv_1_18.A sg13cmos5l_nand2_1_1.B 0
C9768 sg13cmos5l_dfrbp_1_23.CLK a_14583_5770# 0.25065f
C9769 sg13cmos5l_dfrbp_1_23.Q a_14612_6460# 0.13903f
C9770 sg13cmos5l_dlhr_1_0.D a_11556_1944# 0
C9771 a_15850_4873# a_15590_4650# 0.87117f
C9772 sg13cmos5l_buf_1_30.X sg13cmos5l_a22oi_1_2.B1 0.02249f
C9773 sg13cmos5l_buf_1_28.A sg13cmos5l_dfrbp_1_1.D 0
C9774 sg13cmos5l_dfrbp_1_6.RESET_B sg13cmos5l_dfrbp_1_17.Q_N 0
C9775 a_8084_8436# ph_sw[4] 0
C9776 sg13cmos5l_dfrbp_1_22.D a_17721_6477# 0
C9777 a_708_5416# a_1227_5423# 0.38871f
C9778 a_1125_5423# a_996_5837# 0.01562f
C9779 sg13cmos5l_a22oi_1_2.B1 a_8680_1664# 0.00136f
C9780 sg13cmos5l_inv_1_6.A cko 0
C9781 a_11556_3904# a_11973_3911# 0.49014f
C9782 a_11270_4338# a_11844_4325# 0.36169f
C9783 sg13cmos5l_dfrbp_1_6.D a_2224_5654# 0.0083f
C9784 sg13cmos5l_dlygate4sd2_1_0.X sg13cmos5l_buf_1_32.A 0
C9785 sg13cmos5l_inv_1_14.A a_6697_3192# 0.00407f
C9786 sg13cmos5l_buf_1_30.A sg13cmos5l_buf_1_30.X 0.00816f
C9787 a_4005_4629# sg13cmos5l_buf_1_38.A 0.00146f
C9788 a_12651_9308# sg13cmos5l_buf_1_5.A 0
C9789 sg13cmos5l_buf_1_111.A a_19904_7806# 0.03465f
C9790 a_14166_7656# a_14032_6382# 0
C9791 sg13cmos5l_dfrbp_1_8.D a_15684_4650# 0
C9792 sg13cmos5l_buf_1_30.A a_8680_1664# 0.32833f
C9793 a_16268_1590# nh_sw[8] 0.00237f
C9794 sg13cmos5l_inv_1_28.Y a_11769_7989# 0.00288f
C9795 sg13cmos5l_a22oi_1_1.Y nh_sw[8] 0.00156f
C9796 sg13cmos5l_dfrbp_1_11.Q a_8468_4948# 0.13691f
C9797 sg13cmos5l_dfrbp_1_8.RESET_B a_17392_4870# 0.18223f
C9798 sg13cmos5l_nand2_1_0.A a_11372_3102# 0.06456f
C9799 sg13cmos5l_buf_1_24.A a_8204_2352# 0.29665f
C9800 a_14583_5770# a_15132_5814# 0
C9801 a_14714_5776# a_15177_5769# 0.13395f
C9802 sg13cmos5l_buf_1_79.X a_10473_9186# 0
C9803 sg13cmos5l_buf_1_4.X a_15909_2399# 0.00737f
C9804 a_1576_1758# a_1760_1758# 0.11523f
C9805 a_5704_1664# a_5600_1758# 0.00624f
C9806 sg13cmos5l_a221oi_1_0.A2 sg13cmos5l_buf_1_45.A 0.01855f
C9807 a_13393_7666# cks 0
C9808 sg13cmos5l_dlhr_1_11.GATE sg13cmos5l_dfrbp_1_6.D 0
C9809 sg13cmos5l_inv_1_1.A a_16587_6935# 0.00183f
C9810 a_422_7362# a_1065_6971# 0.00806f
C9811 a_11174_2826# nl_sw[6] 0.05323f
C9812 a_10010_9196# pl_sw[5] 0.00427f
C9813 cks ph_sw[5] 0.00674f
C9814 a_17961_8793# a_17916_8838# 0
C9815 ph_sw[2] pl_sw[3] 0.06572f
C9816 a_3676_7964# a_3962_7288# 0.00637f
C9817 a_4324_7996# a_3831_7282# 0.00236f
C9818 a_4076_7624# a_3625_7282# 0.00663f
C9819 sg13cmos5l_or2_1_0.A a_19244_2352# 0
C9820 a_19130_6172# VPWR 0.35896f
C9821 a_9033_6162# a_8988_6198# 0
C9822 a_8852_6484# a_8785_6154# 0.0018f
C9823 sg13cmos5l_dfrbp_1_6.D a_2248_1664# 0
C9824 a_15147_8447# a_15012_7992# 0
C9825 sg13cmos5l_dfrbp_1_0.RESET_B nh_sw[9] 0
C9826 sg13cmos5l_dfrbp_1_21.Q a_19412_6484# 0
C9827 sg13cmos5l_dfrbp_1_0.CLK nl_sw[8] 0.09593f
C9828 sg13cmos5l_dlhr_1_0.D nh_sw[4] 0.02656f
C9829 sg13cmos5l_dfrbp_1_18.Q sg13cmos5l_buf_1_31.X 0.00132f
C9830 sg13cmos5l_a22oi_1_1.Y a_18117_3117# 0
C9831 sg13cmos5l_inv_1_2.A a_16204_4338# 0.0055f
C9832 sg13cmos5l_dfrbp_1_0.D a_17595_3947# 0
C9833 sg13cmos5l_inv_1_8.A a_4640_3986# 0
C9834 sg13cmos5l_inv_1_29.A sg13cmos5l_dlhr_1_6.D 0.00574f
C9835 sg13cmos5l_inv_1_11.Y nl_sw[5] 0.02648f
C9836 a_15016_6294# a_14996_5412# 0
C9837 a_17896_9224# pl_sw[9] 0.01466f
C9838 a_15876_7362# VPWR 0
C9839 sg13cmos5l_dlhr_1_9.D a_6315_3911# 0
C9840 a_4005_4629# sg13cmos5l_or2_1_0.A 0
C9841 sg13cmos5l_inv_1_7.A a_12980_6924# 0
C9842 sg13cmos5l_dfrbp_1_6.D a_17108_7972# 0
C9843 a_2628_3151# VPWR 0.00942f
C9844 sg13cmos5l_dfrbp_1_16.Q a_11072_5347# 0
C9845 sg13cmos5l_inv_1_0.A sg13cmos5l_o21ai_1_0.A1 0.15093f
C9846 sg13cmos5l_buf_1_65.X sg13cmos5l_dlhr_1_5.GATE 0
C9847 sg13cmos5l_buf_1_98.A a_13641_7674# 0.31551f
C9848 a_3578_2752# a_3688_1664# 0
C9849 sg13cmos5l_nor2b_1_0.Y sg13cmos5l_a22oi_1_0.B1 0.13316f
C9850 sg13cmos5l_dlhr_1_15.D sg13cmos5l_a22oi_1_1.B2 0.03557f
C9851 a_20288_7010# frame 0
C9852 sg13cmos5l_nand2_1_0.A nh_sw[5] 0.7551f
C9853 a_2436_8861# VPWR 0.01095f
C9854 sg13cmos5l_or2_1_0.A sg13cmos5l_a22oi_1_1.Y 0.85233f
C9855 sg13cmos5l_buf_1_77.A a_7863_7282# 0
C9856 a_7312_4142# a_7055_4261# 0.35645f
C9857 a_902_3142# VPWR 0.35054f
C9858 sg13cmos5l_dlhr_1_0.GATE nh_sw[3] 0
C9859 sg13cmos5l_a221oi_1_1.C1 sg13cmos5l_nand2_1_0.B 0
C9860 a_1862_8874# a_2224_7166# 0
C9861 sg13cmos5l_dlhr_1_5.D a_7796_6460# 0.25675f
C9862 sg13cmos5l_buf_1_37.A nh_sw[0] 0.00608f
C9863 sg13cmos5l_inv_1_9.Y sg13cmos5l_or2_1_0.A 0.02429f
C9864 sg13cmos5l_dlhr_1_0.GATE a_7034_3148# 0.00922f
C9865 sg13cmos5l_nand2_1_1.A a_13258_3361# 0
C9866 sg13cmos5l_inv_1_8.A a_7394_5850# 0
C9867 a_7657_7282# a_8276_6924# 0.00161f
C9868 a_7863_7282# a_8457_7281# 0.09085f
C9869 sg13cmos5l_dlhr_1_5.D a_7520_7010# 0.03407f
C9870 a_7994_7288# a_8209_7326# 0.00284f
C9871 sg13cmos5l_dfrbp_1_6.RESET_B sg13cmos5l_dfrbp_1_22.Q_N 0.01546f
C9872 sg13cmos5l_buf_1_78.A a_6219_6284# 0.00101f
C9873 sg13cmos5l_dlhr_1_5.GATE a_5962_8404# 0.00363f
C9874 sg13cmos5l_buf_1_95.X a_12404_7972# 0
C9875 a_12651_9308# a_13460_7996# 0
C9876 sg13cmos5l_dfrbp_1_0.CLK sg13cmos5l_nand2_1_1.A 0.67027f
C9877 sg13cmos5l_and3_1_0.C a_13572_3151# 0
C9878 sg13cmos5l_inv_1_7.A sg13cmos5l_buf_1_57.X 0.02072f
C9879 a_620_2352# a_1580_2352# 0
C9880 sg13cmos5l_dfrbp_1_23.CLK a_14929_5814# 0
C9881 a_16751_2749# a_16953_2511# 0.00675f
C9882 sg13cmos5l_dfrbp_1_4.Q_N nh_sw[6] 0
C9883 a_15590_4650# a_17135_4727# 0
C9884 sg13cmos5l_inv_1_8.A sg13cmos5l_buf_1_78.A 0.31106f
C9885 a_8746_8404# ph_sw[4] 0
C9886 sg13cmos5l_dfrbp_1_6.D a_5700_6480# 0.01746f
C9887 sg13cmos5l_buf_1_3.A a_20288_7010# 0
C9888 a_18856_8436# sg13cmos5l_dlhr_1_15.Q 0.00217f
C9889 sg13cmos5l_a22oi_1_2.B1 sg13cmos5l_dlhr_1_0.Q_N 0
C9890 sg13cmos5l_inv_1_17.A sg13cmos5l_buf_1_61.X 0
C9891 sg13cmos5l_inv_1_20.Y sg13cmos5l_buf_1_62.X 0.65154f
C9892 sg13cmos5l_buf_1_31.X a_7316_3460# 0.00509f
C9893 sg13cmos5l_buf_1_79.X a_11360_9318# 0
C9894 a_7336_9224# VPWR 0.24784f
C9895 sg13cmos5l_dfrbp_1_6.RESET_B a_14844_7326# 0.00107f
C9896 sg13cmos5l_dfrbp_1_6.D sg13cmos5l_dlhr_1_1.D 0.22484f
C9897 a_17367_8794# a_17327_7285# 0.00196f
C9898 a_18959_3215# sg13cmos5l_buf_1_18.X 0
C9899 a_17498_8800# a_16587_6935# 0
C9900 a_17161_8794# a_17584_7166# 0
C9901 sg13cmos5l_buf_1_65.X sg13cmos5l_inv_1_14.A 0.0239f
C9902 sg13cmos5l_buf_1_95.X sg13cmos5l_buf_1_94.X 0.54108f
C9903 sg13cmos5l_inv_1_18.A a_9705_4650# 0
C9904 a_9189_8447# sg13cmos5l_buf_1_57.X 0.00441f
C9905 a_5104_4870# a_5132_3864# 0.00625f
C9906 sg13cmos5l_dfrbp_1_1.Q a_11372_3102# 0.00206f
C9907 sg13cmos5l_buf_1_30.A sg13cmos5l_dlhr_1_0.Q_N 0.02293f
C9908 a_7498_7897# a_7941_7653# 0.02241f
C9909 sg13cmos5l_dfrbp_1_6.D a_7524_7992# 0.0093f
C9910 sg13cmos5l_dfrbp_1_0.RESET_B sg13cmos5l_buf_1_9.A 0.99333f
C9911 sg13cmos5l_buf_1_63.A sg13cmos5l_buf_1_40.A 0.11523f
C9912 sg13cmos5l_dlhr_1_15.D sg13cmos5l_a221oi_1_0.A2 0
C9913 sg13cmos5l_dfrbp_1_21.Q_N sg13cmos5l_or2_1_0.A 0
C9914 sg13cmos5l_inv_1_28.Y cks 0.0157f
C9915 a_13324_4696# a_13520_4696# 0.00343f
C9916 sg13cmos5l_buf_1_105.A a_17712_8436# 0
C9917 sg13cmos5l_inv_1_27.Y sg13cmos5l_buf_1_110.A 0.0174f
C9918 a_14632_9224# sg13cmos5l_buf_1_95.X 0.01019f
C9919 sg13cmos5l_inv_1_3.A a_15500_9150# 0.00256f
C9920 sg13cmos5l_inv_1_17.A a_3962_7288# 0.02194f
C9921 sg13cmos5l_inv_1_14.A a_8905_4704# 0
C9922 sg13cmos5l_buf_1_57.X sg13cmos5l_a221oi_1_0.B2 0
C9923 a_14377_5770# a_14928_5412# 0
C9924 sg13cmos5l_buf_1_34.X sg13cmos5l_buf_1_24.A 0
C9925 sg13cmos5l_inv_1_0.Y sg13cmos5l_o21ai_1_0.Y 0
C9926 sg13cmos5l_dlhr_1_2.Q_N sg13cmos5l_buf_1_25.A 0.00585f
C9927 a_16940_3102# a_16751_2749# 0
C9928 sg13cmos5l_buf_1_4.X a_17008_2630# 0.00487f
C9929 a_7052_9150# a_5988_8440# 0
C9930 a_6568_9224# a_6405_8447# 0.01066f
C9931 sg13cmos5l_dfrbp_1_23.Q_N sg13cmos5l_o21ai_1_0.B1 0
C9932 sg13cmos5l_buf_1_31.X a_620_2352# 0.038f
C9933 a_18272_9318# ph_sw[9] 0
C9934 a_15531_7796# cks 0.00302f
C9935 sg13cmos5l_buf_1_78.X pl_sw[3] 0.48253f
C9936 a_18196_8824# sg13cmos5l_buf_1_105.A 0
C9937 sg13cmos5l_dlhr_1_10.Q_N VPWR 0.26132f
C9938 a_4324_7996# a_4425_7281# 0.00637f
C9939 a_4349_7636# a_4244_6924# 0
C9940 sg13cmos5l_buf_1_31.X a_4244_3900# 0
C9941 sg13cmos5l_dfrbp_1_16.Q sg13cmos5l_dfrbp_1_2.D 0
C9942 sg13cmos5l_buf_1_3.A a_19628_2352# 0.00194f
C9943 sg13cmos5l_inv_1_20.Y a_2804_6924# 0
C9944 sg13cmos5l_nor2_1_0.A a_13572_3151# 0.01085f
C9945 a_15887_8797# a_16271_7751# 0.00707f
C9946 sg13cmos5l_dfrbp_1_22.D a_14726_7674# 0.00348f
C9947 sg13cmos5l_buf_1_4.X a_17126_1626# 0.02002f
C9948 a_5577_2435# sg13cmos5l_buf_1_25.X 0
C9949 sg13cmos5l_buf_1_40.A sg13cmos5l_inv_1_8.Y 0.00251f
C9950 a_9256_9224# a_9673_9240# 0.0033f
C9951 sg13cmos5l_buf_1_90.X a_13768_8436# 0.0018f
C9952 a_10230_4632# sg13cmos5l_dfrbp_1_1.Q 0
C9953 sg13cmos5l_buf_1_79.X a_10665_7281# 0
C9954 a_13047_7690# ph_sw[6] 0
C9955 sg13cmos5l_inv_1_9.Y a_1672_3176# 0
C9956 a_19227_9190# ph_sw[9] 0.00254f
C9957 a_1862_8874# pl_sw[2] 0
C9958 a_682_6892# a_708_6928# 0.43042f
C9959 sg13cmos5l_nor2_1_1.A sg13cmos5l_nor2b_1_1.Y 0.42139f
C9960 sg13cmos5l_buf_1_64.A sg13cmos5l_dfrbp_1_8.RESET_B 0.00239f
C9961 sg13cmos5l_buf_1_3.A a_20296_1664# 0.32797f
C9962 a_16356_7349# VPWR 0.00674f
C9963 sg13cmos5l_dlhr_1_9.D a_8588_3864# 0
C9964 sg13cmos5l_buf_1_65.X a_3574_7850# 0
C9965 a_4847_4727# sg13cmos5l_or2_1_0.A 0.00124f
C9966 sg13cmos5l_buf_1_24.A a_6598_4663# 0
C9967 sg13cmos5l_dfrbp_1_1.Q nh_sw[5] 0.01404f
C9968 a_17584_7166# sg13cmos5l_dfrbp_1_21.Q 0
C9969 a_3016_9318# a_2667_8447# 0
C9970 sg13cmos5l_buf_1_44.A sg13cmos5l_buf_1_25.A 0
C9971 a_2824_2388# a_3008_1758# 0.00304f
C9972 sg13cmos5l_dlhr_1_3.Q_N sg13cmos5l_buf_1_39.A 0.00233f
C9973 a_15884_3102# sg13cmos5l_buf_1_2.X 0.01377f
C9974 sg13cmos5l_buf_1_5.X a_16268_3102# 0.03289f
C9975 sg13cmos5l_inv_1_6.A a_19028_5412# 0.00238f
C9976 sg13cmos5l_buf_1_41.X VPWR 0.28861f
C9977 sg13cmos5l_nor2b_1_0.Y a_14377_5770# 0
C9978 sg13cmos5l_buf_1_101.X sg13cmos5l_dlhr_1_12.D 0.00102f
C9979 sg13cmos5l_inv_1_2.A a_10282_7897# 0
C9980 a_2505_8483# VPWR 0
C9981 a_7312_4142# a_7257_4023# 0.00464f
C9982 a_7892_3900# a_8588_3864# 0.00695f
C9983 sg13cmos5l_inv_1_18.A sg13cmos5l_or2_1_0.A 0.02827f
C9984 a_18164_7996# a_18164_6924# 0
C9985 sg13cmos5l_dfrbp_1_18.Q a_8043_7796# 0.04681f
C9986 sg13cmos5l_inv_1_26.Y cks 0.01862f
C9987 sg13cmos5l_buf_1_68.X sg13cmos5l_buf_1_62.X 0
C9988 sg13cmos5l_inv_1_8.A sg13cmos5l_dfrbp_1_18.Q 0
C9989 sg13cmos5l_dlhr_1_1.Q a_2934_4632# 0.57979f
C9990 sg13cmos5l_buf_1_73.X sg13cmos5l_inv_1_18.A 0
C9991 a_5800_9224# pl_sw[4] 0.2906f
C9992 a_424_9318# rdy 0.02507f
C9993 sg13cmos5l_dlhr_1_0.GATE a_6560_3270# 0.00181f
C9994 sg13cmos5l_dfrbp_1_8.RESET_B a_17545_7728# 0
C9995 a_11464_8436# a_11560_7010# 0.00125f
C9996 sg13cmos5l_dfrbp_1_0.RESET_B a_17508_3138# 0
C9997 sg13cmos5l_dlhr_1_5.D sg13cmos5l_dlhr_1_5.Q 0
C9998 sg13cmos5l_buf_1_96.A a_10665_7281# 0.29516f
C9999 a_16042_6892# a_15974_6162# 0
C10000 a_424_1664# nl_sw[0] 0.0426f
C10001 sg13cmos5l_buf_1_19.X nl_sw[9] 0.21016f
C10002 sg13cmos5l_buf_1_78.A a_5988_6175# 0
C10003 sg13cmos5l_buf_1_19.A VPWR 0.97235f
C10004 sg13cmos5l_inv_1_1.A a_17713_8838# 0
C10005 sg13cmos5l_buf_1_34.X a_3588_4968# 0.04437f
C10006 sg13cmos5l_dlhr_1_0.D sg13cmos5l_buf_1_8.A 0
C10007 a_12896_3270# a_12998_3138# 0
C10008 a_11460_2392# a_11877_2399# 0.49014f
C10009 a_11174_2826# a_11072_2474# 0
C10010 a_13258_3361# a_13701_3117# 0.02241f
C10011 sg13cmos5l_inv_1_27.Y a_14166_7656# 0
C10012 a_8783_7751# a_9202_7674# 0.00176f
C10013 sg13cmos5l_dlhr_1_11.GATE a_13035_6284# 0
C10014 a_12651_9308# ph_sw[5] 0.00112f
C10015 a_15500_9150# cks 0
C10016 sg13cmos5l_buf_1_78.A a_6184_9224# 0.32107f
C10017 sg13cmos5l_buf_1_73.X a_6568_9224# 0.00697f
C10018 a_5800_9224# sg13cmos5l_buf_1_74.X 0
C10019 sg13cmos5l_buf_1_44.A a_5408_3986# 0.06168f
C10020 sg13cmos5l_dfrbp_1_0.CLK a_13701_3117# 0.35504f
C10021 sg13cmos5l_inv_1_2.A sg13cmos5l_and3_1_0.C 0.03055f
C10022 a_18376_2388# a_18122_2388# 0
C10023 a_2380_6162# a_1815_4666# 0
C10024 a_17135_4727# a_17392_4870# 0.35645f
C10025 sg13cmos5l_nor2_1_2.A VPWR 0.43775f
C10026 sg13cmos5l_a22oi_1_1.B1 sg13cmos5l_nor2_1_1.A 0.00192f
C10027 sg13cmos5l_nand2_1_1.B a_14900_2352# 0.00603f
C10028 sg13cmos5l_buf_1_107.X VPWR 0.23256f
C10029 a_1125_6935# cks 0.00228f
C10030 sg13cmos5l_dfrbp_1_6.RESET_B a_18278_8112# 0.00107f
C10031 sg13cmos5l_dfrbp_1_0.D sg13cmos5l_dfrbp_1_0.CLK 0.7979f
C10032 sg13cmos5l_dfrbp_1_6.D a_7796_6460# 0.00569f
C10033 sg13cmos5l_inv_1_3.A sg13cmos5l_o21ai_1_0.B1 0
C10034 sg13cmos5l_a22oi_1_2.B1 a_10696_1758# 0.00219f
C10035 sg13cmos5l_buf_1_31.X a_7430_3576# 0
C10036 sg13cmos5l_buf_1_45.A a_8905_4704# 0.01134f
C10037 a_19344_6484# sg13cmos5l_buf_8_0.A 0
C10038 a_19209_5769# sg13cmos5l_dlhr_1_16.Q_N 0.00294f
C10039 sg13cmos5l_dfrbp_1_6.D a_7520_7010# 0.00382f
C10040 sg13cmos5l_dlhr_1_9.D a_6602_5692# 0
C10041 sg13cmos5l_dfrbp_1_22.D a_17529_7047# 0
C10042 sg13cmos5l_dfrbp_1_6.D a_18480_5028# 0.01062f
C10043 a_12704_4782# a_12721_4261# 0
C10044 sg13cmos5l_buf_1_29.A sg13cmos5l_a221oi_1_0.B1 0
C10045 sg13cmos5l_dlhr_1_6.D sg13cmos5l_a22oi_1_1.B2 0.21505f
C10046 a_9937_8797# a_10282_7897# 0
C10047 sg13cmos5l_dfrbp_1_8.RESET_B sg13cmos5l_dlhr_1_12.D 0
C10048 a_4349_7636# cks 0.01088f
C10049 sg13cmos5l_inv_1_1.A a_15590_4650# 0.00925f
C10050 sg13cmos5l_dlhr_1_15.D a_11752_6294# 0
C10051 a_15012_7992# sg13cmos5l_buf_1_116.A 0
C10052 sg13cmos5l_inv_1_14.A a_6479_2749# 0.00399f
C10053 sg13cmos5l_buf_1_101.X VPWR 0.2554f
C10054 sg13cmos5l_inv_1_2.A a_16677_6141# 0.01737f
C10055 sg13cmos5l_inv_1_8.A a_4244_6924# 0
C10056 sg13cmos5l_dfrbp_1_6.D a_8783_7751# 0
C10057 sg13cmos5l_dfrbp_1_8.RESET_B a_15821_3864# 0.04913f
C10058 sg13cmos5l_buf_1_31.X a_9524_4972# 0.04381f
C10059 sg13cmos5l_buf_1_18.A sg13cmos5l_buf_1_0.A 0.2518f
C10060 a_682_5380# a_1227_5423# 0.00999f
C10061 a_708_5416# a_996_5837# 0.4806f
C10062 sg13cmos5l_dfrbp_1_6.RESET_B a_17894_8436# 0
C10063 sg13cmos5l_dfrbp_1_0.RESET_B sg13cmos5l_dfrbp_1_1.D 0.13169f
C10064 sg13cmos5l_a22oi_1_1.B1 a_10464_2427# 0
C10065 sg13cmos5l_buf_1_111.A a_19412_6484# 0
C10066 sg13cmos5l_dlhr_1_9.D sg13cmos5l_dlhr_1_5.D 0
C10067 sg13cmos5l_buf_1_4.X nh_sw[7] 0
C10068 a_6647_5459# a_6315_3911# 0
C10069 a_3588_4968# a_3599_3215# 0
C10070 sg13cmos5l_buf_1_31.X a_5079_3154# 0.00375f
C10071 a_14996_5412# a_14928_5412# 0
C10072 sg13cmos5l_dfrbp_1_8.RESET_B a_5820_5773# 0.52337f
C10073 a_7226_1636# a_7689_1626# 0.13395f
C10074 a_6889_1680# a_7508_1948# 0.00161f
C10075 sg13cmos5l_inv_1_14.A a_6507_8447# 0.02314f
C10076 sg13cmos5l_dfrbp_1_21.Q a_13072_4142# 0
C10077 sg13cmos5l_buf_1_57.X a_14822_6924# 0
C10078 sg13cmos5l_dfrbp_1_6.RESET_B sg13cmos5l_buf_1_105.A 0.07607f
C10079 a_10010_9196# pl_sw[6] 0
C10080 a_13100_8400# VPWR 0.24945f
C10081 a_9879_9202# a_10292_9508# 0.15652f
C10082 sg13cmos5l_dfrbp_1_16.Q_N sg13cmos5l_buf_1_59.A 0
C10083 sg13cmos5l_dfrbp_1_10.Q sg13cmos5l_buf_1_26.X 0
C10084 sg13cmos5l_dlhr_1_6.D a_12804_6175# 0.00845f
C10085 sg13cmos5l_dfrbp_1_22.D a_16528_7894# 0.02327f
C10086 sg13cmos5l_inv_1_8.A a_7316_3460# 0
C10087 sg13cmos5l_dfrbp_1_6.D a_14583_5770# 0
C10088 sg13cmos5l_dfrbp_1_20.Q_N ph_sw[5] 0
C10089 sg13cmos5l_buf_1_41.A nh_sw[2] 0
C10090 sg13cmos5l_buf_1_65.X a_3692_9150# 0.04362f
C10091 sg13cmos5l_or2_1_0.A sg13cmos5l_buf_1_40.X 0
C10092 sg13cmos5l_inv_1_14.A a_6789_4629# 0.00564f
C10093 sg13cmos5l_inv_1_2.A a_18146_4338# 0
C10094 sg13cmos5l_a22oi_1_1.B2 a_13698_5412# 0.19069f
C10095 sg13cmos5l_buf_1_2.X a_15492_2392# 0.01533f
C10096 a_16268_3102# a_15909_2399# 0.01014f
C10097 sg13cmos5l_buf_1_31.X a_2565_3911# 0
C10098 sg13cmos5l_buf_1_24.X a_5704_1664# 0.33695f
C10099 sg13cmos5l_inv_1_17.A a_5220_2392# 0
C10100 a_3562_4873# a_3302_4650# 0.87117f
C10101 sg13cmos5l_buf_1_110.A a_16068_6928# 0.02245f
C10102 sg13cmos5l_inv_1_2.A a_12841_7728# 0
C10103 a_17498_8800# a_17713_8838# 0.00284f
C10104 a_17161_8794# a_17780_8436# 0.00161f
C10105 a_17367_8794# a_17961_8793# 0.09085f
C10106 sg13cmos5l_buf_1_45.X a_8796_5814# 0
C10107 sg13cmos5l_dfrbp_1_8.D sg13cmos5l_dfrbp_1_21.Q 2.33591f
C10108 sg13cmos5l_buf_1_2.A nl_sw[8] 0.03084f
C10109 sg13cmos5l_dfrbp_1_8.RESET_B VPWR 17.0959f
C10110 a_3974_2388# sg13cmos5l_buf_1_39.A 0
C10111 sg13cmos5l_dlhr_1_6.D sg13cmos5l_a221oi_1_0.A2 0.00131f
C10112 a_11464_9224# a_11464_8436# 0.00912f
C10113 sg13cmos5l_or2_1_1.B a_13072_4142# 0
C10114 sg13cmos5l_dfrbp_1_18.Q a_8276_6924# 0.00386f
C10115 sg13cmos5l_dfrbp_1_6.RESET_B a_17392_4870# 0.01378f
C10116 sg13cmos5l_dlhr_1_11.Q a_13161_7281# 0.30374f
C10117 a_14800_3358# sg13cmos5l_dfrbp_1_0.Q 0.00647f
C10118 sg13cmos5l_inv_1_8.A a_620_2352# 0
C10119 sg13cmos5l_buf_1_111.A a_18856_8436# 0.0023f
C10120 sg13cmos5l_buf_8_0.A a_19227_4654# 0.53974f
C10121 sg13cmos5l_inv_1_0.A sg13cmos5l_a22oi_1_1.B1 0.06045f
C10122 a_8588_3864# a_8296_3986# 0.03269f
C10123 sg13cmos5l_buf_1_45.X sg13cmos5l_buf_1_31.X 0.02475f
C10124 sg13cmos5l_dlhr_1_15.Q sg13cmos5l_dfrbp_1_8.D 0
C10125 sg13cmos5l_inv_1_8.A a_4244_3900# 0.00322f
C10126 a_11567_7751# sg13cmos5l_dlhr_1_6.D 0
C10127 sg13cmos5l_dfrbp_1_23.Q_N a_14714_5776# 0
C10128 a_3308_5376# a_2148_3904# 0
C10129 sg13cmos5l_dfrbp_1_18.Q a_9620_7972# 0.05813f
C10130 a_15414_7354# VPWR 0.25136f
C10131 a_3664_8678# sg13cmos5l_dfrbp_1_16.Q 0
C10132 sg13cmos5l_dfrbp_1_15.D a_1227_6935# 0.01838f
C10133 sg13cmos5l_dlhr_1_1.Q sg13cmos5l_dfrbp_1_9.Q 0.00401f
C10134 sg13cmos5l_buf_1_96.A a_11560_7010# 0.01035f
C10135 a_13100_8400# a_12698_7288# 0
C10136 sg13cmos5l_buf_1_40.A a_1227_6935# 0.05095f
C10137 a_3505_3215# a_3688_1664# 0
C10138 sg13cmos5l_dfrbp_1_6.RESET_B a_7689_1626# 0.49127f
C10139 sg13cmos5l_buf_1_93.X ph_sw[7] 0.04988f
C10140 a_5796_3904# a_6903_3154# 0
C10141 sg13cmos5l_dlhr_1_0.GATE a_7316_2388# 0.00921f
C10142 sg13cmos5l_o21ai_1_0.Y a_13572_3151# 0
C10143 a_12998_3138# a_14543_3215# 0
C10144 a_11877_2399# a_11979_2399# 0.6663f
C10145 a_11460_2392# a_12976_2630# 0.00159f
C10146 sg13cmos5l_buf_1_61.X a_1484_9150# 0.00831f
C10147 sg13cmos5l_buf_1_29.A sg13cmos5l_inv_1_11.Y 0.33836f
C10148 a_424_3270# VPWR 0.13371f
C10149 sg13cmos5l_dlhr_1_15.D a_10318_5412# 0
C10150 a_8043_7796# cks 0.00655f
C10151 a_19340_8400# a_19424_7010# 0
C10152 a_17545_7728# a_18096_7996# 0
C10153 sg13cmos5l_buf_1_38.A sg13cmos5l_buf_1_39.A 0.05453f
C10154 a_1662_8374# VPWR 0.09761f
C10155 sg13cmos5l_inv_1_8.A cks 4.5537f
C10156 sg13cmos5l_dfrbp_1_0.CLK a_15884_3102# 0.00213f
C10157 a_2667_8447# sg13cmos5l_dlhr_1_9.Q_N 0
C10158 a_15590_4650# a_15702_4187# 0
C10159 a_15850_4873# a_15821_3864# 0
C10160 sg13cmos5l_inv_1_17.A a_1862_4338# 0
C10161 sg13cmos5l_a221oi_1_0.C1 a_9524_4972# 0
C10162 sg13cmos5l_buf_1_10.A a_10725_7653# 0
C10163 a_14426_7288# a_14640_6924# 0.01249f
C10164 sg13cmos5l_dlhr_1_5.GATE a_8468_4948# 0
C10165 sg13cmos5l_dfrbp_1_0.RESET_B a_14745_3453# 0.00372f
C10166 sg13cmos5l_dlhr_1_0.GATE a_6198_3120# 0.05279f
C10167 sg13cmos5l_buf_1_8.X a_9823_2364# 0
C10168 a_7863_7282# a_7994_7288# 0.65127f
C10169 sg13cmos5l_a22oi_1_2.B1 a_11364_1626# 0
C10170 a_3625_7282# sg13cmos5l_inv_1_19.A 0
C10171 sg13cmos5l_dfrbp_1_8.RESET_B a_12698_7288# 0
C10172 sg13cmos5l_dlhr_1_9.D a_8041_5770# 0.00858f
C10173 sg13cmos5l_dfrbp_1_6.D sg13cmos5l_dlhr_1_5.Q 0.299f
C10174 a_12216_5728# sg13cmos5l_a221oi_1_0.B1 0.16671f
C10175 sg13cmos5l_buf_1_40.A sg13cmos5l_buf_1_32.A 0.24961f
C10176 sg13cmos5l_dfrbp_1_6.D sg13cmos5l_inv_1_19.A 2.87273f
C10177 sg13cmos5l_buf_1_2.A sg13cmos5l_nand2_1_1.A 0.18233f
C10178 a_10708_9172# pl_sw[6] 0
C10179 sg13cmos5l_dfrbp_1_8.D a_16298_4338# 0
C10180 a_10292_9508# a_10225_9178# 0.0018f
C10181 a_10473_9186# a_10428_9222# 0
C10182 a_9879_9202# sg13cmos5l_buf_1_90.X 0
C10183 a_1672_3176# sg13cmos5l_buf_1_40.X 0
C10184 sg13cmos5l_inv_1_18.A sg13cmos5l_dfrbp_1_2.D 0
C10185 a_17386_1849# nl_sw[9] 0
C10186 a_4753_4727# a_5266_4650# 0
C10187 sg13cmos5l_dfrbp_1_6.D sg13cmos5l_dfrbp_1_20.Q 0.03179f
C10188 a_682_5380# a_1065_5459# 0.00337f
C10189 sg13cmos5l_buf_1_2.A a_16293_4629# 0
C10190 a_8041_5770# a_7892_3900# 0
C10191 a_3588_4968# sg13cmos5l_dfrbp_1_10.Q_N 0
C10192 sg13cmos5l_dlhr_1_12.D a_18096_7996# 0
C10193 a_18486_8866# a_18164_7996# 0
C10194 sg13cmos5l_dfrbp_1_8.RESET_B a_8233_6216# 0
C10195 a_10783_3876# VPWR 0.37827f
C10196 sg13cmos5l_buf_1_30.X a_8680_1664# 0.28943f
C10197 sg13cmos5l_buf_1_79.X a_11464_9224# 0
C10198 sg13cmos5l_buf_1_31.X a_5606_3576# 0
C10199 sg13cmos5l_buf_1_104.X cko 0.01323f
C10200 sg13cmos5l_buf_1_34.X a_3575_6553# 0
C10201 sg13cmos5l_dfrbp_1_8.RESET_B sg13cmos5l_dfrbp_1_11.Q 0.17964f
C10202 a_6889_1680# a_7440_1948# 0
C10203 sg13cmos5l_inv_1_7.A sg13cmos5l_dfrbp_1_0.RESET_B 0.01728f
C10204 sg13cmos5l_inv_1_14.A sg13cmos5l_dfrbp_1_18.Q_N 0
C10205 sg13cmos5l_buf_1_63.A a_620_7638# 0.03692f
C10206 sg13cmos5l_buf_1_4.A sg13cmos5l_nor2_1_1.A 0.02255f
C10207 sg13cmos5l_nand2_1_0.B sg13cmos5l_dfrbp_1_4.D 0.00719f
C10208 sg13cmos5l_dlygate4sd2_1_0.X sg13cmos5l_buf_1_40.X 0.00881f
C10209 a_1948_7964# cks 0.00495f
C10210 a_15850_4873# VPWR 0.09631f
C10211 a_11556_3904# VPWR 0.09022f
C10212 sg13cmos5l_dlhr_1_6.D a_10726_5760# 0
C10213 sg13cmos5l_nor2b_1_0.Y sg13cmos5l_buf_1_7.A 0
C10214 a_17498_8800# a_17894_8436# 0.00949f
C10215 sg13cmos5l_dlhr_1_12.D a_17712_8436# 0
C10216 sg13cmos5l_inv_1_20.Y a_2727_6380# 0
C10217 sg13cmos5l_nor2b_1_0.Y a_10707_2388# 0.00335f
C10218 sg13cmos5l_buf_1_31.X sg13cmos5l_a22oi_1_2.B2 0
C10219 sg13cmos5l_dlhr_1_5.Q a_10024_5498# 0
C10220 a_12549_9165# sg13cmos5l_buf_1_95.X 0.0242f
C10221 sg13cmos5l_dlhr_1_9.D sg13cmos5l_dfrbp_1_6.D 0.02702f
C10222 sg13cmos5l_nand2_1_0.A sg13cmos5l_buf_1_28.X 0.08132f
C10223 a_5132_9150# sg13cmos5l_dfrbp_1_8.RESET_B 0.00233f
C10224 sg13cmos5l_buf_1_31.X a_2314_3361# 0.02284f
C10225 sg13cmos5l_a22oi_1_1.B2 a_15412_5800# 0
C10226 a_8022_3120# sg13cmos5l_buf_1_25.A 0.00661f
C10227 sg13cmos5l_buf_1_45.X sg13cmos5l_a221oi_1_0.C1 0
C10228 sg13cmos5l_dfrbp_1_6.RESET_B a_9865_7282# 0.03182f
C10229 sg13cmos5l_inv_1_17.A sg13cmos5l_dfrbp_1_10.Q 0
C10230 sg13cmos5l_buf_1_2.X a_16011_2399# 0.01848f
C10231 sg13cmos5l_buf_1_6.A nl_sw[8] 0
C10232 a_1576_1758# VPWR 0.12769f
C10233 sg13cmos5l_buf_1_24.X a_5600_1758# 0.05983f
C10234 sg13cmos5l_dlhr_1_1.Q_N a_3396_4650# 0
C10235 sg13cmos5l_dfrbp_1_20.Q a_10024_5498# 0
C10236 sg13cmos5l_dlhr_1_2.D sg13cmos5l_buf_1_26.X 0
C10237 sg13cmos5l_buf_1_57.X a_14708_6924# 0.05023f
C10238 a_17498_8800# sg13cmos5l_buf_1_105.A 0
C10239 a_19227_4654# sg13cmos5l_inv_1_5.A 0.01439f
C10240 sg13cmos5l_dlhr_1_6.D a_11752_6294# 0.00211f
C10241 a_6117_6141# a_6346_4873# 0.0019f
C10242 sg13cmos5l_dfrbp_1_6.D sg13cmos5l_buf_1_33.A 0.0147f
C10243 sg13cmos5l_dlhr_1_11.GATE a_11940_9186# 0
C10244 a_10433_1652# nl_sw[5] 0
C10245 sg13cmos5l_inv_1_8.A a_5079_3154# 0
C10246 a_422_7362# a_1125_6935# 0.02431f
C10247 a_9865_7282# a_10412_6126# 0.001f
C10248 sg13cmos5l_dfrbp_1_21.Q_N a_19412_6484# 0
C10249 a_11464_9224# sg13cmos5l_buf_1_96.A 0
C10250 sg13cmos5l_buf_1_97.A a_13100_8400# 0
C10251 sg13cmos5l_a221oi_1_0.B2 sg13cmos5l_dfrbp_1_0.RESET_B 0.01722f
C10252 sg13cmos5l_dfrbp_1_8.RESET_B a_1967_7285# 0.00918f
C10253 sg13cmos5l_dfrbp_1_20.Q_N sg13cmos5l_buf_1_31.X 0.01028f
C10254 a_10071_7282# a_9865_7282# 0.2777f
C10255 sg13cmos5l_dfrbp_1_1.Q a_18122_2388# 0
C10256 a_8972_9150# cks 0
C10257 a_18096_7996# VPWR 0
C10258 sg13cmos5l_inv_1_3.A a_14194_6162# 0
C10259 sg13cmos5l_buf_1_93.X a_14820_7674# 0
C10260 a_16748_9150# a_16271_7751# 0
C10261 sg13cmos5l_dlhr_1_11.D sg13cmos5l_dlhr_1_6.D 0
C10262 a_6602_5692# a_6647_5459# 0.36169f
C10263 sg13cmos5l_dfrbp_1_23.Q_N a_15177_5769# 0
C10264 sg13cmos5l_inv_1_26.Y pl_sw[9] 0.39657f
C10265 sg13cmos5l_dfrbp_1_15.D sg13cmos5l_dfrbp_1_16.Q 0.36181f
C10266 a_10534_7687# sg13cmos5l_dlhr_1_5.Q 0
C10267 sg13cmos5l_buf_1_31.X a_2409_4650# 0
C10268 sg13cmos5l_buf_1_65.X a_2621_7636# 0
C10269 sg13cmos5l_inv_1_0.A a_13486_5412# 0.00139f
C10270 sg13cmos5l_buf_1_40.A sg13cmos5l_dfrbp_1_16.Q 0
C10271 sg13cmos5l_or2_1_0.A a_14900_2352# 0
C10272 a_8276_6924# cks 0
C10273 a_17584_7166# a_17519_6239# 0
C10274 sg13cmos5l_dfrbp_1_8.D a_16234_6385# 0
C10275 a_16164_4663# cks 0
C10276 ph_sw[2] sg13cmos5l_buf_1_62.X 0
C10277 sg13cmos5l_dlhr_1_0.GATE sg13cmos5l_dlhr_1_0.D 0.8838f
C10278 a_7055_4261# a_6903_3154# 0
C10279 sg13cmos5l_dlhr_1_11.Q a_13641_7674# 0.03065f
C10280 a_6315_3911# a_7034_3148# 0
C10281 a_11979_2399# a_12976_2630# 0.07046f
C10282 a_3578_2752# sg13cmos5l_buf_1_39.A 0.0043f
C10283 sg13cmos5l_buf_1_41.X sg13cmos5l_buf_1_25.X 0
C10284 sg13cmos5l_dlhr_1_9.D a_10024_5498# 0.00193f
C10285 a_13803_3260# sg13cmos5l_buf_1_5.X 0
C10286 a_14543_3215# a_14800_3358# 0.35645f
C10287 sg13cmos5l_dfrbp_1_0.CLK a_15492_2392# 0.10472f
C10288 sg13cmos5l_buf_1_34.X a_4753_4727# 0.00872f
C10289 sg13cmos5l_nor2b_1_0.Y sg13cmos5l_a22oi_1_0.Y 0.02095f
C10290 sg13cmos5l_buf_1_79.X sg13cmos5l_buf_1_5.A 0
C10291 a_6184_9224# cks 0
C10292 sg13cmos5l_dfrbp_1_20.Q a_10534_7687# 0
C10293 sg13cmos5l_inv_1_27.Y a_15369_8065# 0
C10294 a_5770_3868# a_5637_2399# 0
C10295 sg13cmos5l_dfrbp_1_8.RESET_B a_16260_6480# 0.02698f
C10296 sg13cmos5l_inv_1_8.A a_2565_3911# 0.36027f
C10297 a_1192_1664# a_1864_1664# 0.00277f
C10298 a_7863_7282# a_8247_5770# 0
C10299 VPWR ph_sw[10] 0.27021f
C10300 a_10225_9178# sg13cmos5l_buf_1_90.X 0
C10301 sg13cmos5l_buf_1_97.A sg13cmos5l_dfrbp_1_8.RESET_B 1.19127f
C10302 a_17712_8436# VPWR 0
C10303 sg13cmos5l_dfrbp_1_24.Q_N a_14152_8522# 0
C10304 a_9620_7972# cks 0.00329f
C10305 a_18870_7656# sg13cmos5l_dlhr_1_15.Q_N 0.12876f
C10306 sg13cmos5l_buf_1_64.A sg13cmos5l_dfrbp_1_6.RESET_B 0
C10307 a_3826_8874# sg13cmos5l_dlhr_1_9.Q 0
C10308 a_2748_6126# a_3562_4873# 0
C10309 sg13cmos5l_buf_1_10.A a_12404_7972# 0
C10310 a_13100_8400# a_13047_7690# 0.00249f
C10311 sg13cmos5l_dfrbp_1_1.Q sg13cmos5l_buf_1_4.X 0.01828f
C10312 a_1967_5773# a_2228_4972# 0.01097f
C10313 a_2804_5412# a_2409_4650# 0.00543f
C10314 sg13cmos5l_buf_1_43.A sg13cmos5l_or2_1_0.A 0.04345f
C10315 sg13cmos5l_buf_1_44.X ph_sw[2] 0.02602f
C10316 sg13cmos5l_buf_1_94.X sg13cmos5l_dfrbp_1_24.Q_N 0
C10317 sg13cmos5l_nand2_1_1.A sg13cmos5l_buf_1_6.A 0
C10318 sg13cmos5l_buf_1_8.X a_12719_2749# 0
C10319 a_2054_3138# a_2732_1590# 0
C10320 sg13cmos5l_dfrbp_1_6.RESET_B a_4456_1664# 0
C10321 sg13cmos5l_buf_1_45.X a_8043_7796# 0.05582f
C10322 a_10464_2427# a_11434_2356# 0.00289f
C10323 sg13cmos5l_dfrbp_1_4.D a_11174_2826# 0.31372f
C10324 a_1227_5423# sg13cmos5l_dlygate4sd2_1_0.A 0
C10325 sg13cmos5l_inv_1_8.A sg13cmos5l_buf_1_45.X 0
C10326 sg13cmos5l_buf_1_34.X sg13cmos5l_buf_1_31.X 0.02762f
C10327 sg13cmos5l_buf_1_19.A a_18356_6460# 0
C10328 sg13cmos5l_dfrbp_1_0.Q VPWR 0.98603f
C10329 sg13cmos5l_dfrbp_1_0.Q nl_sw[7] 0.00235f
C10330 sg13cmos5l_buf_1_5.A a_12815_4261# 0
C10331 a_3976_9224# pl_sw[2] 0.00244f
C10332 sg13cmos5l_inv_1_18.A a_9291_8447# 0.03208f
C10333 a_708_6928# cks 0.06328f
C10334 a_3609_4023# sg13cmos5l_buf_1_44.A 0
C10335 sg13cmos5l_buf_1_38.A a_5510_4338# 0
C10336 a_620_2352# sg13cmos5l_buf_1_32.X 0.3217f
C10337 a_16751_2749# nl_sw[8] 0
C10338 sg13cmos5l_buf_1_2.A sg13cmos5l_dfrbp_1_0.D 0
C10339 a_14426_7288# a_14641_7326# 0.00284f
C10340 a_14295_7282# a_14889_7281# 0.09085f
C10341 a_14089_7282# a_14708_6924# 0.00161f
C10342 sg13cmos5l_a221oi_1_0.C1 sg13cmos5l_a22oi_1_2.B2 0.31513f
C10343 sg13cmos5l_a221oi_1_0.A2 a_8972_3864# 0
C10344 sg13cmos5l_buf_1_65.X ph_sw[1] 0.00684f
C10345 sg13cmos5l_dfrbp_1_6.RESET_B a_17545_7728# 0.01104f
C10346 sg13cmos5l_dfrbp_1_8.RESET_B a_13047_7690# 0
C10347 sg13cmos5l_buf_1_96.A sg13cmos5l_buf_1_5.A 0
C10348 sg13cmos5l_buf_1_41.A sg13cmos5l_dlhr_1_1.Q 0.27311f
C10349 sg13cmos5l_buf_1_30.X sg13cmos5l_dlhr_1_0.Q_N 0
C10350 sg13cmos5l_buf_1_65.X a_1000_9224# 0.01135f
C10351 sg13cmos5l_buf_1_77.X VPWR 0.27271f
C10352 a_18961_5814# a_19028_5412# 0.0018f
C10353 sg13cmos5l_buf_1_45.A a_8468_4948# 0
C10354 a_8660_5412# sg13cmos5l_dfrbp_1_12.Q_N 0.00539f
C10355 a_12896_3270# VPWR 0.08032f
C10356 a_7689_1626# a_7924_1612# 0.00566f
C10357 a_7508_1948# a_7644_1662# 0.00404f
C10358 a_8680_1664# sg13cmos5l_dlhr_1_0.Q_N 0.0698f
C10359 a_9832_1664# a_10888_1664# 0.00155f
C10360 sg13cmos5l_buf_1_77.A a_9705_4650# 0
C10361 a_682_5380# a_996_5837# 0.00659f
C10362 a_708_5416# a_934_5837# 0.00523f
C10363 sg13cmos5l_buf_1_19.A ph_sw[9] 0.01611f
C10364 sg13cmos5l_dfrbp_1_1.Q sg13cmos5l_buf_1_28.X 0.06569f
C10365 a_1664_7806# cks 0
C10366 sg13cmos5l_dfrbp_1_15.D a_4005_4629# 0.00119f
C10367 a_17135_4727# VPWR 0.25813f
C10368 sg13cmos5l_buf_1_63.X sg13cmos5l_buf_1_40.A 0.00316f
C10369 sg13cmos5l_buf_1_111.A sg13cmos5l_dfrbp_1_8.D 0
C10370 a_17108_7972# ph_sw[8] 0
C10371 sg13cmos5l_dfrbp_1_6.D a_18615_5770# 0.00244f
C10372 sg13cmos5l_dfrbp_1_21.Q a_17972_4948# 0.00418f
C10373 sg13cmos5l_and3_1_0.C a_13520_4696# 0.00202f
C10374 sg13cmos5l_dlhr_1_9.D a_4950_7354# 0.05216f
C10375 sg13cmos5l_buf_1_41.A a_1997_6126# 0.00122f
C10376 a_16268_3102# nh_sw[7] 0
C10377 sg13cmos5l_buf_1_10.A sg13cmos5l_nand2_1_1.B 0
C10378 sg13cmos5l_and3_1_0.C a_11530_3868# 0
C10379 a_12814_4692# a_11556_3904# 0
C10380 sg13cmos5l_inv_1_27.Y sg13cmos5l_buf_1_95.X 0.02569f
C10381 sg13cmos5l_inv_1_5.A a_20392_3900# 0.31501f
C10382 sg13cmos5l_dfrbp_1_23.CLK sg13cmos5l_inv_1_0.A 0.00305f
C10383 sg13cmos5l_dlhr_1_11.GATE sg13cmos5l_inv_1_7.A 0.39895f
C10384 sg13cmos5l_buf_1_31.X a_3599_3215# 0.01563f
C10385 sg13cmos5l_dlhr_1_2.Q_N sg13cmos5l_buf_1_26.A 0.01467f
C10386 sg13cmos5l_dlhr_1_2.Q sg13cmos5l_buf_1_25.A 0.03195f
C10387 sg13cmos5l_dfrbp_1_6.RESET_B a_10900_7312# 0.00452f
C10388 a_7226_1636# VPWR 0.36106f
C10389 sg13cmos5l_inv_1_2.A a_14726_7674# 0
C10390 sg13cmos5l_dfrbp_1_9.Q a_3876_4663# 0.00189f
C10391 sg13cmos5l_buf_1_74.X a_6405_8447# 0.00616f
C10392 sg13cmos5l_buf_1_107.X ph_sw[9] 0.02068f
C10393 sg13cmos5l_buf_1_110.A sg13cmos5l_dfrbp_1_8.D 0.00225f
C10394 sg13cmos5l_buf_1_57.X sg13cmos5l_buf_1_89.A 0.0031f
C10395 sg13cmos5l_dfrbp_1_6.RESET_B sg13cmos5l_dlhr_1_12.D 0.01872f
C10396 a_8084_8436# a_8043_7796# 0
C10397 sg13cmos5l_buf_1_5.A sg13cmos5l_a221oi_1_0.B1 0
C10398 a_6959_6239# a_6789_4629# 0.00564f
C10399 sg13cmos5l_dlhr_1_6.D a_12324_6162# 0
C10400 sg13cmos5l_inv_1_8.A a_8084_8436# 0
C10401 sg13cmos5l_or2_1_0.A a_5510_4338# 0.01656f
C10402 sg13cmos5l_dfrbp_1_6.RESET_B a_15821_3864# 0.20032f
C10403 sg13cmos5l_buf_1_40.A sg13cmos5l_inv_1_9.Y 0.09082f
C10404 sg13cmos5l_dfrbp_1_21.Q a_13324_4696# 0
C10405 sg13cmos5l_dfrbp_1_21.Q_N a_19548_6198# 0
C10406 sg13cmos5l_buf_1_34.X a_4349_7636# 0.02272f
C10407 sg13cmos5l_dfrbp_1_23.CLK a_12490_6385# 0.0022f
C10408 sg13cmos5l_buf_1_101.X ph_sw[9] 0.05939f
C10409 sg13cmos5l_buf_1_43.A a_1672_3176# 0
C10410 sg13cmos5l_nand2_1_1.A a_16751_2749# 0
C10411 a_13486_5760# sg13cmos5l_a22oi_1_1.B2 0.01681f
C10412 sg13cmos5l_and3_1_0.X a_13792_5760# 0
C10413 a_4873_3192# sg13cmos5l_buf_1_25.A 0
C10414 a_11473_7751# sg13cmos5l_inv_1_29.A 0
C10415 sg13cmos5l_dfrbp_1_6.RESET_B a_5820_5773# 0.01892f
C10416 sg13cmos5l_inv_1_17.A a_4566_2818# 0
C10417 sg13cmos5l_buf_8_1.A a_17224_3270# 0
C10418 sg13cmos5l_inv_1_8.A a_5266_4650# 0
C10419 sg13cmos5l_buf_1_28.A nl_sw[5] 0
C10420 a_10230_4632# sg13cmos5l_dlhr_1_20.Q_N 0.12876f
C10421 sg13cmos5l_nor2_1_0.A a_13234_4338# 0
C10422 sg13cmos5l_inv_1_20.Y a_3676_7964# 0.00277f
C10423 sg13cmos5l_dfrbp_1_8.D a_17519_6239# 0.02361f
C10424 a_6315_3911# a_6560_3270# 0
C10425 sg13cmos5l_buf_1_10.A a_12230_6162# 0.02468f
C10426 sg13cmos5l_inv_1_8.A a_2314_3361# 0
C10427 a_12976_2630# sg13cmos5l_dfrbp_1_4.Q_N 0.15881f
C10428 sg13cmos5l_dfrbp_1_0.CLK a_16011_2399# 0.01816f
C10429 sg13cmos5l_buf_1_34.A sg13cmos5l_buf_1_39.A 0.05551f
C10430 sg13cmos5l_buf_1_73.A sg13cmos5l_inv_1_18.A 0
C10431 a_8204_9150# sg13cmos5l_buf_1_77.A 0
C10432 sg13cmos5l_buf_1_45.X a_8972_9150# 0
C10433 a_3860_2388# nl_sw[2] 0
C10434 sg13cmos5l_buf_1_37.A VPWR 0.62438f
C10435 a_14628_8440# pl_sw[7] 0
C10436 a_6213_3911# a_5739_2399# 0.00238f
C10437 sg13cmos5l_buf_1_111.A a_17780_8436# 0
C10438 a_17896_9224# a_17961_8793# 0.00121f
C10439 sg13cmos5l_nor2_1_0.A a_13520_4696# 0.00926f
C10440 sg13cmos5l_dfrbp_1_15.D a_996_7349# 0
C10441 sg13cmos5l_inv_1_17.A a_2757_3117# 0.00303f
C10442 sg13cmos5l_nor2_1_0.A a_11530_3868# 0
C10443 ph_sw[0] pl_sw[2] 0.00443f
C10444 pl_sw[1] ph_sw[1] 0.14234f
C10445 sg13cmos5l_buf_1_40.A a_996_7349# 0.02341f
C10446 a_10022_7674# a_10116_7674# 0.00718f
C10447 sg13cmos5l_buf_1_45.X a_8276_6924# 0.02984f
C10448 sg13cmos5l_dfrbp_1_0.CLK a_16936_1758# 0
C10449 a_14612_6460# a_14714_5776# 0
C10450 pl_sw[1] a_1000_9224# 0.2906f
C10451 sg13cmos5l_buf_1_103.A cks 0
C10452 sg13cmos5l_or2_1_1.B a_13324_4696# 0.01168f
C10453 sg13cmos5l_dfrbp_1_0.CLK a_16703_3871# 0
C10454 sg13cmos5l_inv_1_14.A a_7336_9224# 0.00586f
C10455 sg13cmos5l_buf_1_74.X a_8204_9150# 0.29561f
C10456 sg13cmos5l_buf_1_73.X sg13cmos5l_buf_1_77.A 0
C10457 sg13cmos5l_buf_1_73.X pl_sw[4] 0.01706f
C10458 a_11464_8436# ph_sw[5] 0
C10459 a_17135_4727# a_17554_4650# 0.00176f
C10460 sg13cmos5l_buf_1_18.X nl_sw[9] 0.01857f
C10461 sg13cmos5l_dfrbp_1_6.RESET_B VPWR 22.5133f
C10462 sg13cmos5l_inv_1_1.A sg13cmos5l_dlhr_1_12.D 0
C10463 sg13cmos5l_buf_1_6.A a_13701_3117# 0
C10464 a_5796_3904# a_5673_3138# 0
C10465 a_5770_3868# a_5492_3460# 0.00602f
C10466 a_5408_3986# a_4873_3192# 0.00251f
C10467 sg13cmos5l_dfrbp_1_4.D a_11072_2474# 0.08149f
C10468 a_4076_5376# a_4950_5699# 0
C10469 sg13cmos5l_buf_1_31.X a_10220_3102# 0
C10470 sg13cmos5l_inv_1_8.A a_2409_4650# 0.01706f
C10471 a_17751_7690# a_17545_7728# 0.27532f
C10472 sg13cmos5l_buf_1_2.A a_15884_3102# 0.00376f
C10473 sg13cmos5l_dfrbp_1_6.D a_6647_5459# 0
C10474 sg13cmos5l_buf_1_3.X nl_sw[10] 0
C10475 sg13cmos5l_buf_1_73.X sg13cmos5l_buf_1_74.X 0.00835f
C10476 sg13cmos5l_buf_1_76.X a_7052_9150# 0.29592f
C10477 sg13cmos5l_buf_1_5.A sg13cmos5l_nand2_1_1.A 0.23231f
C10478 sg13cmos5l_buf_1_18.A a_17008_2630# 0
C10479 a_17700_1639# nl_sw[9] 0.00608f
C10480 a_10412_6126# VPWR 0.3383f
C10481 a_1862_8874# sg13cmos5l_dfrbp_1_16.Q_N 0
C10482 a_6086_4650# a_6213_3911# 0
C10483 a_6372_4968# a_5796_3904# 0
C10484 a_10071_7282# VPWR 0.18166f
C10485 sg13cmos5l_buf_1_8.X a_10464_2427# 0.00578f
C10486 a_4950_7354# sg13cmos5l_dlhr_1_7.Q_N 0.12876f
C10487 sg13cmos5l_dfrbp_1_8.RESET_B a_3945_5041# 0
C10488 a_19209_5769# sg13cmos5l_dlhr_1_16.Q 0.28714f
C10489 a_8247_5770# sg13cmos5l_buf_1_46.A 0.00133f
C10490 a_14543_3215# VPWR 0.27228f
C10491 sg13cmos5l_buf_1_0.X a_20012_1590# 0.31326f
C10492 sg13cmos5l_dfrbp_1_8.D sg13cmos5l_a22oi_1_1.Y 0.00317f
C10493 sg13cmos5l_dlhr_1_9.Q ph_sw[2] 0.002f
C10494 sg13cmos5l_dlhr_1_15.D sg13cmos5l_inv_1_29.Y 0.00139f
C10495 sg13cmos5l_buf_1_110.A a_15876_4968# 0
C10496 a_7247_8797# pl_sw[4] 0
C10497 sg13cmos5l_dfrbp_1_6.D a_19209_5769# 0
C10498 sg13cmos5l_buf_1_18.A sg13cmos5l_buf_8_0.A 0.2308f
C10499 sg13cmos5l_buf_1_34.X sg13cmos5l_inv_1_8.A 0.18599f
C10500 sg13cmos5l_dfrbp_1_16.Q a_10331_3900# 0
C10501 a_17700_3456# d_out[1] 0
C10502 a_17498_8800# a_17545_7728# 0
C10503 sg13cmos5l_dlhr_1_12.D a_17751_7690# 0
C10504 sg13cmos5l_buf_1_31.X sg13cmos5l_dfrbp_1_10.Q_N 0.21655f
C10505 sg13cmos5l_dfrbp_1_6.RESET_B a_12698_7288# 0.04624f
C10506 sg13cmos5l_dfrbp_1_20.Q a_10587_4692# 0
C10507 a_9832_1664# VPWR 0.24919f
C10508 sg13cmos5l_buf_1_74.X a_7247_8797# 0.00196f
C10509 sg13cmos5l_inv_1_2.A a_16528_7894# 0.04308f
C10510 a_15784_1664# nl_sw[8] 0.01603f
C10511 sg13cmos5l_inv_1_1.A VPWR 0.73134f
C10512 sg13cmos5l_buf_1_25.A a_8588_2352# 0.00391f
C10513 a_8772_8440# a_7941_7653# 0
C10514 a_8746_8404# a_8043_7796# 0
C10515 sg13cmos5l_buf_1_10.A a_11771_5412# 0
C10516 a_11182_4676# VPWR 0
C10517 a_7796_6460# a_7631_4727# 0
C10518 sg13cmos5l_or2_1_0.A a_6084_4325# 0.00259f
C10519 a_15206_2826# a_15300_2826# 0.00718f
C10520 sg13cmos5l_dfrbp_1_6.RESET_B a_16551_3987# 0.55322f
C10521 sg13cmos5l_dfrbp_1_21.Q a_12520_4782# 0
C10522 a_16260_6480# a_17135_4727# 0
C10523 sg13cmos5l_buf_1_79.X ph_sw[5] 0.47837f
C10524 sg13cmos5l_nor2b_1_0.Y a_10613_2758# 0.01197f
C10525 sg13cmos5l_dfrbp_1_23.CLK a_13775_6239# 0.02839f
C10526 sg13cmos5l_nand2_1_0.A a_11270_4338# 0.00119f
C10527 sg13cmos5l_dfrbp_1_0.Q a_17769_2017# 0
C10528 sg13cmos5l_dlhr_1_10.Q a_20118_6144# 0.56969f
C10529 a_11190_7354# sg13cmos5l_dlhr_1_18.Q_N 0.12876f
C10530 a_10484_6924# a_10598_6924# 0.00122f
C10531 sg13cmos5l_inv_1_20.Y sg13cmos5l_inv_1_17.A 0.3181f
C10532 sg13cmos5l_dfrbp_1_6.RESET_B a_8233_6216# 0.00815f
C10533 sg13cmos5l_dfrbp_1_8.RESET_B a_2380_6162# 0.17543f
C10534 sg13cmos5l_nand2_1_1.A a_18760_2388# 0
C10535 sg13cmos5l_and3_1_0.X a_14152_5498# 0.04012f
C10536 sg13cmos5l_dlhr_1_11.GATE a_10868_8436# 0.13308f
C10537 sg13cmos5l_dfrbp_1_6.RESET_B sg13cmos5l_dfrbp_1_11.Q 0.46439f
C10538 a_7034_3148# a_7249_3130# 0.00284f
C10539 a_7497_3138# sg13cmos5l_dlhr_1_2.Q_N 0.00294f
C10540 sg13cmos5l_buf_1_5.X a_15909_2399# 0.00876f
C10541 sg13cmos5l_dfrbp_1_6.RESET_B a_17554_4650# 0
C10542 a_8378_5776# sg13cmos5l_a221oi_1_0.A2 0
C10543 a_19227_9190# sg13cmos5l_inv_1_6.A 0.00679f
C10544 sg13cmos5l_buf_1_0.A a_17126_1626# 0
C10545 a_15821_3864# a_15206_2826# 0
C10546 a_422_7362# a_708_6928# 0.50066f
C10547 a_17498_8800# sg13cmos5l_dlhr_1_12.D 0
C10548 sg13cmos5l_dfrbp_1_15.D a_3669_6320# 0
C10549 sg13cmos5l_dfrbp_1_0.D a_16751_2749# 0.0012f
C10550 sg13cmos5l_dlhr_1_9.D a_10587_4692# 0.19341f
C10551 sg13cmos5l_dfrbp_1_8.D sg13cmos5l_dfrbp_1_21.Q_N 0.47766f
C10552 sg13cmos5l_nor2_1_0.A a_12022_3134# 0
C10553 a_10292_9508# a_10282_7897# 0
C10554 sg13cmos5l_dfrbp_1_18.Q a_10827_7796# 0
C10555 sg13cmos5l_dfrbp_1_0.CLK sg13cmos5l_dfrbp_1_5.Q_N 0.004f
C10556 sg13cmos5l_buf_1_10.A a_14032_6382# 0
C10557 sg13cmos5l_inv_1_8.A a_3599_3215# 0
C10558 sg13cmos5l_inv_1_28.Y a_11464_8436# 0.01463f
C10559 a_7055_4261# sg13cmos5l_dfrbp_1_10.Q 0
C10560 a_15887_8797# pl_sw[7] 0
C10561 a_6213_3911# a_6385_2749# 0
C10562 sg13cmos5l_dfrbp_1_0.Q a_14056_1664# 0
C10563 sg13cmos5l_inv_1_26.Y a_19340_8400# 0.00256f
C10564 sg13cmos5l_buf_8_0.A sg13cmos5l_buf_1_0.A 0.22488f
C10565 a_416_7806# sg13cmos5l_dfrbp_1_6.D 0.00158f
C10566 a_15702_4187# a_15821_3864# 0.1333f
C10567 sg13cmos5l_dfrbp_1_0.D a_17412_1944# 0.02637f
C10568 sg13cmos5l_inv_1_17.A a_3801_3453# 0.0016f
C10569 a_5132_9150# sg13cmos5l_dfrbp_1_6.RESET_B 0
C10570 sg13cmos5l_nor2b_1_0.Y sg13cmos5l_nand2_1_1.B 0.6316f
C10571 a_17751_7690# VPWR 0.18166f
C10572 a_10827_7796# a_11769_7989# 0
C10573 a_10308_7992# a_10534_7687# 0.00523f
C10574 a_10725_7653# a_10596_7687# 0.01562f
C10575 sg13cmos5l_dfrbp_1_0.CLK a_18671_1703# 0.00289f
C10576 a_15208_6200# a_14996_5412# 0.0096f
C10577 sg13cmos5l_dfrbp_1_20.Q_N a_9620_7972# 0.25747f
C10578 a_8905_4704# a_8972_3864# 0
C10579 sg13cmos5l_or2_1_1.B a_12520_4782# 0
C10580 sg13cmos5l_inv_1_8.A a_2122_8404# 0
C10581 sg13cmos5l_dfrbp_1_0.CLK a_18363_4270# 0.00276f
C10582 sg13cmos5l_buf_1_96.A ph_sw[5] 0
C10583 a_7657_7282# cks 0
C10584 sg13cmos5l_buf_1_2.A a_15492_2392# 0.04042f
C10585 sg13cmos5l_dfrbp_1_10.Q_N a_3212_1590# 0
C10586 sg13cmos5l_dlhr_1_9.D a_6086_4650# 0.00734f
C10587 a_3505_3215# sg13cmos5l_buf_1_39.A 0
C10588 sg13cmos5l_a22oi_1_2.B2 sg13cmos5l_nand2_1_0.B 0.00307f
C10589 a_5796_3904# sg13cmos5l_dlhr_1_2.D 0
C10590 a_11973_3911# sg13cmos5l_buf_1_8.A 0
C10591 sg13cmos5l_dfrbp_1_2.Q_N sg13cmos5l_a22oi_1_1.Y 0
C10592 a_13701_3117# a_12815_1703# 0
C10593 sg13cmos5l_dfrbp_1_8.RESET_B sg13cmos5l_dlhr_1_5.GATE 0.39362f
C10594 sg13cmos5l_dfrbp_1_6.RESET_B a_1967_7285# 0.22052f
C10595 a_4950_5699# sg13cmos5l_dfrbp_1_29.Q_N 0.25039f
C10596 a_5452_5850# a_5820_5773# 0.00294f
C10597 sg13cmos5l_buf_1_19.A a_18860_6888# 0.03015f
C10598 a_18345_7674# a_18870_7656# 0.13715f
C10599 a_17882_7684# sg13cmos5l_dlhr_1_15.Q 0
C10600 sg13cmos5l_inv_1_8.A sg13cmos5l_dlhr_1_1.Q_N 0.05737f
C10601 sg13cmos5l_dfrbp_1_15.D a_2554_8112# 0
C10602 a_4244_8436# a_4324_7996# 0.00104f
C10603 a_14342_8874# a_14152_8522# 0.00201f
C10604 a_14602_8404# a_14628_8440# 0.43042f
C10605 a_524_4614# sg13cmos5l_or2_1_0.A 0
C10606 a_2667_8447# sg13cmos5l_dfrbp_1_16.Q_N 0
C10607 sg13cmos5l_buf_1_38.A a_6153_3947# 0
C10608 sg13cmos5l_buf_1_18.A a_18376_2388# 0.33346f
C10609 sg13cmos5l_buf_1_3.A sg13cmos5l_dlhr_1_16.Q_N 0.00263f
C10610 sg13cmos5l_buf_1_5.A a_13701_3117# 0.02674f
C10611 a_15206_2826# VPWR 0.9321f
C10612 a_6789_4629# a_7312_4142# 0
C10613 a_6891_4772# a_6315_3911# 0
C10614 a_6372_4968# a_7055_4261# 0
C10615 a_996_5837# sg13cmos5l_dlygate4sd2_1_0.A 0
C10616 sg13cmos5l_dfrbp_1_8.RESET_B a_14536_7806# 0.00384f
C10617 sg13cmos5l_dfrbp_1_6.D a_11824_7894# 0
C10618 sg13cmos5l_dfrbp_1_0.RESET_B sg13cmos5l_buf_1_2.X 0.16285f
C10619 sg13cmos5l_buf_1_9.A a_9823_2364# 0.00473f
C10620 sg13cmos5l_buf_1_10.A sg13cmos5l_or2_1_0.A 0.02805f
C10621 sg13cmos5l_dfrbp_1_8.RESET_B a_5684_4948# 0.0012f
C10622 sg13cmos5l_buf_1_18.A a_18928_1846# 0
C10623 a_17498_8800# VPWR 0.359f
C10624 a_16552_1664# VPWR 0.25033f
C10625 sg13cmos5l_buf_1_18.A sg13cmos5l_inv_1_5.A 0
C10626 sg13cmos5l_buf_1_40.A sg13cmos5l_buf_1_40.X 0.56489f
C10627 a_16552_1664# nl_sw[7] 0
C10628 a_682_6892# cks 0.03308f
C10629 sg13cmos5l_dfrbp_1_6.RESET_B a_16260_6480# 0.51899f
C10630 a_15702_4187# VPWR 0.35993f
C10631 a_620_2352# a_416_2474# 0.03376f
C10632 sg13cmos5l_dfrbp_1_6.RESET_B sg13cmos5l_buf_1_97.A 0.28826f
C10633 sg13cmos5l_inv_1_29.A sg13cmos5l_inv_1_0.Y 0
C10634 a_12132_9504# sg13cmos5l_dfrbp_1_23.CLK 0
C10635 a_13391_9263# a_13593_9501# 0.00675f
C10636 a_12651_9308# a_13297_9263# 0.00667f
C10637 sg13cmos5l_buf_1_77.A a_8580_8874# 0
C10638 a_8972_9150# a_8746_8404# 0
C10639 a_2122_8404# a_1948_7964# 0.00704f
C10640 a_4244_3900# a_4640_3986# 0.03121f
C10641 a_3407_4261# sg13cmos5l_buf_1_44.A 0
C10642 a_14726_7674# a_14889_7281# 0
C10643 a_5452_5850# VPWR 0.14703f
C10644 sg13cmos5l_dfrbp_1_0.RESET_B a_12721_4261# 0
C10645 a_10783_4292# a_10783_3876# 0
C10646 a_19796_3436# d_out[1] 0.00309f
C10647 sg13cmos5l_buf_1_28.A a_9164_1590# 0.01832f
C10648 a_3625_7282# a_3488_7010# 0.00973f
C10649 a_3831_7282# a_4177_7326# 0.00722f
C10650 a_422_5850# a_1227_5423# 0.11742f
C10651 sg13cmos5l_buf_1_79.X sg13cmos5l_inv_1_28.Y 0.01772f
C10652 sg13cmos5l_dfrbp_1_6.RESET_B sg13cmos5l_dlhr_1_11.Q_N 0.03703f
C10653 sg13cmos5l_buf_1_64.A a_3016_9318# 0
C10654 a_7924_1612# VPWR 0
C10655 sg13cmos5l_buf_1_63.X a_620_7638# 0.32553f
C10656 sg13cmos5l_o21ai_1_0.A1 a_12075_3911# 0.00904f
C10657 a_13418_4696# sg13cmos5l_dfrbp_1_0.RESET_B 0
C10658 sg13cmos5l_dfrbp_1_0.Q a_20012_2352# 0.00165f
C10659 sg13cmos5l_inv_1_14.A sg13cmos5l_dfrbp_1_8.RESET_B 1.31582f
C10660 sg13cmos5l_buf_1_24.A a_6681_2511# 0.00387f
C10661 a_9189_8447# a_8783_7751# 0.0091f
C10662 sg13cmos5l_dlhr_1_6.D a_8468_4948# 0
C10663 sg13cmos5l_or2_1_0.A a_6153_3947# 0
C10664 sg13cmos5l_dfrbp_1_6.RESET_B a_16462_4023# 0.00343f
C10665 sg13cmos5l_buf_1_0.A a_18376_2388# 0
C10666 sg13cmos5l_dlhr_1_10.Q a_19828_6148# 0
C10667 a_13803_3260# nh_sw[7] 0
C10668 sg13cmos5l_dfrbp_1_6.RESET_B a_13047_7690# 0.00119f
C10669 sg13cmos5l_dfrbp_1_8.RESET_B a_4652_6126# 0.00337f
C10670 sg13cmos5l_a22oi_1_0.B1 sg13cmos5l_buf_1_28.X 0.00592f
C10671 sg13cmos5l_dlhr_1_11.GATE a_12232_8436# 0.01856f
C10672 a_8022_3120# sg13cmos5l_buf_1_26.A 0
C10673 sg13cmos5l_buf_1_25.X a_7226_1636# 0
C10674 sg13cmos5l_buf_1_3.A d_out[1] 0.04017f
C10675 sg13cmos5l_dlhr_1_2.D sg13cmos5l_dlhr_1_0.Q 0
C10676 sg13cmos5l_buf_1_0.A a_18928_1846# 0.02482f
C10677 sg13cmos5l_buf_1_0.A sg13cmos5l_inv_1_5.A 0
C10678 sg13cmos5l_buf_1_101.X a_16271_7751# 0
C10679 sg13cmos5l_inv_1_1.A a_16260_6480# 0.01087f
C10680 sg13cmos5l_dlhr_1_6.D sg13cmos5l_inv_1_29.Y 0.0204f
C10681 a_9033_6162# sg13cmos5l_buf_1_29.A 0.00134f
C10682 sg13cmos5l_buf_1_56.A a_8784_6484# 0
C10683 sg13cmos5l_nor2_1_0.A a_13092_3138# 0
C10684 a_9865_7282# sg13cmos5l_buf_1_56.A 0
C10685 a_17327_7285# sg13cmos5l_dlhr_1_10.Q 0
C10686 sg13cmos5l_inv_1_28.Y sg13cmos5l_buf_1_96.A 0.34308f
C10687 a_6315_3911# sg13cmos5l_dlhr_1_0.D 0
C10688 sg13cmos5l_buf_1_39.A nl_sw[3] 0.0073f
C10689 a_15062_4292# a_14814_3876# 0
C10690 a_15821_3864# a_16462_4338# 0.32273f
C10691 a_16204_4338# a_16298_4338# 0.0019f
C10692 sg13cmos5l_dfrbp_1_0.D a_19508_1924# 0
C10693 sg13cmos5l_dfrbp_1_6.D sg13cmos5l_inv_1_0.A 0
C10694 a_13076_5376# sg13cmos5l_a22oi_1_1.B2 0.06395f
C10695 a_11567_7751# a_11473_7751# 0.32273f
C10696 sg13cmos5l_inv_1_3.A sg13cmos5l_dfrbp_1_23.Q_N 0
C10697 a_6903_3154# a_6697_3192# 0.27703f
C10698 sg13cmos5l_buf_1_6.A a_15492_2392# 0
C10699 sg13cmos5l_buf_1_57.X sg13cmos5l_buf_1_29.A 0.0102f
C10700 sg13cmos5l_a221oi_1_0.B1 a_11182_4948# 0.02202f
C10701 sg13cmos5l_inv_1_8.A a_3407_8797# 0.01155f
C10702 sg13cmos5l_buf_1_103.A pl_sw[9] 0.13919f
C10703 a_10230_4632# sg13cmos5l_a22oi_1_0.Y 0
C10704 sg13cmos5l_buf_1_57.X a_10665_7281# 0
C10705 a_10827_7796# cks 0.00586f
C10706 sg13cmos5l_dfrbp_1_0.RESET_B nl_sw[5] 0
C10707 sg13cmos5l_inv_1_20.Y a_2831_7630# 0.04136f
C10708 a_8905_4704# a_9456_4972# 0
C10709 sg13cmos5l_buf_1_2.A a_16011_2399# 0.00123f
C10710 a_2934_4632# sg13cmos5l_inv_1_19.A 0.00184f
C10711 sg13cmos5l_dlhr_1_9.D a_7631_4727# 0.00939f
C10712 sg13cmos5l_inv_1_17.A a_3826_8874# 0.00108f
C10713 sg13cmos5l_dfrbp_1_8.RESET_B a_3574_7850# 0.00358f
C10714 a_7055_4261# sg13cmos5l_dlhr_1_2.D 0
C10715 a_11270_1626# a_11844_1639# 0.36169f
C10716 a_4041_2745# sg13cmos5l_buf_1_33.A 0
C10717 sg13cmos5l_buf_1_37.A sg13cmos5l_buf_1_25.X 0
C10718 sg13cmos5l_nor2b_1_0.Y a_11771_5412# 0.05111f
C10719 sg13cmos5l_dfrbp_1_6.D a_3664_4142# 0
C10720 sg13cmos5l_buf_1_78.A cks 0.02299f
C10721 sg13cmos5l_buf_1_40.A a_934_7349# 0
C10722 a_1192_1664# sg13cmos5l_buf_1_35.A 0.00327f
C10723 sg13cmos5l_dfrbp_1_6.D a_12490_6385# 0.00786f
C10724 a_5820_5773# a_5951_5383# 0.48921f
C10725 sg13cmos5l_buf_1_86.A VPWR 0.31985f
C10726 sg13cmos5l_buf_1_29.A sg13cmos5l_buf_1_28.A 0
C10727 sg13cmos5l_dfrbp_1_6.RESET_B a_1484_6126# 0.00236f
C10728 sg13cmos5l_dfrbp_1_0.D a_15784_1664# 0
C10729 sg13cmos5l_buf_1_45.X a_7657_7282# 0.01602f
C10730 a_14628_8440# a_16144_8678# 0.00159f
C10731 a_15045_8447# a_15147_8447# 0.6663f
C10732 a_17108_7972# a_17233_7285# 0
C10733 a_14858_2388# VPWR 0.00707f
C10734 a_7888_4870# a_7055_4261# 0.00599f
C10735 a_7631_4727# a_7892_3900# 0.00292f
C10736 sg13cmos5l_dfrbp_1_12.Q_N a_5796_3904# 0
C10737 a_12361_7282# VPWR 0.47194f
C10738 sg13cmos5l_buf_1_93.X sg13cmos5l_dfrbp_1_23.CLK 0
C10739 sg13cmos5l_dfrbp_1_8.RESET_B a_16271_7751# 0
C10740 a_2340_3456# sg13cmos5l_buf_1_33.A 0
C10741 sg13cmos5l_dfrbp_1_16.Q a_10202_7288# 0
C10742 sg13cmos5l_dfrbp_1_6.RESET_B sg13cmos5l_buf_1_25.X 0.06588f
C10743 sg13cmos5l_buf_1_73.A a_7881_8065# 0
C10744 sg13cmos5l_dfrbp_1_6.RESET_B a_2306_7660# 0.00496f
C10745 sg13cmos5l_buf_1_94.X a_14916_8861# 0
C10746 a_12420_9199# sg13cmos5l_inv_1_7.A 0
C10747 sg13cmos5l_o21ai_1_0.Y a_12022_3134# 0.12419f
C10748 sg13cmos5l_dfrbp_1_1.D a_9823_2364# 0.19628f
C10749 a_1227_5423# sg13cmos5l_nand2_1_2.B 0
C10750 a_15200_1758# VPWR 0.07549f
C10751 a_1125_5423# a_1815_4666# 0.00881f
C10752 a_15200_1758# nl_sw[7] 0
C10753 sg13cmos5l_dfrbp_1_6.RESET_B a_18356_6460# 0.00736f
C10754 sg13cmos5l_buf_1_44.X a_5069_5376# 0.01478f
C10755 a_16462_4338# VPWR 0
C10756 a_1956_8874# sg13cmos5l_buf_1_58.A 0
C10757 sg13cmos5l_buf_1_64.A pl_sw[2] 0.05531f
C10758 a_14228_9484# sg13cmos5l_dfrbp_1_23.CLK 0.14287f
C10759 sg13cmos5l_inv_1_27.Y sg13cmos5l_dfrbp_1_24.Q_N 0.00137f
C10760 sg13cmos5l_buf_1_38.A sg13cmos5l_buf_1_44.A 0
C10761 sg13cmos5l_buf_1_77.A a_9291_8447# 0.00224f
C10762 a_8439_6178# VPWR 0.18166f
C10763 a_15012_7992# sg13cmos5l_buf_1_89.A 0
C10764 sg13cmos5l_dlhr_1_9.D a_2934_4632# 0.00212f
C10765 sg13cmos5l_inv_1_3.A a_14854_8861# 0
C10766 a_5951_5383# VPWR 0.24659f
C10767 a_12933_6141# a_13681_6239# 0.01058f
C10768 sg13cmos5l_a221oi_1_1.C1 sg13cmos5l_a22oi_1_2.B2 0.35908f
C10769 sg13cmos5l_buf_1_90.X a_12841_7728# 0
C10770 sg13cmos5l_dfrbp_1_0.RESET_B a_13258_3361# 0.32724f
C10771 sg13cmos5l_buf_1_30.A a_6117_6141# 0
C10772 sg13cmos5l_buf_1_65.X sg13cmos5l_buf_1_61.X 0.40033f
C10773 a_2732_9150# sg13cmos5l_inv_1_19.A 0
C10774 a_422_5850# a_1065_5459# 0.00806f
C10775 sg13cmos5l_a221oi_1_0.A2 a_9111_4666# 0.01407f
C10776 sg13cmos5l_dfrbp_1_21.Q a_18368_4782# 0
C10777 sg13cmos5l_or2_1_0.A sg13cmos5l_dlhr_1_2.Q_N 0.00169f
C10778 sg13cmos5l_dfrbp_1_6.D sg13cmos5l_buf_1_59.A 0
C10779 a_11556_1944# VPWR 0.09169f
C10780 sg13cmos5l_o21ai_1_0.A1 a_11913_3947# 0.00125f
C10781 sg13cmos5l_nand2_1_0.A a_13803_3260# 0
C10782 a_3676_7964# ph_sw[2] 0
C10783 sg13cmos5l_dfrbp_1_6.RESET_B ph_sw[9] 0.80566f
C10784 sg13cmos5l_inv_1_27.Y sg13cmos5l_buf_1_10.A 0.7226f
C10785 sg13cmos5l_dfrbp_1_0.RESET_B sg13cmos5l_dfrbp_1_0.CLK 0.38233f
C10786 a_9189_8447# sg13cmos5l_dfrbp_1_20.Q 0.00329f
C10787 a_19593_6162# sg13cmos5l_dlhr_1_16.Q_N 0.00108f
C10788 a_2436_4325# a_2667_3911# 0.15089f
C10789 sg13cmos5l_buf_1_24.A a_7622_2064# 0
C10790 a_15492_2392# a_16751_2749# 0.01741f
C10791 a_15909_2399# a_17008_2630# 0
C10792 a_3016_9318# VPWR 0.13135f
C10793 a_12361_7282# a_12698_7288# 0.64635f
C10794 a_12567_7282# a_12913_7326# 0.00722f
C10795 sg13cmos5l_buf_1_5.X nh_sw[7] 0.02362f
C10796 sg13cmos5l_o21ai_1_0.A1 a_11973_3911# 0.00425f
C10797 a_7504_8678# sg13cmos5l_dlhr_1_5.D 0
C10798 sg13cmos5l_dfrbp_1_8.RESET_B a_5312_6294# 0
C10799 a_6741_5459# a_6372_4968# 0
C10800 sg13cmos5l_nand2_1_0.B a_10220_3102# 0.00178f
C10801 a_9673_9240# ph_sw[5] 0
C10802 a_11190_7354# sg13cmos5l_nor2_1_0.A 0
C10803 sg13cmos5l_nor2b_1_0.Y sg13cmos5l_or2_1_0.A 0.02719f
C10804 a_8576_1758# nh_sw[4] 0
C10805 sg13cmos5l_buf_1_0.A a_18577_1703# 0.00251f
C10806 a_2224_7166# VPWR 0.16114f
C10807 sg13cmos5l_buf_1_101.X sg13cmos5l_dlhr_1_15.D 0
C10808 a_11980_4948# VPWR 0.00796f
C10809 a_11473_7751# a_11752_6294# 0
C10810 sg13cmos5l_or2_1_0.A sg13cmos5l_buf_1_44.A 0.28444f
C10811 sg13cmos5l_dlhr_1_1.GATE a_6380_7638# 0
C10812 sg13cmos5l_buf_1_40.A sg13cmos5l_buf_1_43.A 0.00185f
C10813 a_2565_8447# sg13cmos5l_inv_1_19.A 0
C10814 sg13cmos5l_buf_1_18.A sg13cmos5l_dfrbp_1_1.Q 0.00187f
C10815 sg13cmos5l_dlhr_1_5.D a_6891_4772# 0
C10816 sg13cmos5l_dfrbp_1_21.Q sg13cmos5l_and3_1_0.C 0
C10817 sg13cmos5l_inv_1_18.A a_9879_9202# 0
C10818 sg13cmos5l_buf_1_60.A a_4349_7636# 0
C10819 sg13cmos5l_dfrbp_1_18.Q cks 0.17513f
C10820 a_4460_9150# a_4559_7630# 0
C10821 sg13cmos5l_dfrbp_1_0.D sg13cmos5l_dfrbp_1_0.Q_N 0
C10822 a_422_7362# a_682_6892# 0.87117f
C10823 a_15821_3864# a_17399_3947# 0
C10824 a_16572_4261# a_17750_4325# 0.00523f
C10825 a_16462_4338# a_16551_3987# 0.00667f
C10826 sg13cmos5l_buf_1_57.X a_12216_5728# 0.00471f
C10827 sg13cmos5l_and3_1_0.X sg13cmos5l_a22oi_1_1.B2 0.23268f
C10828 a_3692_9150# sg13cmos5l_dfrbp_1_8.RESET_B 0
C10829 a_6568_9224# pl_sw[3] 0.0055f
C10830 a_5988_8440# sg13cmos5l_dfrbp_1_6.D 0
C10831 a_7497_3138# a_8022_3120# 0.13715f
C10832 sg13cmos5l_buf_1_6.A a_16011_2399# 0
C10833 a_4172_1590# a_4456_1664# 0.13542f
C10834 VPWR nh_sw[4] 0.25818f
C10835 sg13cmos5l_buf_1_57.X a_11560_7010# 0
C10836 sg13cmos5l_dlhr_1_9.D sg13cmos5l_a221oi_1_0.B2 0
C10837 sg13cmos5l_buf_1_60.X a_4324_7996# 0
C10838 a_10230_4632# sg13cmos5l_buf_1_46.A 0.57235f
C10839 sg13cmos5l_buf_1_45.X a_7394_5850# 0
C10840 a_15974_6162# VPWR 0.92751f
C10841 sg13cmos5l_dfrbp_1_9.Q sg13cmos5l_inv_1_19.A 0
C10842 sg13cmos5l_inv_1_2.A sg13cmos5l_buf_8_1.A 0
C10843 a_8439_6178# a_8233_6216# 0.27532f
C10844 sg13cmos5l_dlhr_1_9.D sg13cmos5l_dfrbp_1_11.Q_N 0.00178f
C10845 sg13cmos5l_dlhr_1_3.Q_N a_5028_2826# 0
C10846 a_10406_9624# VPWR 0.00418f
C10847 a_16677_6141# sg13cmos5l_dfrbp_1_21.Q 0.00154f
C10848 a_8439_6178# sg13cmos5l_dfrbp_1_11.Q 0
C10849 sg13cmos5l_dfrbp_1_6.D a_5132_3864# 0.04797f
C10850 sg13cmos5l_buf_1_73.A sg13cmos5l_buf_1_77.A 0
C10851 a_14854_8861# cks 0
C10852 sg13cmos5l_buf_1_73.A pl_sw[4] 0
C10853 sg13cmos5l_a22oi_1_1.Y a_15380_3436# 0
C10854 sg13cmos5l_dfrbp_1_6.D a_13775_6239# 0.00708f
C10855 a_5951_5383# sg13cmos5l_dfrbp_1_11.Q 0
C10856 sg13cmos5l_inv_1_26.Y a_17961_8793# 0.00667f
C10857 sg13cmos5l_inv_1_2.A a_8689_7751# 0
C10858 sg13cmos5l_dfrbp_1_6.RESET_B a_2380_6162# 0.0135f
C10859 a_14628_8440# sg13cmos5l_dfrbp_1_22.D 0
C10860 a_16144_8678# a_15887_8797# 0.35645f
C10861 sg13cmos5l_inv_1_6.A sg13cmos5l_dlhr_1_10.Q_N 0.01457f
C10862 sg13cmos5l_inv_1_3.A a_12516_6480# 0.00456f
C10863 sg13cmos5l_buf_1_8.A a_10888_1664# 0.32736f
C10864 pl_sw[1] sg13cmos5l_buf_1_61.X 0.09097f
C10865 sg13cmos5l_or2_1_1.B sg13cmos5l_and3_1_0.C 0
C10866 a_16657_2749# VPWR 0.00167f
C10867 a_16748_9150# pl_sw[7] 0.2906f
C10868 sg13cmos5l_dfrbp_1_12.Q_N a_7055_4261# 0.04733f
C10869 a_7631_4727# a_8296_3986# 0.01113f
C10870 sg13cmos5l_dfrbp_1_6.D a_2122_3868# 0.02569f
C10871 sg13cmos5l_buf_1_68.X a_1484_9150# 0.29592f
C10872 sg13cmos5l_buf_1_74.X sg13cmos5l_buf_1_73.A 0.04155f
C10873 sg13cmos5l_inv_1_14.A sg13cmos5l_buf_1_77.X 0.10706f
C10874 sg13cmos5l_dfrbp_1_6.D a_17700_3456# 0
C10875 sg13cmos5l_dfrbp_1_8.RESET_B sg13cmos5l_dlhr_1_15.D 0.05629f
C10876 a_4244_6924# cks 0
C10877 a_16042_6892# sg13cmos5l_buf_1_4.A 0
C10878 a_12815_4261# sg13cmos5l_o21ai_1_0.B1 0
C10879 sg13cmos5l_o21ai_1_0.Y a_13092_3138# 0
C10880 a_11556_1944# a_11973_1605# 0.48921f
C10881 a_11270_1626# a_12075_1748# 0.11742f
C10882 a_11530_1849# a_11913_2017# 0.00337f
C10883 a_17931_1748# VPWR 0.2098f
C10884 a_1125_5423# a_1472_4782# 0.00194f
C10885 a_17399_3947# VPWR 0.93486f
C10886 sg13cmos5l_buf_1_110.A a_16204_4338# 0
C10887 sg13cmos5l_buf_1_31.X sg13cmos5l_inv_1_11.Y 0
C10888 sg13cmos5l_dfrbp_1_21.Q sg13cmos5l_nor2_1_0.A 0.03294f
C10889 a_13648_9406# pl_sw[7] 0
C10890 sg13cmos5l_inv_1_3.A cks 0.11711f
C10891 sg13cmos5l_buf_1_0.A sg13cmos5l_dfrbp_1_1.Q 0.39355f
C10892 sg13cmos5l_a221oi_1_1.C1 a_11268_5760# 0.00295f
C10893 a_11072_5347# sg13cmos5l_nor2b_1_0.Y 0.03964f
C10894 sg13cmos5l_a221oi_1_0.C1 sg13cmos5l_a221oi_1_0.B1 0.03487f
C10895 sg13cmos5l_a221oi_1_0.A2 sg13cmos5l_dfrbp_1_10.Q 0
C10896 sg13cmos5l_dfrbp_1_21.Q a_18146_4338# 0
C10897 sg13cmos5l_dfrbp_1_15.D a_2348_7624# 0.00343f
C10898 sg13cmos5l_buf_1_56.A VPWR 0.31883f
C10899 sg13cmos5l_dlhr_1_9.D sg13cmos5l_dfrbp_1_9.Q 0
C10900 a_19244_2352# sg13cmos5l_buf_1_19.X 0.02472f
C10901 sg13cmos5l_inv_1_3.A a_16306_8874# 0
C10902 sg13cmos5l_dfrbp_1_1.Q a_13803_3260# 0.00321f
C10903 a_14612_6460# sg13cmos5l_dfrbp_1_23.Q_N 0.25039f
C10904 sg13cmos5l_inv_1_17.A ph_sw[2] 0.00223f
C10905 a_17751_7690# ph_sw[9] 0
C10906 a_516_7362# cks 0
C10907 sg13cmos5l_buf_1_30.A a_7161_6477# 0
C10908 sg13cmos5l_buf_1_9.A a_10464_2427# 0.00478f
C10909 a_4950_7354# sg13cmos5l_buf_1_59.A 0.56969f
C10910 sg13cmos5l_dfrbp_1_16.Q a_4736_5498# 0.00151f
C10911 sg13cmos5l_inv_1_14.A a_7226_1636# 0
C10912 a_13035_6284# sg13cmos5l_inv_1_0.A 0
C10913 sg13cmos5l_a221oi_1_0.A2 sg13cmos5l_inv_1_0.Y 0.20854f
C10914 VPWR pl_sw[2] 0.41541f
C10915 a_13652_1924# VPWR 0.35642f
C10916 sg13cmos5l_dfrbp_1_6.RESET_B sg13cmos5l_dlhr_1_5.GATE 0.99259f
C10917 sg13cmos5l_dfrbp_1_9.Q sg13cmos5l_buf_1_33.A 0
C10918 sg13cmos5l_nand2_1_0.A sg13cmos5l_buf_1_5.X 0.18971f
C10919 a_10998_9168# pl_sw[6] 0.00101f
C10920 sg13cmos5l_buf_1_73.X a_7498_7897# 0
C10921 a_3664_4142# a_3826_4338# 0.0019f
C10922 a_3407_4261# a_3313_4261# 0.32273f
C10923 sg13cmos5l_buf_1_8.X sg13cmos5l_dlhr_1_0.D 0
C10924 a_16011_2399# a_16751_2749# 0.3087f
C10925 a_422_5850# a_996_5837# 0.36169f
C10926 sg13cmos5l_a22oi_1_1.B1 a_12075_3911# 0.02189f
C10927 sg13cmos5l_buf_1_19.A sg13cmos5l_inv_1_6.A 0.03095f
C10928 a_12490_6385# a_13035_6284# 0.00999f
C10929 a_12230_6162# a_12933_6141# 0.02453f
C10930 sg13cmos5l_buf_1_60.A sg13cmos5l_inv_1_8.A 0
C10931 sg13cmos5l_nor2_1_0.A sg13cmos5l_or2_1_1.B 0.37284f
C10932 sg13cmos5l_dfrbp_1_6.RESET_B a_14536_7806# 0.00415f
C10933 sg13cmos5l_dfrbp_1_8.RESET_B a_6959_6239# 0.03865f
C10934 sg13cmos5l_dfrbp_1_23.CLK a_16042_6892# 0
C10935 sg13cmos5l_dfrbp_1_6.RESET_B a_5684_4948# 0.06002f
C10936 a_18219_3260# a_19161_3453# 0
C10937 a_17700_3456# a_17926_3151# 0.00523f
C10938 a_18117_3117# a_17988_3151# 0.01562f
C10939 sg13cmos5l_a221oi_1_0.A2 a_6372_4968# 0.00399f
C10940 a_16751_2749# a_16936_1758# 0
C10941 sg13cmos5l_buf_1_30.A sg13cmos5l_buf_1_25.A 0.03825f
C10942 a_1862_4338# a_2667_3911# 0.11742f
C10943 sg13cmos5l_nand2_1_1.B a_11372_3102# 0.0014f
C10944 sg13cmos5l_buf_1_26.A a_8588_2352# 0.05183f
C10945 a_16703_3871# a_16751_2749# 0
C10946 sg13cmos5l_inv_1_26.Y sg13cmos5l_dlhr_1_15.Q_N 0
C10947 a_17498_8800# ph_sw[9] 0
C10948 sg13cmos5l_dfrbp_1_6.RESET_B a_8593_5814# 0
C10949 sg13cmos5l_buf_1_45.X a_8592_5412# 0
C10950 a_1864_9224# sg13cmos5l_inv_1_8.A 0
C10951 a_18999_6178# a_18615_5770# 0.00973f
C10952 sg13cmos5l_buf_1_60.X a_1760_9318# 0
C10953 sg13cmos5l_buf_1_104.A a_19624_8436# 0.3232f
C10954 a_2224_7166# a_1967_7285# 0.35645f
C10955 a_20288_7010# VPWR 0.11262f
C10956 a_12841_7728# a_12567_7282# 0
C10957 a_17386_1849# a_17829_1605# 0.02241f
C10958 a_3308_9150# sg13cmos5l_buf_1_65.X 0.32564f
C10959 sg13cmos5l_buf_1_46.A a_8588_2352# 0
C10960 a_16551_3987# a_17399_3947# 0.11742f
C10961 a_10613_2758# nh_sw[5] 0
C10962 ph_sw[6] pl_sw[7] 0.20158f
C10963 a_7247_8797# a_7498_7897# 0
C10964 a_7316_3460# a_7430_3576# 0.00122f
C10965 a_7497_3138# sg13cmos5l_dlhr_1_2.Q 0.31105f
C10966 sg13cmos5l_buf_1_39.A a_3008_1758# 0
C10967 a_3212_1590# a_3496_1758# 0.01225f
C10968 sg13cmos5l_buf_1_8.A a_13017_1941# 0
C10969 sg13cmos5l_dfrbp_1_6.D a_6198_3120# 0
C10970 a_5704_1664# nl_sw[2] 0
C10971 a_4172_1590# VPWR 0.25161f
C10972 sg13cmos5l_inv_1_2.A sg13cmos5l_inv_1_29.A 0
C10973 sg13cmos5l_dlhr_1_9.Q_N VPWR 0.2592f
C10974 a_19227_9190# sg13cmos5l_buf_1_104.X 0.00157f
C10975 sg13cmos5l_dfrbp_1_10.Q a_6697_3192# 0.00871f
C10976 sg13cmos5l_buf_1_57.X a_13686_7354# 0
C10977 a_6697_3192# a_6736_2630# 0
C10978 a_6903_3154# a_6479_2749# 0.02159f
C10979 sg13cmos5l_or2_1_0.A a_17988_3151# 0
C10980 sg13cmos5l_dlhr_1_15.D a_15850_4873# 0.00497f
C10981 sg13cmos5l_inv_1_14.A sg13cmos5l_dfrbp_1_6.RESET_B 0.8189f
C10982 sg13cmos5l_buf_1_45.X sg13cmos5l_dfrbp_1_18.Q 0.3524f
C10983 sg13cmos5l_dfrbp_1_6.D a_3241_2746# 0.00192f
C10984 a_17776_6382# VPWR 0.15729f
C10985 a_5220_2392# a_5637_2399# 0.49014f
C10986 sg13cmos5l_buf_1_18.A a_19528_6924# 0.05031f
C10987 a_8233_6216# sg13cmos5l_buf_1_56.A 0
C10988 a_9033_6162# a_9558_6144# 0.13715f
C10989 sg13cmos5l_or2_1_0.A a_1760_3986# 0.00134f
C10990 a_10230_4632# sg13cmos5l_nand2_1_1.B 0
C10991 sg13cmos5l_inv_1_27.Y sg13cmos5l_nor2b_1_0.Y 0
C10992 sg13cmos5l_buf_1_1.A a_13017_1941# 0
C10993 a_4736_5498# a_4005_4629# 0.00313f
C10994 sg13cmos5l_a221oi_1_0.C1 a_11782_4325# 0
C10995 a_8488_9224# pl_sw[5] 0
C10996 a_7631_4727# a_8392_3270# 0.00401f
C10997 sg13cmos5l_buf_1_5.A a_12980_6924# 0.00542f
C10998 sg13cmos5l_buf_1_34.X a_4640_3986# 0.00403f
C10999 sg13cmos5l_dfrbp_1_6.D a_6891_4772# 0
C11000 sg13cmos5l_buf_1_65.X a_5796_8874# 0
C11001 sg13cmos5l_a22oi_1_1.Y a_16204_4338# 0.01003f
C11002 sg13cmos5l_dfrbp_1_6.RESET_B a_4652_6126# 0.00125f
C11003 sg13cmos5l_nor2b_1_0.Y sg13cmos5l_dfrbp_1_2.D 0.48146f
C11004 a_15887_8797# sg13cmos5l_dfrbp_1_22.D 0.00284f
C11005 a_16724_8436# sg13cmos5l_dfrbp_1_25.Q_N 0.25039f
C11006 sg13cmos5l_buf_1_57.X a_9558_6144# 0.02373f
C11007 a_19628_2352# VPWR 0.25253f
C11008 sg13cmos5l_dfrbp_1_11.Q_N a_8296_3986# 0
C11009 sg13cmos5l_buf_1_79.X a_9620_7972# 0
C11010 a_5079_3154# a_4934_2826# 0
C11011 sg13cmos5l_nand2_1_1.B nh_sw[5] 0.01705f
C11012 a_14708_6924# a_14583_5770# 0
C11013 sg13cmos5l_inv_1_0.A a_12800_5498# 0
C11014 a_9111_4666# a_8905_4704# 0.27532f
C11015 a_7631_4727# a_8050_4650# 0.00176f
C11016 a_1864_9224# a_1948_7964# 0
C11017 sg13cmos5l_inv_1_0.A a_10587_4692# 0.02325f
C11018 sg13cmos5l_buf_1_0.X nl_sw[10] 0.19126f
C11019 sg13cmos5l_dfrbp_1_8.RESET_B a_2621_7636# 0.01597f
C11020 sg13cmos5l_nand2_1_1.A sg13cmos5l_o21ai_1_0.B1 0.72647f
C11021 a_15974_6162# a_16260_6480# 0.50066f
C11022 a_16234_6385# a_16677_6141# 0.02241f
C11023 sg13cmos5l_buf_1_6.A a_14924_1590# 0.33661f
C11024 a_12075_1748# a_13072_1846# 0.06778f
C11025 a_20296_1664# VPWR 0.24861f
C11026 a_6372_4968# a_6697_3192# 0
C11027 a_6789_4629# a_6903_3154# 0.00161f
C11028 a_5702_8874# a_5988_8440# 0.50066f
C11029 sg13cmos5l_dfrbp_1_6.RESET_B a_18860_6888# 0
C11030 sg13cmos5l_dlhr_1_15.D a_18096_7996# 0
C11031 sg13cmos5l_dfrbp_1_6.D a_1402_3864# 0
C11032 sg13cmos5l_inv_1_7.A a_12719_2749# 0.02087f
C11033 sg13cmos5l_buf_1_32.A nl_sw[0] 0.02343f
C11034 sg13cmos5l_buf_1_98.A a_14152_8522# 0.0011f
C11035 sg13cmos5l_dfrbp_1_15.D sg13cmos5l_buf_1_58.A 0.15481f
C11036 a_13392_7996# VPWR 0
C11037 sg13cmos5l_buf_1_3.A sg13cmos5l_dlhr_1_16.Q 0.104f
C11038 a_4107_4772# VPWR 0.21142f
C11039 sg13cmos5l_buf_1_8.A VPWR 0.73136f
C11040 a_10473_9186# sg13cmos5l_dlhr_1_11.GATE 0
C11041 sg13cmos5l_inv_1_7.A a_10308_7992# 0
C11042 a_11272_8522# a_10725_7653# 0
C11043 sg13cmos5l_buf_1_40.A sg13cmos5l_buf_1_58.A 0.0022f
C11044 sg13cmos5l_buf_1_5.A sg13cmos5l_buf_1_57.X 0.02236f
C11045 sg13cmos5l_dfrbp_1_8.RESET_B sg13cmos5l_inv_1_6.A 0
C11046 sg13cmos5l_dfrbp_1_1.Q sg13cmos5l_buf_1_5.X 0.01808f
C11047 sg13cmos5l_dfrbp_1_16.Q a_8570_6172# 0
C11048 a_708_5416# a_1815_4666# 0
C11049 a_996_5837# sg13cmos5l_nand2_1_2.B 0
C11050 a_11752_6294# sg13cmos5l_inv_1_0.Y 0
C11051 a_1158_3142# a_1192_1664# 0.00247f
C11052 sg13cmos5l_buf_1_28.X a_10707_2388# 0
C11053 a_10783_3876# sg13cmos5l_o21ai_1_0.A2 0
C11054 sg13cmos5l_dfrbp_1_6.D a_1609_4704# 0.02783f
C11055 sg13cmos5l_buf_1_31.X a_9457_4642# 0
C11056 a_12420_9199# a_12232_8436# 0
C11057 sg13cmos5l_dfrbp_1_6.RESET_B a_3574_7850# 0.00796f
C11058 sg13cmos5l_buf_1_41.A sg13cmos5l_inv_1_19.A 0.02542f
C11059 sg13cmos5l_buf_1_19.X a_19090_1626# 0
C11060 sg13cmos5l_dfrbp_1_1.D a_10464_2427# 0
C11061 sg13cmos5l_dfrbp_1_18.Q a_8084_8436# 0.16367f
C11062 sg13cmos5l_buf_1_1.A nl_sw[7] 0.07368f
C11063 sg13cmos5l_buf_1_1.A VPWR 0.25501f
C11064 sg13cmos5l_buf_1_3.A sg13cmos5l_dfrbp_1_6.D 0
C11065 a_20488_6294# a_20488_5498# 0.01095f
C11066 a_11556_3904# sg13cmos5l_o21ai_1_0.A2 0
C11067 a_16751_2749# sg13cmos5l_dfrbp_1_5.Q_N 0.04107f
C11068 a_16657_2749# a_17170_2826# 0
C11069 sg13cmos5l_buf_1_65.X a_616_9224# 0.02462f
C11070 sg13cmos5l_buf_1_86.A ph_sw[9] 0
C11071 sg13cmos5l_inv_1_27.Y a_14342_8874# 0.01078f
C11072 a_12933_6141# a_14032_6382# 0
C11073 a_13035_6284# a_13775_6239# 0.3087f
C11074 a_13686_7354# a_14089_7282# 0.00386f
C11075 sg13cmos5l_dfrbp_1_8.D a_16102_4663# 0
C11076 a_17674_3361# nh_sw[8] 0
C11077 a_3609_8559# cks 0.00109f
C11078 sg13cmos5l_dfrbp_1_6.RESET_B a_16271_7751# 0.20159f
C11079 sg13cmos5l_buf_1_44.X sg13cmos5l_dfrbp_1_16.Q 0.01919f
C11080 sg13cmos5l_dfrbp_1_8.RESET_B sg13cmos5l_dlhr_1_6.D 0
C11081 a_18959_3215# sg13cmos5l_dfrbp_1_3.Q_N 0.04107f
C11082 a_19216_3358# a_18865_3215# 0.01017f
C11083 a_17519_6239# a_18368_4782# 0.00134f
C11084 a_8378_5776# a_8468_4948# 0
C11085 sg13cmos5l_a221oi_1_0.A2 a_7888_4870# 0.05433f
C11086 sg13cmos5l_dfrbp_1_8.RESET_B ph_sw[1] 0.00314f
C11087 a_20492_8400# cko 0.00109f
C11088 sg13cmos5l_or2_1_0.A a_8022_3120# 0.00173f
C11089 a_1760_3986# a_1672_3176# 0
C11090 sg13cmos5l_dfrbp_1_8.RESET_B a_1000_9224# 0
C11091 a_5988_8440# ph_sw[3] 0
C11092 a_2148_3904# a_3313_4261# 0.4858f
C11093 sg13cmos5l_buf_1_2.A sg13cmos5l_dfrbp_1_0.RESET_B 0.3525f
C11094 sg13cmos5l_nand2_1_0.A a_11002_3142# 0
C11095 sg13cmos5l_buf_1_24.A sg13cmos5l_buf_1_28.A 0
C11096 sg13cmos5l_a22oi_1_1.B1 a_11973_3911# 0.01455f
C11097 sg13cmos5l_dfrbp_1_6.RESET_B sg13cmos5l_buf_1_45.A 0.68548f
C11098 sg13cmos5l_buf_1_57.X a_16068_6162# 0
C11099 a_18999_6178# a_19209_5769# 0.00483f
C11100 a_18793_6216# a_19028_5412# 0.00454f
C11101 a_2879_6432# VPWR 0.27373f
C11102 a_13641_7674# a_13161_7281# 0.00848f
C11103 sg13cmos5l_dlhr_1_1.GATE a_2748_6126# 0.00562f
C11104 a_2804_6924# sg13cmos5l_dfrbp_1_16.Q 0.13336f
C11105 a_17412_1944# a_18671_1703# 0.01741f
C11106 sg13cmos5l_o21ai_1_0.A1 a_11488_4676# 0.01734f
C11107 sg13cmos5l_buf_1_25.A a_5704_1664# 0
C11108 a_1227_6935# a_1878_6337# 0
C11109 sg13cmos5l_dlhr_1_9.D sg13cmos5l_buf_1_41.A 0.18922f
C11110 a_1862_4338# a_1956_4338# 0.00718f
C11111 sg13cmos5l_dlygate4sd2_1_0.X a_1760_3986# 0.07188f
C11112 sg13cmos5l_a22oi_1_0.Y sg13cmos5l_buf_1_28.X 0
C11113 a_17674_3361# a_18117_3117# 0.02241f
C11114 a_17224_3270# a_17414_3138# 0.00201f
C11115 sg13cmos5l_dlhr_1_5.GATE a_5452_5850# 0.00143f
C11116 a_10433_4248# VPWR 0
C11117 sg13cmos5l_dfrbp_1_20.Q_N sg13cmos5l_dfrbp_1_18.Q 0.46239f
C11118 sg13cmos5l_dfrbp_1_10.Q a_5908_3124# 0
C11119 sg13cmos5l_buf_1_57.X sg13cmos5l_dfrbp_1_23.Q 0.62127f
C11120 a_6560_3270# a_5739_2399# 0.00405f
C11121 sg13cmos5l_dlhr_1_15.D a_17135_4727# 0.00213f
C11122 sg13cmos5l_buf_1_40.A a_524_4614# 0
C11123 sg13cmos5l_dfrbp_1_6.D a_4276_2776# 0
C11124 sg13cmos5l_buf_8_1.A a_19616_3986# 0
C11125 sg13cmos5l_dlhr_1_12.D ph_sw[7] 0.00265f
C11126 sg13cmos5l_buf_1_41.A sg13cmos5l_buf_1_33.A 0.01791f
C11127 a_5637_2399# a_6736_2630# 0
C11128 a_5220_2392# a_6479_2749# 0.01741f
C11129 sg13cmos5l_dfrbp_1_10.Q a_5637_2399# 0
C11130 sg13cmos5l_nor2_1_0.A a_13072_1846# 0
C11131 a_422_7362# a_516_7362# 0.00718f
C11132 sg13cmos5l_inv_1_7.A a_12742_6175# 0
C11133 sg13cmos5l_buf_1_1.A a_15439_1630# 0
C11134 sg13cmos5l_buf_1_30.A a_6961_4261# 0.02015f
C11135 a_1463_8741# a_1484_9150# 0.00674f
C11136 a_5452_5850# a_5684_4948# 0
C11137 a_10318_5412# sg13cmos5l_dfrbp_1_10.Q 0
C11138 sg13cmos5l_dfrbp_1_12.Q_N a_7732_3124# 0
C11139 sg13cmos5l_a22oi_1_1.Y a_17386_1849# 0
C11140 sg13cmos5l_buf_1_5.A a_14089_7282# 0.01769f
C11141 sg13cmos5l_a22oi_1_1.Y a_14814_3876# 0.19403f
C11142 sg13cmos5l_dfrbp_1_6.RESET_B a_5312_6294# 0
C11143 sg13cmos5l_buf_1_45.X cks 0.02613f
C11144 sg13cmos5l_inv_1_1.A a_16271_7751# 0.02566f
C11145 a_5492_3460# a_5628_3174# 0.00404f
C11146 a_5673_3138# a_5908_3124# 0.00566f
C11147 sg13cmos5l_dfrbp_1_6.RESET_B a_2386_5850# 0
C11148 sg13cmos5l_dlhr_1_2.D a_6697_3192# 0.13469f
C11149 sg13cmos5l_buf_1_8.A a_11973_1605# 0.00521f
C11150 sg13cmos5l_inv_1_17.A a_2824_2388# 0.0309f
C11151 a_11360_9318# sg13cmos5l_dlhr_1_11.GATE 0
C11152 sg13cmos5l_a221oi_1_0.B1 sg13cmos5l_nand2_1_0.B 0
C11153 sg13cmos5l_or2_1_0.A a_17674_3361# 0.00746f
C11154 a_5492_3460# a_5220_2392# 0
C11155 a_5673_3138# a_5637_2399# 0.02336f
C11156 a_9705_4650# a_10230_4632# 0.13715f
C11157 sg13cmos5l_buf_1_5.A a_13178_7684# 0.07407f
C11158 a_17132_9150# ph_sw[8] 0.00169f
C11159 sg13cmos5l_buf_1_44.X a_4005_4629# 0.00855f
C11160 a_11973_1605# sg13cmos5l_buf_1_1.A 0
C11161 sg13cmos5l_dfrbp_1_8.RESET_B a_7312_4142# 0
C11162 a_13652_1924# a_14056_1664# 0.00464f
C11163 a_16260_6480# a_17776_6382# 0.00294f
C11164 a_16677_6141# a_17519_6239# 0.00437f
C11165 sg13cmos5l_dfrbp_1_18.Q a_10233_8559# 0.00107f
C11166 a_20672_1758# VPWR 0.06845f
C11167 sg13cmos5l_o21ai_1_0.B1 a_13701_3117# 0.01509f
C11168 sg13cmos5l_dfrbp_1_1.Q a_15909_2399# 0.00571f
C11169 sg13cmos5l_dfrbp_1_16.Q sg13cmos5l_nor2_1_0.A 0
C11170 pl_sw[1] a_616_9224# 0
C11171 a_5962_8404# a_6276_8861# 0.00659f
C11172 a_5988_8440# a_6214_8861# 0.00523f
C11173 sg13cmos5l_dfrbp_1_0.RESET_B a_12921_2511# 0.00343f
C11174 a_5416_9224# ph_sw[3] 0.2906f
C11175 sg13cmos5l_inv_1_7.A sg13cmos5l_nor2_1_1.A 0
C11176 sg13cmos5l_buf_1_73.A a_7994_7288# 0
C11177 sg13cmos5l_inv_1_14.A a_5452_5850# 0
C11178 a_5104_4870# VPWR 0.14743f
C11179 sg13cmos5l_buf_1_5.A a_14924_1590# 0
C11180 a_12716_8400# sg13cmos5l_inv_1_29.A 0
C11181 sg13cmos5l_inv_1_7.A a_11824_7894# 0.00267f
C11182 sg13cmos5l_dfrbp_1_6.D a_2160_4972# 0
C11183 VPWR ph_sw[7] 0.34941f
C11184 a_16395_4772# a_17337_4965# 0
C11185 a_15876_4968# a_16102_4663# 0.00523f
C11186 a_16293_4629# a_16164_4663# 0.01562f
C11187 sg13cmos5l_dfrbp_1_23.CLK a_13484_8400# 0
C11188 sg13cmos5l_buf_1_38.A a_4873_3192# 0
C11189 a_16264_9224# a_15887_8797# 0.00624f
C11190 sg13cmos5l_buf_1_93.X a_15147_8447# 0
C11191 sg13cmos5l_o21ai_1_0.A2 a_12896_3270# 0
C11192 sg13cmos5l_dfrbp_1_18.Q a_8746_8404# 0.008f
C11193 a_18480_5028# sg13cmos5l_dfrbp_1_0.CLK 0
C11194 a_3407_4261# a_3860_2388# 0
C11195 a_1967_5773# a_2169_5535# 0.00675f
C11196 sg13cmos5l_or2_1_0.A a_11372_3102# 0
C11197 a_12651_9308# cks 0
C11198 sg13cmos5l_dlhr_1_11.GATE a_10665_7281# 0.0014f
C11199 sg13cmos5l_inv_1_2.A sg13cmos5l_a22oi_1_1.B2 0.01978f
C11200 sg13cmos5l_buf_1_10.A a_13072_4142# 0.00326f
C11201 a_422_7362# cks 0.03755f
C11202 sg13cmos5l_and3_1_0.C sg13cmos5l_a22oi_1_1.Y 0.86533f
C11203 a_17588_2388# sg13cmos5l_buf_1_18.X 0
C11204 sg13cmos5l_inv_1_27.Y a_14916_8861# 0.00186f
C11205 sg13cmos5l_dfrbp_1_1.Q a_11002_3142# 0
C11206 sg13cmos5l_dfrbp_1_1.Q a_10696_1758# 0
C11207 a_14089_7282# sg13cmos5l_dfrbp_1_23.Q 0.14976f
C11208 a_13092_3138# nh_sw[6] 0
C11209 sg13cmos5l_dfrbp_1_0.RESET_B sg13cmos5l_buf_1_6.A 0.00855f
C11210 a_8084_8436# cks 0.00956f
C11211 sg13cmos5l_dfrbp_1_6.RESET_B sg13cmos5l_dlhr_1_15.D 0.1588f
C11212 sg13cmos5l_dfrbp_1_0.RESET_B a_11530_1849# 0.34769f
C11213 sg13cmos5l_a221oi_1_0.A2 sg13cmos5l_dfrbp_1_12.Q_N 0.23039f
C11214 a_7052_9150# VPWR 0.24865f
C11215 a_2667_3911# a_2757_3117# 0.00922f
C11216 a_3664_4142# a_2340_3456# 0
C11217 sg13cmos5l_or2_1_0.A sg13cmos5l_dlhr_1_2.Q 0.00257f
C11218 sg13cmos5l_buf_1_30.A a_7863_7282# 0
C11219 sg13cmos5l_buf_1_18.X a_17829_1605# 0
C11220 a_18760_2388# a_18671_1703# 0
C11221 sg13cmos5l_buf_1_34.X a_4244_6924# 0.0185f
C11222 sg13cmos5l_buf_1_45.X a_9524_4972# 0
C11223 a_18363_4270# a_18760_2388# 0
C11224 sg13cmos5l_nand2_1_0.A a_11364_1626# 0
C11225 sg13cmos5l_buf_1_26.A sg13cmos5l_buf_1_28.X 0
C11226 a_19593_6162# sg13cmos5l_dlhr_1_16.Q 0.00397f
C11227 sg13cmos5l_buf_1_3.A nh_sw[9] 0
C11228 sg13cmos5l_dlhr_1_1.GATE a_2638_6162# 0.00146f
C11229 a_14166_7656# a_14295_7282# 0
C11230 a_17931_1748# a_18873_1941# 0
C11231 a_17829_1605# a_17700_1639# 0.01562f
C11232 a_18671_1703# a_19508_1924# 0.1333f
C11233 a_17412_1944# a_17638_1639# 0.00523f
C11234 a_10230_4632# sg13cmos5l_or2_1_0.A 0
C11235 a_1967_7285# a_2879_6432# 0.00445f
C11236 sg13cmos5l_dlhr_1_5.GATE a_8439_6178# 0.23671f
C11237 sg13cmos5l_dlhr_1_1.GATE a_1967_5773# 0.00227f
C11238 a_15357_1816# nh_sw[7] 0.03803f
C11239 sg13cmos5l_nand2_1_0.B a_11782_4325# 0
C11240 sg13cmos5l_dfrbp_1_23.CLK a_14844_7326# 0
C11241 sg13cmos5l_dlhr_1_5.GATE a_5951_5383# 0.01245f
C11242 a_17414_3138# a_18959_3215# 0
C11243 sg13cmos5l_nand2_1_0.B sg13cmos5l_inv_1_11.Y 0
C11244 sg13cmos5l_or2_1_0.A a_4873_3192# 0.00384f
C11245 sg13cmos5l_dfrbp_1_6.D a_19593_6162# 0
C11246 sg13cmos5l_buf_8_0.X a_19209_5769# 0
C11247 a_6560_3270# a_6385_2749# 0
C11248 sg13cmos5l_dlhr_1_2.Q a_7820_2352# 0.01208f
C11249 sg13cmos5l_dfrbp_1_8.D a_15702_5842# 0
C11250 cks pl_sw[9] 0.7597f
C11251 pl_sw[4] pl_sw[3] 0.11406f
C11252 sg13cmos5l_inv_1_26.Y a_18345_7674# 0
C11253 sg13cmos5l_o21ai_1_0.A1 VPWR 0.4934f
C11254 a_6736_2630# a_6479_2749# 0.35645f
C11255 sg13cmos5l_dfrbp_1_10.Q a_6479_2749# 0
C11256 sg13cmos5l_dlhr_1_9.Q sg13cmos5l_dfrbp_1_16.Q 0.01937f
C11257 a_13178_7684# a_13460_7996# 0.68988f
C11258 a_5194_2356# sg13cmos5l_dlhr_1_0.D 0
C11259 sg13cmos5l_or2_1_0.A nh_sw[5] 0
C11260 sg13cmos5l_buf_1_34.X a_4934_2826# 0.07127f
C11261 sg13cmos5l_buf_1_104.A a_18486_8866# 0
C11262 a_1402_3864# a_1121_4166# 0.33585f
C11263 sg13cmos5l_buf_1_30.A sg13cmos5l_a22oi_1_0.Y 0
C11264 sg13cmos5l_buf_1_1.A a_17769_2017# 0
C11265 a_2436_8861# sg13cmos5l_buf_1_61.X 0
C11266 sg13cmos5l_dfrbp_1_20.Q_N cks 0.02728f
C11267 a_6346_4873# sg13cmos5l_or2_1_0.A 0
C11268 sg13cmos5l_buf_1_4.A a_15590_4650# 0.03408f
C11269 sg13cmos5l_nor2_1_0.A sg13cmos5l_a22oi_1_1.Y 0
C11270 a_5820_5773# sg13cmos5l_dlhr_1_0.GATE 0
C11271 a_16306_8874# pl_sw[9] 0
C11272 sg13cmos5l_buf_1_10.A a_12912_6924# 0
C11273 sg13cmos5l_inv_1_7.A sg13cmos5l_inv_1_0.A 0.02208f
C11274 sg13cmos5l_dfrbp_1_6.RESET_B a_6959_6239# 0.21126f
C11275 sg13cmos5l_buf_1_98.A a_14032_6382# 0
C11276 sg13cmos5l_dfrbp_1_6.D a_16042_6892# 0.0076f
C11277 sg13cmos5l_buf_1_74.X pl_sw[3] 0.05367f
C11278 a_1815_4666# a_1862_4338# 0
C11279 a_16724_8436# ph_sw[8] 0
C11280 sg13cmos5l_inv_1_1.A sg13cmos5l_dlhr_1_15.D 0.02979f
C11281 sg13cmos5l_dlhr_1_4.Q_N a_6560_3270# 0.01282f
C11282 sg13cmos5l_buf_1_39.A a_4840_1664# 0.00989f
C11283 a_4172_1590# sg13cmos5l_buf_1_25.X 0.00284f
C11284 sg13cmos5l_dfrbp_1_6.D a_2566_3151# 0
C11285 sg13cmos5l_inv_1_6.A a_17135_4727# 0
C11286 sg13cmos5l_buf_1_8.A a_14056_1664# 0.00152f
C11287 sg13cmos5l_inv_1_2.A a_11567_7751# 0
C11288 sg13cmos5l_or2_1_0.A a_650_3900# 0.00174f
C11289 sg13cmos5l_inv_1_18.A a_8570_6172# 0
C11290 a_2790_7996# VPWR 0
C11291 a_4324_7996# sg13cmos5l_dlhr_1_1.GATE 0.00372f
C11292 sg13cmos5l_or2_1_0.A a_18057_3529# 0
C11293 sg13cmos5l_dfrbp_1_10.Q a_5492_3460# 0.01227f
C11294 sg13cmos5l_dlhr_1_2.D a_5637_2399# 0
C11295 a_6198_3120# a_5739_2399# 0
C11296 a_3860_2388# a_3974_2388# 0.00122f
C11297 sg13cmos5l_buf_1_96.A sg13cmos5l_a221oi_1_1.C1 0
C11298 sg13cmos5l_dfrbp_1_6.RESET_B a_4514_7666# 0
C11299 sg13cmos5l_buf_1_101.X pl_sw[7] 0.19212f
C11300 sg13cmos5l_or2_1_0.A sg13cmos5l_dlygate4sd3_1_0.X 0.05557f
C11301 a_3664_8678# a_3831_7282# 0
C11302 sg13cmos5l_buf_1_5.A sg13cmos5l_dlhr_1_14.Q_N 0.00577f
C11303 sg13cmos5l_buf_1_19.A a_18961_5814# 0.00103f
C11304 sg13cmos5l_buf_1_44.X a_4847_4727# 0.03517f
C11305 sg13cmos5l_inv_1_7.A a_12490_6385# 0.00305f
C11306 a_16677_6141# sg13cmos5l_dfrbp_1_21.Q_N 0
C11307 a_17519_6239# a_17721_6477# 0.00675f
C11308 a_16779_6284# a_17425_6239# 0.00667f
C11309 a_14056_1664# sg13cmos5l_buf_1_1.A 0.29036f
C11310 a_14924_1590# a_15784_1664# 0
C11311 sg13cmos5l_inv_1_2.A a_14628_8440# 0.11456f
C11312 sg13cmos5l_dfrbp_1_1.Q a_17008_2630# 0.00356f
C11313 sg13cmos5l_buf_1_34.X a_4244_3900# 0.00664f
C11314 a_6276_8861# a_6507_8447# 0.15089f
C11315 a_6405_8447# a_7153_8797# 0.01058f
C11316 a_5962_8404# a_6345_8483# 0.00337f
C11317 a_6789_4629# sg13cmos5l_dfrbp_1_10.Q 0
C11318 sg13cmos5l_dfrbp_1_0.RESET_B a_16751_2749# 0.25667f
C11319 sg13cmos5l_nand2_1_0.A nh_sw[7] 0
C11320 a_14820_7674# VPWR 0
C11321 a_5673_3138# a_5492_3460# 0.40925f
C11322 a_4873_3192# a_5424_3460# 0
C11323 sg13cmos5l_dlhr_1_0.GATE VPWR 0.91351f
C11324 sg13cmos5l_inv_1_14.A a_5951_5383# 0.00132f
C11325 sg13cmos5l_inv_1_27.Y a_12933_6141# 0
C11326 sg13cmos5l_inv_1_8.A a_7378_6162# 0
C11327 sg13cmos5l_dfrbp_1_1.Q a_17126_1626# 0.00925f
C11328 sg13cmos5l_inv_1_0.A sg13cmos5l_a221oi_1_0.B2 0.00251f
C11329 a_8468_4948# a_9111_4666# 0
C11330 a_19734_5842# a_19227_4654# 0.00768f
C11331 a_10233_8559# cks 0.00109f
C11332 sg13cmos5l_dfrbp_1_0.RESET_B a_17412_1944# 0.49659f
C11333 sg13cmos5l_a22oi_1_2.B2 a_9524_4972# 0
C11334 sg13cmos5l_buf_1_38.A a_4018_3138# 0
C11335 a_13652_3900# sg13cmos5l_buf_1_7.A 0.00234f
C11336 sg13cmos5l_buf_1_93.X sg13cmos5l_dfrbp_1_25.Q_N 0.00235f
C11337 a_16748_9150# sg13cmos5l_dfrbp_1_22.D 0
C11338 a_17135_4727# sg13cmos5l_dfrbp_1_8.Q_N 0.04107f
C11339 a_17392_4870# a_17041_4727# 0.01017f
C11340 sg13cmos5l_dfrbp_1_0.RESET_B a_17750_4325# 0
C11341 sg13cmos5l_o21ai_1_0.Y a_13072_1846# 0
C11342 sg13cmos5l_inv_1_18.A a_9260_2352# 0.07115f
C11343 a_5414_6162# a_5069_5376# 0
C11344 sg13cmos5l_buf_1_34.X cks 0.15187f
C11345 a_1065_5459# sg13cmos5l_inv_1_8.Y 0
C11346 sg13cmos5l_dfrbp_1_18.Q a_10288_8678# 0.0039f
C11347 sg13cmos5l_buf_1_38.A a_3860_2388# 0.01923f
C11348 a_20392_7712# frame 0.1256f
C11349 a_2757_3117# nh_sw[1] 0.00181f
C11350 sg13cmos5l_dlhr_1_11.GATE a_11560_7010# 0
C11351 a_620_7638# sg13cmos5l_buf_1_58.A 0
C11352 sg13cmos5l_dlhr_1_15.D a_17751_7690# 0.00722f
C11353 sg13cmos5l_buf_1_10.A sg13cmos5l_dfrbp_1_2.Q_N 0
C11354 sg13cmos5l_a221oi_1_1.C1 sg13cmos5l_a221oi_1_0.B1 0
C11355 a_19240_7712# cko 0
C11356 sg13cmos5l_nand2_1_1.B sg13cmos5l_buf_1_4.X 0
C11357 a_19244_2352# sg13cmos5l_buf_1_18.X 0.32214f
C11358 a_19628_2352# a_20012_2352# 0.00492f
C11359 sg13cmos5l_dfrbp_1_6.RESET_B nl_sw[4] 0.05604f
C11360 sg13cmos5l_buf_1_73.A a_7498_7897# 0.01727f
C11361 a_11464_8436# a_10827_7796# 0.00212f
C11362 sg13cmos5l_buf_1_45.X a_8204_2352# 0
C11363 a_6346_4873# a_6729_5041# 0.00337f
C11364 a_6372_4968# a_6789_4629# 0.48921f
C11365 a_6086_4650# a_6891_4772# 0.11742f
C11366 sg13cmos5l_a22oi_1_1.B1 a_14800_3358# 0
C11367 a_8746_8404# cks 0.01879f
C11368 sg13cmos5l_buf_1_28.X a_10613_2758# 0
C11369 sg13cmos5l_dfrbp_1_0.RESET_B a_12815_1703# 0.20032f
C11370 sg13cmos5l_dfrbp_1_8.RESET_B pl_sw[7] 0
C11371 sg13cmos5l_buf_1_104.A sg13cmos5l_buf_1_18.A 0
C11372 sg13cmos5l_buf_8_2.X a_20008_7712# 0.32347f
C11373 sg13cmos5l_dfrbp_1_6.RESET_B a_2621_7636# 0.04594f
C11374 a_4244_3900# a_3599_3215# 0.00529f
C11375 a_3407_4261# a_3856_3358# 0.00459f
C11376 sg13cmos5l_inv_1_28.Y a_12980_6924# 0
C11377 sg13cmos5l_dfrbp_1_6.RESET_B a_5770_3868# 0.34964f
C11378 sg13cmos5l_or2_1_0.A a_8588_2352# 0
C11379 sg13cmos5l_dfrbp_1_8.RESET_B a_6998_5837# 0
C11380 sg13cmos5l_buf_1_5.A sg13cmos5l_dfrbp_1_0.RESET_B 0.02739f
C11381 sg13cmos5l_buf_1_45.X a_8084_8436# 0.04759f
C11382 a_15702_5842# a_15876_4968# 0
C11383 a_4322_6162# VPWR 0
C11384 sg13cmos5l_buf_1_25.A sg13cmos5l_buf_1_30.X 0
C11385 sg13cmos5l_buf_1_26.A sg13cmos5l_a22oi_1_2.B1 0.00579f
C11386 sg13cmos5l_buf_1_9.A sg13cmos5l_dlhr_1_0.D 0.00411f
C11387 a_18928_1846# a_18577_1703# 0.01017f
C11388 a_18671_1703# sg13cmos5l_dfrbp_1_0.Q_N 0.04107f
C11389 sg13cmos5l_dfrbp_1_6.RESET_B sg13cmos5l_inv_1_6.A 0.19247f
C11390 sg13cmos5l_buf_1_19.A sg13cmos5l_buf_1_104.X 0
C11391 sg13cmos5l_buf_1_3.A a_20392_7712# 0.01101f
C11392 a_1873_5773# VPWR 0.00287f
C11393 sg13cmos5l_dlhr_1_5.GATE sg13cmos5l_buf_1_56.A 0
C11394 sg13cmos5l_dfrbp_1_16.Q a_2727_6380# 0.01708f
C11395 sg13cmos5l_buf_1_25.A a_8680_1664# 0
C11396 a_17498_8800# sg13cmos5l_dlhr_1_15.D 0.00171f
C11397 a_18959_3215# a_19216_3358# 0.35645f
C11398 a_1878_6337# sg13cmos5l_dfrbp_1_15.Q_N 0.25039f
C11399 a_15887_8797# a_15782_7362# 0
C11400 sg13cmos5l_buf_1_30.A sg13cmos5l_buf_1_26.A 0.71575f
C11401 a_1006_4167# ckc 0
C11402 sg13cmos5l_dlhr_1_15.D a_15702_4187# 0
C11403 sg13cmos5l_buf_1_73.X a_7153_8797# 0.003f
C11404 sg13cmos5l_nand2_1_1.B sg13cmos5l_buf_1_28.X 0.55459f
C11405 a_1463_8511# pl_sw[0] 0
C11406 a_3562_4873# a_3407_4261# 0
C11407 sg13cmos5l_dfrbp_1_9.Q a_3664_4142# 0.01519f
C11408 a_13178_7684# a_13393_7666# 0.00284f
C11409 a_6479_2749# a_6898_2826# 0.00176f
C11410 a_5739_2399# sg13cmos5l_dlhr_1_0.D 0
C11411 sg13cmos5l_buf_1_45.X sg13cmos5l_a22oi_1_2.B2 0
C11412 sg13cmos5l_buf_1_34.X a_5446_2813# 0
C11413 sg13cmos5l_inv_1_28.Y sg13cmos5l_buf_1_57.X 0
C11414 sg13cmos5l_buf_1_107.X sg13cmos5l_buf_1_104.X 0
C11415 a_2122_8404# cks 0.01712f
C11416 sg13cmos5l_buf_8_2.X a_19624_8436# 0.00285f
C11417 a_14900_2352# a_15466_2356# 0.00288f
C11418 a_9823_2364# nl_sw[5] 0.00707f
C11419 sg13cmos5l_buf_1_4.A a_17392_4870# 0
C11420 a_6180_4650# sg13cmos5l_or2_1_0.A 0
C11421 sg13cmos5l_nor2b_1_0.Y a_13072_4142# 0.01565f
C11422 sg13cmos5l_dfrbp_1_11.Q sg13cmos5l_dlhr_1_0.GATE 0
C11423 sg13cmos5l_a22oi_1_0.Y a_11270_4338# 0
C11424 sg13cmos5l_inv_1_18.A sg13cmos5l_nor2_1_0.A 0
C11425 sg13cmos5l_inv_1_20.Y sg13cmos5l_buf_1_65.X 0.24832f
C11426 sg13cmos5l_buf_1_30.A sg13cmos5l_buf_1_46.A 0.00247f
C11427 a_11846_9186# a_13391_9263# 0
C11428 sg13cmos5l_dfrbp_1_6.RESET_B sg13cmos5l_dlhr_1_6.D 0.02823f
C11429 a_14449_3215# a_14962_3138# 0
C11430 sg13cmos5l_dfrbp_1_6.D a_16587_6935# 0.00849f
C11431 a_2409_4650# a_2565_3911# 0.03561f
C11432 a_2228_4972# a_2148_3904# 0
C11433 sg13cmos5l_dfrbp_1_6.RESET_B a_8412_7326# 0
C11434 sg13cmos5l_or2_1_0.A a_2054_3138# 0.00776f
C11435 sg13cmos5l_dfrbp_1_6.RESET_B sg13cmos5l_dfrbp_1_8.Q_N 0.05116f
C11436 a_16940_3102# cks 0.04091f
C11437 sg13cmos5l_dfrbp_1_11.Q a_9076_5800# 0
C11438 sg13cmos5l_buf_1_24.X nl_sw[2] 0
C11439 sg13cmos5l_buf_1_77.A a_8966_6600# 0
C11440 sg13cmos5l_inv_1_2.A sg13cmos5l_dlhr_1_11.D 0
C11441 sg13cmos5l_dfrbp_1_16.Q_N VPWR 0.2658f
C11442 a_6198_3120# a_6385_2749# 0
C11443 sg13cmos5l_dlhr_1_2.D a_6479_2749# 0.05968f
C11444 sg13cmos5l_buf_1_34.X a_5079_3154# 0.00392f
C11445 sg13cmos5l_dlhr_1_6.D a_10412_6126# 0.00758f
C11446 sg13cmos5l_dfrbp_1_1.Q nh_sw[7] 0.01746f
C11447 a_3212_1590# nh_sw[2] 0
C11448 sg13cmos5l_dfrbp_1_6.RESET_B a_7750_7687# 0
C11449 sg13cmos5l_buf_1_79.X a_10827_7796# 0
C11450 a_10230_4632# sg13cmos5l_dfrbp_1_2.D 0
C11451 a_3407_8797# a_4244_6924# 0
C11452 sg13cmos5l_dfrbp_1_15.D a_3831_7282# 0.23921f
C11453 sg13cmos5l_dfrbp_1_6.RESET_B a_20204_5376# 0.00196f
C11454 sg13cmos5l_buf_1_31.X a_9033_6162# 0.0165f
C11455 a_10071_7282# sg13cmos5l_dlhr_1_6.D 0
C11456 sg13cmos5l_inv_1_2.A a_15887_8797# 0.02642f
C11457 sg13cmos5l_dlhr_1_1.Q a_3396_4650# 0
C11458 sg13cmos5l_a22oi_1_1.A1 sg13cmos5l_buf_1_4.X 0
C11459 sg13cmos5l_dlhr_1_5.Q a_8390_6924# 0
C11460 sg13cmos5l_dfrbp_1_1.Q a_18376_2388# 0.00454f
C11461 a_8982_7354# a_9865_7282# 0
C11462 a_8468_4948# sg13cmos5l_dfrbp_1_10.Q 0
C11463 a_7504_8678# a_7666_8874# 0.0019f
C11464 a_7247_8797# a_7153_8797# 0.32273f
C11465 sg13cmos5l_dfrbp_1_0.RESET_B a_18760_2388# 0
C11466 a_16177_7751# VPWR 0
C11467 a_6198_3120# sg13cmos5l_dlhr_1_4.Q_N 0.12876f
C11468 sg13cmos5l_buf_1_110.A a_14726_7674# 0.00439f
C11469 a_11464_9224# sg13cmos5l_dlhr_1_11.GATE 0.03505f
C11470 sg13cmos5l_dfrbp_1_10.Q a_2859_3260# 0
C11471 a_4873_3192# sg13cmos5l_buf_1_34.A 0
C11472 sg13cmos5l_dfrbp_1_1.Q a_18928_1846# 0.00197f
C11473 sg13cmos5l_buf_1_57.X sg13cmos5l_buf_1_31.X 0.62376f
C11474 sg13cmos5l_dfrbp_1_2.D nh_sw[5] 0.00144f
C11475 a_14889_7281# sg13cmos5l_a22oi_1_1.B2 0
C11476 sg13cmos5l_dfrbp_1_12.Q_N a_8905_4704# 0.13859f
C11477 a_2228_4972# sg13cmos5l_or2_1_0.A 0
C11478 sg13cmos5l_inv_1_5.A sg13cmos5l_dfrbp_1_1.Q 0.00147f
C11479 a_3578_2752# a_3860_2388# 0.68988f
C11480 sg13cmos5l_buf_1_19.X nl_sw[10] 0.03907f
C11481 a_5700_6480# a_5710_5850# 0
C11482 a_12022_3134# a_11877_2399# 0.00179f
C11483 sg13cmos5l_dfrbp_1_16.Q a_8660_5412# 0.01444f
C11484 sg13cmos5l_nor2_1_0.A a_11394_4948# 0.01735f
C11485 a_708_5416# sg13cmos5l_nor2_1_2.A 0
C11486 sg13cmos5l_buf_1_40.X nl_sw[0] 0
C11487 sg13cmos5l_buf_1_31.X sg13cmos5l_buf_1_28.A 0
C11488 sg13cmos5l_buf_1_10.A a_13284_3456# 0.00141f
C11489 sg13cmos5l_nor2b_1_1.Y VPWR 0.38174f
C11490 sg13cmos5l_nor2b_1_1.Y nl_sw[7] 0
C11491 sg13cmos5l_buf_1_96.A a_10827_7796# 0.02854f
C11492 a_11556_3904# a_11979_2399# 0
C11493 a_2340_3456# a_3241_2746# 0
C11494 a_2757_3117# a_3447_2746# 0.00827f
C11495 sg13cmos5l_dfrbp_1_1.Q a_15357_1816# 0.00117f
C11496 sg13cmos5l_inv_1_29.Y sg13cmos5l_inv_1_0.Y 0
C11497 a_996_5837# sg13cmos5l_inv_1_8.Y 0
C11498 a_13234_1626# nh_sw[6] 0.00151f
C11499 a_6789_4629# a_7888_4870# 0
C11500 a_6346_4873# a_6660_4663# 0.00659f
C11501 a_6891_4772# a_7631_4727# 0.3087f
C11502 sg13cmos5l_buf_1_65.X sg13cmos5l_inv_1_2.A 0.00555f
C11503 a_10288_8678# cks 0.01239f
C11504 sg13cmos5l_dfrbp_1_9.Q a_6560_3270# 0
C11505 sg13cmos5l_dfrbp_1_0.RESET_B a_15784_1664# 0.01141f
C11506 sg13cmos5l_a22oi_1_1.B1 a_15821_3864# 0
C11507 sg13cmos5l_buf_1_38.A a_3856_3358# 0.02698f
C11508 a_4244_3900# sg13cmos5l_dfrbp_1_10.Q_N 0
C11509 sg13cmos5l_dfrbp_1_6.RESET_B a_7312_4142# 0.17543f
C11510 sg13cmos5l_buf_1_45.A nh_sw[4] 0
C11511 a_13768_8436# a_14342_8874# 0
C11512 sg13cmos5l_dfrbp_1_8.RESET_B a_8378_5776# 0
C11513 sg13cmos5l_buf_1_45.X a_8746_8404# 0
C11514 a_16264_9224# a_16748_9150# 0.03472f
C11515 a_5508_6162# VPWR 0
C11516 a_1672_3176# a_2054_3138# 0
C11517 sg13cmos5l_buf_1_65.X sg13cmos5l_buf_1_68.X 0.14385f
C11518 sg13cmos5l_inv_1_27.Y sg13cmos5l_buf_1_98.A 0
C11519 a_4176_6924# VPWR 0
C11520 a_16485_6935# cks 0.00425f
C11521 sg13cmos5l_dlhr_1_5.GATE a_4107_4772# 0
C11522 sg13cmos5l_dlhr_1_0.D sg13cmos5l_dfrbp_1_1.D 0.0679f
C11523 sg13cmos5l_nor2_1_2.A a_1192_1664# 0
C11524 sg13cmos5l_dfrbp_1_16.Q a_3530_6320# 0.0192f
C11525 sg13cmos5l_buf_1_40.A a_1760_3986# 0
C11526 sg13cmos5l_buf_1_4.X nh_sw[8] 1.14687f
C11527 sg13cmos5l_buf_1_19.A a_18865_3215# 0.00469f
C11528 a_12106_9409# a_11567_7751# 0
C11529 sg13cmos5l_buf_1_41.A a_3488_7010# 0.0354f
C11530 sg13cmos5l_buf_1_10.A a_13324_4696# 0
C11531 a_1997_6126# a_3575_6553# 0
C11532 a_2879_6432# a_2380_6162# 0
C11533 a_20392_3900# a_20392_3176# 0.00833f
C11534 sg13cmos5l_dfrbp_1_22.D a_15876_7362# 0
C11535 a_11656_3176# VPWR 0.25873f
C11536 sg13cmos5l_dfrbp_1_8.RESET_B sg13cmos5l_buf_1_61.X 0
C11537 sg13cmos5l_buf_1_60.X a_5800_9224# 0
C11538 sg13cmos5l_a22oi_1_0.B1 a_11002_3142# 0
C11539 sg13cmos5l_a22oi_1_0.B1 a_10696_1758# 0
C11540 sg13cmos5l_dfrbp_1_9.Q a_5132_3864# 0
C11541 a_12132_9504# sg13cmos5l_inv_1_7.A 0
C11542 sg13cmos5l_dlhr_1_11.GATE sg13cmos5l_buf_1_5.A 0.10476f
C11543 sg13cmos5l_dfrbp_1_8.RESET_B a_14602_8404# 0.34614f
C11544 sg13cmos5l_nand2_1_1.B sg13cmos5l_a22oi_1_2.B1 0.23861f
C11545 ph_sw[7] ph_sw[9] 0
C11546 ph_sw[8] frame 0
C11547 a_14166_7656# a_14726_7674# 0
C11548 a_3588_4968# a_3876_4663# 0.4806f
C11549 a_3407_8797# cks 0.00886f
C11550 a_19227_4654# a_20200_3270# 0.00434f
C11551 sg13cmos5l_dlhr_1_9.Q a_3669_6320# 0.02107f
C11552 sg13cmos5l_buf_1_44.X a_4559_7630# 0.02723f
C11553 sg13cmos5l_nor2b_1_0.Y sg13cmos5l_dfrbp_1_2.Q_N 0
C11554 sg13cmos5l_a22oi_1_0.Y a_11844_4325# 0
C11555 sg13cmos5l_buf_1_25.A sg13cmos5l_buf_1_24.X 0.22855f
C11556 a_13391_9263# a_13648_9406# 0.35645f
C11557 a_7924_1612# nl_sw[4] 0
C11558 sg13cmos5l_nand2_1_0.A sg13cmos5l_dfrbp_1_1.Q 0.28563f
C11559 sg13cmos5l_dfrbp_1_6.D sg13cmos5l_dfrbp_1_22.Q_N 0.00353f
C11560 sg13cmos5l_a22oi_1_1.B1 VPWR 0.45024f
C11561 a_1125_6935# a_1873_7285# 0.01058f
C11562 a_424_8436# a_1196_8400# 0
C11563 sg13cmos5l_buf_1_79.X sg13cmos5l_dfrbp_1_18.Q 0.01915f
C11564 sg13cmos5l_dfrbp_1_9.Q a_2122_3868# 0
C11565 sg13cmos5l_dfrbp_1_8.RESET_B a_3962_7288# 0
C11566 sg13cmos5l_or2_1_0.A a_3856_3358# 0
C11567 a_9705_4650# sg13cmos5l_buf_1_28.X 0
C11568 a_19340_8400# cks 0.03322f
C11569 sg13cmos5l_buf_1_30.A a_7497_3138# 0.0039f
C11570 sg13cmos5l_dlygate4sd2_1_0.A a_1158_3142# 0.04268f
C11571 sg13cmos5l_buf_1_87.A ph_sw[8] 0.1876f
C11572 a_14814_3876# a_14900_2352# 0
C11573 sg13cmos5l_buf_1_57.X sg13cmos5l_a221oi_1_0.C1 0
C11574 a_3676_7964# sg13cmos5l_dfrbp_1_16.Q 0.00889f
C11575 sg13cmos5l_dfrbp_1_16.Q_N a_1967_7285# 0.04654f
C11576 sg13cmos5l_dfrbp_1_21.Q a_13792_5760# 0
C11577 sg13cmos5l_dfrbp_1_15.D a_4425_7281# 0.0162f
C11578 sg13cmos5l_dlhr_1_5.Q sg13cmos5l_buf_1_29.A 0.01229f
C11579 a_1662_8374# sg13cmos5l_buf_1_61.X 0
C11580 sg13cmos5l_dlhr_1_5.GATE a_2879_6432# 0
C11581 sg13cmos5l_buf_1_2.X sg13cmos5l_nor2_1_1.A 0.02525f
C11582 a_6507_8447# a_7449_8559# 0
C11583 a_8084_8436# a_8746_8404# 0.00329f
C11584 sg13cmos5l_dfrbp_1_6.D a_14844_7326# 0
C11585 sg13cmos5l_dlygate4sd2_1_0.A a_1006_4167# 0.04865f
C11586 sg13cmos5l_buf_1_110.A a_16528_7894# 0
C11587 sg13cmos5l_dfrbp_1_20.Q sg13cmos5l_buf_1_29.A 0.06918f
C11588 sg13cmos5l_dfrbp_1_8.RESET_B a_6903_3154# 0
C11589 sg13cmos5l_inv_1_17.A sg13cmos5l_buf_1_32.A 0
C11590 sg13cmos5l_or2_1_0.A a_416_3986# 0
C11591 a_2596_7996# VPWR 0.36073f
C11592 a_1946_4660# a_2228_4972# 0.68988f
C11593 a_3574_7850# sg13cmos5l_dlhr_1_9.Q_N 0.12876f
C11594 sg13cmos5l_or2_1_0.A sg13cmos5l_buf_1_4.X 0.00434f
C11595 a_5604_4338# VPWR 0
C11596 sg13cmos5l_dfrbp_1_20.Q a_10665_7281# 0.02957f
C11597 sg13cmos5l_dfrbp_1_1.Q a_18577_1703# 0.00188f
C11598 sg13cmos5l_dlhr_1_15.D a_11980_4948# 0
C11599 sg13cmos5l_dfrbp_1_6.RESET_B a_1125_5423# 0.07029f
C11600 a_19227_4654# sg13cmos5l_a22oi_1_1.A1 0.00527f
C11601 a_4041_2745# a_4276_2776# 0.00566f
C11602 a_3860_2388# sg13cmos5l_buf_1_34.A 0
C11603 a_4652_6126# a_4107_4772# 0
C11604 sg13cmos5l_buf_1_41.A a_3664_4142# 0
C11605 sg13cmos5l_buf_1_93.X ph_sw[8] 0.00134f
C11606 sg13cmos5l_dfrbp_1_6.RESET_B a_15412_5800# 0.00484f
C11607 a_6865_6239# a_5820_5773# 0
C11608 sg13cmos5l_dfrbp_1_18.Q sg13cmos5l_buf_1_96.A 0
C11609 sg13cmos5l_buf_1_7.A a_13803_3260# 0.03822f
C11610 sg13cmos5l_buf_1_10.A a_10202_7288# 0
C11611 a_12896_3270# a_11979_2399# 0.00212f
C11612 a_13258_3361# a_12719_2749# 0
C11613 sg13cmos5l_buf_1_31.X sg13cmos5l_dlhr_1_1.Q 0
C11614 a_16264_9224# ph_sw[6] 0
C11615 pl_sw[1] sg13cmos5l_buf_1_68.X 0.19466f
C11616 sg13cmos5l_buf_1_101.X a_16144_8678# 0
C11617 a_4950_5699# sg13cmos5l_inv_1_19.A 0
C11618 sg13cmos5l_or2_1_1.B a_13792_5760# 0
C11619 sg13cmos5l_buf_1_76.X ph_sw[3] 0.05255f
C11620 sg13cmos5l_dlhr_1_0.GATE sg13cmos5l_buf_1_25.X 0
C11621 sg13cmos5l_buf_1_96.A a_11769_7989# 0
C11622 a_3856_3358# a_3578_2752# 0.005f
C11623 sg13cmos5l_dlhr_1_15.D a_15974_6162# 0
C11624 sg13cmos5l_dfrbp_1_0.CLK a_12719_2749# 0.00999f
C11625 a_11072_5347# a_11370_5760# 0.00571f
C11626 a_7631_4727# a_7833_4965# 0.00675f
C11627 sg13cmos5l_and3_1_0.C a_14900_2352# 0
C11628 a_11464_8436# cks 0.00664f
C11629 sg13cmos5l_dlhr_1_9.D sg13cmos5l_buf_1_29.A 0.03027f
C11630 a_13391_9263# ph_sw[6] 0.00724f
C11631 a_3407_8797# a_3609_8559# 0.00675f
C11632 sg13cmos5l_a22oi_1_1.B1 a_16551_3987# 0
C11633 sg13cmos5l_dfrbp_1_6.RESET_B a_8972_3864# 0
C11634 sg13cmos5l_dfrbp_1_8.RESET_B a_2436_4325# 0.00465f
C11635 sg13cmos5l_dlhr_1_11.GATE a_13460_7996# 0
C11636 a_902_3142# a_908_1590# 0
C11637 a_2804_5412# sg13cmos5l_dlhr_1_1.Q 0.00666f
C11638 sg13cmos5l_inv_1_2.A a_11846_9186# 0.00292f
C11639 sg13cmos5l_or2_1_0.A sg13cmos5l_buf_1_28.X 0.00102f
C11640 sg13cmos5l_buf_1_87.A a_18999_6178# 0
C11641 a_3692_9150# pl_sw[2] 0.00437f
C11642 sg13cmos5l_nand2_1_1.B a_16268_3102# 0
C11643 a_2757_3117# a_2859_3260# 0.66105f
C11644 a_2054_3138# a_2148_3138# 0.00718f
C11645 a_6865_6239# VPWR 0
C11646 a_2565_3911# sg13cmos5l_dfrbp_1_10.Q_N 0
C11647 a_8982_7354# VPWR 0.25006f
C11648 a_17327_7285# cks 0
C11649 a_17041_4727# VPWR 0
C11650 a_13072_1846# nh_sw[6] 0.01474f
C11651 sg13cmos5l_dfrbp_1_9.Q a_6198_3120# 0
C11652 sg13cmos5l_buf_1_10.A a_12520_4782# 0.01225f
C11653 a_2727_6380# a_3669_6320# 0.00999f
C11654 sg13cmos5l_buf_1_24.A a_5700_6480# 0.03163f
C11655 sg13cmos5l_buf_1_41.A sg13cmos5l_buf_1_59.A 0
C11656 sg13cmos5l_inv_1_3.A a_12815_4261# 0
C11657 a_6380_7638# a_6117_6141# 0
C11658 sg13cmos5l_dfrbp_1_21.Q sg13cmos5l_buf_8_1.A 0.00675f
C11659 sg13cmos5l_dfrbp_1_9.Q a_3241_2746# 0.02848f
C11660 sg13cmos5l_buf_1_104.X ph_sw[10] 0.14f
C11661 sg13cmos5l_dfrbp_1_22.D a_16356_7349# 0.00203f
C11662 sg13cmos5l_inv_1_6.A sg13cmos5l_buf_1_86.A 0.57123f
C11663 sg13cmos5l_buf_1_3.A a_18999_6178# 0.0089f
C11664 sg13cmos5l_dlhr_1_9.D a_4950_5699# 0.05168f
C11665 sg13cmos5l_dfrbp_1_15.Q_N a_1227_5423# 0
C11666 a_7812_7687# VPWR 0.00674f
C11667 sg13cmos5l_dlhr_1_16.Q_N VPWR 0.25185f
C11668 sg13cmos5l_inv_1_1.A a_15412_5800# 0.00206f
C11669 sg13cmos5l_dfrbp_1_8.RESET_B a_16144_8678# 0.17573f
C11670 sg13cmos5l_o21ai_1_0.A1 a_12120_3456# 0.00451f
C11671 sg13cmos5l_nand2_1_1.B a_13652_3900# 0
C11672 a_14986_7897# a_15429_7653# 0.02241f
C11673 sg13cmos5l_dfrbp_1_21.Q a_18960_5412# 0
C11674 sg13cmos5l_a22oi_1_1.B2 a_15684_4650# 0
C11675 a_11782_1639# nl_sw[6] 0
C11676 sg13cmos5l_buf_1_4.A a_15821_3864# 0.04485f
C11677 a_4847_4727# a_5049_4965# 0.00675f
C11678 sg13cmos5l_buf_1_3.A a_20288_2474# 0.00484f
C11679 a_5951_5383# a_5770_3868# 0
C11680 a_5799_5499# a_5796_3904# 0
C11681 a_5820_5773# a_6315_3911# 0
C11682 sg13cmos5l_inv_1_17.A sg13cmos5l_dfrbp_1_16.Q 1.18832f
C11683 sg13cmos5l_nor2b_1_0.Y a_13284_3456# 0
C11684 sg13cmos5l_buf_1_43.A nl_sw[0] 0.03236f
C11685 a_1125_6935# a_1997_6126# 0.00445f
C11686 sg13cmos5l_buf_1_30.A a_7248_3460# 0
C11687 sg13cmos5l_buf_1_41.A a_3792_2388# 0
C11688 sg13cmos5l_dlygate4sd2_1_0.A a_2859_3260# 0
C11689 a_11182_4948# sg13cmos5l_dfrbp_1_0.RESET_B 0
C11690 a_12814_4692# sg13cmos5l_a22oi_1_1.B1 0
C11691 a_13486_5412# VPWR 0.29848f
C11692 sg13cmos5l_inv_1_0.A a_12721_4261# 0
C11693 sg13cmos5l_dfrbp_1_21.Q a_14152_5498# 0.00675f
C11694 a_6188_1590# nh_sw[3] 0.00179f
C11695 sg13cmos5l_buf_8_2.X a_18486_8866# 0
C11696 sg13cmos5l_nor2_1_2.A a_1862_4338# 0
C11697 sg13cmos5l_inv_1_29.A a_11190_7354# 0
C11698 sg13cmos5l_inv_1_17.A a_3688_1664# 0.00119f
C11699 a_10464_2427# nl_sw[5] 0.00917f
C11700 sg13cmos5l_buf_1_79.X cks 0.02277f
C11701 a_3016_9318# a_2621_7636# 0.00251f
C11702 sg13cmos5l_nand2_1_1.A a_19161_3453# 0
C11703 sg13cmos5l_dfrbp_1_6.D a_18278_8112# 0
C11704 sg13cmos5l_buf_1_44.X a_5510_4338# 0
C11705 sg13cmos5l_inv_1_0.A a_13418_4696# 0.00353f
C11706 a_8486_8874# a_9189_8447# 0.02431f
C11707 sg13cmos5l_a22oi_1_1.A1 a_20392_3900# 0.001f
C11708 a_13572_3151# a_13510_3151# 0
C11709 sg13cmos5l_dfrbp_1_20.Q a_12216_5728# 0
C11710 sg13cmos5l_buf_1_86.A a_20204_5376# 0
C11711 a_3308_9150# sg13cmos5l_dfrbp_1_8.RESET_B 0
C11712 sg13cmos5l_inv_1_0.A a_11364_4338# 0
C11713 a_6405_8447# sg13cmos5l_buf_1_30.A 0.002f
C11714 a_1192_1664# a_1576_1758# 0.03269f
C11715 sg13cmos5l_a22oi_1_2.B2 a_10220_3102# 0.00775f
C11716 sg13cmos5l_nor2b_1_0.Y a_13324_4696# 0.13774f
C11717 a_2228_4972# a_2342_5088# 0.00122f
C11718 a_2409_4650# sg13cmos5l_dlhr_1_1.Q_N 0.00294f
C11719 sg13cmos5l_buf_1_29.A a_9823_2364# 0.00686f
C11720 sg13cmos5l_buf_1_77.A a_8570_6172# 0.016f
C11721 a_4559_7630# sg13cmos5l_dlhr_1_9.Q 0.00182f
C11722 a_20008_7712# a_19904_7806# 0.00624f
C11723 sg13cmos5l_buf_1_34.X a_3599_3215# 0
C11724 sg13cmos5l_dfrbp_1_20.Q a_11560_7010# 0
C11725 a_6315_3911# VPWR 0.21455f
C11726 a_2596_7996# a_1967_7285# 0.00886f
C11727 a_1948_7964# a_1873_7285# 0
C11728 sg13cmos5l_buf_1_4.A VPWR 0.81904f
C11729 sg13cmos5l_dlhr_1_6.D a_8439_6178# 0.01988f
C11730 sg13cmos5l_buf_1_4.A nl_sw[7] 0
C11731 sg13cmos5l_dlygate4sd2_1_0.A a_1472_4782# 0
C11732 a_2348_7624# a_2583_7710# 0.00404f
C11733 a_8457_7281# a_8570_6172# 0.00688f
C11734 sg13cmos5l_dfrbp_1_6.RESET_B a_18961_5814# 0
C11735 sg13cmos5l_buf_1_10.A sg13cmos5l_dlhr_1_18.Q_N 0
C11736 sg13cmos5l_a22oi_1_1.A1 a_16268_3102# 0
C11737 sg13cmos5l_buf_1_101.X sg13cmos5l_dfrbp_1_22.D 0.0029f
C11738 a_17041_4727# a_17554_4650# 0
C11739 VPWR d_out[1] 0.30728f
C11740 nh_sw[10] d_out[0] 1.21761f
C11741 nl_sw[4] nh_sw[4] 0.18057f
C11742 a_5710_5850# sg13cmos5l_inv_1_19.A 0
C11743 sg13cmos5l_or2_1_1.B a_14152_5498# 0
C11744 sg13cmos5l_dfrbp_1_8.RESET_B a_5796_8874# 0
C11745 a_3505_3215# a_4018_3138# 0
C11746 a_9040_7894# a_8852_6484# 0
C11747 a_9620_7972# a_9033_6162# 0
C11748 a_8783_7751# a_9558_6144# 0
C11749 sg13cmos5l_inv_1_1.A pl_sw[7] 0.00196f
C11750 sg13cmos5l_inv_1_2.A a_16748_9150# 0
C11751 sg13cmos5l_dfrbp_1_0.CLK sg13cmos5l_nor2_1_1.A 0.78101f
C11752 sg13cmos5l_dlhr_1_15.D a_17776_6382# 0.00244f
C11753 a_7052_9150# sg13cmos5l_inv_1_14.A 0.34069f
C11754 a_8468_4948# sg13cmos5l_dfrbp_1_12.Q_N 0.02034f
C11755 sg13cmos5l_buf_1_44.X pl_sw[4] 0
C11756 sg13cmos5l_buf_1_96.A cks 0.02705f
C11757 sg13cmos5l_buf_1_65.X a_1463_8741# 0
C11758 sg13cmos5l_a22oi_1_1.B1 a_16462_4023# 0
C11759 sg13cmos5l_inv_1_17.A a_4005_4629# 0.01263f
C11760 a_13652_3900# sg13cmos5l_a22oi_1_1.A1 0
C11761 sg13cmos5l_dfrbp_1_8.RESET_B a_2505_3947# 0
C11762 sg13cmos5l_inv_1_18.A sg13cmos5l_buf_1_26.X 0.03644f
C11763 a_1065_5459# sg13cmos5l_inv_1_9.Y 0
C11764 a_3016_9318# ph_sw[1] 0.0021f
C11765 sg13cmos5l_buf_1_60.A cks 0.00219f
C11766 sg13cmos5l_dfrbp_1_20.Q_N a_10288_8678# 0
C11767 a_9620_7972# sg13cmos5l_buf_1_57.X 0.03311f
C11768 sg13cmos5l_buf_8_0.X frame 0.0303f
C11769 sg13cmos5l_dlhr_1_11.GATE a_13393_7666# 0
C11770 sg13cmos5l_dfrbp_1_6.RESET_B a_9456_4972# 0
C11771 sg13cmos5l_buf_8_0.X a_19796_3436# 0
C11772 sg13cmos5l_inv_1_2.A a_13648_9406# 0.00692f
C11773 sg13cmos5l_dlhr_1_11.GATE ph_sw[5] 0.02283f
C11774 a_2859_3260# a_3801_3453# 0
C11775 a_2340_3456# a_2566_3151# 0.00523f
C11776 a_2757_3117# a_2628_3151# 0.01562f
C11777 a_2314_3361# sg13cmos5l_dfrbp_1_10.Q_N 0
C11778 sg13cmos5l_dlhr_1_15.Q cko 0
C11779 sg13cmos5l_or2_1_0.A sg13cmos5l_a22oi_1_2.B1 0
C11780 sg13cmos5l_buf_1_10.A a_12520_3176# 0.33679f
C11781 sg13cmos5l_dfrbp_1_8.RESET_B a_1862_4338# 0.09874f
C11782 sg13cmos5l_dlhr_1_5.GATE sg13cmos5l_dlhr_1_0.GATE 0
C11783 sg13cmos5l_dfrbp_1_16.Q a_7216_6382# 0.00161f
C11784 a_16268_1590# nh_sw[6] 0
C11785 sg13cmos5l_dfrbp_1_23.CLK VPWR 0.87314f
C11786 sg13cmos5l_buf_1_65.X ph_sw[2] 0.09443f
C11787 sg13cmos5l_inv_1_8.A sg13cmos5l_dlhr_1_1.Q 0.40294f
C11788 a_2748_6126# a_2638_6162# 0.4858f
C11789 a_3669_6320# a_3530_6320# 0.00659f
C11790 sg13cmos5l_buf_8_2.X sg13cmos5l_buf_1_18.A 0.01717f
C11791 sg13cmos5l_buf_1_107.X a_18097_7666# 0
C11792 sg13cmos5l_inv_1_17.A sg13cmos5l_inv_1_9.Y 0
C11793 sg13cmos5l_dfrbp_1_22.D a_16425_6971# 0
C11794 sg13cmos5l_buf_1_3.A a_19526_6600# 0.00176f
C11795 sg13cmos5l_buf_1_8.X a_10888_1664# 0.28823f
C11796 sg13cmos5l_buf_1_30.A sg13cmos5l_or2_1_0.A 0.02849f
C11797 a_2727_6380# a_3308_5376# 0
C11798 a_2748_6126# a_1967_5773# 0
C11799 sg13cmos5l_dfrbp_1_6.RESET_B a_13977_6477# 0.00343f
C11800 sg13cmos5l_buf_1_57.X a_14714_5776# 0.00238f
C11801 a_11434_2356# VPWR 0.10266f
C11802 sg13cmos5l_dfrbp_1_8.RESET_B sg13cmos5l_dfrbp_1_22.D 0.36834f
C11803 sg13cmos5l_buf_1_73.X sg13cmos5l_buf_1_30.A 0
C11804 a_14726_7674# a_15369_8065# 0.00806f
C11805 a_15012_7992# a_15531_7796# 0.38902f
C11806 sg13cmos5l_buf_1_73.A a_7153_8797# 0.00132f
C11807 a_5684_4948# sg13cmos5l_dlhr_1_0.GATE 0.16312f
C11808 sg13cmos5l_buf_1_4.A a_16551_3987# 0.00589f
C11809 sg13cmos5l_buf_1_26.A sg13cmos5l_buf_1_30.X 0.15666f
C11810 a_1862_8874# a_2565_8447# 0.02431f
C11811 sg13cmos5l_inv_1_8.A a_1997_6126# 0.00222f
C11812 a_20008_8436# frame 0.01006f
C11813 sg13cmos5l_buf_1_3.A sg13cmos5l_buf_8_0.X 0.0561f
C11814 sg13cmos5l_buf_1_26.A a_8680_1664# 0.02f
C11815 sg13cmos5l_buf_1_5.A a_14583_5770# 0.00434f
C11816 sg13cmos5l_buf_1_19.A a_18959_3215# 0
C11817 sg13cmos5l_buf_1_40.A sg13cmos5l_dlygate4sd3_1_0.X 0.00102f
C11818 a_16268_3102# nh_sw[8] 0
C11819 sg13cmos5l_buf_1_58.A sg13cmos5l_buf_1_62.X 0
C11820 sg13cmos5l_dfrbp_1_11.Q a_6315_3911# 0.01881f
C11821 a_10288_8678# a_10233_8559# 0.00464f
C11822 a_16271_7751# ph_sw[7] 0
C11823 a_19340_8400# pl_sw[9] 0.28893f
C11824 sg13cmos5l_dfrbp_1_22.D a_15414_7354# 0.04057f
C11825 sg13cmos5l_nor2_1_2.A ckc 0.00183f
C11826 sg13cmos5l_dfrbp_1_2.D sg13cmos5l_buf_1_28.X 0
C11827 sg13cmos5l_inv_1_29.A sg13cmos5l_or2_1_1.B 0.00134f
C11828 sg13cmos5l_buf_1_30.A a_7820_2352# 0
C11829 sg13cmos5l_dfrbp_1_18.Q a_9673_9240# 0.03169f
C11830 a_12132_9504# a_12232_8436# 0.00636f
C11831 sg13cmos5l_dfrbp_1_6.RESET_B a_8378_5776# 0.00619f
C11832 sg13cmos5l_buf_1_57.X a_14194_6162# 0
C11833 sg13cmos5l_dfrbp_1_21.Q sg13cmos5l_dlhr_1_19.Q_N 0.0061f
C11834 a_8841_5769# a_8796_5814# 0
C11835 sg13cmos5l_inv_1_0.A a_13258_3361# 0
C11836 a_7095_1642# nh_sw[3] 0.00117f
C11837 a_11913_2017# nl_sw[6] 0
C11838 sg13cmos5l_buf_1_87.A a_20008_8436# 0
C11839 a_4076_7624# a_3575_6553# 0
C11840 sg13cmos5l_dfrbp_1_16.Q_N a_2380_6162# 0
C11841 sg13cmos5l_inv_1_29.A a_12567_7282# 0.00418f
C11842 a_708_6928# a_1873_7285# 0.4858f
C11843 sg13cmos5l_buf_1_77.A sg13cmos5l_nor2_1_0.A 0
C11844 a_6903_3154# a_7226_1636# 0
C11845 sg13cmos5l_dlygate4sd2_1_0.A a_902_3142# 0.47891f
C11846 a_8772_8440# a_9291_8447# 0.38871f
C11847 a_9189_8447# a_9060_8861# 0.01562f
C11848 a_12404_7972# pl_sw[6] 0
C11849 sg13cmos5l_dfrbp_1_23.CLK a_12698_7288# 0.00483f
C11850 sg13cmos5l_inv_1_14.A sg13cmos5l_dlhr_1_0.GATE 0.06969f
C11851 a_18999_6178# a_19593_6162# 0.09085f
C11852 a_18793_6216# a_19130_6172# 0.64635f
C11853 sg13cmos5l_inv_1_0.A sg13cmos5l_dfrbp_1_0.CLK 0
C11854 sg13cmos5l_inv_1_2.A ph_sw[6] 0.00335f
C11855 a_17961_8793# cks 0.01946f
C11856 a_7247_8797# sg13cmos5l_buf_1_30.A 0
C11857 sg13cmos5l_buf_1_31.X a_8841_5769# 0.00416f
C11858 sg13cmos5l_dfrbp_1_6.RESET_B sg13cmos5l_buf_1_61.X 0
C11859 sg13cmos5l_buf_1_41.A a_3241_2746# 0.04587f
C11860 sg13cmos5l_buf_1_3.A a_20008_8436# 0.00333f
C11861 sg13cmos5l_nor2b_1_0.Y a_12520_4782# 0.00295f
C11862 a_1463_8741# pl_sw[1] 0
C11863 sg13cmos5l_inv_1_27.Y a_14640_6924# 0
C11864 sg13cmos5l_dfrbp_1_8.RESET_B sg13cmos5l_dfrbp_1_10.Q 0
C11865 a_8588_3864# VPWR 0.25225f
C11866 sg13cmos5l_buf_1_34.X sg13cmos5l_dfrbp_1_10.Q_N 0
C11867 sg13cmos5l_buf_1_45.X sg13cmos5l_buf_1_79.X 0
C11868 sg13cmos5l_dfrbp_1_6.RESET_B a_14602_8404# 0
C11869 sg13cmos5l_buf_8_1.A a_17493_3947# 0.02251f
C11870 a_15887_8797# a_16089_8559# 0.00675f
C11871 sg13cmos5l_a22oi_1_0.B1 sg13cmos5l_nand2_1_0.A 0.6341f
C11872 sg13cmos5l_or2_1_0.A a_20392_3900# 0
C11873 a_2831_7630# sg13cmos5l_dfrbp_1_16.Q 0
C11874 a_10308_7992# sg13cmos5l_buf_1_29.A 0
C11875 sg13cmos5l_dlhr_1_6.D sg13cmos5l_buf_1_56.A 0.00854f
C11876 a_5414_6162# a_4847_4727# 0
C11877 sg13cmos5l_dfrbp_1_16.Q a_5796_3904# 0
C11878 a_12106_9409# a_11846_9186# 0.87117f
C11879 a_1948_7964# a_1997_6126# 0.00258f
C11880 sg13cmos5l_buf_1_58.A a_2583_7710# 0
C11881 a_10308_7992# a_10665_7281# 0
C11882 a_10725_7653# a_10484_6924# 0.01991f
C11883 sg13cmos5l_dlhr_1_5.Q a_9558_6144# 0.00274f
C11884 sg13cmos5l_buf_1_24.A a_6213_3911# 0.04871f
C11885 a_14628_8440# pl_sw[8] 0
C11886 a_8204_9150# pl_sw[5] 0
C11887 sg13cmos5l_buf_1_5.X a_13556_2388# 0
C11888 sg13cmos5l_dlhr_1_5.Q_N sg13cmos5l_buf_1_31.X 0.01562f
C11889 sg13cmos5l_buf_1_34.X a_3407_8797# 0.00336f
C11890 sg13cmos5l_buf_1_3.A a_20488_4782# 0
C11891 sg13cmos5l_nand2_1_1.A cks 0.00311f
C11892 sg13cmos5l_a221oi_1_0.B1 a_12358_5388# 0
C11893 a_18376_9224# sg13cmos5l_buf_1_87.A 0.28827f
C11894 sg13cmos5l_a221oi_1_0.C1 sg13cmos5l_dfrbp_1_0.RESET_B 0.01999f
C11895 ph_sw[1] pl_sw[2] 0.56174f
C11896 sg13cmos5l_dfrbp_1_8.RESET_B a_6276_8861# 0.00632f
C11897 sg13cmos5l_dfrbp_1_6.RESET_B a_708_5416# 0.51287f
C11898 sg13cmos5l_dfrbp_1_6.RESET_B a_3962_7288# 0.0034f
C11899 sg13cmos5l_dfrbp_1_20.Q a_9558_6144# 0
C11900 sg13cmos5l_o21ai_1_0.A2 sg13cmos5l_buf_1_8.A 0
C11901 a_5820_5773# a_6602_5692# 0.4806f
C11902 sg13cmos5l_a221oi_1_0.B1 a_9524_4972# 0
C11903 sg13cmos5l_inv_1_28.Y sg13cmos5l_dlhr_1_11.GATE 0.50622f
C11904 sg13cmos5l_inv_1_6.A a_20288_7010# 0.00276f
C11905 sg13cmos5l_or2_1_0.A a_16268_3102# 0.00422f
C11906 sg13cmos5l_inv_1_8.A a_2364_4686# 0
C11907 sg13cmos5l_dfrbp_1_23.Q a_14583_5770# 0
C11908 a_14426_7288# a_14377_5770# 0
C11909 sg13cmos5l_buf_1_73.X pl_sw[5] 0.18996f
C11910 a_16293_4629# cks 0.03214f
C11911 sg13cmos5l_buf_1_18.X nl_sw[10] 0
C11912 sg13cmos5l_buf_1_32.A a_1864_1664# 0.00362f
C11913 a_15782_7362# a_15876_7362# 0.00718f
C11914 sg13cmos5l_nor2_1_0.A a_13034_5412# 0
C11915 sg13cmos5l_buf_1_4.A a_16260_6480# 0.01394f
C11916 sg13cmos5l_buf_1_93.X a_16160_9318# 0
C11917 a_18860_9150# a_19227_9190# 0.0604f
C11918 sg13cmos5l_dfrbp_1_8.RESET_B a_6372_4968# 0.49553f
C11919 sg13cmos5l_dfrbp_1_6.D a_8784_6484# 0
C11920 sg13cmos5l_a221oi_1_0.A2 a_10789_4654# 0.00191f
C11921 sg13cmos5l_dfrbp_1_8.RESET_B ckc 0
C11922 sg13cmos5l_dfrbp_1_6.D a_9865_7282# 0.00669f
C11923 sg13cmos5l_or2_1_0.A a_13652_3900# 0.00163f
C11924 a_16395_4772# sg13cmos5l_a22oi_1_1.A1 0
C11925 a_3856_3358# a_3505_3215# 0.01017f
C11926 a_3599_3215# sg13cmos5l_dfrbp_1_10.Q_N 0.05615f
C11927 sg13cmos5l_dfrbp_1_6.RESET_B a_6903_3154# 0.00325f
C11928 sg13cmos5l_buf_1_79.X a_12651_9308# 0.0013f
C11929 sg13cmos5l_buf_1_10.A a_12075_1748# 0
C11930 sg13cmos5l_buf_1_5.A sg13cmos5l_dfrbp_1_20.Q 0
C11931 a_2757_3117# sg13cmos5l_buf_1_41.X 0.00938f
C11932 a_19216_3358# nl_sw[9] 0
C11933 sg13cmos5l_buf_1_65.X sg13cmos5l_buf_1_78.X 0.00713f
C11934 sg13cmos5l_inv_1_27.Y a_13810_9186# 0
C11935 a_16264_9224# sg13cmos5l_buf_1_101.X 0.29712f
C11936 sg13cmos5l_inv_1_2.A a_8998_8861# 0
C11937 sg13cmos5l_dlhr_1_9.D a_9558_6144# 0
C11938 a_15784_9224# a_14628_8440# 0
C11939 sg13cmos5l_dfrbp_1_0.RESET_B sg13cmos5l_o21ai_1_0.B1 2.53772f
C11940 a_6602_5692# VPWR 0.00674f
C11941 a_2638_6162# a_1967_5773# 0
C11942 sg13cmos5l_inv_1_3.A a_13701_3117# 0.0033f
C11943 a_13768_8436# sg13cmos5l_buf_1_98.A 0.3298f
C11944 sg13cmos5l_buf_1_79.X a_8084_8436# 0
C11945 sg13cmos5l_or2_1_0.A a_11270_4338# 0.01335f
C11946 sg13cmos5l_buf_1_57.X a_15177_5769# 0.00457f
C11947 a_11748_2813# VPWR 0.01166f
C11948 sg13cmos5l_dfrbp_1_18.Q a_10428_9222# 0
C11949 sg13cmos5l_a22oi_1_1.B2 a_15062_4292# 0.00121f
C11950 sg13cmos5l_dfrbp_1_6.RESET_B a_10420_5760# 0
C11951 a_15012_7992# a_15300_7687# 0.4806f
C11952 a_7247_8797# pl_sw[5] 0
C11953 sg13cmos5l_buf_1_4.A a_16462_4023# 0.00292f
C11954 sg13cmos5l_nand2_1_1.B a_13803_3260# 0.0124f
C11955 sg13cmos5l_dlhr_1_15.Q_N cks 0.00132f
C11956 a_424_3270# ckc 0.00265f
C11957 sg13cmos5l_inv_1_27.Y sg13cmos5l_dlhr_1_11.Q 0.01989f
C11958 a_2374_8861# a_2436_8861# 0
C11959 a_2565_8447# a_2667_8447# 0.6663f
C11960 a_2148_8440# a_3664_8678# 0.00159f
C11961 sg13cmos5l_dlhr_1_5.D VPWR 0.34857f
C11962 sg13cmos5l_buf_1_26.A sg13cmos5l_dlhr_1_0.Q_N 0.00408f
C11963 sg13cmos5l_buf_1_78.X a_5962_8404# 0.02027f
C11964 sg13cmos5l_buf_1_90.X a_11567_7751# 0
C11965 sg13cmos5l_dfrbp_1_11.Q a_8588_3864# 0.01347f
C11966 sg13cmos5l_dfrbp_1_22.D a_18096_7996# 0
C11967 sg13cmos5l_buf_1_10.A sg13cmos5l_and3_1_0.C 0
C11968 a_17519_6239# sg13cmos5l_buf_8_1.A 0
C11969 sg13cmos5l_inv_1_17.A a_3669_6320# 0.02145f
C11970 a_20392_3900# sg13cmos5l_buf_1_3.X 0.00133f
C11971 a_9865_7282# a_10024_5498# 0
C11972 sg13cmos5l_buf_1_8.X VPWR 0.41085f
C11973 sg13cmos5l_dfrbp_1_6.RESET_B a_2436_4325# 0.02136f
C11974 sg13cmos5l_buf_1_18.A sg13cmos5l_a22oi_1_1.A1 0.02387f
C11975 sg13cmos5l_buf_1_60.X sg13cmos5l_buf_1_73.X 0.00181f
C11976 a_15110_5412# VPWR 0.00418f
C11977 sg13cmos5l_dfrbp_1_21.Q a_19028_5412# 0
C11978 a_9076_5800# sg13cmos5l_buf_1_45.A 0
C11979 sg13cmos5l_buf_1_40.A a_2228_4972# 0
C11980 a_12800_5498# a_11973_3911# 0
C11981 sg13cmos5l_dlhr_1_5.GATE a_5508_6162# 0
C11982 sg13cmos5l_dfrbp_1_22.D a_17712_8436# 0
C11983 a_7249_3130# VPWR 0
C11984 a_708_6928# a_1997_6126# 0
C11985 a_10230_4632# a_10331_3900# 0
C11986 sg13cmos5l_inv_1_0.Y a_11556_3904# 0
C11987 a_9291_8447# a_10031_8797# 0.3087f
C11988 sg13cmos5l_dfrbp_1_8.RESET_B a_16264_9224# 0
C11989 sg13cmos5l_nor2b_1_0.Y a_12520_3176# 0
C11990 sg13cmos5l_dfrbp_1_6.RESET_B a_11473_7751# 0.00202f
C11991 sg13cmos5l_dlhr_1_9.D sg13cmos5l_buf_1_24.A 0.03022f
C11992 sg13cmos5l_a22oi_1_0.B1 sg13cmos5l_dfrbp_1_1.Q 0.00533f
C11993 sg13cmos5l_dfrbp_1_23.CLK sg13cmos5l_dlhr_1_11.Q_N 0.00569f
C11994 sg13cmos5l_nor2b_1_0.Y a_10331_1924# 0.0944f
C11995 a_6479_2749# a_6572_1590# 0
C11996 a_18568_7010# sg13cmos5l_dlhr_1_10.Q 0
C11997 a_19593_6162# a_19526_6600# 0
C11998 a_19412_6484# a_19344_6484# 0
C11999 a_18999_6178# a_19345_6154# 0.00722f
C12000 sg13cmos5l_buf_1_79.X sg13cmos5l_dfrbp_1_20.Q_N 0.39671f
C12001 sg13cmos5l_buf_1_30.A sg13cmos5l_dfrbp_1_2.D 0
C12002 a_9524_4972# sg13cmos5l_inv_1_11.Y 0
C12003 sg13cmos5l_nand2_1_2.B a_1158_3142# 0.00336f
C12004 sg13cmos5l_buf_1_57.X sg13cmos5l_a221oi_1_1.C1 0
C12005 a_12719_2749# a_12921_2511# 0.00675f
C12006 sg13cmos5l_dfrbp_1_6.RESET_B a_16144_8678# 0
C12007 rdy sg13cmos5l_buf_1_62.X 0
C12008 sg13cmos5l_dfrbp_1_21.Q sg13cmos5l_a22oi_1_1.B2 0.36396f
C12009 sg13cmos5l_dfrbp_1_16.Q a_7055_4261# 0
C12010 sg13cmos5l_buf_1_111.A cko 0
C12011 sg13cmos5l_dfrbp_1_8.RESET_B a_13391_9263# 0.20048f
C12012 a_10308_7992# a_11560_7010# 0
C12013 a_10596_7687# a_10202_7288# 0
C12014 sg13cmos5l_buf_1_58.A a_1878_6337# 0.03353f
C12015 a_2621_7636# a_2879_6432# 0.00242f
C12016 sg13cmos5l_buf_8_0.X a_19593_6162# 0.00285f
C12017 a_1463_8511# sg13cmos5l_inv_1_19.A 0.03809f
C12018 a_15887_8797# pl_sw[8] 0
C12019 sg13cmos5l_dfrbp_1_23.CLK a_13047_7690# 0.00192f
C12020 a_13297_9263# a_13178_7684# 0
C12021 sg13cmos5l_dfrbp_1_6.D a_17545_7728# 0.00102f
C12022 sg13cmos5l_nand2_1_1.A a_18219_3260# 0.02652f
C12023 a_12719_2749# sg13cmos5l_dfrbp_1_1.Q_N 0
C12024 sg13cmos5l_buf_1_30.A a_6660_4663# 0.00228f
C12025 a_6198_3120# a_6188_1590# 0
C12026 sg13cmos5l_inv_1_0.A a_9940_4636# 0
C12027 a_7336_9224# sg13cmos5l_inv_1_2.A 0
C12028 sg13cmos5l_buf_1_41.A a_2697_3529# 0
C12029 sg13cmos5l_nand2_1_2.B a_1006_4167# 0.00153f
C12030 sg13cmos5l_dlygate4sd2_1_0.A sg13cmos5l_nor2_1_2.A 0.84309f
C12031 sg13cmos5l_dfrbp_1_6.RESET_B a_4380_7326# 0
C12032 sg13cmos5l_buf_1_10.A sg13cmos5l_nor2_1_0.A 0.50122f
C12033 sg13cmos5l_dfrbp_1_8.RESET_B sg13cmos5l_dlhr_1_2.D 0
C12034 sg13cmos5l_inv_1_17.A sg13cmos5l_buf_1_40.X 0.00398f
C12035 a_5799_5499# a_6741_5459# 0.00999f
C12036 a_4076_7624# a_4349_7636# 0.15652f
C12037 a_3574_7850# sg13cmos5l_dfrbp_1_16.Q_N 0.02223f
C12038 sg13cmos5l_inv_1_8.A a_3876_4663# 0.00654f
C12039 sg13cmos5l_inv_1_27.Y a_14641_7326# 0.00194f
C12040 sg13cmos5l_dlhr_1_15.D sg13cmos5l_o21ai_1_0.A1 0.00109f
C12041 sg13cmos5l_buf_1_0.A sg13cmos5l_a22oi_1_1.A1 0.02799f
C12042 sg13cmos5l_buf_8_1.A sg13cmos5l_a22oi_1_1.Y 0.24944f
C12043 sg13cmos5l_dfrbp_1_0.CLK a_17700_3456# 0.0896f
C12044 a_15592_6200# VPWR 0.25098f
C12045 sg13cmos5l_inv_1_20.Y a_2505_8483# 0
C12046 sg13cmos5l_nand2_1_2.B a_1815_4666# 0
C12047 sg13cmos5l_buf_1_10.A a_12841_7728# 0
C12048 a_15782_7362# a_16356_7349# 0.36169f
C12049 a_12804_6175# sg13cmos5l_dfrbp_1_21.Q 0.00132f
C12050 a_12933_6141# a_13324_4696# 0
C12051 sg13cmos5l_buf_1_18.A nh_sw[8] 0
C12052 sg13cmos5l_buf_1_6.A a_12719_2749# 0.01323f
C12053 a_11979_2399# a_11556_1944# 0
C12054 sg13cmos5l_dfrbp_1_8.RESET_B a_7888_4870# 0.18237f
C12055 sg13cmos5l_buf_1_31.X sg13cmos5l_dlhr_1_1.D 0.00337f
C12056 a_2824_2388# nh_sw[1] 0.28845f
C12057 sg13cmos5l_or2_1_1.B sg13cmos5l_a22oi_1_1.B2 0.1642f
C12058 a_12716_8400# ph_sw[6] 0
C12059 sg13cmos5l_buf_1_2.A sg13cmos5l_nor2_1_1.A 0.13021f
C12060 sg13cmos5l_dfrbp_1_8.RESET_B a_2757_3117# 0.00379f
C12061 sg13cmos5l_dfrbp_1_6.RESET_B a_5628_3174# 0.00115f
C12062 sg13cmos5l_buf_1_19.A a_18793_6216# 0.02894f
C12063 sg13cmos5l_dlhr_1_12.D sg13cmos5l_dfrbp_1_6.D 0
C12064 sg13cmos5l_dfrbp_1_6.RESET_B a_5220_2392# 0.54753f
C12065 sg13cmos5l_a22oi_1_2.B2 sg13cmos5l_a221oi_1_0.B1 0
C12066 a_18409_5770# sg13cmos5l_buf_8_0.A 0
C12067 sg13cmos5l_inv_1_2.A a_10450_8874# 0
C12068 a_5674_6385# a_5414_6162# 0.87117f
C12069 sg13cmos5l_dlhr_1_9.D a_3588_4968# 0.00424f
C12070 sg13cmos5l_inv_1_1.A a_16144_8678# 0.04049f
C12071 a_15784_9224# a_15887_8797# 0
C12072 a_8041_5770# VPWR 0.51219f
C12073 sg13cmos5l_buf_1_79.X a_8746_8404# 0
C12074 a_1280_6294# sg13cmos5l_inv_1_19.A 0.00227f
C12075 sg13cmos5l_or2_1_0.A a_11844_4325# 0
C12076 sg13cmos5l_dfrbp_1_6.RESET_B a_9111_4666# 0.03472f
C12077 sg13cmos5l_buf_1_18.A a_18117_3117# 0.00992f
C12078 a_1873_5773# a_2386_5850# 0
C12079 a_2804_5412# sg13cmos5l_dlhr_1_1.D 0.25445f
C12080 a_11817_2435# VPWR 0
C12081 a_19412_6484# a_19227_4654# 0
C12082 a_16271_7751# a_16177_7751# 0.32273f
C12083 sg13cmos5l_inv_1_7.A a_12075_3911# 0.00193f
C12084 sg13cmos5l_dfrbp_1_6.D a_5820_5773# 0
C12085 sg13cmos5l_nand2_1_1.B sg13cmos5l_buf_1_5.X 0.49136f
C12086 a_2667_8447# a_3313_8797# 0.00667f
C12087 a_2148_8440# sg13cmos5l_dfrbp_1_15.D 0.00257f
C12088 a_12106_9409# ph_sw[6] 0.00114f
C12089 sg13cmos5l_inv_1_2.A a_16356_7349# 0
C12090 sg13cmos5l_buf_1_90.X sg13cmos5l_dlhr_1_11.D 0
C12091 a_13484_8400# sg13cmos5l_inv_1_7.A 0
C12092 sg13cmos5l_buf_1_78.X a_6507_8447# 0.02291f
C12093 a_1862_4338# sg13cmos5l_buf_1_37.A 0
C12094 sg13cmos5l_dfrbp_1_21.Q_N sg13cmos5l_buf_8_1.A 0.0021f
C12095 sg13cmos5l_buf_1_29.A sg13cmos5l_inv_1_0.A 0
C12096 a_14436_8874# VPWR 0
C12097 sg13cmos5l_buf_1_104.X sg13cmos5l_buf_1_86.A 0.06331f
C12098 sg13cmos5l_dfrbp_1_6.RESET_B a_2505_3947# 0
C12099 sg13cmos5l_dfrbp_1_8.RESET_B sg13cmos5l_dlygate4sd2_1_0.A 0
C12100 sg13cmos5l_dfrbp_1_6.RESET_B a_12873_6553# 0
C12101 sg13cmos5l_dlhr_1_16.Q VPWR 0.37434f
C12102 sg13cmos5l_buf_1_110.A sg13cmos5l_dlhr_1_19.Q_N 0.2198f
C12103 sg13cmos5l_inv_1_17.A a_3308_5376# 0
C12104 a_10094_2780# VPWR 0
C12105 sg13cmos5l_o21ai_1_0.A1 sg13cmos5l_o21ai_1_0.A2 0.29004f
C12106 sg13cmos5l_buf_1_25.A sg13cmos5l_dfrbp_1_1.Q 0.0028f
C12107 sg13cmos5l_buf_1_60.A sg13cmos5l_buf_1_34.X 0.14457f
C12108 a_7441_1618# nh_sw[3] 0
C12109 sg13cmos5l_buf_1_18.A sg13cmos5l_or2_1_0.A 0.06331f
C12110 a_3625_7282# VPWR 0.41448f
C12111 a_19227_9190# a_19240_7712# 0
C12112 sg13cmos5l_dlhr_1_5.GATE a_6865_6239# 0.00306f
C12113 sg13cmos5l_dlhr_1_2.Q a_7508_1948# 0
C12114 sg13cmos5l_dfrbp_1_6.RESET_B a_1862_4338# 0.05407f
C12115 sg13cmos5l_dfrbp_1_6.RESET_B a_17224_3270# 0.00449f
C12116 sg13cmos5l_a221oi_1_0.A2 sg13cmos5l_or2_1_1.B 0
C12117 sg13cmos5l_dfrbp_1_6.D VPWR 3.73771f
C12118 a_10031_8797# sg13cmos5l_dfrbp_1_27.Q_N 0.04107f
C12119 a_9937_8797# a_10450_8874# 0
C12120 a_6479_2749# a_6889_1680# 0.00405f
C12121 a_7316_2388# a_7095_1642# 0.0071f
C12122 sg13cmos5l_dlhr_1_0.D a_6188_1590# 0
C12123 sg13cmos5l_buf_1_7.A nh_sw[7] 0
C12124 sg13cmos5l_dfrbp_1_2.D a_11270_4338# 0.29043f
C12125 a_17961_8793# pl_sw[9] 0.01171f
C12126 a_18959_3215# sg13cmos5l_dfrbp_1_0.Q 0.00159f
C12127 sg13cmos5l_nand2_1_0.B sg13cmos5l_dfrbp_1_0.RESET_B 0.0068f
C12128 sg13cmos5l_nor2_1_1.A a_12921_2511# 0
C12129 a_14254_2444# a_14476_2388# 0
C12130 sg13cmos5l_dlhr_1_5.GATE a_7812_7687# 0
C12131 sg13cmos5l_dfrbp_1_6.RESET_B sg13cmos5l_dfrbp_1_22.D 0.12615f
C12132 sg13cmos5l_inv_1_8.A a_4076_7624# 0
C12133 sg13cmos5l_inv_1_29.A a_14166_7656# 0
C12134 sg13cmos5l_buf_1_96.A a_11268_5760# 0
C12135 sg13cmos5l_dlygate4sd2_1_0.A a_424_3270# 0
C12136 sg13cmos5l_buf_1_87.A a_17916_8838# 0
C12137 sg13cmos5l_buf_1_58.A a_2727_6380# 0
C12138 sg13cmos5l_buf_1_0.A a_18117_3117# 0.00543f
C12139 sg13cmos5l_dlhr_1_11.D a_11190_7354# 0
C12140 sg13cmos5l_inv_1_17.A sg13cmos5l_buf_1_39.A 0.03408f
C12141 sg13cmos5l_inv_1_17.A a_4559_7630# 0
C12142 a_9705_4650# a_9660_4686# 0
C12143 a_9524_4972# a_9457_4642# 0.0018f
C12144 sg13cmos5l_buf_1_77.A a_8660_5412# 0
C12145 a_10417_7326# cks 0
C12146 sg13cmos5l_buf_1_44.X sg13cmos5l_buf_1_44.A 0.13366f
C12147 sg13cmos5l_inv_1_0.A sg13cmos5l_buf_1_2.A 0
C12148 a_12420_9199# ph_sw[5] 0
C12149 a_14800_3358# a_14962_3138# 0.0019f
C12150 a_4934_2826# a_5324_1590# 0
C12151 a_8439_6178# a_8378_5776# 0.00694f
C12152 a_8570_6172# a_8247_5770# 0
C12153 sg13cmos5l_buf_1_41.A a_2566_3151# 0
C12154 sg13cmos5l_inv_1_20.Y sg13cmos5l_dfrbp_1_8.RESET_B 0.04207f
C12155 sg13cmos5l_dfrbp_1_8.RESET_B a_7449_8559# 0.00474f
C12156 a_8457_7281# a_8660_5412# 0
C12157 a_2732_1590# nl_sw[2] 0.0079f
C12158 sg13cmos5l_dfrbp_1_11.Q a_8041_5770# 0.04115f
C12159 sg13cmos5l_nor2b_1_0.Y sg13cmos5l_and3_1_0.C 0.04233f
C12160 sg13cmos5l_a22oi_1_2.B2 sg13cmos5l_inv_1_11.Y 0.3363f
C12161 sg13cmos5l_dfrbp_1_0.D a_18219_3260# 0.05954f
C12162 sg13cmos5l_buf_1_18.A a_19904_7806# 0.01054f
C12163 a_11460_2392# sg13cmos5l_buf_1_8.A 0.00505f
C12164 sg13cmos5l_dfrbp_1_0.RESET_B nl_sw[6] 0.27391f
C12165 sg13cmos5l_dlhr_1_0.D nl_sw[5] 0.05753f
C12166 a_16724_8436# a_17367_8794# 0
C12167 a_10022_7674# a_10028_6126# 0
C12168 sg13cmos5l_inv_1_2.A sg13cmos5l_buf_1_101.X 0
C12169 sg13cmos5l_nand2_1_2.B a_1472_4782# 0.04214f
C12170 a_2667_8447# sg13cmos5l_buf_1_41.A 0
C12171 a_10024_5498# VPWR 0.13979f
C12172 sg13cmos5l_buf_1_10.A a_11986_7674# 0
C12173 a_16485_6935# a_17327_7285# 0.0032f
C12174 a_16294_7349# a_16356_7349# 0
C12175 a_15782_7362# a_16425_6971# 0.00806f
C12176 sg13cmos5l_dfrbp_1_8.RESET_B sg13cmos5l_dfrbp_1_12.Q_N 0.00239f
C12177 sg13cmos5l_a22oi_1_1.A1 sg13cmos5l_buf_1_5.X 0
C12178 sg13cmos5l_dfrbp_1_6.RESET_B a_682_5380# 0.32083f
C12179 sg13cmos5l_buf_1_6.A sg13cmos5l_nor2_1_1.A 0.25961f
C12180 a_12719_2749# a_12815_1703# 0.02584f
C12181 a_12976_2630# a_13072_1846# 0
C12182 a_18746_5776# a_18363_4270# 0.00267f
C12183 sg13cmos5l_or2_1_0.A sg13cmos5l_buf_1_0.A 0.07248f
C12184 sg13cmos5l_dfrbp_1_6.D a_12698_7288# 0.00675f
C12185 sg13cmos5l_dfrbp_1_8.RESET_B a_15782_7362# 0.10447f
C12186 sg13cmos5l_inv_1_14.A a_6865_6239# 0.01669f
C12187 a_17926_3151# VPWR 0
C12188 a_10282_7897# a_10665_8065# 0.00337f
C12189 sg13cmos5l_buf_1_57.X a_10827_7796# 0
C12190 sg13cmos5l_or2_1_0.A a_13803_3260# 0.00348f
C12191 a_8783_7751# sg13cmos5l_buf_1_31.X 0.0059f
C12192 sg13cmos5l_dfrbp_1_6.RESET_B sg13cmos5l_dfrbp_1_10.Q 0.16311f
C12193 a_2374_4325# VPWR 0
C12194 sg13cmos5l_dfrbp_1_6.RESET_B a_6736_2630# 0.18078f
C12195 sg13cmos5l_buf_1_45.A sg13cmos5l_a22oi_1_1.B1 0
C12196 sg13cmos5l_inv_1_2.A a_13100_8400# 0.00661f
C12197 a_2824_2388# a_3447_2746# 0
C12198 a_5700_6480# a_6219_6284# 0.38902f
C12199 a_5414_6162# a_6057_6553# 0.00806f
C12200 sg13cmos5l_buf_1_65.X sg13cmos5l_buf_1_63.A 0
C12201 a_12549_9165# pl_sw[6] 0.00173f
C12202 sg13cmos5l_inv_1_1.A sg13cmos5l_dfrbp_1_22.D 0.03093f
C12203 sg13cmos5l_nand2_1_1.B a_15909_2399# 0
C12204 sg13cmos5l_dfrbp_1_6.RESET_B sg13cmos5l_and3_1_0.X 0
C12205 a_15414_7354# a_15782_7362# 0
C12206 sg13cmos5l_inv_1_18.A sg13cmos5l_dlhr_1_0.Q 0
C12207 sg13cmos5l_buf_1_79.X a_10288_8678# 0.00549f
C12208 a_3575_6553# sg13cmos5l_inv_1_19.A 0.0563f
C12209 sg13cmos5l_dfrbp_1_6.RESET_B a_18097_7666# 0
C12210 sg13cmos5l_dfrbp_1_8.RESET_B a_2374_8861# 0
C12211 sg13cmos5l_dfrbp_1_6.RESET_B sg13cmos5l_inv_1_0.Y 0
C12212 sg13cmos5l_dfrbp_1_6.D a_8233_6216# 0.01001f
C12213 a_10613_2758# a_10696_1758# 0
C12214 a_4425_7281# a_4736_5498# 0
C12215 a_3016_9318# sg13cmos5l_buf_1_61.X 0.00268f
C12216 sg13cmos5l_dfrbp_1_16.Q a_6741_5459# 0.01383f
C12217 sg13cmos5l_dlhr_1_0.GATE nl_sw[4] 0
C12218 a_14900_2352# nh_sw[6] 0
C12219 sg13cmos5l_buf_1_18.A sg13cmos5l_buf_1_3.X 0
C12220 sg13cmos5l_buf_1_24.A a_6647_5459# 0.05182f
C12221 sg13cmos5l_dfrbp_1_6.D sg13cmos5l_dfrbp_1_11.Q 0
C12222 a_934_5837# sg13cmos5l_inv_1_9.Y 0
C12223 a_9291_8447# pl_sw[5] 0
C12224 sg13cmos5l_dfrbp_1_8.D sg13cmos5l_buf_1_4.X 0
C12225 sg13cmos5l_or2_1_0.A sg13cmos5l_buf_1_30.X 0
C12226 a_424_3270# a_424_1664# 0
C12227 sg13cmos5l_dfrbp_1_6.RESET_B a_5673_3138# 0.53721f
C12228 sg13cmos5l_buf_1_29.A a_10420_5412# 0
C12229 sg13cmos5l_buf_1_10.A sg13cmos5l_o21ai_1_0.Y 0.0369f
C12230 sg13cmos5l_dlhr_1_0.GATE a_5770_3868# 0.03083f
C12231 a_4518_7996# cks 0
C12232 sg13cmos5l_inv_1_8.A a_5700_6480# 0.03635f
C12233 a_4244_8436# sg13cmos5l_dfrbp_1_15.D 0.13912f
C12234 sg13cmos5l_buf_1_73.A sg13cmos5l_buf_1_30.A 0.11788f
C12235 a_10665_7281# a_10420_5412# 0
C12236 sg13cmos5l_dlhr_1_11.D sg13cmos5l_dfrbp_1_21.Q 0
C12237 sg13cmos5l_buf_1_56.A a_9456_4972# 0
C12238 sg13cmos5l_buf_1_29.A a_9242_4660# 0.00958f
C12239 sg13cmos5l_dlhr_1_6.Q_N a_9705_4650# 0
C12240 a_12216_5728# sg13cmos5l_inv_1_0.A 0
C12241 sg13cmos5l_nor2_1_0.A sg13cmos5l_nor2b_1_0.Y 0.90486f
C12242 sg13cmos5l_or2_1_1.B a_10726_5760# 0.00224f
C12243 sg13cmos5l_inv_1_8.A sg13cmos5l_dlhr_1_1.D 0.05427f
C12244 sg13cmos5l_inv_1_2.A sg13cmos5l_dfrbp_1_8.RESET_B 0.47239f
C12245 a_15147_8447# VPWR 0.20823f
C12246 sg13cmos5l_dfrbp_1_0.RESET_B a_11174_2826# 0.11716f
C12247 sg13cmos5l_inv_1_7.A a_11973_3911# 0.00284f
C12248 sg13cmos5l_buf_1_9.A a_10888_1664# 0.00892f
C12249 a_2732_9150# ph_sw[0] 0
C12250 sg13cmos5l_dfrbp_1_6.RESET_B a_6372_4968# 0.00111f
C12251 a_7238_7674# a_7881_8065# 0.00806f
C12252 a_7524_7992# a_8043_7796# 0.38902f
C12253 sg13cmos5l_nand2_1_0.A sg13cmos5l_buf_1_7.A 0.02408f
C12254 a_18345_7674# cks 0.00239f
C12255 sg13cmos5l_nand2_1_1.B a_10696_1758# 0.01197f
C12256 sg13cmos5l_nand2_1_1.B a_11002_3142# 0
C12257 a_11752_6294# sg13cmos5l_or2_1_1.B 0
C12258 sg13cmos5l_inv_1_2.A a_15414_7354# 0
C12259 a_4950_7354# VPWR 0.25701f
C12260 sg13cmos5l_dfrbp_1_17.D a_2565_8447# 0
C12261 sg13cmos5l_buf_1_31.X a_6213_3911# 0
C12262 sg13cmos5l_dfrbp_1_8.RESET_B sg13cmos5l_buf_1_68.X 0.00115f
C12263 sg13cmos5l_dlhr_1_11.GATE a_9620_7972# 0
C12264 a_1227_6935# a_2169_7047# 0
C12265 sg13cmos5l_dfrbp_1_22.D a_17751_7690# 0.2382f
C12266 a_8204_2352# a_8214_1608# 0
C12267 sg13cmos5l_dlhr_1_0.D a_7095_1642# 0.03995f
C12268 sg13cmos5l_dfrbp_1_2.D a_11844_4325# 0
C12269 sg13cmos5l_dfrbp_1_6.D a_1967_7285# 0
C12270 sg13cmos5l_inv_1_14.A a_6315_3911# 0.01335f
C12271 sg13cmos5l_buf_1_110.A sg13cmos5l_a22oi_1_1.B2 0
C12272 sg13cmos5l_inv_1_1.A sg13cmos5l_and3_1_0.X 0
C12273 a_1580_2352# sg13cmos5l_inv_1_19.A 0.0072f
C12274 sg13cmos5l_nor2_1_1.A a_16751_2749# 0.02163f
C12275 sg13cmos5l_dfrbp_1_20.Q_N a_9673_9240# 0.15955f
C12276 sg13cmos5l_buf_1_105.A ph_sw[8] 0
C12277 sg13cmos5l_inv_1_29.A a_13596_7710# 0
C12278 sg13cmos5l_buf_1_57.X sg13cmos5l_dfrbp_1_23.Q_N 0.01076f
C12279 a_12616_5498# a_12520_4782# 0.00182f
C12280 sg13cmos5l_inv_1_28.Y sg13cmos5l_dfrbp_1_20.Q 0
C12281 sg13cmos5l_dlhr_1_11.D a_12567_7282# 0.00188f
C12282 sg13cmos5l_buf_1_0.A sg13cmos5l_buf_1_3.X 0
C12283 a_15492_2392# cks 0
C12284 sg13cmos5l_nor2_1_0.A a_13138_2826# 0
C12285 sg13cmos5l_dfrbp_1_23.CLK a_14536_7806# 0.01753f
C12286 sg13cmos5l_inv_1_0.Y a_11182_4676# 0
C12287 sg13cmos5l_buf_1_58.A a_1227_5423# 0
C12288 a_5425_3130# VPWR 0
C12289 sg13cmos5l_nor2_1_1.A a_17412_1944# 0
C12290 sg13cmos5l_nand2_1_2.B a_902_3142# 0
C12291 sg13cmos5l_dfrbp_1_18.Q a_9033_6162# 0
C12292 sg13cmos5l_dlhr_1_6.D a_9076_5800# 0
C12293 a_5194_2356# VPWR 0.1f
C12294 sg13cmos5l_dfrbp_1_8.RESET_B a_9937_8797# 0.00381f
C12295 a_14342_8874# a_14295_7282# 0
C12296 sg13cmos5l_dfrbp_1_6.D a_16260_6480# 0.00574f
C12297 VPWR nh_sw[9] 0.22654f
C12298 sg13cmos5l_buf_1_63.A pl_sw[1] 0.002f
C12299 sg13cmos5l_a22oi_1_1.A1 a_15909_2399# 0
C12300 sg13cmos5l_buf_1_45.X a_7378_6162# 0
C12301 a_11873_5760# VPWR 0
C12302 a_16572_4261# cks 0.02938f
C12303 a_19028_5412# d_out[2] 0
C12304 a_11979_2399# sg13cmos5l_buf_1_8.A 0.00986f
C12305 sg13cmos5l_dfrbp_1_22.D a_17498_8800# 0.01396f
C12306 sg13cmos5l_a22oi_1_0.Y sg13cmos5l_nand2_1_0.A 0.41217f
C12307 sg13cmos5l_buf_1_90.X a_11846_9186# 0.05582f
C12308 sg13cmos5l_dfrbp_1_18.Q sg13cmos5l_buf_1_57.X 0.52308f
C12309 a_16587_6935# a_17233_7285# 0.00667f
C12310 a_19240_7712# a_19130_6172# 0
C12311 sg13cmos5l_buf_1_73.A pl_sw[5] 0.00311f
C12312 a_5702_8874# VPWR 0.92951f
C12313 sg13cmos5l_dlhr_1_5.Q sg13cmos5l_buf_1_31.X 0.01258f
C12314 a_4873_3192# a_4840_1664# 0
C12315 sg13cmos5l_dlhr_1_8.Q_N a_1125_6935# 0
C12316 sg13cmos5l_nand2_1_1.A a_16940_3102# 0.00837f
C12317 sg13cmos5l_dlhr_1_15.D sg13cmos5l_a22oi_1_1.B1 0.03408f
C12318 sg13cmos5l_buf_1_31.X sg13cmos5l_inv_1_19.A 0.12468f
C12319 sg13cmos5l_dfrbp_1_6.D sg13cmos5l_dlhr_1_11.Q_N 0.00281f
C12320 a_18860_9150# sg13cmos5l_buf_1_107.X 0.00643f
C12321 sg13cmos5l_buf_1_101.X a_17792_9318# 0.00208f
C12322 a_10282_7897# a_10596_7687# 0.00659f
C12323 pl_sw[2] sg13cmos5l_buf_1_61.X 0.19855f
C12324 sg13cmos5l_or2_1_0.A sg13cmos5l_buf_1_5.X 0.10851f
C12325 a_2621_7636# sg13cmos5l_dfrbp_1_16.Q_N 0.00718f
C12326 a_16293_4629# a_16940_3102# 0
C12327 a_15876_4968# sg13cmos5l_buf_1_4.X 0
C12328 a_16748_9150# pl_sw[8] 0.00512f
C12329 sg13cmos5l_dfrbp_1_20.Q sg13cmos5l_buf_1_31.X 0.00758f
C12330 sg13cmos5l_buf_1_104.X a_20288_7010# 0
C12331 a_17751_7690# a_18097_7666# 0.00722f
C12332 sg13cmos5l_dfrbp_1_6.RESET_B a_6898_2826# 0
C12333 a_3826_4338# VPWR 0
C12334 sg13cmos5l_buf_1_18.A a_20392_2388# 0
C12335 sg13cmos5l_buf_1_5.A sg13cmos5l_nor2_1_1.A 0.06242f
C12336 a_13035_6284# VPWR 0.20788f
C12337 sg13cmos5l_inv_1_2.A a_15850_4873# 0
C12338 sg13cmos5l_dfrbp_1_0.CLK a_14449_3215# 0
C12339 a_5700_6480# a_5988_6175# 0.4806f
C12340 sg13cmos5l_dlhr_1_9.D a_4753_4727# 0
C12341 a_424_9318# a_424_8436# 0
C12342 sg13cmos5l_buf_1_60.X a_3664_8678# 0.00202f
C12343 sg13cmos5l_dfrbp_1_6.RESET_B a_13391_9263# 0
C12344 sg13cmos5l_buf_1_5.A a_11824_7894# 0
C12345 sg13cmos5l_inv_1_27.Y pl_sw[6] 0
C12346 sg13cmos5l_buf_1_40.X a_1864_1664# 0.03744f
C12347 sg13cmos5l_buf_1_32.A sg13cmos5l_buf_1_35.A 0.01573f
C12348 a_12324_6162# sg13cmos5l_dfrbp_1_21.Q 0
C12349 a_18860_9150# sg13cmos5l_buf_1_101.X 0.32697f
C12350 sg13cmos5l_dfrbp_1_8.RESET_B a_3826_8874# 0
C12351 sg13cmos5l_buf_1_79.X a_11464_8436# 0.00314f
C12352 sg13cmos5l_dfrbp_1_6.D a_13047_7690# 0
C12353 sg13cmos5l_dfrbp_1_16.Q sg13cmos5l_a221oi_1_0.A2 0.02335f
C12354 a_422_5850# sg13cmos5l_nor2_1_2.A 0
C12355 a_2804_5412# sg13cmos5l_inv_1_19.A 0.01435f
C12356 a_8488_9224# a_7941_7653# 0
C12357 sg13cmos5l_buf_1_77.A a_7238_7674# 0
C12358 a_1121_4166# VPWR 0.24864f
C12359 a_14962_3138# VPWR 0
C12360 a_9879_9202# a_8772_8440# 0
C12361 sg13cmos5l_or2_1_1.B a_10318_5412# 0
C12362 sg13cmos5l_dfrbp_1_6.RESET_B sg13cmos5l_dlhr_1_2.D 0.53239f
C12363 sg13cmos5l_buf_1_19.A nl_sw[9] 0
C12364 sg13cmos5l_dlhr_1_0.GATE a_7312_4142# 0
C12365 a_2757_3117# sg13cmos5l_buf_1_37.A 0.00136f
C12366 a_7524_7992# a_8276_6924# 0
C12367 sg13cmos5l_dfrbp_1_6.RESET_B a_4566_2818# 0.01855f
C12368 sg13cmos5l_buf_1_95.X a_13593_9501# 0.00114f
C12369 sg13cmos5l_buf_1_7.A sg13cmos5l_dfrbp_1_1.Q 0.2586f
C12370 sg13cmos5l_dfrbp_1_23.Q a_12742_6175# 0
C12371 a_14089_7282# sg13cmos5l_dfrbp_1_23.Q_N 0
C12372 sg13cmos5l_buf_1_110.A a_14628_8440# 0.03262f
C12373 VPWR ph_sw[3] 0.2069f
C12374 sg13cmos5l_dfrbp_1_25.Q_N VPWR 0.17778f
C12375 sg13cmos5l_dlhr_1_9.D sg13cmos5l_buf_1_31.X 0.0252f
C12376 a_11656_3176# sg13cmos5l_o21ai_1_0.A2 0.00607f
C12377 a_13768_8436# sg13cmos5l_dlhr_1_11.Q 0.00406f
C12378 sg13cmos5l_inv_1_3.A sg13cmos5l_buf_1_57.X 0.02209f
C12379 sg13cmos5l_buf_1_44.X a_4425_7281# 0.00416f
C12380 a_8043_7796# a_8783_7751# 0.3087f
C12381 a_7941_7653# a_9040_7894# 0
C12382 sg13cmos5l_dfrbp_1_6.RESET_B a_7888_4870# 0
C12383 sg13cmos5l_dfrbp_1_1.D a_10888_1664# 0.04742f
C12384 a_1125_6935# sg13cmos5l_inv_1_19.A 0.02539f
C12385 a_15909_2399# nh_sw[8] 0
C12386 sg13cmos5l_a22oi_1_1.B2 sg13cmos5l_a22oi_1_1.Y 0.21142f
C12387 sg13cmos5l_nand2_1_0.A a_13556_2388# 0.00655f
C12388 sg13cmos5l_inv_1_1.A a_16264_9224# 0.33093f
C12389 sg13cmos5l_o21ai_1_0.A1 a_11460_2392# 0
C12390 a_10331_3900# sg13cmos5l_buf_1_28.X 0.00101f
C12391 a_12324_6162# sg13cmos5l_or2_1_1.B 0
C12392 sg13cmos5l_dfrbp_1_6.RESET_B a_2757_3117# 0.05468f
C12393 sg13cmos5l_buf_1_31.X sg13cmos5l_buf_1_33.A 0
C12394 a_13641_7674# a_13681_6239# 0
C12395 sg13cmos5l_inv_1_11.Y a_10220_3102# 0
C12396 sg13cmos5l_dlhr_1_1.GATE sg13cmos5l_or2_1_0.A 0.00327f
C12397 sg13cmos5l_buf_1_31.X a_7892_3900# 0
C12398 a_11464_8436# sg13cmos5l_buf_1_96.A 0.32683f
C12399 a_12716_8400# a_13100_8400# 0.00492f
C12400 sg13cmos5l_a22oi_1_1.B1 sg13cmos5l_o21ai_1_0.A2 0
C12401 sg13cmos5l_dlhr_1_0.D a_9164_1590# 0.00154f
C12402 a_12980_6924# a_12516_6480# 0
C12403 sg13cmos5l_dlhr_1_9.D a_2804_5412# 0.13566f
C12404 sg13cmos5l_inv_1_14.A a_8588_3864# 0
C12405 sg13cmos5l_inv_1_5.A a_20392_3176# 0.04885f
C12406 sg13cmos5l_buf_1_9.A VPWR 0.38806f
C12407 a_11844_1639# nh_sw[5] 0
C12408 a_8841_5769# sg13cmos5l_a221oi_1_1.C1 0
C12409 a_3308_9150# a_3016_9318# 0.03269f
C12410 sg13cmos5l_dfrbp_1_6.RESET_B a_9268_6148# 0.00521f
C12411 sg13cmos5l_dlhr_1_5.GATE a_6602_5692# 0.00229f
C12412 sg13cmos5l_buf_1_44.X a_5028_2826# 0
C12413 sg13cmos5l_dlhr_1_15.D a_17041_4727# 0
C12414 a_16011_2399# cks 0
C12415 a_18486_8866# a_18856_8436# 0.00308f
C12416 a_12980_6924# cks 0
C12417 sg13cmos5l_dlhr_1_9.Q a_3831_7282# 0.03055f
C12418 sg13cmos5l_dlhr_1_5.Q sg13cmos5l_a221oi_1_0.C1 0.00944f
C12419 sg13cmos5l_dfrbp_1_6.D sg13cmos5l_buf_1_25.X 0
C12420 sg13cmos5l_dlhr_1_5.GATE sg13cmos5l_dlhr_1_5.D 0.78851f
C12421 sg13cmos5l_nor2b_1_0.Y sg13cmos5l_o21ai_1_0.Y 0.00221f
C12422 sg13cmos5l_buf_1_24.A nh_sw[3] 0
C12423 sg13cmos5l_a22oi_1_0.Y sg13cmos5l_dfrbp_1_1.Q 0
C12424 a_5739_2399# VPWR 0.21452f
C12425 sg13cmos5l_dfrbp_1_8.RESET_B a_12716_8400# 0.0074f
C12426 pl_sw[7] ph_sw[7] 0.53137f
C12427 ph_sw[6] pl_sw[8] 0.01768f
C12428 sg13cmos5l_dfrbp_1_6.D a_18356_6460# 0.03453f
C12429 sg13cmos5l_buf_1_5.A sg13cmos5l_inv_1_0.A 0.00167f
C12430 sg13cmos5l_buf_1_24.A a_7034_3148# 0.00403f
C12431 a_5704_1664# nl_sw[3] 0.0016f
C12432 sg13cmos5l_inv_1_8.Y a_1158_3142# 0
C12433 a_12800_5498# VPWR 0.06666f
C12434 sg13cmos5l_dfrbp_1_6.RESET_B sg13cmos5l_dlygate4sd2_1_0.A 0.00211f
C12435 sg13cmos5l_a22oi_1_1.A1 a_17008_2630# 0
C12436 sg13cmos5l_dfrbp_1_20.Q sg13cmos5l_a221oi_1_0.C1 0.21168f
C12437 sg13cmos5l_dfrbp_1_4.Q_N sg13cmos5l_buf_1_8.A 0.00361f
C12438 a_16703_3871# cks 0.01758f
C12439 sg13cmos5l_buf_1_103.A a_17108_7972# 0
C12440 a_20392_7712# VPWR 0.2479f
C12441 a_10587_4692# VPWR 0.27123f
C12442 sg13cmos5l_inv_1_8.A a_6213_3911# 0.00209f
C12443 sg13cmos5l_buf_1_57.X a_12516_6480# 0.02296f
C12444 sg13cmos5l_buf_1_90.X a_13648_9406# 0.00128f
C12445 a_4349_7636# sg13cmos5l_dlhr_1_9.D 0.00188f
C12446 sg13cmos5l_buf_1_87.A a_17367_8794# 0
C12447 a_10308_7992# ph_sw[5] 0
C12448 sg13cmos5l_buf_1_18.A a_19412_6484# 0.03146f
C12449 a_18164_6924# sg13cmos5l_dfrbp_1_8.D 0.13102f
C12450 sg13cmos5l_nor2b_1_0.Y a_11054_4292# 0
C12451 sg13cmos5l_or2_1_0.A a_15909_2399# 0
C12452 sg13cmos5l_dfrbp_1_10.Q_N a_3496_1758# 0
C12453 a_5210_3148# VPWR 0.37093f
C12454 sg13cmos5l_nor2_1_1.A a_15784_1664# 0.00409f
C12455 sg13cmos5l_a22oi_1_1.A1 a_17354_4180# 0.00702f
C12456 a_14152_8522# a_13641_7674# 0.00999f
C12457 a_14800_3358# a_14745_3453# 0.00464f
C12458 sg13cmos5l_buf_1_5.A a_12490_6385# 0
C12459 a_4041_2745# a_4456_1664# 0.0067f
C12460 sg13cmos5l_buf_1_77.X sg13cmos5l_inv_1_2.A 0.24096f
C12461 sg13cmos5l_inv_1_8.Y a_1006_4167# 0.00252f
C12462 sg13cmos5l_nand2_1_2.B sg13cmos5l_nor2_1_2.A 0.14907f
C12463 sg13cmos5l_buf_1_33.A a_3212_1590# 0.01359f
C12464 sg13cmos5l_dlhr_1_15.D a_13486_5412# 0.00632f
C12465 a_12106_9409# sg13cmos5l_dfrbp_1_8.RESET_B 0.31899f
C12466 sg13cmos5l_inv_1_3.A a_14089_7282# 0.0395f
C12467 sg13cmos5l_dfrbp_1_0.D a_16940_3102# 0
C12468 sg13cmos5l_buf_1_57.X cks 0.00207f
C12469 sg13cmos5l_nand2_1_1.B nh_sw[7] 1.08774f
C12470 sg13cmos5l_or2_1_0.A a_13017_4023# 0
C12471 sg13cmos5l_buf_8_0.A sg13cmos5l_a22oi_1_1.A1 0.00622f
C12472 sg13cmos5l_inv_1_2.A a_17135_4727# 0.00736f
C12473 a_1088_7806# a_708_6928# 0
C12474 sg13cmos5l_inv_1_14.A a_6602_5692# 0.01085f
C12475 sg13cmos5l_buf_1_116.A VPWR 0.31123f
C12476 a_6086_4650# VPWR 0.92739f
C12477 a_6959_6239# a_6865_6239# 0.32273f
C12478 sg13cmos5l_buf_1_60.X sg13cmos5l_dfrbp_1_15.D 0
C12479 sg13cmos5l_dlhr_1_9.D sg13cmos5l_a221oi_1_0.C1 0.54298f
C12480 a_12933_6141# sg13cmos5l_and3_1_0.C 0
C12481 sg13cmos5l_buf_1_79.X sg13cmos5l_buf_1_96.A 0.00117f
C12482 sg13cmos5l_dlhr_1_1.GATE a_1672_3176# 0.00232f
C12483 sg13cmos5l_buf_1_111.A a_15887_8797# 0
C12484 sg13cmos5l_buf_1_29.A sg13cmos5l_dlhr_1_0.D 0.00367f
C12485 a_15784_9224# ph_sw[6] 0.00225f
C12486 sg13cmos5l_dfrbp_1_8.RESET_B a_14889_7281# 0.00171f
C12487 a_17508_3138# VPWR 0
C12488 a_10010_9196# a_9291_8447# 0
C12489 a_9879_9202# a_10031_8797# 0
C12490 a_5132_9150# ph_sw[3] 0
C12491 sg13cmos5l_buf_1_32.A nh_sw[1] 0
C12492 sg13cmos5l_inv_1_20.Y sg13cmos5l_dfrbp_1_6.RESET_B 0.0269f
C12493 a_7812_7687# a_6959_6239# 0
C12494 sg13cmos5l_dfrbp_1_6.RESET_B a_18793_6216# 0.00281f
C12495 sg13cmos5l_inv_1_27.Y a_10484_6924# 0
C12496 a_1948_7964# sg13cmos5l_dlhr_1_8.Q_N 0.00294f
C12497 a_2596_7996# a_2621_7636# 0.65127f
C12498 a_2348_7624# a_2831_7630# 0.00161f
C12499 sg13cmos5l_dlhr_1_15.D sg13cmos5l_buf_1_4.A 0.02891f
C12500 a_8043_7796# sg13cmos5l_dlhr_1_5.Q 0
C12501 a_5510_4338# a_5796_3904# 0.50066f
C12502 sg13cmos5l_dfrbp_1_1.Q a_13556_2388# 0.01269f
C12503 a_1873_7285# cks 0
C12504 sg13cmos5l_inv_1_8.A sg13cmos5l_inv_1_19.A 0.11889f
C12505 sg13cmos5l_buf_1_110.A a_15887_8797# 0.02584f
C12506 a_12075_3911# a_12721_4261# 0.00667f
C12507 sg13cmos5l_dfrbp_1_0.RESET_B a_12625_2749# 0
C12508 sg13cmos5l_buf_1_9.A a_11973_1605# 0
C12509 a_14889_7281# a_15414_7354# 0.13715f
C12510 a_14708_6924# a_14844_7326# 0.00404f
C12511 sg13cmos5l_dfrbp_1_23.Q sg13cmos5l_inv_1_0.A 0
C12512 sg13cmos5l_dlhr_1_1.GATE sg13cmos5l_dlygate4sd2_1_0.X 0.03512f
C12513 sg13cmos5l_dfrbp_1_8.RESET_B a_1463_8741# 0.00345f
C12514 sg13cmos5l_dfrbp_1_6.RESET_B sg13cmos5l_dfrbp_1_12.Q_N 0.04218f
C12515 a_8783_7751# a_9620_7972# 0.1333f
C12516 a_9189_8447# a_9865_7282# 0
C12517 sg13cmos5l_buf_1_19.A a_19240_7712# 0.07176f
C12518 a_17008_2630# nh_sw[8] 0.01188f
C12519 sg13cmos5l_dfrbp_1_6.RESET_B a_15782_7362# 0
C12520 a_17961_8793# a_17327_7285# 0.00218f
C12521 a_3308_9150# pl_sw[2] 0.00325f
C12522 a_18345_7674# pl_sw[9] 0
C12523 sg13cmos5l_o21ai_1_0.A1 a_11979_2399# 0
C12524 sg13cmos5l_buf_1_34.X a_4076_5376# 0.00232f
C12525 sg13cmos5l_nand2_1_1.B a_15357_1816# 0.34055f
C12526 sg13cmos5l_dlhr_1_1.GATE a_1946_4660# 0.00719f
C12527 a_1125_5423# a_1873_5773# 0.01058f
C12528 sg13cmos5l_inv_1_14.A a_7249_3130# 0
C12529 sg13cmos5l_dfrbp_1_6.RESET_B a_3801_3453# 0.00343f
C12530 sg13cmos5l_buf_1_90.X ph_sw[6] 0
C12531 sg13cmos5l_buf_1_31.X a_8296_3986# 0
C12532 a_9558_6144# a_9242_4660# 0
C12533 sg13cmos5l_buf_1_56.A a_9111_4666# 0
C12534 a_9033_6162# a_9524_4972# 0
C12535 a_17126_1626# nh_sw[8] 0.0068f
C12536 a_16779_6284# cks 0.00275f
C12537 sg13cmos5l_dfrbp_1_23.Q a_12490_6385# 0
C12538 a_13686_7354# a_13775_6239# 0
C12539 sg13cmos5l_dlhr_1_11.Q_N a_13035_6284# 0
C12540 sg13cmos5l_dlhr_1_0.D a_7441_1618# 0.00108f
C12541 sg13cmos5l_dfrbp_1_8.RESET_B ph_sw[2] 0
C12542 sg13cmos5l_buf_1_107.X a_19240_7712# 0
C12543 sg13cmos5l_buf_1_87.A a_18870_7656# 0.05387f
C12544 a_20492_8400# ph_sw[10] 0.02285f
C12545 sg13cmos5l_inv_1_5.A a_20200_3270# 0.02222f
C12546 a_5988_8440# ph_sw[4] 0
C12547 sg13cmos5l_dfrbp_1_8.RESET_B sg13cmos5l_nand2_1_2.B 0
C12548 sg13cmos5l_dlhr_1_5.GATE a_8041_5770# 0
C12549 a_12933_6141# sg13cmos5l_nor2_1_0.A 0.0168f
C12550 sg13cmos5l_dfrbp_1_1.D VPWR 0.23506f
C12551 sg13cmos5l_nand2_1_0.A a_10613_2758# 0
C12552 sg13cmos5l_buf_1_57.X a_9524_4972# 0
C12553 a_3588_4968# a_3664_4142# 0
C12554 a_3302_4650# a_3407_4261# 0
C12555 sg13cmos5l_inv_1_8.A sg13cmos5l_dlhr_1_9.D 0.76696f
C12556 a_1463_8741# a_1662_8374# 0.04716f
C12557 sg13cmos5l_dfrbp_1_23.CLK sg13cmos5l_dlhr_1_15.D 0.00145f
C12558 sg13cmos5l_buf_1_3.A a_18870_7656# 0
C12559 a_19227_9190# sg13cmos5l_dlhr_1_15.Q 0
C12560 sg13cmos5l_dlhr_1_9.Q a_4425_7281# 0.00205f
C12561 a_13047_7690# a_13035_6284# 0
C12562 a_1948_7964# sg13cmos5l_inv_1_19.A 0.00147f
C12563 sg13cmos5l_inv_1_28.Y a_10308_7992# 0.00969f
C12564 a_10998_9168# a_10725_7653# 0.0019f
C12565 a_6385_2749# VPWR 0
C12566 sg13cmos5l_a22oi_1_1.A1 nh_sw[7] 0
C12567 sg13cmos5l_buf_1_34.X a_5324_1590# 0.33666f
C12568 a_13698_5412# sg13cmos5l_a22oi_1_1.B1 0
C12569 sg13cmos5l_buf_1_34.X a_4518_7996# 0
C12570 a_5951_5383# a_6372_4968# 0
C12571 sg13cmos5l_dfrbp_1_11.Q a_6086_4650# 0
C12572 sg13cmos5l_inv_1_2.A sg13cmos5l_dfrbp_1_6.RESET_B 0.11593f
C12573 sg13cmos5l_buf_1_24.A a_6560_3270# 0.00284f
C12574 sg13cmos5l_buf_1_60.X a_4460_9150# 0.28943f
C12575 sg13cmos5l_buf_1_44.X a_5600_8522# 0.00142f
C12576 a_11940_9186# VPWR 0
C12577 a_2732_9150# sg13cmos5l_buf_1_64.A 0
C12578 a_5600_1758# nl_sw[3] 0
C12579 sg13cmos5l_buf_1_44.X a_4873_3192# 0.00259f
C12580 a_14583_5770# a_14714_5776# 0.65127f
C12581 sg13cmos5l_dlhr_1_12.D ph_sw[8] 0
C12582 sg13cmos5l_buf_1_57.X a_14612_6460# 0.04745f
C12583 sg13cmos5l_dfrbp_1_16.Q a_10318_5412# 0.01821f
C12584 a_8247_5770# a_8660_5412# 0.15652f
C12585 a_6741_5459# a_6843_5459# 0.00337f
C12586 sg13cmos5l_a221oi_1_0.B2 a_11488_4676# 0
C12587 a_12800_5498# a_12814_4692# 0
C12588 sg13cmos5l_inv_1_1.A a_15782_7362# 0.03488f
C12589 sg13cmos5l_buf_8_0.A a_18117_3117# 0
C12590 a_13178_7684# cks 0.00498f
C12591 sg13cmos5l_buf_1_18.A a_19548_6198# 0
C12592 sg13cmos5l_dfrbp_1_16.Q a_8905_4704# 0
C12593 sg13cmos5l_inv_1_0.Y a_11980_4948# 0
C12594 sg13cmos5l_nand2_1_0.A sg13cmos5l_nand2_1_1.B 0.17527f
C12595 sg13cmos5l_inv_1_18.A sg13cmos5l_a221oi_1_0.A2 0.01704f
C12596 sg13cmos5l_or2_1_0.A a_17008_2630# 0
C12597 sg13cmos5l_dlhr_1_4.Q_N VPWR 0.27066f
C12598 sg13cmos5l_a22oi_1_1.A1 sg13cmos5l_inv_1_5.A 0.15106f
C12599 sg13cmos5l_nand2_1_1.A a_20008_3900# 0.31821f
C12600 sg13cmos5l_buf_1_5.A a_13775_6239# 0.01391f
C12601 a_5194_2356# sg13cmos5l_buf_1_25.X 0.00353f
C12602 sg13cmos5l_buf_1_5.X sg13cmos5l_dfrbp_1_7.Q_N 0.00717f
C12603 sg13cmos5l_dfrbp_1_10.Q nh_sw[4] 0.00232f
C12604 sg13cmos5l_inv_1_6.A sg13cmos5l_dlhr_1_16.Q_N 0.20351f
C12605 a_4041_2745# VPWR 0.62893f
C12606 sg13cmos5l_dlhr_1_5.GATE sg13cmos5l_dfrbp_1_6.D 0.79165f
C12607 a_5988_8440# sg13cmos5l_buf_1_24.A 0
C12608 sg13cmos5l_inv_1_2.A a_14543_3215# 0.00766f
C12609 sg13cmos5l_buf_1_45.X a_9033_6162# 0
C12610 a_18376_9224# sg13cmos5l_buf_1_105.A 0
C12611 sg13cmos5l_buf_1_77.A a_8692_7312# 0
C12612 sg13cmos5l_buf_1_94.X a_14986_7897# 0
C12613 sg13cmos5l_or2_1_0.A a_17354_4180# 0
C12614 a_7631_4727# VPWR 0.26103f
C12615 a_6865_6239# sg13cmos5l_dlhr_1_6.D 0
C12616 a_3688_1664# nh_sw[1] 0.00149f
C12617 sg13cmos5l_nor2_1_0.A a_11372_3102# 0.00918f
C12618 sg13cmos5l_dfrbp_1_1.Q a_20392_3176# 0
C12619 sg13cmos5l_buf_1_59.A a_3588_4968# 0
C12620 sg13cmos5l_dlhr_1_0.GATE a_7452_3174# 0
C12621 sg13cmos5l_dfrbp_1_0.RESET_B a_19161_3453# 0.00343f
C12622 sg13cmos5l_dfrbp_1_6.D a_14536_7806# 0
C12623 a_8457_7281# a_8692_7312# 0.00566f
C12624 a_8276_6924# sg13cmos5l_dlhr_1_5.Q 0.00128f
C12625 sg13cmos5l_dfrbp_1_6.D a_5684_4948# 0.01103f
C12626 a_2340_3456# VPWR 0.11367f
C12627 sg13cmos5l_buf_1_77.A a_8689_7751# 0.00915f
C12628 sg13cmos5l_buf_1_7.A a_14458_4270# 0
C12629 sg13cmos5l_or2_1_0.A sg13cmos5l_buf_8_0.A 0.02883f
C12630 sg13cmos5l_dfrbp_1_6.RESET_B a_9937_8797# 0.00153f
C12631 sg13cmos5l_inv_1_3.A sg13cmos5l_dlhr_1_14.Q_N 0.01166f
C12632 sg13cmos5l_dfrbp_1_6.RESET_B a_17938_6162# 0.00152f
C12633 a_7812_7687# sg13cmos5l_dlhr_1_6.D 0
C12634 sg13cmos5l_inv_1_2.A sg13cmos5l_inv_1_1.A 0.04878f
C12635 a_15590_4650# sg13cmos5l_buf_1_2.X 0
C12636 a_15876_4968# a_16268_3102# 0
C12637 a_2831_7630# sg13cmos5l_buf_1_58.A 0
C12638 sg13cmos5l_dlhr_1_8.Q_N a_1664_7806# 0.01282f
C12639 sg13cmos5l_dfrbp_1_20.Q a_8276_6924# 0
C12640 a_8689_7751# a_8457_7281# 0
C12641 a_516_7362# pl_sw[0] 0
C12642 a_5510_4338# a_7055_4261# 0
C12643 a_5770_3868# a_6315_3911# 0.00999f
C12644 a_5796_3904# a_6084_4325# 0.4806f
C12645 sg13cmos5l_buf_1_32.A a_3447_2746# 0
C12646 a_2824_2388# sg13cmos5l_buf_1_41.X 0.33135f
C12647 sg13cmos5l_buf_1_65.X sg13cmos5l_buf_1_63.X 0.08652f
C12648 VPWR ph_sw[8] 0.32184f
C12649 nh_sw[7] nh_sw[8] 0
C12650 a_13652_3900# sg13cmos5l_dfrbp_1_2.Q_N 0.25039f
C12651 sg13cmos5l_inv_1_29.Y sg13cmos5l_dfrbp_1_21.Q 0.01195f
C12652 sg13cmos5l_buf_1_45.X sg13cmos5l_buf_1_28.A 0
C12653 sg13cmos5l_nor2_1_0.A a_12616_5498# 0.00444f
C12654 a_7812_7687# a_7750_7687# 0
C12655 a_9620_7972# sg13cmos5l_dfrbp_1_20.Q 0.13029f
C12656 a_11656_3176# a_11460_2392# 0.00158f
C12657 sg13cmos5l_dfrbp_1_1.D a_11973_1605# 0
C12658 sg13cmos5l_nor2_1_0.A a_10230_4632# 0
C12659 sg13cmos5l_dlhr_1_16.Q_N a_20204_5376# 0.00126f
C12660 sg13cmos5l_buf_1_31.X a_8392_3270# 0.00206f
C12661 a_14745_3453# VPWR 0
C12662 sg13cmos5l_dfrbp_1_9.Q a_4456_1664# 0
C12663 a_2934_4632# VPWR 0.25276f
C12664 sg13cmos5l_inv_1_26.Y a_19209_5769# 0
C12665 sg13cmos5l_dlhr_1_6.D a_13486_5412# 0.01098f
C12666 sg13cmos5l_inv_1_14.A sg13cmos5l_dfrbp_1_6.D 0.02549f
C12667 sg13cmos5l_dfrbp_1_8.RESET_B a_16089_8559# 0.00477f
C12668 a_11973_3911# a_12721_4261# 0.01058f
C12669 sg13cmos5l_dfrbp_1_0.CLK a_12075_3911# 0.01854f
C12670 a_7524_7992# a_7657_7282# 0
C12671 a_7941_7653# a_7863_7282# 0.03359f
C12672 a_1158_3142# sg13cmos5l_buf_1_32.A 0
C12673 a_16548_6175# cks 0.01496f
C12674 sg13cmos5l_dfrbp_1_23.Q a_13775_6239# 0.03172f
C12675 a_14089_7282# a_14612_6460# 0
C12676 a_708_6928# sg13cmos5l_inv_1_19.A 0.01219f
C12677 sg13cmos5l_dfrbp_1_0.Q nl_sw[9] 0.00719f
C12678 sg13cmos5l_buf_1_78.X sg13cmos5l_dfrbp_1_8.RESET_B 0.04194f
C12679 sg13cmos5l_dfrbp_1_0.RESET_B sg13cmos5l_dfrbp_1_4.D 0.12467f
C12680 sg13cmos5l_nor2_1_0.A nh_sw[5] 0.00722f
C12681 sg13cmos5l_dlygate4sd3_1_0.X nl_sw[0] 0
C12682 sg13cmos5l_dlhr_1_11.GATE a_10827_7796# 0.06674f
C12683 a_7504_8678# ph_sw[4] 0
C12684 sg13cmos5l_dfrbp_1_6.D a_4652_6126# 0.00165f
C12685 sg13cmos5l_dfrbp_1_22.D a_17776_6382# 0
C12686 a_11530_3868# a_11556_3904# 0.43042f
C12687 a_17700_3456# a_18760_2388# 0
C12688 a_18117_3117# a_18376_2388# 0.00999f
C12689 a_8660_5412# a_8774_5412# 0.00122f
C12690 sg13cmos5l_buf_1_3.A d_out[0] 0.03374f
C12691 a_1006_4167# sg13cmos5l_buf_1_32.A 0
C12692 sg13cmos5l_dlhr_1_10.Q a_19209_5769# 0
C12693 sg13cmos5l_inv_1_29.Y sg13cmos5l_or2_1_1.B 0.25726f
C12694 a_12132_9504# sg13cmos5l_buf_1_5.A 0
C12695 sg13cmos5l_inv_1_7.A VPWR 2.36265f
C12696 a_4005_4629# sg13cmos5l_dfrbp_1_9.Q_N 0.00102f
C12697 a_8588_2352# a_9260_2352# 0
C12698 a_13460_7996# a_13775_6239# 0
C12699 a_13641_7674# a_14032_6382# 0.00248f
C12700 sg13cmos5l_dfrbp_1_8.D a_16395_4772# 0.02639f
C12701 a_8233_6216# a_7631_4727# 0
C12702 a_1664_7806# sg13cmos5l_inv_1_19.A 0
C12703 sg13cmos5l_buf_1_58.A a_1484_9150# 0
C12704 sg13cmos5l_inv_1_28.Y a_11824_7894# 0.01326f
C12705 a_18117_3117# a_18928_1846# 0
C12706 a_18219_3260# a_18671_1703# 0.00122f
C12707 sg13cmos5l_inv_1_3.A sg13cmos5l_dfrbp_1_0.RESET_B 0
C12708 sg13cmos5l_dfrbp_1_11.Q a_7631_4727# 0.02514f
C12709 a_18363_4270# a_18219_3260# 0.01076f
C12710 sg13cmos5l_nand2_1_1.B sg13cmos5l_dfrbp_1_1.Q 4.70891f
C12711 a_19616_3986# sg13cmos5l_dfrbp_1_0.Q 0
C12712 sg13cmos5l_nand2_1_1.A nl_sw[8] 0.01084f
C12713 sg13cmos5l_buf_1_79.X a_9673_9240# 0.12381f
C12714 a_13486_5412# a_13698_5412# 0.22838f
C12715 a_14714_5776# a_14929_5814# 0.00284f
C12716 a_14583_5770# a_15177_5769# 0.09085f
C12717 a_14377_5770# a_14996_5412# 0.00161f
C12718 sg13cmos5l_buf_1_24.A a_7316_2388# 0.01079f
C12719 sg13cmos5l_buf_1_34.X nh_sw[2] 0
C12720 pl_sw[5] pl_sw[3] 0.00376f
C12721 cks pl_sw[0] 0.00912f
C12722 sg13cmos5l_or2_1_0.A nh_sw[7] 0.00281f
C12723 sg13cmos5l_inv_1_1.A a_16294_7349# 0
C12724 sg13cmos5l_dlhr_1_14.Q_N cks 0.00203f
C12725 a_2732_9150# VPWR 0.25727f
C12726 a_9189_8447# VPWR 0.24947f
C12727 a_9879_9202# pl_sw[5] 0.00584f
C12728 sg13cmos5l_or2_1_0.A a_18376_2388# 0
C12729 a_18999_6178# VPWR 0.18237f
C12730 a_3574_7850# a_3625_7282# 0
C12731 a_3676_7964# a_3831_7282# 0.00556f
C12732 a_8570_6172# a_8785_6154# 0.00284f
C12733 sg13cmos5l_dlhr_1_9.D sg13cmos5l_nand2_1_0.B 0.00262f
C12734 sg13cmos5l_buf_1_107.X pl_sw[8] 0
C12735 sg13cmos5l_dfrbp_1_20.Q_N a_9033_6162# 0
C12736 sg13cmos5l_inv_1_8.Y a_902_3142# 0.03503f
C12737 a_15045_8447# a_15531_7796# 0
C12738 sg13cmos5l_dlhr_1_5.GATE a_4950_7354# 0
C12739 a_5739_2399# sg13cmos5l_buf_1_25.X 0.00462f
C12740 a_8988_6198# sg13cmos5l_dfrbp_1_11.Q 0
C12741 sg13cmos5l_a22oi_1_1.Y a_17414_3138# 0.30533f
C12742 a_16572_4261# a_16940_3102# 0
C12743 a_8972_3864# sg13cmos5l_a22oi_1_1.B1 0
C12744 sg13cmos5l_dfrbp_1_18.Q sg13cmos5l_dlhr_1_5.Q_N 0.00281f
C12745 sg13cmos5l_buf_1_24.A a_6198_3120# 0.00372f
C12746 sg13cmos5l_dlhr_1_15.D a_15110_5412# 0
C12747 sg13cmos5l_inv_1_2.A a_15702_4187# 0.03911f
C12748 sg13cmos5l_a221oi_1_0.B2 VPWR 0.20777f
C12749 sg13cmos5l_or2_1_0.A sg13cmos5l_inv_1_5.A 0
C12750 sg13cmos5l_a22oi_1_0.Y sg13cmos5l_a22oi_1_0.B1 0.17556f
C12751 sg13cmos5l_buf_1_94.X a_15429_7653# 0
C12752 sg13cmos5l_dfrbp_1_11.Q_N VPWR 0.17778f
C12753 sg13cmos5l_buf_1_18.A sg13cmos5l_dfrbp_1_8.D 0
C12754 a_20288_2474# VPWR 0.07134f
C12755 sg13cmos5l_dlhr_1_1.Q a_2565_3911# 0.00336f
C12756 sg13cmos5l_buf_1_101.X pl_sw[8] 0.01163f
C12757 sg13cmos5l_dlhr_1_13.Q_N VPWR 0.33185f
C12758 sg13cmos5l_dfrbp_1_1.Q a_20200_3270# 0
C12759 sg13cmos5l_dlhr_1_15.Q a_19130_6172# 0
C12760 sg13cmos5l_dfrbp_1_16.Q a_6789_4629# 0
C12761 sg13cmos5l_dfrbp_1_23.CLK sg13cmos5l_dlhr_1_6.D 0.00477f
C12762 sg13cmos5l_dfrbp_1_6.D a_16271_7751# 0.00178f
C12763 sg13cmos5l_inv_1_7.A a_12698_7288# 0.0031f
C12764 sg13cmos5l_inv_1_17.A sg13cmos5l_buf_1_44.A 0
C12765 a_4436_3436# VPWR 0.36602f
C12766 sg13cmos5l_buf_1_24.A a_6891_4772# 0
C12767 sg13cmos5l_inv_1_0.A a_11182_4948# 0.02982f
C12768 a_1227_5423# a_1760_3986# 0
C12769 sg13cmos5l_o21ai_1_0.B1 a_12719_2749# 0
C12770 a_3447_2746# a_3688_1664# 0.00603f
C12771 sg13cmos5l_buf_1_111.A a_18272_9318# 0.06036f
C12772 sg13cmos5l_dfrbp_1_6.RESET_B a_422_5850# 0.09738f
C12773 a_1088_7806# a_682_6892# 0
C12774 a_904_7806# a_708_6928# 0.00557f
C12775 sg13cmos5l_inv_1_3.A a_15012_7992# 0
C12776 a_13768_8436# pl_sw[6] 0
C12777 a_3599_3215# nh_sw[2] 0
C12778 sg13cmos5l_inv_1_27.Y a_13161_7281# 0.01897f
C12779 sg13cmos5l_buf_1_18.A sg13cmos5l_buf_1_0.X 0
C12780 a_2565_8447# VPWR 0.24932f
C12781 a_6315_3911# a_7312_4142# 0.07046f
C12782 a_3664_8678# sg13cmos5l_dlhr_1_1.GATE 0
C12783 sg13cmos5l_dlhr_1_5.D a_6959_6239# 0.04734f
C12784 a_7657_7282# a_7796_6460# 0
C12785 sg13cmos5l_buf_1_40.X sg13cmos5l_buf_1_35.A 0.00766f
C12786 sg13cmos5l_buf_1_32.X sg13cmos5l_buf_1_33.A 0
C12787 sg13cmos5l_buf_1_111.A a_19227_9190# 0.00356f
C12788 sg13cmos5l_inv_1_8.A a_6647_5459# 0.00357f
C12789 sg13cmos5l_dlhr_1_0.GATE a_6903_3154# 0.25294f
C12790 a_7863_7282# a_8209_7326# 0.00722f
C12791 a_7657_7282# a_7520_7010# 0.00973f
C12792 sg13cmos5l_dlhr_1_5.GATE a_5702_8874# 0.30239f
C12793 a_4107_4772# sg13cmos5l_dfrbp_1_10.Q 0.00285f
C12794 sg13cmos5l_dfrbp_1_6.RESET_B a_17746_7362# 0
C12795 sg13cmos5l_dfrbp_1_0.RESET_B cks 0.16871f
C12796 a_16293_4629# sg13cmos5l_nand2_1_1.A 0
C12797 sg13cmos5l_buf_1_95.X a_11567_7751# 0.00161f
C12798 a_12651_9308# a_13178_7684# 0.00203f
C12799 sg13cmos5l_dfrbp_1_9.Q VPWR 0.87913f
C12800 sg13cmos5l_inv_1_7.A a_11973_1605# 0
C12801 sg13cmos5l_dfrbp_1_18.Q sg13cmos5l_dlhr_1_11.GATE 0
C12802 a_10292_9508# sg13cmos5l_dfrbp_1_8.RESET_B 0
C12803 sg13cmos5l_a22oi_1_1.B2 a_14900_2352# 0.0018f
C12804 sg13cmos5l_buf_1_65.X sg13cmos5l_inv_1_18.A 0
C12805 a_18746_5776# a_18480_5028# 0
C12806 sg13cmos5l_buf_1_93.X a_17896_9224# 0
C12807 a_15784_9224# sg13cmos5l_buf_1_101.X 0
C12808 a_16011_2399# a_16953_2511# 0
C12809 a_15500_9150# a_15045_8447# 0.00154f
C12810 sg13cmos5l_buf_1_95.X a_14628_8440# 0
C12811 sg13cmos5l_dfrbp_1_8.RESET_B pl_sw[8] 0
C12812 a_13138_2826# nh_sw[6] 0
C12813 a_15876_4968# a_16395_4772# 0.38902f
C12814 a_15590_4650# a_16233_5041# 0.00806f
C12815 sg13cmos5l_buf_1_8.X sg13cmos5l_o21ai_1_0.A2 0.02539f
C12816 sg13cmos5l_a22oi_1_1.B1 a_11979_2399# 0
C12817 a_10220_3102# a_10618_3142# 0
C12818 sg13cmos5l_buf_1_28.X a_10331_1924# 0
C12819 sg13cmos5l_dfrbp_1_8.D sg13cmos5l_buf_1_0.A 0
C12820 a_8486_8874# ph_sw[4] 0
C12821 sg13cmos5l_dlhr_1_11.GATE a_11769_7989# 0
C12822 sg13cmos5l_dfrbp_1_6.D a_5312_6294# 0.07101f
C12823 a_708_5416# a_1873_5773# 0.4858f
C12824 a_2248_9224# sg13cmos5l_buf_1_62.X 0.00554f
C12825 sg13cmos5l_buf_1_31.X a_7034_3148# 0.01365f
C12826 sg13cmos5l_dfrbp_1_6.RESET_B a_14889_7281# 0.54004f
C12827 a_11973_3911# sg13cmos5l_dfrbp_1_0.CLK 0.3519f
C12828 a_19216_3358# a_19244_2352# 0.00625f
C12829 a_18959_3215# a_19628_2352# 0.00829f
C12830 a_17367_8794# a_16587_6935# 0.00274f
C12831 sg13cmos5l_buf_1_65.X a_6568_9224# 0.00772f
C12832 a_15016_9224# sg13cmos5l_buf_1_94.X 0.29729f
C12833 a_13324_4696# a_13652_3900# 0
C12834 sg13cmos5l_inv_1_18.A a_8905_4704# 0.02577f
C12835 a_7498_7897# a_7238_7674# 0.87117f
C12836 sg13cmos5l_or2_1_0.A sg13cmos5l_nand2_1_0.A 0.05941f
C12837 sg13cmos5l_inv_1_7.A a_12814_4692# 0
C12838 sg13cmos5l_dfrbp_1_11.Q sg13cmos5l_dfrbp_1_11.Q_N 0.01011f
C12839 sg13cmos5l_buf_1_0.A sg13cmos5l_buf_1_0.X 0.0542f
C12840 sg13cmos5l_inv_1_5.A sg13cmos5l_buf_1_3.X 0.02399f
C12841 sg13cmos5l_buf_1_31.X sg13cmos5l_inv_1_0.A 0
C12842 sg13cmos5l_inv_1_20.Y a_3016_9318# 0.07228f
C12843 a_14632_9224# a_15016_9224# 0.00492f
C12844 sg13cmos5l_dlhr_1_5.GATE ph_sw[3] 0
C12845 sg13cmos5l_inv_1_17.A a_3831_7282# 0.06131f
C12846 sg13cmos5l_buf_1_24.A sg13cmos5l_dlhr_1_0.D 0.94333f
C12847 a_16940_3102# a_16011_2399# 0.00149f
C12848 sg13cmos5l_inv_1_14.A a_5702_8874# 0
C12849 a_15012_7992# cks 0.00336f
C12850 sg13cmos5l_buf_1_104.A pl_sw[10] 0.41391f
C12851 a_10868_8436# VPWR 0.3556f
C12852 sg13cmos5l_dfrbp_1_16.Q_N a_3962_7288# 0
C12853 sg13cmos5l_dfrbp_1_10.Q a_10433_4248# 0.00857f
C12854 a_19526_6600# VPWR 0.00418f
C12855 sg13cmos5l_dfrbp_1_0.D nl_sw[8] 0
C12856 sg13cmos5l_dlhr_1_5.Q sg13cmos5l_a221oi_1_1.C1 0
C12857 sg13cmos5l_buf_1_3.A a_18760_2388# 0
C12858 sg13cmos5l_buf_1_31.X a_3664_4142# 0
C12859 sg13cmos5l_buf_1_56.A a_9268_6148# 0
C12860 sg13cmos5l_dfrbp_1_8.RESET_B a_15784_9224# 0
C12861 a_15793_8797# a_15429_7653# 0
C12862 sg13cmos5l_buf_1_4.X a_17386_1849# 0
C12863 a_16940_3102# a_16936_1758# 0.00207f
C12864 a_2148_8440# sg13cmos5l_buf_1_62.X 0
C12865 sg13cmos5l_buf_1_97.A sg13cmos5l_inv_1_7.A 0.03391f
C12866 sg13cmos5l_buf_1_90.X a_13100_8400# 0.33099f
C12867 sg13cmos5l_dfrbp_1_6.RESET_B ph_sw[2] 0
C12868 a_9705_4650# sg13cmos5l_dfrbp_1_1.Q 0
C12869 a_16703_3871# a_16940_3102# 0
C12870 sg13cmos5l_buf_1_24.X nl_sw[3] 0.00274f
C12871 sg13cmos5l_inv_1_9.Y a_1158_3142# 0.04243f
C12872 sg13cmos5l_inv_1_2.A a_16462_4338# 0.01035f
C12873 sg13cmos5l_dfrbp_1_6.RESET_B sg13cmos5l_nand2_1_2.B 0.01337f
C12874 sg13cmos5l_dfrbp_1_20.Q sg13cmos5l_a221oi_1_1.C1 0.02889f
C12875 sg13cmos5l_buf_1_3.A a_19508_1924# 0
C12876 sg13cmos5l_dfrbp_1_22.D ph_sw[7] 0
C12877 sg13cmos5l_buf_8_0.X VPWR 1.70567f
C12878 sg13cmos5l_dfrbp_1_1.Q nh_sw[8] 0.02073f
C12879 sg13cmos5l_dlhr_1_20.Q_N sg13cmos5l_a22oi_1_0.Y 0
C12880 a_17792_9318# a_17498_8800# 0.00308f
C12881 a_14822_6924# VPWR 0.00418f
C12882 sg13cmos5l_inv_1_1.A a_14889_7281# 0.00126f
C12883 sg13cmos5l_dfrbp_1_16.Q a_8468_4948# 0
C12884 sg13cmos5l_dlhr_1_9.D a_7474_4338# 0
C12885 sg13cmos5l_dfrbp_1_6.D sg13cmos5l_dlhr_1_15.D 0.03919f
C12886 a_2248_1664# nl_sw[1] 0.12236f
C12887 a_4041_2745# sg13cmos5l_buf_1_25.X 0.00491f
C12888 sg13cmos5l_buf_1_97.A a_9189_8447# 0
C12889 sg13cmos5l_inv_1_8.Y sg13cmos5l_nor2_1_2.A 0.02258f
C12890 sg13cmos5l_inv_1_9.Y a_1006_4167# 0.04781f
C12891 sg13cmos5l_dfrbp_1_10.Q_N nh_sw[2] 0
C12892 sg13cmos5l_buf_1_35.A sg13cmos5l_buf_1_39.A 0
C12893 sg13cmos5l_buf_1_101.X a_17161_8794# 0.00156f
C12894 sg13cmos5l_buf_1_90.X sg13cmos5l_dfrbp_1_8.RESET_B 0.05017f
C12895 sg13cmos5l_inv_1_27.Y a_14426_7288# 0.03761f
C12896 a_3313_8797# VPWR 0
C12897 sg13cmos5l_inv_1_14.A ph_sw[3] 0.00364f
C12898 sg13cmos5l_dfrbp_1_15.D sg13cmos5l_dlhr_1_1.GATE 3.09301f
C12899 a_17882_7684# a_18164_6924# 0.00126f
C12900 sg13cmos5l_buf_1_5.A a_14449_3215# 0.00807f
C12901 sg13cmos5l_dfrbp_1_18.Q a_7524_7992# 0.1151f
C12902 sg13cmos5l_inv_1_7.A a_13047_7690# 0
C12903 sg13cmos5l_buf_1_10.A sg13cmos5l_inv_1_29.A 0.14953f
C12904 sg13cmos5l_buf_1_40.A sg13cmos5l_dlhr_1_1.GATE 0.13131f
C12905 a_2565_8447# a_1967_7285# 0
C12906 sg13cmos5l_dfrbp_1_1.Q a_18117_3117# 0
C12907 sg13cmos5l_dlhr_1_9.D sg13cmos5l_a221oi_1_1.C1 0.01551f
C12908 sg13cmos5l_dfrbp_1_16.Q sg13cmos5l_inv_1_29.Y 0
C12909 sg13cmos5l_dlhr_1_5.D sg13cmos5l_dlhr_1_6.D 0.00256f
C12910 sg13cmos5l_dlhr_1_1.Q a_2409_4650# 0.28724f
C12911 a_11072_5347# sg13cmos5l_nand2_1_0.A 0
C12912 sg13cmos5l_nand2_1_1.A a_13701_3117# 0.0106f
C12913 sg13cmos5l_dfrbp_1_0.RESET_B a_18219_3260# 0.55463f
C12914 sg13cmos5l_a22oi_1_2.B1 a_11844_1639# 0
C12915 a_2859_3260# a_3688_1664# 0
C12916 sg13cmos5l_dfrbp_1_6.RESET_B a_6572_1590# 0
C12917 a_5104_4870# sg13cmos5l_dfrbp_1_10.Q 0
C12918 a_20008_8436# VPWR 0.24861f
C12919 sg13cmos5l_buf_1_110.A ph_sw[6] 0.00162f
C12920 sg13cmos5l_dlhr_1_0.GATE a_5220_2392# 0.10518f
C12921 a_11434_2356# a_11460_2392# 0.43042f
C12922 a_13258_3361# a_12998_3138# 0.87117f
C12923 sg13cmos5l_buf_1_40.X nh_sw[1] 0
C12924 sg13cmos5l_buf_1_95.X sg13cmos5l_dlhr_1_11.D 0.00275f
C12925 sg13cmos5l_inv_1_27.Y a_13641_7674# 0
C12926 a_422_7362# pl_sw[0] 0
C12927 sg13cmos5l_dfrbp_1_0.D sg13cmos5l_nand2_1_1.A 0.03985f
C12928 sg13cmos5l_dlhr_1_11.GATE a_12516_6480# 0
C12929 sg13cmos5l_buf_1_19.A sg13cmos5l_dfrbp_1_21.Q 0.002f
C12930 a_12132_9504# ph_sw[5] 0.00116f
C12931 sg13cmos5l_inv_1_7.A a_14056_1664# 0
C12932 a_7750_7687# sg13cmos5l_dlhr_1_5.D 0
C12933 sg13cmos5l_buf_1_10.A a_11877_2399# 0.0018f
C12934 sg13cmos5l_buf_1_44.A a_5796_3904# 0.01837f
C12935 sg13cmos5l_dfrbp_1_0.CLK a_12998_3138# 0.01471f
C12936 a_1997_6126# a_2409_4650# 0
C12937 sg13cmos5l_dfrbp_1_15.Q_N a_1815_4666# 0
C12938 a_18568_7010# cks 0
C12939 sg13cmos5l_dlhr_1_5.GATE a_6086_4650# 0
C12940 a_20488_4782# VPWR 0.12966f
C12941 sg13cmos5l_a221oi_1_0.C1 sg13cmos5l_inv_1_0.A 0.42964f
C12942 sg13cmos5l_nor2_1_0.A a_11370_5760# 0.01562f
C12943 a_16160_9318# VPWR 0.07364f
C12944 sg13cmos5l_dfrbp_1_8.RESET_B sg13cmos5l_buf_1_63.A 0.01626f
C12945 a_9060_8861# ph_sw[4] 0
C12946 sg13cmos5l_buf_1_19.A sg13cmos5l_dlhr_1_15.Q 0.19038f
C12947 a_4847_4727# a_5492_3460# 0
C12948 sg13cmos5l_a22oi_1_2.B1 a_10331_1924# 0.18697f
C12949 sg13cmos5l_dfrbp_1_6.D a_6959_6239# 0.00618f
C12950 a_3962_7288# a_4176_6924# 0.01249f
C12951 a_19412_6484# sg13cmos5l_buf_8_0.A 0
C12952 sg13cmos5l_dlhr_1_11.GATE cks 0.10092f
C12953 a_18746_5776# a_19142_5412# 0.00949f
C12954 sg13cmos5l_buf_1_31.X a_6560_3270# 0.00108f
C12955 a_902_3142# sg13cmos5l_buf_1_32.A 0
C12956 sg13cmos5l_dlhr_1_12.D a_17233_7285# 0
C12957 sg13cmos5l_or2_1_0.A sg13cmos5l_dfrbp_1_1.Q 0.00477f
C12958 sg13cmos5l_dfrbp_1_8.RESET_B a_11190_7354# 0
C12959 sg13cmos5l_inv_1_20.Y pl_sw[2] 0.00186f
C12960 sg13cmos5l_dfrbp_1_8.D sg13cmos5l_buf_1_5.X 0
C12961 sg13cmos5l_inv_1_5.A a_20392_2388# 0
C12962 sg13cmos5l_dfrbp_1_8.RESET_B a_17161_8794# 0
C12963 a_4076_7624# cks 0
C12964 a_10031_8797# a_10282_7897# 0
C12965 sg13cmos5l_nand2_1_1.B a_14458_4270# 0.00103f
C12966 a_18376_9224# VPWR 0.25277f
C12967 a_5684_4948# a_6086_4650# 0
C12968 sg13cmos5l_a22oi_1_1.B2 a_16102_4663# 0
C12969 sg13cmos5l_inv_1_8.A a_3488_7010# 0
C12970 sg13cmos5l_inv_1_2.A a_15974_6162# 0.0259f
C12971 sg13cmos5l_buf_1_28.X a_9260_2352# 0.00705f
C12972 sg13cmos5l_buf_1_31.X a_9242_4660# 0.04689f
C12973 sg13cmos5l_inv_1_2.A a_10406_9624# 0
C12974 sg13cmos5l_buf_1_111.A a_19130_6172# 0
C12975 sg13cmos5l_buf_1_107.X sg13cmos5l_dlhr_1_15.Q 0
C12976 a_20492_8400# sg13cmos5l_buf_1_86.A 0
C12977 sg13cmos5l_dfrbp_1_7.Q_N nh_sw[7] 0
C12978 sg13cmos5l_inv_1_17.A a_4425_7281# 0
C12979 sg13cmos5l_dfrbp_1_8.RESET_B sg13cmos5l_inv_1_8.Y 0
C12980 a_15702_5842# sg13cmos5l_dlhr_1_19.Q_N 0.12876f
C12981 ph_sw[8] ph_sw[9] 0.19348f
C12982 sg13cmos5l_dfrbp_1_8.RESET_B a_5069_5376# 0.22014f
C12983 sg13cmos5l_a22oi_1_0.B1 a_10613_2758# 0
C12984 sg13cmos5l_buf_1_26.A sg13cmos5l_buf_1_25.A 0.09795f
C12985 a_7095_1642# a_7689_1626# 0.09085f
C12986 a_6889_1680# a_7226_1636# 0.64635f
C12987 a_15884_3102# nl_sw[8] 0.12101f
C12988 a_17108_7972# cks 0
C12989 a_9879_9202# a_10010_9196# 0.65127f
C12990 a_12232_8436# VPWR 0.26929f
C12991 a_9879_9202# pl_sw[6] 0
C12992 a_1463_8511# a_1862_8874# 0.00522f
C12993 sg13cmos5l_inv_1_0.A sg13cmos5l_o21ai_1_0.B1 0
C12994 sg13cmos5l_buf_1_63.A a_1662_8374# 0
C12995 sg13cmos5l_buf_1_101.X sg13cmos5l_dlhr_1_15.Q 0
C12996 sg13cmos5l_buf_1_41.A VPWR 0.76019f
C12997 a_4349_7636# sg13cmos5l_buf_1_59.A 0.00248f
C12998 sg13cmos5l_dfrbp_1_16.Q_N a_4380_7326# 0
C12999 a_20672_6294# VPWR 0.05605f
C13000 sg13cmos5l_buf_1_31.X a_5132_3864# 0
C13001 a_2596_7996# sg13cmos5l_buf_1_61.X 0
C13002 sg13cmos5l_buf_1_4.X a_17220_1626# 0
C13003 sg13cmos5l_inv_1_8.A a_7034_3148# 0.00107f
C13004 sg13cmos5l_buf_1_78.X sg13cmos5l_dfrbp_1_6.RESET_B 0
C13005 sg13cmos5l_buf_1_46.A sg13cmos5l_buf_1_25.A 0
C13006 sg13cmos5l_o21ai_1_0.A1 sg13cmos5l_dfrbp_1_10.Q 0
C13007 sg13cmos5l_inv_1_2.A a_17399_3947# 0
C13008 sg13cmos5l_inv_1_14.A a_6086_4650# 0.04749f
C13009 sg13cmos5l_buf_1_31.X a_2122_3868# 0
C13010 sg13cmos5l_inv_1_8.Y a_424_3270# 0.02099f
C13011 a_2228_4972# a_2161_4642# 0.0018f
C13012 a_2409_4650# a_2364_4686# 0
C13013 sg13cmos5l_buf_1_110.A a_15876_7362# 0
C13014 a_17233_7285# VPWR 0
C13015 sg13cmos5l_buf_1_77.X a_10292_9508# 0
C13016 sg13cmos5l_inv_1_20.Y sg13cmos5l_dlhr_1_9.Q_N 0.01859f
C13017 sg13cmos5l_inv_1_0.Y sg13cmos5l_o21ai_1_0.A1 0.16244f
C13018 sg13cmos5l_buf_1_65.X a_4559_7630# 0
C13019 sg13cmos5l_a22oi_1_0.B1 sg13cmos5l_nand2_1_1.B 0.01066f
C13020 sg13cmos5l_nand2_1_0.A sg13cmos5l_dfrbp_1_2.D 0.03421f
C13021 a_17367_8794# a_17713_8838# 0.00722f
C13022 sg13cmos5l_buf_1_45.X a_8841_5769# 0.00454f
C13023 sg13cmos5l_buf_1_44.X a_4244_8436# 0
C13024 sg13cmos5l_dfrbp_1_23.CLK pl_sw[7] 0
C13025 a_10888_1664# nl_sw[5] 0
C13026 sg13cmos5l_inv_1_6.A sg13cmos5l_dlhr_1_16.Q 0.07016f
C13027 sg13cmos5l_dlhr_1_6.D a_8041_5770# 0.0042f
C13028 sg13cmos5l_dfrbp_1_6.D a_5770_3868# 0.0042f
C13029 a_18356_6460# a_18999_6178# 0
C13030 sg13cmos5l_buf_1_97.A a_10868_8436# 0.04084f
C13031 a_15821_3864# sg13cmos5l_buf_1_2.X 0.00153f
C13032 a_16204_4338# a_16268_3102# 0
C13033 sg13cmos5l_dfrbp_1_8.RESET_B sg13cmos5l_dfrbp_1_21.Q 0.01837f
C13034 sg13cmos5l_dlhr_1_11.Q a_12913_7326# 0
C13035 sg13cmos5l_a22oi_1_2.B2 sg13cmos5l_dfrbp_1_0.RESET_B 0
C13036 a_7820_9150# ph_sw[4] 0
C13037 a_8588_3864# a_8972_3864# 0.00492f
C13038 sg13cmos5l_inv_1_8.A a_3664_4142# 0.00262f
C13039 a_18164_7996# sg13cmos5l_dfrbp_1_8.D 0
C13040 sg13cmos5l_dfrbp_1_23.Q_N a_14583_5770# 0.00188f
C13041 sg13cmos5l_dfrbp_1_18.Q a_8783_7751# 0.03016f
C13042 sg13cmos5l_nor2_1_0.A sg13cmos5l_buf_1_28.X 0.04366f
C13043 a_1967_5773# a_2148_3904# 0
C13044 sg13cmos5l_buf_1_39.A nh_sw[1] 0
C13045 sg13cmos5l_inv_1_6.A sg13cmos5l_dfrbp_1_6.D 0
C13046 a_14708_6924# VPWR 0.10648f
C13047 sg13cmos5l_dfrbp_1_1.Q sg13cmos5l_buf_1_3.X 0.45449f
C13048 sg13cmos5l_dlhr_1_1.Q sg13cmos5l_dlhr_1_1.Q_N 0.00528f
C13049 a_13100_8400# a_12567_7282# 0.00129f
C13050 a_12716_8400# a_12361_7282# 0
C13051 sg13cmos5l_nand2_1_1.A a_15884_3102# 0.00825f
C13052 a_904_7806# a_682_6892# 0
C13053 sg13cmos5l_dlhr_1_1.D cks 0
C13054 a_16485_6935# a_16779_6284# 0
C13055 a_4436_3436# sg13cmos5l_buf_1_25.X 0
C13056 sg13cmos5l_dfrbp_1_6.RESET_B a_6889_1680# 0
C13057 pl_sw[2] sg13cmos5l_buf_1_68.X 0
C13058 a_16264_9224# ph_sw[7] 0
C13059 sg13cmos5l_dlhr_1_0.GATE sg13cmos5l_dfrbp_1_10.Q 0.03139f
C13060 sg13cmos5l_inv_1_1.A a_16089_8559# 0.0016f
C13061 a_13072_4142# a_13017_4023# 0.00464f
C13062 sg13cmos5l_dlhr_1_0.GATE a_6736_2630# 0.04632f
C13063 a_13284_3456# a_13803_3260# 0.38902f
C13064 sg13cmos5l_a22oi_1_1.A1 a_14458_4270# 0
C13065 a_12998_3138# a_13641_3529# 0.00806f
C13066 a_11174_2826# a_12719_2749# 0
C13067 a_11460_2392# a_11748_2813# 0.4806f
C13068 a_11434_2356# a_11979_2399# 0.00999f
C13069 sg13cmos5l_buf_1_76.X ph_sw[4] 0.19111f
C13070 sg13cmos5l_inv_1_27.Y a_14986_7897# 0.00522f
C13071 a_17595_3947# VPWR 0
C13072 a_7524_7992# cks 0.0034f
C13073 a_15876_4968# sg13cmos5l_buf_1_5.X 0
C13074 sg13cmos5l_a221oi_1_0.C1 a_10420_5412# 0.05263f
C13075 sg13cmos5l_dfrbp_1_0.CLK a_14800_3358# 0.01347f
C13076 a_20012_2352# a_20288_2474# 0.00624f
C13077 sg13cmos5l_buf_1_18.X a_18122_2388# 0
C13078 a_2824_2388# sg13cmos5l_buf_1_37.A 0.03382f
C13079 sg13cmos5l_buf_1_32.A sg13cmos5l_buf_1_41.X 0
C13080 sg13cmos5l_a221oi_1_0.C1 a_9242_4660# 0
C13081 sg13cmos5l_buf_1_10.A a_10022_7674# 0
C13082 sg13cmos5l_dlhr_1_5.GATE a_7631_4727# 0
C13083 sg13cmos5l_dlhr_1_0.GATE a_5673_3138# 0.02092f
C13084 a_12075_3911# sg13cmos5l_buf_1_6.A 0
C13085 sg13cmos5l_buf_1_8.X a_11460_2392# 0.03083f
C13086 sg13cmos5l_dfrbp_1_6.D sg13cmos5l_dlhr_1_6.D 0.075f
C13087 sg13cmos5l_dlhr_1_16.Q a_20204_5376# 0.33155f
C13088 sg13cmos5l_dfrbp_1_8.RESET_B a_12567_7282# 0
C13089 sg13cmos5l_buf_1_2.X nl_sw[7] 0.18265f
C13090 sg13cmos5l_dfrbp_1_6.D sg13cmos5l_dfrbp_1_8.Q_N 0
C13091 sg13cmos5l_buf_1_2.X VPWR 0.32967f
C13092 sg13cmos5l_buf_1_31.X a_7316_2388# 0
C13093 sg13cmos5l_dfrbp_1_9.Q sg13cmos5l_buf_1_25.X 0
C13094 a_10473_9186# sg13cmos5l_dlhr_1_21.Q_N 0.00294f
C13095 a_10010_9196# a_10225_9178# 0.00284f
C13096 sg13cmos5l_buf_1_73.A a_6380_7638# 0
C13097 a_1158_3142# sg13cmos5l_buf_1_40.X 0
C13098 sg13cmos5l_dlhr_1_15.D a_13035_6284# 0
C13099 sg13cmos5l_dfrbp_1_6.RESET_B a_2824_2388# 0
C13100 sg13cmos5l_dlhr_1_0.GATE a_6372_4968# 0.0096f
C13101 sg13cmos5l_inv_1_8.A sg13cmos5l_buf_1_59.A 0
C13102 sg13cmos5l_inv_1_2.A a_17776_6382# 0
C13103 sg13cmos5l_dfrbp_1_23.CLK a_13486_5760# 0
C13104 a_15492_2392# nl_sw[8] 0.0125f
C13105 sg13cmos5l_buf_1_2.A a_15590_4650# 0.01817f
C13106 sg13cmos5l_dlhr_1_5.GATE a_8988_6198# 0
C13107 a_9260_2352# sg13cmos5l_a22oi_1_2.B1 0.00189f
C13108 a_17780_8436# a_18164_7996# 0
C13109 a_17961_8793# a_18345_7674# 0.01f
C13110 sg13cmos5l_buf_1_30.X a_7508_1948# 0
C13111 a_12721_4261# VPWR 0
C13112 sg13cmos5l_buf_1_31.X a_6198_3120# 0.00279f
C13113 a_18615_5770# a_18746_5776# 0.65127f
C13114 sg13cmos5l_dfrbp_1_8.RESET_B a_5799_5499# 0.56409f
C13115 sg13cmos5l_buf_1_31.X a_3241_2746# 0
C13116 sg13cmos5l_inv_1_14.A a_7666_8874# 0
C13117 a_1402_3864# a_1580_2352# 0
C13118 sg13cmos5l_nor2_1_2.A sg13cmos5l_buf_1_32.A 0.0028f
C13119 sg13cmos5l_nand2_1_0.B a_10464_2427# 0.00188f
C13120 sg13cmos5l_inv_1_14.A sg13cmos5l_dlhr_1_4.Q_N 0
C13121 sg13cmos5l_inv_1_18.A a_8468_4948# 0
C13122 sg13cmos5l_buf_1_30.A a_9260_2352# 0
C13123 a_10292_9508# sg13cmos5l_dfrbp_1_6.RESET_B 0.11416f
C13124 a_1088_7806# cks 0.00305f
C13125 sg13cmos5l_buf_1_77.A a_10726_5760# 0
C13126 sg13cmos5l_buf_1_10.A sg13cmos5l_a22oi_1_1.B2 0
C13127 a_8588_2352# sg13cmos5l_buf_1_26.X 0.32026f
C13128 sg13cmos5l_dfrbp_1_22.D a_16177_7751# 0.0045f
C13129 a_11364_4338# VPWR 0
C13130 a_1967_7285# sg13cmos5l_buf_1_41.A 0
C13131 sg13cmos5l_dlhr_1_6.D a_10024_5498# 0
C13132 sg13cmos5l_dfrbp_1_21.Q a_15850_4873# 0
C13133 sg13cmos5l_dfrbp_1_6.RESET_B pl_sw[8] 0
C13134 sg13cmos5l_dfrbp_1_23.CLK a_13977_6477# 0
C13135 sg13cmos5l_nor2b_1_0.Y a_11877_2399# 0
C13136 sg13cmos5l_inv_1_20.Y a_2879_6432# 0
C13137 a_17161_8794# a_17712_8436# 0
C13138 a_11846_9186# sg13cmos5l_buf_1_95.X 0.0299f
C13139 sg13cmos5l_dfrbp_1_21.Q a_11556_3904# 0
C13140 sg13cmos5l_nand2_1_1.B sg13cmos5l_buf_1_25.A 0
C13141 sg13cmos5l_dfrbp_1_2.D sg13cmos5l_dfrbp_1_1.Q 0.00438f
C13142 sg13cmos5l_inv_1_3.A a_14583_5770# 0
C13143 sg13cmos5l_inv_1_14.A a_7631_4727# 0
C13144 sg13cmos5l_a22oi_1_1.B2 a_15702_5842# 0
C13145 sg13cmos5l_buf_1_31.X a_1290_3206# 0.04298f
C13146 a_7497_3138# sg13cmos5l_buf_1_25.A 0.00721f
C13147 sg13cmos5l_dfrbp_1_6.RESET_B a_9344_7010# 0.00891f
C13148 a_6188_1590# VPWR 0.25103f
C13149 sg13cmos5l_buf_8_1.A a_17988_3151# 0
C13150 sg13cmos5l_buf_8_2.X sg13cmos5l_buf_1_104.A 0.1238f
C13151 a_14377_5770# sg13cmos5l_nand2_1_1.B 0
C13152 a_17367_8794# sg13cmos5l_buf_1_105.A 0
C13153 sg13cmos5l_dlhr_1_11.GATE a_12651_9308# 0
C13154 sg13cmos5l_inv_1_8.A a_5988_8440# 0.09868f
C13155 sg13cmos5l_inv_1_9.Y a_902_3142# 0.03854f
C13156 sg13cmos5l_buf_1_10.A a_12804_6175# 0.00436f
C13157 sg13cmos5l_dfrbp_1_21.Q_N a_19130_6172# 0
C13158 a_17776_6382# a_17938_6162# 0.0019f
C13159 sg13cmos5l_buf_1_97.A a_12232_8436# 0
C13160 sg13cmos5l_or2_1_1.B a_10783_3876# 0
C13161 sg13cmos5l_dfrbp_1_18.Q sg13cmos5l_dlhr_1_5.Q 0.00284f
C13162 sg13cmos5l_dfrbp_1_1.Q a_20392_2388# 0.32456f
C13163 sg13cmos5l_buf_1_31.X a_1402_3864# 0
C13164 sg13cmos5l_buf_1_111.A sg13cmos5l_buf_1_19.A 0.14427f
C13165 sg13cmos5l_inv_1_26.Y frame 0
C13166 sg13cmos5l_dfrbp_1_0.RESET_B a_16953_2511# 0.0039f
C13167 sg13cmos5l_nand2_1_1.A a_15492_2392# 0
C13168 sg13cmos5l_inv_1_17.A a_4873_3192# 0
C13169 sg13cmos5l_inv_1_8.A a_5132_3864# 0.00211f
C13170 a_6602_5692# a_6998_5837# 0
C13171 sg13cmos5l_dfrbp_1_18.Q sg13cmos5l_dfrbp_1_20.Q 0.8397f
C13172 sg13cmos5l_buf_1_79.X sg13cmos5l_buf_1_57.X 0
C13173 sg13cmos5l_dlhr_1_1.D a_2565_3911# 0
C13174 sg13cmos5l_buf_1_89.A VPWR 0.39487f
C13175 sg13cmos5l_dfrbp_1_15.D a_2386_7362# 0
C13176 sg13cmos5l_buf_1_31.X a_1609_4704# 0
C13177 a_12216_5728# a_11973_3911# 0.003f
C13178 sg13cmos5l_or2_1_1.B a_11556_3904# 0
C13179 a_17327_7285# a_16779_6284# 0
C13180 sg13cmos5l_inv_1_0.A sg13cmos5l_nand2_1_0.B 0.26016f
C13181 sg13cmos5l_dfrbp_1_6.RESET_B a_15784_9224# 0
C13182 VPWR nl_sw[5] 0.31764f
C13183 sg13cmos5l_buf_1_34.X a_3876_4663# 0.00115f
C13184 sg13cmos5l_nand2_1_1.A a_16572_4261# 0
C13185 a_6315_3911# a_6903_3154# 0
C13186 sg13cmos5l_dfrbp_1_0.CLK a_15300_2826# 0
C13187 sg13cmos5l_buf_1_7.A a_13556_2388# 0
C13188 nl_sw[0] comp_p 0.54526f
C13189 sg13cmos5l_dlhr_1_0.GATE a_6898_2826# 0.0017f
C13190 a_13284_3456# sg13cmos5l_buf_1_5.X 0.00141f
C13191 a_11748_2813# a_11979_2399# 0.15089f
C13192 sg13cmos5l_dlhr_1_9.D a_8592_5412# 0
C13193 a_3447_2746# sg13cmos5l_buf_1_39.A 0
C13194 a_3241_2746# a_3212_1590# 0
C13195 sg13cmos5l_inv_1_27.Y a_15429_7653# 0
C13196 sg13cmos5l_buf_1_111.A sg13cmos5l_buf_1_107.X 0.462f
C13197 sg13cmos5l_inv_1_26.Y sg13cmos5l_buf_1_87.A 0.02735f
C13198 sg13cmos5l_dfrbp_1_8.RESET_B a_16234_6385# 0.02051f
C13199 a_5510_4338# a_5637_2399# 0
C13200 sg13cmos5l_inv_1_8.A a_2122_3868# 0.00458f
C13201 sg13cmos5l_buf_1_10.A sg13cmos5l_a221oi_1_0.A2 0
C13202 sg13cmos5l_dlhr_1_15.D a_12800_5498# 0
C13203 sg13cmos5l_inv_1_1.A pl_sw[8] 0.00192f
C13204 sg13cmos5l_dfrbp_1_23.CLK a_14602_8404# 0.01386f
C13205 sg13cmos5l_dlhr_1_21.Q_N a_11360_9318# 0.01282f
C13206 a_18345_7674# sg13cmos5l_dlhr_1_15.Q_N 0.00294f
C13207 a_8783_7751# cks 0.00651f
C13208 sg13cmos5l_buf_1_38.A nl_sw[2] 0.02002f
C13209 sg13cmos5l_buf_1_18.A sg13cmos5l_buf_1_19.X 0.07075f
C13210 a_16293_4629# a_16572_4261# 0.00112f
C13211 sg13cmos5l_dfrbp_1_0.CLK a_13017_1941# 0
C13212 sg13cmos5l_dfrbp_1_1.Q sg13cmos5l_dfrbp_1_7.Q_N 0
C13213 sg13cmos5l_dfrbp_1_0.CLK a_15821_3864# 0
C13214 a_1662_8374# a_1227_6935# 0
C13215 a_18568_7010# pl_sw[9] 0
C13216 sg13cmos5l_buf_1_10.A a_11567_7751# 0.0241f
C13217 a_1967_5773# a_1946_4660# 0
C13218 a_2224_5654# a_2409_4650# 0
C13219 sg13cmos5l_inv_1_26.Y sg13cmos5l_buf_1_3.A 0.30883f
C13220 sg13cmos5l_dlhr_1_0.GATE sg13cmos5l_dlhr_1_2.D 1.28367f
C13221 sg13cmos5l_buf_1_111.A sg13cmos5l_buf_1_101.X 0.02438f
C13222 a_3016_9318# ph_sw[2] 0
C13223 sg13cmos5l_dfrbp_1_0.RESET_B a_16940_3102# 0.01234f
C13224 sg13cmos5l_buf_1_8.X a_11979_2399# 0.00165f
C13225 sg13cmos5l_inv_1_17.A sg13cmos5l_dlygate4sd3_1_0.X 0
C13226 a_4244_6924# sg13cmos5l_inv_1_19.A 0.00127f
C13227 a_8204_9150# a_7941_7653# 0
C13228 sg13cmos5l_buf_1_45.X a_7524_7992# 0.02039f
C13229 sg13cmos5l_dlhr_1_0.GATE a_4566_2818# 0
C13230 a_10464_2427# a_11174_2826# 0
C13231 sg13cmos5l_inv_1_0.A nl_sw[6] 0.002f
C13232 sg13cmos5l_buf_1_31.X sg13cmos5l_dlhr_1_0.D 0
C13233 sg13cmos5l_dlhr_1_15.Q ph_sw[10] 0
C13234 sg13cmos5l_buf_1_87.A sg13cmos5l_dlhr_1_10.Q 0
C13235 a_9256_9224# VPWR 0.24889f
C13236 sg13cmos5l_dfrbp_1_8.D a_17354_4180# 0
C13237 sg13cmos5l_dfrbp_1_6.RESET_B sg13cmos5l_buf_1_90.X 0
C13238 sg13cmos5l_buf_1_96.A sg13cmos5l_buf_1_57.X 0
C13239 sg13cmos5l_dlhr_1_15.D sg13cmos5l_buf_1_116.A 0.00896f
C13240 sg13cmos5l_buf_1_65.X sg13cmos5l_buf_1_77.A 0.00983f
C13241 sg13cmos5l_buf_1_65.X pl_sw[4] 0.00649f
C13242 sg13cmos5l_buf_1_110.A sg13cmos5l_buf_1_101.X 0
C13243 a_17931_1748# nl_sw[9] 0.00989f
C13244 sg13cmos5l_buf_1_94.X a_17516_9150# 0.03554f
C13245 a_17132_9150# sg13cmos5l_buf_1_103.A 0.00454f
C13246 sg13cmos5l_buf_1_93.X sg13cmos5l_inv_1_26.Y 0
C13247 a_11973_3911# sg13cmos5l_buf_1_6.A 0
C13248 a_16011_2399# nl_sw[8] 0.05359f
C13249 sg13cmos5l_buf_1_9.A sg13cmos5l_o21ai_1_0.A2 0.0156f
C13250 a_14295_7282# a_14641_7326# 0.00722f
C13251 a_12980_6924# a_13094_6924# 0.00122f
C13252 sg13cmos5l_dfrbp_1_8.D sg13cmos5l_buf_8_0.A 0
C13253 sg13cmos5l_inv_1_8.A a_5416_9224# 0
C13254 a_8378_5776# a_8588_3864# 0
C13255 a_13484_8400# sg13cmos5l_buf_1_5.A 0.28898f
C13256 sg13cmos5l_buf_1_3.A sg13cmos5l_dlhr_1_10.Q 0.3798f
C13257 sg13cmos5l_buf_1_105.A a_18870_7656# 0.00228f
C13258 a_18615_5770# a_19164_5814# 0
C13259 a_18746_5776# a_19209_5769# 0.13395f
C13260 sg13cmos5l_buf_1_60.X sg13cmos5l_buf_1_62.X 0.1482f
C13261 sg13cmos5l_buf_1_77.A a_10318_5412# 0
C13262 sg13cmos5l_buf_1_19.A d_out[2] 0
C13263 a_9448_1664# a_9832_1664# 0.00492f
C13264 a_13258_3361# VPWR 0.10496f
C13265 sg13cmos5l_buf_1_65.X sg13cmos5l_buf_1_74.X 0.17403f
C13266 a_12814_4692# a_12721_4261# 0
C13267 sg13cmos5l_and3_1_0.C a_13652_3900# 0.05416f
C13268 a_15784_9224# sg13cmos5l_inv_1_1.A 0.00642f
C13269 a_15500_9150# sg13cmos5l_buf_1_93.X 0.00692f
C13270 sg13cmos5l_buf_1_77.A a_8905_4704# 0
C13271 sg13cmos5l_dlhr_1_6.D a_11873_5760# 0
C13272 sg13cmos5l_dlhr_1_8.Q_N cks 0.00259f
C13273 sg13cmos5l_dfrbp_1_6.D a_1125_5423# 0.01317f
C13274 a_1196_8400# sg13cmos5l_buf_1_40.A 0
C13275 sg13cmos5l_or2_1_0.A sg13cmos5l_a22oi_1_0.B1 0.03607f
C13276 a_16271_7751# ph_sw[8] 0
C13277 sg13cmos5l_dfrbp_1_0.CLK VPWR 2.45106f
C13278 sg13cmos5l_dfrbp_1_21.Q a_17135_4727# 0.00402f
C13279 a_13324_4696# a_13036_4948# 0
C13280 sg13cmos5l_buf_1_0.A sg13cmos5l_buf_1_19.X 0.10697f
C13281 sg13cmos5l_dlhr_1_9.D a_4244_6924# 0
C13282 sg13cmos5l_buf_1_60.X sg13cmos5l_buf_1_44.X 0
C13283 sg13cmos5l_inv_1_27.Y a_15016_9224# 0
C13284 a_13648_9406# sg13cmos5l_buf_1_95.X 0.01542f
C13285 sg13cmos5l_and3_1_0.C a_11270_4338# 0
C13286 sg13cmos5l_dfrbp_1_6.RESET_B sg13cmos5l_buf_1_63.A 0
C13287 sg13cmos5l_buf_1_57.X sg13cmos5l_a221oi_1_0.B1 0
C13288 sg13cmos5l_buf_1_31.X a_2697_3529# 0
C13289 sg13cmos5l_a22oi_1_1.B2 a_14928_5412# 0
C13290 sg13cmos5l_dfrbp_1_6.RESET_B a_11190_7354# 0.01588f
C13291 a_7095_1642# VPWR 0.18163f
C13292 sg13cmos5l_buf_8_2.X pl_sw[10] 0.07581f
C13293 a_6184_9224# a_5988_8440# 0.00158f
C13294 a_8022_3120# sg13cmos5l_dlhr_1_0.Q 0
C13295 sg13cmos5l_dfrbp_1_0.Q a_14476_2388# 0
C13296 sg13cmos5l_dfrbp_1_6.RESET_B a_17161_8794# 0.0022f
C13297 sg13cmos5l_buf_1_41.A sg13cmos5l_buf_1_25.X 0
C13298 sg13cmos5l_dfrbp_1_10.Q sg13cmos5l_a22oi_1_1.B1 0.27129f
C13299 sg13cmos5l_dlhr_1_6.D a_13035_6284# 0.01168f
C13300 sg13cmos5l_dfrbp_1_8.RESET_B sg13cmos5l_buf_1_110.A 1.34409f
C13301 sg13cmos5l_inv_1_8.A a_7504_8678# 0
C13302 sg13cmos5l_inv_1_8.A a_6198_3120# 0
C13303 sg13cmos5l_dfrbp_1_6.RESET_B a_15062_4292# 0
C13304 a_9865_7282# sg13cmos5l_buf_1_29.A 0.00133f
C13305 sg13cmos5l_buf_1_19.A sg13cmos5l_a22oi_1_1.Y 0
C13306 sg13cmos5l_dfrbp_1_21.Q_N sg13cmos5l_dlhr_1_10.Q_N 0
C13307 sg13cmos5l_dfrbp_1_8.RESET_B sg13cmos5l_dfrbp_1_16.Q 4.03638f
C13308 sg13cmos5l_and3_1_0.X sg13cmos5l_a22oi_1_1.B1 0.00145f
C13309 sg13cmos5l_buf_1_34.X a_4076_7624# 0.01495f
C13310 a_10202_7288# a_10484_6924# 0.68988f
C13311 sg13cmos5l_inv_1_0.Y sg13cmos5l_a22oi_1_1.B1 0
C13312 a_18376_9224# ph_sw[9] 0.01311f
C13313 sg13cmos5l_nand2_1_1.A a_16011_2399# 0
C13314 sg13cmos5l_dfrbp_1_6.RESET_B sg13cmos5l_inv_1_8.Y 0.01289f
C13315 sg13cmos5l_inv_1_17.A a_4018_3138# 0.00169f
C13316 a_13076_5376# a_13486_5412# 0.00104f
C13317 sg13cmos5l_dfrbp_1_6.RESET_B a_5069_5376# 0.04541f
C13318 sg13cmos5l_inv_1_17.A a_3860_2388# 0.03645f
C13319 a_6647_5459# a_7394_5850# 0.00718f
C13320 sg13cmos5l_buf_1_46.A sg13cmos5l_a22oi_1_0.Y 0.06647f
C13321 sg13cmos5l_buf_8_1.A a_17674_3361# 0
C13322 sg13cmos5l_buf_1_110.A a_15414_7354# 0.00471f
C13323 sg13cmos5l_inv_1_8.A a_6891_4772# 0.02351f
C13324 a_9705_4650# sg13cmos5l_dlhr_1_20.Q_N 0.00294f
C13325 sg13cmos5l_buf_1_65.X sg13cmos5l_buf_1_58.A 0
C13326 sg13cmos5l_nor2_1_0.A a_13652_3900# 0.00186f
C13327 sg13cmos5l_nand2_1_1.A a_16936_1758# 0
C13328 cks sg13cmos5l_inv_1_19.A 0.03979f
C13329 sg13cmos5l_buf_1_33.A nl_sw[1] 0.0338f
C13330 sg13cmos5l_dfrbp_1_0.CLK a_15718_2813# -0
C13331 a_15380_3436# sg13cmos5l_buf_1_5.X 0.00649f
C13332 sg13cmos5l_buf_1_40.A a_1096_6294# 0.00856f
C13333 sg13cmos5l_buf_1_10.A a_11752_6294# 0.00307f
C13334 sg13cmos5l_nand2_1_1.A a_16703_3871# 0
C13335 a_12976_2630# a_13138_2826# 0.0019f
C13336 a_12719_2749# a_12625_2749# 0.32273f
C13337 sg13cmos5l_inv_1_8.A a_1290_3206# 0
C13338 sg13cmos5l_buf_1_32.A a_1576_1758# 0.00341f
C13339 a_8204_9150# a_8488_9224# 0.13542f
C13340 a_3578_2752# nl_sw[2] 0
C13341 sg13cmos5l_nor2b_1_0.Y sg13cmos5l_a22oi_1_1.B2 0.31649f
C13342 sg13cmos5l_inv_1_9.Y sg13cmos5l_nor2_1_2.A 0.30331f
C13343 pl_sw[2] ph_sw[2] 0.17285f
C13344 sg13cmos5l_dfrbp_1_8.RESET_B a_17519_6239# 0
C13345 a_7994_7288# sg13cmos5l_a221oi_1_0.A2 0
C13346 sg13cmos5l_dfrbp_1_8.D nh_sw[7] 0
C13347 sg13cmos5l_dfrbp_1_20.Q cks 0.03085f
C13348 sg13cmos5l_buf_1_45.X a_7796_6460# 0.00433f
C13349 sg13cmos5l_inv_1_17.A a_2054_3138# 0
C13350 sg13cmos5l_nor2_1_0.A a_11270_4338# 0
C13351 sg13cmos5l_dfrbp_1_0.D a_16572_4261# 0.00319f
C13352 a_16293_4629# a_16703_3871# 0.01088f
C13353 a_10022_7674# a_10665_8065# 0.00806f
C13354 a_10308_7992# a_10827_7796# 0.38902f
C13355 a_1088_7806# a_422_7362# 0
C13356 a_14612_6460# a_14583_5770# 0.00776f
C13357 a_13035_6284# a_13698_5412# 0
C13358 a_13768_8436# a_13641_7674# 0
C13359 a_13484_8400# a_13460_7996# 0
C13360 sg13cmos5l_buf_1_10.A sg13cmos5l_dlhr_1_11.D 0.0261f
C13361 sg13cmos5l_dfrbp_1_0.CLK a_16551_3987# 0
C13362 sg13cmos5l_buf_1_73.X a_8488_9224# 0
C13363 sg13cmos5l_dlhr_1_1.D a_2409_4650# 0.00768f
C13364 sg13cmos5l_inv_1_8.A a_1402_3864# 0.01768f
C13365 a_2859_3260# sg13cmos5l_buf_1_39.A 0
C13366 a_10473_9186# VPWR 0.61715f
C13367 sg13cmos5l_buf_1_95.X ph_sw[6] 1.05886f
C13368 sg13cmos5l_inv_1_1.A a_17161_8794# 0
C13369 sg13cmos5l_buf_1_103.A a_16724_8436# 0
C13370 sg13cmos5l_buf_1_45.X a_8783_7751# 0
C13371 a_5510_4338# a_5492_3460# 0
C13372 sg13cmos5l_buf_1_6.A a_12998_3138# 0.03025f
C13373 a_10464_2427# a_11072_2474# 0.0358f
C13374 sg13cmos5l_dfrbp_1_6.RESET_B sg13cmos5l_dfrbp_1_21.Q 0.18091f
C13375 sg13cmos5l_inv_1_6.A a_20392_7712# 0
C13376 sg13cmos5l_buf_1_19.A sg13cmos5l_dfrbp_1_21.Q_N 0.00184f
C13377 sg13cmos5l_inv_1_8.A a_1609_4704# 0.00472f
C13378 sg13cmos5l_dlhr_1_0.GATE sg13cmos5l_dfrbp_1_12.Q_N 0
C13379 sg13cmos5l_dfrbp_1_0.CLK a_11973_1605# 0.36457f
C13380 a_15531_7796# a_16042_6892# 0
C13381 a_15429_7653# a_16068_6928# 0
C13382 a_8390_6924# VPWR 0.00418f
C13383 sg13cmos5l_dlhr_1_9.D cks 0.00936f
C13384 sg13cmos5l_dfrbp_1_23.Q a_14844_7326# 0
C13385 a_13775_6239# a_14194_6162# 0.00176f
C13386 sg13cmos5l_a221oi_1_1.C1 sg13cmos5l_inv_1_0.A 0.00885f
C13387 sg13cmos5l_dfrbp_1_6.RESET_B sg13cmos5l_dlhr_1_15.Q 0.01214f
C13388 sg13cmos5l_dfrbp_1_8.RESET_B a_14166_7656# 0
C13389 sg13cmos5l_dfrbp_1_8.RESET_B sg13cmos5l_buf_1_63.X 0.22374f
C13390 sg13cmos5l_dfrbp_1_8.RESET_B a_4005_4629# 0.0529f
C13391 sg13cmos5l_o21ai_1_0.A2 sg13cmos5l_dfrbp_1_1.D 0
C13392 a_19209_5769# a_19164_5814# 0
C13393 a_14996_5412# sg13cmos5l_a22oi_1_1.A1 0
C13394 sg13cmos5l_or2_1_0.A sg13cmos5l_buf_1_25.A 0.00156f
C13395 a_13641_3529# VPWR 0
C13396 sg13cmos5l_inv_1_5.A sg13cmos5l_buf_1_0.X 0
C13397 sg13cmos5l_dlhr_1_6.D a_12800_5498# 0
C13398 sg13cmos5l_nand2_1_1.B sg13cmos5l_buf_1_7.A 0.02702f
C13399 sg13cmos5l_nand2_1_1.B a_10707_2388# 0.01289f
C13400 sg13cmos5l_buf_1_110.A a_15850_4873# 0
C13401 sg13cmos5l_a221oi_1_0.A2 sg13cmos5l_nor2b_1_0.Y 0.00736f
C13402 sg13cmos5l_dfrbp_1_23.CLK a_13076_5376# 0
C13403 sg13cmos5l_buf_1_28.X sg13cmos5l_buf_1_26.X 0
C13404 sg13cmos5l_inv_1_11.Y sg13cmos5l_buf_1_28.A 0
C13405 sg13cmos5l_dlhr_1_15.D ph_sw[8] 0
C13406 sg13cmos5l_dfrbp_1_8.RESET_B sg13cmos5l_a22oi_1_1.Y 0
C13407 sg13cmos5l_dlhr_1_5.Q a_9524_4972# 0
C13408 a_9256_9224# sg13cmos5l_buf_1_97.A 0
C13409 sg13cmos5l_inv_1_26.Y a_19593_6162# 0
C13410 sg13cmos5l_dfrbp_1_6.RESET_B sg13cmos5l_or2_1_1.B 0.01244f
C13411 sg13cmos5l_buf_1_41.A a_2380_6162# 0
C13412 sg13cmos5l_dfrbp_1_22.D sg13cmos5l_buf_1_4.A 0.00372f
C13413 a_17367_8794# a_17545_7728# 0
C13414 sg13cmos5l_dfrbp_1_8.RESET_B sg13cmos5l_inv_1_9.Y 0
C13415 sg13cmos5l_buf_1_31.X a_2566_3151# 0
C13416 sg13cmos5l_nand2_1_0.A a_13072_4142# 0
C13417 a_904_7806# cks 0.01686f
C13418 sg13cmos5l_dfrbp_1_6.RESET_B a_12567_7282# 0.07116f
C13419 sg13cmos5l_a22oi_1_0.Y a_10613_2758# 0
C13420 sg13cmos5l_buf_1_45.X a_6213_3911# 0
C13421 a_9164_1590# VPWR 0.25135f
C13422 sg13cmos5l_buf_1_74.X a_6507_8447# 0
C13423 sg13cmos5l_dlhr_1_2.Q sg13cmos5l_dlhr_1_0.Q 0.03613f
C13424 sg13cmos5l_buf_1_25.A a_7820_2352# 0
C13425 sg13cmos5l_dfrbp_1_0.Q a_17588_2388# 0
C13426 sg13cmos5l_buf_1_77.X a_10224_9508# 0
C13427 a_8746_8404# a_7524_7992# 0
C13428 a_8486_8874# a_8043_7796# 0
C13429 sg13cmos5l_buf_1_63.X a_1662_8374# 0
C13430 a_1463_8511# sg13cmos5l_dfrbp_1_17.D 0.04031f
C13431 sg13cmos5l_inv_1_1.A sg13cmos5l_dfrbp_1_21.Q 0.02463f
C13432 sg13cmos5l_inv_1_8.A a_8486_8874# 0
C13433 a_6959_6239# a_7631_4727# 0
C13434 sg13cmos5l_or2_1_0.A a_5408_3986# 0
C13435 a_16677_6141# a_16395_4772# 0
C13436 sg13cmos5l_buf_1_46.A sg13cmos5l_buf_1_26.A 0
C13437 sg13cmos5l_dfrbp_1_23.CLK a_12873_6553# 0
C13438 a_10665_7281# a_10900_7312# 0.00566f
C13439 a_10202_7288# a_10598_6924# 0.00949f
C13440 a_19528_6924# a_19412_6484# 0.00384f
C13441 sg13cmos5l_dlhr_1_10.Q a_19593_6162# 0.29925f
C13442 sg13cmos5l_dfrbp_1_0.Q a_17829_1605# 0.00848f
C13443 sg13cmos5l_and3_1_0.X a_13486_5412# 0.01683f
C13444 a_6903_3154# a_7249_3130# 0.00722f
C13445 sg13cmos5l_dfrbp_1_6.RESET_B a_5799_5499# 0.04476f
C13446 a_15876_4968# nh_sw[7] 0
C13447 sg13cmos5l_buf_1_25.X a_6188_1590# 0.30346f
C13448 a_15884_3102# a_15492_2392# 0
C13449 a_8041_5770# a_8378_5776# 0.64635f
C13450 a_8247_5770# sg13cmos5l_a221oi_1_0.A2 0.00267f
C13451 sg13cmos5l_buf_1_111.A ph_sw[10] 0
C13452 sg13cmos5l_buf_1_0.A a_17386_1849# 0
C13453 sg13cmos5l_inv_1_8.A a_7833_4965# 0
C13454 sg13cmos5l_inv_1_7.A sg13cmos5l_dlhr_1_15.D 0.02151f
C13455 sg13cmos5l_a22oi_1_0.Y sg13cmos5l_nand2_1_1.B 0.06378f
C13456 sg13cmos5l_a22oi_1_0.B1 sg13cmos5l_dfrbp_1_2.D 0.0033f
C13457 a_17367_8794# sg13cmos5l_dlhr_1_12.D 0.00804f
C13458 sg13cmos5l_buf_1_60.X sg13cmos5l_dlhr_1_9.Q 0
C13459 sg13cmos5l_inv_1_20.Y sg13cmos5l_dfrbp_1_16.Q_N 0.52221f
C13460 a_17161_8794# a_17498_8800# 0.64635f
C13461 sg13cmos5l_dfrbp_1_15.D a_2748_6126# 0.00395f
C13462 sg13cmos5l_dlhr_1_9.D a_9524_4972# 0.00317f
C13463 sg13cmos5l_dfrbp_1_8.D a_16486_6175# 0
C13464 a_11360_9318# VPWR 0.07238f
C13465 a_9673_9240# sg13cmos5l_buf_1_57.X 0
C13466 sg13cmos5l_dfrbp_1_18.Q a_10308_7992# 0.00384f
C13467 a_10010_9196# a_10282_7897# 0
C13468 sg13cmos5l_nand2_1_1.A a_18363_4270# 0.03003f
C13469 a_7055_4261# sg13cmos5l_dlhr_1_2.Q 0.00219f
C13470 sg13cmos5l_buf_1_10.A a_12324_6162# 0
C13471 sg13cmos5l_dfrbp_1_0.CLK a_17170_2826# 0
C13472 sg13cmos5l_dlhr_1_5.GATE sg13cmos5l_buf_1_41.A 0
C13473 sg13cmos5l_buf_1_34.A nl_sw[2] 0
C13474 a_15147_8447# pl_sw[7] 0
C13475 a_6315_3911# sg13cmos5l_dfrbp_1_10.Q 0
C13476 sg13cmos5l_o21ai_1_0.B1 a_14449_3215# 0.00179f
C13477 a_6315_3911# a_6736_2630# 0
C13478 sg13cmos5l_dfrbp_1_6.D a_13977_6477# 0
C13479 sg13cmos5l_buf_1_111.A a_18196_8824# 0
C13480 sg13cmos5l_dfrbp_1_23.CLK sg13cmos5l_dfrbp_1_22.D 0
C13481 sg13cmos5l_dfrbp_1_0.D a_16936_1758# 0.07427f
C13482 sg13cmos5l_inv_1_17.A a_3856_3358# 0.03907f
C13483 sg13cmos5l_buf_1_45.X sg13cmos5l_dlhr_1_5.Q 0.05286f
C13484 sg13cmos5l_nor2_1_0.A a_11844_4325# 0
C13485 a_17135_4727# a_17493_3947# 0
C13486 sg13cmos5l_dfrbp_1_0.D a_16703_3871# 0
C13487 a_10827_7796# a_11824_7894# 0.06778f
C13488 a_10022_7674# a_10596_7687# 0.36169f
C13489 sg13cmos5l_inv_1_8.A a_1862_8874# 0.00169f
C13490 sg13cmos5l_dfrbp_1_20.Q_N a_8783_7751# 0.04458f
C13491 a_20392_6924# ph_sw[10] 0.29213f
C13492 sg13cmos5l_dfrbp_1_0.CLK a_16462_4023# 0
C13493 sg13cmos5l_dlhr_1_7.Q_N cks 0
C13494 sg13cmos5l_inv_1_17.A a_2148_8440# 0.00596f
C13495 sg13cmos5l_dfrbp_1_0.D a_18574_5028# 0.01389f
C13496 a_6380_7638# pl_sw[3] 0.28823f
C13497 sg13cmos5l_a22oi_1_1.A1 sg13cmos5l_buf_1_7.A 0
C13498 sg13cmos5l_buf_1_6.A a_14800_3358# 0
C13499 a_12998_3138# a_12815_1703# 0
C13500 sg13cmos5l_dfrbp_1_6.RESET_B a_1227_6935# 0.55488f
C13501 sg13cmos5l_dlhr_1_15.D sg13cmos5l_a221oi_1_0.B2 0.02685f
C13502 a_11464_9224# sg13cmos5l_dlhr_1_21.Q_N 0.0698f
C13503 a_5069_5376# a_5452_5850# 0.35645f
C13504 sg13cmos5l_inv_1_8.A a_2160_4972# 0
C13505 a_17751_7690# sg13cmos5l_dlhr_1_15.Q 0
C13506 a_17882_7684# a_18164_7996# 0.68988f
C13507 sg13cmos5l_dlhr_1_9.D a_2565_3911# 0
C13508 sg13cmos5l_dfrbp_1_6.D a_8378_5776# 0
C13509 sg13cmos5l_a221oi_1_1.C1 a_10420_5412# 0.00427f
C13510 a_14342_8874# a_14628_8440# 0.50066f
C13511 sg13cmos5l_buf_1_2.A a_15821_3864# 0.00591f
C13512 a_3313_8797# a_3574_7850# 0
C13513 a_4244_8436# a_3676_7964# 0
C13514 sg13cmos5l_buf_1_65.X rdy 0.00238f
C13515 a_3407_8797# a_4076_7624# 0.01073f
C13516 sg13cmos5l_dfrbp_1_0.CLK a_14056_1664# 0
C13517 a_17108_7972# a_16485_6935# 0.00613f
C13518 sg13cmos5l_buf_1_29.A VPWR 0.76524f
C13519 sg13cmos5l_buf_1_40.X sg13cmos5l_buf_1_41.X 0
C13520 sg13cmos5l_buf_1_32.A sg13cmos5l_buf_1_37.A 0.01144f
C13521 sg13cmos5l_buf_1_5.A a_12998_3138# 0
C13522 a_6372_4968# a_6315_3911# 0
C13523 a_10665_7281# VPWR 0.627f
C13524 sg13cmos5l_inv_1_17.A a_3562_4873# 0.03439f
C13525 sg13cmos5l_dfrbp_1_8.RESET_B a_4847_4727# 0.2053f
C13526 sg13cmos5l_buf_1_9.A a_11460_2392# 0.03262f
C13527 a_17367_8794# VPWR 0.18312f
C13528 a_18409_5770# sg13cmos5l_a22oi_1_1.A1 0.00132f
C13529 a_10888_1664# a_11530_1849# 0.00308f
C13530 sg13cmos5l_dfrbp_1_6.RESET_B a_16234_6385# 0.33251f
C13531 a_11752_6294# sg13cmos5l_nor2b_1_0.Y 0.00475f
C13532 a_10473_9186# sg13cmos5l_buf_1_97.A 0.30822f
C13533 a_10292_9508# a_10406_9624# 0.00122f
C13534 sg13cmos5l_inv_1_7.A sg13cmos5l_o21ai_1_0.A2 0
C13535 sg13cmos5l_and3_1_0.C a_13803_3260# 0
C13536 ph_sw[10] d_out[2] 0.00265f
C13537 sg13cmos5l_buf_1_45.X sg13cmos5l_dlhr_1_9.D 0.0255f
C13538 sg13cmos5l_nand2_1_1.B a_13556_2388# 0
C13539 a_14996_5412# sg13cmos5l_or2_1_0.A 0
C13540 sg13cmos5l_dfrbp_1_21.Q a_15702_4187# 0
C13541 a_8972_9150# a_8486_8874# 0
C13542 a_12651_9308# a_12420_9199# 0.15089f
C13543 a_12132_9504# a_13297_9263# 0.4858f
C13544 a_3407_4261# a_3609_4023# 0.00675f
C13545 a_1862_8874# a_1948_7964# 0
C13546 a_13072_4142# sg13cmos5l_dfrbp_1_1.Q 0
C13547 sg13cmos5l_dfrbp_1_23.CLK sg13cmos5l_and3_1_0.X 0.00229f
C13548 sg13cmos5l_inv_1_18.A sg13cmos5l_dfrbp_1_8.RESET_B 0.03476f
C13549 sg13cmos5l_dfrbp_1_0.RESET_B a_12815_4261# 0.24205f
C13550 a_422_7362# sg13cmos5l_inv_1_19.A 0
C13551 sg13cmos5l_inv_1_26.Y a_19345_6154# 0
C13552 a_4950_5699# VPWR 0.36196f
C13553 sg13cmos5l_buf_1_26.X sg13cmos5l_a22oi_1_2.B1 0.00189f
C13554 a_9260_2352# sg13cmos5l_buf_1_30.X 0.31928f
C13555 sg13cmos5l_dlhr_1_1.GATE a_4736_5498# 0
C13556 a_18959_3215# d_out[1] 0.00151f
C13557 a_8486_8874# a_8276_6924# 0
C13558 a_3625_7282# a_3962_7288# 0.64635f
C13559 sg13cmos5l_dfrbp_1_6.RESET_B a_13116_7326# 0
C13560 sg13cmos5l_buf_1_45.X a_7892_3900# 0.00349f
C13561 sg13cmos5l_dfrbp_1_6.D a_708_5416# 0.02103f
C13562 a_7441_1618# VPWR 0
C13563 sg13cmos5l_inv_1_2.A a_16177_7751# 0
C13564 sg13cmos5l_nor2_1_2.A sg13cmos5l_buf_1_40.X 0.00736f
C13565 sg13cmos5l_dfrbp_1_0.Q a_19244_2352# 0.01267f
C13566 sg13cmos5l_buf_1_30.A sg13cmos5l_buf_1_26.X 0.3901f
C13567 a_6568_9224# sg13cmos5l_dfrbp_1_8.RESET_B 0
C13568 sg13cmos5l_buf_1_2.A VPWR 0.69581f
C13569 sg13cmos5l_buf_1_2.A nl_sw[7] 0
C13570 sg13cmos5l_dlhr_1_6.D a_7631_4727# 0.00152f
C13571 sg13cmos5l_buf_1_24.A a_7689_1626# 0.00747f
C13572 sg13cmos5l_dfrbp_1_6.RESET_B a_17493_3947# 0.32059f
C13573 a_15466_2356# a_15909_2399# 0.02241f
C13574 a_17519_6239# a_17135_4727# 0
C13575 sg13cmos5l_nand2_1_0.A a_10331_3900# 0.02986f
C13576 sg13cmos5l_dfrbp_1_0.Q a_20012_1590# 0
C13577 a_11190_7354# a_12361_7282# 0
C13578 sg13cmos5l_dlhr_1_5.Q sg13cmos5l_a22oi_1_2.B2 0
C13579 a_13284_3456# nh_sw[7] 0
C13580 sg13cmos5l_nand2_1_1.B sg13cmos5l_buf_1_26.A 0
C13581 sg13cmos5l_inv_1_27.Y a_14377_5770# 0
C13582 sg13cmos5l_dfrbp_1_6.RESET_B a_10028_6126# 0
C13583 a_12841_7728# pl_sw[6] 0
C13584 sg13cmos5l_dfrbp_1_8.RESET_B a_3669_6320# 0.31914f
C13585 sg13cmos5l_dlhr_1_11.GATE a_11464_8436# 0.04892f
C13586 sg13cmos5l_buf_1_5.X a_15780_2813# 0
C13587 a_2314_3361# sg13cmos5l_inv_1_19.A 0
C13588 sg13cmos5l_buf_1_25.X a_7095_1642# 0
C13589 a_9448_1664# nh_sw[4] 0.00486f
C13590 a_16204_4338# a_15909_2399# 0
C13591 sg13cmos5l_dfrbp_1_20.Q sg13cmos5l_a22oi_1_2.B2 0.16126f
C13592 sg13cmos5l_inv_1_1.A a_16234_6385# 0.00722f
C13593 a_8233_6216# sg13cmos5l_buf_1_29.A 0
C13594 a_8852_6484# a_8966_6600# 0.00122f
C13595 a_10028_6126# a_10412_6126# 0.00492f
C13596 sg13cmos5l_dlhr_1_6.D a_8988_6198# 0
C13597 sg13cmos5l_buf_1_43.A a_902_3142# 0.00183f
C13598 sg13cmos5l_nor2_1_0.A a_13803_3260# 0.00722f
C13599 sg13cmos5l_dfrbp_1_15.D a_1967_5773# 0
C13600 a_10071_7282# a_10028_6126# 0
C13601 sg13cmos5l_buf_1_29.A sg13cmos5l_dfrbp_1_11.Q 0
C13602 a_8588_3864# sg13cmos5l_dfrbp_1_10.Q 0
C13603 pl_sw[1] rdy 0.00347f
C13604 sg13cmos5l_a221oi_1_0.B1 sg13cmos5l_dfrbp_1_0.RESET_B 0.01277f
C13605 sg13cmos5l_dfrbp_1_1.Q sg13cmos5l_buf_1_0.X 0.06123f
C13606 sg13cmos5l_buf_1_40.A a_1967_5773# 0
C13607 a_14814_3876# sg13cmos5l_buf_1_5.X 0.00105f
C13608 sg13cmos5l_dfrbp_1_0.Q a_16268_1590# 0.00559f
C13609 sg13cmos5l_dfrbp_1_6.RESET_B sg13cmos5l_buf_1_111.A 0
C13610 a_15821_3864# sg13cmos5l_dfrbp_1_6.Q_N 0.04107f
C13611 sg13cmos5l_dfrbp_1_0.D a_18671_1703# 0
C13612 sg13cmos5l_a22oi_1_1.Y sg13cmos5l_dfrbp_1_0.Q 0
C13613 sg13cmos5l_dfrbp_1_0.RESET_B nl_sw[8] 0.02417f
C13614 sg13cmos5l_dlhr_1_0.D nl_sw[6] 0
C13615 sg13cmos5l_dfrbp_1_0.D a_18363_4270# 0.06054f
C13616 a_18870_7656# VPWR 0.25001f
C13617 sg13cmos5l_buf_1_6.A a_15300_2826# 0
C13618 sg13cmos5l_dfrbp_1_0.CLK a_18873_1941# 0
C13619 a_11824_7894# a_11769_7989# 0.00464f
C13620 sg13cmos5l_buf_1_116.A a_15412_5800# 0
C13621 sg13cmos5l_inv_1_8.A a_2667_8447# 0.02155f
C13622 a_9705_4650# sg13cmos5l_a22oi_1_0.Y 0.00577f
C13623 a_10308_7992# cks 0.00632f
C13624 sg13cmos5l_buf_1_57.X a_10417_7326# 0
C13625 sg13cmos5l_inv_1_20.Y a_2596_7996# 0
C13626 a_2409_4650# sg13cmos5l_inv_1_19.A 0.00245f
C13627 sg13cmos5l_inv_1_17.A a_4244_8436# 0.0045f
C13628 sg13cmos5l_dfrbp_1_6.RESET_B sg13cmos5l_buf_1_110.A 0.06059f
C13629 a_6315_3911# sg13cmos5l_dlhr_1_2.D 0
C13630 sg13cmos5l_buf_1_98.A sg13cmos5l_inv_1_29.A 0
C13631 sg13cmos5l_buf_1_44.A a_5908_3124# 0
C13632 sg13cmos5l_buf_1_41.X sg13cmos5l_buf_1_39.A 0
C13633 sg13cmos5l_dlhr_1_9.D sg13cmos5l_a22oi_1_2.B2 0.54216f
C13634 sg13cmos5l_dfrbp_1_6.D a_2436_4325# 0.00156f
C13635 a_13803_3260# a_14440_1664# 0.00111f
C13636 sg13cmos5l_dfrbp_1_6.RESET_B sg13cmos5l_dfrbp_1_16.Q 0.10998f
C13637 sg13cmos5l_buf_1_103.A sg13cmos5l_buf_1_87.A 0
C13638 sg13cmos5l_buf_1_44.A a_5637_2399# 0
C13639 a_904_7806# a_422_7362# 0
C13640 a_5820_5773# a_5710_5850# 0.4858f
C13641 a_5452_5850# a_5799_5499# 0.06778f
C13642 a_5069_5376# a_5951_5383# 0.00437f
C13643 sg13cmos5l_buf_1_97.A a_11360_9318# 0
C13644 sg13cmos5l_buf_1_73.A a_6117_6141# 0
C13645 a_12216_5728# VPWR 0.24314f
C13646 sg13cmos5l_buf_1_18.A sg13cmos5l_buf_1_18.X 0.01705f
C13647 a_14628_8440# a_14916_8861# 0.4806f
C13648 a_17135_4727# sg13cmos5l_a22oi_1_1.Y 0
C13649 sg13cmos5l_or2_1_0.A sg13cmos5l_buf_1_7.A 0.02502f
C13650 sg13cmos5l_dfrbp_1_15.D a_4324_7996# 0.00666f
C13651 a_14602_8404# a_15147_8447# 0.00999f
C13652 a_14342_8874# a_15887_8797# 0
C13653 sg13cmos5l_inv_1_6.A a_18999_6178# 0
C13654 a_12921_2511# VPWR 0
C13655 sg13cmos5l_buf_1_5.A a_14800_3358# 0
C13656 a_12933_6141# sg13cmos5l_a22oi_1_1.B2 0
C13657 a_11560_7010# VPWR 0.13634f
C13658 sg13cmos5l_inv_1_7.A sg13cmos5l_dlhr_1_6.D 0.0218f
C13659 sg13cmos5l_dfrbp_1_16.Q a_10412_6126# 0.00551f
C13660 a_1580_2352# nh_sw[0] 0.2906f
C13661 sg13cmos5l_buf_1_93.X a_13297_9263# 0
C13662 sg13cmos5l_dfrbp_1_8.RESET_B a_15369_8065# 0
C13663 a_2054_3138# a_1864_1664# 0
C13664 sg13cmos5l_dfrbp_1_16.Q a_10071_7282# 0
C13665 sg13cmos5l_dfrbp_1_8.RESET_B sg13cmos5l_dfrbp_1_14.Q_N 0.00112f
C13666 a_12361_7282# sg13cmos5l_dfrbp_1_21.Q 0
C13667 sg13cmos5l_buf_1_73.A a_7941_7653# 0.00469f
C13668 a_19734_5842# sg13cmos5l_a22oi_1_1.A1 0
C13669 a_10464_2427# sg13cmos5l_dfrbp_1_4.D 0.23388f
C13670 sg13cmos5l_inv_1_2.A sg13cmos5l_a22oi_1_1.B1 0.02017f
C13671 a_10331_1924# a_10696_1758# 0.01003f
C13672 sg13cmos5l_dfrbp_1_1.Q_N VPWR 0.17907f
C13673 sg13cmos5l_buf_1_86.A sg13cmos5l_dlhr_1_15.Q 0
C13674 sg13cmos5l_dfrbp_1_6.RESET_B a_17519_6239# 0.25431f
C13675 sg13cmos5l_dfrbp_1_6.Q_N VPWR 0.18031f
C13676 sg13cmos5l_buf_1_34.X sg13cmos5l_inv_1_19.A 0.50311f
C13677 sg13cmos5l_buf_1_79.X sg13cmos5l_dlhr_1_11.GATE 0.04887f
C13678 a_10233_8559# sg13cmos5l_dfrbp_1_20.Q 0
C13679 sg13cmos5l_a221oi_1_0.A2 a_8022_3120# 0
C13680 sg13cmos5l_and3_1_0.C sg13cmos5l_buf_1_5.X 0
C13681 a_13391_9263# sg13cmos5l_dfrbp_1_23.CLK 0.0031f
C13682 a_13648_9406# sg13cmos5l_dfrbp_1_24.Q_N 0.15881f
C13683 sg13cmos5l_buf_1_93.X sg13cmos5l_buf_1_103.A 0.14191f
C13684 a_18409_5770# sg13cmos5l_or2_1_0.A 0
C13685 sg13cmos5l_buf_1_95.X sg13cmos5l_buf_1_101.X 0
C13686 sg13cmos5l_buf_1_77.A a_8998_8861# 0
C13687 sg13cmos5l_dfrbp_1_9.Q_N sg13cmos5l_buf_1_44.A 0
C13688 a_2565_8447# a_2621_7636# 0.00642f
C13689 sg13cmos5l_dfrbp_1_0.CLK a_12120_3456# 0
C13690 sg13cmos5l_dlhr_1_9.D a_2409_4650# 0
C13691 sg13cmos5l_dfrbp_1_0.RESET_B sg13cmos5l_nand2_1_1.A 3.97898f
C13692 sg13cmos5l_inv_1_3.A a_15045_8447# 0.01086f
C13693 a_5710_5850# VPWR 0
C13694 a_13035_6284# a_13977_6477# 0
C13695 a_12516_6480# a_12742_6175# 0.00523f
C13696 a_12933_6141# a_12804_6175# 0.01562f
C13697 sg13cmos5l_inv_1_8.A sg13cmos5l_buf_1_76.X 0.00564f
C13698 a_2732_9150# ph_sw[1] 0.0104f
C13699 sg13cmos5l_buf_1_30.A a_5414_6162# 0
C13700 a_20392_3176# a_20200_3270# 0.01225f
C13701 a_8746_8404# sg13cmos5l_dlhr_1_5.Q 0
C13702 sg13cmos5l_dfrbp_1_6.RESET_B d_out[2] 0
C13703 sg13cmos5l_buf_1_97.A a_10665_7281# 0
C13704 sg13cmos5l_buf_1_45.X a_8296_3986# 0.018f
C13705 sg13cmos5l_buf_1_6.A VPWR 0.37932f
C13706 a_11530_1849# VPWR 0.10177f
C13707 sg13cmos5l_buf_1_6.A nl_sw[7] 0
C13708 sg13cmos5l_buf_1_110.A sg13cmos5l_inv_1_1.A 0.22499f
C13709 a_14632_9224# sg13cmos5l_buf_1_94.X 0.00201f
C13710 a_16293_4629# sg13cmos5l_dfrbp_1_0.RESET_B 0
C13711 sg13cmos5l_dlhr_1_6.D sg13cmos5l_a221oi_1_0.B2 0.00158f
C13712 sg13cmos5l_buf_1_95.X a_13100_8400# 0
C13713 sg13cmos5l_dfrbp_1_9.Q a_5770_3868# 0
C13714 sg13cmos5l_buf_1_31.X nh_sw[0] 0.01395f
C13715 sg13cmos5l_nand2_1_1.B a_10613_2758# 0.01694f
C13716 sg13cmos5l_dlhr_1_6.D sg13cmos5l_dfrbp_1_11.Q_N 0
C13717 sg13cmos5l_dfrbp_1_0.RESET_B sg13cmos5l_inv_1_11.Y 0
C13718 a_2374_4325# a_2436_4325# 0
C13719 sg13cmos5l_or2_1_0.A sg13cmos5l_a22oi_1_0.Y 0.00521f
C13720 sg13cmos5l_buf_1_30.A a_7238_7674# 0.00172f
C13721 a_15909_2399# a_15780_2813# 0.01562f
C13722 a_15492_2392# a_16011_2399# 0.38871f
C13723 a_416_7806# cks 0.00135f
C13724 sg13cmos5l_buf_1_44.X sg13cmos5l_dlhr_1_1.GATE 0.00197f
C13725 a_12567_7282# a_12361_7282# 0.27822f
C13726 sg13cmos5l_buf_1_0.A sg13cmos5l_buf_1_18.X 0.07927f
C13727 sg13cmos5l_buf_8_1.A a_18122_2388# 0
C13728 sg13cmos5l_dfrbp_1_6.RESET_B sg13cmos5l_buf_1_63.X 0.00679f
C13729 a_15380_3436# nh_sw[7] 0.01333f
C13730 a_11986_7674# pl_sw[6] 0
C13731 sg13cmos5l_dfrbp_1_6.RESET_B a_14166_7656# 0.01348f
C13732 sg13cmos5l_o21ai_1_0.A1 a_11530_3868# 0.03155f
C13733 sg13cmos5l_dfrbp_1_8.RESET_B a_5674_6385# 0
C13734 sg13cmos5l_dfrbp_1_22.D a_15592_6200# 0
C13735 sg13cmos5l_buf_1_29.A sg13cmos5l_dlhr_1_17.Q_N 0.00359f
C13736 sg13cmos5l_dfrbp_1_20.Q a_11268_5760# 0
C13737 sg13cmos5l_buf_1_65.X a_7498_7897# 0
C13738 sg13cmos5l_buf_1_34.X sg13cmos5l_dlhr_1_9.D 0.16478f
C13739 sg13cmos5l_dlhr_1_11.GATE sg13cmos5l_buf_1_96.A 0.21291f
C13740 sg13cmos5l_dlhr_1_2.Q a_7732_3124# 0
C13741 sg13cmos5l_dfrbp_1_8.RESET_B a_3308_5376# 0
C13742 sg13cmos5l_buf_1_78.A a_5988_8440# 0.04216f
C13743 sg13cmos5l_dfrbp_1_6.D a_5628_3174# 0
C13744 sg13cmos5l_dfrbp_1_10.Q a_7249_3130# 0
C13745 a_16703_3871# a_15492_2392# 0
C13746 a_16572_4261# a_16011_2399# 0
C13747 sg13cmos5l_dfrbp_1_6.D a_5220_2392# 0.00378f
C13748 sg13cmos5l_inv_1_0.A sg13cmos5l_dfrbp_1_4.D 0
C13749 sg13cmos5l_a22oi_1_2.B2 a_9823_2364# 0.0746f
C13750 sg13cmos5l_inv_1_14.A nl_sw[5] 0
C13751 a_12404_7972# a_12230_6162# 0
C13752 sg13cmos5l_dlhr_1_1.GATE a_2804_6924# 0.00816f
C13753 sg13cmos5l_dfrbp_1_8.RESET_B sg13cmos5l_buf_1_95.X 0.22569f
C13754 a_2565_8447# ph_sw[1] 0
C13755 sg13cmos5l_dfrbp_1_6.RESET_B sg13cmos5l_a22oi_1_1.Y 0.03304f
C13756 sg13cmos5l_buf_1_34.X sg13cmos5l_buf_1_33.A 0
C13757 sg13cmos5l_dfrbp_1_22.Q_N sg13cmos5l_dlhr_1_10.Q 0
C13758 a_2122_8404# sg13cmos5l_inv_1_19.A 0.00104f
C13759 a_4460_9150# a_4324_7996# 0
C13760 a_8296_3986# a_8204_2352# 0
C13761 a_19136_9318# cks 0.04201f
C13762 a_16298_4338# a_16462_4338# 0
C13763 a_16572_4261# a_16703_3871# 0.48921f
C13764 VPWR d_out[0] 0.16231f
C13765 nl_sw[2] nl_sw[3] 0.15014f
C13766 sg13cmos5l_dfrbp_1_0.D a_17638_1639# 0
C13767 sg13cmos5l_dfrbp_1_6.RESET_B sg13cmos5l_inv_1_9.Y 0.00177f
C13768 sg13cmos5l_nor2_1_1.A cks 0
C13769 sg13cmos5l_dfrbp_1_8.RESET_B a_934_7349# 0
C13770 a_7034_3148# a_7316_3460# 0.68988f
C13771 sg13cmos5l_inv_1_8.A sg13cmos5l_dfrbp_1_17.Q_N 0.00368f
C13772 sg13cmos5l_dfrbp_1_24.Q_N ph_sw[6] 0.00532f
C13773 sg13cmos5l_buf_8_1.A sg13cmos5l_buf_1_4.X 0.00475f
C13774 a_11824_7894# cks 0
C13775 sg13cmos5l_buf_1_57.X a_10416_6924# 0
C13776 sg13cmos5l_inv_1_3.A sg13cmos5l_inv_1_0.A 0.22087f
C13777 a_9705_4650# sg13cmos5l_buf_1_46.A 0.30929f
C13778 sg13cmos5l_buf_1_60.X a_3676_7964# 0
C13779 sg13cmos5l_inv_1_2.A a_17041_4727# 0.00518f
C13780 sg13cmos5l_buf_1_45.X a_6647_5459# 0
C13781 a_11464_9224# VPWR 0.2577f
C13782 sg13cmos5l_dfrbp_1_8.RESET_B a_4559_7630# 0
C13783 sg13cmos5l_buf_1_10.A sg13cmos5l_inv_1_29.Y 0.04004f
C13784 sg13cmos5l_dfrbp_1_6.D a_2505_3947# 0
C13785 a_12815_1703# a_13017_1941# 0.00675f
C13786 a_12075_1748# a_12721_1703# 0.00667f
C13787 sg13cmos5l_buf_1_5.X a_14440_1664# 0.2906f
C13788 a_15974_6162# sg13cmos5l_dfrbp_1_21.Q 0
C13789 sg13cmos5l_buf_1_40.X a_1576_1758# 0.02393f
C13790 a_1580_2352# a_1760_1758# 0
C13791 sg13cmos5l_buf_1_43.A sg13cmos5l_nor2_1_2.A 0.08477f
C13792 a_7052_9150# sg13cmos5l_buf_1_78.X 0
C13793 sg13cmos5l_buf_1_77.X sg13cmos5l_inv_1_18.A 0
C13794 a_7336_9224# pl_sw[4] 0
C13795 a_15045_8447# cks 0.01764f
C13796 sg13cmos5l_dfrbp_1_6.D a_12873_6553# 0
C13797 sg13cmos5l_buf_1_5.A a_10900_7312# 0
C13798 sg13cmos5l_a22oi_1_1.Y a_14543_3215# 0
C13799 a_5799_5499# a_5951_5383# 0.66105f
C13800 sg13cmos5l_nor2_1_0.A a_13036_4948# 0.00167f
C13801 sg13cmos5l_dfrbp_1_6.RESET_B sg13cmos5l_dfrbp_1_15.Q_N 0.00289f
C13802 sg13cmos5l_buf_1_111.A a_17498_8800# 0
C13803 sg13cmos5l_buf_1_2.A a_16462_4023# 0
C13804 a_15147_8447# a_16144_8678# 0.07046f
C13805 sg13cmos5l_dlhr_1_0.GATE a_6572_1590# 0.00357f
C13806 sg13cmos5l_dlhr_1_15.D a_17233_7285# 0.01834f
C13807 sg13cmos5l_inv_1_3.A a_12490_6385# 0
C13808 a_16751_2749# VPWR 0.26061f
C13809 sg13cmos5l_or2_1_1.B a_11980_4948# 0
C13810 sg13cmos5l_buf_1_40.A nl_sw[2] 0
C13811 a_13686_7354# VPWR 0.25227f
C13812 a_7537_4727# a_7055_4261# 0
C13813 a_17132_9150# cks 0.00188f
C13814 a_17751_7690# a_17519_6239# 0.00199f
C13815 sg13cmos5l_dfrbp_1_6.D a_1862_4338# 0.01896f
C13816 sg13cmos5l_buf_1_74.X a_7336_9224# 0.00569f
C13817 sg13cmos5l_dfrbp_1_6.RESET_B a_996_7349# 0
C13818 sg13cmos5l_dfrbp_1_8.RESET_B a_15238_7687# 0
C13819 a_3599_3215# sg13cmos5l_buf_1_33.A 0
C13820 a_3488_7010# cks 0
C13821 sg13cmos5l_buf_1_87.A a_18746_5776# 0
C13822 a_15782_7362# sg13cmos5l_buf_1_4.A 0
C13823 a_12075_3911# sg13cmos5l_o21ai_1_0.B1 0.00112f
C13824 sg13cmos5l_dfrbp_1_17.D a_1125_6935# 0.00138f
C13825 sg13cmos5l_buf_1_44.A a_5492_3460# 0
C13826 a_7238_7674# pl_sw[5] 0
C13827 sg13cmos5l_buf_1_6.A a_11973_1605# 0
C13828 sg13cmos5l_o21ai_1_0.Y a_13803_3260# 0
C13829 a_11530_1849# a_11973_1605# 0.02241f
C13830 a_11270_1626# a_11556_1944# 0.50066f
C13831 a_17412_1944# VPWR 0.07475f
C13832 sg13cmos5l_dfrbp_1_6.RESET_B sg13cmos5l_dfrbp_1_21.Q_N 0.2328f
C13833 sg13cmos5l_inv_1_6.A sg13cmos5l_buf_8_0.X 0.39539f
C13834 sg13cmos5l_buf_1_104.X a_20392_7712# 0.00108f
C13835 sg13cmos5l_buf_1_110.A a_15702_4187# 0
C13836 a_17750_4325# VPWR 0
C13837 sg13cmos5l_dfrbp_1_22.D sg13cmos5l_dfrbp_1_6.D 0.10735f
C13838 sg13cmos5l_a221oi_1_0.A2 sg13cmos5l_dlhr_1_2.Q 0.0023f
C13839 a_17961_8793# a_18568_7010# 0
C13840 sg13cmos5l_dfrbp_1_21.Q a_17399_3947# 0
C13841 a_5416_9224# sg13cmos5l_buf_1_78.A 0
C13842 sg13cmos5l_buf_1_76.X a_6184_9224# 0.00689f
C13843 sg13cmos5l_buf_1_73.X a_5800_9224# 0.33469f
C13844 sg13cmos5l_inv_1_7.A a_11460_2392# 0.01072f
C13845 sg13cmos5l_dfrbp_1_15.D a_1846_7850# 0.00434f
C13846 a_9558_6144# VPWR 0.25157f
C13847 sg13cmos5l_buf_1_45.X a_8392_3270# 0.04331f
C13848 sg13cmos5l_dlhr_1_9.D sg13cmos5l_dlhr_1_1.Q_N 0.00281f
C13849 sg13cmos5l_buf_1_40.A a_1846_7850# 0.00362f
C13850 sg13cmos5l_buf_1_31.X a_1760_1758# 0
C13851 VPWR ph_sw[4] 0.28974f
C13852 sg13cmos5l_dfrbp_1_1.Q a_13284_3456# 0.028f
C13853 a_13775_6239# sg13cmos5l_dfrbp_1_23.Q_N 0.05028f
C13854 a_14032_6382# a_13681_6239# 0.01017f
C13855 sg13cmos5l_dfrbp_1_0.RESET_B a_13701_3117# 0.06075f
C13856 a_4244_6924# sg13cmos5l_buf_1_59.A 0
C13857 a_4425_7281# a_4660_7312# 0.00566f
C13858 sg13cmos5l_buf_1_30.A a_7216_6382# 0.03486f
C13859 a_12516_6480# sg13cmos5l_inv_1_0.A 0
C13860 sg13cmos5l_dfrbp_1_16.Q a_5452_5850# 0.01036f
C13861 sg13cmos5l_a221oi_1_0.A2 a_10230_4632# 0.00484f
C13862 sg13cmos5l_or2_1_0.A sg13cmos5l_buf_1_26.A 0
C13863 sg13cmos5l_dlhr_1_21.Q_N ph_sw[5] 0.01457f
C13864 sg13cmos5l_buf_1_30.A a_7336_7010# 0.00415f
C13865 sg13cmos5l_buf_1_24.A a_5820_5773# 0.01541f
C13866 sg13cmos5l_buf_1_19.X a_18928_1846# 0
C13867 a_12815_1703# VPWR 0.258f
C13868 sg13cmos5l_dfrbp_1_0.D sg13cmos5l_dfrbp_1_0.RESET_B 0.32605f
C13869 a_15466_2356# nh_sw[7] 0.01596f
C13870 sg13cmos5l_nand2_1_1.B sg13cmos5l_a22oi_1_1.A1 0.1266f
C13871 sg13cmos5l_o21ai_1_0.A1 a_12022_3134# 0.09918f
C13872 a_10288_8678# sg13cmos5l_dfrbp_1_20.Q 0
C13873 a_17896_9224# VPWR 0.25101f
C13874 sg13cmos5l_inv_1_2.A sg13cmos5l_buf_1_4.A 0.023f
C13875 a_2667_3911# a_3313_4261# 0.00667f
C13876 sg13cmos5l_buf_1_5.A VPWR 1.00524f
C13877 sg13cmos5l_buf_1_46.A sg13cmos5l_or2_1_0.A 0.0879f
C13878 a_20008_8436# sg13cmos5l_inv_1_6.A 0.33665f
C13879 sg13cmos5l_buf_1_5.A nl_sw[7] 0
C13880 sg13cmos5l_dfrbp_1_6.D a_682_5380# 0.02038f
C13881 a_12490_6385# a_12516_6480# 0.43042f
C13882 sg13cmos5l_dfrbp_1_23.CLK a_15782_7362# 0
C13883 sg13cmos5l_dlhr_1_5.GATE a_8390_6924# 0
C13884 a_424_8436# a_620_7638# 0.00183f
C13885 sg13cmos5l_dfrbp_1_6.RESET_B a_4847_4727# 0.03207f
C13886 a_17414_3138# a_17988_3151# 0.36169f
C13887 sg13cmos5l_dfrbp_1_10.Q_N sg13cmos5l_inv_1_19.A 0
C13888 sg13cmos5l_buf_8_0.X a_20204_5376# 0.02046f
C13889 sg13cmos5l_buf_1_25.X a_7441_1618# 0
C13890 a_16011_2399# a_16936_1758# 0.00193f
C13891 sg13cmos5l_buf_1_78.A a_7504_8678# 0
C13892 a_16551_3987# a_16751_2749# 0
C13893 a_16703_3871# a_16011_2399# 0.00236f
C13894 a_8392_3270# a_8204_2352# 0
C13895 sg13cmos5l_dfrbp_1_6.D sg13cmos5l_dfrbp_1_10.Q 0.50904f
C13896 a_1065_6971# VPWR 0
C13897 a_17367_8794# ph_sw[9] 0
C13898 sg13cmos5l_inv_1_6.A a_20488_4782# 0.00137f
C13899 sg13cmos5l_buf_1_24.A VPWR 0.88731f
C13900 sg13cmos5l_dfrbp_1_8.RESET_B a_7881_8065# 0
C13901 a_19424_7010# VPWR 0.07402f
C13902 sg13cmos5l_dlhr_1_1.GATE a_1878_6337# 0.14062f
C13903 a_1227_6935# a_2224_7166# 0.07046f
C13904 sg13cmos5l_dfrbp_1_6.D sg13cmos5l_and3_1_0.X 0
C13905 a_17386_1849# a_17126_1626# 0.87117f
C13906 sg13cmos5l_nor2_1_0.A a_13017_4023# 0
C13907 sg13cmos5l_inv_1_18.A sg13cmos5l_dfrbp_1_6.RESET_B 1.56788f
C13908 ph_sw[7] pl_sw[8] 0.58978f
C13909 pl_sw[7] ph_sw[8] 0.44097f
C13910 sg13cmos5l_dfrbp_1_6.D a_18097_7666# 0
C13911 sg13cmos5l_buf_1_60.X sg13cmos5l_inv_1_17.A 0.04052f
C13912 a_7034_3148# a_7430_3576# 0.00949f
C13913 a_15466_2356# a_15357_1816# 0
C13914 sg13cmos5l_dfrbp_1_6.D a_5673_3138# 0.00959f
C13915 a_2732_1590# a_3008_1758# 0.00624f
C13916 sg13cmos5l_buf_1_43.A a_424_3270# 0.01524f
C13917 sg13cmos5l_inv_1_18.A a_10412_6126# 0
C13918 sg13cmos5l_inv_1_26.Y a_17894_8436# 0
C13919 sg13cmos5l_dlhr_1_9.Q sg13cmos5l_dlhr_1_1.GATE 0.02247f
C13920 sg13cmos5l_buf_1_111.A sg13cmos5l_buf_1_86.A 0
C13921 sg13cmos5l_buf_1_57.X a_12980_6924# 0
C13922 sg13cmos5l_inv_1_18.A a_10071_7282# 0
C13923 sg13cmos5l_a22oi_1_0.Y sg13cmos5l_dfrbp_1_2.D 0.53765f
C13924 a_16068_6162# VPWR 0
C13925 a_5194_2356# a_5220_2392# 0.43042f
C13926 a_8570_6172# a_8852_6484# 0.68988f
C13927 sg13cmos5l_inv_1_2.A sg13cmos5l_dfrbp_1_23.CLK 0.02838f
C13928 sg13cmos5l_nor2_1_0.A a_10696_1758# 0.00343f
C13929 a_9705_4650# sg13cmos5l_nand2_1_1.B 0.01094f
C13930 sg13cmos5l_buf_1_30.A a_5796_3904# 0.00781f
C13931 a_16268_1590# a_16552_1664# 0.13542f
C13932 sg13cmos5l_a221oi_1_0.C1 a_11973_3911# 0
C13933 a_16724_8436# cks 0.02917f
C13934 sg13cmos5l_buf_1_5.A a_12698_7288# 0.00544f
C13935 sg13cmos5l_inv_1_26.Y sg13cmos5l_buf_1_105.A 0
C13936 sg13cmos5l_dfrbp_1_6.D ckc 0.00834f
C13937 sg13cmos5l_dfrbp_1_6.RESET_B a_3669_6320# 0
C13938 sg13cmos5l_a22oi_1_1.Y a_15702_4187# 0.01085f
C13939 sg13cmos5l_nand2_1_1.B nh_sw[8] 0
C13940 a_16144_8678# sg13cmos5l_dfrbp_1_25.Q_N 0.15881f
C13941 a_15147_8447# sg13cmos5l_dfrbp_1_22.D 0.00381f
C13942 sg13cmos5l_dlhr_1_0.GATE a_6889_1680# 0.04794f
C13943 sg13cmos5l_inv_1_3.A a_13775_6239# 0.02689f
C13944 sg13cmos5l_buf_1_57.X a_9033_6162# 0.00398f
C13945 a_18760_2388# VPWR 0.25162f
C13946 sg13cmos5l_inv_1_8.A sg13cmos5l_dfrbp_1_17.D 0
C13947 sg13cmos5l_buf_1_79.X a_8783_7751# 0
C13948 sg13cmos5l_dfrbp_1_12.Q_N a_8588_3864# 0.00358f
C13949 sg13cmos5l_dfrbp_1_23.Q VPWR 0.46769f
C13950 sg13cmos5l_buf_1_86.A a_20392_6924# 0.32476f
C13951 a_17751_7690# sg13cmos5l_dfrbp_1_21.Q_N 0
C13952 sg13cmos5l_buf_1_59.A cks 0
C13953 a_416_7806# a_422_7362# 0
C13954 sg13cmos5l_dfrbp_1_10.Q_N sg13cmos5l_buf_1_33.A 0
C13955 sg13cmos5l_inv_1_0.A a_9524_4972# 0
C13956 a_15784_9224# ph_sw[7] 0
C13957 sg13cmos5l_dfrbp_1_8.RESET_B a_2348_7624# 0.01881f
C13958 sg13cmos5l_buf_1_6.A a_14056_1664# 0
C13959 a_11973_1605# a_12815_1703# 0.00437f
C13960 a_11556_1944# a_13072_1846# 0.00294f
C13961 a_16234_6385# a_15974_6162# 0.87117f
C13962 a_19508_1924# VPWR 0.35758f
C13963 sg13cmos5l_buf_1_38.A sg13cmos5l_dlhr_1_3.Q_N 0.00113f
C13964 sg13cmos5l_inv_1_28.Y sg13cmos5l_dlhr_1_21.Q_N 0.01783f
C13965 a_5702_8874# a_5796_8874# 0.00718f
C13966 a_13593_9501# sg13cmos5l_dlhr_1_11.Q 0
C13967 a_1463_8511# VPWR 0.09468f
C13968 sg13cmos5l_inv_1_7.A a_11979_2399# 0.00728f
C13969 a_20008_7712# cko 0.00136f
C13970 sg13cmos5l_dfrbp_1_15.D a_1480_7806# 0
C13971 a_13460_7996# VPWR 0.10681f
C13972 a_3588_4968# VPWR 0.07223f
C13973 sg13cmos5l_buf_1_40.X sg13cmos5l_buf_1_37.A 0
C13974 sg13cmos5l_buf_1_31.X a_7689_1626# 0
C13975 a_11973_3911# sg13cmos5l_o21ai_1_0.B1 0.00389f
C13976 sg13cmos5l_buf_1_40.A a_1480_7806# 0.04465f
C13977 sg13cmos5l_dfrbp_1_1.Q a_15380_3436# 0
C13978 sg13cmos5l_dfrbp_1_16.Q a_8439_6178# 0.0036f
C13979 sg13cmos5l_nand2_1_0.A a_15466_2356# 0
C13980 a_18870_7656# ph_sw[9] 0.00112f
C13981 sg13cmos5l_dfrbp_1_0.RESET_B a_15884_3102# 0.01443f
C13982 sg13cmos5l_dfrbp_1_16.Q a_5951_5383# 0.01285f
C13983 sg13cmos5l_dfrbp_1_6.RESET_B a_2554_8112# 0
C13984 sg13cmos5l_buf_8_2.X a_19904_7806# 0.06077f
C13985 sg13cmos5l_buf_1_24.A sg13cmos5l_dfrbp_1_11.Q 0.14164f
C13986 sg13cmos5l_dfrbp_1_1.D a_9544_2474# 0
C13987 a_15784_1664# VPWR 0.26292f
C13988 a_15784_1664# nl_sw[7] 0.00219f
C13989 a_12549_9165# a_12404_7972# 0.00285f
C13990 a_14814_4292# VPWR 0
C13991 sg13cmos5l_inv_1_29.Y sg13cmos5l_nor2b_1_0.Y 0.14761f
C13992 a_15780_2813# nh_sw[7] 0
C13993 a_4244_3900# a_5132_3864# 0.00145f
C13994 a_3407_4261# sg13cmos5l_buf_1_38.A 0.00375f
C13995 sg13cmos5l_dfrbp_1_17.D a_1948_7964# 0.00122f
C13996 a_16751_2749# a_17170_2826# 0.00176f
C13997 sg13cmos5l_dfrbp_1_8.RESET_B pl_sw[4] 0.0025f
C13998 sg13cmos5l_buf_1_77.A sg13cmos5l_dfrbp_1_8.RESET_B 0.08919f
C13999 sg13cmos5l_a22oi_1_1.B1 a_13234_4338# 0
C14000 sg13cmos5l_buf_1_26.X sg13cmos5l_buf_1_30.X 0.21913f
C14001 a_13686_7354# sg13cmos5l_dlhr_1_11.Q_N 0.12876f
C14002 sg13cmos5l_dlhr_1_5.GATE sg13cmos5l_buf_1_29.A 0
C14003 sg13cmos5l_dfrbp_1_8.D a_17337_4965# 0.00272f
C14004 a_12516_6480# a_13775_6239# 0.01741f
C14005 sg13cmos5l_dfrbp_1_8.RESET_B a_5926_6175# 0
C14006 sg13cmos5l_or2_1_0.A sg13cmos5l_nand2_1_1.B 0.04901f
C14007 a_5988_8440# cks 0.00999f
C14008 sg13cmos5l_buf_1_3.X a_20392_3176# 0.33998f
C14009 sg13cmos5l_dfrbp_1_6.RESET_B sg13cmos5l_dfrbp_1_14.Q_N 0.00904f
C14010 sg13cmos5l_buf_1_26.X a_8680_1664# 0.01281f
C14011 a_8247_5770# a_8468_4948# 0.0071f
C14012 a_8378_5776# a_7631_4727# 0
C14013 sg13cmos5l_buf_1_44.X a_6380_7638# 0
C14014 sg13cmos5l_or2_1_0.A a_7497_3138# 0.00326f
C14015 sg13cmos5l_dfrbp_1_8.RESET_B a_8457_7281# 0.00351f
C14016 a_12520_4782# sg13cmos5l_dfrbp_1_1.Q 0
C14017 sg13cmos5l_nand2_1_0.B a_12075_3911# 0
C14018 a_2148_3904# a_3407_4261# 0.01741f
C14019 a_2565_3911# a_3664_4142# 0
C14020 a_13520_4696# sg13cmos5l_a22oi_1_1.B1 0
C14021 sg13cmos5l_nand2_1_0.A a_10331_1924# 0
C14022 sg13cmos5l_buf_1_74.X sg13cmos5l_dfrbp_1_8.RESET_B 0.00243f
C14023 sg13cmos5l_buf_1_30.A sg13cmos5l_dlhr_1_0.Q 0.00363f
C14024 sg13cmos5l_a22oi_1_1.B1 a_11530_3868# 0.01488f
C14025 sg13cmos5l_buf_1_57.X a_16779_6284# 0
C14026 a_20672_4782# d_out[1] 0
C14027 a_1280_6294# VPWR 0.06706f
C14028 sg13cmos5l_buf_1_8.A a_14476_2388# 0
C14029 sg13cmos5l_dlhr_1_1.GATE a_2727_6380# 0.00187f
C14030 a_13178_7684# a_12980_6924# 0
C14031 a_12841_7728# a_13161_7281# 0
C14032 a_17126_1626# a_17220_1626# 0.00718f
C14033 a_17829_1605# a_17931_1748# 0.66105f
C14034 sg13cmos5l_a22oi_1_0.B1 a_10331_3900# 0.00777f
C14035 a_19136_9318# pl_sw[9] 0
C14036 a_17493_3947# a_17399_3947# 0.87117f
C14037 sg13cmos5l_dlhr_1_5.GATE a_4950_5699# 0.13205f
C14038 a_17674_3361# a_17414_3138# 0.87117f
C14039 sg13cmos5l_buf_1_97.A sg13cmos5l_buf_1_5.A 0
C14040 sg13cmos5l_buf_1_8.A a_13234_1626# 0
C14041 sg13cmos5l_dfrbp_1_6.D sg13cmos5l_dlhr_1_2.D 0
C14042 a_3008_1758# nl_sw[2] 0
C14043 sg13cmos5l_dfrbp_1_10.Q a_5425_3130# 0
C14044 sg13cmos5l_dfrbp_1_0.Q a_14900_2352# 0.10274f
C14045 sg13cmos5l_buf_1_57.X a_14089_7282# 0.00165f
C14046 a_7316_3460# a_7316_2388# 0
C14047 a_7497_3138# a_7820_2352# 0
C14048 sg13cmos5l_dlhr_1_15.D a_16233_5041# 0
C14049 sg13cmos5l_dfrbp_1_6.D a_4566_2818# 0.04666f
C14050 sg13cmos5l_a22oi_1_2.B2 a_10464_2427# 0.00622f
C14051 a_17425_6239# VPWR 0.00103f
C14052 sg13cmos5l_buf_1_110.A a_15974_6162# 0.01058f
C14053 a_5220_2392# a_5739_2399# 0.38871f
C14054 a_5637_2399# a_5508_2813# 0.01562f
C14055 sg13cmos5l_dlhr_1_15.D sg13cmos5l_dfrbp_1_0.CLK 0
C14056 a_10028_6126# sg13cmos5l_buf_1_56.A 0.31703f
C14057 sg13cmos5l_or2_1_0.A a_3407_4261# 0.0026f
C14058 sg13cmos5l_buf_1_46.A sg13cmos5l_dfrbp_1_2.D 0.02497f
C14059 sg13cmos5l_buf_1_30.A a_7055_4261# 0.02504f
C14060 a_5452_5850# a_4847_4727# 0.00446f
C14061 a_5069_5376# a_5104_4870# 0.00446f
C14062 sg13cmos5l_buf_1_5.A sg13cmos5l_dlhr_1_11.Q_N 0.00186f
C14063 sg13cmos5l_a22oi_1_1.A1 a_18117_3117# 0
C14064 sg13cmos5l_dfrbp_1_1.Q sg13cmos5l_buf_1_19.X 0.0051f
C14065 sg13cmos5l_buf_1_31.X a_9865_7282# 0.0029f
C14066 sg13cmos5l_buf_1_65.X a_5600_8522# 0
C14067 sg13cmos5l_dfrbp_1_6.RESET_B a_5674_6385# 0.33546f
C14068 sg13cmos5l_a22oi_1_1.Y a_16462_4338# 0
C14069 sg13cmos5l_inv_1_14.A sg13cmos5l_buf_1_29.A 0
C14070 a_6198_3120# a_7316_3460# 0
C14071 sg13cmos5l_dfrbp_1_6.RESET_B a_3308_5376# 0
C14072 sg13cmos5l_dfrbp_1_25.Q_N sg13cmos5l_dfrbp_1_22.D 0.00179f
C14073 sg13cmos5l_dfrbp_1_6.D a_2757_3117# 0.005f
C14074 sg13cmos5l_and3_1_0.C nh_sw[7] 0
C14075 sg13cmos5l_buf_1_8.A a_11270_1626# 0.0081f
C14076 a_17132_9150# pl_sw[9] 0.00231f
C14077 a_10318_5412# a_10230_4632# 0
C14078 sg13cmos5l_buf_1_79.X sg13cmos5l_dfrbp_1_20.Q 0
C14079 a_5210_3148# a_5220_2392# 0.00753f
C14080 a_9242_4660# a_9524_4972# 0.68988f
C14081 a_524_4614# sg13cmos5l_nor2_1_2.A 0.00449f
C14082 sg13cmos5l_dfrbp_1_6.RESET_B sg13cmos5l_buf_1_95.X 0
C14083 sg13cmos5l_dfrbp_1_8.RESET_B sg13cmos5l_buf_1_58.A 0.00205f
C14084 sg13cmos5l_dlhr_1_11.Q sg13cmos5l_inv_1_29.A 0
C14085 sg13cmos5l_buf_1_5.A a_13047_7690# 0.04734f
C14086 sg13cmos5l_buf_1_37.A sg13cmos5l_buf_1_39.A 0
C14087 sg13cmos5l_buf_1_44.X a_3302_4650# 0
C14088 sg13cmos5l_o21ai_1_0.Y a_12721_1703# 0
C14089 a_15974_6162# a_17519_6239# 0
C14090 sg13cmos5l_dfrbp_1_0.Q_N VPWR 0.17829f
C14091 a_5416_9224# cks 0
C14092 a_13017_4023# sg13cmos5l_o21ai_1_0.Y 0
C14093 sg13cmos5l_o21ai_1_0.B1 a_12998_3138# 0.00746f
C14094 sg13cmos5l_buf_1_38.A a_3974_2388# 0
C14095 sg13cmos5l_dfrbp_1_1.Q a_15466_2356# 0.00577f
C14096 a_5702_8874# a_6276_8861# 0.36169f
C14097 sg13cmos5l_dfrbp_1_0.RESET_B a_15492_2392# 0.50844f
C14098 sg13cmos5l_inv_1_7.A sg13cmos5l_dfrbp_1_4.Q_N 0.00795f
C14099 sg13cmos5l_or2_1_0.A sg13cmos5l_a22oi_1_1.A1 0.13351f
C14100 sg13cmos5l_buf_1_73.A a_7863_7282# 0.00153f
C14101 a_3396_4650# VPWR 0
C14102 a_13035_6284# sg13cmos5l_and3_1_0.X 0.00121f
C14103 VPWR ph_sw[5] 0.27199f
C14104 sg13cmos5l_buf_1_5.A a_14056_1664# 0.03376f
C14105 sg13cmos5l_dfrbp_1_17.D a_708_6928# 0
C14106 sg13cmos5l_dfrbp_1_16.Q sg13cmos5l_buf_1_56.A 0
C14107 sg13cmos5l_buf_1_32.X nh_sw[0] 0
C14108 a_2054_3138# sg13cmos5l_buf_1_35.A 0
C14109 sg13cmos5l_dfrbp_1_6.RESET_B sg13cmos5l_buf_1_39.A 0.0811f
C14110 sg13cmos5l_dfrbp_1_6.D a_1210_4654# 0
C14111 a_15782_7362# a_15592_6200# 0
C14112 a_13297_9263# a_13484_8400# 0
C14113 sg13cmos5l_buf_1_93.X a_14854_8861# 0
C14114 sg13cmos5l_dfrbp_1_6.RESET_B a_4559_7630# 0.0254f
C14115 a_15590_4650# a_16164_4663# 0.36169f
C14116 a_5132_3864# a_5079_3154# 0.00249f
C14117 sg13cmos5l_dfrbp_1_0.RESET_B a_16572_4261# 0.00163f
C14118 a_18959_3215# nh_sw[9] 0
C14119 sg13cmos5l_a22oi_1_2.B2 sg13cmos5l_inv_1_0.A 0
C14120 sg13cmos5l_dfrbp_1_18.Q a_8486_8874# 0.34988f
C14121 a_3313_4261# a_3447_2746# 0
C14122 sg13cmos5l_inv_1_27.Y a_12404_7972# 0
C14123 sg13cmos5l_dfrbp_1_6.D sg13cmos5l_dlygate4sd2_1_0.A 0.00326f
C14124 a_1227_5423# a_2169_5535# 0
C14125 a_12132_9504# cks 0
C14126 a_620_7638# a_1846_7850# 0
C14127 sg13cmos5l_buf_1_96.A sg13cmos5l_dfrbp_1_20.Q 0.01738f
C14128 a_20392_3176# a_20392_2388# 0.00912f
C14129 sg13cmos5l_dfrbp_1_0.CLK sg13cmos5l_o21ai_1_0.A2 0
C14130 a_1662_8374# sg13cmos5l_buf_1_58.A 0.00156f
C14131 a_17008_2630# sg13cmos5l_buf_1_18.X 0
C14132 sg13cmos5l_dfrbp_1_0.Q nl_sw[10] 0.22607f
C14133 a_10288_8678# a_10308_7992# 0
C14134 a_10031_8797# a_10022_7674# 0
C14135 a_14295_7282# a_14426_7288# 0.65127f
C14136 sg13cmos5l_dlhr_1_11.Q_N sg13cmos5l_dfrbp_1_23.Q 0.00287f
C14137 sg13cmos5l_dfrbp_1_1.Q a_12520_3176# 0.00303f
C14138 a_13775_6239# a_14612_6460# 0.1333f
C14139 a_13803_3260# nh_sw[6] 0
C14140 sg13cmos5l_dfrbp_1_6.RESET_B a_15238_7687# 0
C14141 a_7504_8678# cks 0.01239f
C14142 sg13cmos5l_buf_1_3.X a_20200_3270# 0.062f
C14143 sg13cmos5l_buf_1_60.X a_1484_9150# 0.00102f
C14144 a_1864_9224# sg13cmos5l_inv_1_19.A 0.0032f
C14145 a_2732_9150# sg13cmos5l_buf_1_61.X 0.29859f
C14146 a_8041_5770# sg13cmos5l_dfrbp_1_12.Q_N 0
C14147 sg13cmos5l_a221oi_1_0.A2 a_7537_4727# 0.00487f
C14148 a_14583_5770# sg13cmos5l_nand2_1_1.A 0
C14149 sg13cmos5l_or2_1_0.A a_7248_3460# 0
C14150 sg13cmos5l_inv_1_27.Y sg13cmos5l_buf_1_94.X 0
C14151 sg13cmos5l_inv_1_3.A sg13cmos5l_buf_1_93.X 0.1118f
C14152 a_2148_3904# sg13cmos5l_buf_1_38.A 0
C14153 sg13cmos5l_nand2_1_0.B a_11913_3947# 0
C14154 sg13cmos5l_nand2_1_0.A a_12075_1748# 0
C14155 sg13cmos5l_nor2_1_1.A a_16953_2511# 0.00114f
C14156 sg13cmos5l_dfrbp_1_6.D a_516_5850# 0
C14157 sg13cmos5l_buf_1_57.X a_16548_6175# 0
C14158 a_1121_4166# ckc 0
C14159 a_19412_6484# a_19734_5842# 0
C14160 a_3575_6553# VPWR 0.92816f
C14161 sg13cmos5l_dfrbp_1_10.Q sg13cmos5l_buf_1_9.A 0
C14162 sg13cmos5l_dlhr_1_1.GATE a_3530_6320# 0
C14163 a_17126_1626# a_17700_1639# 0.36169f
C14164 a_9705_4650# sg13cmos5l_or2_1_0.A 0
C14165 sg13cmos5l_dlhr_1_1.GATE a_1227_5423# 0.03126f
C14166 a_2224_7166# sg13cmos5l_dfrbp_1_15.Q_N 0
C14167 a_1873_7285# a_1997_6126# 0
C14168 sg13cmos5l_inv_1_27.Y a_14632_9224# 0.33093f
C14169 a_14228_9484# sg13cmos5l_inv_1_3.A 0
C14170 a_2122_3868# a_2565_3911# 0.02241f
C14171 sg13cmos5l_dfrbp_1_23.CLK a_14889_7281# 0.00137f
C14172 sg13cmos5l_nand2_1_0.B a_11973_3911# 0
C14173 sg13cmos5l_inv_1_20.Y a_3625_7282# 0.07505f
C14174 a_20392_6924# a_20288_7010# 0.00624f
C14175 a_17700_3456# a_18219_3260# 0.38902f
C14176 a_17414_3138# a_18057_3529# 0.00806f
C14177 sg13cmos5l_dlhr_1_5.GATE a_5710_5850# 0.00238f
C14178 sg13cmos5l_buf_1_29.A sg13cmos5l_buf_1_45.A 0
C14179 sg13cmos5l_dfrbp_1_8.RESET_B sg13cmos5l_buf_1_10.A 0.00984f
C14180 sg13cmos5l_buf_1_34.X nh_sw[3] 0
C14181 cks frame 0.00714f
C14182 sg13cmos5l_dfrbp_1_6.D a_18793_6216# 0
C14183 sg13cmos5l_or2_1_0.A nh_sw[8] 0.0029f
C14184 sg13cmos5l_buf_1_73.X a_6405_8447# 0.00269f
C14185 a_7316_3460# sg13cmos5l_dlhr_1_0.D 0
C14186 a_11913_3947# nl_sw[6] 0
C14187 sg13cmos5l_inv_1_26.Y a_17545_7728# 0
C14188 a_13047_7690# a_13460_7996# 0.15652f
C14189 sg13cmos5l_dfrbp_1_10.Q a_5739_2399# 0
C14190 a_4934_2826# sg13cmos5l_dlhr_1_0.D 0
C14191 a_5220_2392# a_6385_2749# 0.4858f
C14192 a_5739_2399# a_6736_2630# 0.07046f
C14193 a_11182_4948# VPWR 0.29932f
C14194 sg13cmos5l_or2_1_0.A sg13cmos5l_buf_1_38.A 0.76355f
C14195 sg13cmos5l_buf_1_24.A sg13cmos5l_buf_1_25.X 0
C14196 sg13cmos5l_dfrbp_1_8.RESET_B a_15702_5842# 0.00631f
C14197 sg13cmos5l_buf_1_1.A a_17829_1605# 0
C14198 a_2565_8447# sg13cmos5l_buf_1_61.X 0.00161f
C14199 sg13cmos5l_buf_1_30.A a_7257_4023# 0
C14200 a_5069_5376# sg13cmos5l_dlhr_1_0.GATE 0
C14201 sg13cmos5l_buf_1_64.A a_4349_7636# 0
C14202 sg13cmos5l_dfrbp_1_2.D sg13cmos5l_nand2_1_1.B 0.0236f
C14203 a_16724_8436# pl_sw[9] 0
C14204 a_16940_3102# sg13cmos5l_nor2_1_1.A 0
C14205 a_17896_9224# ph_sw[9] 0.00129f
C14206 a_7095_1642# nl_sw[4] 0
C14207 a_524_4614# a_424_3270# 0
C14208 a_16160_9318# pl_sw[7] 0
C14209 sg13cmos5l_buf_1_87.A cks 0.31281f
C14210 sg13cmos5l_a22oi_1_1.Y a_17399_3947# 0.03735f
C14211 sg13cmos5l_dfrbp_1_6.D a_15782_7362# 0.01147f
C14212 sg13cmos5l_dfrbp_1_6.RESET_B sg13cmos5l_buf_1_43.A 0.00392f
C14213 a_11973_3911# nl_sw[6] 0
C14214 sg13cmos5l_buf_1_57.X sg13cmos5l_dlhr_1_14.Q_N 0.02529f
C14215 a_14543_3215# a_14900_2352# 0
C14216 sg13cmos5l_buf_1_8.A a_13072_1846# 0.00412f
C14217 a_3688_1664# a_4172_1590# 0.03472f
C14218 sg13cmos5l_or2_1_0.A a_2148_3904# 0.00677f
C14219 sg13cmos5l_dfrbp_1_10.Q a_5210_3148# 0.01346f
C14220 a_3676_7964# sg13cmos5l_dlhr_1_1.GATE 0
C14221 sg13cmos5l_or2_1_0.A a_18117_3117# 0.00702f
C14222 a_4076_7624# a_4518_7996# 0
C14223 a_4324_7996# a_4282_8112# 0.00949f
C14224 sg13cmos5l_inv_1_18.A a_8439_6178# 0
C14225 sg13cmos5l_dlhr_1_9.D sg13cmos5l_a221oi_1_0.B1 0
C14226 sg13cmos5l_dlhr_1_2.D a_5194_2356# 0
C14227 a_5673_3138# a_5739_2399# 0
C14228 a_10587_4692# sg13cmos5l_inv_1_0.Y 0
C14229 a_18870_7656# a_18860_6888# 0
C14230 a_18345_7674# a_18568_7010# 0
C14231 a_4566_2818# a_5194_2356# 0.00361f
C14232 a_3578_2752# a_3974_2388# 0.00949f
C14233 sg13cmos5l_buf_1_34.A sg13cmos5l_dlhr_1_3.Q_N 0.02282f
C14234 sg13cmos5l_a221oi_1_0.C1 a_11488_4676# 0
C14235 sg13cmos5l_buf_1_3.A cks 0
C14236 a_9673_9240# a_8783_7751# 0
C14237 sg13cmos5l_dfrbp_1_6.RESET_B a_7881_8065# 0
C14238 sg13cmos5l_inv_1_28.Y VPWR 0.42534f
C14239 sg13cmos5l_buf_1_5.A a_13574_8112# 0
C14240 a_1580_2352# VPWR 0.25602f
C14241 a_13072_1846# sg13cmos5l_buf_1_1.A 0
C14242 a_17519_6239# a_17776_6382# 0.35645f
C14243 a_16779_6284# a_16548_6175# 0.15089f
C14244 a_16260_6480# a_17425_6239# 0.4858f
C14245 sg13cmos5l_buf_1_77.X sg13cmos5l_buf_1_77.A 0.03128f
C14246 sg13cmos5l_buf_1_77.X pl_sw[4] 0
C14247 sg13cmos5l_inv_1_2.A a_14436_8874# 0
C14248 sg13cmos5l_o21ai_1_0.B1 a_14800_3358# 0
C14249 a_6214_8861# a_6276_8861# 0
C14250 a_5702_8874# a_6345_8483# 0.00806f
C14251 a_6405_8447# a_7247_8797# 0.0032f
C14252 sg13cmos5l_dfrbp_1_0.RESET_B a_16011_2399# 0.55194f
C14253 a_5210_3148# a_5673_3138# 0.13395f
C14254 a_4873_3192# a_5492_3460# 0.00161f
C14255 a_15531_7796# VPWR 0.20741f
C14256 a_4753_4727# VPWR 0
C14257 sg13cmos5l_a221oi_1_0.A2 sg13cmos5l_buf_1_28.X 0
C14258 sg13cmos5l_buf_1_31.X a_8576_1758# 0
C14259 sg13cmos5l_buf_1_93.X cks 0.0111f
C14260 sg13cmos5l_or2_1_1.B sg13cmos5l_o21ai_1_0.A1 0
C14261 sg13cmos5l_inv_1_7.A a_11473_7751# 0
C14262 sg13cmos5l_dfrbp_1_1.Q a_17386_1849# 0
C14263 sg13cmos5l_inv_1_0.A a_11268_5760# 0.00358f
C14264 sg13cmos5l_a22oi_1_2.B2 a_10420_5412# 0.45334f
C14265 a_11072_5347# a_11771_5412# 0
C14266 sg13cmos5l_buf_1_74.X sg13cmos5l_buf_1_77.X 0.98439f
C14267 sg13cmos5l_buf_1_73.X a_8204_9150# 0
C14268 sg13cmos5l_dfrbp_1_16.Q a_4107_4772# 0
C14269 a_19028_5412# a_19227_4654# 0
C14270 sg13cmos5l_dfrbp_1_0.RESET_B a_16936_1758# 0.00164f
C14271 sg13cmos5l_dfrbp_1_0.D a_18480_5028# 0.17638f
C14272 a_16395_4772# sg13cmos5l_buf_8_1.A 0
C14273 sg13cmos5l_inv_1_2.A sg13cmos5l_dfrbp_1_6.D 0.0336f
C14274 sg13cmos5l_buf_1_93.X a_16306_8874# 0
C14275 sg13cmos5l_dfrbp_1_0.RESET_B a_16703_3871# 0.00144f
C14276 sg13cmos5l_nor2_1_0.A sg13cmos5l_nand2_1_0.A 0.37763f
C14277 sg13cmos5l_dfrbp_1_18.Q a_9060_8861# 0
C14278 sg13cmos5l_buf_1_38.A a_3578_2752# 0.00971f
C14279 sg13cmos5l_buf_1_104.X sg13cmos5l_buf_8_0.X 0
C14280 a_14228_9484# cks 0
C14281 sg13cmos5l_buf_1_30.A a_6741_5459# 0.01769f
C14282 sg13cmos5l_buf_1_76.X sg13cmos5l_buf_1_78.A 0.00234f
C14283 sg13cmos5l_nand2_1_1.B sg13cmos5l_dfrbp_1_7.Q_N 0.00342f
C14284 a_19244_2352# a_19628_2352# 0.00492f
C14285 a_18376_2388# sg13cmos5l_buf_1_18.X 0.29702f
C14286 sg13cmos5l_dfrbp_1_8.RESET_B rdy 0
C14287 a_7336_9224# a_7498_7897# 0
C14288 a_11464_8436# a_10308_7992# 0
C14289 sg13cmos5l_buf_1_31.X VPWR 1.67599f
C14290 sg13cmos5l_dfrbp_1_1.Q a_12075_1748# 0
C14291 sg13cmos5l_buf_1_5.X nh_sw[6] 0.1888f
C14292 a_6346_4873# a_6789_4629# 0.02241f
C14293 a_6086_4650# a_6372_4968# 0.50066f
C14294 a_2565_3911# a_3241_2746# 0
C14295 a_8486_8874# cks 0.01874f
C14296 sg13cmos5l_dfrbp_1_0.RESET_B a_11913_2017# 0
C14297 sg13cmos5l_buf_1_28.X a_10427_2736# 0
C14298 sg13cmos5l_buf_1_97.A ph_sw[5] 0.5328f
C14299 sg13cmos5l_dfrbp_1_6.RESET_B a_2348_7624# 0.14834f
C14300 a_3664_4142# a_3599_3215# 0
C14301 sg13cmos5l_dfrbp_1_6.RESET_B a_5510_4338# 0.11729f
C14302 sg13cmos5l_buf_1_10.A a_11556_3904# 0.04441f
C14303 a_1997_6126# sg13cmos5l_dlhr_1_1.Q 0
C14304 sg13cmos5l_buf_1_18.X a_18928_1846# 0
C14305 sg13cmos5l_or2_1_0.A a_7820_2352# 0
C14306 sg13cmos5l_buf_1_34.X sg13cmos5l_buf_1_59.A 0.20976f
C14307 sg13cmos5l_nand2_1_0.A a_14440_1664# 0
C14308 sg13cmos5l_inv_1_18.A nh_sw[4] 0.05408f
C14309 sg13cmos5l_o21ai_1_0.A1 a_11270_1626# 0
C14310 sg13cmos5l_dlhr_1_15.D sg13cmos5l_buf_1_29.A 0
C14311 sg13cmos5l_inv_1_26.Y VPWR 0.46304f
C14312 a_15177_5769# a_15590_4650# 0
C14313 a_15702_5842# a_15850_4873# 0.00624f
C14314 sg13cmos5l_dlhr_1_15.D a_10665_7281# 0.0014f
C14315 a_20012_1590# a_20296_1664# 0.13542f
C14316 sg13cmos5l_buf_1_18.A sg13cmos5l_buf_8_1.A 0
C14317 a_20008_8436# sg13cmos5l_buf_1_104.X 0.13137f
C14318 a_2122_3868# a_2314_3361# 0
C14319 sg13cmos5l_dlhr_1_5.GATE a_9558_6144# 0
C14320 a_2804_5412# VPWR 0.3587f
C14321 sg13cmos5l_dfrbp_1_16.Q a_2879_6432# 0.01586f
C14322 a_2804_6924# a_2748_6126# 0
C14323 sg13cmos5l_buf_1_25.A a_7508_1948# 0
C14324 sg13cmos5l_buf_1_64.A sg13cmos5l_inv_1_8.A 0
C14325 a_17367_8794# sg13cmos5l_dlhr_1_15.D 0.00259f
C14326 a_1484_6126# a_1280_6294# 0.03376f
C14327 sg13cmos5l_and3_1_0.C sg13cmos5l_dfrbp_1_1.Q 0
C14328 sg13cmos5l_or2_1_0.A a_5424_3460# 0
C14329 sg13cmos5l_dlygate4sd3_1_0.X a_1158_3142# 0.00168f
C14330 sg13cmos5l_dfrbp_1_6.D a_17938_6162# 0
C14331 sg13cmos5l_dfrbp_1_16.Q a_10433_4248# 0
C14332 sg13cmos5l_buf_1_73.X a_7247_8797# 0.00257f
C14333 a_15500_9150# VPWR 0.24835f
C14334 sg13cmos5l_or2_1_0.A a_3578_2752# 0
C14335 sg13cmos5l_dfrbp_1_8.D a_18409_5770# 0.06299f
C14336 a_13047_7690# a_13393_7666# 0.00722f
C14337 a_13460_7996# a_13574_8112# 0.00122f
C14338 a_6736_2630# a_6385_2749# 0.01017f
C14339 a_1862_8874# cks 0.01813f
C14340 a_4005_4629# a_4107_4772# 0.66105f
C14341 sg13cmos5l_dlhr_1_10.Q VPWR 0.41535f
C14342 a_14900_2352# a_15206_2826# 0.0142f
C14343 sg13cmos5l_buf_1_4.A a_15684_4650# 0
C14344 a_5799_5499# sg13cmos5l_dlhr_1_0.GATE 0
C14345 sg13cmos5l_buf_1_77.A sg13cmos5l_dfrbp_1_6.RESET_B 0.60264f
C14346 sg13cmos5l_inv_1_17.A sg13cmos5l_dlhr_1_1.GATE 0.02135f
C14347 a_1125_6935# VPWR 0.25239f
C14348 a_2732_9150# a_3308_9150# 0.00319f
C14349 a_2248_9224# sg13cmos5l_buf_1_65.X 0.00557f
C14350 a_1006_4167# sg13cmos5l_dlygate4sd3_1_0.X 0.1979f
C14351 a_9164_1590# nl_sw[4] 0
C14352 a_11846_9186# a_12489_9577# 0.00806f
C14353 a_11072_5347# sg13cmos5l_or2_1_0.A 0
C14354 a_12132_9504# a_12651_9308# 0.38902f
C14355 sg13cmos5l_dfrbp_1_6.RESET_B a_5926_6175# 0
C14356 sg13cmos5l_dfrbp_1_6.D a_16294_7349# 0
C14357 a_9033_6162# a_8841_5769# 0.00895f
C14358 a_8852_6484# a_8660_5412# 0
C14359 a_2409_4650# a_2122_3868# 0
C14360 a_1946_4660# a_2148_3904# 0
C14361 sg13cmos5l_or2_1_0.A a_1672_3176# 0.00422f
C14362 sg13cmos5l_buf_1_57.X a_15012_7992# 0.00461f
C14363 sg13cmos5l_dfrbp_1_22.D ph_sw[8] 0
C14364 sg13cmos5l_dfrbp_1_6.RESET_B a_8457_7281# 0.4757f
C14365 sg13cmos5l_buf_1_33.A a_3496_1758# 0.00785f
C14366 sg13cmos5l_dfrbp_1_11.Q a_8796_5814# 0
C14367 a_3212_1590# VPWR 0.25633f
C14368 a_4349_7636# VPWR 0.18273f
C14369 a_13593_9501# pl_sw[6] 0
C14370 a_4840_1664# nl_sw[2] 0
C14371 sg13cmos5l_inv_1_18.A sg13cmos5l_buf_1_56.A 0.17017f
C14372 sg13cmos5l_dfrbp_1_10.Q sg13cmos5l_dlhr_1_4.Q_N 0.00842f
C14373 sg13cmos5l_dlhr_1_2.D a_5739_2399# 0
C14374 sg13cmos5l_dlhr_1_15.D sg13cmos5l_buf_1_2.A 0.00428f
C14375 sg13cmos5l_buf_1_74.X sg13cmos5l_dfrbp_1_6.RESET_B 0
C14376 sg13cmos5l_dlygate4sd2_1_0.A a_1121_4166# 0.03587f
C14377 sg13cmos5l_dfrbp_1_10.Q a_4041_2745# 0
C14378 a_9705_4650# sg13cmos5l_dfrbp_1_2.D 0
C14379 sg13cmos5l_dfrbp_1_6.RESET_B a_8985_7989# 0.00343f
C14380 a_3407_8797# a_3488_7010# 0
C14381 a_17776_6382# sg13cmos5l_dfrbp_1_21.Q_N 0.16215f
C14382 a_16268_1590# sg13cmos5l_buf_1_1.A 0.32703f
C14383 sg13cmos5l_inv_1_2.A a_15147_8447# 0.02834f
C14384 sg13cmos5l_dlhr_1_5.GATE sg13cmos5l_buf_1_24.A 0.16109f
C14385 sg13cmos5l_dfrbp_1_1.Q a_15849_2435# 0
C14386 a_8982_7354# a_9344_7010# 0.04055f
C14387 sg13cmos5l_buf_1_34.X a_5132_3864# 0.00108f
C14388 sg13cmos5l_buf_1_31.X sg13cmos5l_dfrbp_1_11.Q 0
C14389 sg13cmos5l_or2_1_0.A sg13cmos5l_dlygate4sd2_1_0.X 0.03396f
C14390 a_7631_4727# sg13cmos5l_dfrbp_1_10.Q 0
C14391 sg13cmos5l_buf_8_1.A sg13cmos5l_buf_1_0.A 0
C14392 a_6507_8447# a_7153_8797# 0.00667f
C14393 sg13cmos5l_dfrbp_1_0.RESET_B sg13cmos5l_dfrbp_1_5.Q_N 0.00917f
C14394 sg13cmos5l_inv_1_14.A ph_sw[4] 0.00525f
C14395 sg13cmos5l_inv_1_27.Y a_14032_6382# 0
C14396 a_15300_7687# VPWR 0.00674f
C14397 a_5673_3138# sg13cmos5l_dlhr_1_4.Q_N 0.00294f
C14398 sg13cmos5l_nor2_1_0.A sg13cmos5l_dfrbp_1_1.Q 0.18748f
C14399 sg13cmos5l_dfrbp_1_10.Q a_2340_3456# 0
C14400 sg13cmos5l_a221oi_1_0.C1 VPWR 0.76438f
C14401 sg13cmos5l_dfrbp_1_16.Q a_5104_4870# 0
C14402 a_1946_4660# sg13cmos5l_or2_1_0.A 0
C14403 sg13cmos5l_buf_1_24.A a_5684_4948# 0
C14404 sg13cmos5l_dfrbp_1_0.RESET_B a_18671_1703# 0.20037f
C14405 a_3447_2746# a_3860_2388# 0.15652f
C14406 a_3308_9150# a_2565_8447# 0.00532f
C14407 sg13cmos5l_buf_1_65.X a_2148_8440# 0.00322f
C14408 sg13cmos5l_buf_1_110.A ph_sw[7] 0
C14409 a_12075_3911# a_12625_2749# 0
C14410 sg13cmos5l_dfrbp_1_2.Q_N sg13cmos5l_buf_1_7.A 0
C14411 sg13cmos5l_dfrbp_1_0.RESET_B a_18363_4270# 0.01089f
C14412 sg13cmos5l_dfrbp_1_8.RESET_B sg13cmos5l_buf_1_44.A 0.00749f
C14413 a_5674_6385# a_5951_5383# 0
C14414 sg13cmos5l_dfrbp_1_18.Q a_9129_8483# 0
C14415 a_6086_4650# sg13cmos5l_dlhr_1_2.D 0
C14416 sg13cmos5l_buf_1_38.A sg13cmos5l_buf_1_34.A 0.05903f
C14417 sg13cmos5l_inv_1_28.Y sg13cmos5l_buf_1_97.A 0.17554f
C14418 sg13cmos5l_dlhr_1_11.GATE a_12980_6924# 0.00266f
C14419 sg13cmos5l_buf_1_30.A sg13cmos5l_a221oi_1_0.A2 0.08221f
C14420 sg13cmos5l_buf_1_18.A cko 0
C14421 sg13cmos5l_buf_1_10.A a_12896_3270# 0.00117f
C14422 a_11848_8436# a_11567_7751# 0.0027f
C14423 sg13cmos5l_dfrbp_1_0.CLK a_11460_2392# 0.11661f
C14424 sg13cmos5l_buf_1_96.A a_10308_7992# 0.05002f
C14425 sg13cmos5l_dfrbp_1_1.Q a_14440_1664# 0.00338f
C14426 sg13cmos5l_buf_1_45.X sg13cmos5l_dlhr_1_0.D 0
C14427 a_6372_4968# a_7631_4727# 0.01741f
C14428 a_12721_1703# nh_sw[6] 0.0113f
C14429 a_9060_8861# cks 0
C14430 sg13cmos5l_inv_1_8.A a_5820_5773# 0.11651f
C14431 sg13cmos5l_inv_1_11.Y a_9823_2364# 0.0084f
C14432 sg13cmos5l_dfrbp_1_0.RESET_B a_14924_1590# 0
C14433 sg13cmos5l_dfrbp_1_6.RESET_B sg13cmos5l_buf_1_58.A 0.06996f
C14434 a_3664_4142# sg13cmos5l_dfrbp_1_10.Q_N 0
C14435 sg13cmos5l_a22oi_1_1.B1 a_15062_4292# 0.00338f
C14436 sg13cmos5l_dfrbp_1_6.RESET_B a_6084_4325# 0.00218f
C14437 sg13cmos5l_buf_1_18.X a_18577_1703# 0
C14438 sg13cmos5l_dfrbp_1_6.RESET_B a_15016_6294# 0.02216f
C14439 sg13cmos5l_o21ai_1_0.B1 VPWR 0.72786f
C14440 sg13cmos5l_dlhr_1_15.D a_12216_5728# 0.00611f
C14441 sg13cmos5l_inv_1_14.A sg13cmos5l_buf_1_24.A 2.83611f
C14442 sg13cmos5l_dfrbp_1_8.RESET_B a_8247_5770# 0
C14443 a_2248_9224# pl_sw[1] 0
C14444 sg13cmos5l_buf_1_45.X a_8486_8874# 0.00302f
C14445 a_11530_3868# sg13cmos5l_buf_1_8.X 0
C14446 a_6219_6284# VPWR 0.20551f
C14447 a_14726_7674# a_14426_7288# 0
C14448 a_13648_9406# sg13cmos5l_buf_1_98.A 0
C14449 a_16042_6892# cks 0.01023f
C14450 sg13cmos5l_dfrbp_1_16.Q a_3771_6553# 0.00156f
C14451 sg13cmos5l_dlhr_1_5.GATE a_3588_4968# 0
C14452 sg13cmos5l_dlhr_1_0.Q sg13cmos5l_buf_1_30.X 0
C14453 sg13cmos5l_buf_1_19.A a_17988_3151# 0
C14454 sg13cmos5l_dlhr_1_11.GATE sg13cmos5l_buf_1_57.X 0
C14455 sg13cmos5l_or2_1_0.A sg13cmos5l_dfrbp_1_2.D 0.08387f
C14456 a_1997_6126# a_2638_6477# 0.00675f
C14457 a_2804_6924# a_1967_5773# 0
C14458 a_1967_7285# a_2804_5412# 0
C14459 sg13cmos5l_a22oi_1_1.B2 a_13652_3900# 0
C14460 a_2554_8112# pl_sw[2] 0
C14461 pl_sw[9] frame 0
C14462 sg13cmos5l_dfrbp_1_22.D sg13cmos5l_dlhr_1_13.Q_N 0.08201f
C14463 sg13cmos5l_dfrbp_1_6.D a_422_5850# 0.32646f
C14464 a_8043_7796# VPWR 0.20642f
C14465 a_12651_9308# sg13cmos5l_buf_1_93.X 0
C14466 sg13cmos5l_or2_1_0.A sg13cmos5l_buf_1_34.A 0
C14467 sg13cmos5l_nand2_1_0.A sg13cmos5l_o21ai_1_0.Y 0
C14468 sg13cmos5l_inv_1_8.A VPWR 1.79552f
C14469 sg13cmos5l_dfrbp_1_8.D a_19734_5842# 0
C14470 sg13cmos5l_dfrbp_1_8.RESET_B a_14342_8874# 0.12261f
C14471 sg13cmos5l_dfrbp_1_9.Q a_2505_3947# 0
C14472 sg13cmos5l_nand2_1_0.B a_10888_1664# 0
C14473 sg13cmos5l_dlygate4sd2_1_0.X a_1672_3176# 0.17357f
C14474 sg13cmos5l_dlhr_1_1.GATE a_996_5837# 0
C14475 a_6385_2749# a_6898_2826# 0
C14476 a_8204_2352# sg13cmos5l_dlhr_1_0.D 0.0023f
C14477 a_4005_4629# a_5104_4870# 0
C14478 a_4107_4772# a_4847_4727# 0.3087f
C14479 a_2667_8447# cks 0.01921f
C14480 a_19227_4654# sg13cmos5l_dfrbp_1_3.Q_N 0
C14481 sg13cmos5l_dlhr_1_9.Q a_2748_6126# 0.05004f
C14482 a_14900_2352# a_14858_2388# 0
C14483 sg13cmos5l_nor2b_1_1.Y a_14476_2388# 0.01382f
C14484 sg13cmos5l_inv_1_7.A sg13cmos5l_inv_1_0.Y 0
C14485 a_6660_4663# sg13cmos5l_or2_1_0.A 0
C14486 sg13cmos5l_nor2b_1_0.Y a_10783_3876# 0.01709f
C14487 sg13cmos5l_buf_1_44.X a_4324_7996# 0
C14488 sg13cmos5l_a22oi_1_0.Y a_10331_3900# 0.00137f
C14489 sg13cmos5l_dfrbp_1_11.Q sg13cmos5l_a221oi_1_0.C1 0
C14490 a_12549_9165# sg13cmos5l_inv_1_27.Y 0
C14491 sg13cmos5l_buf_1_87.A pl_sw[9] 0.3193f
C14492 sg13cmos5l_nor2_1_2.A a_1760_3986# 0
C14493 sg13cmos5l_buf_1_4.X a_17414_3138# 0.00728f
C14494 sg13cmos5l_inv_1_29.A pl_sw[6] 0
C14495 a_1125_6935# a_1967_7285# 0.0032f
C14496 sg13cmos5l_dfrbp_1_6.D a_17746_7362# 0
C14497 sg13cmos5l_dfrbp_1_9.Q a_1862_4338# 0
C14498 sg13cmos5l_dlhr_1_12.Q_N cks 0.00245f
C14499 sg13cmos5l_dfrbp_1_8.RESET_B a_3831_7282# 0.01934f
C14500 sg13cmos5l_nand2_1_0.A a_11054_4292# 0.00823f
C14501 sg13cmos5l_buf_1_31.X sg13cmos5l_dlhr_1_17.Q_N 0.0579f
C14502 sg13cmos5l_dfrbp_1_21.Q sg13cmos5l_a22oi_1_1.B1 0
C14503 sg13cmos5l_dfrbp_1_8.RESET_B a_7498_7897# 0.0057f
C14504 sg13cmos5l_dlhr_1_2.D a_6385_2749# 0.00302f
C14505 sg13cmos5l_nor2b_1_0.Y a_11556_3904# 0.05888f
C14506 sg13cmos5l_dfrbp_1_16.Q_N a_1227_6935# 0
C14507 sg13cmos5l_dlhr_1_6.D sg13cmos5l_buf_1_29.A 0.62671f
C14508 sg13cmos5l_buf_1_79.X a_11824_7894# 0
C14509 sg13cmos5l_dfrbp_1_23.CLK pl_sw[8] 0
C14510 sg13cmos5l_buf_1_3.A pl_sw[9] 0
C14511 sg13cmos5l_dfrbp_1_6.RESET_B a_524_4614# 0
C14512 sg13cmos5l_dfrbp_1_15.D a_4177_7326# 0
C14513 a_10665_7281# sg13cmos5l_dlhr_1_6.D 0
C14514 sg13cmos5l_inv_1_2.A sg13cmos5l_dfrbp_1_25.Q_N 0.00855f
C14515 sg13cmos5l_dfrbp_1_1.Q sg13cmos5l_buf_1_18.X 0.17075f
C14516 a_8084_8436# a_8486_8874# 0
C14517 sg13cmos5l_dfrbp_1_6.D a_14889_7281# 0.01203f
C14518 sg13cmos5l_a22oi_1_2.B2 sg13cmos5l_dlhr_1_0.D 0
C14519 sg13cmos5l_dfrbp_1_6.RESET_B sg13cmos5l_buf_1_10.A 0.83692f
C14520 sg13cmos5l_dlhr_1_4.Q_N sg13cmos5l_dlhr_1_2.D 0
C14521 sg13cmos5l_a221oi_1_0.B2 sg13cmos5l_inv_1_0.Y 0.00664f
C14522 a_16160_9318# a_16144_8678# 0.00347f
C14523 a_1815_4666# a_2228_4972# 0.15652f
C14524 sg13cmos5l_buf_1_93.X pl_sw[9] 0.01181f
C14525 a_1948_7964# VPWR 0.6564f
C14526 sg13cmos5l_dfrbp_1_10.Q a_4436_3436# 0.15372f
C14527 sg13cmos5l_or2_1_0.A sg13cmos5l_dfrbp_1_7.Q_N 0.00156f
C14528 sg13cmos5l_dfrbp_1_20.Q a_10417_7326# 0
C14529 sg13cmos5l_dfrbp_1_1.Q a_17700_1639# 0
C14530 sg13cmos5l_dfrbp_1_16.Q sg13cmos5l_dlhr_1_0.GATE 0
C14531 sg13cmos5l_buf_1_98.A ph_sw[6] 0
C14532 a_16164_4663# a_15821_3864# 0
C14533 a_3860_2388# a_3996_2790# 0.00404f
C14534 a_4041_2745# a_4566_2818# 0.13715f
C14535 sg13cmos5l_dfrbp_1_0.RESET_B a_17638_1639# 0
C14536 sg13cmos5l_buf_1_41.A a_2436_4325# 0
C14537 a_4652_6126# a_3588_4968# 0
C14538 a_16264_9224# ph_sw[8] 0
C14539 sg13cmos5l_buf_1_65.X a_4244_8436# 0
C14540 a_3308_9150# a_3313_8797# 0
C14541 sg13cmos5l_dfrbp_1_6.RESET_B a_15702_5842# 0
C14542 a_11072_5347# sg13cmos5l_dfrbp_1_2.D 0
C14543 sg13cmos5l_or2_1_1.B sg13cmos5l_a22oi_1_1.B1 0
C14544 sg13cmos5l_buf_1_76.X cks 0
C14545 sg13cmos5l_buf_1_10.A a_10071_7282# 0
C14546 sg13cmos5l_buf_1_7.A a_13284_3456# 0.01726f
C14547 sg13cmos5l_o21ai_1_0.B1 a_11973_1605# 0
C14548 sg13cmos5l_dfrbp_1_16.Q a_9076_5800# 0
C14549 a_4076_5376# sg13cmos5l_inv_1_19.A 0.00703f
C14550 a_7941_7653# a_8570_6172# 0
C14551 a_11973_3911# a_12625_2749# 0
C14552 sg13cmos5l_dfrbp_1_0.CLK a_11979_2399# 0.04429f
C14553 sg13cmos5l_buf_1_96.A a_11824_7894# 0
C14554 a_3599_3215# a_3241_2746# 0
C14555 a_3856_3358# a_3447_2746# 0.00159f
C14556 a_9129_8483# cks 0
C14557 a_7631_4727# a_7888_4870# 0.35645f
C14558 a_6789_4629# a_7537_4727# 0.01058f
C14559 sg13cmos5l_inv_1_8.A sg13cmos5l_dfrbp_1_11.Q 0.15132f
C14560 a_1760_9318# sg13cmos5l_buf_1_62.X 0.06f
C14561 a_2667_8447# a_3609_8559# 0
C14562 a_12489_9577# ph_sw[6] 0
C14563 sg13cmos5l_dfrbp_1_9.Q sg13cmos5l_dfrbp_1_10.Q 0.68048f
C14564 sg13cmos5l_buf_1_8.X a_12022_3134# 0.00137f
C14565 sg13cmos5l_o21ai_1_0.A2 sg13cmos5l_buf_1_6.A 0
C14566 sg13cmos5l_dfrbp_1_8.RESET_B a_1760_3986# 0
C14567 a_13768_8436# a_14152_8522# 0.03269f
C14568 sg13cmos5l_dlhr_1_11.GATE a_13178_7684# 0.00629f
C14569 sg13cmos5l_dfrbp_1_20.Q_N a_8486_8874# 0
C14570 sg13cmos5l_inv_1_6.A a_18870_7656# 0
C14571 sg13cmos5l_dfrbp_1_6.D sg13cmos5l_nand2_1_2.B 0.02281f
C14572 a_8972_9150# VPWR 0.2477f
C14573 sg13cmos5l_buf_1_3.X a_20392_2388# 0.04119f
C14574 a_18615_5770# sg13cmos5l_dfrbp_1_0.D 0
C14575 a_12814_4692# sg13cmos5l_o21ai_1_0.B1 0
C14576 sg13cmos5l_buf_1_45.X a_9060_8861# 0
C14577 a_5988_6175# VPWR 0.00674f
C14578 a_2314_3361# a_2697_3529# 0.00337f
C14579 a_2340_3456# a_2757_3117# 0.48921f
C14580 a_2054_3138# a_2859_3260# 0.11742f
C14581 a_16587_6935# cks 0.023f
C14582 a_8276_6924# VPWR 0.10785f
C14583 sg13cmos5l_dfrbp_1_1.Q sg13cmos5l_o21ai_1_0.Y 0.86286f
C14584 a_16164_4663# VPWR 0.00674f
C14585 sg13cmos5l_dfrbp_1_9.Q a_5673_3138# 0
C14586 a_1997_6126# a_2474_6162# 0.00176f
C14587 sg13cmos5l_dlhr_1_0.Q sg13cmos5l_dlhr_1_0.Q_N 0.00177f
C14588 a_2879_6432# a_3669_6320# 0.02241f
C14589 a_2727_6380# a_2748_6126# 0.38871f
C14590 a_6184_9224# VPWR 0.24741f
C14591 sg13cmos5l_dlhr_1_9.D a_4076_5376# 0.00601f
C14592 a_1997_6126# a_2224_5654# 0.00801f
C14593 sg13cmos5l_buf_1_90.X sg13cmos5l_dfrbp_1_23.CLK 0.01635f
C14594 a_9620_7972# VPWR 0.35691f
C14595 sg13cmos5l_inv_1_1.A a_15702_5842# 0.00284f
C14596 sg13cmos5l_nor2_1_1.A nl_sw[8] 0.02453f
C14597 sg13cmos5l_dfrbp_1_8.RESET_B a_14916_8861# 0.00194f
C14598 sg13cmos5l_inv_1_3.A a_13484_8400# 0.00307f
C14599 a_14986_7897# a_14726_7674# 0.87117f
C14600 sg13cmos5l_nand2_1_1.B a_13072_4142# 0
C14601 sg13cmos5l_dfrbp_1_21.Q sg13cmos5l_dlhr_1_16.Q_N 0
C14602 a_4847_4727# a_5104_4870# 0.35645f
C14603 sg13cmos5l_buf_1_73.A a_6405_8447# 0.00276f
C14604 sg13cmos5l_dfrbp_1_17.Q_N cks 0.00532f
C14605 sg13cmos5l_inv_1_2.A sg13cmos5l_buf_1_116.A 0
C14606 sg13cmos5l_dlygate4sd3_1_0.X a_902_3142# 0.05531f
C14607 a_9865_7282# sg13cmos5l_a221oi_1_1.C1 0
C14608 a_2934_4632# a_2757_3117# 0
C14609 sg13cmos5l_buf_1_65.X sg13cmos5l_buf_1_30.A 0
C14610 sg13cmos5l_dfrbp_1_8.RESET_B a_4425_7281# 0
C14611 sg13cmos5l_buf_1_18.A a_19028_5412# 0.01693f
C14612 a_1125_6935# a_1484_6126# 0.00401f
C14613 sg13cmos5l_dlygate4sd2_1_0.A a_2340_3456# 0
C14614 a_14714_5776# VPWR 0.35716f
C14615 sg13cmos5l_dlhr_1_6.D a_12216_5728# 0.0044f
C14616 a_708_6928# VPWR 0.07913f
C14617 sg13cmos5l_buf_1_103.A a_17545_7728# 0
C14618 sg13cmos5l_inv_1_0.A a_12815_4261# 0.01185f
C14619 sg13cmos5l_dfrbp_1_16.Q_N sg13cmos5l_dfrbp_1_16.Q 0.00669f
C14620 sg13cmos5l_nand2_1_0.B VPWR 0.73659f
C14621 sg13cmos5l_dfrbp_1_21.Q a_13486_5412# 0.00222f
C14622 sg13cmos5l_inv_1_29.A a_10484_6924# 0
C14623 sg13cmos5l_buf_1_5.A sg13cmos5l_dlhr_1_15.D 0.02707f
C14624 a_11560_7010# sg13cmos5l_dlhr_1_6.D 0
C14625 sg13cmos5l_dlhr_1_5.GATE a_3575_6553# 0
C14626 sg13cmos5l_buf_1_96.A sg13cmos5l_inv_1_0.A 0
C14627 sg13cmos5l_inv_1_26.Y ph_sw[9] 0.01735f
C14628 a_10010_9196# a_10022_7674# 0
C14629 a_8486_8874# a_8746_8404# 0.87117f
C14630 sg13cmos5l_dfrbp_1_6.RESET_B a_7994_7288# 0.01869f
C14631 a_5800_9224# pl_sw[3] 0.00196f
C14632 sg13cmos5l_buf_1_33.A a_5324_1590# 0
C14633 sg13cmos5l_buf_1_39.A a_4172_1590# 0.01209f
C14634 a_3212_1590# sg13cmos5l_buf_1_25.X 0
C14635 a_1946_4660# a_2342_5088# 0.00949f
C14636 a_1664_7806# VPWR 0.06567f
C14637 a_4324_7996# sg13cmos5l_dlhr_1_9.Q 0.01067f
C14638 sg13cmos5l_buf_1_77.A a_8439_6178# 0.00864f
C14639 sg13cmos5l_dfrbp_1_20.Q a_10416_6924# 0
C14640 a_6022_4325# VPWR 0
C14641 a_2348_7624# a_2224_7166# 0
C14642 a_1948_7964# a_1967_7285# 0.00916f
C14643 VPWR nl_sw[6] 0.34572f
C14644 nh_sw[0] nl_sw[1] 0.18045f
C14645 nh_sw[7] nh_sw[6] 0.01114f
C14646 sg13cmos5l_nand2_1_1.A sg13cmos5l_nor2_1_1.A 0.00625f
C14647 nl_sw[9] nh_sw[9] 0.4175f
C14648 sg13cmos5l_buf_1_32.X VPWR 0.28956f
C14649 sg13cmos5l_buf_1_4.A sg13cmos5l_dfrbp_1_21.Q 0.06793f
C14650 a_8276_6924# a_8233_6216# 0
C14651 a_8457_7281# a_8439_6178# 0.01087f
C14652 a_7820_9150# sg13cmos5l_buf_1_45.X 0.00135f
C14653 sg13cmos5l_buf_1_73.A a_8204_9150# 0.03551f
C14654 a_8276_6924# sg13cmos5l_dfrbp_1_11.Q 0
C14655 a_13284_3456# a_13556_2388# 0
C14656 sg13cmos5l_o21ai_1_0.B1 a_14056_1664# 0
C14657 sg13cmos5l_dfrbp_1_29.Q_N sg13cmos5l_inv_1_19.A 0
C14658 sg13cmos5l_buf_1_103.A sg13cmos5l_dlhr_1_12.D 0
C14659 a_18480_5028# a_18574_5028# 0.00729f
C14660 sg13cmos5l_dlhr_1_10.Q ph_sw[9] 0
C14661 sg13cmos5l_buf_1_38.A nl_sw[3] 0.00153f
C14662 sg13cmos5l_or2_1_1.B a_13486_5412# 0.02435f
C14663 a_8783_7751# a_9033_6162# 0.00561f
C14664 a_20118_6144# frame 0
C14665 sg13cmos5l_dfrbp_1_6.RESET_B sg13cmos5l_dlhr_1_2.Q_N 0.00466f
C14666 sg13cmos5l_buf_1_41.A a_1862_4338# 0
C14667 a_4436_3436# a_4566_2818# 0
C14668 a_3505_3215# a_3578_2752# 0
C14669 sg13cmos5l_dfrbp_1_10.Q_N a_3241_2746# 0.13382f
C14670 sg13cmos5l_dfrbp_1_0.CLK sg13cmos5l_dfrbp_1_4.Q_N 0.00129f
C14671 a_6568_9224# a_7052_9150# 0.03472f
C14672 sg13cmos5l_buf_1_73.X sg13cmos5l_buf_1_73.A 0.06193f
C14673 sg13cmos5l_inv_1_0.A sg13cmos5l_a221oi_1_0.B1 0.01974f
C14674 a_7631_4727# sg13cmos5l_dfrbp_1_12.Q_N 0.00637f
C14675 a_7888_4870# sg13cmos5l_dfrbp_1_11.Q_N 0.15881f
C14676 a_13484_8400# cks 0.00874f
C14677 sg13cmos5l_buf_1_78.X sg13cmos5l_dfrbp_1_6.D 0
C14678 sg13cmos5l_inv_1_17.A a_3302_4650# 0.05193f
C14679 sg13cmos5l_dfrbp_1_8.RESET_B a_3313_4261# 0.01358f
C14680 sg13cmos5l_dfrbp_1_20.Q_N a_9060_8861# 0
C14681 sg13cmos5l_nor2_1_0.A sg13cmos5l_a22oi_1_0.B1 0.31391f
C14682 a_20492_8400# a_20392_7712# 0.00139f
C14683 a_8783_7751# sg13cmos5l_buf_1_57.X 0.00179f
C14684 a_11072_2474# a_10888_1664# 0.00304f
C14685 sg13cmos5l_inv_1_2.A a_11940_9186# 0
C14686 sg13cmos5l_buf_8_0.X a_18959_3215# 0
C14687 sg13cmos5l_dlhr_1_1.D sg13cmos5l_dlhr_1_1.Q 0.01174f
C14688 a_15702_5842# a_15702_4187# 0
C14689 sg13cmos5l_buf_1_65.X pl_sw[5] 0.00676f
C14690 sg13cmos5l_dlhr_1_15.D sg13cmos5l_dfrbp_1_23.Q 0
C14691 a_2859_3260# a_3856_3358# 0.06778f
C14692 a_2054_3138# a_2628_3151# 0.36169f
C14693 sg13cmos5l_inv_1_29.Y a_11370_5760# 0
C14694 sg13cmos5l_buf_1_29.A a_8972_3864# 0
C14695 sg13cmos5l_dfrbp_1_6.RESET_B sg13cmos5l_nor2b_1_0.Y 0.00325f
C14696 sg13cmos5l_dfrbp_1_22.Q_N cks 0
C14697 sg13cmos5l_dlhr_1_5.GATE a_4753_4727# 0
C14698 a_15357_1816# nh_sw[6] 0
C14699 a_13297_9263# VPWR 0
C14700 sg13cmos5l_buf_1_24.A a_6959_6239# 0
C14701 sg13cmos5l_dfrbp_1_16.Q a_4176_6924# 0
C14702 a_3669_6320# a_3771_6553# 0.00337f
C14703 a_3575_6553# a_4652_6126# 0
C14704 a_2748_6126# a_3530_6320# 0.4806f
C14705 a_2727_6380# a_2638_6162# 0.00667f
C14706 sg13cmos5l_dfrbp_1_22.D a_17233_7285# 0.00226f
C14707 sg13cmos5l_dfrbp_1_23.CLK sg13cmos5l_dfrbp_1_21.Q 0.00834f
C14708 sg13cmos5l_buf_1_3.A a_20118_6144# 0
C14709 a_19136_9318# sg13cmos5l_dlhr_1_15.Q_N 0
C14710 a_2727_6380# a_1967_5773# 0.01103f
C14711 a_2879_6432# a_3308_5376# 0.00999f
C14712 a_1997_6126# sg13cmos5l_dlhr_1_1.D 0
C14713 sg13cmos5l_dlhr_1_9.D sg13cmos5l_dfrbp_1_29.Q_N 0.00358f
C14714 sg13cmos5l_dfrbp_1_6.RESET_B sg13cmos5l_buf_1_44.A 0.27854f
C14715 a_20672_5498# VPWR 0.05559f
C14716 sg13cmos5l_inv_1_1.A a_14928_5412# 0
C14717 sg13cmos5l_buf_1_57.X a_14583_5770# 0.00272f
C14718 a_11174_2826# VPWR 0.93659f
C14719 sg13cmos5l_dfrbp_1_8.D sg13cmos5l_a22oi_1_1.A1 0.06901f
C14720 sg13cmos5l_dfrbp_1_8.RESET_B a_14985_8483# 0
C14721 sg13cmos5l_nand2_1_1.B sg13cmos5l_dfrbp_1_2.Q_N 0
C14722 a_14726_7674# a_15429_7653# 0.02453f
C14723 sg13cmos5l_buf_1_103.A VPWR 0.26348f
C14724 sg13cmos5l_buf_1_4.A a_16298_4338# 0
C14725 a_5104_4870# sg13cmos5l_dfrbp_1_14.Q_N 0.15881f
C14726 a_4847_4727# sg13cmos5l_dlhr_1_0.GATE 0.00143f
C14727 a_7336_9224# a_7153_8797# 0
C14728 sg13cmos5l_buf_1_73.A a_7247_8797# 0.02767f
C14729 a_19227_9190# a_20008_7712# 0
C14730 a_1862_8874# a_2122_8404# 0.87117f
C14731 sg13cmos5l_buf_1_26.A a_7508_1948# 0
C14732 a_8392_3270# a_8214_1608# 0.00154f
C14733 sg13cmos5l_dfrbp_1_9.Q a_2757_3117# 0.37281f
C14734 sg13cmos5l_dlhr_1_5.GATE sg13cmos5l_buf_1_31.X 0
C14735 a_13076_5376# a_12721_4261# 0
C14736 sg13cmos5l_dlhr_1_12.Q_N pl_sw[9] 0.00307f
C14737 sg13cmos5l_nand2_1_1.B a_10331_3900# 0.01222f
C14738 a_17988_3151# sg13cmos5l_dfrbp_1_0.Q 0
C14739 sg13cmos5l_dlhr_1_15.D a_14814_4292# 0
C14740 sg13cmos5l_dfrbp_1_16.Q sg13cmos5l_a22oi_1_1.B1 0
C14741 a_15177_5769# VPWR 0.62721f
C14742 sg13cmos5l_buf_1_30.A a_6479_2749# 0
C14743 a_11846_9186# a_11848_8436# 0
C14744 sg13cmos5l_dfrbp_1_6.RESET_B a_8247_5770# 0.00402f
C14745 a_11973_1605# nl_sw[6] 0.01296f
C14746 sg13cmos5l_dfrbp_1_21.Q a_15132_5814# 0
C14747 sg13cmos5l_dfrbp_1_17.D cks 0.02792f
C14748 sg13cmos5l_buf_1_87.A a_19340_8400# 0
C14749 sg13cmos5l_nor2_1_2.A a_650_3900# 0
C14750 a_708_6928# a_1967_7285# 0.01741f
C14751 sg13cmos5l_inv_1_29.A a_10598_6924# 0
C14752 sg13cmos5l_dfrbp_1_23.CLK sg13cmos5l_or2_1_1.B 0
C14753 a_3676_7964# a_2748_6126# 0
C14754 a_11394_4948# sg13cmos5l_o21ai_1_0.A1 0.19068f
C14755 sg13cmos5l_inv_1_2.A ph_sw[8] 0.00256f
C14756 sg13cmos5l_buf_8_1.A a_17008_2630# 0
C14757 sg13cmos5l_nand2_1_1.A a_19378_3138# 0
C14758 a_6903_3154# a_7095_1642# 0
C14759 sg13cmos5l_buf_1_44.X a_5408_3986# 0.00108f
C14760 sg13cmos5l_buf_1_40.A sg13cmos5l_or2_1_0.A 0.02299f
C14761 a_2732_9150# sg13cmos5l_inv_1_20.Y 0.31941f
C14762 sg13cmos5l_buf_1_60.X sg13cmos5l_buf_1_65.X 1.63805f
C14763 sg13cmos5l_dfrbp_1_6.RESET_B a_10665_8065# 0.00157f
C14764 sg13cmos5l_nor2_1_2.A sg13cmos5l_dlygate4sd3_1_0.X 0.00916f
C14765 a_8772_8440# a_8998_8861# 0.00523f
C14766 a_8746_8404# a_9060_8861# 0.00659f
C14767 a_11567_7751# pl_sw[6] 0
C14768 sg13cmos5l_dfrbp_1_23.CLK a_12567_7282# 0.00135f
C14769 a_5220_2392# a_6188_1590# 0
C14770 sg13cmos5l_nand2_1_0.A nh_sw[6] 0
C14771 a_18999_6178# a_18793_6216# 0.27532f
C14772 sg13cmos5l_inv_1_0.A a_11782_4325# 0
C14773 a_6507_8447# sg13cmos5l_buf_1_30.A 0
C14774 a_17713_8838# cks 0
C14775 sg13cmos5l_dfrbp_1_16.Q_N a_996_7349# 0
C14776 sg13cmos5l_dfrbp_1_8.RESET_B sg13cmos5l_dlhr_1_2.Q 0
C14777 a_14900_2352# sg13cmos5l_buf_1_1.A 0
C14778 a_19227_9190# a_19624_8436# 0.00883f
C14779 sg13cmos5l_inv_1_27.Y a_16068_6928# 0
C14780 sg13cmos5l_buf_1_77.A sg13cmos5l_buf_1_56.A 0
C14781 sg13cmos5l_a22oi_1_1.Y sg13cmos5l_nor2b_1_1.Y 0
C14782 sg13cmos5l_buf_1_24.A nl_sw[4] 0
C14783 a_7474_4338# VPWR 0
C14784 sg13cmos5l_dfrbp_1_6.D a_2824_2388# 0.00543f
C14785 sg13cmos5l_dfrbp_1_6.RESET_B a_14342_8874# 0.00208f
C14786 sg13cmos5l_nand2_1_2.B a_1121_4166# 0.0061f
C14787 a_18480_5028# a_18363_4270# 0.00852f
C14788 sg13cmos5l_buf_8_1.A a_17354_4180# 0.00373f
C14789 a_15147_8447# a_16089_8559# 0
C14790 sg13cmos5l_buf_1_58.A a_2224_7166# 0
C14791 sg13cmos5l_dlhr_1_6.D a_9558_6144# 0.00495f
C14792 sg13cmos5l_buf_1_33.A nh_sw[2] 0.21193f
C14793 sg13cmos5l_dfrbp_1_6.RESET_B a_19444_5800# 0.00424f
C14794 sg13cmos5l_dlhr_1_5.Q a_9033_6162# 0.02005f
C14795 sg13cmos5l_buf_1_24.A a_5770_3868# 0.00183f
C14796 a_13681_6239# a_13324_4696# 0
C14797 ph_sw[2] ph_sw[3] 0.12227f
C14798 ph_sw[0] cks 0.00186f
C14799 sg13cmos5l_buf_1_10.A a_12361_7282# 0.02465f
C14800 a_13803_3260# a_14254_2444# 0
C14801 a_13701_3117# sg13cmos5l_nor2_1_1.A 0.00707f
C14802 sg13cmos5l_buf_1_30.A a_6789_4629# 0.05109f
C14803 sg13cmos5l_a221oi_1_0.C1 a_10783_4292# 0
C14804 sg13cmos5l_inv_1_14.A sg13cmos5l_buf_1_31.X 0.025f
C14805 sg13cmos5l_dfrbp_1_6.RESET_B a_3831_7282# 0.01177f
C14806 sg13cmos5l_dfrbp_1_8.RESET_B a_5600_8522# 0
C14807 sg13cmos5l_dfrbp_1_20.Q a_9033_6162# 0
C14808 sg13cmos5l_dfrbp_1_0.D sg13cmos5l_nor2_1_1.A 0.12222f
C14809 sg13cmos5l_dfrbp_1_8.RESET_B a_4873_3192# 0
C14810 sg13cmos5l_dfrbp_1_6.RESET_B a_7498_7897# 0.32305f
C14811 sg13cmos5l_inv_1_8.A a_3945_5041# 0
C14812 sg13cmos5l_dfrbp_1_10.Q_N a_4276_2776# 0
C14813 a_1948_7964# a_2306_7660# 0.00566f
C14814 sg13cmos5l_buf_1_57.X sg13cmos5l_dlhr_1_5.Q 1.1139f
C14815 sg13cmos5l_a221oi_1_1.C1 VPWR 0.34024f
C14816 sg13cmos5l_dlhr_1_15.D a_17425_6239# 0.00165f
C14817 sg13cmos5l_dfrbp_1_11.Q_N sg13cmos5l_dfrbp_1_12.Q_N 0
C14818 sg13cmos5l_inv_1_2.A sg13cmos5l_inv_1_7.A 0
C14819 a_15590_4650# cks 0
C14820 a_2248_9224# a_2436_8861# 0
C14821 sg13cmos5l_inv_1_20.Y a_2565_8447# 0.02769f
C14822 a_19628_2352# nl_sw[10] 0.12756f
C14823 sg13cmos5l_buf_1_95.X ph_sw[7] 0.00107f
C14824 sg13cmos5l_dfrbp_1_2.Q_N sg13cmos5l_a22oi_1_1.A1 0
C14825 sg13cmos5l_buf_1_5.A sg13cmos5l_dlhr_1_6.D 0
C14826 sg13cmos5l_buf_1_4.A a_16234_6385# 0.00318f
C14827 sg13cmos5l_dlhr_1_13.Q_N a_15782_7362# 0.04978f
C14828 a_16264_9224# a_16160_9318# 0.00624f
C14829 sg13cmos5l_buf_1_6.A a_11460_2392# 0.01565f
C14830 sg13cmos5l_dfrbp_1_8.RESET_B a_6346_4873# 0.32247f
C14831 sg13cmos5l_dfrbp_1_20.Q sg13cmos5l_buf_1_57.X 0.21662f
C14832 sg13cmos5l_o21ai_1_0.B1 a_12120_3456# 0
C14833 a_11434_2356# a_11270_1626# 0
C14834 a_11460_2392# a_11530_1849# 0
C14835 sg13cmos5l_nor2_1_0.A sg13cmos5l_dlhr_1_20.Q_N 0
C14836 sg13cmos5l_buf_1_18.A sg13cmos5l_dfrbp_1_3.Q_N 0.0042f
C14837 sg13cmos5l_a221oi_1_0.A2 a_9660_4686# 0
C14838 sg13cmos5l_dfrbp_1_6.D a_9344_7010# 0
C14839 a_20296_1664# nl_sw[10] 0.002f
C14840 a_15876_4968# sg13cmos5l_a22oi_1_1.A1 0.00391f
C14841 sg13cmos5l_or2_1_0.A a_13072_4142# 0.00213f
C14842 a_424_9318# sg13cmos5l_buf_1_62.X 0
C14843 sg13cmos5l_buf_1_10.A a_11556_1944# 0
C14844 sg13cmos5l_buf_1_79.X a_12132_9504# 0
C14845 a_2054_3138# sg13cmos5l_buf_1_41.X 0
C14846 sg13cmos5l_dfrbp_1_16.Q a_6865_6239# 0
C14847 sg13cmos5l_inv_1_2.A a_9189_8447# 0.35307f
C14848 a_13648_9406# a_13810_9186# 0.0019f
C14849 sg13cmos5l_buf_1_24.A sg13cmos5l_dlhr_1_6.D 0
C14850 sg13cmos5l_dlhr_1_9.D a_9033_6162# 0
C14851 a_1873_7285# sg13cmos5l_inv_1_19.A 0
C14852 sg13cmos5l_a22oi_1_1.B1 sg13cmos5l_a22oi_1_1.Y 0.36621f
C14853 sg13cmos5l_inv_1_1.A a_14342_8874# 0
C14854 sg13cmos5l_buf_1_3.A a_19828_6148# 0
C14855 sg13cmos5l_dfrbp_1_8.RESET_B sg13cmos5l_dlygate4sd3_1_0.X 0
C14856 sg13cmos5l_a22oi_1_1.B2 sg13cmos5l_buf_1_5.X 0.00409f
C14857 a_11072_2474# VPWR 0.08181f
C14858 sg13cmos5l_buf_1_57.X a_14929_5814# 0
C14859 sg13cmos5l_buf_1_40.A a_1672_3176# 0
C14860 a_1227_5423# a_1967_5773# 0.3087f
C14861 a_15531_7796# a_16271_7751# 0.3087f
C14862 a_15429_7653# a_16528_7894# 0
C14863 sg13cmos5l_dfrbp_1_6.RESET_B a_8774_5412# 0
C14864 a_4460_9150# sg13cmos5l_buf_1_73.X 0
C14865 sg13cmos5l_buf_1_60.X pl_sw[1] 0
C14866 a_11530_3868# sg13cmos5l_buf_1_9.A 0.00168f
C14867 sg13cmos5l_nand2_1_1.B a_13284_3456# 0.02834f
C14868 a_18278_8112# cks 0
C14869 sg13cmos5l_dlhr_1_9.D sg13cmos5l_buf_1_57.X 0
C14870 a_7657_7282# VPWR 0.44035f
C14871 sg13cmos5l_inv_1_2.A sg13cmos5l_dlhr_1_13.Q_N 0
C14872 a_2148_8440# a_2436_8861# 0.4806f
C14873 a_2122_8404# a_2667_8447# 0.00999f
C14874 a_1862_8874# a_3407_8797# 0
C14875 a_13648_9406# sg13cmos5l_dlhr_1_11.Q 0
C14876 sg13cmos5l_inv_1_8.A a_2380_6162# 0
C14877 sg13cmos5l_buf_1_26.A a_7440_1948# 0
C14878 a_1096_6294# a_996_5837# 0
C14879 sg13cmos5l_dfrbp_1_11.Q a_7474_4338# 0.0017f
C14880 sg13cmos5l_buf_1_78.X a_5702_8874# 0.048f
C14881 sg13cmos5l_dfrbp_1_8.D sg13cmos5l_or2_1_0.A 0.0044f
C14882 sg13cmos5l_dfrbp_1_9.Q a_3801_3453# 0
C14883 sg13cmos5l_inv_1_26.Y a_18860_6888# 0.01379f
C14884 sg13cmos5l_buf_1_10.A a_11980_4948# 0
C14885 sg13cmos5l_inv_1_17.A a_2748_6126# 0.03849f
C14886 sg13cmos5l_dfrbp_1_22.D sg13cmos5l_buf_1_89.A 0.00139f
C14887 sg13cmos5l_dfrbp_1_6.RESET_B a_1760_3986# 0
C14888 sg13cmos5l_buf_1_40.A sg13cmos5l_dlygate4sd2_1_0.X 0.90365f
C14889 a_18746_5776# VPWR 0.35951f
C14890 sg13cmos5l_buf_1_90.X a_14436_8874# 0
C14891 sg13cmos5l_dfrbp_1_8.RESET_B sg13cmos5l_buf_1_98.A 0.00579f
C14892 a_17894_8436# cks 0
C14893 a_12651_9308# a_13484_8400# 0.00754f
C14894 sg13cmos5l_and3_1_0.X a_13418_4696# 0
C14895 a_14996_5412# sg13cmos5l_and3_1_0.C 0
C14896 sg13cmos5l_dfrbp_1_1.Q nh_sw[6] 0.06248f
C14897 sg13cmos5l_dfrbp_1_21.Q a_15110_5412# 0
C14898 sg13cmos5l_inv_1_29.A a_13161_7281# 0
C14899 a_4349_7636# a_4652_6126# 0.0014f
C14900 sg13cmos5l_dfrbp_1_23.Q sg13cmos5l_dlhr_1_6.D 0.08373f
C14901 sg13cmos5l_inv_1_0.Y a_13418_4696# 0
C14902 a_12616_5498# a_11556_3904# 0
C14903 sg13cmos5l_buf_8_1.A a_18376_2388# 0
C14904 a_7316_3460# a_7689_1626# 0.00186f
C14905 a_7497_3138# a_7508_1948# 0.00208f
C14906 sg13cmos5l_dlhr_1_5.GATE a_6219_6284# 0.03802f
C14907 a_8746_8404# a_9129_8483# 0.00337f
C14908 a_9189_8447# a_9937_8797# 0.01058f
C14909 sg13cmos5l_dfrbp_1_6.RESET_B a_10596_7687# 0.01392f
C14910 sg13cmos5l_dlhr_1_11.D pl_sw[6] 0
C14911 sg13cmos5l_dfrbp_1_23.CLK a_13116_7326# 0
C14912 a_19130_6172# a_19344_6484# 0.01249f
C14913 a_19593_6162# a_20118_6144# 0.13715f
C14914 a_18860_6888# sg13cmos5l_dlhr_1_10.Q 0
C14915 a_5739_2399# a_6572_1590# 0.00498f
C14916 sg13cmos5l_dfrbp_1_18.Q a_9865_7282# 0.02726f
C14917 sg13cmos5l_buf_1_105.A cks 0.53135f
C14918 a_682_6892# VPWR 0.10416f
C14919 a_17674_3361# sg13cmos5l_dfrbp_1_0.Q 0
C14920 sg13cmos5l_buf_1_31.X sg13cmos5l_buf_1_45.A 0
C14921 a_17792_9318# ph_sw[8] 0
C14922 a_11979_2399# a_12921_2511# 0
C14923 sg13cmos5l_dlhr_1_16.Q_N d_out[2] 0
C14924 sg13cmos5l_buf_8_1.A sg13cmos5l_inv_1_5.A 0
C14925 sg13cmos5l_dfrbp_1_6.RESET_B a_14916_8861# 0
C14926 sg13cmos5l_dlhr_1_5.GATE a_8043_7796# 0
C14927 sg13cmos5l_buf_1_110.A sg13cmos5l_buf_1_4.A 0.38511f
C14928 a_13460_7996# sg13cmos5l_dlhr_1_6.D 0
C14929 sg13cmos5l_buf_1_3.A a_20008_3900# 0.00147f
C14930 sg13cmos5l_inv_1_8.A sg13cmos5l_dlhr_1_5.GATE 0.40799f
C14931 a_1664_7806# a_1484_6126# 0
C14932 a_10725_7653# sg13cmos5l_dlhr_1_18.Q_N 0
C14933 a_10596_7687# a_10071_7282# 0
C14934 sg13cmos5l_buf_1_24.A a_7312_4142# 0
C14935 sg13cmos5l_buf_1_34.A nl_sw[3] 0.04397f
C14936 sg13cmos5l_buf_1_78.X ph_sw[3] 0
C14937 a_15147_8447# pl_sw[8] 0
C14938 a_13297_9263# a_13047_7690# 0
C14939 sg13cmos5l_nand2_1_1.A a_17700_3456# 0.05048f
C14940 a_5673_3138# a_6188_1590# 0.00106f
C14941 a_15884_3102# sg13cmos5l_nor2_1_1.A 0
C14942 sg13cmos5l_buf_1_5.X a_14254_2444# 0.00232f
C14943 sg13cmos5l_buf_1_30.A a_8468_4948# 0.00163f
C14944 a_12976_2630# a_12721_1703# 0
C14945 sg13cmos5l_buf_1_34.X sg13cmos5l_dfrbp_1_17.Q_N 0.0018f
C14946 a_18860_9150# ph_sw[8] 0.29087f
C14947 sg13cmos5l_buf_1_41.A a_2757_3117# 0.04412f
C14948 sg13cmos5l_dfrbp_1_6.RESET_B a_4425_7281# 0.46244f
C14949 sg13cmos5l_dfrbp_1_8.RESET_B a_7153_8797# 0.01388f
C14950 a_5799_5499# a_6602_5692# 0.15089f
C14951 a_3676_7964# a_4324_7996# 0.13395f
C14952 sg13cmos5l_buf_1_29.A a_9544_2474# 0.01304f
C14953 sg13cmos5l_inv_1_8.A a_5684_4948# 0.01214f
C14954 sg13cmos5l_dlhr_1_15.D a_11182_4948# 0.00381f
C14955 sg13cmos5l_dfrbp_1_10.Q nl_sw[5] 0.00971f
C14956 a_416_2474# VPWR 0.06874f
C14957 sg13cmos5l_dfrbp_1_23.Q a_13698_5412# 0.01073f
C14958 a_4640_3986# VPWR 0.08114f
C14959 sg13cmos5l_dlhr_1_11.Q ph_sw[6] 0
C14960 sg13cmos5l_dfrbp_1_0.CLK a_17224_3270# 0
C14961 a_17392_4870# cks 0
C14962 sg13cmos5l_inv_1_20.Y a_3313_8797# 0.01798f
C14963 sg13cmos5l_inv_1_17.A a_3814_4663# 0
C14964 a_16042_6892# a_16485_6935# 0.02241f
C14965 a_15592_6200# sg13cmos5l_dfrbp_1_21.Q 0
C14966 sg13cmos5l_buf_1_7.A a_12075_1748# 0
C14967 sg13cmos5l_buf_1_6.A a_11979_2399# 0.00252f
C14968 sg13cmos5l_inv_1_14.A a_6219_6284# 0.02228f
C14969 sg13cmos5l_dlhr_1_1.Q sg13cmos5l_inv_1_19.A 0.01528f
C14970 sg13cmos5l_dfrbp_1_6.D a_11190_7354# 0.00274f
C14971 sg13cmos5l_buf_1_65.X a_10010_9196# 0
C14972 a_17972_4948# sg13cmos5l_a22oi_1_1.A1 0.00495f
C14973 sg13cmos5l_or2_1_0.A sg13cmos5l_dfrbp_1_2.Q_N 0.0014f
C14974 a_2566_3151# sg13cmos5l_dfrbp_1_10.Q_N 0
C14975 sg13cmos5l_dfrbp_1_8.RESET_B a_2054_3138# 0.00128f
C14976 sg13cmos5l_dfrbp_1_6.RESET_B a_8022_3120# 0.00116f
C14977 sg13cmos5l_dfrbp_1_6.RESET_B a_5028_2826# 0
C14978 sg13cmos5l_buf_1_110.A sg13cmos5l_dfrbp_1_23.CLK 0
C14979 sg13cmos5l_inv_1_2.A a_10868_8436# 0
C14980 a_15784_9224# a_15147_8447# 0.00473f
C14981 a_7394_5850# VPWR 0
C14982 sg13cmos5l_inv_1_18.A sg13cmos5l_a22oi_1_1.B1 0
C14983 sg13cmos5l_buf_1_8.X a_11270_1626# 0.04503f
C14984 sg13cmos5l_inv_1_8.A sg13cmos5l_inv_1_14.A 0.16853f
C14985 sg13cmos5l_buf_1_79.X a_8486_8874# 0
C14986 a_1997_6126# sg13cmos5l_inv_1_19.A 0.01205f
C14987 a_6405_8447# pl_sw[3] 0.00355f
C14988 sg13cmos5l_or2_1_0.A a_10331_3900# 0.00565f
C14989 sg13cmos5l_dfrbp_1_4.D a_10888_1664# 0.00158f
C14990 a_12625_2749# VPWR 0.00115f
C14991 a_2224_5654# sg13cmos5l_dlhr_1_1.D 0.16565f
C14992 sg13cmos5l_dfrbp_1_6.D sg13cmos5l_inv_1_8.Y 0.0221f
C14993 a_19130_6172# a_19227_4654# 0
C14994 sg13cmos5l_buf_1_18.A a_17414_3138# 0
C14995 d_out[1] d_out[2] 0.00816f
C14996 a_16528_7894# a_16473_7989# 0.00464f
C14997 sg13cmos5l_dfrbp_1_6.D a_5069_5376# 0.03276f
C14998 a_10827_7796# VPWR 0.21206f
C14999 sg13cmos5l_and3_1_0.C sg13cmos5l_buf_1_7.A 0.03361f
C15000 sg13cmos5l_nand2_1_1.B a_15380_3436# 0
C15001 a_2667_8447# a_3407_8797# 0.3087f
C15002 sg13cmos5l_inv_1_8.A a_4652_6126# 0
C15003 a_12716_8400# sg13cmos5l_inv_1_7.A 0.00373f
C15004 sg13cmos5l_dfrbp_1_8.RESET_B a_2228_4972# 0.00431f
C15005 sg13cmos5l_buf_1_29.A a_10420_5760# 0
C15006 sg13cmos5l_buf_1_78.A VPWR 0.45673f
C15007 sg13cmos5l_dlhr_1_9.D sg13cmos5l_dlhr_1_1.Q 0.20343f
C15008 sg13cmos5l_buf_1_45.A sg13cmos5l_a221oi_1_0.C1 0
C15009 sg13cmos5l_dlhr_1_17.Q_N sg13cmos5l_a221oi_1_1.C1 0
C15010 sg13cmos5l_dfrbp_1_6.RESET_B a_12933_6141# 0.05417f
C15011 sg13cmos5l_inv_1_27.Y a_13768_8436# 0
C15012 sg13cmos5l_buf_1_4.A a_16268_1590# 0.00613f
C15013 sg13cmos5l_nand2_1_0.B a_12120_3456# 0
C15014 sg13cmos5l_buf_1_4.A sg13cmos5l_a22oi_1_1.Y 0.02358f
C15015 sg13cmos5l_dfrbp_1_21.Q sg13cmos5l_dlhr_1_16.Q 0
C15016 a_3976_9224# sg13cmos5l_buf_1_34.X 0
C15017 sg13cmos5l_dlhr_1_15.D sg13cmos5l_buf_1_31.X 0
C15018 sg13cmos5l_and3_1_0.X sg13cmos5l_dfrbp_1_0.CLK 0
C15019 sg13cmos5l_dlhr_1_5.GATE a_5988_6175# 0.00819f
C15020 sg13cmos5l_dlhr_1_1.GATE a_2169_7047# 0.00216f
C15021 sg13cmos5l_dfrbp_1_6.RESET_B a_17674_3361# 0.01244f
C15022 a_5951_5383# sg13cmos5l_buf_1_44.A 0
C15023 sg13cmos5l_inv_1_20.Y sg13cmos5l_buf_1_41.A 0.22524f
C15024 a_10031_8797# a_10450_8874# 0.00176f
C15025 sg13cmos5l_dlhr_1_5.GATE a_8276_6924# 0
C15026 sg13cmos5l_dfrbp_1_10.Q a_7095_1642# 0
C15027 a_19412_6484# a_19548_6198# 0.00404f
C15028 a_19593_6162# a_19828_6148# 0.00566f
C15029 a_17713_8838# pl_sw[9] 0.00131f
C15030 sg13cmos5l_dfrbp_1_8.RESET_B a_11272_8522# 0.0021f
C15031 a_12106_9409# sg13cmos5l_inv_1_7.A 0
C15032 sg13cmos5l_dfrbp_1_6.D sg13cmos5l_dfrbp_1_21.Q 0.05773f
C15033 sg13cmos5l_nand2_1_0.B a_10783_4292# 0
C15034 sg13cmos5l_nor2_1_1.A a_15492_2392# 0.02852f
C15035 sg13cmos5l_inv_1_8.A a_3574_7850# 0
C15036 sg13cmos5l_inv_1_29.A a_13641_7674# 0
C15037 pl_sw[0] sg13cmos5l_inv_1_19.A 0.00157f
C15038 a_12120_3456# nl_sw[6] 0
C15039 sg13cmos5l_dfrbp_1_16.Q a_8588_3864# 0
C15040 a_5324_1590# nh_sw[3] 0
C15041 sg13cmos5l_nor2_1_2.A a_416_3986# 0.04157f
C15042 sg13cmos5l_buf_1_87.A a_17961_8793# 0.00528f
C15043 sg13cmos5l_buf_1_0.A a_17414_3138# 0
C15044 sg13cmos5l_inv_1_17.A a_2732_1590# 0.00189f
C15045 sg13cmos5l_nor2_1_0.A sg13cmos5l_buf_1_7.A 0.06391f
C15046 a_9242_4660# a_9457_4642# 0.00284f
C15047 sg13cmos5l_inv_1_17.A a_4324_7996# 0
C15048 sg13cmos5l_dfrbp_1_23.CLK a_14166_7656# 0.01295f
C15049 sg13cmos5l_nor2_1_0.A a_10707_2388# 0
C15050 a_9865_7282# cks 0
C15051 sg13cmos5l_nand2_1_1.A a_19796_3436# 0.00395f
C15052 sg13cmos5l_inv_1_2.A a_16160_9318# 0
C15053 sg13cmos5l_inv_1_0.A a_12704_4782# 0.00158f
C15054 sg13cmos5l_buf_1_103.A ph_sw[9] 0
C15055 a_16572_4261# sg13cmos5l_nor2_1_1.A 0
C15056 a_3241_2746# a_3496_1758# 0
C15057 a_8439_6178# a_8247_5770# 0.00127f
C15058 sg13cmos5l_dfrbp_1_8.RESET_B a_8772_8440# 0.50833f
C15059 a_2248_9224# sg13cmos5l_dfrbp_1_8.RESET_B 0.00212f
C15060 sg13cmos5l_buf_1_73.X pl_sw[3] 0.0201f
C15061 sg13cmos5l_nor2b_1_0.Y a_11980_4948# 0.00372f
C15062 sg13cmos5l_dfrbp_1_0.D a_17700_3456# 0.03778f
C15063 sg13cmos5l_inv_1_27.Y a_12912_6924# 0
C15064 a_11268_2826# sg13cmos5l_buf_1_8.A 0
C15065 sg13cmos5l_inv_1_18.A a_8982_7354# 0.00188f
C15066 sg13cmos5l_dfrbp_1_23.Q_N VPWR 0.25077f
C15067 sg13cmos5l_dfrbp_1_0.CLK a_18959_3215# 0
C15068 a_8592_5412# VPWR 0
C15069 a_16068_6928# a_17584_7166# 0.00159f
C15070 a_16485_6935# a_16587_6935# 0.6663f
C15071 sg13cmos5l_dfrbp_1_6.D sg13cmos5l_or2_1_1.B 0
C15072 sg13cmos5l_buf_1_10.A sg13cmos5l_buf_1_8.A 0
C15073 a_7052_9150# pl_sw[4] 0
C15074 sg13cmos5l_buf_1_6.A sg13cmos5l_dfrbp_1_4.Q_N 0.00433f
C15075 sg13cmos5l_a22oi_1_1.A1 a_15380_3436# 0
C15076 sg13cmos5l_dfrbp_1_8.RESET_B a_7537_4727# 0
C15077 a_12625_2749# a_11973_1605# 0
C15078 a_11979_2399# a_12815_1703# 0
C15079 a_18615_5770# a_18363_4270# 0.00445f
C15080 sg13cmos5l_dfrbp_1_6.D a_12567_7282# 0.00196f
C15081 a_19161_3453# VPWR 0.00145f
C15082 sg13cmos5l_buf_1_19.A a_19344_6484# 0
C15083 a_10282_7897# a_10725_7653# 0.02241f
C15084 sg13cmos5l_buf_1_57.X a_10308_7992# 0.0081f
C15085 sg13cmos5l_buf_1_3.A sg13cmos5l_nand2_1_1.A 0.02448f
C15086 sg13cmos5l_dfrbp_1_8.RESET_B a_3856_3358# 0
C15087 sg13cmos5l_dfrbp_1_6.RESET_B sg13cmos5l_dlhr_1_2.Q 0.30219f
C15088 sg13cmos5l_or2_1_0.A a_13284_3456# 0
C15089 a_2348_7624# a_2790_7996# 0
C15090 a_2596_7996# a_2554_8112# 0.00949f
C15091 a_1948_7964# a_3574_7850# 0
C15092 a_8783_7751# sg13cmos5l_dlhr_1_5.Q_N 0
C15093 sg13cmos5l_dfrbp_1_6.RESET_B a_5508_2813# 0.02314f
C15094 a_13161_7281# sg13cmos5l_a22oi_1_1.B2 0
C15095 a_19028_5412# sg13cmos5l_buf_8_0.A 0.01387f
C15096 a_6184_9224# sg13cmos5l_inv_1_14.A 0
C15097 sg13cmos5l_buf_1_74.X a_7052_9150# 0.00779f
C15098 sg13cmos5l_inv_1_2.A a_12232_8436# 0
C15099 sg13cmos5l_buf_1_0.X a_20392_2388# 0
C15100 a_5414_6162# a_6117_6141# 0.02453f
C15101 sg13cmos5l_dfrbp_1_18.Q VPWR 0.99265f
C15102 a_1864_9224# a_1862_8874# 0
C15103 a_11846_9186# pl_sw[6] 0.0488f
C15104 a_17972_4948# sg13cmos5l_or2_1_0.A 0
C15105 sg13cmos5l_nand2_1_1.B a_15466_2356# 0
C15106 sg13cmos5l_dfrbp_1_6.RESET_B a_12616_5498# 0.01636f
C15107 a_14889_7281# sg13cmos5l_dlhr_1_13.Q_N 0.00294f
C15108 a_15592_6200# a_16234_6385# 0.00308f
C15109 sg13cmos5l_dfrbp_1_8.RESET_B a_2148_8440# 0.503f
C15110 sg13cmos5l_buf_1_64.A cks 0.00503f
C15111 sg13cmos5l_buf_1_79.X a_9060_8861# 0.00325f
C15112 sg13cmos5l_nor2_1_0.A sg13cmos5l_a22oi_1_0.Y 0
C15113 a_2638_6477# sg13cmos5l_inv_1_19.A 0
C15114 a_20492_8400# sg13cmos5l_buf_8_0.X 0
C15115 sg13cmos5l_dfrbp_1_6.RESET_B a_10230_4632# 0
C15116 sg13cmos5l_dfrbp_1_16.Q a_6602_5692# 0
C15117 sg13cmos5l_buf_1_18.A a_19216_3358# 0.05498f
C15118 sg13cmos5l_dfrbp_1_6.D a_5799_5499# 0
C15119 sg13cmos5l_buf_1_44.X a_5800_9224# 0
C15120 sg13cmos5l_dfrbp_1_6.RESET_B a_5600_8522# 0.00235f
C15121 a_11769_7989# VPWR 0
C15122 sg13cmos5l_and3_1_0.C a_13556_2388# 0
C15123 sg13cmos5l_dlhr_1_15.D sg13cmos5l_a221oi_1_0.C1 0.03765f
C15124 sg13cmos5l_dfrbp_1_6.RESET_B a_4873_3192# 0.01288f
C15125 a_3313_8797# a_3826_8874# 0
C15126 sg13cmos5l_inv_1_2.A a_17233_7285# 0
C15127 a_3407_8797# sg13cmos5l_dfrbp_1_17.Q_N 0.04107f
C15128 a_3664_8678# sg13cmos5l_dfrbp_1_15.D 0.003f
C15129 sg13cmos5l_dlhr_1_0.GATE a_5510_4338# 0.04548f
C15130 a_10412_6126# a_10230_4632# 0
C15131 sg13cmos5l_buf_1_29.A a_9111_4666# 0.00588f
C15132 a_2732_9150# ph_sw[2] 0
C15133 sg13cmos5l_dfrbp_1_8.RESET_B a_3562_4873# 0.34412f
C15134 sg13cmos5l_dfrbp_1_16.Q sg13cmos5l_dlhr_1_5.D 0.00147f
C15135 sg13cmos5l_buf_8_0.X a_20672_4782# 0
C15136 sg13cmos5l_buf_1_87.A sg13cmos5l_dlhr_1_15.Q_N 0.01292f
C15137 a_13324_4696# sg13cmos5l_or2_1_0.A 0
C15138 sg13cmos5l_dfrbp_1_6.RESET_B a_15208_6200# 0.03047f
C15139 a_7238_7674# a_7941_7653# 0.02453f
C15140 sg13cmos5l_dfrbp_1_6.RESET_B a_6346_4873# 0
C15141 sg13cmos5l_dfrbp_1_4.D VPWR 0.46089f
C15142 sg13cmos5l_nand2_1_0.A a_11877_2399# 0.01501f
C15143 a_1280_6294# a_1125_5423# 0.00429f
C15144 sg13cmos5l_buf_1_77.X a_7153_8797# 0
C15145 sg13cmos5l_nand2_1_1.B a_12520_3176# 0.00162f
C15146 a_17545_7728# cks 0.00376f
C15147 sg13cmos5l_nand2_1_1.B a_10331_1924# 0.04462f
C15148 sg13cmos5l_inv_1_11.Y sg13cmos5l_dlhr_1_0.D 0
C15149 sg13cmos5l_buf_1_26.A a_9260_2352# 0.0085f
C15150 sg13cmos5l_buf_1_25.A sg13cmos5l_buf_1_26.X 0.00246f
C15151 sg13cmos5l_dfrbp_1_17.D a_2122_8404# 0.00314f
C15152 a_20008_8436# a_20492_8400# 0.03472f
C15153 a_4244_6924# VPWR 0.11291f
C15154 a_19227_9190# sg13cmos5l_buf_1_18.A 0
C15155 sg13cmos5l_dlhr_1_1.GATE a_4660_7312# 0
C15156 sg13cmos5l_buf_1_31.X a_5770_3868# 0
C15157 a_3692_9150# sg13cmos5l_inv_1_8.A 0
C15158 sg13cmos5l_buf_1_97.A a_10827_7796# 0
C15159 sg13cmos5l_dlhr_1_11.GATE a_8783_7751# 0
C15160 sg13cmos5l_inv_1_28.Y sg13cmos5l_dlhr_1_6.D 0
C15161 sg13cmos5l_dfrbp_1_10.Q a_9164_1590# 0
C15162 a_7820_2352# a_7508_1948# 0.00504f
C15163 a_8204_2352# a_7689_1626# 0.00475f
C15164 sg13cmos5l_dlhr_1_10.Q_N a_20488_6294# 0.02372f
C15165 a_416_3986# a_424_3270# 0.00273f
C15166 sg13cmos5l_dfrbp_1_2.D a_10331_3900# 0
C15167 sg13cmos5l_buf_1_105.A pl_sw[9] 0.01077f
C15168 sg13cmos5l_dfrbp_1_6.RESET_B sg13cmos5l_dlygate4sd3_1_0.X 0
C15169 sg13cmos5l_dfrbp_1_6.D a_1227_6935# 0
C15170 sg13cmos5l_inv_1_3.A VPWR 0.78883f
C15171 sg13cmos5l_dlhr_1_15.D sg13cmos5l_o21ai_1_0.B1 0
C15172 a_4349_7636# a_4514_7666# 0.00722f
C15173 sg13cmos5l_a22oi_1_1.A1 sg13cmos5l_buf_1_19.X 0
C15174 sg13cmos5l_nor2_1_1.A a_16011_2399# 0.01949f
C15175 sg13cmos5l_buf_1_19.A a_19227_4654# 0.00171f
C15176 a_5926_6175# sg13cmos5l_dlhr_1_0.GATE 0
C15177 sg13cmos5l_buf_1_0.A a_19216_3358# 0.00623f
C15178 sg13cmos5l_buf_1_107.X a_19624_8436# 0.00165f
C15179 a_11473_7751# a_11560_7010# 0
C15180 a_14900_2352# sg13cmos5l_nor2b_1_1.Y 0.04387f
C15181 sg13cmos5l_inv_1_0.Y a_9940_4636# 0
C15182 a_10587_4692# a_10789_4654# 0.01126f
C15183 sg13cmos5l_inv_1_17.A nl_sw[2] 0
C15184 sg13cmos5l_nor2_1_0.A a_13556_2388# 0.16275f
C15185 a_516_7362# VPWR 0
C15186 sg13cmos5l_dlhr_1_2.D a_7095_1642# 0
C15187 sg13cmos5l_buf_1_77.A a_9076_5800# 0.00145f
C15188 a_10900_7312# cks 0
C15189 a_5908_3124# sg13cmos5l_buf_1_24.X 0
C15190 a_7316_3460# VPWR 0.11944f
C15191 sg13cmos5l_nor2_1_1.A a_16936_1758# 0
C15192 sg13cmos5l_dfrbp_1_8.D a_19412_6484# 0
C15193 VPWR nl_sw[1] 0.1227f
C15194 sg13cmos5l_dfrbp_1_18.Q a_8233_6216# 0
C15195 nh_sw[2] nh_sw[3] 0.03616f
C15196 sg13cmos5l_buf_1_5.X a_17414_3138# 0
C15197 a_5637_2399# sg13cmos5l_buf_1_24.X 0.00786f
C15198 a_16703_3871# sg13cmos5l_nor2_1_1.A 0
C15199 a_4934_2826# VPWR 0.93187f
C15200 sg13cmos5l_dlhr_1_6.D a_8796_5814# 0
C15201 sg13cmos5l_dfrbp_1_8.RESET_B a_10031_8797# 0.21706f
C15202 sg13cmos5l_dlhr_1_12.D cks 0.02406f
C15203 sg13cmos5l_dfrbp_1_6.D a_16234_6385# 0.00756f
C15204 sg13cmos5l_dlhr_1_5.Q a_8841_5769# 0
C15205 sg13cmos5l_inv_1_2.A sg13cmos5l_buf_1_2.X 0
C15206 sg13cmos5l_inv_1_26.Y sg13cmos5l_inv_1_6.A 0
C15207 a_20488_4782# a_20672_4782# 0.11523f
C15208 sg13cmos5l_buf_1_45.X a_8784_6484# 0
C15209 a_15821_3864# cks 0.02382f
C15210 sg13cmos5l_dfrbp_1_6.RESET_B sg13cmos5l_buf_1_98.A 0.04189f
C15211 sg13cmos5l_dfrbp_1_6.D sg13cmos5l_buf_1_32.A 0.02944f
C15212 sg13cmos5l_inv_1_8.Y a_1121_4166# 0.0134f
C15213 sg13cmos5l_dfrbp_1_22.D a_17367_8794# 0.24813f
C15214 sg13cmos5l_inv_1_1.A a_15208_6200# 0.29087f
C15215 sg13cmos5l_buf_1_110.A a_15592_6200# 0.01311f
C15216 sg13cmos5l_dfrbp_1_21.Q a_11873_5760# 0
C15217 a_19240_7712# a_18999_6178# 0.00168f
C15218 sg13cmos5l_buf_1_31.X sg13cmos5l_dlhr_1_6.D 0.0221f
C15219 a_16587_6935# a_17327_7285# 0.3087f
C15220 a_16068_6928# sg13cmos5l_dfrbp_1_8.D 0
C15221 a_7336_9224# pl_sw[5] 0.2906f
C15222 sg13cmos5l_nand2_1_1.A a_14449_3215# 0.00634f
C15223 sg13cmos5l_dfrbp_1_4.Q_N a_12815_1703# 0
C15224 a_3976_9224# a_3407_8797# 0.00648f
C15225 sg13cmos5l_inv_1_29.Y a_11844_4325# 0
C15226 sg13cmos5l_a22oi_1_1.A1 a_16204_4338# 0.0111f
C15227 a_19209_5769# a_18363_4270# 0.00368f
C15228 a_13258_3361# a_13572_3151# 0.00659f
C15229 a_620_2352# VPWR 0.25133f
C15230 a_2348_7624# sg13cmos5l_dfrbp_1_16.Q_N 0.00313f
C15231 sg13cmos5l_buf_1_58.A a_2790_7996# 0
C15232 sg13cmos5l_or2_1_0.A a_15380_3436# 0.00243f
C15233 sg13cmos5l_buf_1_38.A a_4840_1664# 0
C15234 a_4244_3900# VPWR 0.3582f
C15235 sg13cmos5l_dfrbp_1_20.Q sg13cmos5l_dlhr_1_5.Q_N 0
C15236 sg13cmos5l_inv_1_6.A sg13cmos5l_dlhr_1_10.Q 0.49856f
C15237 a_14426_7288# sg13cmos5l_a22oi_1_1.B2 0
C15238 sg13cmos5l_dfrbp_1_6.RESET_B a_8588_2352# 0.00203f
C15239 sg13cmos5l_dfrbp_1_0.CLK a_13572_3151# 0
C15240 a_12516_6480# VPWR 0.08049f
C15241 a_6219_6284# a_6959_6239# 0.3087f
C15242 a_6117_6141# a_7216_6382# 0
C15243 sg13cmos5l_buf_1_60.X a_2436_8861# 0.00357f
C15244 sg13cmos5l_nand2_1_1.B a_15780_2813# 0.00153f
C15245 sg13cmos5l_buf_1_89.A a_15782_7362# 0
C15246 a_14889_7281# a_14822_6924# 0
C15247 a_13035_6284# sg13cmos5l_dfrbp_1_21.Q 0
C15248 a_18376_9224# a_18860_9150# 0.03472f
C15249 sg13cmos5l_dfrbp_1_8.RESET_B a_4244_8436# 0.00817f
C15250 sg13cmos5l_buf_1_7.A sg13cmos5l_o21ai_1_0.Y 0
C15251 a_2474_6162# sg13cmos5l_inv_1_19.A 0
C15252 sg13cmos5l_o21ai_1_0.B1 sg13cmos5l_o21ai_1_0.A2 0.26329f
C15253 sg13cmos5l_dfrbp_1_6.D a_10028_6126# 0.00359f
C15254 sg13cmos5l_dfrbp_1_16.Q a_8041_5770# 0.01693f
C15255 sg13cmos5l_nor2_1_0.A sg13cmos5l_buf_1_46.A 0
C15256 sg13cmos5l_buf_1_29.A sg13cmos5l_dfrbp_1_10.Q 0.0294f
C15257 sg13cmos5l_buf_1_45.A sg13cmos5l_nand2_1_0.B 0
C15258 a_2224_5654# sg13cmos5l_inv_1_19.A 0.00928f
C15259 sg13cmos5l_dlhr_1_9.D a_8841_5769# 0.00966f
C15260 sg13cmos5l_a22oi_1_1.B1 a_14900_2352# 0
C15261 sg13cmos5l_buf_1_19.A a_18164_6924# 0
C15262 sg13cmos5l_dlhr_1_1.GATE a_1956_4338# 0
C15263 sg13cmos5l_or2_1_1.B a_11873_5760# 0
C15264 a_12216_5728# a_13076_5376# 0
C15265 sg13cmos5l_buf_8_0.X a_19616_3986# 0
C15266 sg13cmos5l_dfrbp_1_6.RESET_B a_7153_8797# 0
C15267 a_7524_7992# a_7796_6460# 0
C15268 VPWR cks 3.08199f
C15269 sg13cmos5l_dlhr_1_0.GATE a_6084_4325# 0.01959f
C15270 sg13cmos5l_inv_1_8.A a_6959_6239# 0
C15271 sg13cmos5l_nand2_1_1.B a_14814_3876# 0.01749f
C15272 a_2340_3456# a_2824_2388# 0
C15273 a_2054_3138# sg13cmos5l_buf_1_37.A 0
C15274 sg13cmos5l_dfrbp_1_6.RESET_B a_3860_2388# 0.10737f
C15275 sg13cmos5l_buf_1_29.A sg13cmos5l_inv_1_0.Y 0
C15276 sg13cmos5l_dfrbp_1_15.D sg13cmos5l_buf_1_40.A 0
C15277 sg13cmos5l_dfrbp_1_1.Q a_11877_2399# 0
C15278 a_12520_4782# sg13cmos5l_or2_1_0.A 0
C15279 a_12980_6924# sg13cmos5l_inv_1_0.A 0
C15280 a_13100_8400# sg13cmos5l_dlhr_1_11.Q 0.00194f
C15281 a_7524_7992# a_8783_7751# 0.01741f
C15282 sg13cmos5l_dfrbp_1_6.RESET_B a_6180_4650# 0
C15283 sg13cmos5l_dfrbp_1_1.D a_9448_1664# 0
C15284 sg13cmos5l_dfrbp_1_18.Q sg13cmos5l_buf_1_97.A 0
C15285 sg13cmos5l_dfrbp_1_11.Q a_7316_3460# 0
C15286 sg13cmos5l_nor2b_1_0.Y sg13cmos5l_buf_1_8.A 0.52646f
C15287 sg13cmos5l_inv_1_18.A a_8588_3864# 0
C15288 a_18117_3117# sg13cmos5l_buf_1_19.X 0
C15289 sg13cmos5l_nand2_1_0.A a_12976_2630# 0.00909f
C15290 sg13cmos5l_buf_1_77.X a_8772_8440# 0
C15291 sg13cmos5l_dlhr_1_11.GATE a_12420_9199# 0
C15292 sg13cmos5l_nand2_1_1.B a_12075_1748# 0
C15293 sg13cmos5l_dfrbp_1_0.Q a_18122_2388# 0.00374f
C15294 sg13cmos5l_dfrbp_1_6.RESET_B a_2054_3138# 0.12735f
C15295 a_13035_6284# sg13cmos5l_or2_1_1.B 0
C15296 sg13cmos5l_buf_1_24.A a_9544_2474# 0
C15297 sg13cmos5l_buf_1_31.X a_7312_4142# 0
C15298 a_12232_8436# a_12716_8400# 0.03472f
C15299 sg13cmos5l_dlhr_1_11.GATE sg13cmos5l_dfrbp_1_20.Q 0
C15300 sg13cmos5l_buf_1_110.A sg13cmos5l_dfrbp_1_6.D 0.02345f
C15301 sg13cmos5l_dfrbp_1_16.Q a_3625_7282# 0.16371f
C15302 sg13cmos5l_dlhr_1_0.D a_8214_1608# 0.01143f
C15303 sg13cmos5l_buf_1_10.A sg13cmos5l_o21ai_1_0.A1 0.05909f
C15304 a_10028_6126# a_10024_5498# 0.00679f
C15305 sg13cmos5l_dfrbp_1_6.D sg13cmos5l_dfrbp_1_16.Q 0.02097f
C15306 a_9865_7282# sg13cmos5l_a22oi_1_2.B2 0
C15307 sg13cmos5l_nor2_1_1.A sg13cmos5l_dfrbp_1_5.Q_N 0.0102f
C15308 sg13cmos5l_dfrbp_1_8.RESET_B sg13cmos5l_dlhr_1_11.Q 0.00229f
C15309 sg13cmos5l_buf_1_44.X sg13cmos5l_dlhr_1_3.Q_N 0
C15310 sg13cmos5l_buf_1_57.X sg13cmos5l_inv_1_0.A 0
C15311 sg13cmos5l_dlhr_1_11.D a_13161_7281# 0
C15312 sg13cmos5l_dlhr_1_6.D sg13cmos5l_a221oi_1_0.C1 0
C15313 a_12698_7288# cks 0
C15314 ph_sw[6] pl_sw[6] 0.11709f
C15315 pl_sw[8] ph_sw[8] 0.92098f
C15316 a_17961_8793# sg13cmos5l_dlhr_1_12.Q_N 0.00294f
C15317 sg13cmos5l_or2_1_0.A sg13cmos5l_buf_1_19.X 0.00164f
C15318 a_7430_3576# VPWR 0.00482f
C15319 sg13cmos5l_dfrbp_1_6.D a_3688_1664# 0
C15320 sg13cmos5l_and3_1_0.C sg13cmos5l_nand2_1_1.B 0.01823f
C15321 sg13cmos5l_dlhr_1_5.GATE a_7657_7282# 0.04726f
C15322 a_6479_2749# sg13cmos5l_buf_1_24.X 0
C15323 sg13cmos5l_dfrbp_1_6.RESET_B a_2228_4972# 0.12861f
C15324 a_5446_2813# VPWR 0
C15325 sg13cmos5l_dfrbp_1_8.RESET_B a_11848_8436# 0.0189f
C15326 a_12106_9409# a_12232_8436# 0
C15327 sg13cmos5l_a22oi_1_0.Y a_11054_4292# 0
C15328 sg13cmos5l_buf_1_4.X sg13cmos5l_dfrbp_1_0.Q 0.01854f
C15329 sg13cmos5l_dfrbp_1_6.D a_17519_6239# 0.01646f
C15330 a_14628_8440# a_14426_7288# 0
C15331 sg13cmos5l_buf_1_24.A a_6903_3154# 0.00496f
C15332 sg13cmos5l_dfrbp_1_8.RESET_B sg13cmos5l_buf_1_30.A 2.45645f
C15333 sg13cmos5l_dlhr_1_16.Q d_out[2] 0.00416f
C15334 a_12358_5388# VPWR 0.01649f
C15335 a_16551_3987# cks 0.03667f
C15336 a_9256_9224# sg13cmos5l_inv_1_2.A 0.00832f
C15337 sg13cmos5l_a22oi_1_1.B2 sg13cmos5l_nand2_1_0.A 0
C15338 sg13cmos5l_inv_1_8.A a_2621_7636# 0
C15339 a_12404_7972# a_12841_7728# 0.00314f
C15340 sg13cmos5l_buf_1_103.A a_16271_7751# 0
C15341 sg13cmos5l_buf_1_57.X a_12490_6385# 0.01462f
C15342 sg13cmos5l_inv_1_8.A a_5770_3868# 0.00209f
C15343 a_9524_4972# VPWR 0.11082f
C15344 sg13cmos5l_dfrbp_1_21.Q a_12800_5498# 0.00207f
C15345 sg13cmos5l_buf_1_90.X a_11940_9186# 0
C15346 a_4076_7624# sg13cmos5l_dlhr_1_9.D 0
C15347 a_17584_7166# sg13cmos5l_dfrbp_1_8.D 0
C15348 a_17327_7285# sg13cmos5l_dfrbp_1_22.Q_N 0.04107f
C15349 a_17233_7285# a_17746_7362# 0
C15350 sg13cmos5l_buf_1_18.A a_19130_6172# 0.06551f
C15351 a_1463_8511# sg13cmos5l_buf_1_61.X 0
C15352 sg13cmos5l_nor2b_1_0.Y a_10433_4248# 0
C15353 a_3609_8559# VPWR 0
C15354 sg13cmos5l_nor2_1_0.A a_10613_2758# 0.02069f
C15355 a_5492_3460# sg13cmos5l_buf_1_24.X 0
C15356 sg13cmos5l_nor2_1_1.A a_14924_1590# 0.00123f
C15357 a_5079_3154# VPWR 0.19194f
C15358 sg13cmos5l_dfrbp_1_16.Q a_10024_5498# 0.00703f
C15359 a_4460_9150# sg13cmos5l_dfrbp_1_15.D 0.00115f
C15360 sg13cmos5l_a22oi_1_1.A1 a_14814_3876# 0.00704f
C15361 a_13701_3117# a_14449_3215# 0.01058f
C15362 sg13cmos5l_dfrbp_1_6.RESET_B a_11272_8522# 0.00244f
C15363 sg13cmos5l_dlhr_1_15.D a_14714_5776# 0.0142f
C15364 sg13cmos5l_buf_1_33.A a_2248_1664# 0.32547f
C15365 sg13cmos5l_buf_1_58.A sg13cmos5l_dfrbp_1_16.Q_N 0.0049f
C15366 sg13cmos5l_inv_1_3.A sg13cmos5l_dlhr_1_11.Q_N 0.01491f
C15367 a_18345_7674# a_18580_7660# 0.00566f
C15368 a_18164_7996# a_18300_7710# 0.00404f
C15369 sg13cmos5l_dlhr_1_15.Q a_20392_7712# 0
C15370 a_14612_6460# VPWR 0.35357f
C15371 a_18368_4782# sg13cmos5l_a22oi_1_1.A1 0
C15372 sg13cmos5l_or2_1_0.A a_16204_4338# 0
C15373 sg13cmos5l_buf_1_45.X a_5820_5773# 0
C15374 a_7216_6382# a_7161_6477# 0.00464f
C15375 a_6219_6284# sg13cmos5l_dlhr_1_6.D 0
C15376 a_15784_9224# ph_sw[8] 0
C15377 sg13cmos5l_inv_1_2.A sg13cmos5l_dfrbp_1_0.CLK 0.09412f
C15378 sg13cmos5l_buf_1_116.A sg13cmos5l_dfrbp_1_21.Q 0.02723f
C15379 a_12516_6480# a_12814_4692# 0
C15380 a_5132_9150# cks 0.00799f
C15381 sg13cmos5l_dfrbp_1_6.D a_14166_7656# 0
C15382 sg13cmos5l_dfrbp_1_6.D a_4005_4629# 0
C15383 sg13cmos5l_dlhr_1_1.D sg13cmos5l_inv_1_19.A 0.04993f
C15384 a_2565_3911# VPWR 0.24597f
C15385 a_18219_3260# VPWR 0.22813f
C15386 a_12216_5728# sg13cmos5l_and3_1_0.X 0
C15387 sg13cmos5l_or2_1_1.B a_12800_5498# 0.00698f
C15388 sg13cmos5l_dfrbp_1_6.RESET_B a_8772_8440# 0.00233f
C15389 a_9879_9202# a_9291_8447# 0
C15390 sg13cmos5l_nor2_1_0.A sg13cmos5l_nand2_1_1.B 1.16906f
C15391 sg13cmos5l_inv_1_14.A a_7657_7282# 0
C15392 a_8043_7796# sg13cmos5l_dlhr_1_6.D 0
C15393 a_424_3270# comp_p 0.00264f
C15394 sg13cmos5l_dlhr_1_0.GATE a_6153_3947# 0
C15395 a_12216_5728# sg13cmos5l_inv_1_0.Y 0
C15396 sg13cmos5l_or2_1_1.B a_10587_4692# 0
C15397 sg13cmos5l_or2_1_0.A a_12520_3176# 0
C15398 sg13cmos5l_inv_1_27.Y a_10202_7288# 0
C15399 a_1948_7964# a_2621_7636# 0.09085f
C15400 a_2348_7624# a_2596_7996# 0.68988f
C15401 a_7524_7992# sg13cmos5l_dlhr_1_5.Q 0
C15402 sg13cmos5l_buf_1_95.X sg13cmos5l_dfrbp_1_23.CLK 0.01165f
C15403 sg13cmos5l_inv_1_8.A ph_sw[1] 0.01159f
C15404 a_1967_7285# cks 0
C15405 a_5510_4338# a_5604_4338# 0.00718f
C15406 sg13cmos5l_dfrbp_1_1.Q a_12976_2630# 0.00181f
C15407 sg13cmos5l_dfrbp_1_6.D sg13cmos5l_a22oi_1_1.Y 0
C15408 a_1760_9318# a_1484_9150# 0.00624f
C15409 sg13cmos5l_buf_1_110.A a_15147_8447# 0.03286f
C15410 a_12075_3911# a_12815_4261# 0.3087f
C15411 a_14708_6924# a_14889_7281# 0.40925f
C15412 sg13cmos5l_buf_1_9.A a_11270_1626# 0.02386f
C15413 sg13cmos5l_dfrbp_1_0.RESET_B a_12719_2749# 0.26101f
C15414 sg13cmos5l_a221oi_1_0.A2 sg13cmos5l_nand2_1_0.A 0.00281f
C15415 a_7941_7653# a_8689_7751# 0.01058f
C15416 sg13cmos5l_dfrbp_1_6.D sg13cmos5l_inv_1_9.Y 0.00281f
C15417 sg13cmos5l_buf_1_45.X VPWR 0.87151f
C15418 sg13cmos5l_dfrbp_1_11.Q a_7430_3576# 0
C15419 sg13cmos5l_nand2_1_0.A a_14254_2444# 0.00933f
C15420 a_18865_3215# a_18760_2388# 0
C15421 sg13cmos5l_and3_1_0.C sg13cmos5l_a22oi_1_1.A1 0.01015f
C15422 a_17545_7728# pl_sw[9] 0
C15423 sg13cmos5l_nand2_1_1.B a_14440_1664# 0
C15424 sg13cmos5l_dfrbp_1_6.RESET_B a_3856_3358# 0.18223f
C15425 sg13cmos5l_dlhr_1_1.GATE a_1815_4666# 0.28617f
C15426 a_5104_4870# sg13cmos5l_buf_1_44.A 0.00133f
C15427 sg13cmos5l_dfrbp_1_8.RESET_B pl_sw[5] 0
C15428 a_416_7806# pl_sw[0] 0.01136f
C15429 a_9033_6162# a_9242_4660# 0.00273f
C15430 a_8852_6484# a_8905_4704# 0
C15431 a_9558_6144# a_9111_4666# 0
C15432 sg13cmos5l_buf_1_31.X a_8972_3864# 0
C15433 a_17386_1849# nh_sw[8] 0.00235f
C15434 a_1121_4166# sg13cmos5l_buf_1_32.A 0
C15435 sg13cmos5l_dlhr_1_0.D a_7622_2064# 0.00124f
C15436 sg13cmos5l_dfrbp_1_16.Q a_4950_7354# 0
C15437 a_16260_6480# cks 0.02584f
C15438 sg13cmos5l_buf_1_97.A cks 1.18778f
C15439 sg13cmos5l_dfrbp_1_11.Q a_9524_4972# 0
C15440 sg13cmos5l_dfrbp_1_9.Q a_2824_2388# 0.0024f
C15441 sg13cmos5l_inv_1_5.A sg13cmos5l_dfrbp_1_3.Q_N 0.00207f
C15442 sg13cmos5l_buf_1_87.A a_18345_7674# 0.01215f
C15443 sg13cmos5l_dlhr_1_9.D sg13cmos5l_dlhr_1_1.D 0.02075f
C15444 a_1280_6294# a_708_5416# 0
C15445 sg13cmos5l_buf_1_45.A sg13cmos5l_a221oi_1_1.C1 0
C15446 sg13cmos5l_dfrbp_1_6.RESET_B a_2148_8440# 0
C15447 sg13cmos5l_dlhr_1_5.GATE a_7394_5850# 0
C15448 a_12230_6162# sg13cmos5l_nor2_1_0.A 0
C15449 sg13cmos5l_nand2_1_0.B sg13cmos5l_o21ai_1_0.A2 0.12489f
C15450 a_17224_3270# a_16751_2749# 0.01067f
C15451 sg13cmos5l_buf_1_57.X a_9242_4660# 0
C15452 sg13cmos5l_buf_1_64.A sg13cmos5l_buf_1_34.X 0.03519f
C15453 a_3976_9224# sg13cmos5l_buf_1_60.A 0
C15454 a_1125_6935# a_1125_5423# 0.00861f
C15455 a_18568_7010# a_18615_5770# 0
C15456 a_18860_6888# a_18746_5776# 0
C15457 sg13cmos5l_buf_1_3.A a_18345_7674# 0
C15458 sg13cmos5l_buf_1_105.A a_19340_8400# 0.00186f
C15459 sg13cmos5l_dlhr_1_9.Q a_4177_7326# 0.00154f
C15460 sg13cmos5l_buf_1_5.A a_13076_5376# 0
C15461 sg13cmos5l_dfrbp_1_6.RESET_B sg13cmos5l_buf_1_4.X 0.00132f
C15462 sg13cmos5l_buf_1_29.A a_9268_6148# 0
C15463 a_1088_7806# sg13cmos5l_inv_1_19.A 0
C15464 a_8204_2352# VPWR 0.25258f
C15465 sg13cmos5l_a221oi_1_0.B1 a_12075_3911# 0
C15466 a_5951_5383# a_6346_4873# 0.00406f
C15467 sg13cmos5l_inv_1_2.A a_10473_9186# 0.01793f
C15468 sg13cmos5l_buf_1_90.X sg13cmos5l_inv_1_7.A 0.00723f
C15469 sg13cmos5l_dlhr_1_12.D pl_sw[9] 0
C15470 sg13cmos5l_dfrbp_1_6.D sg13cmos5l_dfrbp_1_21.Q_N 0.19407f
C15471 a_12651_9308# VPWR 0.20877f
C15472 sg13cmos5l_buf_1_78.A sg13cmos5l_dlhr_1_5.GATE 0.0026f
C15473 a_11556_1944# nh_sw[5] 0.00688f
C15474 a_16462_4023# cks 0
C15475 sg13cmos5l_buf_1_24.A a_5220_2392# 0.00206f
C15476 sg13cmos5l_buf_1_73.A pl_sw[3] 0
C15477 a_13792_5760# a_14377_5770# 0
C15478 a_17161_8794# ph_sw[8] 0
C15479 a_422_7362# VPWR 0.92921f
C15480 sg13cmos5l_buf_1_103.A sg13cmos5l_dlhr_1_15.D 0.00296f
C15481 sg13cmos5l_inv_1_8.A a_7312_4142# 0.00255f
C15482 sg13cmos5l_buf_1_57.X a_13775_6239# 0.02411f
C15483 sg13cmos5l_o21ai_1_0.A2 nl_sw[6] 0.00886f
C15484 sg13cmos5l_buf_1_107.X a_18486_8866# 0
C15485 a_13047_7690# cks 0.00417f
C15486 a_8084_8436# VPWR 0.35649f
C15487 sg13cmos5l_nor2_1_0.A sg13cmos5l_a22oi_1_1.A1 0
C15488 sg13cmos5l_buf_1_44.X sg13cmos5l_buf_1_38.A 0.12329f
C15489 a_5606_3576# VPWR 0.00482f
C15490 sg13cmos5l_a22oi_1_1.A1 a_18146_4338# 0
C15491 a_5796_3904# sg13cmos5l_buf_1_25.A 0
C15492 a_15380_3436# sg13cmos5l_dfrbp_1_7.Q_N 0.25039f
C15493 sg13cmos5l_buf_1_34.A a_4840_1664# 0.32805f
C15494 a_4934_2826# sg13cmos5l_buf_1_25.X 0.00505f
C15495 a_3793_2790# VPWR 0
C15496 sg13cmos5l_buf_1_60.X sg13cmos5l_dfrbp_1_8.RESET_B 0.32188f
C15497 sg13cmos5l_dlhr_1_15.D a_15177_5769# 0.01145f
C15498 sg13cmos5l_buf_1_101.X a_18486_8866# 0
C15499 sg13cmos5l_inv_1_18.A a_9202_7674# 0
C15500 sg13cmos5l_nor2b_1_0.Y sg13cmos5l_o21ai_1_0.A1 0.10736f
C15501 a_1864_1664# nl_sw[2] 0
C15502 sg13cmos5l_buf_1_45.X a_8233_6216# 0.04623f
C15503 sg13cmos5l_buf_1_45.X sg13cmos5l_dfrbp_1_11.Q 1.76369f
C15504 sg13cmos5l_buf_1_77.A a_8982_7354# 0.04359f
C15505 sg13cmos5l_or2_1_0.A a_14814_3876# 0.00536f
C15506 sg13cmos5l_dfrbp_1_6.RESET_B sg13cmos5l_buf_1_28.X 0.0023f
C15507 sg13cmos5l_dfrbp_1_16.Q a_3826_4338# 0
C15508 sg13cmos5l_a22oi_1_2.B2 VPWR 0.55658f
C15509 a_8276_6924# sg13cmos5l_dlhr_1_6.D 0
C15510 sg13cmos5l_dlhr_1_5.Q a_7796_6460# 0
C15511 sg13cmos5l_inv_1_7.A a_11190_7354# 0
C15512 a_2314_3361# VPWR 0.11995f
C15513 a_8276_6924# a_8412_7326# 0.00404f
C15514 a_8457_7281# a_8982_7354# 0.13715f
C15515 sg13cmos5l_dfrbp_1_6.D a_4847_4727# 0.02945f
C15516 sg13cmos5l_or2_1_0.A a_18368_4782# 0
C15517 sg13cmos5l_o21ai_1_0.B1 a_11460_2392# 0
C15518 sg13cmos5l_dfrbp_1_6.RESET_B a_10031_8797# 0.08227f
C15519 sg13cmos5l_inv_1_3.A a_13574_8112# 0
C15520 sg13cmos5l_buf_1_5.A sg13cmos5l_dfrbp_1_22.D 0
C15521 sg13cmos5l_dfrbp_1_6.RESET_B a_19344_6484# 0
C15522 a_9620_7972# sg13cmos5l_dlhr_1_6.D 0
C15523 a_19244_2352# nh_sw[9] 0.14039f
C15524 a_15500_9150# pl_sw[7] 0
C15525 sg13cmos5l_a221oi_1_0.A2 sg13cmos5l_dfrbp_1_1.Q 0
C15526 VPWR pl_sw[9] 0.21947f
C15527 sg13cmos5l_inv_1_27.Y sg13cmos5l_dlhr_1_18.Q_N 0
C15528 a_2596_7996# sg13cmos5l_buf_1_58.A 0.00112f
C15529 a_8783_7751# sg13cmos5l_dlhr_1_5.Q 0
C15530 sg13cmos5l_dlhr_1_9.Q a_3407_4261# 0
C15531 sg13cmos5l_buf_1_78.A sg13cmos5l_inv_1_14.A 0.01176f
C15532 sg13cmos5l_dfrbp_1_23.Q a_13076_5376# 0
C15533 a_13686_7354# sg13cmos5l_and3_1_0.X 0
C15534 sg13cmos5l_a221oi_1_0.C1 a_8972_3864# 0
C15535 a_5510_4338# a_6315_3911# 0.11742f
C15536 sg13cmos5l_dfrbp_1_1.Q a_14254_2444# 0
C15537 sg13cmos5l_buf_1_65.X a_1196_8400# 0.00253f
C15538 sg13cmos5l_dfrbp_1_20.Q_N VPWR 0.34313f
C15539 a_1864_9224# sg13cmos5l_dfrbp_1_17.D 0.0013f
C15540 sg13cmos5l_inv_1_18.A sg13cmos5l_dfrbp_1_6.D 0.02453f
C15541 sg13cmos5l_dfrbp_1_0.RESET_B sg13cmos5l_nor2_1_1.A 0.26956f
C15542 a_1484_6126# cks 0
C15543 a_13072_4142# sg13cmos5l_dfrbp_1_2.Q_N 0.15881f
C15544 a_12721_4261# a_13234_4338# 0
C15545 a_14889_7281# sg13cmos5l_buf_1_89.A 0.29123f
C15546 sg13cmos5l_nor2_1_0.A a_11771_5412# 0
C15547 a_8783_7751# sg13cmos5l_dfrbp_1_20.Q 0.00143f
C15548 a_9040_7894# a_8689_7751# 0.01017f
C15549 sg13cmos5l_buf_1_19.A sg13cmos5l_buf_1_18.A 0.66857f
C15550 a_10031_8797# a_10071_7282# 0
C15551 sg13cmos5l_buf_1_44.X sg13cmos5l_or2_1_0.A 0.02702f
C15552 sg13cmos5l_dfrbp_1_1.D a_11270_1626# 0.298f
C15553 a_8660_5412# sg13cmos5l_buf_1_46.A 0
C15554 sg13cmos5l_nor2_1_0.A a_9705_4650# 0
C15555 a_17961_8793# sg13cmos5l_dfrbp_1_22.Q_N 0
C15556 a_904_7806# a_1088_7806# 0.11523f
C15557 sg13cmos5l_buf_1_44.X sg13cmos5l_buf_1_73.X 0.0236f
C15558 sg13cmos5l_dfrbp_1_11.Q a_8204_2352# 0
C15559 sg13cmos5l_dlhr_1_15.D sg13cmos5l_a221oi_1_1.C1 0.09879f
C15560 a_2409_4650# VPWR 0.63991f
C15561 sg13cmos5l_dlhr_1_1.GATE a_1472_4782# 0
C15562 sg13cmos5l_dlhr_1_0.GATE sg13cmos5l_buf_1_44.A 0.54865f
C15563 a_11270_4338# a_10783_3876# 0
C15564 a_11973_3911# a_12815_4261# 0.0032f
C15565 a_620_7638# sg13cmos5l_buf_1_40.A 0.00278f
C15566 sg13cmos5l_buf_1_29.A sg13cmos5l_dfrbp_1_12.Q_N 0
C15567 sg13cmos5l_dlhr_1_6.D sg13cmos5l_nand2_1_0.B 0
C15568 a_17220_1626# nh_sw[8] 0
C15569 sg13cmos5l_dlhr_1_9.D a_7796_6460# 0
C15570 a_14089_7282# a_13775_6239# 0.00541f
C15571 a_14295_7282# a_14032_6382# 0
C15572 sg13cmos5l_dlhr_1_0.D a_10433_1652# 0.01263f
C15573 sg13cmos5l_buf_1_7.A nh_sw[6] 0.00698f
C15574 sg13cmos5l_buf_1_31.X a_9456_4972# 0
C15575 sg13cmos5l_and3_1_0.C sg13cmos5l_or2_1_0.A 2.40426f
C15576 sg13cmos5l_inv_1_2.A a_11360_9318# 0.00129f
C15577 sg13cmos5l_buf_1_107.X sg13cmos5l_buf_1_18.A 0
C15578 sg13cmos5l_dfrbp_1_0.RESET_B a_10464_2427# 0
C15579 a_3962_7288# a_3575_6553# 0
C15580 a_3625_7282# a_3669_6320# 0.00374f
C15581 sg13cmos5l_buf_1_28.X a_9832_1664# 0.12207f
C15582 a_17414_3138# nh_sw[7] 0
C15583 a_1864_9224# ph_sw[0] 0
C15584 sg13cmos5l_dfrbp_1_6.RESET_B a_4244_8436# 0
C15585 sg13cmos5l_dlhr_1_11.GATE a_10308_7992# 0.08689f
C15586 sg13cmos5l_inv_1_8.A a_1125_5423# 0
C15587 sg13cmos5l_dfrbp_1_6.D a_3669_6320# 0
C15588 a_11270_4338# a_11556_3904# 0.50066f
C15589 sg13cmos5l_buf_1_10.A sg13cmos5l_a22oi_1_1.B1 0.02149f
C15590 sg13cmos5l_nand2_1_1.B sg13cmos5l_o21ai_1_0.Y 0.00404f
C15591 sg13cmos5l_buf_1_25.A sg13cmos5l_dlhr_1_0.Q 0
C15592 sg13cmos5l_buf_1_26.A sg13cmos5l_buf_1_26.X 0.13752f
C15593 a_10233_8559# VPWR 0
C15594 sg13cmos5l_buf_1_5.A sg13cmos5l_and3_1_0.X 0
C15595 sg13cmos5l_dfrbp_1_8.D a_15876_4968# 0.04329f
C15596 a_1480_7806# a_1484_9150# 0
C15597 sg13cmos5l_dlhr_1_8.Q_N sg13cmos5l_inv_1_19.A 0.006f
C15598 sg13cmos5l_inv_1_7.A sg13cmos5l_dfrbp_1_21.Q 0.02458f
C15599 a_17700_3456# a_18671_1703# 0
C15600 sg13cmos5l_buf_1_4.A a_16102_4663# 0
C15601 sg13cmos5l_buf_1_34.X VPWR 1.10556f
C15602 cks ph_sw[9] 0.05547f
C15603 a_18363_4270# a_17700_3456# 0
C15604 sg13cmos5l_dfrbp_1_8.RESET_B a_16395_4772# 0.5526f
C15605 sg13cmos5l_buf_1_46.A sg13cmos5l_buf_1_26.X 0.00257f
C15606 sg13cmos5l_buf_1_24.A a_6736_2630# 0.02847f
C15607 sg13cmos5l_buf_1_24.A sg13cmos5l_dfrbp_1_10.Q 0.023f
C15608 sg13cmos5l_dfrbp_1_0.CLK nl_sw[9] 0.01158f
C15609 a_14377_5770# a_14152_5498# 0.01873f
C15610 a_14583_5770# a_14929_5814# 0.00722f
C15611 a_6188_1590# a_6572_1590# 0.00492f
C15612 sg13cmos5l_dfrbp_1_6.RESET_B a_19227_4654# 0.00522f
C15613 sg13cmos5l_buf_1_4.X a_15206_2826# 0
C15614 sg13cmos5l_buf_1_19.A sg13cmos5l_buf_1_0.A 0.65247f
C15615 sg13cmos5l_buf_8_0.A a_19216_3358# 0
C15616 a_13574_8112# cks 0
C15617 a_422_7362# a_1967_7285# 0
C15618 a_8746_8404# VPWR 0.09571f
C15619 sg13cmos5l_a221oi_1_0.B1 a_11973_3911# 0
C15620 a_20392_7712# a_20392_6924# 0.00912f
C15621 a_8439_6178# a_8785_6154# 0.00722f
C15622 a_16160_9318# pl_sw[8] 0
C15623 a_15045_8447# a_15012_7992# 0
C15624 a_14628_8440# a_15429_7653# 0
C15625 a_7055_4261# sg13cmos5l_buf_1_25.A 0
C15626 a_5446_2813# sg13cmos5l_buf_1_25.X 0
C15627 sg13cmos5l_buf_1_4.X a_16552_1664# 0.28823f
C15628 sg13cmos5l_dfrbp_1_21.Q a_18999_6178# 0
C15629 sg13cmos5l_a22oi_1_1.Y a_14962_3138# 0
C15630 sg13cmos5l_dlhr_1_15.D a_18746_5776# 0
C15631 sg13cmos5l_buf_1_24.A a_5673_3138# 0.00166f
C15632 a_1196_8400# pl_sw[1] 0
C15633 sg13cmos5l_inv_1_26.Y sg13cmos5l_buf_1_104.X 0.30148f
C15634 sg13cmos5l_buf_1_41.A a_2824_2388# 0.0055f
C15635 sg13cmos5l_nor2_1_0.A sg13cmos5l_or2_1_0.A 0.78388f
C15636 a_11268_5760# VPWR 0
C15637 sg13cmos5l_inv_1_14.A sg13cmos5l_dfrbp_1_18.Q 0
C15638 a_10318_5412# sg13cmos5l_nand2_1_0.A 0
C15639 sg13cmos5l_inv_1_9.Y a_1121_4166# 0.02338f
C15640 sg13cmos5l_inv_1_0.A sg13cmos5l_dfrbp_1_0.RESET_B 0.01217f
C15641 sg13cmos5l_dfrbp_1_6.RESET_B sg13cmos5l_dlhr_1_11.Q 0.19626f
C15642 sg13cmos5l_buf_1_94.X a_14726_7674# 0
C15643 sg13cmos5l_buf_1_110.A sg13cmos5l_buf_1_116.A 0.15713f
C15644 sg13cmos5l_inv_1_7.A sg13cmos5l_or2_1_1.B 0.01893f
C15645 a_16953_2511# VPWR 0
C15646 a_18376_9224# pl_sw[8] 0
C15647 sg13cmos5l_dfrbp_1_1.Q sg13cmos5l_dfrbp_1_3.Q_N 0
C15648 a_18870_7656# a_18793_6216# 0
C15649 sg13cmos5l_dlhr_1_15.Q a_18999_6178# 0
C15650 sg13cmos5l_dfrbp_1_6.RESET_B sg13cmos5l_a22oi_1_2.B1 0
C15651 sg13cmos5l_dlhr_1_9.D a_6213_3911# 0
C15652 sg13cmos5l_buf_1_77.X pl_sw[5] 0.01257f
C15653 sg13cmos5l_inv_1_7.A a_12567_7282# 0.00597f
C15654 sg13cmos5l_dfrbp_1_6.D a_15369_8065# 0
C15655 sg13cmos5l_buf_1_24.A a_6372_4968# 0.03707f
C15656 sg13cmos5l_inv_1_17.A a_3609_4023# 0.0011f
C15657 sg13cmos5l_dfrbp_1_6.D sg13cmos5l_dfrbp_1_14.Q_N 0.03478f
C15658 a_3599_3215# VPWR 0.27233f
C15659 sg13cmos5l_buf_1_64.A a_3407_8797# 0.0057f
C15660 sg13cmos5l_o21ai_1_0.B1 a_11979_2399# 0.00116f
C15661 a_6117_6141# a_6741_5459# 0
C15662 sg13cmos5l_dfrbp_1_6.RESET_B a_11848_8436# 0.00315f
C15663 a_13100_8400# pl_sw[6] 0.29109f
C15664 sg13cmos5l_inv_1_3.A a_14536_7806# 0.00179f
C15665 sg13cmos5l_dfrbp_1_6.RESET_B sg13cmos5l_buf_1_30.A 1.35513f
C15666 sg13cmos5l_buf_1_104.X sg13cmos5l_dlhr_1_10.Q 0
C15667 sg13cmos5l_dfrbp_1_20.Q sg13cmos5l_dlhr_1_5.Q 0.13945f
C15668 sg13cmos5l_dfrbp_1_23.Q sg13cmos5l_and3_1_0.X 0.23566f
C15669 sg13cmos5l_dlhr_1_9.Q sg13cmos5l_buf_1_38.A 0
C15670 a_5796_3904# a_6961_4261# 0.4858f
C15671 a_2122_8404# VPWR 0.10681f
C15672 sg13cmos5l_buf_1_31.X a_9544_2474# 0
C15673 a_6084_4325# a_6315_3911# 0.15089f
C15674 sg13cmos5l_inv_1_2.A sg13cmos5l_buf_1_2.A 0.24452f
C15675 sg13cmos5l_a221oi_1_0.C1 a_9456_4972# 0
C15676 a_7657_7282# a_6959_6239# 0
C15677 a_15784_9224# a_16160_9318# 0.03376f
C15678 a_19090_1626# nh_sw[9] 0
C15679 a_12815_4261# a_12998_3138# 0
C15680 sg13cmos5l_o21ai_1_0.A2 a_11072_2474# 0
C15681 a_3588_4968# sg13cmos5l_dfrbp_1_10.Q 0
C15682 a_20204_5376# a_20672_5498# 0.00114f
C15683 sg13cmos5l_dfrbp_1_6.RESET_B a_18164_6924# 0.08275f
C15684 a_16940_3102# VPWR 0.2944f
C15685 sg13cmos5l_or2_1_1.B sg13cmos5l_a221oi_1_0.B2 0.01328f
C15686 a_12651_9308# a_13047_7690# 0
C15687 a_12549_9165# a_12841_7728# 0.00282f
C15688 a_12132_9504# a_13178_7684# 0
C15689 sg13cmos5l_dlhr_1_1.Q_N VPWR 0.33185f
C15690 a_10010_9196# sg13cmos5l_dfrbp_1_8.RESET_B 0.00197f
C15691 sg13cmos5l_dfrbp_1_8.RESET_B pl_sw[6] 0.20612f
C15692 a_17700_1639# nh_sw[8] 0
C15693 a_18615_5770# a_18480_5028# 0.00503f
C15694 a_13556_2388# nh_sw[6] 0
C15695 a_15590_4650# a_16293_4629# 0.02453f
C15696 a_15850_4873# a_16395_4772# 0.00999f
C15697 a_15016_9224# a_14628_8440# 0
C15698 sg13cmos5l_dlhr_1_9.D sg13cmos5l_dlhr_1_5.Q 0
C15699 a_4244_6924# a_4652_6126# 0
C15700 a_4107_4772# a_4873_3192# 0
C15701 sg13cmos5l_dlhr_1_11.GATE a_11824_7894# 0.03296f
C15702 sg13cmos5l_dlhr_1_9.D sg13cmos5l_inv_1_19.A 0.122f
C15703 sg13cmos5l_dlhr_1_12.Q_N a_18345_7674# 0
C15704 sg13cmos5l_dfrbp_1_6.D a_5674_6385# 0.0121f
C15705 sg13cmos5l_a22oi_1_2.B1 a_9832_1664# 0.02613f
C15706 sg13cmos5l_dfrbp_1_22.D a_17425_6239# 0
C15707 sg13cmos5l_buf_1_31.X a_6903_3154# 0.0047f
C15708 sg13cmos5l_dfrbp_1_20.Q_N sg13cmos5l_buf_1_97.A 0
C15709 sg13cmos5l_a22oi_1_1.B2 a_14458_4270# 0
C15710 a_11530_3868# sg13cmos5l_dfrbp_1_0.CLK 0.00151f
C15711 a_11556_3904# a_11844_4325# 0.4806f
C15712 sg13cmos5l_dfrbp_1_6.RESET_B a_14641_7326# 0
C15713 sg13cmos5l_dlhr_1_12.D a_16485_6935# 0.00228f
C15714 a_18117_3117# sg13cmos5l_buf_1_18.X 0
C15715 sg13cmos5l_nor2_1_0.A a_11072_5347# 0.13446f
C15716 sg13cmos5l_buf_1_34.X a_5132_9150# 0.03898f
C15717 sg13cmos5l_dlhr_1_9.D sg13cmos5l_dfrbp_1_20.Q 0.0045f
C15718 sg13cmos5l_inv_1_14.A a_7316_3460# 0.02578f
C15719 sg13cmos5l_buf_1_8.A nh_sw[5] 0.06569f
C15720 a_13391_9263# sg13cmos5l_buf_1_5.A 0
C15721 sg13cmos5l_buf_1_31.X a_1192_1664# 0
C15722 sg13cmos5l_dlhr_1_14.Q_N a_13775_6239# 0
C15723 sg13cmos5l_dlhr_1_0.D sg13cmos5l_buf_1_28.A 0
C15724 sg13cmos5l_dfrbp_1_8.D a_17972_4948# 0
C15725 sg13cmos5l_dlhr_1_5.GATE cks 0.03677f
C15726 sg13cmos5l_inv_1_28.Y a_11473_7751# 0.01606f
C15727 a_19216_3358# a_18928_1846# 0
C15728 a_18959_3215# a_19508_1924# 0.00149f
C15729 a_14928_5412# sg13cmos5l_a22oi_1_1.B1 0
C15730 sg13cmos5l_dfrbp_1_23.CLK a_15016_6294# 0
C15731 a_17961_8793# a_17894_8436# 0
C15732 a_10220_3102# VPWR 0.32402f
C15733 sg13cmos5l_buf_1_104.A cko 0
C15734 a_1125_6935# a_708_5416# 0
C15735 a_708_6928# a_1125_5423# 0
C15736 sg13cmos5l_buf_1_44.X sg13cmos5l_buf_1_34.A 0
C15737 a_6572_1590# a_7095_1642# 0
C15738 a_904_7806# sg13cmos5l_inv_1_19.A 0.00212f
C15739 a_14536_7806# cks 0.00117f
C15740 a_11460_2392# nl_sw[6] 0.02746f
C15741 sg13cmos5l_dlhr_1_6.D sg13cmos5l_a221oi_1_1.C1 0.08975f
C15742 sg13cmos5l_dfrbp_1_6.RESET_B pl_sw[5] 0
C15743 a_10288_8678# VPWR 0.14668f
C15744 a_20118_6144# VPWR 0.24976f
C15745 sg13cmos5l_or2_1_0.A sg13cmos5l_buf_1_18.X 0.00216f
C15746 a_4349_7636# a_3962_7288# 0.00236f
C15747 sg13cmos5l_dfrbp_1_16.Q_N a_3831_7282# 0
C15748 a_17961_8793# sg13cmos5l_buf_1_105.A 0.2939f
C15749 sg13cmos5l_dfrbp_1_6.RESET_B a_16268_3102# 0.00315f
C15750 sg13cmos5l_dfrbp_1_6.D sg13cmos5l_buf_1_39.A 0.01793f
C15751 sg13cmos5l_nor2b_1_0.Y a_11656_3176# 0.00124f
C15752 a_15887_8797# a_15429_7653# 0
C15753 a_16144_8678# a_15531_7796# 0
C15754 sg13cmos5l_buf_1_90.X a_12232_8436# 0
C15755 a_16462_4338# sg13cmos5l_buf_1_4.X 0
C15756 a_16551_3987# a_16940_3102# 0
C15757 sg13cmos5l_buf_1_24.A sg13cmos5l_dlhr_1_2.D 0.63404f
C15758 a_4840_1664# nl_sw[3] 0.12371f
C15759 sg13cmos5l_inv_1_2.A sg13cmos5l_dfrbp_1_6.Q_N 0.00406f
C15760 sg13cmos5l_buf_1_3.A a_18671_1703# 0
C15761 a_17132_9150# a_17108_7972# 0
C15762 sg13cmos5l_buf_1_3.A a_18363_4270# 0
C15763 sg13cmos5l_buf_1_4.A a_15702_5842# 0.03517f
C15764 a_17792_9318# a_17367_8794# 0
C15765 a_16485_6935# VPWR 0.24803f
C15766 sg13cmos5l_dlhr_1_9.D a_7892_3900# 0
C15767 sg13cmos5l_dfrbp_1_16.Q a_7631_4727# 0
C15768 sg13cmos5l_nor2b_1_0.Y sg13cmos5l_a22oi_1_1.B1 0.77845f
C15769 sg13cmos5l_dfrbp_1_6.D a_15238_7687# 0
C15770 sg13cmos5l_dfrbp_1_10.Q_N VPWR 0.30504f
C15771 sg13cmos5l_buf_1_24.A a_7888_4870# 0
C15772 sg13cmos5l_buf_1_111.A ph_sw[8] 0.00328f
C15773 a_3016_9318# a_2148_8440# 0
C15774 sg13cmos5l_inv_1_6.A a_18746_5776# 0.00416f
C15775 a_13572_3151# a_12815_1703# 0
C15776 a_3860_2388# a_4172_1590# 0.00504f
C15777 sg13cmos5l_inv_1_14.A cks 0.02221f
C15778 sg13cmos5l_dfrbp_1_24.Q_N sg13cmos5l_dfrbp_1_23.CLK 0.00132f
C15779 sg13cmos5l_buf_1_35.A a_2732_1590# 0.28798f
C15780 sg13cmos5l_inv_1_27.Y a_14295_7282# 0.02316f
C15781 sg13cmos5l_dlhr_1_15.Q sg13cmos5l_buf_8_0.X 0
C15782 a_6568_9224# ph_sw[3] 0
C15783 a_7055_4261# a_6961_4261# 0.32273f
C15784 sg13cmos5l_dfrbp_1_15.D a_4282_8112# 0
C15785 a_3407_8797# VPWR 0.25964f
C15786 a_7312_4142# a_7474_4338# 0.0019f
C15787 a_17545_7728# a_17327_7285# 0.00674f
C15788 a_17751_7690# a_18164_6924# 0
C15789 sg13cmos5l_buf_1_5.A a_13572_3151# 0
C15790 sg13cmos5l_buf_1_110.A ph_sw[8] 0
C15791 a_2148_8440# a_2224_7166# 0
C15792 sg13cmos5l_inv_1_27.Y sg13cmos5l_nor2_1_0.A 0
C15793 a_7657_7282# sg13cmos5l_dlhr_1_6.D 0
C15794 sg13cmos5l_dfrbp_1_16.Q a_8988_6198# 0
C15795 sg13cmos5l_nand2_1_1.A a_12998_3138# 0
C15796 sg13cmos5l_dfrbp_1_0.RESET_B a_17700_3456# 0.51646f
C15797 sg13cmos5l_dfrbp_1_6.RESET_B a_5704_1664# 0.01252f
C15798 a_19340_8400# VPWR 0.24998f
C15799 sg13cmos5l_dfrbp_1_23.CLK sg13cmos5l_buf_1_10.A 0
C15800 a_11174_2826# a_11460_2392# 0.50066f
C15801 sg13cmos5l_buf_1_60.X sg13cmos5l_dfrbp_1_6.RESET_B 0
C15802 sg13cmos5l_nor2_1_0.A sg13cmos5l_dfrbp_1_2.D 0
C15803 a_13648_9406# a_13641_7674# 0.00239f
C15804 a_13391_9263# a_13460_7996# 0
C15805 sg13cmos5l_dlhr_1_11.GATE a_12490_6385# 0.0021f
C15806 sg13cmos5l_buf_1_86.A a_20008_7712# 0.00505f
C15807 sg13cmos5l_inv_1_7.A a_13072_1846# 0
C15808 sg13cmos5l_buf_1_65.X a_424_8436# 0.28827f
C15809 sg13cmos5l_or2_1_0.A sg13cmos5l_o21ai_1_0.Y 0
C15810 sg13cmos5l_dlhr_1_15.D sg13cmos5l_dfrbp_1_23.Q_N 0.00145f
C15811 a_18409_5770# sg13cmos5l_buf_8_1.A 0
C15812 sg13cmos5l_buf_1_44.A a_5604_4338# 0
C15813 sg13cmos5l_inv_1_8.A sg13cmos5l_buf_1_61.X 0.00184f
C15814 a_1997_6126# a_1609_4704# 0
C15815 sg13cmos5l_buf_1_95.X a_15147_8447# 0
C15816 a_16395_4772# a_17135_4727# 0.3087f
C15817 a_16293_4629# a_17392_4870# 0
C15818 sg13cmos5l_dlhr_1_1.GATE sg13cmos5l_nor2_1_2.A 0
C15819 sg13cmos5l_a221oi_1_0.C1 a_10420_5760# 0
C15820 sg13cmos5l_a221oi_1_0.A2 sg13cmos5l_a22oi_1_0.B1 0
C15821 a_5104_4870# a_4873_3192# 0
C15822 a_4847_4727# a_5210_3148# 0.00236f
C15823 sg13cmos5l_dfrbp_1_6.D sg13cmos5l_buf_1_43.A 0.00655f
C15824 sg13cmos5l_dfrbp_1_6.D a_6057_6553# 0
C15825 a_8841_5769# a_9242_4660# 0
C15826 a_9366_5842# a_8905_4704# 0
C15827 a_19130_6172# sg13cmos5l_buf_8_0.A 0
C15828 a_18409_5770# a_18960_5412# 0
C15829 sg13cmos5l_dfrbp_1_6.RESET_B a_15124_7312# 0.00615f
C15830 sg13cmos5l_buf_1_3.X sg13cmos5l_buf_1_18.X 0
C15831 sg13cmos5l_buf_1_18.A sg13cmos5l_dfrbp_1_0.Q 0.55801f
C15832 a_2248_9224# pl_sw[2] 0.29036f
C15833 sg13cmos5l_inv_1_14.A a_7430_3576# 0
C15834 a_3574_7850# cks 0
C15835 sg13cmos5l_dfrbp_1_8.RESET_B sg13cmos5l_buf_1_5.X 0.00176f
C15836 a_14536_7806# a_14612_6460# 0
C15837 sg13cmos5l_inv_1_8.A a_708_5416# 0
C15838 a_18959_3215# sg13cmos5l_dfrbp_1_0.Q_N 0
C15839 sg13cmos5l_buf_1_31.X a_9111_4666# 0.01924f
C15840 sg13cmos5l_inv_1_2.A a_11464_9224# 0.00917f
C15841 pl_sw[9] ph_sw[9] 0.14182f
C15842 sg13cmos5l_buf_1_107.X a_18164_7996# 0
C15843 sg13cmos5l_dfrbp_1_9.Q sg13cmos5l_buf_1_32.A 0
C15844 sg13cmos5l_buf_1_111.A a_18999_6178# 0
C15845 sg13cmos5l_dlhr_1_9.D sg13cmos5l_dlhr_1_7.Q_N 0.00218f
C15846 sg13cmos5l_inv_1_17.A a_4177_7326# 0
C15847 a_15177_5769# a_15412_5800# 0.00566f
C15848 sg13cmos5l_o21ai_1_0.A1 a_11372_3102# 0
C15849 a_7732_3124# sg13cmos5l_buf_1_25.A 0
C15850 sg13cmos5l_buf_1_4.X a_16657_2749# 0.01395f
C15851 a_7095_1642# a_6889_1680# 0.27532f
C15852 sg13cmos5l_buf_1_64.A sg13cmos5l_buf_1_60.A 0.05882f
C15853 sg13cmos5l_buf_1_45.X sg13cmos5l_dlhr_1_5.GATE 0.17204f
C15854 a_16271_7751# cks 0.02968f
C15855 sg13cmos5l_buf_1_57.X a_16042_6892# 0.00414f
C15856 a_11979_2399# nl_sw[6] 0.02294f
C15857 sg13cmos5l_dfrbp_1_6.RESET_B a_18486_8866# 0.00955f
C15858 a_11464_8436# VPWR 0.25831f
C15859 sg13cmos5l_dfrbp_1_16.Q_N a_4425_7281# 0
C15860 a_4559_7630# a_4950_7354# 0
C15861 a_18860_9150# a_18870_7656# 0
C15862 a_1948_7964# sg13cmos5l_buf_1_61.X 0
C15863 sg13cmos5l_dfrbp_1_22.D a_15531_7796# 0.05047f
C15864 sg13cmos5l_inv_1_8.A a_6903_3154# 0.00118f
C15865 a_3664_8678# sg13cmos5l_buf_1_62.X 0
C15866 sg13cmos5l_buf_1_34.X sg13cmos5l_buf_1_25.X 0.03537f
C15867 sg13cmos5l_buf_1_28.X nh_sw[4] 0.00368f
C15868 a_2148_8440# pl_sw[2] 0
C15869 a_13641_7674# ph_sw[6] 0
C15870 sg13cmos5l_inv_1_2.A a_17750_4325# 0
C15871 sg13cmos5l_a22oi_1_1.B2 a_14377_5770# 0.068f
C15872 sg13cmos5l_nand2_1_1.B nh_sw[6] 0.00972f
C15873 sg13cmos5l_dfrbp_1_16.Q sg13cmos5l_a221oi_1_0.B2 0
C15874 sg13cmos5l_inv_1_17.A sg13cmos5l_dlhr_1_3.Q_N 0
C15875 sg13cmos5l_a221oi_1_0.B1 a_11488_4676# 0.00124f
C15876 a_1946_4660# a_2161_4642# 0.00284f
C15877 a_17327_7285# VPWR 0.26065f
C15878 sg13cmos5l_buf_1_110.A sg13cmos5l_dlhr_1_13.Q_N 0.00617f
C15879 sg13cmos5l_buf_1_77.X a_10010_9196# 0
C15880 sg13cmos5l_buf_1_65.X a_4324_7996# 0
C15881 sg13cmos5l_inv_1_0.Y a_11182_4948# 0.01014f
C15882 a_10230_4632# sg13cmos5l_o21ai_1_0.A1 0
C15883 sg13cmos5l_inv_1_2.A ph_sw[4] 0.01818f
C15884 sg13cmos5l_buf_1_77.A a_8041_5770# 0
C15885 sg13cmos5l_buf_1_45.X a_8593_5814# 0
C15886 sg13cmos5l_buf_1_0.A sg13cmos5l_dfrbp_1_0.Q 0.04526f
C15887 sg13cmos5l_buf_1_24.A sg13cmos5l_dfrbp_1_12.Q_N 0
C15888 a_9448_1664# nl_sw[5] 0
C15889 sg13cmos5l_dfrbp_1_8.RESET_B sg13cmos5l_dlhr_1_1.GATE 0.14347f
C15890 sg13cmos5l_buf_1_98.A a_13876_7660# 0
C15891 a_5194_2356# sg13cmos5l_buf_1_39.A 0.00185f
C15892 sg13cmos5l_nor2b_1_0.Y a_13486_5412# 0.02231f
C15893 sg13cmos5l_dfrbp_1_6.D a_5510_4338# 0.30725f
C15894 sg13cmos5l_buf_1_97.A a_10288_8678# 0
C15895 sg13cmos5l_inv_1_3.A sg13cmos5l_dlhr_1_15.D 0.02641f
C15896 sg13cmos5l_dlhr_1_11.Q a_12361_7282# 0
C15897 sg13cmos5l_dfrbp_1_6.RESET_B a_16395_4772# 0
C15898 a_13803_3260# sg13cmos5l_dfrbp_1_0.Q 0
C15899 a_8457_7281# a_8041_5770# 0
C15900 a_8276_6924# a_8378_5776# 0
C15901 a_8660_5412# sg13cmos5l_or2_1_0.A 0
C15902 sg13cmos5l_buf_1_35.A nl_sw[2] 0.21704f
C15903 sg13cmos5l_buf_1_77.A a_9202_7674# 0
C15904 a_7892_3900# a_8296_3986# 0.0303f
C15905 sg13cmos5l_inv_1_8.A a_2436_4325# 0.01234f
C15906 a_10827_7796# sg13cmos5l_dlhr_1_6.D 0
C15907 sg13cmos5l_o21ai_1_0.A1 nh_sw[5] 0
C15908 a_2732_1590# nh_sw[1] 0.01446f
C15909 sg13cmos5l_buf_1_103.A pl_sw[7] 0.0057f
C15910 sg13cmos5l_dfrbp_1_1.Q a_19216_3358# 0
C15911 a_10308_7992# sg13cmos5l_dlhr_1_5.Q 0
C15912 a_2565_8447# sg13cmos5l_dfrbp_1_16.Q 0
C15913 sg13cmos5l_inv_1_14.A sg13cmos5l_buf_1_45.X 0.10175f
C15914 sg13cmos5l_inv_1_2.A sg13cmos5l_buf_1_5.A 0.00192f
C15915 sg13cmos5l_dlhr_1_0.GATE sg13cmos5l_dlhr_1_2.Q 0
C15916 sg13cmos5l_buf_1_96.A a_10900_7312# 0
C15917 sg13cmos5l_nand2_1_1.A a_14800_3358# 0.00697f
C15918 sg13cmos5l_inv_1_17.A a_3407_4261# 0.01945f
C15919 a_16068_6928# a_16677_6141# 0
C15920 a_16485_6935# a_16260_6480# 0
C15921 sg13cmos5l_dfrbp_1_6.RESET_B a_5600_1758# 0.00529f
C15922 a_4753_4727# sg13cmos5l_dfrbp_1_10.Q 0
C15923 a_12998_3138# a_13701_3117# 0.02453f
C15924 sg13cmos5l_dlhr_1_0.GATE a_5508_2813# 0.00221f
C15925 a_11174_2826# a_11979_2399# 0.11742f
C15926 a_14228_9484# sg13cmos5l_dlhr_1_14.Q_N 0
C15927 sg13cmos5l_dfrbp_1_20.Q a_10308_7992# 0.00715f
C15928 a_20008_3900# VPWR 0.31704f
C15929 sg13cmos5l_a221oi_1_0.A2 sg13cmos5l_buf_1_25.A 0
C15930 a_15850_4873# sg13cmos5l_buf_1_5.X 0
C15931 sg13cmos5l_dfrbp_1_16.Q sg13cmos5l_dfrbp_1_9.Q 0
C15932 sg13cmos5l_buf_1_44.A a_6315_3911# 0
C15933 sg13cmos5l_buf_1_18.X a_20392_2388# 0
C15934 sg13cmos5l_buf_1_19.X sg13cmos5l_buf_1_0.X 0.01148f
C15935 a_2380_6162# a_2409_4650# 0
C15936 sg13cmos5l_a221oi_1_0.C1 a_9111_4666# 0
C15937 sg13cmos5l_buf_1_79.X VPWR 0.27679f
C15938 sg13cmos5l_buf_1_77.A sg13cmos5l_dfrbp_1_6.D 0.02416f
C15939 sg13cmos5l_dfrbp_1_6.RESET_B sg13cmos5l_buf_1_18.A 0.20637f
C15940 sg13cmos5l_dfrbp_1_14.Q_N a_5210_3148# 0
C15941 sg13cmos5l_o21ai_1_0.A2 sg13cmos5l_dfrbp_1_4.D 0.00707f
C15942 sg13cmos5l_buf_1_8.X a_11268_2826# 0
C15943 a_4244_6924# a_4358_6924# 0.00122f
C15944 sg13cmos5l_a22oi_1_2.B1 a_11556_1944# 0
C15945 a_19209_5769# a_19142_5412# 0
C15946 sg13cmos5l_buf_1_45.A a_9524_4972# 0
C15947 sg13cmos5l_a221oi_1_0.A2 sg13cmos5l_dlhr_1_20.Q_N 0.00548f
C15948 sg13cmos5l_dfrbp_1_6.D a_8457_7281# 0.00902f
C15949 sg13cmos5l_dlhr_1_9.D a_6647_5459# 0.01322f
C15950 sg13cmos5l_buf_1_31.X sg13cmos5l_dfrbp_1_10.Q 5.3819f
C15951 sg13cmos5l_buf_1_31.X a_6736_2630# 0
C15952 sg13cmos5l_or2_1_0.A sg13cmos5l_buf_1_26.X 0
C15953 sg13cmos5l_dfrbp_1_8.D a_16204_4338# 0
C15954 a_9879_9202# a_10225_9178# 0.00722f
C15955 sg13cmos5l_buf_1_74.X sg13cmos5l_dfrbp_1_6.D 0
C15956 sg13cmos5l_dlhr_1_15.D a_12516_6480# 0
C15957 sg13cmos5l_inv_1_14.A a_8204_2352# 0
C15958 sg13cmos5l_dlhr_1_0.GATE a_6346_4873# 0
C15959 a_7498_7897# a_7812_7687# 0.00659f
C15960 sg13cmos5l_buf_1_111.A a_19526_6600# 0
C15961 a_6741_5459# a_6961_4261# 0
C15962 a_12704_4782# a_11973_3911# 0.00252f
C15963 a_4005_4629# a_4436_3436# 0
C15964 a_17780_8436# a_17882_7684# 0
C15965 a_17961_8793# a_17545_7728# 0.00236f
C15966 a_12815_4261# VPWR 0.25689f
C15967 sg13cmos5l_buf_1_30.X a_7226_1636# 0
C15968 sg13cmos5l_buf_1_31.X a_5673_3138# 0.01143f
C15969 sg13cmos5l_buf_1_31.X a_908_1590# 0.00267f
C15970 sg13cmos5l_dfrbp_1_8.RESET_B a_5546_5850# 0
C15971 a_7689_1626# a_8214_1608# 0.13715f
C15972 sg13cmos5l_buf_1_26.A sg13cmos5l_dlhr_1_0.Q 0
C15973 sg13cmos5l_dfrbp_1_23.CLK sg13cmos5l_nor2b_1_0.Y 0
C15974 sg13cmos5l_dlhr_1_15.D cks 0.02417f
C15975 a_10010_9196# sg13cmos5l_dfrbp_1_6.RESET_B 0.00284f
C15976 a_10473_9186# a_10292_9508# 0.40925f
C15977 a_15821_3864# nl_sw[8] 0
C15978 sg13cmos5l_buf_1_65.X a_7941_7653# 0
C15979 sg13cmos5l_buf_1_96.A VPWR 0.46401f
C15980 sg13cmos5l_dfrbp_1_6.RESET_B pl_sw[6] 0
C15981 sg13cmos5l_buf_1_77.A a_10024_5498# 0.00355f
C15982 sg13cmos5l_dfrbp_1_0.RESET_B sg13cmos5l_dlhr_1_0.D 0
C15983 sg13cmos5l_dlhr_1_6.D sg13cmos5l_dfrbp_1_23.Q_N 0
C15984 sg13cmos5l_buf_1_65.X a_1760_9318# 0.00108f
C15985 a_3308_9150# sg13cmos5l_inv_1_8.A 0.28823f
C15986 sg13cmos5l_dfrbp_1_22.D a_15300_7687# 0.00779f
C15987 sg13cmos5l_dfrbp_1_15.D sg13cmos5l_buf_1_62.X 0
C15988 sg13cmos5l_buf_1_60.A VPWR 0.32593f
C15989 sg13cmos5l_buf_1_31.X a_6372_4968# 0
C15990 sg13cmos5l_buf_1_79.X a_12698_7288# 0
C15991 a_4244_8436# pl_sw[2] 0
C15992 a_14986_7897# ph_sw[6] 0
C15993 sg13cmos5l_a22oi_1_1.B2 a_14996_5412# 0.01248f
C15994 sg13cmos5l_a22oi_1_2.B1 nh_sw[4] 0
C15995 sg13cmos5l_dfrbp_1_2.D a_11054_4292# 0
C15996 sg13cmos5l_dfrbp_1_6.RESET_B a_8208_6924# 0
C15997 sg13cmos5l_inv_1_14.A sg13cmos5l_a22oi_1_2.B2 0
C15998 a_6697_3192# sg13cmos5l_buf_1_25.A 0.00299f
C15999 sg13cmos5l_inv_1_17.A a_3974_2388# 0
C16000 sg13cmos5l_dfrbp_1_6.RESET_B sg13cmos5l_buf_1_0.A 0.00187f
C16001 sg13cmos5l_buf_1_19.A sg13cmos5l_buf_8_0.A 0.28372f
C16002 sg13cmos5l_dfrbp_1_9.Q a_4005_4629# 0.0017f
C16003 a_3562_4873# a_4107_4772# 0.00999f
C16004 sg13cmos5l_inv_1_2.A a_13460_7996# 0
C16005 a_1864_9224# VPWR 0.25601f
C16006 a_6405_8447# a_7238_7674# 0
C16007 sg13cmos5l_dlhr_1_12.D a_17961_8793# 0
C16008 sg13cmos5l_buf_1_45.X sg13cmos5l_buf_1_45.A 0.00734f
C16009 sg13cmos5l_dlhr_1_9.D a_8050_4650# 0
C16010 sg13cmos5l_buf_8_0.X a_20392_6924# 0.04947f
C16011 sg13cmos5l_buf_1_44.X sg13cmos5l_dfrbp_1_15.D 0
C16012 sg13cmos5l_dlhr_1_11.GATE a_12132_9504# 0.0046f
C16013 sg13cmos5l_dfrbp_1_18.Q sg13cmos5l_dlhr_1_6.D 0
C16014 sg13cmos5l_buf_1_30.A nh_sw[4] 0.02313f
C16015 sg13cmos5l_buf_1_58.A sg13cmos5l_dfrbp_1_6.D 0
C16016 sg13cmos5l_dfrbp_1_21.Q_N a_18999_6178# 0.00403f
C16017 sg13cmos5l_buf_1_4.X sg13cmos5l_buf_1_1.A 0
C16018 sg13cmos5l_dfrbp_1_18.Q a_8412_7326# 0
C16019 sg13cmos5l_buf_1_97.A a_11464_8436# 0.04117f
C16020 sg13cmos5l_buf_1_5.X sg13cmos5l_dfrbp_1_0.Q 0.33306f
C16021 sg13cmos5l_dlhr_1_11.Q a_13396_7312# 0.0014f
C16022 a_16298_4338# sg13cmos5l_buf_1_2.X 0
C16023 sg13cmos5l_dfrbp_1_6.D a_15016_6294# 0.00233f
C16024 sg13cmos5l_buf_1_34.X sg13cmos5l_dlhr_1_5.GATE 0.22543f
C16025 sg13cmos5l_buf_1_41.A sg13cmos5l_buf_1_32.A 0
C16026 sg13cmos5l_buf_1_111.A a_20008_8436# 0
C16027 sg13cmos5l_nand2_1_1.A a_15300_2826# 0
C16028 sg13cmos5l_a221oi_1_0.B1 VPWR 0.52287f
C16029 sg13cmos5l_inv_1_2.A a_14814_4292# 0
C16030 a_10725_7653# sg13cmos5l_inv_1_29.A 0
C16031 a_15592_6200# a_15702_5842# 0
C16032 sg13cmos5l_dlhr_1_1.D a_2122_3868# 0
C16033 nl_sw[8] nl_sw[7] 0.48388f
C16034 nh_sw[9] nl_sw[10] 0.3929f
C16035 nl_sw[9] d_out[0] 0
C16036 VPWR nl_sw[8] 0.20383f
C16037 nh_sw[1] nl_sw[2] 0.08942f
C16038 sg13cmos5l_dfrbp_1_15.D a_2804_6924# 0.01725f
C16039 a_13094_6924# VPWR 0.00418f
C16040 sg13cmos5l_dfrbp_1_6.RESET_B sg13cmos5l_buf_1_30.X 0
C16041 sg13cmos5l_buf_1_65.X a_1846_7850# 0
C16042 sg13cmos5l_dfrbp_1_15.D a_2583_7710# 0
C16043 sg13cmos5l_inv_1_17.A sg13cmos5l_buf_1_38.A 0.48298f
C16044 a_16587_6935# a_16779_6284# 0
C16045 sg13cmos5l_buf_1_89.A sg13cmos5l_dfrbp_1_21.Q 0
C16046 sg13cmos5l_dlhr_1_0.GATE a_8588_2352# 0
C16047 a_6213_3911# a_7034_3148# 0
C16048 sg13cmos5l_nand2_1_1.A a_15821_3864# 0
C16049 a_13701_3117# a_14800_3358# 0
C16050 a_13803_3260# a_14543_3215# 0.3087f
C16051 a_11460_2392# a_12625_2749# 0.4858f
C16052 a_11686_2813# a_11748_2813# 0
C16053 a_17896_9224# a_17792_9318# 0.00624f
C16054 sg13cmos5l_inv_1_27.Y a_14726_7674# 0.01586f
C16055 sg13cmos5l_a221oi_1_0.C1 sg13cmos5l_dfrbp_1_10.Q 0.23099f
C16056 sg13cmos5l_buf_1_28.X sg13cmos5l_buf_1_8.A 0.00208f
C16057 sg13cmos5l_dfrbp_1_6.RESET_B a_9660_4686# 0
C16058 sg13cmos5l_inv_1_8.A a_1862_4338# 0.01028f
C16059 sg13cmos5l_dlhr_1_15.D a_12358_5388# 0.00122f
C16060 a_1227_5423# sg13cmos5l_dlygate4sd2_1_0.X 0
C16061 a_11464_9224# a_12106_9409# 0.00308f
C16062 sg13cmos5l_dfrbp_1_23.CLK a_14342_8874# 0.33641f
C16063 a_18345_7674# a_18278_8112# 0
C16064 a_18870_7656# a_19240_7712# 0.00308f
C16065 a_18164_7996# a_18096_7996# 0
C16066 a_15876_4968# a_16204_4338# 0
C16067 a_16293_4629# a_15821_3864# 0.00209f
C16068 a_3664_8678# sg13cmos5l_dlhr_1_9.Q 0.00167f
C16069 sg13cmos5l_buf_8_0.X d_out[2] 0.745f
C16070 sg13cmos5l_inv_1_17.A a_2148_3904# 0
C16071 sg13cmos5l_a221oi_1_0.C1 sg13cmos5l_inv_1_0.Y 0.24827f
C16072 a_2879_6432# a_3562_4873# 0.00356f
C16073 a_1967_5773# a_1815_4666# 0
C16074 a_1227_5423# a_1946_4660# 0
C16075 sg13cmos5l_buf_1_110.A a_16160_9318# 0.00108f
C16076 sg13cmos5l_buf_1_94.X a_13593_9501# 0
C16077 sg13cmos5l_buf_1_111.A a_18376_9224# 0.33101f
C16078 a_7994_7288# sg13cmos5l_dlhr_1_5.D 0
C16079 sg13cmos5l_buf_1_8.X a_11686_2813# 0
C16080 sg13cmos5l_dfrbp_1_0.RESET_B a_14449_3215# 0.00245f
C16081 sg13cmos5l_buf_1_40.A nl_sw[0] 0
C16082 a_17961_8793# VPWR 0.62408f
C16083 a_1760_9318# pl_sw[1] 0
C16084 sg13cmos5l_inv_1_3.A sg13cmos5l_dlhr_1_6.D 0.01123f
C16085 sg13cmos5l_buf_1_87.A a_18568_7010# 0
C16086 a_4460_9150# sg13cmos5l_buf_1_62.X 0
C16087 a_10473_9186# sg13cmos5l_buf_1_90.X 0
C16088 sg13cmos5l_dfrbp_1_6.RESET_B a_10708_9172# 0.00487f
C16089 sg13cmos5l_dlhr_1_15.D a_14612_6460# 0
C16090 sg13cmos5l_inv_1_18.A a_9189_8447# 0.00986f
C16091 sg13cmos5l_dlhr_1_0.GATE a_6180_4650# 0.00111f
C16092 sg13cmos5l_buf_1_65.X a_8488_9224# 0.31772f
C16093 a_17412_1944# nl_sw[9] 0.02019f
C16094 sg13cmos5l_dfrbp_1_6.D a_524_4614# 0.00398f
C16095 sg13cmos5l_buf_1_73.X a_7238_7674# 0
C16096 sg13cmos5l_buf_1_2.A a_15684_4650# 0
C16097 a_11372_3102# a_11656_3176# 0.13542f
C16098 a_13686_7354# a_14889_7281# 0
C16099 a_12698_7288# a_13094_6924# 0.00949f
C16100 sg13cmos5l_dfrbp_1_8.D a_18368_4782# 0
C16101 a_8247_5770# a_8588_3864# 0
C16102 a_12716_8400# sg13cmos5l_buf_1_5.A 0
C16103 sg13cmos5l_buf_1_105.A a_18345_7674# 0.01139f
C16104 sg13cmos5l_inv_1_17.A sg13cmos5l_or2_1_0.A 0.02412f
C16105 sg13cmos5l_buf_1_30.X a_9832_1664# 0.00333f
C16106 sg13cmos5l_nand2_1_1.A VPWR 0.93982f
C16107 sg13cmos5l_buf_1_31.X sg13cmos5l_dlhr_1_2.D 0.00188f
C16108 a_18746_5776# a_18961_5814# 0.00284f
C16109 a_18615_5770# a_19209_5769# 0.09085f
C16110 a_18409_5770# a_19028_5412# 0.00161f
C16111 sg13cmos5l_buf_1_19.A a_18376_2388# 0.03723f
C16112 sg13cmos5l_buf_1_79.X sg13cmos5l_buf_1_97.A 0.02141f
C16113 sg13cmos5l_buf_1_10.A sg13cmos5l_dfrbp_1_6.D 0.14445f
C16114 sg13cmos5l_buf_1_34.X a_4652_6126# 0.04208f
C16115 a_7095_1642# a_7644_1662# 0
C16116 a_9164_1590# a_9448_1664# 0.13542f
C16117 a_7508_1948# a_7440_1948# 0
C16118 a_7689_1626# a_7622_2064# 0
C16119 sg13cmos5l_buf_1_31.X a_4566_2818# 0
C16120 a_15439_1630# nl_sw[8] 0
C16121 a_4460_9150# sg13cmos5l_buf_1_44.X 0
C16122 a_12814_4692# a_12815_4261# 0
C16123 sg13cmos5l_inv_1_0.Y sg13cmos5l_o21ai_1_0.B1 0.00213f
C16124 sg13cmos5l_inv_1_8.A a_682_5380# 0
C16125 a_2621_7636# cks 0.00202f
C16126 a_19340_8400# ph_sw[9] 0
C16127 a_16293_4629# VPWR 0.24822f
C16128 sg13cmos5l_a22oi_1_1.B1 a_11372_3102# 0
C16129 sg13cmos5l_dfrbp_1_16.Q sg13cmos5l_buf_1_41.A 0.25895f
C16130 a_11782_4325# VPWR 0
C16131 sg13cmos5l_dfrbp_1_6.D a_15702_5842# 0
C16132 sg13cmos5l_buf_1_19.A sg13cmos5l_inv_1_5.A 0
C16133 sg13cmos5l_nor2b_1_0.Y a_11748_2813# 0
C16134 sg13cmos5l_inv_1_11.Y VPWR 0.49049f
C16135 a_20488_4782# d_out[2] 0.00592f
C16136 sg13cmos5l_inv_1_8.A sg13cmos5l_dfrbp_1_10.Q 0
C16137 a_8378_5776# sg13cmos5l_a221oi_1_1.C1 0
C16138 sg13cmos5l_dfrbp_1_21.Q sg13cmos5l_dfrbp_1_0.CLK 0
C16139 sg13cmos5l_buf_1_60.X a_3016_9318# 0
C16140 sg13cmos5l_buf_8_2.X cko 0
C16141 a_15429_7653# ph_sw[6] 0
C16142 a_17493_3947# a_17595_3947# 0.00337f
C16143 sg13cmos5l_inv_1_3.A a_13698_5412# 0.00422f
C16144 sg13cmos5l_buf_1_31.X a_2757_3117# 0.01731f
C16145 sg13cmos5l_dfrbp_1_6.RESET_B a_10484_6924# 0.13772f
C16146 sg13cmos5l_inv_1_6.A cks 0
C16147 a_5908_3124# sg13cmos5l_buf_1_25.A 0
C16148 a_3496_1758# VPWR 0.13024f
C16149 sg13cmos5l_dfrbp_1_9.Q a_4847_4727# 0
C16150 sg13cmos5l_buf_1_25.A a_5637_2399# 0.01017f
C16151 a_7497_3138# sg13cmos5l_dlhr_1_0.Q 0.00409f
C16152 sg13cmos5l_buf_1_57.X a_14844_7326# 0
C16153 sg13cmos5l_dfrbp_1_0.Q a_15909_2399# 0
C16154 sg13cmos5l_dfrbp_1_20.Q sg13cmos5l_inv_1_0.A 0
C16155 a_7247_8797# a_7238_7674# 0
C16156 a_7504_8678# a_7524_7992# 0
C16157 sg13cmos5l_inv_1_2.A ph_sw[5] 1.96936f
C16158 sg13cmos5l_buf_1_41.A a_3688_1664# 0.0017f
C16159 sg13cmos5l_dlhr_1_6.D a_12516_6480# 0.05228f
C16160 sg13cmos5l_inv_1_8.A a_6276_8861# 0.00361f
C16161 sg13cmos5l_dfrbp_1_8.D sg13cmos5l_and3_1_0.C 0.00613f
C16162 a_8296_3986# a_8392_3270# 0.00182f
C16163 sg13cmos5l_nor2b_1_0.Y sg13cmos5l_buf_1_8.X 0.02713f
C16164 a_17425_6239# a_17938_6162# 0
C16165 sg13cmos5l_buf_1_34.X a_3574_7850# 0
C16166 a_12616_5498# sg13cmos5l_a22oi_1_1.B1 0
C16167 a_17367_8794# pl_sw[8] 0
C16168 sg13cmos5l_buf_1_97.A sg13cmos5l_buf_1_96.A 0.0035f
C16169 a_10071_7282# a_10484_6924# 0.15652f
C16170 sg13cmos5l_buf_1_5.A a_14889_7281# 0
C16171 sg13cmos5l_dfrbp_1_8.RESET_B a_6380_7638# 0.01141f
C16172 a_10230_4632# sg13cmos5l_a22oi_1_1.B1 0
C16173 sg13cmos5l_dlhr_1_15.Q_N VPWR 0.2521f
C16174 a_12404_7972# sg13cmos5l_inv_1_29.A 0.15367f
C16175 sg13cmos5l_dfrbp_1_6.RESET_B a_2169_5535# 0.00546f
C16176 sg13cmos5l_inv_1_17.A a_3578_2752# 0.02945f
C16177 sg13cmos5l_a221oi_1_0.B2 a_11394_4948# 0.03105f
C16178 sg13cmos5l_a221oi_1_0.B1 a_12814_4692# 0
C16179 sg13cmos5l_buf_1_110.A a_14708_6924# 0
C16180 sg13cmos5l_inv_1_8.A a_6372_4968# 0.09418f
C16181 sg13cmos5l_buf_8_0.X sg13cmos5l_dfrbp_1_21.Q_N 0
C16182 sg13cmos5l_inv_1_8.A ckc 0.00441f
C16183 ph_sw[1] cks 0
C16184 sg13cmos5l_or2_1_1.B sg13cmos5l_dfrbp_1_0.CLK 0
C16185 sg13cmos5l_nor2_1_0.A a_13072_4142# 0.01811f
C16186 sg13cmos5l_buf_1_65.X a_1480_7806# 0
C16187 ph_sw[2] ph_sw[4] 0
C16188 ph_sw[3] pl_sw[4] 0.20886f
C16189 a_8412_7326# cks 0
C16190 a_20672_6294# d_out[2] 0
C16191 sg13cmos5l_dfrbp_1_8.D a_16677_6141# 0.36233f
C16192 sg13cmos5l_dfrbp_1_6.RESET_B sg13cmos5l_dlhr_1_0.Q_N 0.0012f
C16193 cks a_1000_9224# 0
C16194 sg13cmos5l_nand2_1_1.A a_16551_3987# 0
C16195 a_7312_4142# a_7316_3460# 0
C16196 a_6213_3911# a_6560_3270# 0.00194f
C16197 a_7055_4261# a_7497_3138# 0.01604f
C16198 sg13cmos5l_buf_1_7.A a_14254_2444# 0.01637f
C16199 a_14543_3215# sg13cmos5l_buf_1_5.X 0.02592f
C16200 a_11979_2399# a_12625_2749# 0.00667f
C16201 sg13cmos5l_buf_1_31.X sg13cmos5l_dlygate4sd2_1_0.A 0.04047f
C16202 sg13cmos5l_dlhr_1_9.D sg13cmos5l_inv_1_0.A 0.01452f
C16203 a_4041_2745# sg13cmos5l_buf_1_39.A 0.00785f
C16204 a_3447_2746# nl_sw[2] 0
C16205 sg13cmos5l_dfrbp_1_8.RESET_B a_16617_6553# 0
C16206 a_7863_7282# sg13cmos5l_a221oi_1_0.A2 0
C16207 sg13cmos5l_buf_1_45.X a_6959_6239# 0.00107f
C16208 sg13cmos5l_a22oi_1_2.B1 sg13cmos5l_buf_1_8.A 0.00313f
C16209 sg13cmos5l_buf_1_74.X ph_sw[3] 0
C16210 sg13cmos5l_buf_8_1.A sg13cmos5l_a22oi_1_1.A1 1.86824f
C16211 a_16293_4629# a_16551_3987# 0.0167f
C16212 sg13cmos5l_dfrbp_1_15.D sg13cmos5l_dlhr_1_9.Q 0.36374f
C16213 a_17392_4870# a_16572_4261# 0
C16214 sg13cmos5l_buf_1_29.A a_9448_1664# 0.03496f
C16215 a_10022_7674# a_10725_7653# 0.02453f
C16216 a_12933_6141# a_13486_5412# 0
C16217 a_13775_6239# a_14583_5770# 0.00473f
C16218 sg13cmos5l_buf_1_95.X ph_sw[8] 0
C16219 sg13cmos5l_dfrbp_1_6.D rdy 0.00453f
C16220 sg13cmos5l_dfrbp_1_8.RESET_B nh_sw[7] 0
C16221 sg13cmos5l_dfrbp_1_17.D a_1873_7285# 0
C16222 a_13484_8400# a_13178_7684# 0
C16223 sg13cmos5l_dlhr_1_1.D a_1609_4704# 0.1591f
C16224 a_2340_3456# sg13cmos5l_buf_1_39.A 0
C16225 a_2757_3117# a_3212_1590# 0
C16226 sg13cmos5l_dfrbp_1_6.RESET_B sg13cmos5l_buf_1_24.X 0.0235f
C16227 a_18760_2388# nl_sw[9] 0.00163f
C16228 a_9673_9240# VPWR 0.40758f
C16229 sg13cmos5l_buf_1_59.A sg13cmos5l_inv_1_19.A 0.00359f
C16230 sg13cmos5l_dfrbp_1_6.RESET_B sg13cmos5l_dlhr_1_1.GATE 0.79774f
C16231 a_18960_5412# sg13cmos5l_a22oi_1_1.A1 0
C16232 sg13cmos5l_dfrbp_1_8.RESET_B a_14426_7288# 0.00197f
C16233 a_5510_4338# a_5210_3148# 0
C16234 a_15016_9224# ph_sw[6] 0.00973f
C16235 sg13cmos5l_buf_1_103.A a_16144_8678# 0
C16236 sg13cmos5l_buf_1_6.A a_12022_3134# 0
C16237 a_10464_2427# a_9823_2364# 0
C16238 sg13cmos5l_buf_1_57.X a_15590_4650# 0
C16239 sg13cmos5l_buf_1_38.A a_5796_3904# 0
C16240 a_15531_7796# a_15782_7362# 0
C16241 sg13cmos5l_dfrbp_1_0.CLK a_11270_1626# 0.00212f
C16242 sg13cmos5l_dlhr_1_15.D sg13cmos5l_a22oi_1_2.B2 0
C16243 sg13cmos5l_inv_1_14.A a_10220_3102# 0
C16244 sg13cmos5l_dfrbp_1_23.Q a_14889_7281# 0
C16245 sg13cmos5l_dfrbp_1_8.RESET_B a_1196_8400# 0.01247f
C16246 sg13cmos5l_a221oi_1_0.A2 sg13cmos5l_a22oi_1_0.Y 0.12832f
C16247 sg13cmos5l_a221oi_1_1.C1 a_10420_5760# 0
C16248 sg13cmos5l_dfrbp_1_8.RESET_B a_13641_7674# 0
C16249 sg13cmos5l_dfrbp_1_6.RESET_B a_18164_7996# 0.16514f
C16250 sg13cmos5l_dfrbp_1_8.RESET_B a_3302_4650# 0.11489f
C16251 sg13cmos5l_buf_1_30.X a_7924_1612# 0
C16252 sg13cmos5l_dfrbp_1_6.D a_7994_7288# 0.00671f
C16253 a_7498_7897# sg13cmos5l_dlhr_1_5.D 0
C16254 a_8214_1608# a_8576_1758# 0.04055f
C16255 a_12912_6924# sg13cmos5l_nor2_1_0.A 0
C16256 a_13701_3117# VPWR 0.26486f
C16257 sg13cmos5l_buf_1_60.X pl_sw[2] 0.01481f
C16258 sg13cmos5l_and3_1_0.C sg13cmos5l_dfrbp_1_2.Q_N 0.01762f
C16259 a_20008_3900# a_20012_2352# 0
C16260 sg13cmos5l_buf_1_95.X sg13cmos5l_inv_1_7.A 0.01505f
C16261 sg13cmos5l_dfrbp_1_0.D VPWR 0.72321f
C16262 sg13cmos5l_nand2_1_1.B a_11877_2399# 0.00572f
C16263 sg13cmos5l_dlhr_1_5.Q a_10420_5412# 0
C16264 sg13cmos5l_buf_1_19.A a_18577_1703# 0
C16265 sg13cmos5l_dlhr_1_6.D a_9524_4972# 0
C16266 sg13cmos5l_buf_1_31.X sg13cmos5l_dfrbp_1_12.Q_N 0
C16267 sg13cmos5l_dlhr_1_5.Q a_9242_4660# 0
C16268 sg13cmos5l_inv_1_2.A sg13cmos5l_inv_1_28.Y 0.01449f
C16269 sg13cmos5l_buf_1_31.X a_424_1664# 0.28823f
C16270 sg13cmos5l_inv_1_26.Y a_18793_6216# 0.0021f
C16271 sg13cmos5l_dlhr_1_9.D sg13cmos5l_buf_1_59.A 0.25645f
C16272 sg13cmos5l_inv_1_6.A a_18219_3260# 0
C16273 a_7247_8797# a_7336_7010# 0
C16274 a_6681_2511# VPWR 0
C16275 sg13cmos5l_dfrbp_1_6.RESET_B a_15909_2399# 0.00176f
C16276 sg13cmos5l_dfrbp_1_20.Q a_10420_5412# 0.01013f
C16277 sg13cmos5l_buf_1_31.X a_3801_3453# 0.00171f
C16278 sg13cmos5l_dfrbp_1_6.RESET_B a_10598_6924# 0
C16279 a_12361_7282# pl_sw[6] 0
C16280 a_6184_9224# a_6276_8861# 0
C16281 a_3692_9150# sg13cmos5l_buf_1_34.X 0
C16282 sg13cmos5l_buf_1_65.X a_424_9318# 0
C16283 a_8214_1608# VPWR 0.25014f
C16284 sg13cmos5l_inv_1_2.A a_15531_7796# 0
C16285 sg13cmos5l_buf_1_25.A a_6479_2749# 0.04018f
C16286 sg13cmos5l_dfrbp_1_0.Q a_17008_2630# 0
C16287 a_1196_8400# a_1662_8374# 0
C16288 a_1463_8511# a_1463_8741# 0.13707f
C16289 sg13cmos5l_inv_1_29.A a_12230_6162# 0.00897f
C16290 sg13cmos5l_buf_1_10.A a_11873_5760# 0
C16291 sg13cmos5l_dlhr_1_6.D a_14612_6460# 0
C16292 sg13cmos5l_buf_1_24.A a_6572_1590# 0.32385f
C16293 sg13cmos5l_or2_1_0.A a_5796_3904# 0.00677f
C16294 sg13cmos5l_inv_1_8.A sg13cmos5l_dlhr_1_2.D 0
C16295 a_16260_6480# a_16293_4629# 0
C16296 a_16677_6141# a_15876_4968# 0
C16297 sg13cmos5l_dfrbp_1_23.CLK a_12933_6141# 0.36456f
C16298 a_10665_7281# a_11190_7354# 0.13715f
C16299 a_10484_6924# a_10620_7326# 0.00404f
C16300 a_9865_7282# a_10416_6924# 0
C16301 a_19528_6924# a_19130_6172# 0
C16302 sg13cmos5l_dfrbp_1_0.Q a_17126_1626# 0.02851f
C16303 sg13cmos5l_nand2_1_0.B sg13cmos5l_dfrbp_1_10.Q 0.0041f
C16304 sg13cmos5l_a22oi_1_1.Y a_17595_3947# 0
C16305 sg13cmos5l_buf_1_5.X a_15206_2826# 0.00215f
C16306 sg13cmos5l_dfrbp_1_6.RESET_B a_5546_5850# 0
C16307 a_5492_3460# sg13cmos5l_buf_1_25.A 0
C16308 sg13cmos5l_inv_1_17.A sg13cmos5l_buf_1_34.A 0
C16309 a_15850_4873# nh_sw[7] 0
C16310 a_8247_5770# a_8041_5770# 0.2777f
C16311 sg13cmos5l_buf_8_1.A a_18117_3117# 0.0124f
C16312 sg13cmos5l_buf_1_110.A sg13cmos5l_buf_1_89.A 0.0402f
C16313 a_2122_3868# sg13cmos5l_inv_1_19.A 0
C16314 sg13cmos5l_inv_1_8.A a_7888_4870# 0
C16315 sg13cmos5l_dfrbp_1_6.D sg13cmos5l_nor2b_1_0.Y 0
C16316 sg13cmos5l_dlhr_1_9.D a_10420_5412# 0.00141f
C16317 sg13cmos5l_nor2_1_0.A sg13cmos5l_dfrbp_1_2.Q_N 0.05349f
C16318 sg13cmos5l_buf_1_78.X ph_sw[4] 0.00175f
C16319 a_8204_2352# nl_sw[4] 0.12181f
C16320 sg13cmos5l_inv_1_0.Y sg13cmos5l_nand2_1_0.B 0
C16321 a_17367_8794# a_17161_8794# 0.27471f
C16322 sg13cmos5l_dfrbp_1_15.D a_2727_6380# 0
C16323 a_19240_7712# a_19424_7010# 0.00278f
C16324 sg13cmos5l_dlhr_1_9.D a_9242_4660# 0.0063f
C16325 a_9879_9202# a_10282_7897# 0
C16326 sg13cmos5l_dlhr_1_11.Q a_13876_7660# 0
C16327 sg13cmos5l_dfrbp_1_0.CLK a_17588_2388# 0.00454f
C16328 sg13cmos5l_buf_1_10.A a_13035_6284# 0.00123f
C16329 a_12719_2749# sg13cmos5l_nor2_1_1.A 0
C16330 sg13cmos5l_dfrbp_1_6.D sg13cmos5l_buf_1_44.A 0.09266f
C16331 a_16268_3102# sg13cmos5l_buf_1_1.A 0
C16332 sg13cmos5l_buf_1_2.X a_16268_1590# 0.00135f
C16333 sg13cmos5l_inv_1_8.A a_2757_3117# 0.00476f
C16334 sg13cmos5l_buf_1_44.X pl_sw[3] 0
C16335 a_6789_4629# sg13cmos5l_buf_1_25.A 0
C16336 sg13cmos5l_dfrbp_1_8.RESET_B a_16486_6175# 0
C16337 sg13cmos5l_a22oi_1_1.Y sg13cmos5l_buf_1_2.X 0
C16338 a_15821_3864# a_15884_3102# 0.0051f
C16339 a_15702_4187# sg13cmos5l_buf_1_5.X 0
C16340 sg13cmos5l_o21ai_1_0.B1 a_13572_3151# 0
C16341 sg13cmos5l_buf_1_45.X sg13cmos5l_dlhr_1_6.D 0.23105f
C16342 sg13cmos5l_nor2_1_0.A a_10331_3900# 0
C16343 sg13cmos5l_buf_1_45.X a_8412_7326# 0
C16344 sg13cmos5l_dfrbp_1_0.D a_16551_3987# 0
C16345 a_17392_4870# a_16703_3871# 0.00979f
C16346 a_17135_4727# a_17354_4180# 0
C16347 a_10725_7653# a_11567_7751# 0.00437f
C16348 a_10308_7992# a_11824_7894# 0.00294f
C16349 sg13cmos5l_dfrbp_1_0.CLK a_17829_1605# 0.37541f
C16350 a_14032_6382# a_14152_5498# 0
C16351 sg13cmos5l_buf_1_19.A sg13cmos5l_dfrbp_1_1.Q 0
C16352 a_13681_6239# sg13cmos5l_a22oi_1_1.B2 0.0012f
C16353 a_3308_5376# sg13cmos5l_dfrbp_1_9.Q 0.00474f
C16354 sg13cmos5l_inv_1_7.A a_14900_2352# 0
C16355 sg13cmos5l_dlhr_1_1.D a_2160_4972# 0
C16356 a_12716_8400# ph_sw[5] 0.28827f
C16357 a_2628_3151# a_2732_1590# 0
C16358 a_2859_3260# nl_sw[2] 0
C16359 sg13cmos5l_buf_1_45.X a_7750_7687# 0
C16360 sg13cmos5l_buf_1_103.A sg13cmos5l_dfrbp_1_22.D 0.00194f
C16361 sg13cmos5l_or2_1_0.A sg13cmos5l_buf_8_1.A 0.38633f
C16362 a_17972_4948# a_18368_4782# 0.03121f
C16363 sg13cmos5l_buf_1_6.A a_13092_3138# 0
C16364 sg13cmos5l_buf_1_3.A a_18480_5028# 0
C16365 a_1125_5423# cks 0.00112f
C16366 a_4950_5699# a_5069_5376# 0.1333f
C16367 sg13cmos5l_dlhr_1_15.D a_11268_5760# 0
C16368 sg13cmos5l_inv_1_2.A a_15500_9150# 0.00493f
C16369 sg13cmos5l_inv_1_3.A pl_sw[7] 0
C16370 sg13cmos5l_dfrbp_1_6.D a_8247_5770# 0
C16371 a_17751_7690# a_18164_7996# 0.15652f
C16372 sg13cmos5l_buf_1_32.X a_908_1590# 0.28818f
C16373 sg13cmos5l_dfrbp_1_0.Q_N nl_sw[9] 0.00331f
C16374 sg13cmos5l_buf_1_18.A a_16657_2749# 0
C16375 a_3664_8678# a_3676_7964# 0.00484f
C16376 a_3407_8797# a_3574_7850# 0
C16377 a_2148_8440# sg13cmos5l_dfrbp_1_16.Q_N 0
C16378 sg13cmos5l_buf_1_2.A a_15062_4292# 0
C16379 a_14342_8874# a_14436_8874# 0.00718f
C16380 sg13cmos5l_dfrbp_1_0.CLK a_13072_1846# 0.00197f
C16381 a_16528_7894# a_16068_6928# 0
C16382 a_16271_7751# a_16485_6935# 0.03305f
C16383 sg13cmos5l_buf_1_18.X sg13cmos5l_buf_1_0.X 0
C16384 sg13cmos5l_a221oi_1_0.C1 sg13cmos5l_dfrbp_1_12.Q_N 0
C16385 sg13cmos5l_buf_1_78.X sg13cmos5l_buf_1_24.A 0.03586f
C16386 sg13cmos5l_inv_1_8.A sg13cmos5l_dlygate4sd2_1_0.A 0.08871f
C16387 sg13cmos5l_dfrbp_1_22.D a_15177_5769# 0
C16388 a_15208_6200# sg13cmos5l_buf_1_4.A 0
C16389 sg13cmos5l_buf_1_116.A a_15016_6294# 0
C16390 sg13cmos5l_dfrbp_1_8.RESET_B a_14986_7897# 0.02117f
C16391 a_13072_4142# sg13cmos5l_o21ai_1_0.Y 0.00177f
C16392 a_19444_5800# sg13cmos5l_dlhr_1_16.Q 0
C16393 sg13cmos5l_a221oi_1_0.A2 sg13cmos5l_buf_1_46.A 0.70372f
C16394 sg13cmos5l_buf_1_18.A a_17931_1748# 0
C16395 a_15884_3102# VPWR 0.2606f
C16396 a_10888_1664# a_10433_1652# 0
C16397 sg13cmos5l_buf_1_34.X a_4358_6924# 0
C16398 sg13cmos5l_dfrbp_1_9.Q sg13cmos5l_buf_1_39.A 0
C16399 a_9673_9240# sg13cmos5l_buf_1_97.A 0
C16400 a_10010_9196# a_10406_9624# 0.00949f
C16401 a_7052_9150# sg13cmos5l_buf_1_30.A 0.0026f
C16402 sg13cmos5l_and3_1_0.C a_13284_3456# 0
C16403 a_12520_4782# a_12520_3176# 0
C16404 sg13cmos5l_nand2_1_1.B a_12976_2630# 0
C16405 a_12132_9504# a_12420_9199# 0.4806f
C16406 a_2667_3911# a_3609_4023# 0
C16407 sg13cmos5l_dfrbp_1_0.RESET_B a_12075_3911# 0.55309f
C16408 sg13cmos5l_buf_1_34.X a_4514_7666# 0
C16409 a_4076_5376# VPWR 0.37069f
C16410 sg13cmos5l_buf_1_41.A a_3669_6320# 0.00261f
C16411 a_3831_7282# a_3625_7282# 0.27822f
C16412 sg13cmos5l_dfrbp_1_6.RESET_B a_17008_2630# 0
C16413 sg13cmos5l_dfrbp_1_0.Q nh_sw[7] 0.01096f
C16414 sg13cmos5l_nand2_1_0.A a_10783_3876# 0.00937f
C16415 sg13cmos5l_dfrbp_1_6.RESET_B a_13161_7281# 0.45938f
C16416 sg13cmos5l_inv_1_6.A pl_sw[9] 0
C16417 sg13cmos5l_buf_1_45.X a_7312_4142# 0
C16418 a_7622_2064# VPWR 0.00434f
C16419 a_8378_5776# a_8592_5412# 0.01249f
C16420 sg13cmos5l_inv_1_2.A a_15300_7687# 0
C16421 a_7498_7897# sg13cmos5l_dfrbp_1_6.D 0.00158f
C16422 sg13cmos5l_buf_1_25.A a_5577_2435# 0
C16423 a_3241_2746# sg13cmos5l_inv_1_19.A 0
C16424 sg13cmos5l_dfrbp_1_0.Q a_18376_2388# 0.02972f
C16425 a_17961_8793# ph_sw[9] 0.00513f
C16426 a_12704_4782# VPWR 0.06447f
C16427 a_7820_2352# sg13cmos5l_dlhr_1_0.Q 0.32193f
C16428 sg13cmos5l_buf_1_10.A a_12800_5498# 0.00271f
C16429 a_10665_7281# sg13cmos5l_or2_1_1.B 0
C16430 sg13cmos5l_buf_1_24.A a_6889_1680# 0.03452f
C16431 sg13cmos5l_inv_1_20.Y sg13cmos5l_inv_1_8.A 0.29005f
C16432 sg13cmos5l_or2_1_0.A a_7055_4261# 0.00637f
C16433 sg13cmos5l_dlhr_1_6.D sg13cmos5l_a22oi_1_2.B2 0.00336f
C16434 a_15206_2826# a_15909_2399# 0.02431f
C16435 sg13cmos5l_dfrbp_1_6.RESET_B a_17354_4180# 0.00594f
C16436 a_16779_6284# a_17392_4870# 0
C16437 sg13cmos5l_dfrbp_1_21.Q sg13cmos5l_buf_1_2.A 0
C16438 sg13cmos5l_and3_1_0.C a_13324_4696# 0.24927f
C16439 a_11190_7354# a_11560_7010# 0.03916f
C16440 sg13cmos5l_dfrbp_1_0.Q a_18928_1846# 0
C16441 sg13cmos5l_a221oi_1_0.B1 a_12120_3456# 0
C16442 sg13cmos5l_dfrbp_1_6.RESET_B a_8852_6484# 0.12012f
C16443 sg13cmos5l_dfrbp_1_8.RESET_B a_2748_6126# 0.49068f
C16444 sg13cmos5l_nand2_1_1.A a_20012_2352# 0.00187f
C16445 sg13cmos5l_buf_1_30.X nh_sw[4] 0.08923f
C16446 a_11434_2356# nh_sw[5] 0
C16447 a_7316_3460# a_7452_3174# 0.00404f
C16448 a_7497_3138# a_7732_3124# 0.00566f
C16449 sg13cmos5l_buf_1_4.X sg13cmos5l_nor2b_1_1.Y 0
C16450 sg13cmos5l_buf_1_5.X a_14858_2388# 0
C16451 sg13cmos5l_dfrbp_1_6.RESET_B sg13cmos5l_buf_8_0.A 0.01056f
C16452 sg13cmos5l_buf_1_25.X a_3496_1758# 0
C16453 a_5324_1590# VPWR 0.25566f
C16454 a_15909_2399# a_16552_1664# 0.00541f
C16455 a_8680_1664# nh_sw[4] 0.00464f
C16456 sg13cmos5l_buf_1_77.A a_8988_6198# 0
C16457 a_4518_7996# VPWR 0
C16458 a_15821_3864# a_15492_2392# 0.00121f
C16459 sg13cmos5l_inv_1_8.A sg13cmos5l_dfrbp_1_12.Q_N 0
C16460 sg13cmos5l_buf_1_0.A a_17931_1748# 0.00689f
C16461 sg13cmos5l_a22oi_1_1.B2 sg13cmos5l_nand2_1_1.B 0.37626f
C16462 ph_sw[0] pl_sw[0] 0.11189f
C16463 cks pl_sw[7] 0.00332f
C16464 sg13cmos5l_dfrbp_1_0.D a_17170_2826# 0
C16465 sg13cmos5l_dfrbp_1_15.D a_3530_6320# 0
C16466 sg13cmos5l_nand2_1_1.A a_18873_1941# 0
C16467 a_8570_6172# a_8966_6600# 0.00949f
C16468 a_4456_1664# nh_sw[2] 0.00123f
C16469 sg13cmos5l_nor2_1_0.A a_13284_3456# 0.05387f
C16470 sg13cmos5l_dfrbp_1_18.Q a_10116_7674# 0
C16471 a_17584_7166# a_17529_7047# 0.00464f
C16472 sg13cmos5l_dfrbp_1_0.CLK a_19244_2352# 0
C16473 a_7055_4261# a_7820_2352# 0.00132f
C16474 sg13cmos5l_buf_1_40.A a_1227_5423# 0.05377f
C16475 sg13cmos5l_dfrbp_1_0.Q a_15357_1816# 0.19811f
C16476 a_15821_3864# a_16572_4261# 0.01741f
C16477 a_1402_3864# sg13cmos5l_inv_1_19.A 0.00168f
C16478 sg13cmos5l_inv_1_2.A sg13cmos5l_o21ai_1_0.B1 0
C16479 sg13cmos5l_dfrbp_1_0.D a_17769_2017# 0
C16480 sg13cmos5l_inv_1_17.A a_3505_3215# 0.00524f
C16481 a_19227_9190# sg13cmos5l_buf_1_104.A 0.01926f
C16482 a_18345_7674# VPWR 0.62552f
C16483 a_11567_7751# a_12404_7972# 0.1333f
C16484 sg13cmos5l_inv_1_3.A a_13977_6477# 0.00178f
C16485 a_10827_7796# a_11473_7751# 0.00667f
C16486 sg13cmos5l_buf_1_116.A a_15702_5842# 0.59316f
C16487 sg13cmos5l_inv_1_8.A a_2374_8861# 0
C16488 a_17896_9224# pl_sw[8] 0
C16489 sg13cmos5l_buf_1_57.X a_9865_7282# 0.16111f
C16490 sg13cmos5l_inv_1_20.Y a_1948_7964# 0
C16491 a_7052_9150# pl_sw[5] 0.00158f
C16492 sg13cmos5l_dfrbp_1_6.D a_17988_3151# 0
C16493 a_1609_4704# sg13cmos5l_inv_1_19.A 0.01344f
C16494 sg13cmos5l_dlhr_1_9.D a_6891_4772# 0.00767f
C16495 sg13cmos5l_buf_1_30.A sg13cmos5l_dlhr_1_0.GATE 0
C16496 a_3692_9150# a_3407_8797# 0
C16497 sg13cmos5l_inv_1_17.A a_3664_8678# 0.03514f
C16498 a_13284_3456# a_14440_1664# 0
C16499 a_13701_3117# a_14056_1664# 0
C16500 sg13cmos5l_buf_1_41.X a_2732_1590# 0.07022f
C16501 a_3241_2746# sg13cmos5l_buf_1_33.A 0.00157f
C16502 sg13cmos5l_dfrbp_1_6.D a_1760_3986# 0
C16503 sg13cmos5l_inv_1_26.Y a_17792_9318# 0.06036f
C16504 sg13cmos5l_nor2b_1_0.Y a_11873_5760# 0
C16505 sg13cmos5l_dfrbp_1_6.RESET_B a_2386_7362# 0
C16506 sg13cmos5l_buf_1_44.A a_5194_2356# 0
C16507 a_5069_5376# a_5710_5850# 0.32273f
C16508 a_5452_5850# a_5546_5850# 0.0019f
C16509 sg13cmos5l_nor2_1_0.A a_13324_4696# 0.09599f
C16510 a_10998_9168# sg13cmos5l_dfrbp_1_8.RESET_B 0.00125f
C16511 a_11464_9224# sg13cmos5l_buf_1_90.X 0.28943f
C16512 sg13cmos5l_dfrbp_1_23.CLK sg13cmos5l_buf_1_98.A 0
C16513 sg13cmos5l_inv_1_2.A a_8043_7796# 0
C16514 sg13cmos5l_buf_1_19.A a_19528_6924# 0.005f
C16515 a_18870_7656# sg13cmos5l_dlhr_1_15.Q 0.61496f
C16516 sg13cmos5l_buf_1_18.A a_19628_2352# 0
C16517 a_14342_8874# a_15147_8447# 0.11742f
C16518 a_19904_7806# cko 0
C16519 sg13cmos5l_dfrbp_1_17.Q_N a_4076_7624# 0
C16520 sg13cmos5l_buf_1_2.A a_16298_4338# 0
C16521 sg13cmos5l_dfrbp_1_15.D a_3676_7964# 0.01698f
C16522 sg13cmos5l_or2_1_0.A a_11877_2399# 0
C16523 sg13cmos5l_dlhr_1_15.D a_16485_6935# 0.01784f
C16524 sg13cmos5l_dfrbp_1_21.Q a_12216_5728# 0.2535f
C16525 a_15492_2392# VPWR 0.07931f
C16526 a_6789_4629# a_6961_4261# 0.00107f
C16527 sg13cmos5l_dfrbp_1_0.CLK sg13cmos5l_a22oi_1_1.Y 0.01951f
C16528 a_10416_6924# VPWR 0
C16529 sg13cmos5l_inv_1_26.Y a_18860_9150# 0
C16530 sg13cmos5l_dfrbp_1_8.RESET_B a_15429_7653# 0.06344f
C16531 sg13cmos5l_dfrbp_1_8.RESET_B a_3814_4663# 0
C16532 a_1672_3176# a_1864_1664# 0
C16533 sg13cmos5l_buf_1_94.X a_14628_8440# 0
C16534 a_19028_5412# sg13cmos5l_a22oi_1_1.A1 0
C16535 sg13cmos5l_buf_1_73.A a_7238_7674# 0.05172f
C16536 a_10427_2736# a_10613_2758# 0
C16537 a_11782_1639# VPWR 0
C16538 sg13cmos5l_buf_1_34.X ph_sw[1] 0
C16539 sg13cmos5l_a221oi_1_0.A2 sg13cmos5l_nand2_1_1.B 0
C16540 sg13cmos5l_dfrbp_1_6.RESET_B a_16617_6553# 0
C16541 a_12549_9165# sg13cmos5l_inv_1_29.A 0.00348f
C16542 a_13035_6284# sg13cmos5l_nor2b_1_0.Y 0
C16543 a_16572_4261# VPWR 0.08066f
C16544 sg13cmos5l_a221oi_1_0.A2 a_7497_3138# 0
C16545 sg13cmos5l_and3_1_0.C a_15380_3436# 0
C16546 sg13cmos5l_nand2_1_1.B a_14254_2444# 0
C16547 sg13cmos5l_nand2_1_0.A sg13cmos5l_dfrbp_1_0.Q 0.68248f
C16548 a_16264_9224# sg13cmos5l_buf_1_103.A 0.07864f
C16549 sg13cmos5l_buf_1_77.A a_9189_8447# 0.00355f
C16550 sg13cmos5l_dfrbp_1_8.RESET_B a_424_8436# 0
C16551 a_13391_9263# a_13297_9263# 0.32273f
C16552 sg13cmos5l_inv_1_27.Y a_13593_9501# 0
C16553 a_15016_9224# sg13cmos5l_buf_1_101.X 0
C16554 a_15429_7653# a_15414_7354# 0.01221f
C16555 sg13cmos5l_inv_1_3.A a_14602_8404# 0.00326f
C16556 sg13cmos5l_dfrbp_1_0.RESET_B a_11913_3947# 0
C16557 sg13cmos5l_dfrbp_1_29.Q_N VPWR 0.17778f
C16558 a_11372_3102# sg13cmos5l_buf_1_8.X 0.00165f
C16559 a_12230_6162# a_12804_6175# 0.36169f
C16560 a_8486_8874# sg13cmos5l_dlhr_1_5.Q 0
C16561 a_3962_7288# a_4244_6924# 0.68988f
C16562 a_17988_3151# a_17926_3151# 0
C16563 sg13cmos5l_buf_1_41.A a_3308_5376# 0.29251f
C16564 sg13cmos5l_a22oi_1_1.B2 sg13cmos5l_a22oi_1_1.A1 0.20031f
C16565 sg13cmos5l_dfrbp_1_6.RESET_B a_14426_7288# 0.00868f
C16566 sg13cmos5l_buf_1_45.X a_8972_3864# 0.29839f
C16567 a_10433_1652# VPWR 0
C16568 a_12216_5728# sg13cmos5l_or2_1_1.B 0.20936f
C16569 sg13cmos5l_buf_1_65.X a_5800_9224# 0.00709f
C16570 a_10618_3142# VPWR 0
C16571 a_15590_4650# sg13cmos5l_dfrbp_1_0.RESET_B 0
C16572 sg13cmos5l_nand2_1_0.A a_12896_3270# 0
C16573 sg13cmos5l_o21ai_1_0.A1 a_13652_3900# 0
C16574 sg13cmos5l_dlhr_1_6.D a_11268_5760# 0
C16575 sg13cmos5l_dfrbp_1_9.Q a_5510_4338# 0
C16576 sg13cmos5l_buf_1_95.X a_12232_8436# 0.28827f
C16577 sg13cmos5l_dfrbp_1_0.RESET_B a_11973_3911# 0.05497f
C16578 sg13cmos5l_nand2_1_1.B a_10427_2736# 0.00121f
C16579 a_11560_7010# sg13cmos5l_or2_1_1.B 0
C16580 sg13cmos5l_a22oi_1_1.B1 sg13cmos5l_buf_1_28.X 0.00444f
C16581 sg13cmos5l_or2_1_0.A a_7257_4023# 0
C16582 a_15492_2392# a_15718_2813# 0.00523f
C16583 a_15466_2356# a_15780_2813# 0.00659f
C16584 a_18356_6460# sg13cmos5l_dfrbp_1_0.D 0.00113f
C16585 a_12814_4692# a_12704_4782# 0.0073f
C16586 sg13cmos5l_buf_1_0.A a_19628_2352# 0
C16587 a_14543_3215# nh_sw[7] 0.0055f
C16588 sg13cmos5l_o21ai_1_0.A1 a_11270_4338# 0.06022f
C16589 sg13cmos5l_dfrbp_1_6.RESET_B a_13641_7674# 0.46148f
C16590 sg13cmos5l_dfrbp_1_8.RESET_B a_2638_6162# 0
C16591 sg13cmos5l_inv_1_27.Y a_14152_5498# 0
C16592 sg13cmos5l_buf_1_90.X sg13cmos5l_buf_1_5.A 0.04045f
C16593 sg13cmos5l_buf_1_104.X cks 0
C16594 sg13cmos5l_dfrbp_1_8.RESET_B a_1967_5773# 0.00533f
C16595 sg13cmos5l_buf_1_78.A a_5796_8874# 0
C16596 sg13cmos5l_buf_1_0.A a_20296_1664# 0.0031f
C16597 a_16551_3987# a_15492_2392# 0
C16598 sg13cmos5l_dfrbp_1_6.D a_5028_2826# 0
C16599 sg13cmos5l_buf_1_41.A sg13cmos5l_buf_1_39.A 0.0395f
C16600 sg13cmos5l_buf_1_101.X a_16473_7989# 0
C16601 sg13cmos5l_inv_1_0.A a_10464_2427# 0
C16602 sg13cmos5l_dlhr_1_1.GATE a_2224_7166# 0.01309f
C16603 sg13cmos5l_inv_1_1.A a_16617_6553# 0
C16604 a_11567_7751# a_12230_6162# 0
C16605 a_10028_6126# sg13cmos5l_buf_1_29.A 0.12558f
C16606 sg13cmos5l_buf_1_56.A sg13cmos5l_dlhr_1_6.Q_N 0.00567f
C16607 sg13cmos5l_dfrbp_1_8.RESET_B a_15016_9224# 0
C16608 VPWR nh_sw[2] 0.11139f
C16609 a_2122_8404# ph_sw[1] 0
C16610 sg13cmos5l_nor2b_1_0.Y sg13cmos5l_buf_1_9.A 0.03601f
C16611 a_16552_1664# a_17126_1626# 0
C16612 a_1862_8874# sg13cmos5l_inv_1_19.A 0.00396f
C16613 a_8588_3864# a_8588_2352# 0.001f
C16614 sg13cmos5l_buf_1_40.A a_1065_5459# 0
C16615 sg13cmos5l_buf_1_8.X nh_sw[5] 0.27271f
C16616 a_19227_9190# pl_sw[10] 0.07753f
C16617 a_15821_3864# a_16703_3871# 0.00437f
C16618 a_16572_4261# a_16551_3987# 0.38902f
C16619 a_8972_9150# sg13cmos5l_inv_1_2.A 0.01006f
C16620 sg13cmos5l_inv_1_18.A a_9256_9224# 0.33994f
C16621 a_12404_7972# sg13cmos5l_dlhr_1_11.D 0.27671f
C16622 a_10596_7687# a_10534_7687# 0
C16623 a_6903_3154# a_7316_3460# 0.15652f
C16624 sg13cmos5l_buf_1_6.A a_14476_2388# 0
C16625 a_13803_3260# sg13cmos5l_buf_1_8.A 0
C16626 a_10116_7674# cks 0
C16627 a_17041_4727# sg13cmos5l_buf_1_4.X 0
C16628 a_9705_4650# a_9638_5088# 0
C16629 a_8905_4704# sg13cmos5l_buf_1_46.A 0
C16630 a_9524_4972# a_9456_4972# 0
C16631 sg13cmos5l_inv_1_2.A a_16164_4663# 0.00285f
C16632 sg13cmos5l_dlhr_1_9.D a_7833_4965# 0
C16633 cks sg13cmos5l_buf_1_61.X 0
C16634 sg13cmos5l_dfrbp_1_8.RESET_B a_4324_7996# 0
C16635 sg13cmos5l_inv_1_17.A sg13cmos5l_dfrbp_1_15.D 0.22441f
C16636 a_13803_3260# sg13cmos5l_buf_1_1.A 0
C16637 a_14543_3215# a_15357_1816# 0
C16638 sg13cmos5l_buf_1_41.X nl_sw[2] 0.00402f
C16639 a_12075_1748# a_11844_1639# 0.15089f
C16640 a_11556_1944# a_12721_1703# 0.4858f
C16641 sg13cmos5l_inv_1_17.A sg13cmos5l_buf_1_40.A 0.00125f
C16642 sg13cmos5l_nor2b_1_0.Y a_12800_5498# 0
C16643 sg13cmos5l_buf_1_5.A a_11190_7354# 0
C16644 sg13cmos5l_buf_1_44.A a_5739_2399# 0
C16645 a_14602_8404# cks 0.01602f
C16646 a_4640_3986# sg13cmos5l_dfrbp_1_10.Q 0
C16647 sg13cmos5l_dfrbp_1_6.D a_12933_6141# 0.00824f
C16648 a_5710_5850# a_5799_5499# 0.00667f
C16649 a_2248_1664# nh_sw[0] 0
C16650 a_6741_5459# sg13cmos5l_or2_1_0.A 0
C16651 sg13cmos5l_nor2_1_0.A a_12520_4782# 0.00828f
C16652 sg13cmos5l_buf_1_111.A a_17367_8794# 0
C16653 sg13cmos5l_inv_1_2.A a_9620_7972# 0.00465f
C16654 sg13cmos5l_dfrbp_1_6.RESET_B a_1096_6294# 0.02914f
C16655 sg13cmos5l_or2_1_0.A a_12976_2630# 0
C16656 a_14628_8440# a_15793_8797# 0.4858f
C16657 a_14916_8861# a_15147_8447# 0.15089f
C16658 sg13cmos5l_buf_1_73.A a_7336_7010# 0.00112f
C16659 sg13cmos5l_inv_1_6.A a_20118_6144# 0.05288f
C16660 sg13cmos5l_dlhr_1_15.D a_17327_7285# 0.0313f
C16661 a_14032_6382# sg13cmos5l_a22oi_1_1.B2 0
C16662 sg13cmos5l_dfrbp_1_23.Q_N a_13076_5376# 0
C16663 a_16011_2399# VPWR 0.2134f
C16664 a_12980_6924# VPWR 0.10723f
C16665 a_17545_7728# a_16779_6284# 0
C16666 sg13cmos5l_dfrbp_1_16.Q sg13cmos5l_buf_1_29.A 0.06441f
C16667 sg13cmos5l_buf_1_87.A a_18615_5770# 0
C16668 a_708_5416# cks 0.04233f
C16669 sg13cmos5l_dfrbp_1_1.Q sg13cmos5l_dfrbp_1_0.Q 4.11259f
C16670 a_13686_7354# sg13cmos5l_dfrbp_1_21.Q 0
C16671 sg13cmos5l_buf_1_73.A a_7332_7674# 0
C16672 sg13cmos5l_buf_1_94.X a_15887_8797# 0
C16673 a_1463_8741# a_1125_6935# 0
C16674 sg13cmos5l_buf_1_44.A a_5210_3148# 0.00117f
C16675 sg13cmos5l_o21ai_1_0.Y a_13284_3456# 0.00703f
C16676 sg13cmos5l_buf_1_32.X a_424_1664# 0
C16677 a_11530_1849# a_11270_1626# 0.87117f
C16678 a_16936_1758# VPWR 0.14319f
C16679 sg13cmos5l_inv_1_27.Y sg13cmos5l_inv_1_29.A 0.10995f
C16680 sg13cmos5l_dfrbp_1_6.RESET_B a_16486_6175# 0
C16681 a_16703_3871# VPWR 0.25424f
C16682 sg13cmos5l_dfrbp_1_21.Q a_17750_4325# 0
C16683 a_9033_6162# VPWR 0.62275f
C16684 sg13cmos5l_inv_1_14.A sg13cmos5l_inv_1_11.Y 0
C16685 a_15300_7687# a_14889_7281# 0
C16686 a_6086_4650# sg13cmos5l_buf_1_44.A 0.00108f
C16687 sg13cmos5l_inv_1_3.A a_16144_8678# 0
C16688 sg13cmos5l_dfrbp_1_1.Q a_12896_3270# 0
C16689 a_18574_5028# VPWR 0.01274f
C16690 sg13cmos5l_dlhr_1_0.D a_9823_2364# 0
C16691 a_15208_6200# a_15592_6200# 0.00492f
C16692 a_416_2474# ckc 0
C16693 sg13cmos5l_dfrbp_1_0.RESET_B a_12998_3138# 0.09902f
C16694 sg13cmos5l_inv_1_7.A sg13cmos5l_buf_1_10.A 0.13087f
C16695 sg13cmos5l_dfrbp_1_16.Q a_4950_5699# 0.00665f
C16696 sg13cmos5l_buf_1_8.X a_9823_2780# 0
C16697 a_4425_7281# a_4950_7354# 0.13715f
C16698 a_4244_6924# a_4380_7326# 0.00404f
C16699 sg13cmos5l_a221oi_1_0.A2 a_9705_4650# 0.01347f
C16700 a_11913_2017# VPWR 0
C16701 a_17392_4870# sg13cmos5l_dfrbp_1_0.RESET_B 0
C16702 sg13cmos5l_buf_1_57.X VPWR 1.0537f
C16703 sg13cmos5l_buf_1_4.A sg13cmos5l_buf_1_4.X 0.42079f
C16704 a_15206_2826# nh_sw[7] 0.02188f
C16705 a_4349_7636# ph_sw[2] 0
C16706 a_20118_6144# a_20204_5376# 0
C16707 a_13686_7354# sg13cmos5l_or2_1_1.B 0
C16708 sg13cmos5l_a22oi_1_1.B2 sg13cmos5l_or2_1_0.A 0.00111f
C16709 sg13cmos5l_buf_1_24.A a_7644_1662# 0
C16710 a_2667_3911# a_3407_4261# 0.3087f
C16711 sg13cmos5l_inv_1_8.A a_422_5850# 0
C16712 a_15909_2399# a_16657_2749# 0.01058f
C16713 a_15466_2356# a_15849_2435# 0.00337f
C16714 a_12698_7288# a_12980_6924# 0.68988f
C16715 sg13cmos5l_dfrbp_1_8.RESET_B a_6117_6141# 0.01129f
C16716 sg13cmos5l_dfrbp_1_6.RESET_B a_14986_7897# 0.32843f
C16717 sg13cmos5l_o21ai_1_0.A1 a_11844_4325# 0.00172f
C16718 sg13cmos5l_dfrbp_1_6.RESET_B a_2644_4636# 0.00573f
C16719 sg13cmos5l_buf_1_5.A sg13cmos5l_dfrbp_1_21.Q 0.02396f
C16720 sg13cmos5l_buf_1_28.A VPWR 0.4772f
C16721 a_15702_4187# nh_sw[7] 0
C16722 a_10292_9508# ph_sw[5] 0.00105f
C16723 sg13cmos5l_inv_1_17.A a_4460_9150# 0
C16724 sg13cmos5l_dlhr_1_18.Q_N sg13cmos5l_nor2_1_0.A 0
C16725 sg13cmos5l_buf_1_78.A a_6276_8861# 0.00283f
C16726 a_16551_3987# a_16011_2399# 0
C16727 sg13cmos5l_buf_1_0.A a_20672_1758# 0
C16728 a_1463_8511# sg13cmos5l_buf_1_63.A 0.03733f
C16729 sg13cmos5l_dfrbp_1_6.D a_5508_2813# 0
C16730 sg13cmos5l_buf_1_111.A a_18870_7656# 0
C16731 sg13cmos5l_inv_1_26.Y a_19240_7712# 0.00782f
C16732 a_1873_7285# VPWR 0.00313f
C16733 pl_sw[7] pl_sw[9] 0
C16734 sg13cmos5l_dlhr_1_11.D a_12230_6162# 0
C16735 a_11182_4676# sg13cmos5l_nand2_1_0.A 0
C16736 a_2786_7666# VPWR 0
C16737 sg13cmos5l_dfrbp_1_8.RESET_B a_7941_7653# 0.0063f
C16738 a_2667_8447# sg13cmos5l_inv_1_19.A 0
C16739 sg13cmos5l_inv_1_18.A a_10473_9186# 0
C16740 sg13cmos5l_nor2b_1_0.Y sg13cmos5l_dfrbp_1_1.D 0.02741f
C16741 a_17700_3456# sg13cmos5l_nor2_1_1.A 0.00342f
C16742 sg13cmos5l_dlhr_1_15.D a_12815_4261# 0
C16743 a_16551_3987# a_16703_3871# 0.66105f
C16744 sg13cmos5l_inv_1_3.A a_13076_5376# 0
C16745 a_6697_3192# a_7248_3460# 0
C16746 sg13cmos5l_buf_1_5.X sg13cmos5l_buf_1_8.A 0
C16747 sg13cmos5l_buf_1_39.A a_6188_1590# 0
C16748 sg13cmos5l_buf_1_25.X a_5324_1590# 0.01243f
C16749 a_15206_2826# a_15357_1816# 0
C16750 sg13cmos5l_dfrbp_1_6.D a_4873_3192# 0.01974f
C16751 sg13cmos5l_buf_1_96.A sg13cmos5l_dlhr_1_15.D 0.00217f
C16752 sg13cmos5l_buf_1_45.X a_8378_5776# 0.02841f
C16753 a_16779_6284# VPWR 0.20952f
C16754 a_4934_2826# a_5220_2392# 0.50066f
C16755 sg13cmos5l_buf_1_5.A sg13cmos5l_or2_1_1.B 0
C16756 sg13cmos5l_buf_1_40.A a_996_5837# 0.01209f
C16757 a_8439_6178# a_8852_6484# 0.15652f
C16758 sg13cmos5l_inv_1_2.A a_13297_9263# 0.00756f
C16759 sg13cmos5l_nor2_1_0.A a_12520_3176# 0.0058f
C16760 sg13cmos5l_nor2_1_0.A a_10331_1924# 0
C16761 sg13cmos5l_buf_1_5.X sg13cmos5l_buf_1_1.A 0.01177f
C16762 sg13cmos5l_buf_1_5.A a_14476_2388# 0.00246f
C16763 a_13072_1846# sg13cmos5l_dfrbp_1_1.Q_N 0.15881f
C16764 a_9033_6162# sg13cmos5l_dfrbp_1_11.Q 0.00163f
C16765 a_12815_1703# a_13234_1626# 0.00176f
C16766 sg13cmos5l_a221oi_1_0.C1 a_11530_3868# 0
C16767 a_16144_8678# cks 0.01223f
C16768 a_7631_4727# sg13cmos5l_dlhr_1_2.Q_N 0
C16769 sg13cmos5l_buf_1_5.A a_12567_7282# 0.01486f
C16770 sg13cmos5l_dfrbp_1_6.D a_15208_6200# 0.00569f
C16771 sg13cmos5l_a221oi_1_0.A2 sg13cmos5l_or2_1_0.A 0.00598f
C16772 sg13cmos5l_dfrbp_1_6.RESET_B a_2748_6126# 0.0235f
C16773 sg13cmos5l_inv_1_1.A a_14986_7897# 0
C16774 a_15887_8797# a_15793_8797# 0.32273f
C16775 a_16144_8678# a_16306_8874# 0.0019f
C16776 sg13cmos5l_buf_1_57.X a_8233_6216# 0
C16777 sg13cmos5l_dfrbp_1_6.RESET_B sg13cmos5l_dfrbp_1_1.Q 0.00152f
C16778 sg13cmos5l_dfrbp_1_5.Q_N VPWR 0.18049f
C16779 sg13cmos5l_dfrbp_1_23.Q_N sg13cmos5l_and3_1_0.X 0
C16780 a_1760_9318# a_1662_8374# 0
C16781 sg13cmos5l_dfrbp_1_12.Q_N a_7474_4338# 0
C16782 sg13cmos5l_inv_1_2.A sg13cmos5l_buf_1_103.A 0
C16783 sg13cmos5l_inv_1_8.A a_1463_8741# 0
C16784 a_14089_7282# VPWR 0.40882f
C16785 a_18345_7674# a_18356_6460# 0
C16786 sg13cmos5l_inv_1_0.A a_10420_5412# 0
C16787 sg13cmos5l_dlhr_1_16.Q_N a_19227_4654# 0
C16788 sg13cmos5l_buf_1_63.A a_1280_6294# 0
C16789 sg13cmos5l_dfrbp_1_23.Q sg13cmos5l_dfrbp_1_21.Q 0.00905f
C16790 sg13cmos5l_dfrbp_1_8.RESET_B a_1846_7850# 0
C16791 sg13cmos5l_inv_1_0.A a_9242_4660# 0
C16792 sg13cmos5l_buf_1_6.A a_13072_1846# 0
C16793 sg13cmos5l_dfrbp_1_6.D sg13cmos5l_dlygate4sd3_1_0.X 0
C16794 a_11270_1626# a_12815_1703# 0
C16795 a_18671_1703# VPWR 0.25855f
C16796 a_4640_3986# a_4566_2818# 0
C16797 sg13cmos5l_dlhr_1_15.D sg13cmos5l_a221oi_1_0.B1 0.16941f
C16798 a_18363_4270# VPWR 1.26081f
C16799 sg13cmos5l_inv_1_18.A a_9164_1590# 0
C16800 sg13cmos5l_buf_1_44.X sg13cmos5l_buf_1_62.X 0
C16801 sg13cmos5l_inv_1_2.A a_15177_5769# 0
C16802 a_16528_7894# a_16690_7674# 0.0019f
C16803 sg13cmos5l_buf_1_105.A a_18568_7010# 0
C16804 sg13cmos5l_inv_1_8.A ph_sw[2] 0
C16805 a_13178_7684# VPWR 0.3584f
C16806 sg13cmos5l_dfrbp_1_15.D a_2831_7630# 0.05394f
C16807 sg13cmos5l_buf_1_2.A sg13cmos5l_a22oi_1_1.Y 0.02614f
C16808 sg13cmos5l_and3_1_0.C a_14814_3876# 0.01122f
C16809 sg13cmos5l_buf_1_3.A a_19209_5769# 0.04091f
C16810 a_15238_7687# sg13cmos5l_buf_1_89.A 0
C16811 sg13cmos5l_buf_1_18.X sg13cmos5l_buf_1_19.X 0.03473f
C16812 a_1580_2352# a_2824_2388# 0
C16813 a_12516_6480# a_13076_5376# 0
C16814 a_11752_6294# a_11771_5412# 0
C16815 sg13cmos5l_dfrbp_1_1.Q a_14543_3215# 0
C16816 sg13cmos5l_inv_1_8.A sg13cmos5l_nand2_1_2.B 0.74557f
C16817 sg13cmos5l_nand2_1_0.A a_15206_2826# 0.00421f
C16818 sg13cmos5l_dfrbp_1_0.RESET_B a_14800_3358# 0.18949f
C16819 a_18345_7674# ph_sw[9] 0.04792f
C16820 sg13cmos5l_buf_1_30.A a_6865_6239# 0.00268f
C16821 sg13cmos5l_dfrbp_1_16.Q a_5710_5850# 0
C16822 sg13cmos5l_inv_1_14.A a_8214_1608# 0
C16823 sg13cmos5l_buf_1_90.X ph_sw[5] 0.02889f
C16824 sg13cmos5l_buf_1_24.A a_5799_5499# 0.01507f
C16825 a_14924_1590# VPWR 0.2678f
C16826 a_14924_1590# nl_sw[7] 0.00118f
C16827 sg13cmos5l_dfrbp_1_6.RESET_B a_10998_9168# 0
C16828 a_12520_4782# sg13cmos5l_o21ai_1_0.Y 0
C16829 sg13cmos5l_buf_1_98.A sg13cmos5l_dfrbp_1_6.D 0
C16830 sg13cmos5l_dfrbp_1_23.Q sg13cmos5l_or2_1_1.B 0.18702f
C16831 a_3407_4261# sg13cmos5l_dfrbp_1_9.Q_N 0.04107f
C16832 a_3313_4261# a_3826_4338# 0
C16833 a_2667_3911# sg13cmos5l_buf_1_38.A 0
C16834 a_16751_2749# a_17588_2388# 0.1333f
C16835 a_17008_2630# a_16657_2749# 0.01017f
C16836 a_8488_9224# sg13cmos5l_dfrbp_1_8.RESET_B 0.0137f
C16837 sg13cmos5l_dlhr_1_5.GATE a_7378_6162# 0
C16838 sg13cmos5l_a22oi_1_1.B1 a_13652_3900# 0.013f
C16839 sg13cmos5l_dlhr_1_1.Q VPWR 0.50644f
C16840 a_13161_7281# a_13396_7312# 0.00566f
C16841 sg13cmos5l_dfrbp_1_1.Q a_9832_1664# 0
C16842 a_12230_6162# a_12324_6162# 0.00718f
C16843 a_12933_6141# a_13035_6284# 0.66105f
C16844 sg13cmos5l_dfrbp_1_6.RESET_B a_15429_7653# 0.05221f
C16845 sg13cmos5l_dfrbp_1_23.CLK a_14640_6924# 0
C16846 sg13cmos5l_dfrbp_1_8.RESET_B a_7161_6477# 0.00293f
C16847 sg13cmos5l_dfrbp_1_0.RESET_B a_10888_1664# 0
C16848 a_18219_3260# a_18865_3215# 0.00667f
C16849 a_18959_3215# a_19161_3453# 0.00675f
C16850 sg13cmos5l_inv_1_6.A a_20008_3900# 0.00258f
C16851 a_8247_5770# a_7631_4727# 0.01005f
C16852 sg13cmos5l_or2_1_0.A a_6697_3192# 0.0033f
C16853 sg13cmos5l_a22oi_1_0.B1 a_10783_3876# 0.081f
C16854 sg13cmos5l_buf_1_104.X pl_sw[9] 0
C16855 sg13cmos5l_dfrbp_1_8.RESET_B a_17337_4965# 0.00343f
C16856 a_12913_7326# sg13cmos5l_nor2_1_0.A 0
C16857 sg13cmos5l_a221oi_1_0.A2 a_11072_5347# 0.0023f
C16858 sg13cmos5l_buf_1_31.X a_2824_2388# 0
C16859 a_2565_3911# a_2436_4325# 0.01562f
C16860 a_2148_3904# a_2667_3911# 0.38871f
C16861 sg13cmos5l_buf_1_78.A a_6345_8483# 0
C16862 a_15531_7796# pl_sw[8] 0
C16863 sg13cmos5l_a22oi_1_1.B1 a_11270_4338# 0.0124f
C16864 sg13cmos5l_dfrbp_1_6.RESET_B a_9366_5842# 0.00284f
C16865 sg13cmos5l_buf_1_57.X a_16260_6480# 0.00225f
C16866 a_19227_4654# d_out[1] 0.00143f
C16867 a_18793_6216# a_18746_5776# 0
C16868 sg13cmos5l_dfrbp_1_8.RESET_B a_9040_7894# 0.0085f
C16869 sg13cmos5l_dfrbp_1_6.RESET_B a_424_8436# 0.00226f
C16870 a_1997_6126# VPWR 0.276f
C16871 a_13047_7690# a_12980_6924# 0.00316f
C16872 sg13cmos5l_dlhr_1_1.GATE a_2879_6432# 0.00113f
C16873 a_1967_7285# a_1873_7285# 0.32273f
C16874 a_2224_7166# a_2386_7362# 0.0019f
C16875 a_17126_1626# a_17931_1748# 0.11742f
C16876 a_17412_1944# a_17829_1605# 0.48921f
C16877 sg13cmos5l_inv_1_17.A a_3008_1758# 0
C16878 sg13cmos5l_dlhr_1_15.D sg13cmos5l_nand2_1_1.A 0
C16879 sg13cmos5l_a221oi_1_0.B1 sg13cmos5l_o21ai_1_0.A2 0
C16880 a_17354_4180# a_17399_3947# 0.36169f
C16881 sg13cmos5l_dlhr_1_5.GATE a_4076_5376# 0
C16882 sg13cmos5l_inv_1_3.A sg13cmos5l_and3_1_0.X 0.30591f
C16883 sg13cmos5l_inv_1_27.Y sg13cmos5l_a22oi_1_1.B2 0
C16884 a_9033_6162# sg13cmos5l_dlhr_1_17.Q_N 0.00127f
C16885 sg13cmos5l_dfrbp_1_6.RESET_B a_9448_6924# 0.01563f
C16886 a_7153_8797# sg13cmos5l_dfrbp_1_6.D 0
C16887 sg13cmos5l_inv_1_7.A sg13cmos5l_nor2b_1_0.Y 0.02392f
C16888 sg13cmos5l_buf_1_8.A a_12721_1703# 0.00154f
C16889 a_15909_2399# sg13cmos5l_buf_1_1.A 0
C16890 sg13cmos5l_dfrbp_1_6.D a_4018_3138# 0
C16891 a_17224_3270# cks 0.00116f
C16892 sg13cmos5l_inv_1_18.A sg13cmos5l_buf_1_29.A 0.56179f
C16893 sg13cmos5l_dfrbp_1_10.Q a_7316_3460# 0.00981f
C16894 a_7034_3148# a_7316_2388# 0.00126f
C16895 sg13cmos5l_dfrbp_1_6.D a_3860_2388# 0.00687f
C16896 sg13cmos5l_dlhr_1_15.D a_16293_4629# 0.00494f
C16897 sg13cmos5l_buf_1_107.X sg13cmos5l_buf_1_104.A 0.19269f
C16898 sg13cmos5l_dfrbp_1_10.Q a_4934_2826# 0
C16899 a_16548_6175# VPWR 0.00704f
C16900 a_5194_2356# a_5508_2813# 0.00659f
C16901 a_9558_6144# a_10028_6126# 0.03379f
C16902 a_8852_6484# sg13cmos5l_buf_1_56.A 0
C16903 a_5220_2392# a_5446_2813# 0.00523f
C16904 sg13cmos5l_buf_1_25.X nh_sw[2] 0.01121f
C16905 sg13cmos5l_or2_1_0.A a_2667_3911# 0.00961f
C16906 a_4950_5699# a_4847_4727# 0
C16907 a_15357_1816# a_15200_1758# 0.03547f
C16908 a_17425_6239# sg13cmos5l_dfrbp_1_21.Q 0
C16909 sg13cmos5l_buf_1_30.A a_6315_3911# 0.00119f
C16910 sg13cmos5l_dfrbp_1_22.D cks 0.3532f
C16911 sg13cmos5l_buf_1_5.A a_13116_7326# 0
C16912 sg13cmos5l_buf_1_31.X a_9344_7010# 0.05831f
C16913 a_9448_6924# a_10071_7282# 0
C16914 sg13cmos5l_buf_1_65.X a_6405_8447# 0
C16915 sg13cmos5l_a22oi_1_1.Y sg13cmos5l_dfrbp_1_6.Q_N 0.00774f
C16916 sg13cmos5l_dfrbp_1_6.RESET_B a_2638_6162# 0.01797f
C16917 sg13cmos5l_buf_1_101.X sg13cmos5l_buf_1_104.A 0
C16918 sg13cmos5l_dfrbp_1_23.CLK a_13810_9186# 0
C16919 a_19227_9190# sg13cmos5l_buf_8_2.X 1.04543f
C16920 sg13cmos5l_dfrbp_1_6.RESET_B a_1967_5773# 0.24172f
C16921 sg13cmos5l_buf_1_57.X a_13047_7690# 0
C16922 a_5079_3154# a_5628_3174# 0
C16923 sg13cmos5l_inv_1_1.A a_15429_7653# 0.00692f
C16924 a_15784_9224# a_15531_7796# 0
C16925 sg13cmos5l_buf_1_8.A a_10696_1758# 0.05854f
C16926 sg13cmos5l_dfrbp_1_6.D a_2054_3138# 0.37309f
C16927 sg13cmos5l_inv_1_26.Y pl_sw[8] 0
C16928 a_10318_5412# a_9705_4650# 0
C16929 sg13cmos5l_dlhr_1_21.Q_N sg13cmos5l_dlhr_1_11.GATE 0
C16930 sg13cmos5l_buf_1_78.X a_6219_6284# 0
C16931 a_5079_3154# a_5220_2392# 0.00367f
C16932 a_16102_4663# sg13cmos5l_buf_1_2.X 0
C16933 a_18870_7656# sg13cmos5l_dfrbp_1_21.Q_N 0
C16934 a_14889_7281# a_14714_5776# 0
C16935 a_20672_5498# a_20672_4782# 0.00364f
C16936 a_9111_4666# a_9524_4972# 0.15652f
C16937 sg13cmos5l_dfrbp_1_6.RESET_B a_15016_9224# 0
C16938 a_10473_9186# sg13cmos5l_buf_1_95.X 0
C16939 sg13cmos5l_dfrbp_1_8.RESET_B a_1480_7806# 0
C16940 sg13cmos5l_dfrbp_1_0.CLK a_14900_2352# 0
C16941 sg13cmos5l_buf_1_37.A a_2732_1590# 0.32987f
C16942 a_17638_1639# VPWR 0
C16943 a_12815_1703# a_13072_1846# 0.35645f
C16944 a_16260_6480# a_16779_6284# 0.38902f
C16945 a_15974_6162# a_16617_6553# 0.00806f
C16946 sg13cmos5l_nor2b_1_0.Y sg13cmos5l_a221oi_1_0.B2 0.34809f
C16947 a_6891_4772# a_7034_3148# 0
C16948 sg13cmos5l_buf_1_103.A a_17792_9318# 0.05871f
C16949 sg13cmos5l_buf_1_94.X a_18272_9318# 0
C16950 a_17516_9150# sg13cmos5l_buf_1_107.X 0
C16951 a_6184_9224# ph_sw[2] 0
C16952 sg13cmos5l_a22oi_1_1.Y sg13cmos5l_buf_1_6.A 0.00218f
C16953 sg13cmos5l_o21ai_1_0.B1 a_12022_3134# 0.03943f
C16954 sg13cmos5l_dfrbp_1_1.Q a_15206_2826# 0.00768f
C16955 a_15500_9150# pl_sw[8] 0.00376f
C16956 sg13cmos5l_dlhr_1_6.D a_12815_4261# 0.00149f
C16957 sg13cmos5l_inv_1_28.Y sg13cmos5l_buf_1_90.X 0.20159f
C16958 sg13cmos5l_nor2_1_0.A sg13cmos5l_and3_1_0.C 0.75866f
C16959 a_5962_8404# a_6405_8447# 0.02241f
C16960 a_5702_8874# a_5600_8522# 0
C16961 sg13cmos5l_dfrbp_1_23.CLK sg13cmos5l_dlhr_1_11.Q 0.31538f
C16962 VPWR pl_sw[0] 0.26415f
C16963 sg13cmos5l_dfrbp_1_6.RESET_B a_19528_6924# 0
C16964 sg13cmos5l_inv_1_8.A sg13cmos5l_buf_1_78.X 0.03655f
C16965 sg13cmos5l_inv_1_7.A a_13138_2826# 0
C16966 sg13cmos5l_dlhr_1_14.Q_N VPWR 0.28484f
C16967 a_2364_4686# VPWR 0.00187f
C16968 a_682_5380# cks 0.04609f
C16969 a_12516_6480# sg13cmos5l_and3_1_0.X 0
C16970 sg13cmos5l_nand2_1_0.A a_14858_2388# 0.01305f
C16971 sg13cmos5l_buf_1_96.A sg13cmos5l_dlhr_1_6.D 0
C16972 a_1463_8741# a_708_6928# 0
C16973 sg13cmos5l_dfrbp_1_1.Q a_16552_1664# 0.00143f
C16974 a_416_2474# a_424_1664# 0
C16975 sg13cmos5l_dfrbp_1_16.Q a_9558_6144# 0
C16976 sg13cmos5l_buf_1_38.A nh_sw[1] 0
C16977 sg13cmos5l_buf_1_103.A a_18860_9150# 0
C16978 a_17516_9150# sg13cmos5l_buf_1_101.X 0.00989f
C16979 a_17896_9224# sg13cmos5l_buf_1_111.A 0.00738f
C16980 a_20012_1590# d_out[0] 0.002f
C16981 sg13cmos5l_dfrbp_1_0.RESET_B a_13017_1941# 0.00343f
C16982 a_14708_6924# a_15016_6294# 0.0107f
C16983 sg13cmos5l_dfrbp_1_6.D a_2228_4972# 0.01602f
C16984 sg13cmos5l_inv_1_14.A a_7622_2064# 0
C16985 sg13cmos5l_dfrbp_1_6.RESET_B a_2732_1590# 0
C16986 sg13cmos5l_buf_1_77.X a_7941_7653# 0
C16987 sg13cmos5l_dfrbp_1_6.RESET_B a_4324_7996# 0.05107f
C16988 sg13cmos5l_buf_1_93.X a_15045_8447# 0.00138f
C16989 sg13cmos5l_dfrbp_1_0.RESET_B a_15821_3864# 0
C16990 sg13cmos5l_o21ai_1_0.Y a_12520_3176# 0.09249f
C16991 sg13cmos5l_a22oi_1_2.B2 a_10420_5760# 0.01663f
C16992 sg13cmos5l_buf_1_60.A ph_sw[1] 0
C16993 sg13cmos5l_a221oi_1_0.A2 sg13cmos5l_dfrbp_1_2.D 0.00521f
C16994 sg13cmos5l_inv_1_27.Y a_11567_7751# 0
C16995 a_3407_4261# a_3447_2746# 0.00305f
C16996 sg13cmos5l_buf_1_65.X a_8204_9150# 0.00728f
C16997 sg13cmos5l_dfrbp_1_17.D sg13cmos5l_dlhr_1_8.Q_N 0
C16998 sg13cmos5l_buf_1_93.X a_17132_9150# 0.0388f
C16999 a_16748_9150# sg13cmos5l_buf_1_94.X 0.00848f
C17000 sg13cmos5l_dfrbp_1_9.Q_N sg13cmos5l_buf_1_38.A 0.00616f
C17001 a_18097_7666# cks 0
C17002 sg13cmos5l_buf_1_110.A sg13cmos5l_buf_1_5.A 0
C17003 sg13cmos5l_inv_1_27.Y a_14628_8440# 0.03619f
C17004 a_9291_8447# a_10022_7674# 0
C17005 a_11372_3102# sg13cmos5l_buf_1_9.A 0.32517f
C17006 sg13cmos5l_buf_1_28.X sg13cmos5l_buf_1_8.X 0.02198f
C17007 sg13cmos5l_dlhr_1_11.Q_N a_14089_7282# 0.1374f
C17008 sg13cmos5l_dlhr_1_0.D a_10464_2427# 0
C17009 a_17414_3138# nh_sw[8] 0
C17010 sg13cmos5l_dfrbp_1_8.D sg13cmos5l_buf_8_1.A 0.0014f
C17011 a_12232_8436# sg13cmos5l_buf_1_10.A 0.12094f
C17012 sg13cmos5l_dfrbp_1_6.RESET_B a_16473_7989# 0.00343f
C17013 a_1864_9224# ph_sw[1] 0.29561f
C17014 a_6276_8861# cks 0
C17015 sg13cmos5l_buf_1_3.X sg13cmos5l_dfrbp_1_3.Q_N 0
C17016 a_1967_7285# sg13cmos5l_dlhr_1_1.Q 0
C17017 sg13cmos5l_a221oi_1_0.A2 a_6660_4663# 0
C17018 a_8247_5770# sg13cmos5l_dfrbp_1_11.Q_N 0
C17019 a_20392_3900# d_out[1] 0.12862f
C17020 a_13486_5412# a_13652_3900# 0
C17021 sg13cmos5l_inv_1_28.Y a_11190_7354# 0
C17022 a_18376_2388# a_17931_1748# 0
C17023 sg13cmos5l_buf_1_65.X sg13cmos5l_buf_1_73.X 0.5834f
C17024 sg13cmos5l_buf_1_34.X a_3962_7288# 0.0013f
C17025 sg13cmos5l_dfrbp_1_8.RESET_B a_12358_9199# 0
C17026 a_13648_9406# sg13cmos5l_buf_1_94.X 0
C17027 a_15500_9150# a_15784_9224# 0.13542f
C17028 sg13cmos5l_or2_1_0.A a_5637_2399# 0
C17029 sg13cmos5l_buf_1_45.X a_9111_4666# 0
C17030 sg13cmos5l_dlhr_1_6.D sg13cmos5l_a221oi_1_0.B1 0.00272f
C17031 sg13cmos5l_dfrbp_1_8.D a_18960_5412# 0
C17032 sg13cmos5l_buf_1_4.A a_16268_3102# 0.03215f
C17033 sg13cmos5l_dfrbp_1_9.Q sg13cmos5l_buf_1_44.A 0
C17034 sg13cmos5l_a22oi_1_1.B1 a_11844_4325# 0.00188f
C17035 nh_sw[0] sg13cmos5l_inv_1_19.A 0
C17036 a_19593_6162# a_19209_5769# 0.01108f
C17037 a_19412_6484# a_19028_5412# 0
C17038 a_2638_6477# VPWR 0
C17039 sg13cmos5l_dlhr_1_1.GATE a_3771_6553# 0
C17040 a_17386_1849# a_17700_1639# 0.00659f
C17041 a_17931_1748# a_18928_1846# 0.06778f
C17042 a_12567_7282# ph_sw[5] 0
C17043 cks ckc 0.00309f
C17044 sg13cmos5l_buf_1_24.A sg13cmos5l_dfrbp_1_16.Q 0.0192f
C17045 a_1967_7285# a_1997_6126# 0.00382f
C17046 a_13391_9263# sg13cmos5l_inv_1_3.A 0.00147f
C17047 sg13cmos5l_nand2_1_0.B a_11530_3868# 0.00234f
C17048 a_1862_4338# a_2565_3911# 0.02431f
C17049 a_17414_3138# a_18117_3117# 0.02453f
C17050 sg13cmos5l_dfrbp_1_23.CLK a_14641_7326# 0
C17051 sg13cmos5l_dlhr_1_5.GATE sg13cmos5l_dfrbp_1_29.Q_N 0.00164f
C17052 sg13cmos5l_dfrbp_1_0.RESET_B VPWR 10.2813f
C17053 sg13cmos5l_dfrbp_1_0.RESET_B nl_sw[7] 0
C17054 sg13cmos5l_dlhr_1_0.D nh_sw[3] 0.00355f
C17055 sg13cmos5l_dlygate4sd3_1_0.X a_1121_4166# 0.00768f
C17056 sg13cmos5l_buf_1_73.X a_5962_8404# 0
C17057 sg13cmos5l_a22oi_1_1.Y a_16751_2749# 0.00893f
C17058 a_2409_4650# a_2436_4325# 0
C17059 sg13cmos5l_buf_1_110.A a_16068_6162# 0
C17060 a_13047_7690# a_13178_7684# 0.65127f
C17061 a_5508_2813# a_5739_2399# 0.15089f
C17062 sg13cmos5l_inv_1_11.Y nl_sw[4] 0
C17063 a_11360_9318# sg13cmos5l_buf_1_95.X 0
C17064 sg13cmos5l_or2_1_0.A sg13cmos5l_dfrbp_1_9.Q_N 0.00225f
C17065 sg13cmos5l_buf_1_30.A a_8588_3864# 0.29492f
C17066 sg13cmos5l_dfrbp_1_17.D sg13cmos5l_inv_1_19.A 0.08748f
C17067 sg13cmos5l_buf_1_1.A a_17126_1626# 0
C17068 a_5710_5850# a_4847_4727# 0
C17069 a_5069_5376# a_4753_4727# 0
C17070 sg13cmos5l_inv_1_6.A sg13cmos5l_nand2_1_1.A 0.02555f
C17071 a_16144_8678# pl_sw[9] 0
C17072 a_14449_3215# sg13cmos5l_nor2_1_1.A 0
C17073 sg13cmos5l_a22oi_1_1.Y a_17412_1944# 0
C17074 sg13cmos5l_buf_1_9.A nh_sw[5] 0.18803f
C17075 sg13cmos5l_buf_1_65.X a_7247_8797# 0
C17076 sg13cmos5l_buf_1_101.X pl_sw[10] 0.01224f
C17077 a_9524_4972# sg13cmos5l_dfrbp_1_10.Q 0
C17078 sg13cmos5l_dfrbp_1_6.RESET_B a_6117_6141# 0.05105f
C17079 sg13cmos5l_buf_1_98.A a_13035_6284# 0
C17080 a_12616_5498# a_12800_5498# 0.11523f
C17081 a_11530_3868# nl_sw[6] 0
C17082 sg13cmos5l_buf_1_77.A a_9256_9224# 0.00635f
C17083 sg13cmos5l_inv_1_1.A a_16473_7989# 0.00157f
C17084 sg13cmos5l_dlhr_1_2.D a_7316_3460# 0
C17085 a_6198_3120# a_6560_3270# 0.04055f
C17086 sg13cmos5l_buf_1_40.A a_934_5837# 0
C17087 sg13cmos5l_dfrbp_1_6.D a_3856_3358# 0
C17088 sg13cmos5l_or2_1_0.A a_1956_4338# 0
C17089 sg13cmos5l_inv_1_2.A a_10827_7796# 0
C17090 a_5210_3148# a_5508_2813# 0
C17091 sg13cmos5l_dlhr_1_2.D a_4934_2826# 0
C17092 a_3676_7964# a_4282_8112# 0
C17093 sg13cmos5l_or2_1_0.A a_17414_3138# 0.01176f
C17094 sg13cmos5l_dfrbp_1_10.Q a_5079_3154# 0.02899f
C17095 a_14889_7281# a_15177_5769# 0
C17096 a_9524_4972# sg13cmos5l_inv_1_0.Y 0
C17097 a_10230_4632# a_10587_4692# 0
C17098 a_18345_7674# a_18860_6888# 0.0062f
C17099 a_4566_2818# a_4934_2826# 0
C17100 a_3241_2746# a_3792_2388# 0
C17101 sg13cmos5l_dfrbp_1_6.RESET_B a_7941_7653# 0.06234f
C17102 sg13cmos5l_a221oi_1_0.C1 a_10789_4654# 0.00211f
C17103 sg13cmos5l_buf_1_5.A a_14166_7656# 0.00359f
C17104 sg13cmos5l_buf_1_19.A a_18409_5770# 0.01194f
C17105 sg13cmos5l_dfrbp_1_8.RESET_B a_6961_4261# 0.00134f
C17106 sg13cmos5l_buf_1_77.X a_8488_9224# 0.01598f
C17107 sg13cmos5l_buf_1_37.A nl_sw[2] 0.00423f
C17108 a_6184_9224# sg13cmos5l_buf_1_78.X 0.28822f
C17109 a_16260_6480# a_16548_6175# 0.4806f
C17110 sg13cmos5l_buf_1_31.X sg13cmos5l_inv_1_8.Y 0.00516f
C17111 sg13cmos5l_buf_1_74.X a_9256_9224# 0
C17112 a_7631_4727# a_8022_3120# 0.00266f
C17113 sg13cmos5l_buf_1_33.A nh_sw[0] 0.00698f
C17114 ph_sw[0] sg13cmos5l_inv_1_19.A 0.00127f
C17115 a_6405_8447# a_6507_8447# 0.6663f
C17116 a_5988_8440# a_7504_8678# 0.00159f
C17117 sg13cmos5l_buf_1_94.X ph_sw[6] 0.51662f
C17118 sg13cmos5l_dfrbp_1_0.RESET_B a_15718_2813# 0
C17119 a_15012_7992# VPWR 0.07206f
C17120 sg13cmos5l_dlhr_1_0.GATE sg13cmos5l_buf_1_24.X 0.00986f
C17121 a_5079_3154# a_5673_3138# 0.09085f
C17122 a_4873_3192# a_5210_3148# 0.64635f
C17123 a_3876_4663# VPWR 0.00674f
C17124 sg13cmos5l_or2_1_1.B a_11182_4948# 0
C17125 sg13cmos5l_dfrbp_1_1.Q a_15200_1758# 0
C17126 sg13cmos5l_dfrbp_1_6.D a_416_3986# 0
C17127 sg13cmos5l_dfrbp_1_16.Q a_3588_4968# 0
C17128 sg13cmos5l_buf_1_5.A sg13cmos5l_a22oi_1_1.Y 0
C17129 sg13cmos5l_buf_1_89.A a_15016_6294# 0.05984f
C17130 a_2148_3138# sg13cmos5l_buf_1_35.A 0
C17131 sg13cmos5l_buf_1_93.X a_16724_8436# 0.00956f
C17132 a_14632_9224# ph_sw[6] 0.00804f
C17133 sg13cmos5l_dfrbp_1_6.RESET_B nl_sw[2] 0
C17134 a_15876_4968# sg13cmos5l_buf_8_1.A 0.00132f
C17135 a_16395_4772# a_17041_4727# 0.00667f
C17136 a_17135_4727# a_17337_4965# 0.00675f
C17137 a_8841_5769# VPWR 0.6258f
C17138 sg13cmos5l_buf_1_63.A a_1125_6935# 0.00124f
C17139 sg13cmos5l_dfrbp_1_0.RESET_B a_16551_3987# 0
C17140 sg13cmos5l_o21ai_1_0.Y a_12075_1748# 0
C17141 sg13cmos5l_inv_1_27.Y sg13cmos5l_dlhr_1_11.D 0.00349f
C17142 sg13cmos5l_buf_1_38.A a_3447_2746# 0.00254f
C17143 a_13391_9263# cks 0
C17144 a_17108_7972# a_17545_7728# 0.00314f
C17145 sg13cmos5l_buf_1_10.A a_12721_4261# 0.00865f
C17146 sg13cmos5l_o21ai_1_0.A1 a_13017_4023# 0
C17147 a_18760_2388# a_19244_2352# 0.03472f
C17148 sg13cmos5l_dlhr_1_5.Q_N VPWR 0.25798f
C17149 sg13cmos5l_buf_1_45.X sg13cmos5l_dfrbp_1_10.Q 0.021f
C17150 a_15208_6200# sg13cmos5l_buf_1_116.A 0.03727f
C17151 sg13cmos5l_dfrbp_1_1.Q a_11556_1944# 0
C17152 a_6346_4873# a_6086_4650# 0.87117f
C17153 a_6345_8483# cks 0
C17154 sg13cmos5l_a22oi_1_1.B1 a_13803_3260# 0
C17155 sg13cmos5l_buf_1_28.X a_10094_2780# 0.00119f
C17156 sg13cmos5l_dfrbp_1_0.RESET_B a_11973_1605# 0.05201f
C17157 sg13cmos5l_buf_1_8.X sg13cmos5l_a22oi_1_2.B1 0.00108f
C17158 sg13cmos5l_dfrbp_1_6.RESET_B a_1846_7850# 0.0048f
C17159 a_10224_9508# ph_sw[5] 0
C17160 sg13cmos5l_buf_1_30.A sg13cmos5l_dlhr_1_5.D 0.01824f
C17161 a_3407_4261# a_2859_3260# 0
C17162 a_7153_8797# ph_sw[3] 0
C17163 sg13cmos5l_buf_1_34.X a_4380_7326# 0
C17164 sg13cmos5l_nand2_1_0.A a_13652_1924# 0
C17165 sg13cmos5l_or2_1_0.A a_6479_2749# 0
C17166 a_14166_7656# sg13cmos5l_dfrbp_1_23.Q 0.00122f
C17167 a_2474_6162# VPWR 0
C17168 sg13cmos5l_dlhr_1_1.GATE a_4322_6162# 0
C17169 a_18671_1703# a_18873_1941# 0.00675f
C17170 a_17931_1748# a_18577_1703# 0.00667f
C17171 a_19508_1924# a_20012_1590# 0.03266f
C17172 a_1862_4338# a_2314_3361# 0
C17173 a_19340_8400# sg13cmos5l_buf_1_104.X 0
C17174 a_2224_5654# VPWR 0.16198f
C17175 sg13cmos5l_dlhr_1_5.GATE a_9033_6162# 0
C17176 sg13cmos5l_buf_1_25.A a_7226_1636# 0
C17177 sg13cmos5l_dlhr_1_1.GATE a_1873_5773# 0.00598f
C17178 sg13cmos5l_inv_1_29.Y a_12230_6162# 0.01166f
C17179 a_2804_6924# a_2727_6380# 0
C17180 sg13cmos5l_buf_1_1.A nh_sw[7] 0.01702f
C17181 sg13cmos5l_inv_1_20.Y a_4244_6924# 0
C17182 sg13cmos5l_buf_1_104.A ph_sw[10] 0.20134f
C17183 sg13cmos5l_dfrbp_1_23.CLK a_15124_7312# 0
C17184 sg13cmos5l_dlhr_1_12.D a_17108_7972# 0.26752f
C17185 a_18219_3260# a_18959_3215# 0.3087f
C17186 a_18117_3117# a_19216_3358# 0
C17187 sg13cmos5l_or2_1_0.A a_5492_3460# 0.00172f
C17188 sg13cmos5l_dfrbp_1_8.RESET_B a_7863_7282# 0
C17189 sg13cmos5l_dfrbp_1_6.D a_19344_6484# 0
C17190 sg13cmos5l_buf_1_30.A a_7249_3130# 0
C17191 a_12814_4692# sg13cmos5l_dfrbp_1_0.RESET_B 0
C17192 sg13cmos5l_buf_1_73.X a_6507_8447# 0.00187f
C17193 sg13cmos5l_or2_1_0.A a_3447_2746# 0
C17194 sg13cmos5l_dfrbp_1_8.D sg13cmos5l_dlhr_1_19.Q_N 0
C17195 sg13cmos5l_dlhr_1_5.GATE sg13cmos5l_buf_1_57.X 0.00207f
C17196 sg13cmos5l_inv_1_26.Y sg13cmos5l_dlhr_1_15.Q 0.00638f
C17197 sg13cmos5l_dfrbp_1_9.Q a_1760_3986# 0
C17198 a_13178_7684# a_13574_8112# 0.00949f
C17199 sg13cmos5l_buf_1_34.X a_5220_2392# 0.03407f
C17200 a_12022_3134# nl_sw[6] 0.07106f
C17201 a_3588_4968# a_4005_4629# 0.48921f
C17202 a_3302_4650# a_4107_4772# 0.11742f
C17203 a_1402_3864# a_2122_3868# 0.00255f
C17204 a_18568_7010# VPWR 0.13905f
C17205 a_8488_9224# sg13cmos5l_dfrbp_1_6.RESET_B 0
C17206 sg13cmos5l_inv_1_2.A sg13cmos5l_dfrbp_1_18.Q 0.47541f
C17207 sg13cmos5l_buf_1_4.A a_16395_4772# 0.03345f
C17208 sg13cmos5l_inv_1_17.A a_4282_8112# 0
C17209 sg13cmos5l_dfrbp_1_22.D pl_sw[9] 0.00412f
C17210 a_6789_4629# sg13cmos5l_or2_1_0.A 0
C17211 a_8214_1608# nl_sw[4] 0.01501f
C17212 sg13cmos5l_dlhr_1_11.GATE VPWR 1.08835f
C17213 a_11846_9186# a_12549_9165# 0.02453f
C17214 sg13cmos5l_dfrbp_1_6.D a_14640_6924# 0
C17215 sg13cmos5l_dfrbp_1_6.RESET_B a_7161_6477# 0.00343f
C17216 sg13cmos5l_dfrbp_1_1.D nh_sw[5] 0.12446f
C17217 a_8570_6172# a_8660_5412# 0.00173f
C17218 sg13cmos5l_or2_1_0.A a_1158_3142# 0.00453f
C17219 sg13cmos5l_dfrbp_1_6.RESET_B a_8209_7326# 0
C17220 a_2409_4650# a_1862_4338# 0
C17221 sg13cmos5l_buf_1_57.X a_14536_7806# 0.0702f
C17222 sg13cmos5l_inv_1_6.A sg13cmos5l_dfrbp_1_0.D 0
C17223 sg13cmos5l_buf_1_5.X sg13cmos5l_nor2b_1_1.Y 0.2372f
C17224 sg13cmos5l_buf_1_33.A a_1760_1758# 0
C17225 sg13cmos5l_dfrbp_1_11.Q a_8841_5769# 0.00546f
C17226 a_2248_1664# VPWR 0.27253f
C17227 a_4076_7624# VPWR 0.10844f
C17228 sg13cmos5l_or2_1_0.A a_19216_3358# 0
C17229 sg13cmos5l_dfrbp_1_16.Q_N sg13cmos5l_dlhr_1_1.GATE 0.00764f
C17230 sg13cmos5l_inv_1_18.A a_9558_6144# 0.00489f
C17231 sg13cmos5l_dlhr_1_15.D a_12704_4782# 0
C17232 sg13cmos5l_buf_1_77.A a_8390_6924# 0
C17233 a_6959_6239# a_7378_6162# 0.00176f
C17234 sg13cmos5l_dfrbp_1_6.RESET_B a_9040_7894# 0.18274f
C17235 sg13cmos5l_nor2_1_0.A sg13cmos5l_o21ai_1_0.Y 0.01071f
C17236 sg13cmos5l_buf_1_5.A a_13596_7710# 0
C17237 a_3407_8797# a_3962_7288# 0
C17238 sg13cmos5l_buf_1_44.X a_5049_4965# 0.0021f
C17239 a_2667_8447# a_3488_7010# 0.0012f
C17240 sg13cmos5l_dlygate4sd2_1_0.A cks 0.003f
C17241 a_15357_1816# sg13cmos5l_buf_1_1.A 0.00993f
C17242 a_15784_1664# a_16268_1590# 0.03472f
C17243 a_17519_6239# a_17425_6239# 0.32273f
C17244 sg13cmos5l_inv_1_2.A a_14854_8861# 0
C17245 a_7631_4727# sg13cmos5l_dlhr_1_2.Q 0
C17246 a_8457_7281# a_8390_6924# 0
C17247 a_6507_8447# a_7247_8797# 0.3087f
C17248 sg13cmos5l_buf_1_103.A a_16089_8559# 0
C17249 sg13cmos5l_or2_1_0.A a_1006_4167# 0.04041f
C17250 sg13cmos5l_dfrbp_1_0.RESET_B a_17170_2826# 0
C17251 a_17108_7972# VPWR 0.35701f
C17252 sg13cmos5l_a22oi_1_2.B2 sg13cmos5l_dfrbp_1_10.Q 0.0266f
C17253 a_6568_9224# ph_sw[4] 0.2887f
C17254 a_5673_3138# a_5606_3576# 0
C17255 a_5492_3460# a_5424_3460# 0
C17256 sg13cmos5l_dfrbp_1_6.RESET_B sg13cmos5l_buf_1_25.A 0.48128f
C17257 sg13cmos5l_buf_1_86.A a_19528_6924# 0
C17258 sg13cmos5l_dfrbp_1_1.Q a_17931_1748# 0.00845f
C17259 a_1815_4666# sg13cmos5l_or2_1_0.A 0
C17260 sg13cmos5l_dlhr_1_16.Q a_19227_4654# 0.01719f
C17261 a_3447_2746# a_3578_2752# 0.65127f
C17262 sg13cmos5l_dfrbp_1_0.RESET_B a_17769_2017# 0
C17263 a_2879_6432# a_3302_4650# 0
C17264 sg13cmos5l_buf_1_65.X a_1956_8874# 0
C17265 sg13cmos5l_a22oi_1_2.B2 sg13cmos5l_inv_1_0.Y 0
C17266 a_17972_4948# sg13cmos5l_buf_8_1.A 0.14134f
C17267 sg13cmos5l_dfrbp_1_6.RESET_B a_14377_5770# 0.00188f
C17268 a_12815_4261# a_11979_2399# 0
C17269 a_13072_4142# a_12976_2630# 0
C17270 a_12075_3911# a_12719_2749# 0
C17271 sg13cmos5l_dfrbp_1_8.RESET_B a_3609_4023# 0.00403f
C17272 a_5700_6480# a_5820_5773# 0
C17273 a_5312_6294# sg13cmos5l_dfrbp_1_29.Q_N 0
C17274 sg13cmos5l_dfrbp_1_18.Q a_9937_8797# 0.00865f
C17275 sg13cmos5l_buf_1_18.A d_out[1] 0
C17276 a_516_5850# cks 0
C17277 sg13cmos5l_inv_1_2.A sg13cmos5l_inv_1_3.A 0.36794f
C17278 sg13cmos5l_dlhr_1_11.GATE a_12698_7288# 0.00776f
C17279 sg13cmos5l_dlhr_1_15.D a_18345_7674# 0
C17280 a_620_2352# a_424_1664# 0.00183f
C17281 sg13cmos5l_buf_1_30.A a_8041_5770# 0
C17282 a_1580_2352# sg13cmos5l_buf_1_32.A 0.12817f
C17283 sg13cmos5l_buf_1_10.A a_13258_3361# 0.0013f
C17284 sg13cmos5l_inv_1_29.Y a_11771_5412# 0.04041f
C17285 sg13cmos5l_nand2_1_0.A sg13cmos5l_buf_1_8.A 3.17645f
C17286 sg13cmos5l_inv_1_8.A sg13cmos5l_inv_1_8.Y 0.5154f
C17287 sg13cmos5l_dfrbp_1_1.Q a_13652_1924# 0.13332f
C17288 sg13cmos5l_inv_1_14.A sg13cmos5l_buf_1_28.A 0.00617f
C17289 a_10412_6126# sg13cmos5l_dlhr_1_20.Q_N 0
C17290 a_11844_1639# nh_sw[6] 0
C17291 a_6086_4650# a_6180_4650# 0.00718f
C17292 sg13cmos5l_inv_1_20.Y cks 0.02117f
C17293 a_7449_8559# cks 0.00109f
C17294 sg13cmos5l_dfrbp_1_0.RESET_B a_14056_1664# 0
C17295 sg13cmos5l_inv_1_8.A a_5069_5376# 0.00702f
C17296 sg13cmos5l_a22oi_1_1.B1 sg13cmos5l_buf_1_5.X 0
C17297 sg13cmos5l_dfrbp_1_9.Q a_5028_2826# 0
C17298 sg13cmos5l_dfrbp_1_6.RESET_B a_1480_7806# 0
C17299 sg13cmos5l_buf_1_87.A a_18580_7660# 0
C17300 sg13cmos5l_buf_1_10.A sg13cmos5l_dfrbp_1_0.CLK 0.18177f
C17301 a_9823_2780# sg13cmos5l_dfrbp_1_1.D 0.00238f
C17302 sg13cmos5l_dfrbp_1_6.RESET_B a_5408_3986# 0
C17303 sg13cmos5l_nand2_1_0.A sg13cmos5l_buf_1_1.A 0
C17304 sg13cmos5l_dlhr_1_11.Q sg13cmos5l_dfrbp_1_6.D 0.00346f
C17305 sg13cmos5l_dfrbp_1_8.RESET_B a_5710_5535# 0.00343f
C17306 sg13cmos5l_or2_1_1.B sg13cmos5l_a221oi_1_0.C1 0.0433f
C17307 a_11270_4338# sg13cmos5l_buf_1_8.X 0
C17308 a_14726_7674# a_14295_7282# 0
C17309 a_14536_7806# a_14089_7282# 0.00731f
C17310 a_5700_6480# VPWR 0.07235f
C17311 a_2565_3911# a_2757_3117# 0
C17312 a_19227_9190# a_19904_7806# 0.00153f
C17313 pl_sw[10] ph_sw[10] 0.08871f
C17314 a_15782_7362# cks 0.03055f
C17315 sg13cmos5l_dlhr_1_1.GATE a_4176_6924# 0
C17316 sg13cmos5l_dlhr_1_1.D VPWR 0.55104f
C17317 sg13cmos5l_buf_1_26.X a_9260_2352# 0
C17318 sg13cmos5l_dfrbp_1_16.Q a_3575_6553# 0.05548f
C17319 sg13cmos5l_dfrbp_1_8.RESET_B a_10725_7653# 0
C17320 sg13cmos5l_buf_1_41.A a_3831_7282# 0
C17321 a_1967_7285# a_2224_5654# 0
C17322 a_2224_7166# a_1967_5773# 0
C17323 sg13cmos5l_dlhr_1_0.Q a_7508_1948# 0.00107f
C17324 a_1997_6126# a_2380_6162# 0.35645f
C17325 sg13cmos5l_a22oi_1_0.Y a_10783_3876# 0.17797f
C17326 a_15887_8797# a_16068_6928# 0
C17327 a_16144_8678# a_16485_6935# 0
C17328 sg13cmos5l_buf_1_31.X sg13cmos5l_buf_1_32.A 0.16563f
C17329 sg13cmos5l_dlhr_1_15.D a_16572_4261# 0
C17330 a_12132_9504# sg13cmos5l_buf_1_93.X 0
C17331 a_7524_7992# VPWR 0.07288f
C17332 sg13cmos5l_inv_1_1.A a_14377_5770# 0
C17333 sg13cmos5l_buf_1_30.A sg13cmos5l_dfrbp_1_6.D 0.64476f
C17334 a_5800_9224# sg13cmos5l_dfrbp_1_8.RESET_B 0.01222f
C17335 sg13cmos5l_dfrbp_1_8.D a_19028_5412# 0.00354f
C17336 sg13cmos5l_dlygate4sd2_1_0.X a_1158_3142# 0.0063f
C17337 sg13cmos5l_dfrbp_1_9.Q a_3313_4261# 0.0183f
C17338 a_1402_3864# a_1290_3206# 0.00378f
C17339 a_13641_7674# a_13876_7660# 0.00566f
C17340 a_13460_7996# a_13596_7710# 0.00404f
C17341 sg13cmos5l_buf_1_0.A d_out[1] 0
C17342 sg13cmos5l_buf_1_34.X sg13cmos5l_dfrbp_1_10.Q 0.35018f
C17343 sg13cmos5l_inv_1_7.A a_12616_5498# 0.00157f
C17344 a_7316_2388# sg13cmos5l_dlhr_1_0.D 0.13719f
C17345 a_8841_5769# sg13cmos5l_dlhr_1_17.Q_N 0.00294f
C17346 a_3588_4968# a_4847_4727# 0.01741f
C17347 sg13cmos5l_buf_1_87.A frame 0
C17348 sg13cmos5l_a22oi_1_0.Y a_11556_3904# 0
C17349 sg13cmos5l_buf_1_44.X a_3676_7964# 0
C17350 sg13cmos5l_nand2_1_0.B a_10789_4654# 0.00767f
C17351 a_8468_4948# sg13cmos5l_or2_1_0.A 0
C17352 sg13cmos5l_nor2b_1_0.Y a_12721_4261# 0.01697f
C17353 a_12651_9308# a_13391_9263# 0.3087f
C17354 a_12549_9165# a_13648_9406# 0
C17355 a_1815_4666# a_1672_3176# 0
C17356 a_1125_6935# a_1227_6935# 0.6663f
C17357 a_16940_3102# a_17224_3270# 0.01225f
C17358 sg13cmos5l_dfrbp_1_6.D a_18164_6924# 0.00568f
C17359 sg13cmos5l_buf_1_56.A a_9366_5842# 0
C17360 sg13cmos5l_nand2_1_0.A a_10433_4248# 0
C17361 sg13cmos5l_or2_1_0.A a_2859_3260# 0.00411f
C17362 sg13cmos5l_nor2b_1_0.Y a_13418_4696# 0.00454f
C17363 sg13cmos5l_dfrbp_1_23.CLK pl_sw[6] 0
C17364 sg13cmos5l_buf_1_3.A frame 0.22364f
C17365 sg13cmos5l_buf_1_77.A sg13cmos5l_buf_1_29.A 0.39085f
C17366 sg13cmos5l_o21ai_1_0.B1 a_14476_2388# 0
C17367 sg13cmos5l_dlhr_1_2.D a_8204_2352# 0
C17368 sg13cmos5l_dfrbp_1_8.D sg13cmos5l_a22oi_1_1.B2 0.00697f
C17369 sg13cmos5l_buf_1_34.X a_5673_3138# 0
C17370 sg13cmos5l_buf_1_3.A a_19796_3436# 0.05132f
C17371 sg13cmos5l_inv_1_7.A nh_sw[5] 0
C17372 sg13cmos5l_inv_1_2.A cks 3.94272f
C17373 sg13cmos5l_nor2b_1_0.Y a_11364_4338# 0
C17374 sg13cmos5l_buf_1_107.X sg13cmos5l_buf_8_2.X 0.00142f
C17375 sg13cmos5l_dlhr_1_6.D a_7378_6162# 0
C17376 sg13cmos5l_dfrbp_1_6.RESET_B a_20488_5498# 0
C17377 a_17425_6239# sg13cmos5l_dfrbp_1_21.Q_N 0.00104f
C17378 a_9448_6924# sg13cmos5l_buf_1_56.A 0
C17379 sg13cmos5l_dlhr_1_5.Q a_8784_6484# 0
C17380 sg13cmos5l_buf_1_31.X a_10028_6126# 0.00121f
C17381 sg13cmos5l_inv_1_2.A a_16306_8874# 0
C17382 sg13cmos5l_dlhr_1_5.Q a_9865_7282# 0
C17383 sg13cmos5l_dfrbp_1_1.Q a_19628_2352# 0.00422f
C17384 sg13cmos5l_inv_1_20.Y a_3609_8559# 0.00131f
C17385 a_7247_8797# sg13cmos5l_dfrbp_1_18.Q_N 0.04107f
C17386 a_7153_8797# a_7666_8874# 0
C17387 sg13cmos5l_buf_1_7.A sg13cmos5l_dfrbp_1_0.Q 0.3674f
C17388 sg13cmos5l_buf_1_3.A sg13cmos5l_buf_1_87.A 0
C17389 sg13cmos5l_buf_1_101.X sg13cmos5l_buf_8_2.X 0
C17390 sg13cmos5l_buf_1_110.A a_15531_7796# 0.02734f
C17391 sg13cmos5l_buf_1_6.A a_14900_2352# 0.0431f
C17392 a_1815_4666# a_1946_4660# 0.65127f
C17393 sg13cmos5l_buf_1_97.A sg13cmos5l_dlhr_1_11.GATE 0.07967f
C17394 cks sg13cmos5l_buf_1_68.X 0
C17395 sg13cmos5l_dfrbp_1_10.Q a_3599_3215# 0.00256f
C17396 a_1088_7806# VPWR 0.06655f
C17397 sg13cmos5l_buf_1_103.A pl_sw[8] 0.10556f
C17398 a_16264_9224# pl_sw[9] 0
C17399 sg13cmos5l_dfrbp_1_20.Q a_9865_7282# 0.14792f
C17400 sg13cmos5l_buf_1_44.A a_6188_1590# 0
C17401 sg13cmos5l_dfrbp_1_1.Q a_20296_1664# 0.01718f
C17402 sg13cmos5l_buf_1_45.A sg13cmos5l_buf_1_28.A 0
C17403 a_1472_4782# sg13cmos5l_or2_1_0.A 0
C17404 sg13cmos5l_dfrbp_1_12.Q_N a_9524_4972# 0
C17405 sg13cmos5l_dfrbp_1_0.RESET_B a_18873_1941# 0.00343f
C17406 a_3860_2388# a_4041_2745# 0.40925f
C17407 sg13cmos5l_buf_1_65.X a_3664_8678# 0
C17408 a_3575_6553# a_4005_4629# 0
C17409 sg13cmos5l_dfrbp_1_6.RESET_B a_14996_5412# 0.16366f
C17410 a_6117_6141# a_5951_5383# 0.04171f
C17411 sg13cmos5l_buf_1_94.X sg13cmos5l_buf_1_107.X 0
C17412 sg13cmos5l_dfrbp_1_1.Q sg13cmos5l_buf_1_8.A 0.15704f
C17413 sg13cmos5l_dfrbp_1_16.Q a_8796_5814# 0
C17414 sg13cmos5l_buf_1_24.A a_6843_5459# 0
C17415 a_7941_7653# a_8439_6178# 0
C17416 a_7524_7992# a_8233_6216# 0
C17417 a_4436_3436# a_4873_3192# 0.00314f
C17418 a_11464_8436# a_11473_7751# 0
C17419 sg13cmos5l_buf_1_63.A a_708_6928# 0
C17420 a_2859_3260# a_3578_2752# 0
C17421 a_11973_3911# a_12719_2749# 0
C17422 sg13cmos5l_dfrbp_1_1.Q sg13cmos5l_buf_1_1.A 0.26494f
C17423 sg13cmos5l_nor2b_1_0.Y nl_sw[5] 0
C17424 a_16271_7751# a_16779_6284# 0
C17425 a_6891_4772# a_7833_4965# 0
C17426 a_6372_4968# a_6598_4663# 0.00523f
C17427 a_6789_4629# a_6660_4663# 0.01562f
C17428 sg13cmos5l_inv_1_26.Y sg13cmos5l_buf_1_111.A 1.94351f
C17429 sg13cmos5l_buf_1_94.X sg13cmos5l_buf_1_101.X 0.00984f
C17430 a_9937_8797# cks 0
C17431 sg13cmos5l_dfrbp_1_16.Q sg13cmos5l_buf_1_31.X 0.0243f
C17432 sg13cmos5l_inv_1_8.A a_5799_5499# 0.04673f
C17433 sg13cmos5l_buf_1_2.A a_16102_4663# 0
C17434 sg13cmos5l_buf_1_44.X a_5414_6162# 0.00115f
C17435 sg13cmos5l_a22oi_1_1.B1 a_13017_4023# 0.00109f
C17436 a_12549_9165# ph_sw[6] 0.00925f
C17437 sg13cmos5l_o21ai_1_0.A2 a_10618_3142# 0
C17438 sg13cmos5l_dfrbp_1_6.RESET_B a_6961_4261# 0
C17439 sg13cmos5l_inv_1_7.A sg13cmos5l_buf_1_98.A 0
C17440 sg13cmos5l_dlhr_1_11.GATE a_13047_7690# 0.23852f
C17441 sg13cmos5l_inv_1_17.A sg13cmos5l_buf_1_62.X 0.21783f
C17442 sg13cmos5l_buf_1_65.X sg13cmos5l_buf_1_73.A 0.02545f
C17443 a_15784_9224# sg13cmos5l_buf_1_103.A 0.29477f
C17444 sg13cmos5l_inv_1_1.A a_17516_9150# 0
C17445 sg13cmos5l_buf_1_63.A a_1664_7806# 0
C17446 a_7796_6460# VPWR 0.35835f
C17447 a_2054_3138# a_2340_3456# 0.50066f
C17448 a_2314_3361# a_2757_3117# 0.02241f
C17449 sg13cmos5l_buf_1_95.X sg13cmos5l_buf_1_5.A 0
C17450 a_7520_7010# VPWR 0.06773f
C17451 sg13cmos5l_buf_1_28.X sg13cmos5l_buf_1_9.A 0.02691f
C17452 a_18480_5028# VPWR 0.22238f
C17453 a_12075_1748# nh_sw[6] 0.00103f
C17454 sg13cmos5l_dfrbp_1_9.Q a_4873_3192# 0.03046f
C17455 sg13cmos5l_dfrbp_1_8.RESET_B a_12404_7972# 0
C17456 sg13cmos5l_buf_1_111.A sg13cmos5l_dlhr_1_10.Q 0.0059f
C17457 sg13cmos5l_dfrbp_1_0.RESET_B a_12120_3456# 0.0014f
C17458 sg13cmos5l_buf_1_24.A a_5674_6385# 0
C17459 a_2380_6162# a_2638_6477# 0.00464f
C17460 a_2879_6432# a_2748_6126# 0.49014f
C17461 sg13cmos5l_inv_1_29.Y a_11072_5347# 0.00152f
C17462 a_1967_7285# sg13cmos5l_dlhr_1_1.D 0
C17463 a_1864_9224# sg13cmos5l_buf_1_61.X 0.00911f
C17464 sg13cmos5l_dfrbp_1_16.Q a_2804_5412# 0
C17465 a_4324_7996# pl_sw[2] 0
C17466 sg13cmos5l_dfrbp_1_22.D a_16485_6935# 0.00811f
C17467 a_1878_6337# a_1227_5423# 0
C17468 sg13cmos5l_inv_1_17.A sg13cmos5l_buf_1_44.X 0.00101f
C17469 a_15500_9150# sg13cmos5l_buf_1_110.A 0.00498f
C17470 a_14228_9484# sg13cmos5l_buf_1_93.X 0
C17471 sg13cmos5l_buf_1_90.X a_13297_9263# 0.00783f
C17472 a_8783_7751# VPWR 0.25657f
C17473 sg13cmos5l_inv_1_1.A a_14996_5412# 0.00829f
C17474 sg13cmos5l_buf_1_45.X sg13cmos5l_dfrbp_1_12.Q_N 0.04255f
C17475 sg13cmos5l_dfrbp_1_8.RESET_B a_14152_8522# 0.00231f
C17476 sg13cmos5l_buf_1_4.A sg13cmos5l_buf_1_5.X 0
C17477 sg13cmos5l_dlhr_1_14.Q_N a_14536_7806# 0.02372f
C17478 sg13cmos5l_a22oi_1_1.B2 a_15876_4968# 0
C17479 a_4005_4629# a_4753_4727# 0.01058f
C17480 sg13cmos5l_dfrbp_1_10.Q a_10220_3102# 0.02109f
C17481 sg13cmos5l_dfrbp_1_8.RESET_B sg13cmos5l_buf_1_94.X 0
C17482 a_13648_9406# sg13cmos5l_inv_1_27.Y 0.00115f
C17483 sg13cmos5l_nor2b_1_0.Y a_13258_3361# 0
C17484 sg13cmos5l_inv_1_17.A a_2804_6924# 0
C17485 a_1125_6935# sg13cmos5l_dfrbp_1_16.Q 0
C17486 sg13cmos5l_buf_1_4.X a_17508_3138# 0
C17487 sg13cmos5l_dlhr_1_10.Q a_20392_6924# 0
C17488 a_20492_8400# cks 0
C17489 sg13cmos5l_inv_1_9.Y a_1580_2352# 0.03376f
C17490 sg13cmos5l_inv_1_8.Y sg13cmos5l_buf_1_32.X 0
C17491 sg13cmos5l_buf_1_57.X sg13cmos5l_dlhr_1_15.D 0
C17492 sg13cmos5l_buf_1_76.X a_5988_8440# 0
C17493 sg13cmos5l_dlygate4sd2_1_0.A a_2314_3361# 0
C17494 a_14583_5770# VPWR 0.17797f
C17495 sg13cmos5l_inv_1_18.A ph_sw[5] 0
C17496 sg13cmos5l_nor2b_1_0.Y sg13cmos5l_dfrbp_1_0.CLK 0.17362f
C17497 sg13cmos5l_inv_1_0.A a_12075_3911# 0.00402f
C17498 sg13cmos5l_dfrbp_1_16.Q_N a_2386_7362# 0
C17499 sg13cmos5l_buf_1_34.X a_4566_2818# 0.00516f
C17500 sg13cmos5l_dfrbp_1_8.RESET_B a_14632_9224# 0.01264f
C17501 sg13cmos5l_buf_1_24.A sg13cmos5l_buf_1_39.A 0
C17502 sg13cmos5l_dfrbp_1_21.Q a_14714_5776# 0.01636f
C17503 sg13cmos5l_o21ai_1_0.A1 sg13cmos5l_nand2_1_0.A 0
C17504 sg13cmos5l_buf_1_19.A sg13cmos5l_a22oi_1_1.A1 0.02617f
C17505 sg13cmos5l_buf_1_31.X a_4005_4629# 0
C17506 a_5637_2399# nl_sw[3] 0
C17507 sg13cmos5l_or2_1_0.A a_902_3142# 0.00386f
C17508 a_18568_7010# a_18356_6460# 0
C17509 a_9879_9202# a_10022_7674# 0
C17510 sg13cmos5l_dlhr_1_11.Q a_13035_6284# 0
C17511 sg13cmos5l_dfrbp_1_6.D a_15124_7312# 0
C17512 a_13556_2388# sg13cmos5l_dfrbp_1_0.Q 0
C17513 sg13cmos5l_buf_1_45.X sg13cmos5l_inv_1_2.A 0.02027f
C17514 sg13cmos5l_buf_1_110.A a_15300_7687# 0
C17515 sg13cmos5l_dfrbp_1_6.RESET_B a_7863_7282# 0.0239f
C17516 a_3212_1590# a_3688_1664# 0.05057f
C17517 sg13cmos5l_buf_1_33.A a_4456_1664# 0.00221f
C17518 sg13cmos5l_dfrbp_1_8.RESET_B a_7497_3138# 0
C17519 a_1609_4704# a_2160_4972# 0
C17520 nh_sw[1] nl_sw[3] 0
C17521 VPWR nh_sw[10] 0.17146f
C17522 sg13cmos5l_inv_1_3.A a_14889_7281# 0
C17523 sg13cmos5l_dlhr_1_8.Q_N VPWR 0.28527f
C17524 a_3676_7964# sg13cmos5l_dlhr_1_9.Q 0.37349f
C17525 nl_sw[10] d_out[0] 0.04676f
C17526 sg13cmos5l_dfrbp_1_10.Q sg13cmos5l_dfrbp_1_10.Q_N 0.0329f
C17527 a_20008_7712# a_20392_7712# 0.00492f
C17528 sg13cmos5l_dfrbp_1_20.Q a_10900_7312# 0
C17529 a_6213_3911# VPWR 0.24742f
C17530 sg13cmos5l_buf_8_1.A a_16204_4338# 0
C17531 a_1948_7964# a_1227_6935# 0.01088f
C17532 sg13cmos5l_dfrbp_1_16.Q sg13cmos5l_a221oi_1_0.C1 0.23023f
C17533 a_7796_6460# a_8233_6216# 0.00314f
C17534 sg13cmos5l_buf_1_41.A a_3313_4261# 0.00169f
C17535 sg13cmos5l_buf_1_65.X sg13cmos5l_dfrbp_1_15.D 0.00121f
C17536 a_18860_9150# cks 0.01587f
C17537 sg13cmos5l_dfrbp_1_6.RESET_B a_18409_5770# 0.00834f
C17538 sg13cmos5l_buf_1_31.X sg13cmos5l_inv_1_9.Y 0.03135f
C17539 sg13cmos5l_buf_1_78.A sg13cmos5l_buf_1_78.X 0.13682f
C17540 sg13cmos5l_buf_1_65.X sg13cmos5l_buf_1_40.A 0
C17541 sg13cmos5l_o21ai_1_0.B1 a_13072_1846# 0
C17542 sg13cmos5l_buf_1_10.A a_10665_7281# 0
C17543 a_12998_3138# a_12719_2749# 0
C17544 a_7994_7288# a_8390_6924# 0.00949f
C17545 sg13cmos5l_buf_1_7.A a_14543_3215# 0
C17546 sg13cmos5l_buf_1_103.A a_17161_8794# 0.00364f
C17547 a_17516_9150# a_17498_8800# 0
C17548 a_5820_5773# sg13cmos5l_inv_1_19.A 0
C17549 a_18568_7010# ph_sw[9] 0.02874f
C17550 sg13cmos5l_or2_1_1.B a_14714_5776# 0
C17551 a_12216_5728# a_13034_5412# 0
C17552 sg13cmos5l_buf_1_95.X a_13460_7996# 0
C17553 sg13cmos5l_or2_1_1.B sg13cmos5l_nand2_1_0.B 0.00315f
C17554 sg13cmos5l_buf_1_96.A a_11473_7751# 0.01685f
C17555 sg13cmos5l_dfrbp_1_0.CLK a_13138_2826# 0
C17556 a_3856_3358# a_4041_2745# 0
C17557 a_3505_3215# a_3447_2746# 0
C17558 sg13cmos5l_dlhr_1_15.D a_16779_6284# 0.02767f
C17559 sg13cmos5l_nor2_1_0.A nh_sw[6] 0
C17560 a_7631_4727# a_7537_4727# 0.32273f
C17561 sg13cmos5l_buf_1_73.X a_7336_9224# 0.00909f
C17562 a_12716_8400# cks 0.00983f
C17563 a_422_5850# cks 0.03696f
C17564 sg13cmos5l_a22oi_1_2.B2 sg13cmos5l_dfrbp_1_12.Q_N 0
C17565 sg13cmos5l_inv_1_27.Y ph_sw[6] 0.00217f
C17566 sg13cmos5l_dfrbp_1_15.D a_5962_8404# 0
C17567 sg13cmos5l_buf_1_63.X a_1125_6935# 0
C17568 sg13cmos5l_dfrbp_1_6.RESET_B sg13cmos5l_a22oi_1_0.Y 0.00357f
C17569 sg13cmos5l_dfrbp_1_8.RESET_B a_3407_4261# 0.23934f
C17570 sg13cmos5l_inv_1_2.A a_12651_9308# 0.02162f
C17571 sg13cmos5l_buf_1_76.X a_5416_9224# 0.32349f
C17572 a_2340_3456# a_3856_3358# 0.00294f
C17573 a_2757_3117# a_3599_3215# 0.00437f
C17574 sg13cmos5l_dlhr_1_5.Q VPWR 0.43793f
C17575 VPWR sg13cmos5l_inv_1_19.A 1.05649f
C17576 a_14440_1664# nh_sw[6] 0.01025f
C17577 a_12420_9199# VPWR 0.00926f
C17578 sg13cmos5l_buf_1_4.A a_15909_2399# 0.03538f
C17579 sg13cmos5l_buf_1_9.A sg13cmos5l_a22oi_1_2.B1 0.12672f
C17580 sg13cmos5l_inv_1_11.Y a_9544_2474# 0.03816f
C17581 sg13cmos5l_buf_1_28.X sg13cmos5l_dfrbp_1_1.D 0.02098f
C17582 sg13cmos5l_buf_1_24.A a_6057_6553# 0
C17583 a_2727_6380# a_3530_6320# 0.15089f
C17584 a_3575_6553# a_3669_6320# 0.87117f
C17585 a_2879_6432# a_2638_6162# 0.01058f
C17586 a_2380_6162# a_2474_6162# 0.0019f
C17587 sg13cmos5l_dfrbp_1_9.Q a_3860_2388# 0.00178f
C17588 sg13cmos5l_dlhr_1_9.D a_5820_5773# 0.00431f
C17589 sg13cmos5l_dfrbp_1_22.D a_17327_7285# 0.00419f
C17590 sg13cmos5l_buf_1_3.A a_19593_6162# 0.06586f
C17591 a_2879_6432# a_1967_5773# 0.00206f
C17592 a_1484_6126# sg13cmos5l_dlhr_1_1.D 0
C17593 sg13cmos5l_dfrbp_1_20.Q VPWR 0.7035f
C17594 a_19142_5412# VPWR 0.00418f
C17595 sg13cmos5l_nor2b_1_1.Y nh_sw[7] 0.0014f
C17596 sg13cmos5l_nand2_1_1.B a_10783_3876# 0
C17597 sg13cmos5l_dfrbp_1_8.RESET_B a_15793_8797# 0
C17598 sg13cmos5l_buf_1_73.A a_6507_8447# 0.00341f
C17599 a_7820_9150# a_7504_8678# 0
C17600 a_7336_9224# a_7247_8797# 0
C17601 a_4847_4727# a_4753_4727# 0.32273f
C17602 a_13234_1626# nl_sw[6] 0
C17603 sg13cmos5l_inv_1_8.A sg13cmos5l_dfrbp_1_16.Q 0.05111f
C17604 sg13cmos5l_dfrbp_1_8.RESET_B sg13cmos5l_a22oi_1_1.A1 0.00164f
C17605 sg13cmos5l_buf_1_26.A a_7226_1636# 0
C17606 sg13cmos5l_buf_1_19.A a_18117_3117# 0.03469f
C17607 sg13cmos5l_dfrbp_1_11.Q a_6213_3911# 0.34703f
C17608 sg13cmos5l_dfrbp_1_9.Q a_2054_3138# 0
C17609 sg13cmos5l_dlhr_1_1.Q_N a_2757_3117# 0
C17610 sg13cmos5l_buf_1_104.A sg13cmos5l_buf_1_86.A 0.00261f
C17611 a_13076_5376# a_12815_4261# 0
C17612 sg13cmos5l_o21ai_1_0.A1 sg13cmos5l_dfrbp_1_1.Q 0.00145f
C17613 sg13cmos5l_buf_1_18.A sg13cmos5l_dlhr_1_16.Q 0
C17614 sg13cmos5l_buf_1_65.X a_4460_9150# 0.00858f
C17615 sg13cmos5l_or2_1_0.A sg13cmos5l_buf_1_41.X 0
C17616 sg13cmos5l_nand2_1_2.B a_620_2352# 0
C17617 sg13cmos5l_dfrbp_1_6.RESET_B a_5710_5535# 0.00176f
C17618 sg13cmos5l_a22oi_1_1.B2 a_13324_4696# 0
C17619 sg13cmos5l_dfrbp_1_21.Q a_15177_5769# 0.02297f
C17620 a_11270_1626# nl_sw[6] 0.05173f
C17621 sg13cmos5l_nor2_1_2.A a_2148_3904# 0
C17622 sg13cmos5l_buf_1_87.A sg13cmos5l_dlhr_1_12.Q_N 0.02379f
C17623 sg13cmos5l_dlhr_1_9.D VPWR 1.23902f
C17624 a_1463_8741# cks 0
C17625 sg13cmos5l_inv_1_29.A sg13cmos5l_dlhr_1_18.Q_N 0
C17626 a_708_6928# a_1227_6935# 0.38871f
C17627 a_1125_6935# a_996_7349# 0.01562f
C17628 a_20392_7712# a_20488_6294# 0
C17629 a_12980_6924# sg13cmos5l_dlhr_1_6.D 0
C17630 sg13cmos5l_buf_1_31.X a_4847_4727# 0
C17631 sg13cmos5l_inv_1_17.A sg13cmos5l_dlhr_1_9.Q 0.41374f
C17632 a_11182_4948# a_11394_4948# 0.22838f
C17633 sg13cmos5l_inv_1_2.A sg13cmos5l_dfrbp_1_20.Q_N 0.22272f
C17634 sg13cmos5l_nand2_1_1.A a_18865_3215# 0.01009f
C17635 sg13cmos5l_dfrbp_1_6.D sg13cmos5l_buf_1_18.A 0
C17636 sg13cmos5l_dlhr_1_10.Q sg13cmos5l_dfrbp_1_21.Q_N 0
C17637 a_2248_9224# a_2732_9150# 0.03472f
C17638 a_8486_8874# a_9060_8861# 0.36169f
C17639 sg13cmos5l_dfrbp_1_6.RESET_B a_10725_7653# 0.07384f
C17640 a_8772_8440# a_9189_8447# 0.49014f
C17641 sg13cmos5l_inv_1_0.A a_11973_3911# 0.01723f
C17642 sg13cmos5l_buf_1_33.A VPWR 0.41414f
C17643 sg13cmos5l_buf_1_19.A sg13cmos5l_or2_1_0.A 1.19127f
C17644 a_2934_4632# a_3562_4873# 0.00322f
C17645 a_4172_1590# nl_sw[2] 0.01414f
C17646 sg13cmos5l_buf_1_77.A a_9558_6144# 0
C17647 a_7892_3900# VPWR 0.35865f
C17648 sg13cmos5l_buf_1_77.A ph_sw[4] 0.01101f
C17649 pl_sw[4] ph_sw[4] 1.75092f
C17650 a_14436_8874# pl_sw[6] 0
C17651 sg13cmos5l_inv_1_18.A sg13cmos5l_buf_1_31.X 1.36958f
C17652 ph_sw[2] cks 0
C17653 sg13cmos5l_buf_1_10.A a_12216_5728# 0.0227f
C17654 sg13cmos5l_dfrbp_1_0.CLK a_17988_3151# 0.00362f
C17655 a_2831_7630# a_2804_6924# 0
C17656 a_1664_7806# a_1227_6935# 0
C17657 sg13cmos5l_dlhr_1_6.D a_9033_6162# 0.01265f
C17658 a_2621_7636# a_2786_7666# 0.00722f
C17659 sg13cmos5l_nand2_1_2.B cks 0.00152f
C17660 sg13cmos5l_dfrbp_1_6.RESET_B a_19734_5842# 0.03009f
C17661 a_8982_7354# a_8852_6484# 0.00519f
C17662 sg13cmos5l_dlhr_1_5.Q a_8233_6216# 0.00743f
C17663 sg13cmos5l_buf_1_24.A a_5510_4338# 0.0037f
C17664 a_13284_3456# a_14254_2444# 0
C17665 sg13cmos5l_buf_1_10.A a_11560_7010# 0.03609f
C17666 sg13cmos5l_buf_1_30.A a_6086_4650# 0
C17667 sg13cmos5l_dlhr_1_5.Q sg13cmos5l_dfrbp_1_11.Q 0.00182f
C17668 a_904_7806# VPWR 0.12127f
C17669 sg13cmos5l_o21ai_1_0.B1 sg13cmos5l_a22oi_1_1.Y 0
C17670 sg13cmos5l_buf_8_1.A a_18368_4782# 0.01134f
C17671 sg13cmos5l_or2_1_0.A sg13cmos5l_nor2_1_2.A 0.31906f
C17672 a_1484_9150# sg13cmos5l_buf_1_62.X 0.00109f
C17673 a_11370_5760# sg13cmos5l_a221oi_1_0.B2 0
C17674 sg13cmos5l_dfrbp_1_8.RESET_B a_6405_8447# 0.07252f
C17675 sg13cmos5l_or2_1_1.B a_15177_5769# 0
C17676 sg13cmos5l_buf_1_74.X ph_sw[4] 0.05005f
C17677 sg13cmos5l_buf_1_57.X sg13cmos5l_dlhr_1_6.D 4.62592f
C17678 sg13cmos5l_dfrbp_1_6.RESET_B sg13cmos5l_buf_1_26.A 0.19268f
C17679 sg13cmos5l_buf_1_95.X ph_sw[5] 0.27612f
C17680 sg13cmos5l_inv_1_8.A a_4005_4629# 0.36902f
C17681 sg13cmos5l_dlhr_1_15.D a_16548_6175# 0
C17682 sg13cmos5l_dfrbp_1_21.Q sg13cmos5l_a221oi_1_1.C1 0
C17683 a_2732_9150# a_2148_8440# 0
C17684 sg13cmos5l_inv_1_20.Y a_2122_8404# 0.00102f
C17685 a_15016_9224# ph_sw[7] 0
C17686 sg13cmos5l_dfrbp_1_8.RESET_B sg13cmos5l_buf_1_38.A 0
C17687 a_12520_3176# a_11877_2399# 0.00707f
C17688 sg13cmos5l_dfrbp_1_6.RESET_B sg13cmos5l_buf_1_46.A 0.51392f
C17689 sg13cmos5l_dfrbp_1_6.D a_8208_6924# 0
C17690 sg13cmos5l_dfrbp_1_6.D sg13cmos5l_buf_1_0.A 0
C17691 a_19508_1924# nl_sw[10] 0.01437f
C17692 a_3599_3215# a_3801_3453# 0.00675f
C17693 a_2859_3260# a_3505_3215# 0.00667f
C17694 a_2757_3117# sg13cmos5l_dfrbp_1_10.Q_N 0.01301f
C17695 sg13cmos5l_buf_1_32.X sg13cmos5l_buf_1_32.A 0.10701f
C17696 a_1580_2352# sg13cmos5l_buf_1_40.X 0.33061f
C17697 sg13cmos5l_buf_1_10.A sg13cmos5l_buf_1_6.A 0.01613f
C17698 sg13cmos5l_inv_1_8.A sg13cmos5l_inv_1_9.Y 0.0238f
C17699 sg13cmos5l_nand2_1_0.A sg13cmos5l_nor2b_1_1.Y 0.09074f
C17700 sg13cmos5l_nand2_1_1.B sg13cmos5l_dfrbp_1_0.Q 0.01986f
C17701 sg13cmos5l_dfrbp_1_8.RESET_B a_2148_3904# 0.49032f
C17702 sg13cmos5l_inv_1_2.A a_8746_8404# 0
C17703 sg13cmos5l_buf_1_4.A a_17008_2630# 0
C17704 a_1967_7285# sg13cmos5l_inv_1_19.A 0.00123f
C17705 sg13cmos5l_and3_1_0.C sg13cmos5l_buf_8_1.A 0
C17706 sg13cmos5l_dlhr_1_9.D sg13cmos5l_dfrbp_1_11.Q 0.05899f
C17707 sg13cmos5l_a22oi_1_2.B1 sg13cmos5l_dfrbp_1_1.D 1.13195f
C17708 a_2380_6162# sg13cmos5l_dlhr_1_1.D 0
C17709 sg13cmos5l_buf_1_60.X ph_sw[3] 0
C17710 sg13cmos5l_dfrbp_1_6.RESET_B a_13681_6239# 0
C17711 sg13cmos5l_buf_1_40.A a_1158_3142# 0.00944f
C17712 sg13cmos5l_buf_1_29.A sg13cmos5l_nor2b_1_0.Y 0
C17713 a_9823_2364# VPWR 0.37667f
C17714 a_15012_7992# a_16271_7751# 0.01741f
C17715 sg13cmos5l_or2_1_1.B sg13cmos5l_a221oi_1_1.C1 0.41505f
C17716 sg13cmos5l_buf_1_73.A sg13cmos5l_dfrbp_1_18.Q_N 0.05315f
C17717 sg13cmos5l_nand2_1_1.B a_12896_3270# 0
C17718 a_11270_4338# sg13cmos5l_buf_1_9.A 0
C17719 a_19240_7712# cks 0.00404f
C17720 a_1862_8874# a_2667_8447# 0.11742f
C17721 a_2148_8440# a_2565_8447# 0.49014f
C17722 a_8204_9150# sg13cmos5l_dfrbp_1_8.RESET_B 0.00235f
C17723 sg13cmos5l_buf_1_86.A pl_sw[10] 0.19146f
C17724 sg13cmos5l_dlhr_1_7.Q_N VPWR 0.35357f
C17725 sg13cmos5l_dfrbp_1_11.Q a_7892_3900# 0.01947f
C17726 a_10031_8797# sg13cmos5l_inv_1_7.A 0
C17727 a_10868_8436# a_11272_8522# 0.0303f
C17728 sg13cmos5l_dfrbp_1_9.Q a_3856_3358# 0.00227f
C17729 sg13cmos5l_buf_1_90.X a_10827_7796# 0
C17730 sg13cmos5l_inv_1_6.A a_18363_4270# 0.01326f
C17731 sg13cmos5l_and3_1_0.X a_12815_4261# 0
C17732 a_18356_6460# a_18480_5028# 0
C17733 a_20492_8400# pl_sw[9] 0
C17734 sg13cmos5l_dfrbp_1_8.RESET_B sg13cmos5l_or2_1_0.A 0.26008f
C17735 sg13cmos5l_buf_1_40.A a_1006_4167# 0
C17736 sg13cmos5l_buf_1_31.X sg13cmos5l_buf_1_40.X 0.04266f
C17737 sg13cmos5l_nand2_1_0.A a_11656_3176# 0
C17738 sg13cmos5l_buf_1_110.A a_14714_5776# 0
C17739 a_18615_5770# VPWR 0.18339f
C17740 a_12549_9165# a_13100_8400# 0
C17741 a_12132_9504# a_13484_8400# 0
C17742 sg13cmos5l_dfrbp_1_18.Q a_10292_9508# 0.00281f
C17743 sg13cmos5l_buf_1_73.X sg13cmos5l_dfrbp_1_8.RESET_B 0.32585f
C17744 sg13cmos5l_nor2_1_2.A a_1672_3176# 0
C17745 sg13cmos5l_inv_1_18.A sg13cmos5l_a221oi_1_0.C1 0
C17746 sg13cmos5l_dfrbp_1_21.Q a_18746_5776# 0
C17747 a_8841_5769# sg13cmos5l_buf_1_45.A 0.28229f
C17748 a_13072_1846# nl_sw[6] 0
C17749 sg13cmos5l_inv_1_0.A a_12998_3138# 0
C17750 a_708_6928# sg13cmos5l_dfrbp_1_16.Q 0
C17751 sg13cmos5l_dfrbp_1_16.Q_N a_2748_6126# 0
C17752 sg13cmos5l_buf_1_40.A a_1815_4666# 0.00171f
C17753 a_11771_5412# a_11556_3904# 0
C17754 sg13cmos5l_dlhr_1_5.GATE a_5700_6480# 0.12367f
C17755 a_7497_3138# a_7226_1636# 0
C17756 a_17792_9318# pl_sw[9] 0.00429f
C17757 sg13cmos5l_dfrbp_1_23.CLK a_13161_7281# 0.05078f
C17758 sg13cmos5l_dfrbp_1_6.RESET_B a_12404_7972# 0
C17759 a_9189_8447# a_10031_8797# 0.0032f
C17760 a_8486_8874# a_9129_8483# 0.00806f
C17761 a_19130_6172# a_19412_6484# 0.68988f
C17762 a_18860_6888# a_18568_7010# 0.03269f
C17763 sg13cmos5l_nand2_1_0.A sg13cmos5l_a22oi_1_1.B1 0.03836f
C17764 sg13cmos5l_dfrbp_1_18.Q a_9344_7010# 0
C17765 a_16089_8559# cks 0.00109f
C17766 sg13cmos5l_inv_1_2.A a_16940_3102# 0
C17767 sg13cmos5l_buf_1_41.A a_3860_2388# 0.00131f
C17768 a_3562_4873# sg13cmos5l_dfrbp_1_9.Q 0.00136f
C17769 sg13cmos5l_nor2_1_2.A sg13cmos5l_dlygate4sd2_1_0.X 0.00271f
C17770 a_8296_3986# VPWR 0.13968f
C17771 sg13cmos5l_dfrbp_1_6.RESET_B a_14152_8522# 0
C17772 sg13cmos5l_buf_1_78.X cks 0.02369f
C17773 sg13cmos5l_dlhr_1_5.GATE a_7524_7992# 0.00478f
C17774 sg13cmos5l_buf_8_1.A a_18146_4338# 0
C17775 sg13cmos5l_dfrbp_1_22.D a_17961_8793# 0.00186f
C17776 a_11372_3102# nl_sw[5] 0
C17777 sg13cmos5l_dfrbp_1_8.RESET_B a_12549_9165# 0.05141f
C17778 a_12106_9409# a_12651_9308# 0.00999f
C17779 a_3008_1758# nh_sw[1] 0.00403f
C17780 sg13cmos5l_inv_1_28.Y sg13cmos5l_buf_1_95.X 0
C17781 a_18860_9150# pl_sw[9] 0
C17782 a_10827_7796# a_11190_7354# 0
C17783 a_1948_7964# sg13cmos5l_dfrbp_1_15.Q_N 0
C17784 sg13cmos5l_buf_1_24.A a_6084_4325# 0.0036f
C17785 sg13cmos5l_nand2_1_1.A a_17224_3270# 0.00204f
C17786 a_14800_3358# sg13cmos5l_nor2_1_1.A 0.00142f
C17787 sg13cmos5l_buf_1_10.A a_13686_7354# 0
C17788 sg13cmos5l_dlhr_1_15.D sg13cmos5l_dfrbp_1_0.RESET_B 0
C17789 sg13cmos5l_buf_1_30.A a_7631_4727# 0.00469f
C17790 sg13cmos5l_dfrbp_1_6.RESET_B sg13cmos5l_buf_1_94.X 0
C17791 sg13cmos5l_buf_1_34.X a_3826_8874# 0
C17792 sg13cmos5l_dfrbp_1_8.RESET_B a_7247_8797# 0.23464f
C17793 sg13cmos5l_buf_1_41.A a_2054_3138# 0.00509f
C17794 sg13cmos5l_a221oi_1_0.B1 sg13cmos5l_and3_1_0.X 0
C17795 sg13cmos5l_dfrbp_1_6.RESET_B a_4177_7326# 0
C17796 sg13cmos5l_buf_1_18.A nh_sw[9] 0
C17797 a_5452_5850# a_5710_5535# 0.00464f
C17798 a_5820_5773# a_6647_5459# 0.50066f
C17799 sg13cmos5l_a221oi_1_0.B1 sg13cmos5l_inv_1_0.Y 0.20417f
C17800 sg13cmos5l_inv_1_8.A a_4847_4727# 0.01973f
C17801 sg13cmos5l_dfrbp_1_8.RESET_B a_3578_2752# 0.00107f
C17802 sg13cmos5l_buf_1_65.X a_620_7638# 0.00138f
C17803 sg13cmos5l_dfrbp_1_0.CLK a_17674_3361# 0
C17804 sg13cmos5l_inv_1_20.Y a_3407_8797# 0.01347f
C17805 sg13cmos5l_a221oi_1_0.C1 a_11394_4948# 0.00579f
C17806 a_15782_7362# a_16485_6935# 0.02431f
C17807 sg13cmos5l_buf_1_65.X pl_sw[3] 0.01794f
C17808 sg13cmos5l_dfrbp_1_6.D sg13cmos5l_dlhr_1_6.Q_N 0.00252f
C17809 sg13cmos5l_dfrbp_1_1.Q sg13cmos5l_nor2b_1_1.Y 0.84397f
C17810 sg13cmos5l_buf_1_7.A a_11556_1944# 0
C17811 a_11877_2399# a_12075_1748# 0
C17812 sg13cmos5l_inv_1_3.A pl_sw[8] 0
C17813 sg13cmos5l_inv_1_14.A a_5700_6480# 0.03796f
C17814 sg13cmos5l_dlhr_1_9.D sg13cmos5l_dlhr_1_17.Q_N 0.00198f
C17815 sg13cmos5l_dfrbp_1_6.RESET_B sg13cmos5l_nand2_1_1.B 0
C17816 sg13cmos5l_dfrbp_1_6.D a_10484_6924# 0.00401f
C17817 sg13cmos5l_dfrbp_1_0.Q_N nl_sw[10] 0
C17818 sg13cmos5l_buf_1_65.X a_9879_9202# 0
C17819 a_3801_3453# sg13cmos5l_dfrbp_1_10.Q_N 0
C17820 a_17135_4727# sg13cmos5l_a22oi_1_1.A1 0.00727f
C17821 sg13cmos5l_or2_1_0.A a_10783_3876# 0.00829f
C17822 sg13cmos5l_buf_1_4.A nh_sw[7] 0
C17823 sg13cmos5l_dfrbp_1_6.RESET_B a_7497_3138# 0.4452f
C17824 sg13cmos5l_buf_1_63.X a_708_6928# 0
C17825 sg13cmos5l_buf_1_41.A a_2228_4972# 0
C17826 sg13cmos5l_dfrbp_1_6.RESET_B sg13cmos5l_dlhr_1_3.Q_N 0.00705f
C17827 sg13cmos5l_inv_1_2.A a_10288_8678# 0
C17828 sg13cmos5l_buf_1_103.A sg13cmos5l_buf_1_111.A 0
C17829 a_1290_3206# nh_sw[0] 0.00103f
C17830 sg13cmos5l_buf_1_89.A a_15208_6200# 0.33725f
C17831 sg13cmos5l_dfrbp_1_23.Q a_15016_6294# 0.02051f
C17832 nl_sw[5] nh_sw[5] 0.09106f
C17833 a_6647_5459# VPWR 0.93687f
C17834 a_12216_5728# sg13cmos5l_nor2b_1_0.Y 0
C17835 sg13cmos5l_or2_1_0.A a_11556_3904# 0.00328f
C17836 a_5962_8404# pl_sw[3] 0.02451f
C17837 a_1484_6126# sg13cmos5l_inv_1_19.A 0.04336f
C17838 sg13cmos5l_buf_1_10.A sg13cmos5l_buf_1_5.A 0.11461f
C17839 sg13cmos5l_inv_1_7.A sg13cmos5l_dlhr_1_11.Q 0.00515f
C17840 a_1967_5773# a_1873_5773# 0.32273f
C17841 a_2804_5412# a_3308_5376# 0.03266f
C17842 sg13cmos5l_buf_1_57.X a_15412_5800# 0
C17843 a_2224_5654# a_2386_5850# 0.0019f
C17844 a_12719_2749# VPWR 0.25996f
C17845 a_10464_2427# a_10888_1664# 0
C17846 a_14714_5776# sg13cmos5l_a22oi_1_1.Y 0
C17847 a_18999_6178# a_19227_4654# 0
C17848 sg13cmos5l_dfrbp_1_8.RESET_B sg13cmos5l_dlygate4sd2_1_0.X 0
C17849 a_16271_7751# a_17108_7972# 0.1333f
C17850 a_15429_7653# a_16177_7751# 0.01058f
C17851 sg13cmos5l_dfrbp_1_6.D a_2169_5535# 0.00185f
C17852 sg13cmos5l_buf_1_110.A sg13cmos5l_buf_1_103.A 0.06145f
C17853 sg13cmos5l_inv_1_1.A sg13cmos5l_buf_1_94.X 0.00211f
C17854 sg13cmos5l_dfrbp_1_0.CLK a_11372_3102# 0
C17855 sg13cmos5l_nand2_1_1.B a_14543_3215# 0.03821f
C17856 a_10308_7992# VPWR 0.07547f
C17857 a_1463_8511# sg13cmos5l_buf_1_58.A 0.00111f
C17858 a_2148_8440# a_3313_8797# 0.4858f
C17859 sg13cmos5l_buf_1_31.X sg13cmos5l_buf_1_39.A 0
C17860 sg13cmos5l_inv_1_2.A a_16485_6935# 0.38996f
C17861 sg13cmos5l_dfrbp_1_1.Q a_11656_3176# 0.00212f
C17862 sg13cmos5l_buf_1_0.A nh_sw[9] 0.02911f
C17863 sg13cmos5l_dfrbp_1_11.Q a_8296_3986# 0.00524f
C17864 sg13cmos5l_dfrbp_1_0.RESET_B sg13cmos5l_o21ai_1_0.A2 0.7644f
C17865 a_11848_8436# sg13cmos5l_inv_1_7.A 0.1587f
C17866 sg13cmos5l_dfrbp_1_8.RESET_B a_1946_4660# 0.01492f
C17867 sg13cmos5l_inv_1_5.A d_out[1] 0.44756f
C17868 sg13cmos5l_dfrbp_1_0.Q nh_sw[8] 0.02238f
C17869 sg13cmos5l_inv_1_17.A a_3530_6320# 0.00222f
C17870 sg13cmos5l_dfrbp_1_6.RESET_B a_3407_4261# 0.00454f
C17871 a_15500_9150# sg13cmos5l_buf_1_95.X 0.32189f
C17872 sg13cmos5l_inv_1_3.A a_15784_9224# 0
C17873 sg13cmos5l_dfrbp_1_6.RESET_B a_12230_6162# 0.10968f
C17874 a_19209_5769# VPWR 0.62114f
C17875 sg13cmos5l_buf_1_110.A a_15177_5769# 0.00252f
C17876 a_13648_9406# a_13768_8436# 0
C17877 sg13cmos5l_inv_1_27.Y a_13100_8400# 0
C17878 sg13cmos5l_a22oi_1_1.B1 sg13cmos5l_dfrbp_1_1.Q 0
C17879 sg13cmos5l_dfrbp_1_10.Q sg13cmos5l_inv_1_11.Y 0.01195f
C17880 sg13cmos5l_nand2_1_1.B a_9832_1664# 0.0303f
C17881 sg13cmos5l_buf_1_40.A a_1472_4782# 0.00403f
C17882 sg13cmos5l_dfrbp_1_16.Q_N a_2638_6162# 0
C17883 a_10028_6126# sg13cmos5l_a221oi_1_1.C1 0
C17884 sg13cmos5l_buf_8_1.A sg13cmos5l_buf_1_18.X 0
C17885 sg13cmos5l_dlhr_1_1.GATE a_3625_7282# 0.01383f
C17886 sg13cmos5l_dfrbp_1_16.Q_N a_1967_5773# 0
C17887 sg13cmos5l_dlhr_1_5.GATE a_7796_6460# 0.05853f
C17888 a_8392_3270# VPWR 0.14461f
C17889 sg13cmos5l_nor2b_1_0.Y sg13cmos5l_buf_1_6.A 0
C17890 sg13cmos5l_dlhr_1_1.GATE sg13cmos5l_dfrbp_1_6.D 0.02618f
C17891 sg13cmos5l_dlhr_1_5.GATE a_7520_7010# 0
C17892 a_10031_8797# a_10868_8436# 0.1333f
C17893 a_10288_8678# a_9937_8797# 0.01017f
C17894 sg13cmos5l_dfrbp_1_23.CLK a_14426_7288# 0.04496f
C17895 sg13cmos5l_inv_1_29.A sg13cmos5l_nor2_1_0.A 0.00481f
C17896 sg13cmos5l_inv_1_9.Y sg13cmos5l_buf_1_32.X 0
C17897 a_8972_3864# sg13cmos5l_buf_1_28.A 0
C17898 a_18117_3117# sg13cmos5l_dfrbp_1_0.Q 0.01463f
C17899 a_682_6892# a_1227_6935# 0.00999f
C17900 sg13cmos5l_nor2_1_1.A a_15300_2826# 0
C17901 a_20672_5498# d_out[2] 0.00468f
C17902 a_708_6928# a_996_7349# 0.4806f
C17903 cks pl_sw[8] 0.00156f
C17904 sg13cmos5l_inv_1_29.A a_12841_7728# 0.25901f
C17905 a_6117_6141# sg13cmos5l_dlhr_1_0.GATE 0.00208f
C17906 sg13cmos5l_buf_1_90.X sg13cmos5l_inv_1_3.A 0.01879f
C17907 sg13cmos5l_dfrbp_1_8.RESET_B sg13cmos5l_inv_1_27.Y 0.54596f
C17908 pl_sw[0] a_1000_9224# 0
C17909 sg13cmos5l_o21ai_1_0.A1 sg13cmos5l_a22oi_1_0.B1 0
C17910 sg13cmos5l_buf_1_87.A a_17713_8838# 0
C17911 sg13cmos5l_dfrbp_1_6.RESET_B sg13cmos5l_a22oi_1_1.A1 0.04862f
C17912 a_10596_7687# a_10665_7281# 0
C17913 sg13cmos5l_dfrbp_1_0.CLK nh_sw[5] 0
C17914 sg13cmos5l_inv_1_17.A a_3676_7964# 0.02453f
C17915 a_9111_4666# a_9457_4642# 0.00722f
C17916 sg13cmos5l_buf_1_10.A sg13cmos5l_dfrbp_1_23.Q 0
C17917 sg13cmos5l_nand2_1_1.A a_18959_3215# 0.00891f
C17918 sg13cmos5l_nor2_1_0.A a_11877_2399# 0
C17919 sg13cmos5l_dfrbp_1_6.D a_18164_7996# 0
C17920 sg13cmos5l_dfrbp_1_23.CLK a_13641_7674# 0.00383f
C17921 sg13cmos5l_inv_1_8.A sg13cmos5l_buf_1_40.X 0
C17922 sg13cmos5l_inv_1_0.A a_11488_4676# 0
C17923 a_15821_3864# sg13cmos5l_nor2_1_1.A 0
C17924 a_8972_9150# sg13cmos5l_inv_1_18.A 0.00245f
C17925 sg13cmos5l_buf_1_41.A a_3856_3358# 0
C17926 sg13cmos5l_dfrbp_1_8.RESET_B a_8580_8874# 0
C17927 a_3212_1590# sg13cmos5l_buf_1_39.A 0.0023f
C17928 sg13cmos5l_dfrbp_1_11.Q a_6647_5459# 0.30121f
C17929 sg13cmos5l_buf_1_33.A sg13cmos5l_buf_1_25.X 0.01106f
C17930 sg13cmos5l_inv_1_27.Y a_15414_7354# 0
C17931 a_4349_7636# a_4559_7630# 0.27787f
C17932 a_20008_7712# sg13cmos5l_buf_8_0.X 0.03287f
C17933 sg13cmos5l_inv_1_8.A sg13cmos5l_dfrbp_1_14.Q_N 0.01015f
C17934 sg13cmos5l_or2_1_0.A sg13cmos5l_dfrbp_1_0.Q 0
C17935 sg13cmos5l_dfrbp_1_16.Q sg13cmos5l_a221oi_1_1.C1 0.45199f
C17936 a_416_7806# VPWR 0.06824f
C17937 a_15782_7362# a_17327_7285# 0
C17938 a_16068_6928# a_16356_7349# 0.4806f
C17939 a_16042_6892# a_16587_6935# 0.00999f
C17940 sg13cmos5l_inv_1_6.A sg13cmos5l_dfrbp_1_0.RESET_B 0
C17941 sg13cmos5l_dfrbp_1_23.Q_N sg13cmos5l_dfrbp_1_21.Q 0.00869f
C17942 sg13cmos5l_buf_1_4.A a_16486_6175# 0
C17943 sg13cmos5l_buf_1_31.X sg13cmos5l_buf_1_43.A 0.05242f
C17944 a_7336_9224# sg13cmos5l_buf_1_73.A 0.00225f
C17945 sg13cmos5l_buf_1_77.X a_8204_9150# 0.0093f
C17946 sg13cmos5l_a22oi_1_1.A1 a_14543_3215# 0.00833f
C17947 sg13cmos5l_buf_1_7.A a_13652_1924# 0.03268f
C17948 sg13cmos5l_dfrbp_1_8.RESET_B a_6660_4663# 0.00877f
C17949 a_1672_3176# a_1576_1758# 0
C17950 sg13cmos5l_buf_1_6.A a_13138_2826# 0
C17951 a_12976_2630# a_12075_1748# 0.00346f
C17952 a_12719_2749# a_11973_1605# 0
C17953 sg13cmos5l_inv_1_18.A a_9620_7972# 0.00948f
C17954 a_17132_9150# sg13cmos5l_dlhr_1_12.D 0.00127f
C17955 sg13cmos5l_dfrbp_1_6.D a_10598_6924# 0
C17956 a_10282_7897# a_10022_7674# 0.87117f
C17957 sg13cmos5l_buf_1_19.A a_19412_6484# 0
C17958 a_15784_9224# cks 0
C17959 sg13cmos5l_or2_1_0.A a_12896_3270# 0
C17960 a_1948_7964# a_2554_8112# 0
C17961 sg13cmos5l_buf_1_73.X sg13cmos5l_buf_1_77.X 0.00868f
C17962 sg13cmos5l_buf_1_41.A a_3562_4873# 0.00112f
C17963 a_6184_9224# a_6568_9224# 0.00492f
C17964 sg13cmos5l_inv_1_2.A a_11464_8436# 0
C17965 sg13cmos5l_dlhr_1_9.D a_3945_5041# 0
C17966 a_5674_6385# a_6219_6284# 0.00999f
C17967 a_17135_4727# sg13cmos5l_or2_1_0.A 0
C17968 sg13cmos5l_inv_1_1.A a_15793_8797# 0.00405f
C17969 sg13cmos5l_nand2_1_1.B a_15206_2826# 0.04631f
C17970 sg13cmos5l_dlygate4sd2_1_0.X a_1576_1758# 0
C17971 sg13cmos5l_buf_1_8.X a_11364_1626# 0
C17972 sg13cmos5l_buf_1_34.X ph_sw[2] 0.00261f
C17973 a_2380_6162# sg13cmos5l_inv_1_19.A 0.005f
C17974 a_19136_9318# VPWR 0.07012f
C17975 sg13cmos5l_dfrbp_1_8.RESET_B a_1956_8874# 0
C17976 a_6507_8447# pl_sw[3] 0
C17977 sg13cmos5l_buf_1_105.A a_18580_7660# 0
C17978 a_20008_8436# a_20008_7712# 0.00833f
C17979 sg13cmos5l_inv_1_1.A sg13cmos5l_a22oi_1_1.A1 0.00127f
C17980 a_4425_7281# a_4950_5699# 0.00148f
C17981 sg13cmos5l_dfrbp_1_6.RESET_B a_9705_4650# 0.45087f
C17982 sg13cmos5l_nor2_1_1.A VPWR 0.91153f
C17983 sg13cmos5l_dfrbp_1_11.Q a_8392_3270# 0
C17984 a_15177_5769# sg13cmos5l_a22oi_1_1.Y 0
C17985 sg13cmos5l_a22oi_1_1.B2 a_14814_3876# 0.07445f
C17986 sg13cmos5l_nor2_1_1.A nl_sw[7] 0
C17987 sg13cmos5l_dfrbp_1_6.D a_5546_5850# 0
C17988 sg13cmos5l_dfrbp_1_3.Q_N sg13cmos5l_buf_1_19.X 0.00167f
C17989 a_17108_7972# sg13cmos5l_dlhr_1_15.D 0.16532f
C17990 a_15300_7687# a_15238_7687# 0
C17991 a_9189_8447# pl_sw[5] 0
C17992 a_11824_7894# VPWR 0.15178f
C17993 sg13cmos5l_dfrbp_1_8.Q_N sg13cmos5l_dfrbp_1_0.RESET_B 0
C17994 a_19240_7712# pl_sw[9] 0
C17995 sg13cmos5l_inv_1_18.A sg13cmos5l_nand2_1_0.B 0
C17996 sg13cmos5l_dfrbp_1_23.Q_N sg13cmos5l_or2_1_1.B 0
C17997 a_5104_4870# a_5408_3986# 0
C17998 a_3407_8797# a_3826_8874# 0.00176f
C17999 sg13cmos5l_inv_1_8.A a_5674_6385# 0.02811f
C18000 sg13cmos5l_inv_1_2.A a_17327_7285# 0
C18001 sg13cmos5l_inv_1_8.A a_3308_5376# 0.05893f
C18002 sg13cmos5l_buf_1_9.A sg13cmos5l_buf_1_30.X 0
C18003 sg13cmos5l_dfrbp_1_16.Q a_7657_7282# 0
C18004 sg13cmos5l_buf_8_0.X a_19227_4654# 1.03973f
C18005 a_996_5837# a_1227_5423# 0.15089f
C18006 sg13cmos5l_buf_1_40.A a_902_3142# 0
C18007 a_15045_8447# VPWR 0.24584f
C18008 sg13cmos5l_dfrbp_1_11.Q a_8050_4650# 0
C18009 sg13cmos5l_buf_1_90.X cks 0.02182f
C18010 sg13cmos5l_dfrbp_1_6.RESET_B sg13cmos5l_buf_1_38.A 0.21817f
C18011 sg13cmos5l_dfrbp_1_6.RESET_B a_14032_6382# 0.18223f
C18012 a_10464_2427# VPWR 0.2648f
C18013 sg13cmos5l_dfrbp_1_2.D a_10783_3876# 0
C18014 sg13cmos5l_nand2_1_0.A a_11434_2356# 0.02846f
C18015 a_1997_6126# a_1125_5423# 0.00206f
C18016 sg13cmos5l_buf_1_77.X a_7247_8797# 0
C18017 a_17132_9150# VPWR 0.2482f
C18018 sg13cmos5l_dfrbp_1_17.D a_1862_8874# 0.29288f
C18019 a_1662_8374# a_1956_8874# 0
C18020 a_3488_7010# VPWR 0.07766f
C18021 sg13cmos5l_dlhr_1_1.GATE a_4950_7354# 0.0028f
C18022 a_19624_8436# a_20008_8436# 0.00492f
C18023 a_18856_8436# sg13cmos5l_buf_1_19.A 0.2906f
C18024 a_6736_2630# a_6681_2511# 0.00464f
C18025 sg13cmos5l_dfrbp_1_6.RESET_B a_2148_3904# 0.02621f
C18026 sg13cmos5l_buf_8_2.X sg13cmos5l_buf_1_86.A 0.00492f
C18027 sg13cmos5l_dlhr_1_5.GATE sg13cmos5l_dlhr_1_5.Q 0
C18028 sg13cmos5l_buf_1_97.A a_10308_7992# 0
C18029 sg13cmos5l_dfrbp_1_10.Q a_8214_1608# 0
C18030 sg13cmos5l_dlhr_1_5.GATE sg13cmos5l_inv_1_19.A 0.00161f
C18031 sg13cmos5l_buf_1_34.X a_6572_1590# 0
C18032 sg13cmos5l_dfrbp_1_2.D a_11556_3904# 0.00279f
C18033 sg13cmos5l_buf_1_3.X sg13cmos5l_dfrbp_1_0.Q 0
C18034 sg13cmos5l_inv_1_14.A a_6213_3911# 0.02586f
C18035 a_1463_8511# rdy 0
C18036 sg13cmos5l_or2_1_0.A sg13cmos5l_buf_1_37.A 0
C18037 a_4076_7624# a_4514_7666# 0.0018f
C18038 sg13cmos5l_inv_1_8.A a_4559_7630# 0
C18039 sg13cmos5l_inv_1_3.A sg13cmos5l_dfrbp_1_21.Q 0.01979f
C18040 sg13cmos5l_inv_1_8.Y a_620_2352# 0
C18041 sg13cmos5l_inv_1_29.A a_11986_7674# 0
C18042 a_18486_8866# ph_sw[8] 0
C18043 sg13cmos5l_buf_1_57.X a_13977_6477# 0
C18044 sg13cmos5l_buf_1_107.X a_18856_8436# 0
C18045 sg13cmos5l_buf_1_87.A sg13cmos5l_buf_1_105.A 0.16935f
C18046 sg13cmos5l_a22oi_1_1.B2 sg13cmos5l_and3_1_0.C 0.00271f
C18047 sg13cmos5l_buf_1_63.A cks 0.10089f
C18048 VPWR nh_sw[3] 0.11172f
C18049 sg13cmos5l_buf_8_0.X a_20488_6294# 0.01673f
C18050 a_12404_7972# a_12361_7282# 0
C18051 sg13cmos5l_inv_1_2.A sg13cmos5l_buf_1_79.X 0.46792f
C18052 a_8204_9150# sg13cmos5l_dfrbp_1_6.RESET_B 0.00131f
C18053 sg13cmos5l_nand2_1_0.B a_11394_4948# 0
C18054 a_11190_7354# cks 0
C18055 sg13cmos5l_nor2_1_0.A a_12976_2630# 0.00179f
C18056 sg13cmos5l_dfrbp_1_23.CLK a_14986_7897# 0
C18057 sg13cmos5l_buf_1_60.X a_2732_9150# 0.00547f
C18058 sg13cmos5l_buf_1_26.A nh_sw[4] 0.16398f
C18059 sg13cmos5l_dfrbp_1_8.D a_19130_6172# 0.00308f
C18060 a_7034_3148# VPWR 0.37296f
C18061 a_16551_3987# sg13cmos5l_nor2_1_1.A 0
C18062 a_5220_2392# a_5324_1590# 0
C18063 sg13cmos5l_buf_1_5.X a_14962_3138# 0
C18064 sg13cmos5l_dlhr_1_6.D a_8841_5769# 0.00307f
C18065 sg13cmos5l_dfrbp_1_8.RESET_B a_9291_8447# 0.56069f
C18066 sg13cmos5l_buf_1_4.A sg13cmos5l_dfrbp_1_1.Q 0.02206f
C18067 a_17161_8794# cks 0.01724f
C18068 sg13cmos5l_dfrbp_1_6.RESET_B sg13cmos5l_or2_1_0.A 0.14225f
C18069 a_19227_4654# a_20488_4782# 0.03673f
C18070 sg13cmos5l_buf_1_101.X a_18856_8436# 0.00291f
C18071 sg13cmos5l_dfrbp_1_0.D a_18959_3215# 0
C18072 sg13cmos5l_buf_1_7.A sg13cmos5l_buf_1_8.A 0.17331f
C18073 a_18746_5776# d_out[2] 0
C18074 a_10707_2388# sg13cmos5l_buf_1_8.A 0
C18075 sg13cmos5l_buf_1_73.X sg13cmos5l_dfrbp_1_6.RESET_B 0
C18076 sg13cmos5l_buf_1_77.A sg13cmos5l_buf_1_31.X 0.14281f
C18077 a_16724_8436# sg13cmos5l_dlhr_1_12.D 0.02045f
C18078 sg13cmos5l_dfrbp_1_1.Q d_out[1] 0.01388f
C18079 sg13cmos5l_dfrbp_1_16.Q a_4640_3986# 0
C18080 a_18615_5770# ph_sw[9] 0
C18081 sg13cmos5l_inv_1_8.Y cks 0.06874f
C18082 sg13cmos5l_inv_1_0.A VPWR 1.3476f
C18083 sg13cmos5l_buf_1_24.A sg13cmos5l_buf_1_44.A 0
C18084 sg13cmos5l_dlhr_1_0.GATE sg13cmos5l_buf_1_25.A 0.15781f
C18085 sg13cmos5l_nand2_1_1.A a_13572_3151# 0
C18086 sg13cmos5l_dlhr_1_5.GATE sg13cmos5l_dlhr_1_9.D 0.58347f
C18087 a_13556_2388# a_13652_1924# 0
C18088 a_8982_7354# a_9448_6924# 0.00108f
C18089 sg13cmos5l_buf_1_7.A sg13cmos5l_buf_1_1.A 0.13703f
C18090 a_2757_3117# a_3496_1758# 0.00148f
C18091 a_17516_9150# ph_sw[7] 0
C18092 sg13cmos5l_dfrbp_1_8.RESET_B a_16068_6928# 0.51694f
C18093 sg13cmos5l_a22oi_1_1.A1 a_15702_4187# 0.0117f
C18094 sg13cmos5l_dfrbp_1_6.D a_13161_7281# 0.00655f
C18095 sg13cmos5l_inv_1_3.A sg13cmos5l_or2_1_1.B 0
C18096 a_19378_3138# VPWR 0
C18097 sg13cmos5l_buf_1_57.X a_10116_7674# 0
C18098 sg13cmos5l_dfrbp_1_8.RESET_B a_3505_3215# 0
C18099 sg13cmos5l_or2_1_0.A a_14543_3215# 0.00199f
C18100 a_3664_4142# VPWR 0.15031f
C18101 sg13cmos5l_dfrbp_1_6.RESET_B a_7820_2352# 0.05323f
C18102 a_14295_7282# sg13cmos5l_a22oi_1_1.B2 0
C18103 sg13cmos5l_inv_1_2.A sg13cmos5l_buf_1_96.A 0
C18104 a_12490_6385# VPWR 0.0992f
C18105 a_5674_6385# a_5988_6175# 0.00659f
C18106 a_5700_6480# a_6959_6239# 0.01741f
C18107 sg13cmos5l_dlhr_1_9.D a_5684_4948# 0.00254f
C18108 a_11940_9186# pl_sw[6] 0
C18109 sg13cmos5l_buf_1_60.X a_2565_8447# 0.00201f
C18110 a_14602_8404# sg13cmos5l_buf_1_57.X 0
C18111 a_14708_6924# a_14640_6924# 0
C18112 sg13cmos5l_nor2_1_0.A sg13cmos5l_a22oi_1_1.B2 0
C18113 a_12516_6480# sg13cmos5l_dfrbp_1_21.Q 0.00474f
C18114 sg13cmos5l_dfrbp_1_8.RESET_B a_3664_8678# 0.18264f
C18115 a_4652_6126# sg13cmos5l_inv_1_19.A 0.28827f
C18116 sg13cmos5l_buf_1_79.X a_9937_8797# 0.00965f
C18117 sg13cmos5l_dfrbp_1_6.RESET_B a_19904_7806# 0.00136f
C18118 sg13cmos5l_dfrbp_1_16.Q a_7394_5850# 0
C18119 sg13cmos5l_dfrbp_1_6.D a_8852_6484# 0.00306f
C18120 sg13cmos5l_o21ai_1_0.Y a_11877_2399# 0
C18121 sg13cmos5l_buf_1_63.X a_682_6892# 0
C18122 sg13cmos5l_buf_8_0.X a_20392_3900# 0.00146f
C18123 sg13cmos5l_dfrbp_1_6.RESET_B a_7247_8797# 0.05553f
C18124 sg13cmos5l_buf_1_5.A a_14342_8874# 0
C18125 sg13cmos5l_nand2_1_1.B a_15200_1758# 0.01511f
C18126 a_7524_7992# a_6959_6239# 0.00158f
C18127 a_7238_7674# a_7216_6382# 0
C18128 a_2505_8483# sg13cmos5l_dfrbp_1_15.D 0
C18129 a_7238_7674# a_7336_7010# 0
C18130 sg13cmos5l_inv_1_8.A a_6057_6553# 0
C18131 sg13cmos5l_inv_1_8.A sg13cmos5l_buf_1_43.A 0.07517f
C18132 a_15429_7653# sg13cmos5l_buf_1_4.A 0
C18133 sg13cmos5l_buf_1_29.A a_10230_4632# 0
C18134 sg13cmos5l_buf_1_56.A sg13cmos5l_buf_1_46.A 0.00191f
C18135 sg13cmos5l_dfrbp_1_6.RESET_B a_3578_2752# 0.00209f
C18136 a_9256_9224# a_8772_8440# 0
C18137 sg13cmos5l_dfrbp_1_21.Q cks 0.0232f
C18138 a_16724_8436# VPWR 0.35746f
C18139 sg13cmos5l_dfrbp_1_0.RESET_B a_11460_2392# 0.50507f
C18140 sg13cmos5l_buf_1_30.X sg13cmos5l_dfrbp_1_1.D 0.02806f
C18141 sg13cmos5l_buf_1_28.A a_9544_2474# 0
C18142 a_12232_8436# sg13cmos5l_dlhr_1_11.Q 0
C18143 sg13cmos5l_dlhr_1_11.GATE sg13cmos5l_dlhr_1_6.D 0
C18144 a_7238_7674# a_7332_7674# 0.00718f
C18145 a_15206_2826# nh_sw[8] 0
C18146 a_12804_6175# sg13cmos5l_nor2_1_0.A 0
C18147 sg13cmos5l_inv_1_14.A sg13cmos5l_dlhr_1_9.D 0.02168f
C18148 sg13cmos5l_dfrbp_1_11.Q a_7034_3148# 0
C18149 sg13cmos5l_nand2_1_0.A a_11748_2813# 0.00454f
C18150 sg13cmos5l_buf_1_64.A a_5416_9224# 0
C18151 sg13cmos5l_buf_1_77.X a_8580_8874# 0
C18152 sg13cmos5l_dlhr_1_15.Q cks 0.03217f
C18153 sg13cmos5l_dfrbp_1_6.RESET_B a_1672_3176# 0
C18154 sg13cmos5l_dfrbp_1_0.Q a_20392_2388# 0
C18155 a_12516_6480# sg13cmos5l_or2_1_1.B 0
C18156 a_1864_9224# sg13cmos5l_buf_1_68.X 0.00202f
C18157 sg13cmos5l_dfrbp_1_17.D a_2667_8447# 0
C18158 sg13cmos5l_buf_1_73.A sg13cmos5l_dfrbp_1_8.RESET_B 0.18168f
C18159 a_4005_4629# a_4640_3986# 0
C18160 sg13cmos5l_buf_1_59.A VPWR 0.40533f
C18161 sg13cmos5l_buf_1_97.A a_11824_7894# 0
C18162 a_16552_1664# nh_sw[8] 0.0127f
C18163 a_11848_8436# a_12232_8436# 0.00492f
C18164 sg13cmos5l_dfrbp_1_22.D a_18345_7674# 0
C18165 a_12567_7282# a_12516_6480# 0
C18166 sg13cmos5l_dlhr_1_0.D a_7689_1626# 0.02971f
C18167 sg13cmos5l_dlhr_1_9.D a_4652_6126# 0.00467f
C18168 a_20488_6294# a_20672_6294# 0.11523f
C18169 sg13cmos5l_inv_1_14.A a_7892_3900# 0.0068f
C18170 sg13cmos5l_buf_1_40.A sg13cmos5l_nor2_1_2.A 1.34557f
C18171 sg13cmos5l_nand2_1_0.A sg13cmos5l_buf_1_8.X 0.0898f
C18172 a_6380_7638# sg13cmos5l_dfrbp_1_6.D 0.00145f
C18173 sg13cmos5l_nor2_1_1.A a_17170_2826# 0
C18174 sg13cmos5l_dfrbp_1_20.Q_N a_10292_9508# 0
C18175 pl_sw[8] pl_sw[9] 0.03791f
C18176 sg13cmos5l_inv_1_18.A sg13cmos5l_a221oi_1_1.C1 0
C18177 sg13cmos5l_buf_1_77.A sg13cmos5l_a221oi_1_0.C1 0
C18178 sg13cmos5l_dfrbp_1_6.RESET_B sg13cmos5l_dlygate4sd2_1_0.X 0
C18179 sg13cmos5l_dfrbp_1_21.Q_N a_18746_5776# 0
C18180 sg13cmos5l_a221oi_1_0.A2 sg13cmos5l_nor2_1_0.A 0
C18181 a_3407_8797# ph_sw[2] 0
C18182 sg13cmos5l_inv_1_0.Y a_12704_4782# 0
C18183 a_20488_4782# a_20392_3900# 0.00679f
C18184 a_12567_7282# cks 0
C18185 a_6560_3270# VPWR 0.07853f
C18186 sg13cmos5l_dlhr_1_5.GATE sg13cmos5l_dlhr_1_7.Q_N 0.00197f
C18187 sg13cmos5l_dfrbp_1_18.Q a_10028_6126# 0.00425f
C18188 sg13cmos5l_dfrbp_1_0.CLK a_18122_2388# 0
C18189 a_708_6928# a_934_7349# 0.00523f
C18190 a_5739_2399# sg13cmos5l_buf_1_24.X 0.00878f
C18191 sg13cmos5l_dfrbp_1_6.RESET_B a_1946_4660# 0.01559f
C18192 a_682_6892# a_996_7349# 0.00659f
C18193 a_3792_2388# VPWR 0
C18194 sg13cmos5l_dfrbp_1_8.RESET_B sg13cmos5l_dfrbp_1_27.Q_N 0.00265f
C18195 sg13cmos5l_inv_1_28.Y sg13cmos5l_buf_1_10.A 1.37031f
C18196 a_14628_8440# a_14295_7282# 0
C18197 sg13cmos5l_a22oi_1_0.B1 sg13cmos5l_a22oi_1_1.B1 0.01873f
C18198 sg13cmos5l_a22oi_1_0.Y a_10433_4248# 0.00207f
C18199 sg13cmos5l_dfrbp_1_6.D a_16617_6553# 0
C18200 a_10420_5412# VPWR 0.29882f
C18201 a_13556_2388# sg13cmos5l_buf_1_8.A 0.00455f
C18202 sg13cmos5l_buf_1_110.A sg13cmos5l_dfrbp_1_23.Q_N 0
C18203 a_9242_4660# VPWR 0.36952f
C18204 sg13cmos5l_inv_1_8.A a_5510_4338# 0.0038f
C18205 sg13cmos5l_buf_1_28.X nl_sw[5] 0.3057f
C18206 sg13cmos5l_dfrbp_1_21.Q a_12358_5388# 0
C18207 sg13cmos5l_buf_1_90.X a_12651_9308# 0.00786f
C18208 sg13cmos5l_buf_1_18.A a_18999_6178# 0.02868f
C18209 a_17327_7285# a_17746_7362# 0.00176f
C18210 a_5988_8440# VPWR 0.07261f
C18211 sg13cmos5l_inv_1_17.A a_2831_7630# 0
C18212 sg13cmos5l_buf_1_58.A a_1125_6935# 0.04951f
C18213 sg13cmos5l_nor2_1_0.A a_10427_2736# 0
C18214 sg13cmos5l_dfrbp_1_16.Q a_8592_5412# 0
C18215 a_14254_2444# a_14440_1664# 0
C18216 a_3976_9224# sg13cmos5l_dfrbp_1_17.Q_N 0
C18217 sg13cmos5l_inv_1_0.A a_12814_4692# 0.11936f
C18218 sg13cmos5l_dlhr_1_16.Q sg13cmos5l_inv_1_5.A 0.00822f
C18219 sg13cmos5l_a22oi_1_1.A1 a_16462_4338# 0.00303f
C18220 sg13cmos5l_dfrbp_1_8.RESET_B a_17584_7166# 0.17543f
C18221 sg13cmos5l_dfrbp_1_6.D a_14426_7288# 0.00652f
C18222 a_13701_3117# a_13572_3151# 0.01562f
C18223 a_13284_3456# a_13510_3151# 0.00523f
C18224 a_13803_3260# a_14745_3453# 0
C18225 sg13cmos5l_inv_1_2.A sg13cmos5l_nand2_1_1.A 0
C18226 sg13cmos5l_inv_1_7.A pl_sw[6] 0.00167f
C18227 sg13cmos5l_dlhr_1_15.D a_14583_5770# 0.00407f
C18228 sg13cmos5l_buf_1_29.A a_9823_2780# 0
C18229 a_5132_3864# VPWR 0.29722f
C18230 sg13cmos5l_or2_1_0.A a_15702_4187# 0.00324f
C18231 sg13cmos5l_dfrbp_1_0.CLK sg13cmos5l_buf_1_4.X 0.02223f
C18232 a_13775_6239# VPWR 0.25897f
C18233 sg13cmos5l_inv_1_2.A a_16293_4629# 0.38378f
C18234 a_6959_6239# a_7796_6460# 0.1333f
C18235 a_6117_6141# a_6865_6239# 0.01058f
C18236 a_5700_6480# sg13cmos5l_dlhr_1_6.D 0
C18237 sg13cmos5l_dfrbp_1_6.RESET_B sg13cmos5l_inv_1_27.Y 2.25436f
C18238 sg13cmos5l_buf_1_60.X a_3313_8797# 0.0026f
C18239 sg13cmos5l_nand2_1_1.B a_16657_2749# 0
C18240 a_7520_7010# a_6959_6239# 0.0025f
C18241 a_7336_7010# a_7216_6382# 0
C18242 a_14612_6460# sg13cmos5l_dfrbp_1_21.Q 0
C18243 sg13cmos5l_dfrbp_1_8.RESET_B sg13cmos5l_dfrbp_1_15.D 0.17377f
C18244 sg13cmos5l_buf_1_79.X a_12716_8400# 0.33104f
C18245 sg13cmos5l_dfrbp_1_6.D a_13641_7674# 0
C18246 sg13cmos5l_o21ai_1_0.Y a_12976_2630# 0.00376f
C18247 sg13cmos5l_buf_1_77.A a_8043_7796# 0.00639f
C18248 sg13cmos5l_dfrbp_1_8.RESET_B sg13cmos5l_buf_1_40.A 0
C18249 a_2386_5850# sg13cmos5l_inv_1_19.A 0
C18250 sg13cmos5l_buf_1_19.A sg13cmos5l_dfrbp_1_8.D 0.26991f
C18251 sg13cmos5l_dlhr_1_9.D sg13cmos5l_buf_1_45.A 0.02098f
C18252 a_2122_3868# VPWR 0.11196f
C18253 sg13cmos5l_dfrbp_1_6.RESET_B sg13cmos5l_dfrbp_1_2.D 0.00666f
C18254 sg13cmos5l_or2_1_1.B a_12358_5388# 0.01528f
C18255 a_12216_5728# a_12616_5498# 0.02227f
C18256 a_17700_3456# VPWR 0.0915f
C18257 sg13cmos5l_inv_1_8.A pl_sw[4] 0.00381f
C18258 a_10010_9196# a_9189_8447# 0
C18259 a_7524_7992# sg13cmos5l_dlhr_1_6.D 0
C18260 sg13cmos5l_inv_1_7.A a_13803_3260# 0
C18261 a_1948_7964# a_2348_7624# 0.40925f
C18262 sg13cmos5l_inv_1_8.A a_5926_6175# 0
C18263 a_8043_7796# a_8457_7281# 0.01099f
C18264 sg13cmos5l_buf_1_63.A a_422_7362# 0
C18265 sg13cmos5l_dfrbp_1_6.RESET_B sg13cmos5l_buf_1_34.A 0.03032f
C18266 sg13cmos5l_buf_1_95.X a_13297_9263# 0.00427f
C18267 a_1227_6935# cks 0.00151f
C18268 a_620_2352# sg13cmos5l_buf_1_32.A 0.0012f
C18269 sg13cmos5l_buf_1_74.X a_8043_7796# 0
C18270 sg13cmos5l_dfrbp_1_0.RESET_B a_11979_2399# 0.5526f
C18271 sg13cmos5l_buf_1_9.A a_10696_1758# 0.00402f
C18272 a_14641_7326# a_14708_6924# 0.0018f
C18273 sg13cmos5l_inv_1_8.A sg13cmos5l_buf_1_74.X 0
C18274 a_8841_5769# a_8972_3864# 0
C18275 a_7941_7653# a_7812_7687# 0.01562f
C18276 a_7524_7992# a_7750_7687# 0.00523f
C18277 a_8043_7796# a_8985_7989# 0
C18278 a_19340_8400# a_19240_7712# 0.00139f
C18279 sg13cmos5l_buf_1_65.X sg13cmos5l_buf_1_62.X 2.13211f
C18280 sg13cmos5l_nand2_1_0.A a_11817_2435# 0
C18281 a_19216_3358# sg13cmos5l_buf_1_19.X 0.004f
C18282 sg13cmos5l_nor2_1_0.A a_10726_5760# 0
C18283 sg13cmos5l_buf_1_95.X sg13cmos5l_buf_1_103.A 0.00678f
C18284 sg13cmos5l_nand2_1_1.B a_13652_1924# 0
C18285 a_1125_5423# a_2224_5654# 0
C18286 a_1662_8374# sg13cmos5l_dfrbp_1_15.D 0.00249f
C18287 sg13cmos5l_dfrbp_1_1.Q sg13cmos5l_buf_1_8.X 0.01225f
C18288 a_9033_6162# a_9111_4666# 0.00187f
C18289 a_16234_6385# cks 0.03786f
C18290 a_13161_7281# a_13035_6284# 0
C18291 a_13686_7354# a_12933_6141# 0
C18292 sg13cmos5l_dfrbp_1_16.Q a_4244_6924# 0
C18293 a_20392_3176# a_20296_1664# 0
C18294 sg13cmos5l_dlhr_1_0.D a_10888_1664# 0.00587f
C18295 a_18865_3215# a_18671_1703# 0
C18296 sg13cmos5l_dfrbp_1_11.Q a_9242_4660# 0
C18297 a_5416_9224# VPWR 0.24729f
C18298 a_18363_4270# a_18865_3215# 0
C18299 sg13cmos5l_inv_1_14.A a_8296_3986# 0
C18300 a_1997_6126# a_708_5416# 0
C18301 sg13cmos5l_buf_1_65.X sg13cmos5l_buf_1_44.X 0.02646f
C18302 sg13cmos5l_inv_1_27.Y sg13cmos5l_inv_1_1.A 0
C18303 sg13cmos5l_inv_1_3.A sg13cmos5l_buf_1_110.A 0.01401f
C18304 sg13cmos5l_dfrbp_1_6.D a_1096_6294# 0
C18305 sg13cmos5l_dlhr_1_5.GATE a_6647_5459# 0.00344f
C18306 a_11752_6294# sg13cmos5l_nor2_1_0.A 0
C18307 a_19136_9318# ph_sw[9] 0
C18308 a_18860_6888# a_18615_5770# 0
C18309 sg13cmos5l_buf_1_105.A sg13cmos5l_dlhr_1_12.Q_N 0.03686f
C18310 sg13cmos5l_buf_1_29.A a_8785_6154# 0
C18311 a_1088_7806# a_1000_9224# 0
C18312 sg13cmos5l_dfrbp_1_6.RESET_B a_2342_5088# 0
C18313 a_6385_2749# sg13cmos5l_buf_1_24.X 0
C18314 sg13cmos5l_inv_1_2.A a_9673_9240# 0.01018f
C18315 a_7316_2388# VPWR 0.35768f
C18316 a_14377_5770# sg13cmos5l_a22oi_1_1.B1 0
C18317 sg13cmos5l_dfrbp_1_8.RESET_B a_13768_8436# 0.00917f
C18318 a_11360_9318# a_11272_8522# 0.00235f
C18319 a_17161_8794# pl_sw[9] 0.00106f
C18320 sg13cmos5l_buf_1_43.A sg13cmos5l_buf_1_32.X 0.05669f
C18321 sg13cmos5l_dfrbp_1_20.Q sg13cmos5l_dlhr_1_15.D 0
C18322 a_16703_3871# a_17224_3270# 0.00514f
C18323 sg13cmos5l_buf_1_24.A a_8022_3120# 0
C18324 a_11530_1849# nh_sw[5] 0.00345f
C18325 a_12132_9504# VPWR 0.0924f
C18326 sg13cmos5l_buf_1_44.X a_5962_8404# 0
C18327 a_17493_3947# cks 0
C18328 a_4460_9150# sg13cmos5l_dfrbp_1_8.RESET_B 0.00286f
C18329 sg13cmos5l_dlhr_1_11.D a_12841_7728# 0
C18330 a_11567_7751# a_11986_7674# 0.00176f
C18331 sg13cmos5l_inv_1_6.A a_18480_5028# 0.03119f
C18332 sg13cmos5l_inv_1_8.A a_6084_4325# 0.00236f
C18333 sg13cmos5l_buf_1_57.X a_12873_6553# 0
C18334 pl_sw[0] sg13cmos5l_buf_1_61.X 0.0112f
C18335 sg13cmos5l_buf_1_87.A sg13cmos5l_dlhr_1_12.D 0
C18336 sg13cmos5l_buf_1_107.X a_17780_8436# 0.00122f
C18337 sg13cmos5l_buf_1_25.X nh_sw[3] 0.21905f
C18338 sg13cmos5l_o21ai_1_0.A1 sg13cmos5l_a22oi_1_0.Y 0
C18339 sg13cmos5l_buf_1_18.A a_19526_6600# 0.00128f
C18340 sg13cmos5l_a22oi_1_2.B1 nl_sw[5] 0.10889f
C18341 a_7504_8678# VPWR 0.14716f
C18342 a_6198_3120# VPWR 0.25438f
C18343 sg13cmos5l_dlhr_1_4.Q_N sg13cmos5l_buf_1_24.X 0
C18344 sg13cmos5l_buf_1_5.A a_12933_6141# 0
C18345 sg13cmos5l_buf_1_5.X a_14745_3453# 0
C18346 a_16268_3102# sg13cmos5l_buf_1_2.X 0.33512f
C18347 a_14800_3358# a_14449_3215# 0.01017f
C18348 a_14543_3215# sg13cmos5l_dfrbp_1_7.Q_N 0.04107f
C18349 sg13cmos5l_dfrbp_1_8.RESET_B sg13cmos5l_dfrbp_1_8.D 0.19761f
C18350 sg13cmos5l_a22oi_1_1.A1 a_17399_3947# 0.01021f
C18351 sg13cmos5l_buf_1_41.X a_3008_1758# 0.01215f
C18352 a_8972_9150# sg13cmos5l_buf_1_77.A 0.33093f
C18353 a_3241_2746# VPWR 0.41179f
C18354 a_18376_9224# a_18486_8866# 0
C18355 sg13cmos5l_buf_1_101.X a_17780_8436# 0
C18356 sg13cmos5l_nor2b_1_0.Y a_11182_4948# 0
C18357 sg13cmos5l_buf_1_18.A sg13cmos5l_buf_8_0.X 0
C18358 sg13cmos5l_buf_1_77.A a_8276_6924# 0.00201f
C18359 sg13cmos5l_dlhr_1_9.D sg13cmos5l_dlhr_1_15.D 0
C18360 sg13cmos5l_inv_1_14.A a_6647_5459# 0.03145f
C18361 a_5988_6175# a_5926_6175# 0
C18362 a_7796_6460# sg13cmos5l_dlhr_1_6.D 0.15521f
C18363 a_6891_4772# VPWR 0.20557f
C18364 sg13cmos5l_inv_1_2.A sg13cmos5l_dfrbp_1_0.D 0
C18365 pl_sw[1] sg13cmos5l_buf_1_62.X 0.00118f
C18366 sg13cmos5l_buf_1_111.A cks 0.047f
C18367 sg13cmos5l_dfrbp_1_22.D sg13cmos5l_buf_1_57.X 0.00185f
C18368 sg13cmos5l_dlhr_1_5.Q a_6959_6239# 0
C18369 sg13cmos5l_buf_1_74.X a_8972_9150# 0
C18370 sg13cmos5l_buf_1_77.X sg13cmos5l_buf_1_73.A 0.00944f
C18371 a_6184_9224# pl_sw[4] 0.12447f
C18372 a_11272_8522# a_10665_7281# 0.00118f
C18373 sg13cmos5l_dfrbp_1_6.D a_14986_7897# 0.00108f
C18374 sg13cmos5l_dfrbp_1_1.D a_12721_1703# 0
C18375 sg13cmos5l_dfrbp_1_6.D a_2644_4636# 0
C18376 a_8276_6924# a_8457_7281# 0.40925f
C18377 a_1290_3206# VPWR 0.26218f
C18378 a_16164_4663# a_16102_4663# 0
C18379 VPWR frame 0.31533f
C18380 a_4358_6924# sg13cmos5l_inv_1_19.A 0
C18381 a_19796_3436# VPWR 0.36769f
C18382 sg13cmos5l_inv_1_3.A a_14166_7656# 0.04568f
C18383 a_10868_8436# pl_sw[6] 0
C18384 a_10473_9186# a_10031_8797# 0.02105f
C18385 a_9673_9240# a_9937_8797# 0
C18386 a_10292_9508# a_10288_8678# 0
C18387 sg13cmos5l_dfrbp_1_6.RESET_B a_9291_8447# 0.00621f
C18388 sg13cmos5l_dfrbp_1_6.RESET_B a_19412_6484# 0.11782f
C18389 a_8783_7751# sg13cmos5l_dlhr_1_6.D 0
C18390 sg13cmos5l_inv_1_7.A sg13cmos5l_buf_1_5.X 0
C18391 sg13cmos5l_buf_1_110.A cks 0.02197f
C18392 sg13cmos5l_dfrbp_1_10.Q_N a_2824_2388# 0.02091f
C18393 sg13cmos5l_inv_1_28.Y sg13cmos5l_nor2b_1_0.Y 0.00192f
C18394 a_1948_7964# sg13cmos5l_buf_1_58.A 0.29385f
C18395 a_9040_7894# a_8982_7354# 0
C18396 sg13cmos5l_buf_1_10.A sg13cmos5l_o21ai_1_0.B1 0.07962f
C18397 sg13cmos5l_buf_1_78.A a_6568_9224# 0
C18398 a_6184_9224# sg13cmos5l_buf_1_74.X 0.03436f
C18399 a_5770_3868# a_6213_3911# 0.02241f
C18400 a_12815_4261# a_13234_4338# 0.00176f
C18401 sg13cmos5l_dfrbp_1_0.RESET_B sg13cmos5l_dfrbp_1_4.Q_N 0.00286f
C18402 sg13cmos5l_nand2_1_1.B sg13cmos5l_buf_1_8.A 0.01931f
C18403 sg13cmos5l_buf_1_9.A a_11364_1626# 0
C18404 a_1402_3864# VPWR 0.37071f
C18405 sg13cmos5l_buf_1_60.A ph_sw[2] 0.01093f
C18406 sg13cmos5l_buf_1_87.A VPWR 0.32534f
C18407 a_18928_1846# nh_sw[9] 0.00745f
C18408 a_9291_8447# a_10071_7282# 0
C18409 sg13cmos5l_dfrbp_1_1.D a_10696_1758# 0.00516f
C18410 sg13cmos5l_inv_1_3.A sg13cmos5l_a22oi_1_1.Y 0
C18411 a_16657_2749# nh_sw[8] 0.01245f
C18412 sg13cmos5l_dlhr_1_17.Q_N a_9242_4660# 0
C18413 sg13cmos5l_buf_1_31.X sg13cmos5l_dlhr_1_2.Q_N 0.00613f
C18414 sg13cmos5l_dfrbp_1_6.RESET_B a_16068_6928# 0.0011f
C18415 a_5132_9150# a_5416_9224# 0.13542f
C18416 sg13cmos5l_dfrbp_1_11.Q a_7316_2388# 0
C18417 a_1609_4704# VPWR 0.45072f
C18418 sg13cmos5l_dlhr_1_15.Q pl_sw[9] 0.00291f
C18419 sg13cmos5l_nand2_1_1.B sg13cmos5l_buf_1_1.A 0.02697f
C18420 sg13cmos5l_dfrbp_1_6.RESET_B a_3505_3215# 0
C18421 sg13cmos5l_inv_1_14.A a_8392_3270# 0.00261f
C18422 sg13cmos5l_dlhr_1_6.D a_14583_5770# 0
C18423 a_1125_5423# sg13cmos5l_dlhr_1_1.D 0.00731f
C18424 a_11973_3911# a_12075_3911# 0.6663f
C18425 a_11556_3904# a_13072_4142# 0.00159f
C18426 a_15429_7653# a_15592_6200# 0.00269f
C18427 sg13cmos5l_buf_1_56.A a_9705_4650# 0.00225f
C18428 sg13cmos5l_or2_1_1.B sg13cmos5l_a22oi_1_2.B2 0.31478f
C18429 a_17931_1748# nh_sw[8] 0
C18430 sg13cmos5l_buf_1_3.A VPWR 1.10073f
C18431 sg13cmos5l_dlhr_1_9.D a_6959_6239# 0
C18432 sg13cmos5l_dlhr_1_0.D a_8576_1758# 0.00129f
C18433 sg13cmos5l_dfrbp_1_23.Q a_12933_6141# 0
C18434 sg13cmos5l_inv_1_2.A a_10428_9222# 0
C18435 a_3625_7282# a_2748_6126# 0
C18436 a_3831_7282# a_3575_6553# 0
C18437 a_14962_3138# nh_sw[7] 0
C18438 sg13cmos5l_dfrbp_1_6.RESET_B a_3664_8678# 0
C18439 sg13cmos5l_dfrbp_1_22.D a_16779_6284# 0
C18440 sg13cmos5l_buf_1_57.X sg13cmos5l_and3_1_0.X 0
C18441 a_11270_4338# a_11364_4338# 0.00718f
C18442 sg13cmos5l_buf_1_57.X sg13cmos5l_inv_1_0.Y 0.00202f
C18443 sg13cmos5l_buf_1_31.X sg13cmos5l_nor2b_1_0.Y 0
C18444 sg13cmos5l_buf_1_93.X VPWR 0.2211f
C18445 sg13cmos5l_nand2_1_1.A nl_sw[9] 0
C18446 a_4005_4629# a_4244_3900# 0.01099f
C18447 sg13cmos5l_dfrbp_1_10.Q sg13cmos5l_buf_1_28.A 0.00132f
C18448 a_13641_7674# a_13035_6284# 0
C18449 a_13460_7996# a_12933_6141# 0.0013f
C18450 sg13cmos5l_buf_1_31.X sg13cmos5l_buf_1_44.A 0.01172f
C18451 a_2621_7636# sg13cmos5l_inv_1_19.A 0
C18452 sg13cmos5l_dfrbp_1_8.D a_15850_4873# 0.01623f
C18453 a_18219_3260# a_17829_1605# 0
C18454 a_18117_3117# a_17931_1748# 0
C18455 sg13cmos5l_dfrbp_1_11.Q a_6891_4772# 0.02255f
C18456 sg13cmos5l_dlhr_1_0.D VPWR 0.66629f
C18457 a_14996_5412# sg13cmos5l_a22oi_1_1.B1 0
C18458 sg13cmos5l_dfrbp_1_8.RESET_B a_15876_4968# 0.47971f
C18459 sg13cmos5l_buf_1_24.A sg13cmos5l_dlhr_1_2.Q 0.03908f
C18460 a_14228_9484# VPWR 0.35273f
C18461 a_14377_5770# a_13486_5412# 0
C18462 sg13cmos5l_inv_1_9.Y a_620_2352# 0
C18463 sg13cmos5l_nand2_1_1.B a_10433_4248# 0
C18464 sg13cmos5l_dlhr_1_11.D a_11986_7674# 0
C18465 a_5704_1664# a_6188_1590# 0.03472f
C18466 sg13cmos5l_inv_1_8.A a_6153_3947# 0
C18467 a_8247_5770# a_8796_5814# 0
C18468 sg13cmos5l_a221oi_1_0.A2 a_8660_5412# 0
C18469 a_8378_5776# a_8841_5769# 0.13395f
C18470 sg13cmos5l_buf_1_63.X cks 0.82028f
C18471 sg13cmos5l_inv_1_1.A a_16068_6928# 0.04242f
C18472 a_14166_7656# cks 0.00119f
C18473 a_422_7362# a_1227_6935# 0.11742f
C18474 sg13cmos5l_dfrbp_1_16.Q a_9524_4972# 0
C18475 sg13cmos5l_inv_1_18.A sg13cmos5l_dfrbp_1_18.Q 0.11346f
C18476 sg13cmos5l_buf_1_73.A sg13cmos5l_dfrbp_1_6.RESET_B 0.04003f
C18477 sg13cmos5l_buf_1_65.X sg13cmos5l_dlhr_1_9.Q 0
C18478 a_8486_8874# VPWR 0.92739f
C18479 sg13cmos5l_a221oi_1_0.B1 a_11530_3868# 0
C18480 sg13cmos5l_nand2_1_1.A a_19616_3986# 0.00187f
C18481 a_6315_3911# sg13cmos5l_buf_1_25.A 0
C18482 sg13cmos5l_inv_1_6.A a_19142_5412# 0
C18483 a_4276_2776# VPWR 0
C18484 a_9256_9224# pl_sw[5] 0.0051f
C18485 sg13cmos5l_buf_1_98.A a_13686_7354# 0
C18486 sg13cmos5l_dlhr_1_15.D a_18615_5770# 0
C18487 a_1760_1758# nh_sw[0] 0.00227f
C18488 sg13cmos5l_buf_1_7.A sg13cmos5l_nor2b_1_1.Y 0
C18489 sg13cmos5l_a22oi_1_1.Y cks 0.07003f
C18490 a_4566_2818# nh_sw[2] 0
C18491 sg13cmos5l_inv_1_0.A a_10783_4292# 0
C18492 sg13cmos5l_or2_1_0.A a_17399_3947# 0.01672f
C18493 sg13cmos5l_buf_1_58.A a_708_6928# 0.02002f
C18494 a_7833_4965# VPWR 0
C18495 a_15016_6294# a_14714_5776# 0.00231f
C18496 sg13cmos5l_dlhr_1_5.Q sg13cmos5l_dlhr_1_6.D 0.35015f
C18497 sg13cmos5l_inv_1_9.Y cks 0.09825f
C18498 a_18345_7674# a_18793_6216# 0
C18499 sg13cmos5l_dlhr_1_0.GATE sg13cmos5l_buf_1_26.A 0
C18500 sg13cmos5l_dfrbp_1_0.RESET_B a_18865_3215# 0
C18501 sg13cmos5l_dfrbp_1_6.D a_15429_7653# 0.00142f
C18502 a_2697_3529# VPWR 0
C18503 sg13cmos5l_buf_1_24.A a_6346_4873# 0.03431f
C18504 ph_sw[1] sg13cmos5l_inv_1_19.A 0.0015f
C18505 sg13cmos5l_buf_1_94.X ph_sw[7] 0.10505f
C18506 a_1000_9224# sg13cmos5l_inv_1_19.A 0.00352f
C18507 a_6117_6141# a_6602_5692# 0
C18508 sg13cmos5l_dfrbp_1_6.RESET_B sg13cmos5l_dfrbp_1_27.Q_N 0.05235f
C18509 sg13cmos5l_buf_1_29.A sg13cmos5l_buf_1_28.X 0.49041f
C18510 a_12232_8436# pl_sw[6] 0.00142f
C18511 sg13cmos5l_dfrbp_1_6.RESET_B a_19548_6198# 0
C18512 sg13cmos5l_dfrbp_1_20.Q sg13cmos5l_dlhr_1_6.D 0.0264f
C18513 sg13cmos5l_dfrbp_1_20.Q a_8412_7326# 0
C18514 a_16395_4772# sg13cmos5l_buf_1_2.X 0
C18515 a_1664_7806# sg13cmos5l_buf_1_58.A 0.00688f
C18516 sg13cmos5l_inv_1_27.Y a_12361_7282# 0.03647f
C18517 sg13cmos5l_buf_1_38.A a_4172_1590# 0.33635f
C18518 a_6213_3911# a_7312_4142# 0
C18519 a_6022_4325# a_6084_4325# 0
C18520 a_1862_8874# VPWR 0.94953f
C18521 a_424_8436# sg13cmos5l_dfrbp_1_6.D 0
C18522 a_5796_3904# a_7055_4261# 0.01741f
C18523 a_2565_8447# sg13cmos5l_dlhr_1_1.GATE 0
C18524 sg13cmos5l_dfrbp_1_0.CLK a_16268_3102# 0.00177f
C18525 sg13cmos5l_dfrbp_1_6.RESET_B nl_sw[3] 0
C18526 a_15124_7312# sg13cmos5l_buf_1_89.A 0
C18527 a_18577_1703# nh_sw[9] 0
C18528 a_12075_3911# a_12998_3138# 0
C18529 sg13cmos5l_dfrbp_1_1.D a_11364_1626# 0
C18530 sg13cmos5l_dfrbp_1_8.RESET_B pl_sw[3] 0.0222f
C18531 sg13cmos5l_dfrbp_1_6.D a_9448_6924# 0.00381f
C18532 sg13cmos5l_dfrbp_1_6.RESET_B a_17584_7166# 0.00631f
C18533 a_14449_3215# VPWR 0.00195f
C18534 sg13cmos5l_buf_1_40.A sg13cmos5l_buf_1_37.A 0
C18535 sg13cmos5l_a221oi_1_0.C1 sg13cmos5l_nor2b_1_0.Y 0.17188f
C18536 sg13cmos5l_or2_1_1.B a_11268_5760# 0
C18537 sg13cmos5l_buf_1_45.X sg13cmos5l_dfrbp_1_16.Q 0.02705f
C18538 sg13cmos5l_buf_1_5.A sg13cmos5l_buf_1_98.A 0.00312f
C18539 a_12132_9504# a_13047_7690# 0
C18540 sg13cmos5l_inv_1_26.Y a_19444_5800# 0
C18541 a_2160_4972# VPWR 0
C18542 a_996_7349# cks 0.0033f
C18543 sg13cmos5l_dlhr_1_1.GATE sg13cmos5l_dfrbp_1_9.Q 0
C18544 a_9879_9202# sg13cmos5l_dfrbp_1_8.RESET_B 0.00285f
C18545 sg13cmos5l_dfrbp_1_0.CLK a_13652_3900# 0
C18546 a_10331_3900# a_10783_3876# 0
C18547 a_8043_7796# a_7994_7288# 0
C18548 sg13cmos5l_dlhr_1_9.D sg13cmos5l_dlhr_1_6.D 0
C18549 sg13cmos5l_dfrbp_1_23.CLK a_14377_5770# 0.02672f
C18550 sg13cmos5l_dfrbp_1_23.Q a_15208_6200# 0.04706f
C18551 a_12976_2630# nh_sw[6] 0
C18552 sg13cmos5l_a22oi_1_1.B1 sg13cmos5l_buf_1_7.A 0.00871f
C18553 a_15850_4873# a_15876_4968# 0.43042f
C18554 a_4425_7281# a_3575_6553# 0
C18555 sg13cmos5l_dfrbp_1_6.RESET_B sg13cmos5l_dfrbp_1_15.D 0.51014f
C18556 a_1760_3986# a_1580_2352# 0
C18557 sg13cmos5l_a22oi_1_2.B1 a_9164_1590# 0.00299f
C18558 a_934_5837# a_996_5837# 0
C18559 a_708_5416# a_2224_5654# 0.00159f
C18560 sg13cmos5l_dfrbp_1_6.RESET_B sg13cmos5l_buf_1_40.A 0.19857f
C18561 a_11270_4338# sg13cmos5l_dfrbp_1_0.CLK 0.00141f
C18562 a_17161_8794# a_16485_6935# 0
C18563 sg13cmos5l_dfrbp_1_6.D a_1967_5773# 0.02169f
C18564 sg13cmos5l_buf_1_64.A sg13cmos5l_buf_1_76.X 0.02189f
C18565 sg13cmos5l_inv_1_14.A a_7034_3148# 0.01341f
C18566 sg13cmos5l_dfrbp_1_0.Q sg13cmos5l_buf_1_0.X 0.17824f
C18567 a_4107_4772# sg13cmos5l_buf_1_38.A 0
C18568 a_8570_6172# a_8468_4948# 0
C18569 sg13cmos5l_dfrbp_1_8.D a_17135_4727# 0.02842f
C18570 sg13cmos5l_buf_1_30.A a_9164_1590# 0
C18571 sg13cmos5l_buf_1_1.A nh_sw[8] 0.00119f
C18572 a_18959_3215# a_18671_1703# 0.00718f
C18573 sg13cmos5l_dfrbp_1_11.Q a_7833_4965# 0.00107f
C18574 sg13cmos5l_nor2b_1_0.Y sg13cmos5l_o21ai_1_0.B1 0.00245f
C18575 a_17780_8436# a_17712_8436# 0
C18576 a_18363_4270# a_18959_3215# 0.00639f
C18577 sg13cmos5l_dfrbp_1_0.D nl_sw[9] 0.1098f
C18578 sg13cmos5l_nand2_1_0.A sg13cmos5l_buf_1_9.A 0.83298f
C18579 sg13cmos5l_buf_1_24.A a_8588_2352# 0
C18580 sg13cmos5l_buf_1_79.X a_10292_9508# 0
C18581 sg13cmos5l_buf_1_77.A sg13cmos5l_a221oi_1_1.C1 0.00209f
C18582 a_904_7806# a_1000_9224# 0
C18583 a_13596_7710# cks 0
C18584 sg13cmos5l_inv_1_1.A a_17584_7166# 0
C18585 a_9060_8861# VPWR 0.00674f
C18586 sg13cmos5l_buf_1_43.A a_416_2474# 0.00241f
C18587 a_4076_7624# a_3962_7288# 0
C18588 a_4349_7636# a_3831_7282# 0.00935f
C18589 a_19593_6162# VPWR 0.6244f
C18590 a_9033_6162# a_9268_6148# 0.00566f
C18591 a_8852_6484# a_8988_6198# 0.00404f
C18592 sg13cmos5l_dfrbp_1_1.Q nh_sw[9] 0.03088f
C18593 sg13cmos5l_buf_1_31.X a_1760_3986# 0
C18594 sg13cmos5l_dfrbp_1_6.D a_2732_1590# 0
C18595 sg13cmos5l_o21ai_1_0.A1 sg13cmos5l_nand2_1_1.B 0.00131f
C18596 sg13cmos5l_dlhr_1_5.GATE sg13cmos5l_buf_1_59.A 0.00896f
C18597 a_15147_8447# a_15429_7653# 0
C18598 a_8588_3864# sg13cmos5l_buf_1_25.A 0
C18599 a_13076_5376# sg13cmos5l_dfrbp_1_0.RESET_B 0
C18600 sg13cmos5l_buf_1_10.A nl_sw[6] 0
C18601 sg13cmos5l_a22oi_1_0.Y sg13cmos5l_a22oi_1_1.B1 0.01632f
C18602 sg13cmos5l_a22oi_1_1.Y a_18219_3260# 0
C18603 pl_sw[0] a_616_9224# 0.02213f
C18604 a_13556_2388# sg13cmos5l_nor2b_1_1.Y 0
C18605 sg13cmos5l_inv_1_2.A a_16572_4261# 0.03055f
C18606 a_17132_9150# a_16271_7751# 0.00245f
C18607 sg13cmos5l_inv_1_18.A cks 0.02473f
C18608 sg13cmos5l_inv_1_8.A sg13cmos5l_buf_1_44.A 0.0715f
C18609 a_10587_4692# sg13cmos5l_nand2_1_0.A 0.00108f
C18610 sg13cmos5l_buf_1_111.A pl_sw[9] 1.07788f
C18611 a_16042_6892# VPWR 0.09547f
C18612 sg13cmos5l_dlhr_1_9.D a_7312_4142# 0
C18613 a_4107_4772# sg13cmos5l_or2_1_0.A 0
C18614 sg13cmos5l_inv_1_7.A a_13161_7281# 0
C18615 sg13cmos5l_or2_1_0.A sg13cmos5l_buf_1_8.A 0
C18616 sg13cmos5l_dfrbp_1_16.Q sg13cmos5l_a22oi_1_2.B2 0.25891f
C18617 a_2566_3151# VPWR 0
C18618 sg13cmos5l_buf_1_98.A a_13460_7996# 0.01227f
C18619 sg13cmos5l_inv_1_6.A a_18615_5770# 0.00588f
C18620 a_6959_6239# a_6647_5459# 0
C18621 sg13cmos5l_dfrbp_1_6.RESET_B a_13768_8436# 0.00824f
C18622 sg13cmos5l_buf_1_97.A a_8486_8874# 0
C18623 sg13cmos5l_buf_1_29.A sg13cmos5l_a22oi_1_2.B1 0.5725f
C18624 a_19240_7712# sg13cmos5l_dlhr_1_15.Q_N 0.12906f
C18625 a_6315_3911# a_6961_4261# 0.00667f
C18626 a_2667_8447# VPWR 0.20998f
C18627 a_17751_7690# a_17584_7166# 0
C18628 sg13cmos5l_dfrbp_1_1.Q a_14962_3138# 0
C18629 sg13cmos5l_dlhr_1_0.GATE a_7497_3138# 0
C18630 sg13cmos5l_dfrbp_1_0.RESET_B a_17224_3270# 0.00685f
C18631 a_7994_7288# a_8276_6924# 0.68988f
C18632 sg13cmos5l_buf_1_30.A sg13cmos5l_buf_1_29.A 0
C18633 sg13cmos5l_dlhr_1_0.GATE sg13cmos5l_dlhr_1_3.Q_N 0
C18634 sg13cmos5l_dlhr_1_5.GATE a_5988_8440# 0.00708f
C18635 sg13cmos5l_dlhr_1_12.Q_N VPWR 0.2521f
C18636 sg13cmos5l_dfrbp_1_6.RESET_B sg13cmos5l_dfrbp_1_8.D 1.83263f
C18637 a_11174_2826# a_11268_2826# 0.00718f
C18638 a_13391_9263# a_13178_7684# 0
C18639 a_1125_5423# sg13cmos5l_inv_1_19.A 0.02601f
C18640 sg13cmos5l_buf_1_63.X a_422_7362# 0
C18641 sg13cmos5l_dfrbp_1_23.CLK a_14996_5412# 0
C18642 a_1878_6337# a_1815_4666# 0
C18643 a_14254_2444# nh_sw[6] 0
C18644 a_15876_4968# a_17135_4727# 0.01741f
C18645 sg13cmos5l_buf_1_59.A a_4652_6126# 0.32805f
C18646 sg13cmos5l_dlhr_1_11.GATE a_11473_7751# 0.00357f
C18647 a_8772_8440# ph_sw[4] 0
C18648 a_4847_4727# a_5079_3154# 0.00283f
C18649 sg13cmos5l_dfrbp_1_6.D a_6117_6141# 0.00834f
C18650 a_708_5416# sg13cmos5l_dlhr_1_1.D 0.00232f
C18651 a_18999_6178# sg13cmos5l_buf_8_0.A 0.00132f
C18652 sg13cmos5l_buf_1_31.X a_8022_3120# 0.00521f
C18653 a_8660_5412# a_8905_4704# 0
C18654 a_8841_5769# a_9111_4666# 0.00966f
C18655 sg13cmos5l_buf_1_79.X sg13cmos5l_buf_1_90.X 0.02932f
C18656 a_7820_9150# VPWR 0.24792f
C18657 sg13cmos5l_buf_1_19.A sg13cmos5l_buf_1_19.X 0.00161f
C18658 a_11844_4325# sg13cmos5l_dfrbp_1_0.CLK 0.00125f
C18659 sg13cmos5l_dfrbp_1_6.RESET_B a_12912_6924# 0
C18660 a_17498_8800# a_17584_7166# 0
C18661 a_17161_8794# a_17327_7285# 0
C18662 sg13cmos5l_dlhr_1_12.D a_16587_6935# 0
C18663 a_19216_3358# sg13cmos5l_buf_1_18.X 0
C18664 sg13cmos5l_inv_1_18.A a_9524_4972# 0.00767f
C18665 sg13cmos5l_inv_1_14.A a_6560_3270# 0
C18666 a_2554_8112# cks 0
C18667 frame ph_sw[9] 0
C18668 sg13cmos5l_dfrbp_1_1.Q sg13cmos5l_buf_1_9.A 0.01018f
C18669 a_14536_7806# a_13775_6239# 0.00165f
C18670 sg13cmos5l_inv_1_8.A a_3831_7282# 0
C18671 a_7498_7897# a_8043_7796# 0.00999f
C18672 sg13cmos5l_dfrbp_1_6.D a_7941_7653# 0
C18673 sg13cmos5l_buf_1_3.X a_20296_1664# 0.29081f
C18674 sg13cmos5l_buf_1_76.X VPWR 0.26727f
C18675 sg13cmos5l_buf_1_107.X a_17882_7684# 0
C18676 sg13cmos5l_inv_1_3.A sg13cmos5l_buf_1_95.X 0.0313f
C18677 sg13cmos5l_buf_1_34.X sg13cmos5l_dfrbp_1_16.Q 0.02132f
C18678 sg13cmos5l_inv_1_29.Y sg13cmos5l_nor2_1_0.A 0.02457f
C18679 a_14714_5776# a_14928_5412# 0.01249f
C18680 a_15177_5769# a_15702_5842# 0.13715f
C18681 a_14996_5412# a_15132_5814# 0.00404f
C18682 a_11182_4948# a_11372_3102# 0
C18683 sg13cmos5l_nand2_1_0.A sg13cmos5l_dfrbp_1_1.D 0
C18684 a_7249_3130# sg13cmos5l_buf_1_25.A 0
C18685 sg13cmos5l_dlhr_1_9.D a_1125_5423# 0
C18686 sg13cmos5l_buf_1_4.X a_16751_2749# 0.01534f
C18687 a_7052_9150# a_6405_8447# 0
C18688 sg13cmos5l_inv_1_14.A a_5988_8440# 0.03711f
C18689 sg13cmos5l_buf_1_64.A a_3976_9224# 0.32354f
C18690 sg13cmos5l_buf_1_87.A ph_sw[9] 1.38993f
C18691 sg13cmos5l_buf_1_57.X a_15782_7362# 0
C18692 sg13cmos5l_inv_1_1.A sg13cmos5l_dfrbp_1_8.D 0.12621f
C18693 a_11686_2813# nl_sw[6] 0
C18694 a_18860_9150# a_18345_7674# 0.00119f
C18695 sg13cmos5l_buf_1_101.X a_17882_7684# 0
C18696 sg13cmos5l_dfrbp_1_6.RESET_B a_17780_8436# 0.11569f
C18697 sg13cmos5l_dfrbp_1_16.Q_N a_4177_7326# 0
C18698 a_4349_7636# a_4425_7281# 0.00556f
C18699 a_4559_7630# a_4244_6924# 0.00663f
C18700 sg13cmos5l_dlhr_1_1.GATE sg13cmos5l_buf_1_41.A 0.01797f
C18701 sg13cmos5l_buf_1_3.A a_20012_2352# 0.02777f
C18702 a_1088_7806# sg13cmos5l_buf_1_61.X 0
C18703 sg13cmos5l_buf_1_18.A sg13cmos5l_dfrbp_1_0.CLK 0.70528f
C18704 sg13cmos5l_dfrbp_1_6.D nl_sw[2] 0
C18705 sg13cmos5l_nor2_1_0.A a_13510_3151# 0
C18706 a_15887_8797# a_16528_7894# 0.0058f
C18707 sg13cmos5l_dfrbp_1_22.D a_15012_7992# 0.09643f
C18708 a_16724_8436# a_16271_7751# 0.00525f
C18709 sg13cmos5l_dlhr_1_0.D sg13cmos5l_buf_1_25.X 0.01349f
C18710 sg13cmos5l_and3_1_0.X sg13cmos5l_dfrbp_1_0.RESET_B 0
C18711 sg13cmos5l_buf_1_79.X a_11190_7354# 0
C18712 sg13cmos5l_inv_1_0.Y sg13cmos5l_dfrbp_1_0.RESET_B 0
C18713 a_12841_7728# ph_sw[6] 0
C18714 sg13cmos5l_buf_1_46.A sg13cmos5l_a22oi_1_1.B1 0
C18715 sg13cmos5l_buf_1_3.A ph_sw[9] 0
C18716 a_422_7362# a_996_7349# 0.36169f
C18717 sg13cmos5l_inv_1_2.A a_16703_3871# 0.00643f
C18718 sg13cmos5l_a22oi_1_1.B2 a_13792_5760# 0.01868f
C18719 sg13cmos5l_inv_1_7.A nh_sw[7] 0
C18720 a_1815_4666# a_2161_4642# 0.00722f
C18721 a_2934_4632# a_3302_4650# 0
C18722 a_16587_6935# VPWR 0.20906f
C18723 sg13cmos5l_inv_1_17.A sg13cmos5l_buf_1_35.A 0.00337f
C18724 sg13cmos5l_buf_1_30.X nl_sw[5] 0.00904f
C18725 sg13cmos5l_buf_1_77.X a_9879_9202# 0
C18726 a_5104_4870# sg13cmos5l_or2_1_0.A 0
C18727 sg13cmos5l_buf_1_10.A sg13cmos5l_a221oi_1_1.C1 0
C18728 sg13cmos5l_buf_1_39.A nl_sw[1] 0
C18729 sg13cmos5l_dlhr_1_1.D a_2436_4325# 0
C18730 sg13cmos5l_buf_1_5.X sg13cmos5l_buf_1_2.X 0.13753f
C18731 sg13cmos5l_buf_1_37.A a_3008_1758# 0.05983f
C18732 sg13cmos5l_inv_1_6.A a_19209_5769# 0.00525f
C18733 sg13cmos5l_buf_1_34.A a_4172_1590# 0.00111f
C18734 a_4934_2826# sg13cmos5l_buf_1_39.A 0.00205f
C18735 sg13cmos5l_buf_1_45.X sg13cmos5l_inv_1_18.A 0.06816f
C18736 sg13cmos5l_buf_1_97.A a_9060_8861# 0
C18737 a_13284_3456# sg13cmos5l_dfrbp_1_0.Q 0
C18738 sg13cmos5l_dfrbp_1_6.RESET_B a_15876_4968# 0.00155f
C18739 a_8276_6924# a_8247_5770# 0
C18740 sg13cmos5l_nor2b_1_0.Y sg13cmos5l_nand2_1_0.B 0.40214f
C18741 sg13cmos5l_inv_1_2.A sg13cmos5l_buf_1_57.X 0
C18742 sg13cmos5l_dfrbp_1_17.Q_N VPWR 0.17778f
C18743 a_7055_4261# a_7257_4023# 0.00675f
C18744 sg13cmos5l_inv_1_8.A a_1760_3986# 0.00185f
C18745 a_17545_7728# sg13cmos5l_dfrbp_1_22.Q_N 0
C18746 a_2667_8447# a_1967_7285# 0
C18747 sg13cmos5l_buf_1_78.A pl_sw[4] 0.03984f
C18748 sg13cmos5l_inv_1_17.A a_2667_3911# 0
C18749 sg13cmos5l_buf_1_96.A a_11190_7354# 0.60847f
C18750 sg13cmos5l_dfrbp_1_0.RESET_B a_18959_3215# 0.2003f
C18751 a_3599_3215# a_3688_1664# 0
C18752 sg13cmos5l_dlhr_1_5.GATE a_7504_8678# 0
C18753 sg13cmos5l_inv_1_1.A a_17780_8436# 0
C18754 sg13cmos5l_buf_1_34.X a_4005_4629# 0.03261f
C18755 a_13258_3361# a_13803_3260# 0.00999f
C18756 sg13cmos5l_buf_1_0.A sg13cmos5l_dfrbp_1_0.CLK 0.05829f
C18757 a_9040_7894# a_9202_7674# 0.0019f
C18758 sg13cmos5l_buf_1_95.X cks 0.00645f
C18759 sg13cmos5l_buf_1_2.A a_16268_3102# 0.00104f
C18760 sg13cmos5l_dfrbp_1_10.Q_N sg13cmos5l_buf_1_32.A 0
C18761 sg13cmos5l_nor2b_1_0.Y nl_sw[6] 0.00244f
C18762 sg13cmos5l_buf_1_78.A sg13cmos5l_buf_1_74.X 0
C18763 sg13cmos5l_buf_1_73.X a_7052_9150# 0.00604f
C18764 sg13cmos5l_buf_1_44.A a_6022_4325# 0
C18765 sg13cmos5l_dfrbp_1_0.CLK a_13803_3260# 0.03257f
C18766 sg13cmos5l_dlhr_1_15.D sg13cmos5l_inv_1_0.A 0.68027f
C18767 a_17135_4727# a_17972_4948# 0.1333f
C18768 sg13cmos5l_nand2_1_1.B sg13cmos5l_nor2b_1_1.Y 0.45131f
C18769 a_934_7349# cks 0
C18770 sg13cmos5l_dfrbp_1_6.D a_7161_6477# 0
C18771 sg13cmos5l_a22oi_1_2.B1 a_11530_1849# 0
C18772 sg13cmos5l_buf_1_31.X sg13cmos5l_dlhr_1_2.Q 0.02074f
C18773 a_19734_5842# sg13cmos5l_dlhr_1_16.Q_N 0.12876f
C18774 a_19028_5412# a_18960_5412# 0
C18775 sg13cmos5l_buf_1_45.A a_9242_4660# 0.03161f
C18776 a_20392_2388# a_20296_1664# 0
C18777 a_5132_9150# sg13cmos5l_buf_1_76.X 0.00657f
C18778 sg13cmos5l_inv_1_5.A a_20288_2474# 0
C18779 sg13cmos5l_dfrbp_1_8.D a_15702_4187# 0
C18780 a_9937_8797# sg13cmos5l_buf_1_57.X 0
C18781 a_4559_7630# cks 0.00642f
C18782 sg13cmos5l_dlhr_1_0.GATE sg13cmos5l_buf_1_38.A 0
C18783 sg13cmos5l_inv_1_1.A a_15876_4968# 0.00423f
C18784 a_15429_7653# sg13cmos5l_buf_1_116.A 0.00296f
C18785 sg13cmos5l_inv_1_14.A a_7316_2388# 0.01222f
C18786 a_4847_4727# a_5266_4650# 0.00176f
C18787 sg13cmos5l_dlhr_1_6.D a_8050_4650# 0
C18788 sg13cmos5l_inv_1_2.A a_16779_6284# 0.04276f
C18789 sg13cmos5l_dfrbp_1_1.Q sg13cmos5l_dfrbp_1_1.D 0.0055f
C18790 sg13cmos5l_dfrbp_1_6.D a_9040_7894# 0
C18791 sg13cmos5l_dfrbp_1_8.RESET_B a_16204_4338# 0
C18792 sg13cmos5l_buf_8_0.X sg13cmos5l_buf_8_0.A 0.00116f
C18793 sg13cmos5l_buf_1_3.X a_20672_1758# 0.01136f
C18794 sg13cmos5l_dfrbp_1_6.RESET_B a_620_7638# 0.01207f
C18795 sg13cmos5l_o21ai_1_0.A1 sg13cmos5l_or2_1_0.A 0.31183f
C18796 a_6647_5459# a_7312_4142# 0
C18797 a_6741_5459# a_7055_4261# 0
C18798 a_3588_4968# a_3856_3358# 0
C18799 a_4005_4629# a_3599_3215# 0.0026f
C18800 a_12520_4782# a_11556_3904# 0
C18801 a_17780_8436# a_17751_7690# 0.00623f
C18802 sg13cmos5l_buf_1_30.X a_7095_1642# 0
C18803 a_12075_3911# VPWR 0.23318f
C18804 a_14996_5412# a_15110_5412# 0.00122f
C18805 sg13cmos5l_buf_1_31.X a_4873_3192# 0.01701f
C18806 sg13cmos5l_dfrbp_1_6.RESET_B pl_sw[3] 0
C18807 sg13cmos5l_dfrbp_1_8.RESET_B a_4736_5498# 0.0014f
C18808 a_7226_1636# a_7508_1948# 0.68988f
C18809 sg13cmos5l_buf_1_24.A sg13cmos5l_buf_1_28.X 0.00212f
C18810 sg13cmos5l_dfrbp_1_21.Q a_12815_4261# 0
C18811 sg13cmos5l_dfrbp_1_6.D sg13cmos5l_buf_1_25.A 0
C18812 sg13cmos5l_inv_1_14.A a_7504_8678# 0.00106f
C18813 sg13cmos5l_nand2_1_1.B a_11656_3176# 0.00137f
C18814 sg13cmos5l_inv_1_14.A a_6198_3120# 0
C18815 a_10010_9196# a_10473_9186# 0.13395f
C18816 a_9673_9240# a_10292_9508# 0.00161f
C18817 a_9879_9202# sg13cmos5l_dfrbp_1_6.RESET_B 0.00608f
C18818 a_13484_8400# VPWR 0.24849f
C18819 a_10473_9186# pl_sw[6] 0.00154f
C18820 a_11986_7674# sg13cmos5l_inv_1_29.Y 0
C18821 sg13cmos5l_inv_1_7.A sg13cmos5l_nand2_1_0.A 0.63949f
C18822 sg13cmos5l_dlhr_1_6.D a_12742_6175# 0
C18823 sg13cmos5l_dfrbp_1_22.D a_17108_7972# 0.02793f
C18824 sg13cmos5l_dfrbp_1_6.D a_14377_5770# 0
C18825 a_3976_9224# VPWR 0.24754f
C18826 sg13cmos5l_buf_1_79.X a_12567_7282# 0
C18827 sg13cmos5l_nor2b_1_0.Y a_11174_2826# 0.00178f
C18828 sg13cmos5l_buf_1_65.X sg13cmos5l_inv_1_17.A 0.05293f
C18829 sg13cmos5l_inv_1_14.A a_6891_4772# 0.01433f
C18830 sg13cmos5l_inv_1_2.A a_18363_4270# 0
C18831 sg13cmos5l_a22oi_1_1.B2 a_14152_5498# 0.01424f
C18832 sg13cmos5l_dfrbp_1_2.D a_10433_4248# 0
C18833 sg13cmos5l_nand2_1_1.B sg13cmos5l_a22oi_1_1.B1 0.57426f
C18834 sg13cmos5l_buf_1_43.A a_620_2352# 0.13518f
C18835 sg13cmos5l_buf_1_2.X a_15909_2399# 0.00623f
C18836 sg13cmos5l_buf_1_19.A a_18368_4782# 0
C18837 sg13cmos5l_inv_1_17.A a_5637_2399# 0
C18838 sg13cmos5l_buf_1_24.X a_6188_1590# 0.15149f
C18839 sg13cmos5l_dfrbp_1_9.Q a_3302_4650# 0.30078f
C18840 a_3562_4873# a_3588_4968# 0.43042f
C18841 sg13cmos5l_buf_1_31.X a_650_3900# 0
C18842 sg13cmos5l_inv_1_0.A sg13cmos5l_o21ai_1_0.A2 0.00469f
C18843 sg13cmos5l_dfrbp_1_22.Q_N VPWR 0.17778f
C18844 sg13cmos5l_inv_1_2.A a_13178_7684# 0
C18845 sg13cmos5l_inv_1_18.A sg13cmos5l_dfrbp_1_20.Q_N 0.39723f
C18846 sg13cmos5l_buf_1_77.A sg13cmos5l_dfrbp_1_18.Q 0.14826f
C18847 sg13cmos5l_dlhr_1_0.GATE sg13cmos5l_or2_1_0.A 0.02682f
C18848 a_17498_8800# a_17780_8436# 0.68988f
C18849 sg13cmos5l_buf_1_31.X sg13cmos5l_dlygate4sd3_1_0.X 0.03644f
C18850 sg13cmos5l_dlhr_1_9.D a_9456_4972# 0
C18851 sg13cmos5l_dfrbp_1_6.D a_5408_3986# 0.07214f
C18852 sg13cmos5l_or2_1_1.B a_12815_4261# 0
C18853 sg13cmos5l_inv_1_17.A nh_sw[1] 0.01145f
C18854 sg13cmos5l_dfrbp_1_18.Q a_8457_7281# 0.00965f
C18855 sg13cmos5l_a22oi_1_1.Y a_16940_3102# 0.02836f
C18856 sg13cmos5l_dlhr_1_11.Q a_13686_7354# 0.59316f
C18857 sg13cmos5l_dfrbp_1_6.RESET_B a_17972_4948# 0.02696f
C18858 sg13cmos5l_buf_1_111.A a_19340_8400# 0.03084f
C18859 sg13cmos5l_a221oi_1_0.C1 a_11372_3102# 0
C18860 nl_sw[4] nh_sw[3] 0.02369f
C18861 VPWR nh_sw[0] 0.21518f
C18862 sg13cmos5l_a22oi_1_1.A1 sg13cmos5l_nor2b_1_1.Y 0
C18863 a_8588_3864# sg13cmos5l_a22oi_1_0.Y 0
C18864 sg13cmos5l_buf_1_96.A sg13cmos5l_or2_1_1.B 0
C18865 sg13cmos5l_inv_1_8.A a_3313_4261# 0.00339f
C18866 sg13cmos5l_dfrbp_1_21.Q sg13cmos5l_a221oi_1_0.B1 0.02476f
C18867 sg13cmos5l_dlhr_1_1.D a_1862_4338# 0
C18868 a_3308_5376# a_2565_3911# 0
C18869 sg13cmos5l_dfrbp_1_15.D a_2224_7166# 0.01114f
C18870 sg13cmos5l_dfrbp_1_18.Q a_8985_7989# 0.00162f
C18871 sg13cmos5l_buf_1_43.A cks 0.07403f
C18872 sg13cmos5l_buf_1_40.A a_2224_7166# 0
C18873 sg13cmos5l_inv_1_17.A sg13cmos5l_dfrbp_1_9.Q_N 0.03201f
C18874 sg13cmos5l_dfrbp_1_6.RESET_B a_7508_1948# 0.12215f
C18875 a_16587_6935# a_16260_6480# 0
C18876 a_11072_5347# sg13cmos5l_o21ai_1_0.A1 0
C18877 sg13cmos5l_dlhr_1_0.GATE a_7820_2352# 0
C18878 a_6213_3911# a_6903_3154# 0.00881f
C18879 sg13cmos5l_buf_1_34.X a_4847_4727# 0.00852f
C18880 a_11877_2399# a_12976_2630# 0
C18881 a_11460_2392# a_12719_2749# 0.01741f
C18882 a_13284_3456# a_14543_3215# 0.01741f
C18883 sg13cmos5l_buf_1_61.X sg13cmos5l_inv_1_19.A 0.03574f
C18884 sg13cmos5l_dfrbp_1_20.Q a_10116_7674# 0
C18885 sg13cmos5l_dlhr_1_15.D a_10420_5412# 0
C18886 a_17882_7684# a_18096_7996# 0.01249f
C18887 sg13cmos5l_buf_1_10.A a_12625_2749# 0
C18888 sg13cmos5l_dfrbp_1_17.D VPWR 0.2527f
C18889 sg13cmos5l_dfrbp_1_0.CLK sg13cmos5l_buf_1_5.X 0.71111f
C18890 a_15590_4650# a_15821_3864# 0
C18891 a_2748_6126# a_2934_4632# 0
C18892 sg13cmos5l_a221oi_1_0.C1 a_10230_4632# 0.01364f
C18893 sg13cmos5l_buf_1_10.A a_10827_7796# 0
C18894 sg13cmos5l_dlhr_1_5.GATE a_7833_4965# 0
C18895 a_14426_7288# a_14822_6924# 0.00949f
C18896 a_1227_5423# a_1815_4666# 0
C18897 sg13cmos5l_dfrbp_1_0.RESET_B a_13572_3151# 0.0046f
C18898 sg13cmos5l_o21ai_1_0.B1 a_11372_3102# 0
C18899 sg13cmos5l_buf_1_8.X a_10707_2388# 0
C18900 a_7863_7282# sg13cmos5l_dlhr_1_5.D 0.00267f
C18901 a_7657_7282# a_7994_7288# 0.64635f
C18902 a_3962_7288# sg13cmos5l_inv_1_19.A 0.00107f
C18903 sg13cmos5l_dlhr_1_16.Q a_20488_5498# 0.05941f
C18904 a_708_5416# sg13cmos5l_inv_1_19.A 0.03818f
C18905 sg13cmos5l_dlhr_1_9.D a_8378_5776# 0.01005f
C18906 sg13cmos5l_buf_1_31.X a_8588_2352# 0
C18907 sg13cmos5l_buf_8_0.X sg13cmos5l_inv_1_5.A 0.01573f
C18908 sg13cmos5l_or2_1_1.B sg13cmos5l_a221oi_1_0.B1 0.08555f
C18909 sg13cmos5l_a221oi_1_1.C1 sg13cmos5l_nor2b_1_0.Y 0
C18910 sg13cmos5l_buf_1_87.A a_18860_6888# 0.34287f
C18911 sg13cmos5l_buf_1_5.A sg13cmos5l_dlhr_1_11.Q 0.42455f
C18912 sg13cmos5l_dfrbp_1_8.D a_16462_4338# 0
C18913 a_10473_9186# a_10708_9172# 0.00566f
C18914 a_10292_9508# a_10428_9222# 0.00404f
C18915 sg13cmos5l_dfrbp_1_6.RESET_B a_10225_9178# 0
C18916 a_9673_9240# sg13cmos5l_buf_1_90.X 0
C18917 a_11360_9318# pl_sw[6] 0
C18918 sg13cmos5l_dlhr_1_15.D a_13775_6239# 0
C18919 sg13cmos5l_inv_1_14.A sg13cmos5l_dlhr_1_0.D 0.19911f
C18920 sg13cmos5l_inv_1_18.A a_8746_8404# 0.00952f
C18921 a_11556_3904# a_12520_3176# 0
C18922 sg13cmos5l_inv_1_2.A a_16548_6175# 0.0241f
C18923 a_682_5380# sg13cmos5l_dlhr_1_1.D 0
C18924 VPWR ph_sw[0] 0.24838f
C18925 sg13cmos5l_a22oi_1_1.B1 sg13cmos5l_a22oi_1_1.A1 0.22862f
C18926 a_12361_7282# a_12912_6924# 0
C18927 sg13cmos5l_a221oi_1_0.A2 a_7055_4261# 0.00224f
C18928 a_20392_3176# d_out[1] 0.02017f
C18929 a_4005_4629# sg13cmos5l_dfrbp_1_10.Q_N 0
C18930 a_11913_3947# VPWR 0
C18931 sg13cmos5l_buf_1_30.X a_9164_1590# 0.01085f
C18932 sg13cmos5l_inv_1_7.A sg13cmos5l_dfrbp_1_1.Q 0.17352f
C18933 a_8660_5412# a_8468_4948# 0
C18934 sg13cmos5l_buf_1_31.X a_4018_3138# 0
C18935 sg13cmos5l_nor2b_1_1.Y nh_sw[8] 0
C18936 a_18615_5770# a_18961_5814# 0.00722f
C18937 sg13cmos5l_buf_1_34.X a_3669_6320# 0
C18938 sg13cmos5l_dfrbp_1_8.RESET_B sg13cmos5l_buf_1_62.X 0.00118f
C18939 a_7226_1636# a_7440_1948# 0.01249f
C18940 a_8680_1664# a_9164_1590# 0.03472f
C18941 sg13cmos5l_nor2_1_2.A nl_sw[0] 0
C18942 sg13cmos5l_dfrbp_1_21.Q sg13cmos5l_nand2_1_1.A 0
C18943 a_12814_4692# a_12075_3911# 0.00629f
C18944 sg13cmos5l_dfrbp_1_0.Q sg13cmos5l_buf_1_19.X 0.18801f
C18945 sg13cmos5l_dlhr_1_12.Q_N ph_sw[9] 0.05791f
C18946 a_2348_7624# cks 0.00202f
C18947 a_15590_4650# VPWR 0.92871f
C18948 sg13cmos5l_dfrbp_1_8.RESET_B a_10282_7897# 0
C18949 sg13cmos5l_dfrbp_1_6.D a_14996_5412# 0
C18950 a_11973_3911# VPWR 0.26669f
C18951 sg13cmos5l_dlhr_1_6.D sg13cmos5l_inv_1_0.A 0.00537f
C18952 sg13cmos5l_dfrbp_1_21.Q a_16293_4629# 0
C18953 sg13cmos5l_dlhr_1_12.D a_17894_8436# 0
C18954 sg13cmos5l_nor2b_1_0.Y a_11072_2474# 0.00128f
C18955 sg13cmos5l_dlhr_1_9.D a_3962_7288# 0
C18956 sg13cmos5l_dlhr_1_9.D a_708_5416# 0
C18957 a_8247_5770# sg13cmos5l_a221oi_1_1.C1 0
C18958 a_12651_9308# sg13cmos5l_buf_1_95.X 0.03029f
C18959 sg13cmos5l_dfrbp_1_15.D pl_sw[2] 0
C18960 a_14726_7674# ph_sw[6] 0
C18961 sg13cmos5l_buf_1_24.A sg13cmos5l_buf_1_30.A 0.075f
C18962 sg13cmos5l_a22oi_1_0.B1 sg13cmos5l_buf_1_9.A 0
C18963 sg13cmos5l_o21ai_1_0.B1 nh_sw[5] 0
C18964 sg13cmos5l_buf_1_44.X sg13cmos5l_dfrbp_1_8.RESET_B 0.07596f
C18965 sg13cmos5l_buf_1_31.X a_2054_3138# 0.02608f
C18966 sg13cmos5l_a22oi_1_1.B2 sg13cmos5l_dlhr_1_19.Q_N 0
C18967 sg13cmos5l_dfrbp_1_6.RESET_B a_10202_7288# 0.05815f
C18968 sg13cmos5l_buf_1_2.X a_17008_2630# 0
C18969 a_5425_3130# sg13cmos5l_buf_1_25.A 0
C18970 a_1760_1758# VPWR 0.06379f
C18971 sg13cmos5l_buf_1_57.X a_14889_7281# 0.01206f
C18972 sg13cmos5l_buf_1_25.A a_5194_2356# 0
C18973 sg13cmos5l_dfrbp_1_0.Q a_15466_2356# 0
C18974 sg13cmos5l_dfrbp_1_20.Q a_10420_5760# 0
C18975 a_6507_8447# a_7238_7674# 0
C18976 sg13cmos5l_dlhr_1_6.D a_12490_6385# 0.00171f
C18977 a_6117_6141# a_6086_4650# 0
C18978 sg13cmos5l_inv_1_8.A a_5600_8522# 0.0012f
C18979 sg13cmos5l_o21ai_1_0.A1 sg13cmos5l_dfrbp_1_2.D 0.05895f
C18980 a_10202_7288# a_10412_6126# 0.00105f
C18981 sg13cmos5l_dfrbp_1_21.Q_N a_20118_6144# 0
C18982 sg13cmos5l_buf_1_97.A a_13484_8400# 0
C18983 sg13cmos5l_inv_1_28.Y a_11272_8522# 0.0021f
C18984 sg13cmos5l_dfrbp_1_8.RESET_B a_2804_6924# 0
C18985 sg13cmos5l_dfrbp_1_1.Q a_20288_2474# 0.06094f
C18986 a_10071_7282# a_10202_7288# 0.65127f
C18987 a_4172_1590# nl_sw[3] 0
C18988 pl_sw[0] sg13cmos5l_buf_1_68.X 0.13938f
C18989 a_9705_4650# sg13cmos5l_a22oi_1_1.B1 0
C18990 sg13cmos5l_buf_1_77.A cks 0.027f
C18991 sg13cmos5l_buf_1_93.X a_16271_7751# 0
C18992 a_18278_8112# VPWR 0.00418f
C18993 ph_sw[4] pl_sw[5] 1.9966f
C18994 a_11567_7751# sg13cmos5l_inv_1_29.A 0.00832f
C18995 sg13cmos5l_inv_1_17.A a_3447_2746# 0.02993f
C18996 a_10587_4692# sg13cmos5l_a22oi_1_0.B1 0
C18997 sg13cmos5l_buf_1_46.A a_8588_3864# 0.32065f
C18998 sg13cmos5l_inv_1_8.A a_6346_4873# 0.02559f
C18999 sg13cmos5l_inv_1_0.A a_13698_5412# 0.00103f
C19000 a_8457_7281# cks 0
C19001 sg13cmos5l_or2_1_0.A sg13cmos5l_nor2b_1_1.Y 0
C19002 sg13cmos5l_dfrbp_1_8.D a_15974_6162# 0
C19003 a_17327_7285# a_17519_6239# 0.02016f
C19004 a_17584_7166# a_17776_6382# 0
C19005 sg13cmos5l_buf_1_4.A sg13cmos5l_nand2_1_1.B 0
C19006 sg13cmos5l_dlhr_1_11.Q a_13460_7996# 0.04483f
C19007 a_7055_4261# a_6697_3192# 0
C19008 a_7312_4142# a_7034_3148# 0
C19009 a_14543_3215# a_15380_3436# 0.1333f
C19010 sg13cmos5l_dlhr_1_9.D a_10420_5760# 0
C19011 sg13cmos5l_dfrbp_1_0.CLK a_15909_2399# 0.35895f
C19012 a_11979_2399# a_12719_2749# 0.3087f
C19013 sg13cmos5l_buf_1_74.X cks 0
C19014 a_6213_3911# a_5220_2392# 0
C19015 a_5796_3904# a_5637_2399# 0
C19016 sg13cmos5l_dfrbp_1_8.RESET_B a_16677_6141# 0
C19017 sg13cmos5l_dfrbp_1_6.RESET_B a_12520_4782# 0.00485f
C19018 sg13cmos5l_inv_1_8.A a_650_3900# 0.00134f
C19019 a_1192_1664# sg13cmos5l_buf_1_33.A 0
C19020 sg13cmos5l_buf_1_35.A a_1864_1664# 0.33695f
C19021 a_7863_7282# a_8041_5770# 0
C19022 a_10428_9222# sg13cmos5l_buf_1_90.X 0
C19023 sg13cmos5l_buf_1_29.A sg13cmos5l_buf_1_30.X 0.16288f
C19024 a_17894_8436# VPWR 0.00418f
C19025 a_8985_7989# cks 0
C19026 sg13cmos5l_dfrbp_1_23.CLK a_14152_8522# 0.0723f
C19027 sg13cmos5l_dlhr_1_15.Q sg13cmos5l_dlhr_1_15.Q_N 0.04659f
C19028 a_18870_7656# sg13cmos5l_buf_1_18.A 0
C19029 sg13cmos5l_dfrbp_1_15.D sg13cmos5l_dlhr_1_9.Q_N 0.00478f
C19030 a_17041_4727# sg13cmos5l_a22oi_1_1.A1 0.00287f
C19031 sg13cmos5l_inv_1_8.A sg13cmos5l_dlygate4sd3_1_0.X 0.0109f
C19032 a_2748_6126# sg13cmos5l_dfrbp_1_9.Q 0
C19033 a_15016_9224# ph_sw[8] 0
C19034 sg13cmos5l_buf_1_10.A a_11769_7989# 0
C19035 a_13484_8400# a_13047_7690# 0.00515f
C19036 a_13100_8400# a_12841_7728# 0
C19037 sg13cmos5l_buf_1_41.A a_3302_4650# 0.01312f
C19038 a_1227_5423# a_1472_4782# 0
C19039 sg13cmos5l_buf_1_29.A a_9660_4686# 0.00176f
C19040 sg13cmos5l_buf_1_94.X sg13cmos5l_dfrbp_1_23.CLK 0
C19041 a_2340_3456# a_2732_1590# 0
C19042 sg13cmos5l_dfrbp_1_6.RESET_B a_4840_1664# 0
C19043 sg13cmos5l_inv_1_18.A a_10220_3102# 0
C19044 sg13cmos5l_dfrbp_1_6.RESET_B a_4282_8112# 0
C19045 sg13cmos5l_buf_1_45.X a_7881_8065# 0
C19046 sg13cmos5l_buf_1_105.A VPWR 0.34912f
C19047 a_5510_4338# a_5079_3154# 0
C19048 sg13cmos5l_dfrbp_1_8.RESET_B a_14295_7282# 0.00333f
C19049 sg13cmos5l_inv_1_2.A sg13cmos5l_dfrbp_1_0.RESET_B 0
C19050 sg13cmos5l_dfrbp_1_4.D a_11268_2826# 0
C19051 a_12520_3176# a_12896_3270# 0.03376f
C19052 sg13cmos5l_inv_1_1.A a_15380_3436# 0
C19053 sg13cmos5l_dfrbp_1_8.D a_17399_3947# 0
C19054 sg13cmos5l_or2_1_0.A a_11656_3176# 0
C19055 sg13cmos5l_buf_1_5.A a_13652_3900# 0.00115f
C19056 sg13cmos5l_inv_1_3.A sg13cmos5l_dfrbp_1_24.Q_N 0
C19057 a_14632_9224# sg13cmos5l_dfrbp_1_23.CLK 0.11234f
C19058 sg13cmos5l_dlhr_1_0.GATE a_6660_4663# 0
C19059 a_18671_1703# nl_sw[9] 0.0331f
C19060 sg13cmos5l_inv_1_18.A a_10288_8678# 0
C19061 a_4640_3986# sg13cmos5l_buf_1_44.A 0
C19062 a_5132_3864# a_5770_3868# 0
C19063 a_15429_7653# sg13cmos5l_dlhr_1_13.Q_N 0.00188f
C19064 a_18363_4270# nl_sw[9] 0
C19065 a_14426_7288# a_14708_6924# 0.68988f
C19066 a_20200_3270# d_out[1] 0.01526f
C19067 sg13cmos5l_dfrbp_1_8.RESET_B a_12841_7728# 0
C19068 sg13cmos5l_dfrbp_1_6.RESET_B a_17882_7684# 0.06175f
C19069 sg13cmos5l_buf_1_30.X a_7441_1618# 0
C19070 sg13cmos5l_buf_1_65.X a_1484_9150# 0.00782f
C19071 sg13cmos5l_dfrbp_1_23.CLK sg13cmos5l_nand2_1_1.B 0
C19072 sg13cmos5l_buf_1_19.A sg13cmos5l_buf_1_18.X 0.04614f
C19073 a_8841_5769# sg13cmos5l_dfrbp_1_12.Q_N 0
C19074 sg13cmos5l_dfrbp_1_6.D a_7863_7282# 0.00266f
C19075 a_12998_3138# VPWR 0.94601f
C19076 sg13cmos5l_or2_1_0.A sg13cmos5l_a22oi_1_1.B1 0.74053f
C19077 sg13cmos5l_buf_1_77.A a_9524_4972# 0
C19078 a_20008_3900# d_out[2] 0.0029f
C19079 sg13cmos5l_inv_1_3.A sg13cmos5l_buf_1_10.A 0.00103f
C19080 sg13cmos5l_buf_1_58.A cks 0.00615f
C19081 sg13cmos5l_dfrbp_1_15.D a_4107_4772# 0
C19082 sg13cmos5l_nand2_1_1.B a_11434_2356# 0.00219f
C19083 a_17392_4870# VPWR 0.14588f
C19084 sg13cmos5l_dlhr_1_6.D a_9242_4660# 0
C19085 sg13cmos5l_dfrbp_1_6.D a_18409_5770# 0.02171f
C19086 sg13cmos5l_dfrbp_1_21.Q sg13cmos5l_dfrbp_1_0.D 0.01061f
C19087 sg13cmos5l_inv_1_6.A a_17700_3456# 0
C19088 sg13cmos5l_buf_1_2.X nh_sw[7] 0.03564f
C19089 sg13cmos5l_and3_1_0.C a_11556_3904# 0
C19090 a_12814_4692# a_11973_3911# 0
C19091 a_6507_8447# a_7336_7010# 0.00203f
C19092 a_18363_4270# a_19616_3986# 0.03811f
C19093 sg13cmos5l_buf_1_31.X a_3856_3358# 0.00986f
C19094 sg13cmos5l_dfrbp_1_6.RESET_B sg13cmos5l_dlhr_1_18.Q_N 0.01104f
C19095 sg13cmos5l_nand2_1_0.B a_11372_3102# 0.00243f
C19096 a_7689_1626# VPWR 0.62509f
C19097 sg13cmos5l_buf_1_4.A sg13cmos5l_a22oi_1_1.A1 0.02106f
C19098 sg13cmos5l_dfrbp_1_9.Q a_3814_4663# 0
C19099 sg13cmos5l_inv_1_2.A a_15012_7992# 0
C19100 sg13cmos5l_buf_1_25.A a_5739_2399# 0.02662f
C19101 sg13cmos5l_inv_1_29.A a_11752_6294# 0.0383f
C19102 sg13cmos5l_dlhr_1_6.D a_13775_6239# 0.00581f
C19103 a_6959_6239# a_6891_4772# 0
C19104 a_7216_6382# a_6789_4629# 0
C19105 sg13cmos5l_dlhr_1_6.Q_N sg13cmos5l_buf_1_29.A 0.01089f
C19106 sg13cmos5l_dfrbp_1_6.RESET_B a_16204_4338# 0.18223f
C19107 sg13cmos5l_buf_1_34.X sg13cmos5l_buf_1_39.A 0.29378f
C19108 sg13cmos5l_dfrbp_1_21.Q_N a_19828_6148# 0
C19109 sg13cmos5l_a22oi_1_1.A1 d_out[1] 0
C19110 sg13cmos5l_buf_1_34.X a_4559_7630# 0.02612f
C19111 sg13cmos5l_buf_1_5.A a_15124_7312# 0
C19112 sg13cmos5l_dfrbp_1_23.CLK a_12230_6162# 0.0032f
C19113 a_10484_6924# a_10665_7281# 0.40925f
C19114 sg13cmos5l_dfrbp_1_0.Q a_17386_1849# 0.01271f
C19115 sg13cmos5l_buf_1_76.X sg13cmos5l_dlhr_1_5.GATE 0
C19116 sg13cmos5l_dfrbp_1_23.Q a_13652_3900# 0
C19117 sg13cmos5l_and3_1_0.X a_14583_5770# 0
C19118 a_5210_3148# sg13cmos5l_buf_1_25.A 0
C19119 sg13cmos5l_dlhr_1_11.D sg13cmos5l_inv_1_29.A 0.20106f
C19120 sg13cmos5l_dfrbp_1_6.RESET_B a_4736_5498# 0.00114f
C19121 sg13cmos5l_inv_1_17.A a_3996_2790# 0.0023f
C19122 sg13cmos5l_buf_8_1.A a_17414_3138# 0
C19123 sg13cmos5l_inv_1_8.A a_6180_4650# 0
C19124 a_1862_4338# sg13cmos5l_inv_1_19.A 0.04506f
C19125 a_10230_4632# sg13cmos5l_nand2_1_0.B 0
C19126 a_10587_4692# sg13cmos5l_dlhr_1_20.Q_N 0.13821f
C19127 sg13cmos5l_dfrbp_1_15.D a_2879_6432# 0
C19128 sg13cmos5l_nand2_1_1.A a_17829_1605# 0
C19129 sg13cmos5l_dlhr_1_9.D a_9111_4666# 0.00252f
C19130 a_17327_7285# sg13cmos5l_dfrbp_1_21.Q_N 0
C19131 sg13cmos5l_dfrbp_1_8.D a_17776_6382# 0.00221f
C19132 sg13cmos5l_dlhr_1_21.Q_N VPWR 0.25903f
C19133 sg13cmos5l_dfrbp_1_8.RESET_B sg13cmos5l_dlhr_1_9.Q 0.31686f
C19134 sg13cmos5l_nand2_1_1.A a_17493_3947# 0
C19135 sg13cmos5l_buf_1_10.A a_12516_6480# 0.05743f
C19136 a_12719_2749# sg13cmos5l_dfrbp_1_4.Q_N 0.04107f
C19137 a_12625_2749# a_13138_2826# 0
C19138 sg13cmos5l_dfrbp_1_0.CLK a_17008_2630# 0.0047f
C19139 sg13cmos5l_inv_1_8.A a_2054_3138# 0
C19140 a_4041_2745# nl_sw[2] 0
C19141 a_10998_9168# a_10868_8436# 0
C19142 sg13cmos5l_inv_1_28.Y a_10031_8797# 0
C19143 sg13cmos5l_buf_1_45.X sg13cmos5l_buf_1_77.A 0.08551f
C19144 a_6213_3911# a_6736_2630# 0
C19145 sg13cmos5l_buf_1_18.A d_out[0] 0
C19146 sg13cmos5l_dlhr_1_11.Q ph_sw[5] 0
C19147 a_15045_8447# pl_sw[7] 0
C19148 a_6213_3911# sg13cmos5l_dfrbp_1_10.Q 0
C19149 sg13cmos5l_dfrbp_1_18.Q a_7994_7288# 0
C19150 sg13cmos5l_buf_1_111.A a_17961_8793# 0.00729f
C19151 a_13072_4142# sg13cmos5l_buf_1_8.A 0
C19152 a_524_4614# cks 0.02632f
C19153 sg13cmos5l_inv_1_17.A a_2859_3260# 0.00424f
C19154 a_11072_5347# sg13cmos5l_a22oi_1_1.B1 0
C19155 sg13cmos5l_nor2_1_0.A a_11556_3904# 0.00243f
C19156 sg13cmos5l_buf_1_45.X a_8457_7281# 0.01205f
C19157 a_10022_7674# a_11567_7751# 0
C19158 sg13cmos5l_dfrbp_1_0.CLK a_17126_1626# 0
C19159 sg13cmos5l_nand2_1_0.B nh_sw[5] 0.00257f
C19160 a_1864_1664# nh_sw[1] 0
C19161 pl_sw[1] a_1484_9150# 0.00586f
C19162 a_616_9224# sg13cmos5l_inv_1_19.A 0
C19163 a_7052_9150# sg13cmos5l_buf_1_73.A 0
C19164 sg13cmos5l_buf_1_74.X sg13cmos5l_buf_1_45.X 0.01821f
C19165 sg13cmos5l_inv_1_14.A a_7820_9150# 0
C19166 a_10024_5498# sg13cmos5l_a22oi_1_0.Y 0.00184f
C19167 a_11848_8436# ph_sw[5] -0
C19168 sg13cmos5l_buf_1_10.A cks 0.00905f
C19169 a_3599_3215# sg13cmos5l_buf_1_39.A 0
C19170 a_2340_3456# nl_sw[2] 0
C19171 a_17392_4870# a_17554_4650# 0.0019f
C19172 a_12815_4261# sg13cmos5l_a22oi_1_1.Y 0
C19173 a_5796_3904# a_5492_3460# 0
C19174 a_5408_3986# a_5210_3148# 0
C19175 a_12896_3270# a_12075_1748# 0
C19176 sg13cmos5l_buf_1_6.A a_13803_3260# 0
C19177 sg13cmos5l_buf_1_4.A nh_sw[8] 0.04042f
C19178 sg13cmos5l_buf_1_31.X sg13cmos5l_buf_1_28.X 0
C19179 sg13cmos5l_buf_1_2.A sg13cmos5l_buf_1_5.X 0.03357f
C19180 a_15702_5842# cks 0
C19181 sg13cmos5l_inv_1_8.A a_2228_4972# 0.00596f
C19182 sg13cmos5l_dfrbp_1_6.D a_5710_5535# 0.00135f
C19183 a_17751_7690# a_17882_7684# 0.65127f
C19184 sg13cmos5l_buf_1_76.X sg13cmos5l_inv_1_14.A 0.06506f
C19185 a_17638_1639# nl_sw[9] 0
C19186 sg13cmos5l_buf_1_18.A a_16751_2749# 0
C19187 sg13cmos5l_and3_1_0.C sg13cmos5l_dfrbp_1_0.Q 0
C19188 sg13cmos5l_buf_1_38.A a_6315_3911# 0
C19189 a_8784_6484# VPWR 0
C19190 a_2667_8447# a_3574_7850# 0.00421f
C19191 a_19628_2352# sg13cmos5l_buf_1_0.X 0.00132f
C19192 a_6372_4968# a_6213_3911# 0.00812f
C19193 a_6789_4629# a_5796_3904# 0.00308f
C19194 a_9865_7282# VPWR 0.40986f
C19195 nh_sw[5] nl_sw[6] 0.11676f
C19196 a_682_5380# sg13cmos5l_inv_1_19.A 0
C19197 a_14612_6460# a_15016_6294# 0.0303f
C19198 sg13cmos5l_dfrbp_1_6.D a_10725_7653# 0
C19199 sg13cmos5l_buf_1_8.X a_10613_2758# 0.00153f
C19200 sg13cmos5l_inv_1_2.A sg13cmos5l_dlhr_1_11.GATE 0.01669f
C19201 a_19734_5842# sg13cmos5l_dlhr_1_16.Q 0.59854f
C19202 sg13cmos5l_buf_1_18.A a_17412_1944# 0
C19203 sg13cmos5l_buf_1_104.A a_20392_7712# 0
C19204 a_14800_3358# VPWR 0.15578f
C19205 a_11464_9224# pl_sw[6] 0.0055f
C19206 a_9673_9240# a_10224_9508# 0
C19207 sg13cmos5l_nand2_1_1.B a_11748_2813# 0.00418f
C19208 sg13cmos5l_buf_1_0.A d_out[0] 0.01174f
C19209 sg13cmos5l_buf_1_77.A a_8084_8436# 0
C19210 sg13cmos5l_inv_1_6.A frame 0.17975f
C19211 sg13cmos5l_inv_1_26.Y a_19344_6484# 0
C19212 sg13cmos5l_buf_1_41.A a_2748_6126# 0.01786f
C19213 a_18117_3117# d_out[1] 0
C19214 sg13cmos5l_dlygate4sd3_1_0.X sg13cmos5l_buf_1_32.X 0.03574f
C19215 a_17498_8800# a_17882_7684# 0
C19216 sg13cmos5l_dlhr_1_12.D a_17545_7728# 0
C19217 sg13cmos5l_dfrbp_1_6.RESET_B a_12913_7326# 0
C19218 a_10888_1664# VPWR 0.25957f
C19219 sg13cmos5l_buf_1_74.X a_8084_8436# 0
C19220 a_16268_1590# nl_sw[8] 0.01823f
C19221 sg13cmos5l_nand2_1_1.B sg13cmos5l_buf_1_8.X 0.3043f
C19222 sg13cmos5l_inv_1_2.A a_17108_7972# 0.00325f
C19223 sg13cmos5l_buf_1_25.A a_6385_2749# 0.01378f
C19224 sg13cmos5l_buf_1_77.A sg13cmos5l_a22oi_1_2.B2 0.00763f
C19225 a_8772_8440# a_8043_7796# 0
C19226 sg13cmos5l_inv_1_26.Y a_20008_7712# 0
C19227 sg13cmos5l_buf_1_111.A sg13cmos5l_dlhr_1_15.Q_N 0
C19228 a_11488_4676# VPWR 0
C19229 sg13cmos5l_buf_1_10.A a_12358_5388# 0.00139f
C19230 a_7796_6460# a_7888_4870# 0
C19231 a_2248_9224# sg13cmos5l_inv_1_8.A 0
C19232 sg13cmos5l_or2_1_0.A a_6315_3911# 0.01448f
C19233 sg13cmos5l_buf_1_87.A sg13cmos5l_inv_1_6.A 0
C19234 a_15206_2826# a_15466_2356# 0.87117f
C19235 sg13cmos5l_dfrbp_1_6.RESET_B a_14814_3876# 0
C19236 sg13cmos5l_buf_1_4.A sg13cmos5l_or2_1_0.A 0.02541f
C19237 sg13cmos5l_dfrbp_1_21.Q a_12704_4782# 0
C19238 sg13cmos5l_buf_1_64.A VPWR 0.31161f
C19239 sg13cmos5l_nor2b_1_0.Y sg13cmos5l_dfrbp_1_4.D 0.1642f
C19240 sg13cmos5l_dfrbp_1_23.CLK a_14032_6382# 0.00128f
C19241 sg13cmos5l_nand2_1_0.A a_11364_4338# 0
C19242 a_10665_7281# a_10598_6924# 0
C19243 ckc sg13cmos5l_inv_1_19.A 0
C19244 sg13cmos5l_dfrbp_1_8.RESET_B a_2727_6380# 0.55134f
C19245 sg13cmos5l_dfrbp_1_6.RESET_B a_8570_6172# 0
C19246 sg13cmos5l_nand2_1_1.A a_19244_2352# 0
C19247 a_11174_2826# nh_sw[5] 0.05136f
C19248 sg13cmos5l_dlhr_1_9.D sg13cmos5l_dfrbp_1_10.Q 0
C19249 sg13cmos5l_nand2_1_1.A d_out[2] 0
C19250 sg13cmos5l_dfrbp_1_2.D sg13cmos5l_a22oi_1_1.B1 1.21611f
C19251 pl_sw[5] ph_sw[5] 0.09043f
C19252 cks rdy 0
C19253 sg13cmos5l_dlhr_1_4.Q_N sg13cmos5l_buf_1_25.A 0.00646f
C19254 sg13cmos5l_dfrbp_1_6.RESET_B a_18368_4782# 0
C19255 sg13cmos5l_dfrbp_1_7.Q_N sg13cmos5l_nor2b_1_1.Y 0.00181f
C19256 sg13cmos5l_dfrbp_1_6.RESET_B sg13cmos5l_buf_1_62.X 0
C19257 a_4456_1664# VPWR 0.2494f
C19258 sg13cmos5l_or2_1_0.A d_out[1] 0
C19259 a_3688_1664# a_3496_1758# 0.01225f
C19260 sg13cmos5l_buf_1_3.A sg13cmos5l_inv_1_6.A 0.33692f
C19261 a_15702_4187# a_15466_2356# 0
C19262 sg13cmos5l_buf_1_0.A a_17412_1944# 0.0032f
C19263 sg13cmos5l_dfrbp_1_0.CLK nh_sw[7] 0.43134f
C19264 sg13cmos5l_dfrbp_1_0.RESET_B nl_sw[9] 0.02026f
C19265 sg13cmos5l_dlhr_1_0.D nl_sw[4] 0.04911f
C19266 sg13cmos5l_inv_1_18.A sg13cmos5l_buf_1_79.X 0.37548f
C19267 sg13cmos5l_dfrbp_1_0.D a_17588_2388# 0
C19268 a_20008_7712# sg13cmos5l_dlhr_1_10.Q 0
C19269 sg13cmos5l_buf_8_0.X a_19528_6924# 0
C19270 sg13cmos5l_buf_1_18.A a_19424_7010# 0.00133f
C19271 a_8233_6216# a_8784_6484# 0
C19272 sg13cmos5l_dlhr_1_9.D sg13cmos5l_inv_1_0.Y 0
C19273 sg13cmos5l_nor2_1_0.A a_12896_3270# 0
C19274 sg13cmos5l_dfrbp_1_6.RESET_B a_10282_7897# 0.36701f
C19275 sg13cmos5l_dfrbp_1_18.Q a_10665_8065# 0
C19276 sg13cmos5l_dfrbp_1_0.CLK a_18376_2388# 0.02777f
C19277 sg13cmos5l_dfrbp_1_4.Q_N sg13cmos5l_nor2_1_1.A 0
C19278 sg13cmos5l_inv_1_3.A sg13cmos5l_nor2b_1_0.Y 0.01004f
C19279 a_9344_7010# a_9033_6162# 0
C19280 a_8784_6484# sg13cmos5l_dfrbp_1_11.Q 0
C19281 sg13cmos5l_inv_1_28.Y a_11848_8436# 0.02664f
C19282 a_7055_4261# a_6479_2749# 0
C19283 a_7631_4727# sg13cmos5l_buf_1_25.A 0
C19284 a_14814_3876# a_14543_3215# 0
C19285 sg13cmos5l_dfrbp_1_6.Q_N sg13cmos5l_buf_1_5.X 0.00185f
C19286 a_7892_3900# sg13cmos5l_dfrbp_1_10.Q 0
C19287 sg13cmos5l_dfrbp_1_0.Q a_14440_1664# 0
C19288 sg13cmos5l_inv_1_26.Y a_19624_8436# 0.0497f
C19289 sg13cmos5l_inv_1_17.A a_2628_3151# 0
C19290 sg13cmos5l_dfrbp_1_0.D a_17829_1605# 0.0206f
C19291 sg13cmos5l_buf_1_74.X sg13cmos5l_dfrbp_1_20.Q_N 0
C19292 sg13cmos5l_buf_1_44.X sg13cmos5l_dfrbp_1_6.RESET_B 0.2063f
C19293 a_17972_4948# a_17399_3947# 0
C19294 sg13cmos5l_dfrbp_1_0.D a_17493_3947# 0.00331f
C19295 a_10308_7992# a_11473_7751# 0.4858f
C19296 a_10827_7796# a_10596_7687# 0.15089f
C19297 sg13cmos5l_buf_1_5.A pl_sw[6] 0.00232f
C19298 sg13cmos5l_buf_1_58.A a_422_7362# 0
C19299 a_17545_7728# VPWR 0.41104f
C19300 sg13cmos5l_dfrbp_1_0.CLK a_18928_1846# 0
C19301 sg13cmos5l_buf_1_116.A a_14996_5412# 0
C19302 a_15208_6200# a_15177_5769# 0
C19303 sg13cmos5l_inv_1_8.A a_2148_8440# 0.1001f
C19304 sg13cmos5l_or2_1_1.B a_12704_4782# 0
C19305 a_10282_7897# a_10071_7282# 0
C19306 sg13cmos5l_inv_1_0.A a_13486_5760# 0
C19307 sg13cmos5l_dfrbp_1_6.RESET_B a_9260_2352# 0
C19308 sg13cmos5l_buf_1_2.A a_15909_2399# 0.00142f
C19309 a_7994_7288# cks 0
C19310 a_908_1590# sg13cmos5l_buf_1_33.A 0
C19311 sg13cmos5l_dfrbp_1_10.Q_N sg13cmos5l_buf_1_39.A 0
C19312 sg13cmos5l_dlhr_1_9.D a_6372_4968# 0.00649f
C19313 sg13cmos5l_nand2_1_1.A sg13cmos5l_a22oi_1_1.Y 0.00695f
C19314 a_6213_3911# sg13cmos5l_dlhr_1_2.D 0
C19315 sg13cmos5l_buf_1_6.A sg13cmos5l_buf_1_5.X 0.04833f
C19316 a_13284_3456# a_13652_1924# 0
C19317 sg13cmos5l_nand2_1_0.A nl_sw[5] 0
C19318 sg13cmos5l_buf_1_44.A a_4934_2826# 0
C19319 sg13cmos5l_dfrbp_1_6.RESET_B a_2804_6924# 0.05017f
C19320 sg13cmos5l_dfrbp_1_6.RESET_B sg13cmos5l_and3_1_0.C 0
C19321 sg13cmos5l_dlhr_1_0.GATE nl_sw[3] 0
C19322 sg13cmos5l_inv_1_8.A a_416_3986# 0
C19323 a_5069_5376# sg13cmos5l_dfrbp_1_29.Q_N 0.04107f
C19324 sg13cmos5l_inv_1_2.A a_7524_7992# 0
C19325 sg13cmos5l_dfrbp_1_6.RESET_B a_2583_7710# 0.00152f
C19326 a_19624_8436# sg13cmos5l_dlhr_1_10.Q 0
C19327 a_18345_7674# sg13cmos5l_dlhr_1_15.Q 0.29813f
C19328 sg13cmos5l_inv_1_8.A a_3562_4873# 0.02875f
C19329 sg13cmos5l_a221oi_1_1.C1 a_12616_5498# 0
C19330 sg13cmos5l_buf_1_18.A a_18760_2388# 0.00473f
C19331 sg13cmos5l_dfrbp_1_15.D a_2790_7996# 0
C19332 a_16293_4629# sg13cmos5l_a22oi_1_1.Y 0
C19333 a_4244_8436# a_4349_7636# 0.00441f
C19334 a_14602_8404# a_15045_8447# 0.02241f
C19335 sg13cmos5l_dfrbp_1_0.CLK a_15357_1816# 0
C19336 sg13cmos5l_buf_1_3.A a_20204_5376# 0
C19337 a_16177_7751# a_16068_6928# 0
C19338 a_16271_7751# a_16587_6935# 0
C19339 sg13cmos5l_buf_1_5.A a_13803_3260# 0.01227f
C19340 a_15300_2826# VPWR 0
C19341 a_6789_4629# a_7055_4261# 0.01343f
C19342 sg13cmos5l_a221oi_1_1.C1 a_10230_4632# 0
C19343 a_6891_4772# a_7312_4142# 0
C19344 sg13cmos5l_dfrbp_1_1.Q sg13cmos5l_buf_1_2.X 0.02275f
C19345 a_10900_7312# VPWR 0
C19346 sg13cmos5l_buf_1_34.X pl_sw[4] 0
C19347 sg13cmos5l_dfrbp_1_8.RESET_B a_14726_7674# 0.01744f
C19348 a_18278_8112# ph_sw[9] 0
C19349 sg13cmos5l_dfrbp_1_6.D a_12404_7972# 0
C19350 sg13cmos5l_dfrbp_1_8.RESET_B a_5049_4965# 0.00343f
C19351 sg13cmos5l_buf_1_9.A a_10707_2388# 0.00109f
C19352 a_7336_9224# a_7238_7674# 0
C19353 a_15110_5412# sg13cmos5l_a22oi_1_1.A1 0
C19354 sg13cmos5l_dlhr_1_12.D VPWR 0.42281f
C19355 sg13cmos5l_buf_1_30.A sg13cmos5l_buf_1_31.X 0.01922f
C19356 sg13cmos5l_buf_1_90.X a_12980_6924# 0
C19357 a_13017_1941# VPWR 0
C19358 sg13cmos5l_dlhr_1_10.Q a_19227_4654# 0
C19359 sg13cmos5l_dfrbp_1_6.RESET_B a_16677_6141# 0.06622f
C19360 a_15821_3864# VPWR 0.26139f
C19361 sg13cmos5l_dfrbp_1_9.Q nl_sw[2] 0
C19362 a_12516_6480# sg13cmos5l_nor2b_1_0.Y 0
C19363 sg13cmos5l_dfrbp_1_8.RESET_B a_8660_5412# 0
C19364 sg13cmos5l_and3_1_0.C a_14543_3215# 0
C19365 a_12549_9165# sg13cmos5l_dfrbp_1_23.CLK 0
C19366 a_13648_9406# a_13593_9501# 0.00464f
C19367 a_4244_3900# sg13cmos5l_buf_1_44.A 0
C19368 sg13cmos5l_dfrbp_1_21.Q a_16572_4261# 0
C19369 a_2148_8440# a_1948_7964# 0
C19370 sg13cmos5l_buf_1_77.A a_8746_8404# 0.03313f
C19371 a_8972_9150# a_8772_8440# 0
C19372 a_14986_7897# sg13cmos5l_buf_1_89.A 0
C19373 a_15012_7992# a_14889_7281# 0.01079f
C19374 sg13cmos5l_inv_1_3.A a_14342_8874# 0.0379f
C19375 a_5820_5773# VPWR 0.07212f
C19376 sg13cmos5l_buf_1_31.X comp_p 0.00161f
C19377 sg13cmos5l_buf_1_3.X d_out[1] 0.05719f
C19378 a_8746_8404# a_8457_7281# 0
C19379 a_3831_7282# a_4244_6924# 0.15652f
C19380 sg13cmos5l_buf_1_28.A a_9448_1664# 0.32537f
C19381 sg13cmos5l_dfrbp_1_6.RESET_B a_14295_7282# 0.00429f
C19382 sg13cmos5l_buf_1_64.A a_5132_9150# 0.29592f
C19383 a_8576_1758# VPWR 0.0726f
C19384 sg13cmos5l_o21ai_1_0.A1 a_13072_4142# 0
C19385 sg13cmos5l_dfrbp_1_0.Q sg13cmos5l_buf_1_18.X 0.47414f
C19386 sg13cmos5l_buf_1_24.A sg13cmos5l_buf_1_30.X 0
C19387 a_10433_4248# a_10331_3900# 0
C19388 sg13cmos5l_dfrbp_1_0.RESET_B a_11530_3868# 0.35547f
C19389 sg13cmos5l_buf_1_105.A ph_sw[9] 0.06471f
C19390 a_8772_8440# a_9620_7972# 0
C19391 sg13cmos5l_nand2_1_1.B a_10094_2780# 0.00126f
C19392 sg13cmos5l_dfrbp_1_6.RESET_B sg13cmos5l_nor2_1_0.A 0.00112f
C19393 sg13cmos5l_or2_1_0.A a_8588_3864# 0.00169f
C19394 a_15206_2826# a_15780_2813# 0.36169f
C19395 a_17519_6239# sg13cmos5l_dfrbp_1_0.D 0
C19396 sg13cmos5l_buf_1_0.A a_18760_2388# 0.04489f
C19397 sg13cmos5l_nand2_1_0.A sg13cmos5l_dfrbp_1_0.CLK 0.05134f
C19398 sg13cmos5l_dfrbp_1_0.Q a_17700_1639# 0
C19399 sg13cmos5l_dfrbp_1_6.RESET_B a_12841_7728# 0
C19400 sg13cmos5l_dfrbp_1_8.RESET_B a_3530_6320# 0
C19401 a_11072_2474# nh_sw[5] 0.00128f
C19402 sg13cmos5l_dlhr_1_11.GATE a_12716_8400# 0.0029f
C19403 sg13cmos5l_dfrbp_1_8.RESET_B a_1227_5423# 0.00234f
C19404 sg13cmos5l_buf_1_25.X a_7689_1626# 0
C19405 VPWR nl_sw[7] 0.11218f
C19406 a_1088_7806# sg13cmos5l_buf_1_68.X 0
C19407 sg13cmos5l_buf_1_0.A a_19508_1924# 0.01421f
C19408 sg13cmos5l_dfrbp_1_6.Q_N a_15909_2399# 0
C19409 sg13cmos5l_dfrbp_1_6.D sg13cmos5l_dlhr_1_3.Q_N 0.11097f
C19410 sg13cmos5l_buf_1_101.X a_16528_7894# 0
C19411 sg13cmos5l_inv_1_1.A a_16677_6141# 0
C19412 a_8852_6484# sg13cmos5l_buf_1_29.A 0
C19413 a_9558_6144# sg13cmos5l_dlhr_1_6.Q_N 0.12876f
C19414 a_11567_7751# a_11752_6294# 0
C19415 sg13cmos5l_nor2_1_0.A a_14543_3215# 0
C19416 a_1862_8874# ph_sw[1] 0
C19417 a_18164_6924# sg13cmos5l_dlhr_1_10.Q 0
C19418 a_16552_1664# a_17386_1849# 0.00224f
C19419 a_8296_3986# sg13cmos5l_dfrbp_1_10.Q 0
C19420 a_16204_4338# a_16462_4338# 0.01017f
C19421 a_15821_3864# a_16551_3987# 0.3087f
C19422 sg13cmos5l_dfrbp_1_8.RESET_B a_17529_7047# 0.00343f
C19423 a_6903_3154# a_7034_3148# 0.65127f
C19424 a_11824_7894# a_11473_7751# 0.01017f
C19425 a_11567_7751# sg13cmos5l_dlhr_1_11.D 0.05585f
C19426 sg13cmos5l_inv_1_17.A sg13cmos5l_buf_1_41.X 0.09232f
C19427 sg13cmos5l_dfrbp_1_0.CLK a_18577_1703# 0
C19428 a_13284_3456# sg13cmos5l_buf_1_8.A 0
C19429 sg13cmos5l_buf_1_6.A a_15909_2399# 0
C19430 sg13cmos5l_dfrbp_1_1.Q nl_sw[5] 0.0449f
C19431 a_13593_9501# ph_sw[6] 0
C19432 sg13cmos5l_a221oi_1_0.B1 a_11394_4948# 0.0209f
C19433 a_12106_9409# sg13cmos5l_dlhr_1_11.GATE 0.0025f
C19434 a_10587_4692# sg13cmos5l_a22oi_1_0.Y 0.00213f
C19435 sg13cmos5l_inv_1_8.A a_4244_8436# 0.00783f
C19436 a_10665_8065# cks 0
C19437 sg13cmos5l_buf_1_57.X a_11190_7354# 0
C19438 a_9242_4660# a_9456_4972# 0.01249f
C19439 sg13cmos5l_dlhr_1_9.D a_7888_4870# 0.0044f
C19440 a_17516_9150# ph_sw[8] 0.00581f
C19441 sg13cmos5l_dfrbp_1_8.RESET_B a_3676_7964# 0.01083f
C19442 sg13cmos5l_buf_1_6.A a_12721_1703# 0
C19443 a_14543_3215# a_14440_1664# 0
C19444 sg13cmos5l_dfrbp_1_6.D a_3407_4261# 0
C19445 a_11556_1944# a_11844_1639# 0.4806f
C19446 sg13cmos5l_nor2b_1_0.Y a_12358_5388# 0
C19447 a_14342_8874# cks 0.02177f
C19448 sg13cmos5l_dlygate4sd2_1_0.A sg13cmos5l_inv_1_19.A 0
C19449 sg13cmos5l_buf_1_5.A a_10484_6924# 0
C19450 sg13cmos5l_dfrbp_1_6.D a_12230_6162# 0.01653f
C19451 a_5820_5773# sg13cmos5l_dfrbp_1_11.Q 0.0039f
C19452 a_5546_5850# a_5710_5850# 0
C19453 sg13cmos5l_inv_1_2.A a_8783_7751# 0
C19454 sg13cmos5l_dfrbp_1_0.D a_16268_1590# 0
C19455 sg13cmos5l_dfrbp_1_6.RESET_B a_1878_6337# 0.00288f
C19456 a_5800_9224# ph_sw[3] 0.12542f
C19457 sg13cmos5l_dfrbp_1_0.D sg13cmos5l_a22oi_1_1.Y 0.04248f
C19458 sg13cmos5l_buf_1_45.X a_7994_7288# 0.06704f
C19459 sg13cmos5l_dfrbp_1_15.D sg13cmos5l_dfrbp_1_16.Q_N 1.02326f
C19460 a_14628_8440# a_15887_8797# 0.01741f
C19461 a_14854_8861# a_14916_8861# 0
C19462 a_15045_8447# a_16144_8678# 0
C19463 sg13cmos5l_dlhr_1_15.D a_16587_6935# 0.03295f
C19464 sg13cmos5l_inv_1_6.A a_19593_6162# 0.02196f
C19465 sg13cmos5l_buf_1_5.A sg13cmos5l_buf_1_5.X 0.11609f
C19466 a_7888_4870# a_7892_3900# 0
C19467 a_1125_5423# a_1402_3864# 0.0022f
C19468 sg13cmos5l_buf_1_79.X sg13cmos5l_buf_1_95.X 0.01751f
C19469 sg13cmos5l_buf_1_40.A sg13cmos5l_dfrbp_1_16.Q_N 0
C19470 a_12698_7288# VPWR 0.35647f
C19471 sg13cmos5l_dfrbp_1_16.Q a_7378_6162# 0
C19472 sg13cmos5l_dfrbp_1_9.Q sg13cmos5l_buf_1_25.A 0
C19473 sg13cmos5l_dfrbp_1_8.RESET_B a_16528_7894# 0
C19474 a_3831_7282# cks 0
C19475 sg13cmos5l_dfrbp_1_16.Q a_10417_7326# 0
C19476 a_2757_3117# sg13cmos5l_buf_1_33.A 0
C19477 sg13cmos5l_inv_1_18.A sg13cmos5l_inv_1_11.Y 0
C19478 sg13cmos5l_buf_1_94.X a_15147_8447# 0
C19479 sg13cmos5l_dlhr_1_16.Q sg13cmos5l_a22oi_1_1.A1 0.00236f
C19480 sg13cmos5l_dfrbp_1_6.RESET_B sg13cmos5l_dlhr_1_9.Q 0.14093f
C19481 sg13cmos5l_buf_1_44.A a_5079_3154# 0.00618f
C19482 sg13cmos5l_o21ai_1_0.Y a_12896_3270# 0.06996f
C19483 a_7498_7897# cks 0.00107f
C19484 a_15439_1630# VPWR 0
C19485 a_1125_5423# a_1609_4704# 0
C19486 a_15439_1630# nl_sw[7] 0
C19487 sg13cmos5l_dfrbp_1_6.RESET_B a_17721_6477# 0.00491f
C19488 a_422_7362# rdy 0
C19489 sg13cmos5l_buf_1_44.X a_5452_5850# 0.00394f
C19490 sg13cmos5l_inv_1_17.A sg13cmos5l_nor2_1_2.A 0
C19491 a_16551_3987# VPWR 0.2132f
C19492 a_20392_2388# d_out[1] 0.00251f
C19493 sg13cmos5l_or2_1_0.A sg13cmos5l_buf_1_8.X 0
C19494 sg13cmos5l_dfrbp_1_21.Q a_16703_3871# 0
C19495 a_2122_8404# sg13cmos5l_buf_1_58.A 0
C19496 a_2667_8447# a_2621_7636# 0
C19497 sg13cmos5l_and3_1_0.C a_15702_4187# 0.13336f
C19498 sg13cmos5l_inv_1_27.Y sg13cmos5l_dfrbp_1_23.CLK 2.35969f
C19499 sg13cmos5l_buf_1_77.A a_10288_8678# 0
C19500 a_8233_6216# VPWR 0.40895f
C19501 sg13cmos5l_buf_1_45.X sg13cmos5l_dlhr_1_2.Q_N 0.00992f
C19502 sg13cmos5l_dfrbp_1_6.D sg13cmos5l_a22oi_1_1.A1 0.02518f
C19503 sg13cmos5l_inv_1_3.A a_14916_8861# 0.01835f
C19504 sg13cmos5l_dfrbp_1_1.Q a_13258_3361# 0.00151f
C19505 sg13cmos5l_dfrbp_1_11.Q VPWR 0.91358f
C19506 a_13775_6239# a_13977_6477# 0.00675f
C19507 a_13035_6284# a_13681_6239# 0.00667f
C19508 sg13cmos5l_buf_1_90.X a_13178_7684# 0
C19509 sg13cmos5l_dfrbp_1_0.RESET_B a_12022_3134# 0.00194f
C19510 a_4244_6924# a_4425_7281# 0.40925f
C19511 sg13cmos5l_dfrbp_1_16.Q a_4076_5376# 0.00811f
C19512 a_18865_3215# a_19378_3138# 0
C19513 sg13cmos5l_buf_1_30.A a_6219_6284# 0
C19514 sg13cmos5l_dfrbp_1_21.Q a_18574_5028# 0
C19515 sg13cmos5l_inv_1_20.Y sg13cmos5l_inv_1_19.A 0
C19516 sg13cmos5l_a221oi_1_0.A2 a_8905_4704# 0.00336f
C19517 a_422_5850# sg13cmos5l_dlhr_1_1.D 0.00144f
C19518 sg13cmos5l_buf_1_97.A a_10900_7312# 0
C19519 a_11973_1605# VPWR 0.26616f
C19520 a_15684_4650# sg13cmos5l_dfrbp_1_0.RESET_B 0
C19521 sg13cmos5l_o21ai_1_0.A1 sg13cmos5l_dfrbp_1_2.Q_N 0
C19522 sg13cmos5l_dfrbp_1_0.CLK sg13cmos5l_dfrbp_1_1.Q 0.08753f
C19523 sg13cmos5l_dfrbp_1_9.Q a_5408_3986# 0
C19524 sg13cmos5l_buf_1_57.X sg13cmos5l_dfrbp_1_21.Q 0.09938f
C19525 a_19593_6162# a_20204_5376# 0.0037f
C19526 sg13cmos5l_dlygate4sd3_1_0.X a_416_2474# 0
C19527 a_15909_2399# a_16751_2749# 0.0032f
C19528 a_15206_2826# a_15849_2435# 0.00806f
C19529 sg13cmos5l_dfrbp_1_21.Q_N sg13cmos5l_dfrbp_1_0.D 0
C19530 a_5132_9150# VPWR 0.24743f
C19531 sg13cmos5l_inv_1_8.A sg13cmos5l_buf_1_30.A 0.1788f
C19532 a_12567_7282# a_12980_6924# 0.15652f
C19533 sg13cmos5l_o21ai_1_0.A1 a_10331_3900# 0
C19534 sg13cmos5l_dfrbp_1_6.RESET_B a_11986_7674# 0
C19535 a_7247_8797# sg13cmos5l_dlhr_1_5.D 0
C19536 sg13cmos5l_dfrbp_1_8.RESET_B a_5414_6162# 0.00255f
C19537 sg13cmos5l_dfrbp_1_6.RESET_B a_2161_4642# 0
C19538 a_6741_5459# a_6789_4629# 0.00406f
C19539 ph_sw[8] pl_sw[10] 0.01058f
C19540 ph_sw[5] pl_sw[6] 0.99924f
C19541 a_10010_9196# ph_sw[5] 0.00113f
C19542 sg13cmos5l_nand2_1_0.B sg13cmos5l_buf_1_28.X 0
C19543 sg13cmos5l_a22oi_1_0.Y sg13cmos5l_dfrbp_1_1.D 0
C19544 a_3692_9150# a_3976_9224# 0.13542f
C19545 sg13cmos5l_dfrbp_1_10.Q a_8392_3270# 0.00232f
C19546 sg13cmos5l_buf_1_0.A sg13cmos5l_dfrbp_1_0.Q_N 0.00456f
C19547 sg13cmos5l_dlhr_1_2.Q_N a_8204_2352# 0
C19548 sg13cmos5l_dfrbp_1_6.D a_3974_2388# 0
C19549 sg13cmos5l_buf_1_111.A a_18345_7674# 0
C19550 a_1967_7285# VPWR 0.27071f
C19551 sg13cmos5l_buf_1_41.A nl_sw[2] 0.00225f
C19552 sg13cmos5l_inv_1_29.A sg13cmos5l_inv_1_29.Y 0.0926f
C19553 a_12814_4692# VPWR 0.23615f
C19554 sg13cmos5l_buf_1_24.A sg13cmos5l_buf_1_24.X 0.00182f
C19555 sg13cmos5l_dfrbp_1_8.RESET_B a_7238_7674# 0.02012f
C19556 sg13cmos5l_inv_1_18.A a_9673_9240# 0.00113f
C19557 a_2374_8861# sg13cmos5l_inv_1_19.A 0
C19558 sg13cmos5l_buf_1_60.A a_4559_7630# 0.00236f
C19559 sg13cmos5l_dfrbp_1_6.D a_9705_4650# 0
C19560 sg13cmos5l_dlhr_1_15.D a_12075_3911# 0
C19561 sg13cmos5l_inv_1_29.A ph_sw[6] 0
C19562 a_16572_4261# a_17493_3947# 0.43042f
C19563 a_15821_3864# a_16462_4023# 0.00675f
C19564 sg13cmos5l_buf_1_57.X sg13cmos5l_or2_1_1.B 0.00145f
C19565 sg13cmos5l_inv_1_17.A sg13cmos5l_dfrbp_1_8.RESET_B 1.15757f
C19566 sg13cmos5l_dfrbp_1_15.D a_4311_7710# 0
C19567 a_6405_8447# sg13cmos5l_dfrbp_1_6.D 0.00441f
C19568 a_7052_9150# pl_sw[3] 0
C19569 sg13cmos5l_buf_1_2.A nh_sw[7] 0.70228f
C19570 sg13cmos5l_buf_1_25.X a_4456_1664# 0.32261f
C19571 a_10596_7687# cks 0.00151f
C19572 sg13cmos5l_buf_1_60.X a_4349_7636# 0
C19573 sg13cmos5l_buf_1_45.X a_8247_5770# 0.06551f
C19574 a_16260_6480# VPWR 0.08938f
C19575 a_8439_6178# a_8570_6172# 0.65127f
C19576 sg13cmos5l_dlhr_1_9.D sg13cmos5l_dfrbp_1_12.Q_N 0.02765f
C19577 a_4934_2826# a_5028_2826# 0.00718f
C19578 sg13cmos5l_buf_1_97.A VPWR 0.32562f
C19579 sg13cmos5l_inv_1_2.A a_12420_9199# 0.00314f
C19580 a_8233_6216# sg13cmos5l_dfrbp_1_11.Q 0
C19581 a_12815_1703# a_12721_1703# 0.32273f
C19582 sg13cmos5l_dfrbp_1_6.D sg13cmos5l_buf_1_38.A 0.06205f
C19583 a_16779_6284# sg13cmos5l_dfrbp_1_21.Q 0.00175f
C19584 a_14916_8861# cks 0.00426f
C19585 sg13cmos5l_a221oi_1_0.C1 a_11270_4338# 0
C19586 a_14814_4292# sg13cmos5l_buf_1_5.X 0
C19587 sg13cmos5l_a22oi_1_1.Y a_15884_3102# 0
C19588 sg13cmos5l_dfrbp_1_6.D a_14032_6382# 0.00426f
C19589 a_8041_5770# sg13cmos5l_or2_1_0.A 0
C19590 sg13cmos5l_inv_1_26.Y a_18486_8866# 0
C19591 sg13cmos5l_inv_1_2.A sg13cmos5l_dfrbp_1_20.Q 0
C19592 sg13cmos5l_dfrbp_1_6.RESET_B a_2727_6380# 0.0248f
C19593 a_15045_8447# sg13cmos5l_dfrbp_1_22.D 0
C19594 a_15147_8447# a_15793_8797# 0.00667f
C19595 sg13cmos5l_inv_1_3.A a_12933_6141# 0.00357f
C19596 sg13cmos5l_dlhr_1_15.D sg13cmos5l_dfrbp_1_22.Q_N 0.0022f
C19597 sg13cmos5l_buf_1_35.A nh_sw[1] 0.00245f
C19598 a_17170_2826# VPWR 0
C19599 sg13cmos5l_buf_1_93.X pl_sw[7] 0.01534f
C19600 sg13cmos5l_dfrbp_1_12.Q_N a_7892_3900# 0.26132f
C19601 sg13cmos5l_dlhr_1_11.Q_N VPWR 0.2592f
C19602 a_18345_7674# a_17519_6239# 0.00157f
C19603 sg13cmos5l_buf_1_68.X sg13cmos5l_inv_1_19.A 0.06477f
C19604 sg13cmos5l_dfrbp_1_6.D a_2148_3904# 0.05566f
C19605 sg13cmos5l_inv_1_0.A a_13076_5376# 0.34422f
C19606 a_4425_7281# cks 0.00486f
C19607 a_16068_6928# sg13cmos5l_buf_1_4.A 0
C19608 sg13cmos5l_dfrbp_1_16.Q a_10416_6924# 0
C19609 a_10024_5498# a_9705_4650# 0.00619f
C19610 sg13cmos5l_inv_1_0.A a_9111_4666# 0
C19611 a_17132_9150# sg13cmos5l_dfrbp_1_22.D 0
C19612 sg13cmos5l_buf_1_73.A a_7812_7687# 0.00152f
C19613 sg13cmos5l_dlhr_1_17.Q_N VPWR 0.25203f
C19614 sg13cmos5l_o21ai_1_0.Y a_14543_3215# 0
C19615 a_11270_1626# a_11913_2017# 0.00806f
C19616 a_11556_1944# a_12075_1748# 0.38902f
C19617 sg13cmos5l_dlhr_1_1.D sg13cmos5l_nand2_1_2.B 0
C19618 a_17769_2017# VPWR 0
C19619 a_16462_4023# VPWR 0
C19620 a_3016_9318# sg13cmos5l_buf_1_62.X 0.00349f
C19621 a_14228_9484# pl_sw[7] 0
C19622 sg13cmos5l_buf_1_105.A a_18860_6888# 0
C19623 sg13cmos5l_buf_1_2.A a_15357_1816# 0.02355f
C19624 sg13cmos5l_inv_1_7.A sg13cmos5l_buf_1_7.A 0.05782f
C19625 sg13cmos5l_a22oi_1_2.B2 sg13cmos5l_nor2b_1_0.Y 0
C19626 sg13cmos5l_a221oi_1_1.C1 a_11370_5760# 0.00142f
C19627 sg13cmos5l_dfrbp_1_15.D a_2596_7996# 0.01563f
C19628 a_13047_7690# VPWR 0.18147f
C19629 sg13cmos5l_dfrbp_1_21.Q a_18363_4270# 0
C19630 sg13cmos5l_nand2_1_1.B a_14962_3138# 0
C19631 a_19628_2352# sg13cmos5l_buf_1_19.X 0.33216f
C19632 sg13cmos5l_inv_1_18.A a_9457_4642# 0
C19633 sg13cmos5l_buf_1_29.A sg13cmos5l_nand2_1_0.A 0
C19634 a_5266_4650# sg13cmos5l_buf_1_44.A 0
C19635 sg13cmos5l_buf_1_45.X a_7498_7897# 0.0075f
C19636 a_12075_3911# sg13cmos5l_o21ai_1_0.A2 0
C19637 sg13cmos5l_buf_1_28.X a_11174_2826# 0
C19638 sg13cmos5l_dfrbp_1_0.RESET_B a_13092_3138# 0
C19639 sg13cmos5l_buf_1_9.A a_10613_2758# 0
C19640 sg13cmos5l_dfrbp_1_16.Q sg13cmos5l_dfrbp_1_29.Q_N 0.00618f
C19641 sg13cmos5l_inv_1_14.A a_7689_1626# 0.00239f
C19642 sg13cmos5l_buf_1_104.A sg13cmos5l_buf_8_0.X 0
C19643 sg13cmos5l_buf_1_30.A a_8276_6924# 0
C19644 sg13cmos5l_dfrbp_1_6.D sg13cmos5l_or2_1_0.A 0.06041f
C19645 a_14056_1664# VPWR 0.25231f
C19646 a_11846_9186# a_11567_7751# 0
C19647 a_14056_1664# nl_sw[7] 0
C19648 a_10473_9186# a_10998_9168# 0.13715f
C19649 sg13cmos5l_inv_1_28.Y pl_sw[6] 0.06501f
C19650 sg13cmos5l_buf_1_73.X sg13cmos5l_dfrbp_1_6.D 0
C19651 a_9937_8797# sg13cmos5l_dfrbp_1_20.Q 0
C19652 a_3407_4261# a_3826_4338# 0.00176f
C19653 a_17008_2630# a_16751_2749# 0.35645f
C19654 sg13cmos5l_a22oi_1_1.B1 a_13072_4142# 0.01459f
C19655 sg13cmos5l_buf_1_104.X frame 0.02548f
C19656 a_20672_4782# nh_sw[10] 0
C19657 a_12980_6924# a_13116_7326# 0.00404f
C19658 a_13161_7281# a_13686_7354# 0.13715f
C19659 a_12230_6162# a_13035_6284# 0.11742f
C19660 a_12516_6480# a_12933_6141# 0.48921f
C19661 a_12490_6385# a_12873_6553# 0.00337f
C19662 sg13cmos5l_dfrbp_1_6.RESET_B a_14726_7674# 0.10307f
C19663 a_17700_3456# a_18865_3215# 0.4858f
C19664 a_18219_3260# a_17988_3151# 0.15089f
C19665 sg13cmos5l_dfrbp_1_8.RESET_B a_7216_6382# 0.02413f
C19666 sg13cmos5l_dfrbp_1_23.CLK a_16068_6928# 0
C19667 sg13cmos5l_a221oi_1_0.A2 a_6789_4629# 0.0017f
C19668 sg13cmos5l_dfrbp_1_8.RESET_B a_7336_7010# 0.00186f
C19669 a_16751_2749# a_17126_1626# 0
C19670 sg13cmos5l_buf_8_0.X a_20488_5498# 0.01707f
C19671 a_12361_7282# sg13cmos5l_nor2_1_0.A 0
C19672 a_2122_3868# a_2436_4325# 0.00659f
C19673 a_2148_3904# a_2374_4325# 0.00523f
C19674 sg13cmos5l_dfrbp_1_2.D sg13cmos5l_buf_1_8.X 0
C19675 sg13cmos5l_nand2_1_1.B sg13cmos5l_buf_1_9.A 0.12817f
C19676 sg13cmos5l_dlhr_1_12.D ph_sw[9] 0
C19677 sg13cmos5l_inv_1_26.Y sg13cmos5l_buf_1_18.A 0.21209f
C19678 sg13cmos5l_buf_1_45.X a_8774_5412# 0
C19679 sg13cmos5l_dfrbp_1_6.RESET_B a_8660_5412# 0.11615f
C19680 sg13cmos5l_buf_1_57.X a_16234_6385# 0
C19681 a_18793_6216# a_18615_5770# 0
C19682 sg13cmos5l_buf_1_60.X sg13cmos5l_inv_1_8.A 0.03346f
C19683 sg13cmos5l_buf_1_87.A sg13cmos5l_buf_1_104.X 0
C19684 sg13cmos5l_buf_1_104.A a_20008_8436# 0.00334f
C19685 sg13cmos5l_dfrbp_1_8.RESET_B a_7332_7674# 0
C19686 a_1227_6935# a_1873_7285# 0.00667f
C19687 a_1484_6126# VPWR 0.25385f
C19688 a_12841_7728# a_12361_7282# 0
C19689 a_13047_7690# a_12698_7288# 0.00106f
C19690 a_17126_1626# a_17412_1944# 0.50066f
C19691 a_17386_1849# a_17931_1748# 0.00999f
C19692 a_904_7806# sg13cmos5l_buf_1_68.X 0
C19693 sg13cmos5l_buf_1_6.A nh_sw[7] 0
C19694 a_16551_3987# a_16462_4023# 0
C19695 a_17354_4180# a_17750_4325# 0
C19696 a_16703_3871# a_17493_3947# 0.02241f
C19697 sg13cmos5l_dfrbp_1_4.D nh_sw[5] 0.08629f
C19698 a_9260_2352# nh_sw[4] 0.28823f
C19699 a_7247_8797# sg13cmos5l_dfrbp_1_6.D 0.00106f
C19700 a_7316_3460# sg13cmos5l_dlhr_1_2.Q 0
C19701 a_15466_2356# sg13cmos5l_buf_1_1.A 0
C19702 sg13cmos5l_buf_1_8.A a_11844_1639# 0.00194f
C19703 sg13cmos5l_buf_1_19.A sg13cmos5l_buf_8_1.A 0.00379f
C19704 sg13cmos5l_buf_1_39.A a_3496_1758# 0.06332f
C19705 sg13cmos5l_buf_1_25.X VPWR 0.28754f
C19706 sg13cmos5l_dfrbp_1_6.D a_5424_3460# 0
C19707 a_2306_7660# VPWR 0.00197f
C19708 sg13cmos5l_buf_1_3.A sg13cmos5l_buf_1_104.X 0.2493f
C19709 sg13cmos5l_dfrbp_1_10.Q a_7034_3148# 0.01358f
C19710 a_6697_3192# a_6479_2749# 0.00674f
C19711 a_6903_3154# a_7316_2388# 0
C19712 sg13cmos5l_a22oi_1_1.Y a_15492_2392# 0
C19713 a_6560_3270# a_5220_2392# 0
C19714 sg13cmos5l_buf_1_77.A sg13cmos5l_buf_1_79.X 0
C19715 sg13cmos5l_dlhr_1_15.D a_15590_4650# 0.00911f
C19716 sg13cmos5l_dfrbp_1_6.D a_3578_2752# 0.00535f
C19717 sg13cmos5l_a22oi_1_2.B1 nl_sw[6] 0
C19718 a_18356_6460# VPWR 0.35678f
C19719 a_8570_6172# sg13cmos5l_buf_1_56.A 0
C19720 a_4934_2826# a_5508_2813# 0.36169f
C19721 sg13cmos5l_buf_1_18.A sg13cmos5l_dlhr_1_10.Q 0.20121f
C19722 sg13cmos5l_dlhr_1_15.D a_11973_3911# 0
C19723 a_3688_1664# nh_sw[2] 0.28895f
C19724 sg13cmos5l_buf_1_19.A a_18960_5412# 0
C19725 a_16548_6175# sg13cmos5l_dfrbp_1_21.Q 0.00146f
C19726 a_4736_5498# a_4107_4772# 0
C19727 a_8972_9150# pl_sw[5] 0.00107f
C19728 sg13cmos5l_a221oi_1_0.C1 a_11844_4325# 0
C19729 a_14985_8483# cks 0
C19730 sg13cmos5l_buf_1_5.A a_13161_7281# 0.00884f
C19731 sg13cmos5l_dlhr_1_5.Q_N a_9344_7010# 0.01282f
C19732 a_13572_3151# a_12719_2749# 0
C19733 sg13cmos5l_buf_1_34.X sg13cmos5l_buf_1_44.A 0
C19734 sg13cmos5l_nand2_1_1.A a_14900_2352# 0
C19735 sg13cmos5l_a22oi_1_1.Y a_16572_4261# 0.00856f
C19736 a_11873_5760# a_11771_5412# 0
C19737 sg13cmos5l_buf_1_74.X sg13cmos5l_buf_1_79.X 0
C19738 a_13297_9263# a_13810_9186# 0
C19739 sg13cmos5l_inv_1_1.A a_14726_7674# 0
C19740 a_15784_9224# a_15012_7992# 0
C19741 a_16724_8436# sg13cmos5l_dfrbp_1_22.D 0.14209f
C19742 a_6198_3120# a_6903_3154# 0
C19743 sg13cmos5l_dlhr_1_0.GATE a_7508_1948# 0.00145f
C19744 sg13cmos5l_dfrbp_1_6.RESET_B a_1227_5423# 0.56012f
C19745 sg13cmos5l_buf_1_57.X a_10028_6126# 0.03961f
C19746 sg13cmos5l_buf_1_8.A a_10331_1924# 0.00545f
C19747 a_20012_2352# VPWR 0.25677f
C19748 sg13cmos5l_dfrbp_1_6.D a_1672_3176# 0.32343f
C19749 pl_sw[2] sg13cmos5l_buf_1_62.X 0.02887f
C19750 sg13cmos5l_dfrbp_1_12.Q_N a_8296_3986# 0
C19751 a_18345_7674# sg13cmos5l_dfrbp_1_21.Q_N 0
C19752 sg13cmos5l_dfrbp_1_6.RESET_B sg13cmos5l_buf_1_26.X 0
C19753 a_14708_6924# a_14377_5770# 0
C19754 a_14889_7281# a_14583_5770# 0
C19755 sg13cmos5l_inv_1_0.A sg13cmos5l_and3_1_0.X 0.03181f
C19756 a_7888_4870# a_8050_4650# 0.0019f
C19757 a_9111_4666# a_9242_4660# 0.65127f
C19758 a_20488_5498# a_20488_4782# 0.01275f
C19759 sg13cmos5l_inv_1_0.A sg13cmos5l_inv_1_0.Y 0.74705f
C19760 sg13cmos5l_dfrbp_1_8.RESET_B a_2831_7630# 0.0048f
C19761 nh_sw[10] nl_sw[9] 0
C19762 VPWR ph_sw[9] 0.34979f
C19763 a_15974_6162# a_16677_6141# 0.02453f
C19764 a_16234_6385# a_16779_6284# 0.00999f
C19765 sg13cmos5l_dfrbp_1_8.RESET_B a_5796_3904# 0.00387f
C19766 sg13cmos5l_buf_1_6.A a_15357_1816# 0.0048f
C19767 a_18873_1941# VPWR 0
C19768 sg13cmos5l_buf_1_29.A sg13cmos5l_dfrbp_1_1.Q 0.04218f
C19769 a_6372_4968# a_7034_3148# 0
C19770 a_6891_4772# a_6903_3154# 0
C19771 a_6789_4629# a_6697_3192# 0
C19772 sg13cmos5l_nor2_1_0.A a_11980_4948# 0
C19773 a_10998_9168# a_11360_9318# 0.04055f
C19774 a_13297_9263# sg13cmos5l_dlhr_1_11.Q 0
C19775 a_5702_8874# a_6405_8447# 0.02431f
C19776 sg13cmos5l_dfrbp_1_6.RESET_B a_17529_7047# 0
C19777 a_16177_7751# a_16690_7674# 0
C19778 sg13cmos5l_dfrbp_1_6.D sg13cmos5l_dlygate4sd2_1_0.X 0.00234f
C19779 sg13cmos5l_inv_1_7.A a_13556_2388# 0.04606f
C19780 sg13cmos5l_buf_1_31.X sg13cmos5l_buf_1_30.X 0
C19781 a_13574_8112# VPWR 0.00418f
C19782 sg13cmos5l_buf_1_31.X a_8680_1664# 0
C19783 sg13cmos5l_nand2_1_0.A a_12921_2511# 0.00148f
C19784 a_11272_8522# a_10827_7796# 0
C19785 sg13cmos5l_dfrbp_1_16.Q a_9033_6162# 0
C19786 sg13cmos5l_buf_8_0.X pl_sw[10] 0.00119f
C19787 sg13cmos5l_buf_1_28.X a_11072_2474# 0
C19788 a_1290_3206# a_1192_1664# 0
C19789 sg13cmos5l_dfrbp_1_6.D a_1946_4660# 0.03632f
C19790 sg13cmos5l_dfrbp_1_0.Q nh_sw[6] 0.02625f
C19791 sg13cmos5l_buf_1_31.X a_9660_4686# 0
C19792 a_422_5850# sg13cmos5l_inv_1_19.A 0.00144f
C19793 sg13cmos5l_dfrbp_1_6.RESET_B a_3676_7964# 0.45909f
C19794 sg13cmos5l_buf_1_77.X a_7238_7674# 0
C19795 sg13cmos5l_buf_1_93.X a_14602_8404# 0
C19796 sg13cmos5l_buf_1_110.A sg13cmos5l_buf_1_57.X 0.15888f
C19797 a_3976_9224# ph_sw[1] 0
C19798 sg13cmos5l_buf_1_57.X sg13cmos5l_dfrbp_1_16.Q 0
C19799 sg13cmos5l_buf_1_65.X pl_sw[1] 0.00754f
C19800 sg13cmos5l_buf_1_45.X a_8022_3120# 0.00503f
C19801 a_17588_2388# sg13cmos5l_dfrbp_1_5.Q_N 0.25039f
C19802 sg13cmos5l_a22oi_1_1.B1 sg13cmos5l_dfrbp_1_2.Q_N 0.00437f
C19803 sg13cmos5l_inv_1_3.A sg13cmos5l_buf_1_98.A 0.23188f
C19804 a_13035_6284# a_14032_6382# 0.06778f
C19805 sg13cmos5l_dlhr_1_0.D a_9544_2474# 0
C19806 sg13cmos5l_dfrbp_1_8.D a_17041_4727# 0.00484f
C19807 a_11464_8436# sg13cmos5l_buf_1_10.A 0
C19808 sg13cmos5l_dfrbp_1_6.RESET_B a_16528_7894# 0.18223f
C19809 a_5600_8522# cks 0.03845f
C19810 a_19216_3358# sg13cmos5l_dfrbp_1_3.Q_N 0.15881f
C19811 a_18959_3215# a_19378_3138# 0.00176f
C19812 sg13cmos5l_a221oi_1_0.A2 a_8468_4948# 0.00997f
C19813 sg13cmos5l_buf_1_2.A sg13cmos5l_dfrbp_1_1.Q 0.0251f
C19814 sg13cmos5l_buf_1_19.A cko 0
C19815 a_12120_3456# VPWR 0.02165f
C19816 sg13cmos5l_dfrbp_1_8.RESET_B sg13cmos5l_buf_8_1.A 0
C19817 a_18376_2388# a_17412_1944# 0
C19818 sg13cmos5l_dfrbp_1_8.RESET_B a_1484_9150# 0
C19819 sg13cmos5l_dfrbp_1_8.RESET_B a_13593_9501# 0.00343f
C19820 a_12106_9409# a_12420_9199# 0.00659f
C19821 a_6405_8447# ph_sw[3] 0
C19822 a_2565_3911# a_3313_4261# 0.01058f
C19823 sg13cmos5l_buf_1_34.X a_3831_7282# 0.00267f
C19824 a_2122_3868# a_2505_3947# 0.00337f
C19825 sg13cmos5l_nand2_1_0.A sg13cmos5l_buf_1_6.A 0.09391f
C19826 sg13cmos5l_nand2_1_0.A a_11530_1849# 0
C19827 a_416_3986# a_416_2474# 0
C19828 sg13cmos5l_dlygate4sd3_1_0.X a_620_2352# 0.00764f
C19829 sg13cmos5l_nand2_1_1.A nl_sw[10] 0
C19830 sg13cmos5l_dfrbp_1_8.D sg13cmos5l_dlhr_1_16.Q_N 0
C19831 sg13cmos5l_a22oi_1_1.B1 a_10331_3900# 0.19816f
C19832 sg13cmos5l_dfrbp_1_9.Q a_3609_4023# 0.0028f
C19833 a_20008_8436# pl_sw[10] 0
C19834 sg13cmos5l_nand2_1_1.B sg13cmos5l_dfrbp_1_1.D 0.03203f
C19835 a_19130_6172# a_19028_5412# 0.00728f
C19836 a_18793_6216# a_19209_5769# 0.00178f
C19837 sg13cmos5l_inv_1_27.Y sg13cmos5l_dfrbp_1_6.D 0.33863f
C19838 sg13cmos5l_dfrbp_1_8.RESET_B a_8689_7751# 0
C19839 a_2380_6162# VPWR 0.17062f
C19840 sg13cmos5l_dlhr_1_1.GATE a_3575_6553# 0.00502f
C19841 a_13460_7996# a_13161_7281# 0.00605f
C19842 a_13641_7674# a_13686_7354# 0
C19843 a_17829_1605# a_18671_1703# 0.00437f
C19844 a_17412_1944# a_18928_1846# 0.00294f
C19845 a_1227_6935# a_1997_6126# 0.00804f
C19846 sg13cmos5l_buf_1_25.A a_6188_1590# 0.31303f
C19847 a_1862_4338# a_2122_3868# 0.87117f
C19848 sg13cmos5l_nand2_1_0.B a_11270_4338# 0.00493f
C19849 a_6380_7638# sg13cmos5l_buf_1_24.A 0.0065f
C19850 a_17674_3361# a_18219_3260# 0.00999f
C19851 sg13cmos5l_dlhr_1_5.GATE a_5820_5773# 0.00893f
C19852 a_17399_3947# a_18146_4338# 0.00718f
C19853 a_10783_4292# VPWR 0
C19854 sg13cmos5l_buf_1_29.A a_9366_5842# 0.03277f
C19855 a_16011_2399# a_16268_1590# 0
C19856 sg13cmos5l_buf_1_73.X a_5702_8874# 0.00191f
C19857 sg13cmos5l_buf_8_2.X ph_sw[8] 0
C19858 a_8022_3120# a_8204_2352# 0.00636f
C19859 a_6903_3154# sg13cmos5l_dlhr_1_0.D 0
C19860 sg13cmos5l_a22oi_1_1.Y a_16011_2399# 0
C19861 sg13cmos5l_dfrbp_1_10.Q a_6560_3270# 0.00172f
C19862 sg13cmos5l_dlhr_1_15.D a_17392_4870# 0
C19863 sg13cmos5l_dfrbp_1_6.D sg13cmos5l_buf_1_34.A 0.0319f
C19864 sg13cmos5l_buf_1_5.A nh_sw[7] 0
C19865 a_5446_2813# a_5508_2813# 0
C19866 a_5637_2399# a_6479_2749# 0.0032f
C19867 a_11567_7751# sg13cmos5l_inv_1_29.Y 0
C19868 sg13cmos5l_nor2b_1_0.Y a_10220_3102# 0
C19869 sg13cmos5l_nor2_1_0.A a_13652_1924# 0.00261f
C19870 sg13cmos5l_buf_1_30.A a_7474_4338# 0
C19871 sg13cmos5l_buf_1_31.X sg13cmos5l_dlhr_1_6.Q_N 0.0055f
C19872 sg13cmos5l_buf_1_1.A a_17386_1849# 0
C19873 sg13cmos5l_dfrbp_1_29.Q_N a_4847_4727# 0
C19874 a_1463_8741# sg13cmos5l_inv_1_19.A 0.01979f
C19875 a_1862_8874# sg13cmos5l_buf_1_61.X 0
C19876 sg13cmos5l_dfrbp_1_12.Q_N a_8392_3270# 0
C19877 a_10420_5412# sg13cmos5l_dfrbp_1_10.Q 0
C19878 sg13cmos5l_buf_1_5.A a_14426_7288# 0.01917f
C19879 sg13cmos5l_buf_1_65.X a_6507_8447# 0
C19880 sg13cmos5l_a22oi_1_1.Y a_16703_3871# 0.01334f
C19881 sg13cmos5l_dfrbp_1_6.RESET_B a_5414_6162# 0.10507f
C19882 a_11270_4338# nl_sw[6] 0
C19883 sg13cmos5l_inv_1_1.A a_16528_7894# 0.00472f
C19884 sg13cmos5l_dlhr_1_0.GATE a_7440_1948# 0
C19885 sg13cmos5l_buf_1_57.X a_14166_7656# 0.00228f
C19886 sg13cmos5l_dlhr_1_2.D a_7034_3148# 0
C19887 sg13cmos5l_inv_1_17.A sg13cmos5l_buf_1_37.A 0.12102f
C19888 sg13cmos5l_buf_1_8.A a_12075_1748# 0.00708f
C19889 sg13cmos5l_buf_1_90.X sg13cmos5l_dlhr_1_11.GATE 0.08323f
C19890 sg13cmos5l_dfrbp_1_6.D a_2148_3138# 0
C19891 sg13cmos5l_or2_1_0.A a_1121_4166# 0.0052f
C19892 a_5492_3460# a_5637_2399# 0.01996f
C19893 a_6198_3120# a_5220_2392# 0
C19894 a_5079_3154# a_5508_2813# 0
C19895 sg13cmos5l_dfrbp_1_12.Q_N a_8050_4650# 0
C19896 a_1864_9224# sg13cmos5l_buf_1_58.A 0
C19897 a_14628_8440# ph_sw[6] 0
C19898 sg13cmos5l_dlhr_1_5.GATE VPWR 1.19f
C19899 a_4041_2745# sg13cmos5l_dlhr_1_3.Q_N 0.00294f
C19900 sg13cmos5l_dfrbp_1_8.D sg13cmos5l_buf_1_4.A 0.03793f
C19901 sg13cmos5l_buf_1_94.X ph_sw[8] 0.00225f
C19902 sg13cmos5l_dfrbp_1_6.RESET_B a_7238_7674# 0.0944f
C19903 sg13cmos5l_buf_1_5.A a_13641_7674# 0.00849f
C19904 sg13cmos5l_buf_1_44.X a_4107_4772# 0.00737f
C19905 a_12075_1748# sg13cmos5l_buf_1_1.A 0
C19906 sg13cmos5l_dfrbp_1_8.RESET_B a_7055_4261# 0.00171f
C19907 a_16234_6385# a_16548_6175# 0.00659f
C19908 a_16677_6141# a_17776_6382# 0
C19909 a_16779_6284# a_17519_6239# 0.3087f
C19910 sg13cmos5l_buf_1_98.A cks 0.02688f
C19911 sg13cmos5l_or2_1_1.B sg13cmos5l_dfrbp_1_0.RESET_B 0
C19912 sg13cmos5l_buf_1_79.X sg13cmos5l_buf_1_10.A 0.00196f
C19913 a_5132_3864# sg13cmos5l_dfrbp_1_10.Q 0
C19914 a_7631_4727# a_7497_3138# 0.00128f
C19915 ph_sw[0] ph_sw[1] 0.00343f
C19916 sg13cmos5l_nand2_1_2.B sg13cmos5l_inv_1_19.A 0
C19917 sg13cmos5l_dfrbp_1_1.Q a_12921_2511# 0
C19918 sg13cmos5l_o21ai_1_0.B1 a_13803_3260# 0.02034f
C19919 ph_sw[0] a_1000_9224# 0.13207f
C19920 a_5988_8440# a_6276_8861# 0.4806f
C19921 a_5962_8404# a_6507_8447# 0.00999f
C19922 a_5702_8874# a_7247_8797# 0
C19923 sg13cmos5l_inv_1_17.A sg13cmos5l_dfrbp_1_6.RESET_B 0.09716f
C19924 a_3447_2746# nh_sw[1] 0
C19925 sg13cmos5l_buf_1_73.X ph_sw[3] 0.04021f
C19926 a_14536_7806# VPWR 0.14042f
C19927 sg13cmos5l_buf_1_73.A sg13cmos5l_dlhr_1_5.D 0
C19928 sg13cmos5l_inv_1_14.A a_5820_5773# 0.03151f
C19929 a_5079_3154# a_4873_3192# 0.27532f
C19930 a_5684_4948# VPWR 0.35593f
C19931 a_13775_6239# sg13cmos5l_and3_1_0.X 0.00106f
C19932 sg13cmos5l_inv_1_7.A a_12404_7972# 0.00268f
C19933 sg13cmos5l_dfrbp_1_1.Q sg13cmos5l_dfrbp_1_1.Q_N 0.00126f
C19934 sg13cmos5l_and3_1_0.C sg13cmos5l_buf_1_8.A 0
C19935 sg13cmos5l_dfrbp_1_6.D a_2342_5088# 0
C19936 sg13cmos5l_inv_1_14.A a_8576_1758# 0
C19937 a_15876_4968# a_17041_4727# 0.4858f
C19938 a_16395_4772# a_16164_4663# 0.15089f
C19939 a_16748_9150# a_15887_8797# 0.0068f
C19940 sg13cmos5l_buf_1_93.X a_16144_8678# 0.00264f
C19941 sg13cmos5l_dfrbp_1_23.CLK a_13768_8436# 0.00409f
C19942 sg13cmos5l_dfrbp_1_18.Q a_8772_8440# 0.04935f
C19943 a_3407_4261# a_4041_2745# 0
C19944 a_3308_5376# a_4076_5376# 0.00102f
C19945 sg13cmos5l_or2_1_0.A sg13cmos5l_buf_1_9.A 0
C19946 sg13cmos5l_dlhr_1_11.GATE a_11190_7354# 0.00467f
C19947 sg13cmos5l_buf_1_10.A a_12815_4261# 0.01025f
C19948 sg13cmos5l_nand2_1_1.B a_14745_3453# 0.00289f
C19949 a_18376_2388# a_18760_2388# 0.00492f
C19950 sg13cmos5l_buf_1_45.X sg13cmos5l_dlhr_1_2.Q 0.00216f
C19951 sg13cmos5l_buf_1_31.X sg13cmos5l_buf_1_24.X 0
C19952 a_10868_8436# a_10725_7653# 0.0035f
C19953 sg13cmos5l_inv_1_27.Y a_15147_8447# 0
C19954 sg13cmos5l_dfrbp_1_1.Q sg13cmos5l_buf_1_6.A 0.05863f
C19955 sg13cmos5l_dlhr_1_1.GATE sg13cmos5l_buf_1_31.X 0
C19956 a_14426_7288# sg13cmos5l_dfrbp_1_23.Q 0.00109f
C19957 a_14612_6460# a_15208_6200# 0.00307f
C19958 a_17508_3138# nh_sw[8] 0
C19959 sg13cmos5l_dfrbp_1_8.RESET_B sg13cmos5l_inv_1_29.A 0
C19960 sg13cmos5l_buf_1_96.A sg13cmos5l_buf_1_10.A 0.01515f
C19961 a_7153_8797# cks 0
C19962 sg13cmos5l_dfrbp_1_0.RESET_B a_11270_1626# 0.1127f
C19963 sg13cmos5l_dfrbp_1_16.Q sg13cmos5l_dlhr_1_1.Q 0.00197f
C19964 sg13cmos5l_inv_1_14.A VPWR 1.02318f
C19965 a_2667_3911# a_2859_3260# 0
C19966 sg13cmos5l_buf_1_30.A a_7657_7282# 0.00129f
C19967 sg13cmos5l_buf_1_18.X a_17931_1748# 0
C19968 a_19244_2352# a_18671_1703# 0.00499f
C19969 a_18760_2388# a_18928_1846# 0.0036f
C19970 sg13cmos5l_buf_1_34.X a_4425_7281# 0.06566f
C19971 sg13cmos5l_or2_1_0.A a_5739_2399# 0
C19972 sg13cmos5l_nand2_1_0.A a_12815_1703# 0
C19973 a_18363_4270# a_19244_2352# 0.00104f
C19974 sg13cmos5l_o21ai_1_0.A1 a_12520_3176# 0.00152f
C19975 a_19412_6484# sg13cmos5l_dlhr_1_16.Q 0.00103f
C19976 sg13cmos5l_inv_1_0.A a_13572_3151# 0
C19977 a_13641_7674# sg13cmos5l_dfrbp_1_23.Q 0.00642f
C19978 a_14166_7656# a_14089_7282# 0
C19979 a_4652_6126# VPWR 0.35251f
C19980 a_17412_1944# a_18577_1703# 0.4858f
C19981 a_17931_1748# a_17700_1639# 0.15089f
C19982 sg13cmos5l_dlhr_1_5.GATE a_8233_6216# 0.03151f
C19983 a_1967_7285# a_2380_6162# 0.00529f
C19984 a_2804_6924# a_2879_6432# 0.00528f
C19985 sg13cmos5l_dlhr_1_1.GATE a_2804_5412# 0
C19986 sg13cmos5l_buf_1_25.A a_7095_1642# 0
C19987 sg13cmos5l_inv_1_29.Y a_11752_6294# 0.02208f
C19988 sg13cmos5l_buf_1_5.A sg13cmos5l_nand2_1_0.A 0.0221f
C19989 sg13cmos5l_dfrbp_1_0.D nl_sw[10] 0
C19990 sg13cmos5l_inv_1_7.A sg13cmos5l_nand2_1_1.B 0.03372f
C19991 a_10484_6924# sg13cmos5l_a221oi_1_0.C1 0
C19992 a_15784_1664# nh_sw[7] 0.00281f
C19993 sg13cmos5l_inv_1_20.Y a_3488_7010# 0.01235f
C19994 sg13cmos5l_nand2_1_0.B a_11844_4325# 0.00101f
C19995 sg13cmos5l_dlhr_1_5.GATE sg13cmos5l_dfrbp_1_11.Q 0.00152f
C19996 sg13cmos5l_dfrbp_1_23.CLK a_12912_6924# 0
C19997 sg13cmos5l_dlhr_1_12.D a_16271_7751# 0.04613f
C19998 a_17161_8794# a_17108_7972# 0
C19999 a_17700_3456# a_18959_3215# 0.01741f
C20000 sg13cmos5l_nor2_1_0.A sg13cmos5l_buf_1_8.A 0.03095f
C20001 sg13cmos5l_or2_1_0.A a_5210_3148# 0.00383f
C20002 a_15045_8447# a_15782_7362# 0
C20003 sg13cmos5l_dfrbp_1_6.D a_19412_6484# 0
C20004 sg13cmos5l_buf_8_0.X a_19734_5842# 0.00129f
C20005 a_3692_9150# sg13cmos5l_buf_1_64.A 0.00657f
C20006 a_13324_4696# sg13cmos5l_a22oi_1_1.B1 0
C20007 sg13cmos5l_dlhr_1_2.Q a_8204_2352# 0.34019f
C20008 sg13cmos5l_a22oi_1_1.Y sg13cmos5l_dfrbp_1_5.Q_N 0.00181f
C20009 a_1196_8400# a_1463_8511# 0.02364f
C20010 sg13cmos5l_inv_1_26.Y a_18164_7996# 0
C20011 sg13cmos5l_dfrbp_1_10.Q a_7316_2388# 0
C20012 a_13641_7674# a_13460_7996# 0.40925f
C20013 a_5220_2392# sg13cmos5l_dlhr_1_0.D 0
C20014 a_12841_7728# a_13392_7996# 0
C20015 sg13cmos5l_buf_1_10.A sg13cmos5l_a221oi_1_0.B1 0.03793f
C20016 sg13cmos5l_buf_1_34.X a_5028_2826# 0
C20017 sg13cmos5l_dfrbp_1_1.Q d_out[0] 0.00244f
C20018 a_3302_4650# a_3588_4968# 0.50066f
C20019 a_18860_6888# VPWR 0.3125f
C20020 a_1402_3864# a_1862_4338# 0.01714f
C20021 sg13cmos5l_dlygate4sd2_1_0.X a_1121_4166# 0.00116f
C20022 sg13cmos5l_dfrbp_1_8.RESET_B sg13cmos5l_dlhr_1_19.Q_N 0.03603f
C20023 a_2667_8447# sg13cmos5l_buf_1_61.X 0
C20024 sg13cmos5l_buf_1_4.A a_15876_4968# 0.02056f
C20025 sg13cmos5l_buf_1_77.A a_9673_9240# 0
C20026 a_6086_4650# sg13cmos5l_or2_1_0.A 0
C20027 sg13cmos5l_dlhr_1_1.GATE a_1125_6935# 0.02635f
C20028 a_18568_7010# sg13cmos5l_dfrbp_1_21.Q 0.00182f
C20029 sg13cmos5l_buf_1_65.X sg13cmos5l_dfrbp_1_18.Q_N 0
C20030 a_7689_1626# nl_sw[4] 0.0089f
C20031 sg13cmos5l_dfrbp_1_6.RESET_B a_7216_6382# 0.18225f
C20032 sg13cmos5l_a22oi_1_1.Y a_18363_4270# 0
C20033 sg13cmos5l_dfrbp_1_6.D a_16068_6928# 0.01105f
C20034 a_8439_6178# a_8660_5412# 0.00735f
C20035 a_11844_4325# nl_sw[6] 0
C20036 sg13cmos5l_dfrbp_1_6.RESET_B a_7336_7010# 0.0169f
C20037 sg13cmos5l_dlhr_1_2.D a_6560_3270# 0.03268f
C20038 a_1864_1664# a_1576_1758# 0.00535f
C20039 sg13cmos5l_inv_1_6.A a_17392_4870# 0
C20040 sg13cmos5l_buf_1_39.A a_5324_1590# 0.29531f
C20041 sg13cmos5l_dfrbp_1_6.D a_3505_3215# 0
C20042 sg13cmos5l_inv_1_18.A a_9033_6162# 0.03311f
C20043 a_3574_7850# VPWR 0.25247f
C20044 sg13cmos5l_buf_1_87.A sg13cmos5l_dfrbp_1_22.D 0
C20045 a_4559_7630# a_4518_7996# 0
C20046 a_4349_7636# sg13cmos5l_dlhr_1_1.GATE 0.24835f
C20047 sg13cmos5l_dfrbp_1_10.Q a_6198_3120# 0.00614f
C20048 sg13cmos5l_inv_1_2.A a_11824_7894# 0
C20049 sg13cmos5l_buf_1_89.A a_14996_5412# 0.00198f
C20050 sg13cmos5l_buf_1_74.X a_9673_9240# 0
C20051 sg13cmos5l_buf_8_1.A sg13cmos5l_dfrbp_1_0.Q 0
C20052 sg13cmos5l_buf_1_34.A a_5194_2356# 0
C20053 a_4041_2745# a_3974_2388# 0
C20054 a_3407_8797# a_3831_7282# 0.00308f
C20055 a_3664_8678# a_3625_7282# 0
C20056 sg13cmos5l_inv_1_7.A a_12230_6162# 0.00236f
C20057 sg13cmos5l_buf_1_44.X a_5104_4870# 0.03498f
C20058 a_16779_6284# sg13cmos5l_dfrbp_1_21.Q_N 0
C20059 a_17776_6382# a_17721_6477# 0.00464f
C20060 a_15357_1816# a_15784_1664# 0.10542f
C20061 a_14440_1664# sg13cmos5l_buf_1_1.A 0.13377f
C20062 sg13cmos5l_buf_1_19.A a_19028_5412# 0.04765f
C20063 sg13cmos5l_inv_1_2.A a_15045_8447# 0.37718f
C20064 sg13cmos5l_dfrbp_1_1.Q a_16751_2749# 0.00466f
C20065 a_8276_6924# a_8208_6924# 0
C20066 sg13cmos5l_o21ai_1_0.B1 sg13cmos5l_buf_1_5.X 0.0074f
C20067 sg13cmos5l_dfrbp_1_6.RESET_B a_996_5837# 0.01305f
C20068 sg13cmos5l_inv_1_18.A sg13cmos5l_buf_1_57.X 0.03204f
C20069 sg13cmos5l_dfrbp_1_0.RESET_B a_17588_2388# 0.07243f
C20070 a_16271_7751# VPWR 0.25881f
C20071 sg13cmos5l_inv_1_27.Y a_13035_6284# 0
C20072 a_5673_3138# a_6198_3120# 0.13715f
C20073 a_5210_3148# a_5424_3460# 0.01249f
C20074 sg13cmos5l_inv_1_14.A sg13cmos5l_dfrbp_1_11.Q 1.12197f
C20075 sg13cmos5l_inv_1_2.A a_17132_9150# 0
C20076 a_8783_7751# a_9344_7010# 0.0029f
C20077 sg13cmos5l_dfrbp_1_1.Q a_17412_1944# 0.00684f
C20078 a_416_2474# comp_p 0
C20079 a_8468_4948# a_8905_4704# 0.00314f
C20080 a_11272_8522# cks 0.0046f
C20081 sg13cmos5l_dfrbp_1_0.RESET_B a_17829_1605# 0.05336f
C20082 sg13cmos5l_a22oi_1_2.B2 a_10230_4632# 0.04772f
C20083 sg13cmos5l_buf_1_93.X sg13cmos5l_dfrbp_1_22.D 0.00355f
C20084 a_17135_4727# sg13cmos5l_buf_8_1.A 0.00248f
C20085 a_17392_4870# sg13cmos5l_dfrbp_1_8.Q_N 0.15881f
C20086 sg13cmos5l_dfrbp_1_0.RESET_B a_17493_3947# 0.01265f
C20087 a_12075_3911# a_11979_2399# 0
C20088 sg13cmos5l_buf_1_45.A VPWR 0.4015f
C20089 sg13cmos5l_inv_1_18.A sg13cmos5l_buf_1_28.A 0.39983f
C20090 a_5700_6480# a_5069_5376# 0
C20091 sg13cmos5l_dfrbp_1_18.Q a_10031_8797# 0.01149f
C20092 sg13cmos5l_buf_1_38.A a_4041_2745# 0.07303f
C20093 sg13cmos5l_buf_8_0.X a_20392_3176# 0
C20094 a_10998_9168# a_11464_9224# 0.00204f
C20095 sg13cmos5l_dlhr_1_11.GATE a_12567_7282# 0.2547f
C20096 sg13cmos5l_dlhr_1_15.D a_17545_7728# 0.28173f
C20097 a_20200_3270# a_20288_2474# 0.00235f
C20098 sg13cmos5l_buf_1_30.A a_7394_5850# 0
C20099 sg13cmos5l_dlhr_1_9.Q a_4107_4772# 0
C20100 a_19628_2352# sg13cmos5l_buf_1_18.X 0.03532f
C20101 sg13cmos5l_buf_1_29.A sg13cmos5l_a22oi_1_0.B1 0
C20102 sg13cmos5l_buf_1_73.A sg13cmos5l_dfrbp_1_6.D 0.04089f
C20103 sg13cmos5l_dfrbp_1_1.Q a_12815_1703# 0.00289f
C20104 a_11973_3911# a_11460_2392# 0
C20105 sg13cmos5l_buf_1_45.X a_8588_2352# 0.00391f
C20106 a_2248_9224# cks 0
C20107 a_6086_4650# a_6729_5041# 0.00806f
C20108 a_6372_4968# a_6891_4772# 0.38902f
C20109 a_8772_8440# cks 0.01449f
C20110 sg13cmos5l_buf_1_28.X sg13cmos5l_dfrbp_1_4.D 0.00104f
C20111 sg13cmos5l_dfrbp_1_0.RESET_B a_13072_1846# 0.18533f
C20112 sg13cmos5l_dfrbp_1_6.RESET_B a_2831_7630# 0.01575f
C20113 sg13cmos5l_o21ai_1_0.A2 a_10888_1664# 0
C20114 sg13cmos5l_dfrbp_1_6.RESET_B a_5796_3904# 0.51515f
C20115 a_18760_2388# a_18577_1703# 0
C20116 sg13cmos5l_buf_1_5.A sg13cmos5l_dfrbp_1_1.Q 0.02217f
C20117 cko ph_sw[10] 0.21122f
C20118 sg13cmos5l_o21ai_1_0.A1 a_12075_1748# 0
C20119 sg13cmos5l_dfrbp_1_8.RESET_B a_6741_5459# 0.35226f
C20120 sg13cmos5l_dlhr_1_19.Q_N a_15850_4873# 0
C20121 a_5312_6294# VPWR 0.12012f
C20122 sg13cmos5l_buf_1_63.A a_1088_7806# 0.01054f
C20123 a_18671_1703# a_19090_1626# 0.00176f
C20124 a_18928_1846# sg13cmos5l_dfrbp_1_0.Q_N 0.15881f
C20125 a_14996_5412# sg13cmos5l_dfrbp_1_0.CLK 0
C20126 sg13cmos5l_inv_1_2.A sg13cmos5l_inv_1_0.A 0
C20127 a_2386_5850# VPWR 0.00138f
C20128 a_10598_6924# sg13cmos5l_a221oi_1_0.C1 0
C20129 sg13cmos5l_inv_1_29.Y a_12324_6162# 0
C20130 sg13cmos5l_dfrbp_1_8.RESET_B a_10022_7674# 0
C20131 sg13cmos5l_dlhr_1_12.D sg13cmos5l_dlhr_1_15.D 0.00555f
C20132 a_18959_3215# a_19796_3436# 0.1333f
C20133 a_1096_6294# a_1280_6294# 0.11523f
C20134 a_1997_6126# sg13cmos5l_dfrbp_1_15.Q_N 0.04107f
C20135 sg13cmos5l_or2_1_0.A sg13cmos5l_dlhr_1_4.Q_N 0.00169f
C20136 a_1402_3864# ckc 0
C20137 sg13cmos5l_buf_1_73.X a_7666_8874# 0
C20138 sg13cmos5l_or2_1_0.A a_4041_2745# 0
C20139 a_12520_4782# sg13cmos5l_a22oi_1_1.B1 0
C20140 sg13cmos5l_buf_1_63.X pl_sw[0] 0.28405f
C20141 a_2824_2388# sg13cmos5l_inv_1_19.A 0
C20142 sg13cmos5l_dfrbp_1_9.Q a_3407_4261# 0.03138f
C20143 sg13cmos5l_inv_1_8.A sg13cmos5l_dlhr_1_1.GATE 0.02904f
C20144 a_14166_7656# sg13cmos5l_dlhr_1_14.Q_N 0.12876f
C20145 a_6736_2630# sg13cmos5l_dlhr_1_0.D 0.00325f
C20146 a_8204_2352# a_8588_2352# 0.00492f
C20147 sg13cmos5l_dfrbp_1_10.Q sg13cmos5l_dlhr_1_0.D 0
C20148 sg13cmos5l_buf_1_34.X a_5508_2813# 0
C20149 a_13486_5412# a_13324_4696# 0
C20150 a_3302_4650# a_3396_4650# 0.00718f
C20151 a_20488_4782# a_20392_3176# 0
C20152 a_2148_8440# cks 0.01084f
C20153 sg13cmos5l_buf_8_2.X a_20008_8436# 0.0309f
C20154 sg13cmos5l_nor2b_1_1.Y a_15466_2356# 0
C20155 sg13cmos5l_nor2b_1_0.Y a_12815_4261# 0.02844f
C20156 a_3692_9150# VPWR 0.2471f
C20157 sg13cmos5l_o21ai_1_0.A1 sg13cmos5l_and3_1_0.C 0
C20158 a_7631_4727# sg13cmos5l_or2_1_0.A 0
C20159 sg13cmos5l_a22oi_1_0.Y a_11364_4338# 0
C20160 a_12132_9504# a_13391_9263# 0.01741f
C20161 a_16940_3102# a_17674_3361# 0
C20162 sg13cmos5l_dfrbp_1_6.D a_17584_7166# 0.0039f
C20163 a_9558_6144# a_9366_5842# 0
C20164 sg13cmos5l_buf_1_26.X nh_sw[4] 0.13927f
C20165 a_2934_4632# a_2148_3904# 0
C20166 a_2228_4972# a_2565_3911# 0.01256f
C20167 sg13cmos5l_or2_1_0.A a_2340_3456# 0.00137f
C20168 sg13cmos5l_dfrbp_1_6.RESET_B a_8692_7312# 0.00383f
C20169 sg13cmos5l_dfrbp_1_6.RESET_B sg13cmos5l_buf_8_1.A 0.17572f
C20170 sg13cmos5l_buf_1_4.X cks 0.12853f
C20171 sg13cmos5l_dfrbp_1_11.Q sg13cmos5l_buf_1_45.A 0.04778f
C20172 sg13cmos5l_buf_1_45.X a_8785_6154# 0
C20173 a_13297_9263# pl_sw[6] 0
C20174 sg13cmos5l_dlhr_1_2.D a_7316_2388# 0.2588f
C20175 sg13cmos5l_buf_1_34.X a_4873_3192# 0.03473f
C20176 sg13cmos5l_buf_1_3.A a_18959_3215# 0.0192f
C20177 sg13cmos5l_a22oi_1_2.B2 a_9823_2780# 0
C20178 sg13cmos5l_dlhr_1_6.D a_8784_6484# 0
C20179 sg13cmos5l_buf_1_39.A nh_sw[2] 0.02259f
C20180 sg13cmos5l_dfrbp_1_6.RESET_B a_8689_7751# 0.00107f
C20181 sg13cmos5l_dfrbp_1_15.D a_3625_7282# 0.03674f
C20182 sg13cmos5l_dfrbp_1_6.RESET_B a_18960_5412# 0
C20183 sg13cmos5l_dfrbp_1_8.RESET_B sg13cmos5l_a22oi_1_1.B2 0
C20184 a_9865_7282# sg13cmos5l_dlhr_1_6.D 0
C20185 a_9448_6924# a_9558_6144# 0
C20186 sg13cmos5l_inv_1_2.A a_16724_8436# 0.04744f
C20187 sg13cmos5l_dfrbp_1_15.D sg13cmos5l_dfrbp_1_6.D 0
C20188 sg13cmos5l_dlhr_1_5.Q a_9344_7010# 0
C20189 sg13cmos5l_dfrbp_1_1.Q a_18760_2388# 0.00205f
C20190 a_7247_8797# a_7666_8874# 0.00176f
C20191 sg13cmos5l_buf_1_40.A sg13cmos5l_dfrbp_1_6.D 0.02554f
C20192 a_11877_2399# sg13cmos5l_dfrbp_1_0.Q 0
C20193 sg13cmos5l_dfrbp_1_0.RESET_B a_19244_2352# 0
C20194 sg13cmos5l_a221oi_1_0.B2 a_11771_5412# 0.18594f
C20195 a_18860_9150# a_19136_9318# 0.00624f
C20196 sg13cmos5l_dlhr_1_15.D VPWR 1.29341f
C20197 sg13cmos5l_buf_1_110.A a_15012_7992# 0.01406f
C20198 a_6198_3120# sg13cmos5l_dlhr_1_2.D 0
C20199 a_9620_7972# sg13cmos5l_dlhr_1_6.Q_N 0
C20200 sg13cmos5l_o21ai_1_0.Y sg13cmos5l_buf_1_8.A 0
C20201 a_1948_7964# sg13cmos5l_dlhr_1_1.GATE 0
C20202 sg13cmos5l_dfrbp_1_20.Q a_9344_7010# 0
C20203 sg13cmos5l_dfrbp_1_1.Q a_19508_1924# 0.00426f
C20204 sg13cmos5l_dfrbp_1_6.RESET_B sg13cmos5l_dlhr_1_0.Q 0.54747f
C20205 sg13cmos5l_dfrbp_1_12.Q_N a_9242_4660# 0.00158f
C20206 a_2934_4632# sg13cmos5l_or2_1_0.A 0
C20207 a_3793_2790# a_3860_2388# 0.0018f
C20208 a_3447_2746# a_3996_2790# 0
C20209 a_3578_2752# a_4041_2745# 0.13395f
C20210 sg13cmos5l_dfrbp_1_8.D a_15592_6200# 0
C20211 a_3308_9150# a_2667_8447# 0
C20212 a_2824_2388# sg13cmos5l_buf_1_33.A 0.00186f
C20213 sg13cmos5l_buf_1_37.A a_1864_1664# 0
C20214 sg13cmos5l_dfrbp_1_6.RESET_B a_14152_5498# 0.00566f
C20215 a_5414_6162# a_5951_5383# 0
C20216 a_6959_6239# a_5820_5773# 0
C20217 sg13cmos5l_buf_1_94.X a_16160_9318# 0.00118f
C20218 sg13cmos5l_buf_1_29.A sg13cmos5l_buf_1_25.A 0
C20219 sg13cmos5l_nor2b_1_0.Y sg13cmos5l_a221oi_1_0.B1 0.1677f
C20220 sg13cmos5l_buf_1_7.A a_13258_3361# 0.00288f
C20221 sg13cmos5l_dfrbp_1_16.Q a_8841_5769# 0.02546f
C20222 sg13cmos5l_nor2_1_0.A sg13cmos5l_o21ai_1_0.A1 0.04133f
C20223 sg13cmos5l_buf_8_0.X a_20200_3270# 0
C20224 sg13cmos5l_dlhr_1_11.GATE a_13116_7326# 0
C20225 sg13cmos5l_dfrbp_1_18.Q sg13cmos5l_buf_1_30.A 0
C20226 a_12232_8436# a_12404_7972# 0
C20227 sg13cmos5l_dfrbp_1_0.CLK sg13cmos5l_buf_1_7.A 0.23923f
C20228 a_11973_3911# a_11979_2399# 0.00283f
C20229 a_2757_3117# a_3241_2746# 0
C20230 a_2859_3260# a_3447_2746# 0
C20231 a_16271_7751# a_16260_6480# 0
C20232 sg13cmos5l_dfrbp_1_1.Q a_15784_1664# 0.00127f
C20233 sg13cmos5l_buf_1_94.X a_18376_9224# 0
C20234 a_6891_4772# a_7888_4870# 0.06778f
C20235 a_6086_4650# a_6660_4663# 0.36169f
C20236 a_10031_8797# cks 0.01509f
C20237 sg13cmos5l_dfrbp_1_0.RESET_B a_16268_1590# 0
C20238 sg13cmos5l_inv_1_7.A sg13cmos5l_or2_1_0.A 0.0204f
C20239 a_11846_9186# ph_sw[6] 0.00843f
C20240 sg13cmos5l_a22oi_1_1.B1 a_16204_4338# 0
C20241 sg13cmos5l_buf_1_38.A a_4436_3436# 0.0086f
C20242 sg13cmos5l_dfrbp_1_0.RESET_B sg13cmos5l_a22oi_1_1.Y 0.17335f
C20243 sg13cmos5l_dfrbp_1_23.CLK a_13324_4696# 0
C20244 sg13cmos5l_dfrbp_1_6.RESET_B a_7055_4261# 0.20553f
C20245 sg13cmos5l_buf_1_64.A ph_sw[1] 0
C20246 a_2667_3911# sg13cmos5l_buf_1_41.X 0
C20247 a_3976_9224# sg13cmos5l_buf_1_61.X 0
C20248 sg13cmos5l_dfrbp_1_8.RESET_B sg13cmos5l_a221oi_1_0.A2 0.01105f
C20249 a_16264_9224# sg13cmos5l_buf_1_93.X 0.00607f
C20250 sg13cmos5l_buf_1_45.X a_8772_8440# 0.00193f
C20251 sg13cmos5l_buf_1_65.X a_7336_9224# 0.00823f
C20252 sg13cmos5l_buf_1_63.A sg13cmos5l_dlhr_1_8.Q_N 0.01189f
C20253 a_2314_3361# a_2054_3138# 0.87117f
C20254 a_6959_6239# VPWR 0.28394f
C20255 sg13cmos5l_nor2_1_1.A nl_sw[9] 0
C20256 sg13cmos5l_inv_1_3.A sg13cmos5l_dlhr_1_11.Q 0.0467f
C20257 a_4358_6924# VPWR 0.00418f
C20258 a_10220_3102# a_11372_3102# 0
C20259 a_11556_1944# nh_sw[6] 0.0053f
C20260 sg13cmos5l_dfrbp_1_16.Q_N sg13cmos5l_buf_1_62.X 0
C20261 sg13cmos5l_dfrbp_1_8.RESET_B a_11567_7751# 0.01132f
C20262 sg13cmos5l_dfrbp_1_16.Q a_2224_5654# 0
C20263 a_1227_6935# sg13cmos5l_dlhr_1_1.D 0
C20264 a_2879_6432# a_2727_6380# 0.6663f
C20265 sg13cmos5l_dfrbp_1_21.Q a_18480_5028# 0.00378f
C20266 sg13cmos5l_dfrbp_1_22.D a_16042_6892# 0.0041f
C20267 a_15887_8797# a_16356_7349# 0
C20268 sg13cmos5l_dlhr_1_15.D a_16551_3987# 0
C20269 sg13cmos5l_o21ai_1_0.A2 VPWR 0.56891f
C20270 sg13cmos5l_buf_8_0.X sg13cmos5l_a22oi_1_1.A1 0.00206f
C20271 sg13cmos5l_buf_1_90.X a_12420_9199# 0.01038f
C20272 a_13391_9263# sg13cmos5l_buf_1_93.X 0
C20273 sg13cmos5l_dfrbp_1_8.D sg13cmos5l_dlhr_1_16.Q 0
C20274 sg13cmos5l_dfrbp_1_9.Q sg13cmos5l_buf_1_38.A 0.66123f
C20275 sg13cmos5l_buf_1_4.A a_15380_3436# 0
C20276 sg13cmos5l_dfrbp_1_8.RESET_B a_14628_8440# 0.49029f
C20277 a_12549_9165# sg13cmos5l_inv_1_7.A 0
C20278 sg13cmos5l_a22oi_1_1.B2 a_15850_4873# 0
C20279 a_4107_4772# a_5049_4965# 0
C20280 a_3588_4968# a_3814_4663# 0.00523f
C20281 a_4005_4629# a_3876_4663# 0.01562f
C20282 a_4244_8436# cks 0.04172f
C20283 sg13cmos5l_a22oi_1_0.Y sg13cmos5l_dfrbp_1_0.CLK 0
C20284 sg13cmos5l_dlhr_1_9.D a_10789_4654# 0
C20285 a_8576_1758# nl_sw[4] 0.00403f
C20286 a_13391_9263# a_14228_9484# 0.1333f
C20287 sg13cmos5l_dfrbp_1_6.RESET_B sg13cmos5l_inv_1_29.A 0.04853f
C20288 sg13cmos5l_dfrbp_1_6.D sg13cmos5l_dfrbp_1_8.D 0.84226f
C20289 a_19528_6924# a_19424_7010# 0.00624f
C20290 sg13cmos5l_dfrbp_1_9.Q a_2148_3904# 0.0427f
C20291 a_19624_8436# cks 0
C20292 a_10230_4632# a_10220_3102# 0
C20293 sg13cmos5l_or2_1_0.A a_4436_3436# 0.00185f
C20294 sg13cmos5l_buf_1_18.A a_18746_5776# 0
C20295 sg13cmos5l_buf_1_30.A a_7316_3460# 0
C20296 sg13cmos5l_dlygate4sd2_1_0.A a_1290_3206# 0.01183f
C20297 sg13cmos5l_dlhr_1_2.D sg13cmos5l_dlhr_1_0.D 0.00695f
C20298 sg13cmos5l_nor2b_1_0.Y a_11782_4325# 0
C20299 sg13cmos5l_dfrbp_1_18.Q pl_sw[5] 0.00188f
C20300 sg13cmos5l_dfrbp_1_22.D sg13cmos5l_dlhr_1_12.Q_N 0
C20301 sg13cmos5l_dlhr_1_1.GATE a_708_6928# 0.01317f
C20302 sg13cmos5l_inv_1_29.A a_10412_6126# 0
C20303 sg13cmos5l_dfrbp_1_16.Q_N a_2804_6924# 0.25726f
C20304 sg13cmos5l_dfrbp_1_21.Q a_14583_5770# 0.01273f
C20305 sg13cmos5l_buf_1_34.X a_3860_2388# 0
C20306 sg13cmos5l_nor2b_1_0.Y sg13cmos5l_inv_1_11.Y 0
C20307 a_11182_4948# sg13cmos5l_nand2_1_0.A 0
C20308 sg13cmos5l_buf_1_63.A sg13cmos5l_inv_1_19.A 0.21023f
C20309 sg13cmos5l_dfrbp_1_17.D sg13cmos5l_buf_1_61.X 0
C20310 a_5194_2356# nl_sw[3] 0
C20311 a_10220_3102# nh_sw[5] 0
C20312 VPWR nl_sw[4] 0.19298f
C20313 a_7504_8678# a_7449_8559# 0.00464f
C20314 comp_p nl_sw[1] 0
C20315 sg13cmos5l_dfrbp_1_6.D a_12912_6924# 0
C20316 sg13cmos5l_dlhr_1_11.Q a_12516_6480# 0
C20317 sg13cmos5l_dlygate4sd2_1_0.A a_1402_3864# 0.00146f
C20318 sg13cmos5l_dfrbp_1_8.RESET_B a_6697_3192# 0
C20319 sg13cmos5l_buf_1_26.A nl_sw[5] 0
C20320 a_2409_4650# a_2228_4972# 0.40925f
C20321 a_1609_4704# a_1210_4654# 0
C20322 a_3676_7964# sg13cmos5l_dlhr_1_9.Q_N 0.00294f
C20323 a_16160_9318# a_15793_8797# 0
C20324 a_2621_7636# VPWR 0.18166f
C20325 sg13cmos5l_dfrbp_1_20.Q a_11190_7354# 0.00161f
C20326 sg13cmos5l_dfrbp_1_1.Q sg13cmos5l_dfrbp_1_0.Q_N 0.0014f
C20327 a_5770_3868# VPWR 0.10047f
C20328 sg13cmos5l_dlhr_1_15.D a_12814_4692# 0.00241f
C20329 sg13cmos5l_dfrbp_1_9.Q sg13cmos5l_or2_1_0.A 0.43289f
C20330 sg13cmos5l_dfrbp_1_6.RESET_B a_934_5837# 0
C20331 sg13cmos5l_buf_8_1.A a_15702_4187# 0
C20332 a_4041_2745# sg13cmos5l_buf_1_34.A 0.28815f
C20333 sg13cmos5l_buf_1_41.A a_3407_4261# 0
C20334 sg13cmos5l_dlygate4sd2_1_0.A a_1609_4704# 0.00964f
C20335 a_6959_6239# sg13cmos5l_dfrbp_1_11.Q 0.00881f
C20336 sg13cmos5l_buf_1_7.A a_13641_3529# 0
C20337 sg13cmos5l_inv_1_8.Y sg13cmos5l_inv_1_19.A 0
C20338 sg13cmos5l_dlhr_1_11.Q cks 0.02441f
C20339 a_7657_7282# a_8208_6924# 0
C20340 a_16748_9150# ph_sw[6] 0
C20341 ph_sw[0] sg13cmos5l_buf_1_61.X 0.0351f
C20342 sg13cmos5l_inv_1_6.A VPWR 0.81048f
C20343 a_1192_1664# nh_sw[0] 0.01006f
C20344 a_5069_5376# sg13cmos5l_inv_1_19.A 0
C20345 a_17516_9150# a_17367_8794# 0.00628f
C20346 sg13cmos5l_buf_1_101.X a_15887_8797# 0
C20347 a_18860_6888# ph_sw[9] 0.29844f
C20348 sg13cmos5l_or2_1_1.B a_14583_5770# 0
C20349 sg13cmos5l_buf_1_41.X nh_sw[1] 0.47408f
C20350 a_3599_3215# a_4018_3138# 0.00176f
C20351 sg13cmos5l_dfrbp_1_10.Q_N a_4873_3192# 0
C20352 sg13cmos5l_buf_1_96.A a_10596_7687# 0
C20353 a_3599_3215# a_3860_2388# 0.01523f
C20354 sg13cmos5l_dfrbp_1_0.CLK a_13556_2388# 0.00121f
C20355 sg13cmos5l_dlhr_1_15.D a_16260_6480# 0.03878f
C20356 sg13cmos5l_buf_1_5.A a_14458_4270# 0.00434f
C20357 a_6891_4772# sg13cmos5l_dfrbp_1_12.Q_N 0.00128f
C20358 a_7888_4870# a_7833_4965# 0.00464f
C20359 a_11072_5347# sg13cmos5l_a221oi_1_0.B2 0.08738f
C20360 sg13cmos5l_and3_1_0.C sg13cmos5l_nor2b_1_1.Y 0
C20361 a_11848_8436# cks 0.00817f
C20362 sg13cmos5l_dfrbp_1_15.D a_5702_8874# 0
C20363 a_13648_9406# ph_sw[6] 0.00318f
C20364 sg13cmos5l_buf_1_30.A cks 0
C20365 sg13cmos5l_a22oi_1_1.B1 a_14814_3876# 0.06278f
C20366 a_1196_8400# a_1125_6935# 0.00294f
C20367 sg13cmos5l_dfrbp_1_8.RESET_B a_2667_3911# 0.59292f
C20368 sg13cmos5l_dfrbp_1_6.RESET_B a_7257_4023# 0.00343f
C20369 sg13cmos5l_dfrbp_1_20.Q_N a_8772_8440# 0.01266f
C20370 a_3308_5376# sg13cmos5l_dlhr_1_1.Q 0.32484f
C20371 sg13cmos5l_inv_1_2.A a_12132_9504# 0.1137f
C20372 sg13cmos5l_a22oi_1_1.B2 sg13cmos5l_dfrbp_1_0.Q 0
C20373 sg13cmos5l_buf_1_3.X a_20288_2474# 0.00108f
C20374 sg13cmos5l_buf_1_87.A a_18793_6216# 0
C20375 sg13cmos5l_inv_1_17.A pl_sw[2] 0.00167f
C20376 sg13cmos5l_dlhr_1_6.D VPWR 0.53902f
C20377 a_2054_3138# a_3599_3215# 0
C20378 sg13cmos5l_nand2_1_1.B sg13cmos5l_buf_1_2.X 0
C20379 VPWR ph_sw[1] 0.42395f
C20380 sg13cmos5l_dfrbp_1_16.Q a_5700_6480# 0
C20381 sg13cmos5l_dfrbp_1_8.Q_N VPWR 0.17778f
C20382 a_18164_6924# cks 0
C20383 sg13cmos5l_dlhr_1_5.GATE a_5684_4948# 0
C20384 VPWR a_1000_9224# 0.25023f
C20385 sg13cmos5l_buf_1_31.X sg13cmos5l_nand2_1_0.A 0
C20386 a_13652_1924# nh_sw[6] 0.01388f
C20387 sg13cmos5l_dfrbp_1_8.RESET_B sg13cmos5l_dlhr_1_11.D 0
C20388 sg13cmos5l_buf_1_24.A a_6117_6141# 0.03282f
C20389 sg13cmos5l_dlhr_1_0.Q a_7924_1612# 0
C20390 a_2748_6126# a_3575_6553# 0.50066f
C20391 a_2879_6432# a_3530_6320# 0.01562f
C20392 sg13cmos5l_inv_1_3.A a_13652_3900# 0.0354f
C20393 sg13cmos5l_dlhr_1_15.D sg13cmos5l_dlhr_1_17.Q_N 0
C20394 sg13cmos5l_buf_1_10.A a_12704_4782# 0.00403f
C20395 sg13cmos5l_dfrbp_1_16.Q sg13cmos5l_dlhr_1_1.D 0
C20396 a_10998_9168# ph_sw[5] 0.05214f
C20397 sg13cmos5l_dfrbp_1_9.Q a_3578_2752# 0.00837f
C20398 sg13cmos5l_dlhr_1_9.D a_5069_5376# 0.00931f
C20399 sg13cmos5l_dfrbp_1_22.D a_16587_6935# 0.00645f
C20400 a_1878_6337# a_1873_5773# 0
C20401 sg13cmos5l_dfrbp_1_15.Q_N a_2224_5654# 0
C20402 sg13cmos5l_buf_1_63.A a_904_7806# 0.00819f
C20403 a_902_3142# a_1158_3142# 0.36081f
C20404 sg13cmos5l_inv_1_1.A sg13cmos5l_dlhr_1_19.Q_N 0.00117f
C20405 a_20204_5376# VPWR 0.25765f
C20406 sg13cmos5l_inv_1_27.Y sg13cmos5l_inv_1_7.A 0.0212f
C20407 sg13cmos5l_dfrbp_1_8.RESET_B a_15887_8797# 0.20289f
C20408 sg13cmos5l_o21ai_1_0.A1 sg13cmos5l_o21ai_1_0.Y 0.01623f
C20409 a_14986_7897# a_15531_7796# 0.00999f
C20410 sg13cmos5l_buf_1_40.A a_1121_4166# 0.02421f
C20411 a_12721_1703# nl_sw[6] 0
C20412 a_7336_9224# a_6507_8447# 0
C20413 a_14996_5412# sg13cmos5l_buf_1_2.A 0
C20414 a_5104_4870# a_5049_4965# 0.00464f
C20415 sg13cmos5l_buf_1_4.A a_16204_4338# 0.02255f
C20416 sg13cmos5l_dlhr_1_9.Q a_4322_6162# 0
C20417 sg13cmos5l_buf_1_28.X a_8204_2352# 0
C20418 sg13cmos5l_inv_1_8.A a_6380_7638# 0.00234f
C20419 sg13cmos5l_buf_1_105.A sg13cmos5l_buf_1_104.X 0.00277f
C20420 sg13cmos5l_buf_1_26.A a_7095_1642# 0
C20421 sg13cmos5l_buf_1_19.A a_17414_3138# 0
C20422 sg13cmos5l_dfrbp_1_6.D a_3008_1758# 0
C20423 sg13cmos5l_dfrbp_1_11.Q a_5770_3868# 0
C20424 a_5951_5383# a_5796_3904# 0.00162f
C20425 a_5799_5499# a_6213_3911# 0
C20426 a_5820_5773# a_7312_4142# 0
C20427 a_1006_4167# a_902_3142# 0
C20428 sg13cmos5l_buf_1_41.A a_3974_2388# 0
C20429 sg13cmos5l_inv_1_14.A sg13cmos5l_dlhr_1_5.GATE 0.02512f
C20430 a_11394_4948# sg13cmos5l_dfrbp_1_0.RESET_B 0
C20431 sg13cmos5l_o21ai_1_0.A1 a_11054_4292# 0
C20432 sg13cmos5l_and3_1_0.C sg13cmos5l_a22oi_1_1.B1 0.63243f
C20433 a_13698_5412# VPWR 0.19477f
C20434 sg13cmos5l_dfrbp_1_6.RESET_B a_6741_5459# 0
C20435 sg13cmos5l_dfrbp_1_21.Q a_14929_5814# 0
C20436 a_6572_1590# nh_sw[3] 0.00104f
C20437 a_3016_9318# a_2831_7630# 0
C20438 sg13cmos5l_inv_1_17.A sg13cmos5l_dlhr_1_9.Q_N 0.01457f
C20439 a_10613_2758# nl_sw[5] 0
C20440 sg13cmos5l_dfrbp_1_6.D a_16690_7674# 0
C20441 sg13cmos5l_inv_1_18.A a_8841_5769# 0.01021f
C20442 sg13cmos5l_dlhr_1_5.GATE a_4652_6126# 0.01144f
C20443 sg13cmos5l_nand2_1_1.A a_17988_3151# 0.00766f
C20444 a_18568_7010# sg13cmos5l_dfrbp_1_21.Q_N 0.00152f
C20445 sg13cmos5l_inv_1_0.A a_13520_4696# 0.00443f
C20446 a_8746_8404# a_8772_8440# 0.43042f
C20447 a_10473_9186# a_10725_7653# 0
C20448 sg13cmos5l_dfrbp_1_6.RESET_B a_10022_7674# 0.14444f
C20449 a_14254_2444# sg13cmos5l_dfrbp_1_0.Q 0.3249f
C20450 sg13cmos5l_dfrbp_1_20.Q sg13cmos5l_or2_1_1.B 0.20988f
C20451 sg13cmos5l_inv_1_0.A a_11530_3868# 0
C20452 sg13cmos5l_buf_1_65.X sg13cmos5l_dfrbp_1_8.RESET_B 0.3892f
C20453 pl_sw[5] cks 0
C20454 a_16268_3102# cks 0.00447f
C20455 sg13cmos5l_buf_1_35.A a_1576_1758# 0.00567f
C20456 a_14900_2352# a_14924_1590# 0.00523f
C20457 sg13cmos5l_nor2b_1_1.Y a_14440_1664# 0.0021f
C20458 sg13cmos5l_a22oi_1_2.B2 sg13cmos5l_buf_1_28.X 0.05423f
C20459 sg13cmos5l_inv_1_27.Y sg13cmos5l_dlhr_1_13.Q_N 0
C20460 sg13cmos5l_buf_1_77.A a_9033_6162# 0.04588f
C20461 sg13cmos5l_dfrbp_1_16.Q_N sg13cmos5l_dlhr_1_9.Q 0
C20462 a_7312_4142# VPWR 0.15f
C20463 a_8488_9224# ph_sw[4] 0.00207f
C20464 a_2621_7636# a_1967_7285# 0.01447f
C20465 a_2596_7996# a_2804_6924# 0
C20466 sg13cmos5l_inv_1_18.A sg13cmos5l_dlhr_1_5.Q_N 0.01364f
C20467 sg13cmos5l_buf_1_41.A sg13cmos5l_buf_1_38.A 0.03886f
C20468 sg13cmos5l_dlhr_1_6.D a_8233_6216# 0.25818f
C20469 sg13cmos5l_nor2_1_0.A a_11656_3176# 0.00851f
C20470 a_2348_7624# a_2786_7666# 0.0018f
C20471 a_8457_7281# a_9033_6162# 0.00773f
C20472 a_8982_7354# a_8570_6172# 0
C20473 a_10022_7674# a_10071_7282# 0
C20474 sg13cmos5l_dfrbp_1_6.RESET_B a_19028_5412# 0.12031f
C20475 sg13cmos5l_dlhr_1_6.D sg13cmos5l_dfrbp_1_11.Q 0.00117f
C20476 sg13cmos5l_buf_1_10.A a_10416_6924# 0
C20477 sg13cmos5l_a22oi_1_1.A1 sg13cmos5l_buf_1_2.X 0
C20478 sg13cmos5l_buf_1_77.A sg13cmos5l_buf_1_57.X 0
C20479 sg13cmos5l_dfrbp_1_6.D pl_sw[3] 0.00112f
C20480 a_5799_5499# sg13cmos5l_inv_1_19.A 0
C20481 sg13cmos5l_nand2_1_1.B nl_sw[5] 0.91523f
C20482 sg13cmos5l_dfrbp_1_8.RESET_B a_5962_8404# 0.31845f
C20483 nl_sw[7] VGND 1.12403f
C20484 nh_sw[6] VGND 1.11739f
C20485 nh_sw[3] VGND 1.03666f
C20486 nl_sw[3] VGND 0.89341f
C20487 nh_sw[2] VGND 0.87998f
C20488 nl_sw[2] VGND 1.01085f
C20489 nl_sw[1] VGND 0.70593f
C20490 comp_p VGND 0.40225f
C20491 d_out[0] VGND 0.51649f
C20492 nl_sw[10] VGND 0.61567f
C20493 nh_sw[9] VGND 0.82741f
C20494 nl_sw[9] VGND 1.00931f
C20495 nh_sw[4] VGND 0.65678f
C20496 nl_sw[4] VGND 0.83699f
C20497 nh_sw[1] VGND 0.83004f
C20498 nh_sw[0] VGND 0.63858f
C20499 nl_sw[0] VGND 0.85137f
C20500 nh_sw[10] VGND 1.08932f
C20501 nh_sw[8] VGND 0.77071f
C20502 nl_sw[8] VGND 0.66332f
C20503 nh_sw[7] VGND 0.96608f
C20504 nl_sw[6] VGND 0.73489f
C20505 nh_sw[5] VGND 0.75016f
C20506 nl_sw[5] VGND 0.80718f
C20507 d_out[2] VGND 0.80574f
C20508 d_out[1] VGND 0.44348f
C20509 ckc VGND 0.47177f
C20510 ph_sw[10] VGND 1.31196f
C20511 ph_sw[9] VGND 0.71545f
C20512 cko VGND 0.42835f
C20513 frame VGND 0.53093f
C20514 pl_sw[3] VGND 0.68034f
C20515 pl_sw[0] VGND 0.82729f
C20516 pl_sw[10] VGND 0.67478f
C20517 pl_sw[9] VGND 0.71576f
C20518 pl_sw[6] VGND 0.97917f
C20519 ph_sw[5] VGND 0.77958f
C20520 rdy VGND 0.54502f
C20521 ph_sw[8] VGND 0.74874f
C20522 pl_sw[8] VGND 0.5699f
C20523 ph_sw[7] VGND 0.68697f
C20524 pl_sw[7] VGND 1.07932f
C20525 ph_sw[6] VGND 0.83792f
C20526 cks VGND 2.79101f
C20527 pl_sw[5] VGND 1.00963f
C20528 ph_sw[4] VGND 0.66361f
C20529 pl_sw[4] VGND 0.61595f
C20530 ph_sw[3] VGND 0.88024f
C20531 ph_sw[2] VGND 0.64786f
C20532 pl_sw[2] VGND 0.88487f
C20533 ph_sw[1] VGND 0.6595f
C20534 pl_sw[1] VGND 0.75584f
C20535 ph_sw[0] VGND 0.6288f
C20536 VPWR VGND 38.5849f
C20537 a_20672_1758# VGND 0.08203f ; **FLOATING
C20538 a_19090_1626# VGND 0.00348f
C20539 sg13cmos5l_dfrbp_1_0.Q_N VGND 0.10205f
C20540 a_18577_1703# VGND 0.11471f
C20541 a_17700_1639# VGND 0.03666f
C20542 a_20296_1664# VGND 0.21072f
C20543 a_20012_1590# VGND 0.20935f
C20544 a_19508_1924# VGND 0.29268f
C20545 a_18928_1846# VGND 0.27019f
C20546 a_18671_1703# VGND 0.41451f
C20547 a_17220_1626# VGND 0
C20548 a_17931_1748# VGND 0.19745f
C20549 a_17829_1605# VGND 0.46426f
C20550 a_17412_1944# VGND 1.7384f
C20551 a_17126_1626# VGND 0.20483f
C20552 a_16936_1758# VGND 0.08412f ; **FLOATING
C20553 a_17386_1849# VGND 0.08181f
C20554 a_15439_1630# VGND 0.00856f
C20555 a_15200_1758# VGND 0.04327f ; **FLOATING
C20556 a_13234_1626# VGND 0.00362f
C20557 sg13cmos5l_dfrbp_1_1.Q_N VGND 0.1054f
C20558 a_12721_1703# VGND 0.12486f
C20559 a_11844_1639# VGND 0.03666f
C20560 a_13017_1941# VGND 0.00213f
C20561 a_16552_1664# VGND 0.20735f
C20562 sg13cmos5l_buf_1_1.A VGND 0.36118f
C20563 a_16268_1590# VGND 0.20931f
C20564 a_15784_1664# VGND 0.2086f
C20565 a_15357_1816# VGND 0.22789f
C20566 a_14924_1590# VGND 0.21036f
C20567 a_14440_1664# VGND 0.20914f
C20568 a_14056_1664# VGND 0.21124f
C20569 a_13652_1924# VGND 0.29668f
C20570 a_13072_1846# VGND 0.27728f
C20571 a_12815_1703# VGND 0.43704f
C20572 a_11364_1626# VGND 0
C20573 a_12075_1748# VGND 0.20926f
C20574 a_11973_1605# VGND 0.46795f
C20575 a_11556_1944# VGND 1.75392f
C20576 a_11270_1626# VGND 0.19935f
C20577 a_11530_1849# VGND 0.08242f
C20578 a_10696_1758# VGND 0.08537f ; **FLOATING
C20579 a_10433_1652# VGND 0.01125f
C20580 a_10331_1924# VGND 0.00652f
C20581 a_8576_1758# VGND 0.04344f ; **FLOATING
C20582 a_7924_1612# VGND 0.00751f
C20583 a_7644_1662# VGND 0.00388f
C20584 a_7441_1618# VGND 0
C20585 sg13cmos5l_dlhr_1_0.Q_N VGND 0.24764f
C20586 a_10888_1664# VGND 0.22196f
C20587 a_9832_1664# VGND 0.20811f
C20588 a_9448_1664# VGND 0.20899f
C20589 a_9164_1590# VGND 0.21046f
C20590 a_8680_1664# VGND 0.21177f
C20591 a_8214_1608# VGND 0.31704f
C20592 a_7508_1948# VGND 0.19035f
C20593 a_7689_1626# VGND 0.52985f
C20594 a_7226_1636# VGND 0.09265f
C20595 a_6889_1680# VGND 0.17144f
C20596 a_7095_1642# VGND 0.81418f
C20597 a_5600_1758# VGND 0.04246f ; **FLOATING
C20598 a_3496_1758# VGND 0.08699f ; **FLOATING
C20599 a_3008_1758# VGND 0.04863f ; **FLOATING
C20600 a_1760_1758# VGND 0.03841f ; **FLOATING
C20601 a_1576_1758# VGND 0.08164f ; **FLOATING
C20602 a_6572_1590# VGND 0.20932f
C20603 a_6188_1590# VGND 0.20778f
C20604 a_5704_1664# VGND 0.21185f
C20605 sg13cmos5l_buf_1_24.X VGND 0.31773f
C20606 a_5324_1590# VGND 0.21248f
C20607 a_4840_1664# VGND 0.20785f
C20608 a_4456_1664# VGND 0.21016f
C20609 sg13cmos5l_buf_1_25.X VGND 0.39214f
C20610 a_4172_1590# VGND 0.21044f
C20611 a_3688_1664# VGND 0.21527f
C20612 sg13cmos5l_buf_1_39.A VGND 0.23431f
C20613 a_3212_1590# VGND 0.21714f
C20614 a_2732_1590# VGND 0.22268f
C20615 a_2248_1664# VGND 0.21045f
C20616 sg13cmos5l_buf_1_33.A VGND 0.41676f
C20617 a_1864_1664# VGND 0.2146f
C20618 sg13cmos5l_buf_1_35.A VGND 0.31825f
C20619 a_1192_1664# VGND 0.20863f
C20620 a_908_1590# VGND 0.21045f
C20621 a_424_1664# VGND 0.26186f
C20622 a_20288_2474# VGND 0.04242f ; **FLOATING
C20623 a_18122_2388# VGND 0
C20624 a_20392_2388# VGND 0.22463f
C20625 sg13cmos5l_buf_1_0.X VGND 0.22598f
C20626 sg13cmos5l_buf_1_19.X VGND 0.38113f
C20627 sg13cmos5l_buf_1_18.X VGND 0.2389f
C20628 a_20012_2352# VGND 0.21044f
C20629 a_19628_2352# VGND 0.20571f
C20630 a_19244_2352# VGND 0.20455f
C20631 a_18760_2388# VGND 0.20542f
C20632 a_18376_2388# VGND 0.22792f
C20633 sg13cmos5l_dfrbp_1_5.Q_N VGND 0.10205f
C20634 a_17170_2826# VGND 0.00348f
C20635 a_16657_2749# VGND 0.11471f
C20636 a_17588_2388# VGND 0.28786f
C20637 a_16751_2749# VGND 0.39443f
C20638 a_17008_2630# VGND 0.26676f
C20639 a_16011_2399# VGND 0.19561f
C20640 a_15780_2813# VGND 0.03666f
C20641 a_14858_2388# VGND 0
C20642 a_14476_2388# VGND 0
C20643 a_12921_2511# VGND 0.00226f
C20644 a_15909_2399# VGND 0.44636f
C20645 a_15492_2392# VGND 1.73658f
C20646 a_15466_2356# VGND 0.08287f
C20647 a_15300_2826# VGND 0
C20648 a_15206_2826# VGND 0.2118f
C20649 sg13cmos5l_buf_1_8.A VGND 0.43587f
C20650 sg13cmos5l_nor2b_1_1.Y VGND 0.32398f
C20651 a_14900_2352# VGND 0.19965f
C20652 sg13cmos5l_dfrbp_1_0.Q VGND 0.75782f
C20653 sg13cmos5l_nor2_1_1.A VGND 0.76046f
C20654 a_14254_2444# VGND 0.20231f
C20655 sg13cmos5l_dfrbp_1_4.Q_N VGND 0.10522f
C20656 a_13138_2826# VGND 0.00376f
C20657 a_12625_2749# VGND 0.12282f
C20658 a_13556_2388# VGND 0.29183f
C20659 a_12719_2749# VGND 0.40361f
C20660 a_12976_2630# VGND 0.28072f
C20661 a_11979_2399# VGND 0.19741f
C20662 a_11748_2813# VGND 0.03666f
C20663 a_11072_2474# VGND 0.0393f ; **FLOATING
C20664 a_9823_2364# VGND 0.00164f
C20665 a_11877_2399# VGND 0.44167f
C20666 a_11460_2392# VGND 1.73789f
C20667 a_11434_2356# VGND 0.08205f
C20668 a_11268_2826# VGND 0
C20669 a_11174_2826# VGND 0.20252f
C20670 sg13cmos5l_dfrbp_1_4.D VGND 0.20088f
C20671 a_10613_2758# VGND 0.16636f
C20672 a_10464_2427# VGND 0.29121f
C20673 a_10427_2736# VGND 0.00115f
C20674 a_9544_2474# VGND 0.08055f ; **FLOATING
C20675 a_10094_2780# VGND 0.0059f
C20676 sg13cmos5l_dfrbp_1_1.D VGND 0.30392f
C20677 sg13cmos5l_a22oi_1_2.B1 VGND 0.31438f
C20678 sg13cmos5l_buf_1_30.X VGND 0.327f
C20679 sg13cmos5l_buf_1_28.A VGND 0.26045f
C20680 a_9260_2352# VGND 0.21272f
C20681 sg13cmos5l_buf_1_26.X VGND 0.24978f
C20682 sg13cmos5l_dlhr_1_0.Q VGND 0.29478f
C20683 sg13cmos5l_dlhr_1_0.D VGND 1.14393f
C20684 a_6898_2826# VGND 0.00348f
C20685 a_6385_2749# VGND 0.11471f
C20686 a_8588_2352# VGND 0.20707f
C20687 a_8204_2352# VGND 0.20465f
C20688 a_7820_2352# VGND 0.20668f
C20689 a_7316_2388# VGND 0.28975f
C20690 a_6479_2749# VGND 0.3982f
C20691 a_6736_2630# VGND 0.26724f
C20692 a_5739_2399# VGND 0.19452f
C20693 a_5508_2813# VGND 0.03666f
C20694 a_3974_2388# VGND 0
C20695 a_3792_2388# VGND 0
C20696 a_5637_2399# VGND 0.4458f
C20697 a_5220_2392# VGND 1.73486f
C20698 a_5194_2356# VGND 0.08369f
C20699 a_5028_2826# VGND 0
C20700 a_4934_2826# VGND 0.19874f
C20701 sg13cmos5l_dlhr_1_3.Q_N VGND 0.22626f
C20702 sg13cmos5l_buf_1_34.A VGND 0.32217f
C20703 a_4276_2776# VGND 0.00765f
C20704 a_3996_2790# VGND 0.00395f
C20705 a_4566_2818# VGND 0.31716f
C20706 a_4041_2745# VGND 0.52332f
C20707 a_3860_2388# VGND 0.18916f
C20708 a_3793_2790# VGND 0
C20709 a_3578_2752# VGND 0.09557f
C20710 a_3241_2746# VGND 0.16741f
C20711 a_3447_2746# VGND 0.81448f
C20712 sg13cmos5l_buf_1_41.X VGND 0.32856f
C20713 sg13cmos5l_buf_1_37.A VGND 0.32424f
C20714 a_2824_2388# VGND 0.24565f
C20715 sg13cmos5l_buf_1_32.A VGND 0.3416f
C20716 sg13cmos5l_buf_1_40.X VGND 0.27135f
C20717 a_1580_2352# VGND 0.20622f
C20718 sg13cmos5l_buf_1_32.X VGND 0.21926f
C20719 a_416_2474# VGND 0.08111f ; **FLOATING
C20720 a_620_2352# VGND 0.20881f
C20721 a_20200_3270# VGND 0.08533f ; **FLOATING
C20722 a_19378_3138# VGND 0.00348f
C20723 sg13cmos5l_dfrbp_1_3.Q_N VGND 0.10205f
C20724 a_18865_3215# VGND 0.11471f
C20725 a_17988_3151# VGND 0.03666f
C20726 a_20392_3176# VGND 0.22344f
C20727 sg13cmos5l_buf_1_3.X VGND 0.41298f
C20728 a_19796_3436# VGND 0.29078f
C20729 a_19216_3358# VGND 0.26691f
C20730 a_18959_3215# VGND 0.40072f
C20731 a_17508_3138# VGND 0
C20732 a_18219_3260# VGND 0.19349f
C20733 a_18117_3117# VGND 0.44128f
C20734 a_17700_3456# VGND 1.736f
C20735 a_17414_3138# VGND 0.2138f
C20736 a_17224_3270# VGND 0.079f ; **FLOATING
C20737 a_14962_3138# VGND 0.00348f
C20738 a_17674_3361# VGND 0.08176f
C20739 sg13cmos5l_buf_1_4.X VGND 0.32151f
C20740 a_16940_3102# VGND 0.21015f
C20741 sg13cmos5l_dfrbp_1_7.Q_N VGND 0.10205f
C20742 a_14449_3215# VGND 0.11508f
C20743 a_13572_3151# VGND 0.03735f
C20744 sg13cmos5l_buf_1_2.X VGND 0.3256f
C20745 a_16268_3102# VGND 0.20417f
C20746 sg13cmos5l_buf_1_5.X VGND 0.364f
C20747 a_15884_3102# VGND 0.20554f
C20748 a_15380_3436# VGND 0.28955f
C20749 a_14800_3358# VGND 0.26797f
C20750 a_14543_3215# VGND 0.39783f
C20751 a_13092_3138# VGND 0
C20752 a_13641_3529# VGND 0
C20753 a_13803_3260# VGND 0.1993f
C20754 a_13701_3117# VGND 0.44536f
C20755 a_13284_3456# VGND 1.74075f
C20756 a_12998_3138# VGND 0.21285f
C20757 a_12896_3270# VGND 0.04287f ; **FLOATING
C20758 a_12022_3134# VGND 0.26281f
C20759 a_13258_3361# VGND 0.08512f
C20760 sg13cmos5l_buf_1_6.A VGND 0.74813f
C20761 a_11002_3142# VGND 0.00965f
C20762 a_10618_3142# VGND 0.00979f
C20763 a_12520_3176# VGND 0.20404f
C20764 sg13cmos5l_o21ai_1_0.Y VGND 0.28654f
C20765 sg13cmos5l_o21ai_1_0.A2 VGND 0.24804f
C20766 a_11656_3176# VGND 0.2061f
C20767 sg13cmos5l_buf_1_8.X VGND 0.32779f
C20768 sg13cmos5l_buf_1_9.A VGND 0.3237f
C20769 a_11372_3102# VGND 0.20523f
C20770 sg13cmos5l_buf_1_28.X VGND 0.38599f
C20771 a_10220_3102# VGND 0.23143f
C20772 sg13cmos5l_inv_1_11.Y VGND 0.94761f
C20773 sg13cmos5l_dfrbp_1_1.Q VGND 0.80372f
C20774 sg13cmos5l_buf_1_25.A VGND 0.5842f
C20775 sg13cmos5l_buf_1_26.A VGND 0.41955f
C20776 a_8392_3270# VGND 0.08341f ; **FLOATING
C20777 a_7732_3124# VGND 0.00751f
C20778 a_7452_3174# VGND 0.00388f
C20779 a_7249_3130# VGND 0
C20780 sg13cmos5l_dlhr_1_2.Q_N VGND 0.25666f
C20781 sg13cmos5l_dlhr_1_2.Q VGND 0.46476f
C20782 a_6560_3270# VGND 0.04346f ; **FLOATING
C20783 a_5908_3124# VGND 0.00751f
C20784 a_5628_3174# VGND 0.00388f
C20785 a_5425_3130# VGND 0
C20786 a_8022_3120# VGND 0.31431f
C20787 a_7316_3460# VGND 0.18569f
C20788 a_7497_3138# VGND 0.51773f
C20789 a_7034_3148# VGND 0.08998f
C20790 a_6697_3192# VGND 0.16707f
C20791 a_6903_3154# VGND 0.80823f
C20792 sg13cmos5l_dlhr_1_2.D VGND 0.30343f
C20793 sg13cmos5l_dlhr_1_4.Q_N VGND 0.24619f
C20794 a_4018_3138# VGND 0.00349f
C20795 a_6198_3120# VGND 0.31421f
C20796 a_5492_3460# VGND 0.18293f
C20797 a_5673_3138# VGND 0.51367f
C20798 a_5210_3148# VGND 0.08854f
C20799 a_4873_3192# VGND 0.16494f
C20800 a_5079_3154# VGND 0.805f
C20801 sg13cmos5l_dfrbp_1_10.Q_N VGND 0.33902f
C20802 a_3505_3215# VGND 0.11554f
C20803 a_2566_3151# VGND 0
C20804 a_2628_3151# VGND 0.05221f
C20805 a_3801_3453# VGND 0
C20806 a_4436_3436# VGND 0.29275f
C20807 a_3856_3358# VGND 0.26947f
C20808 a_3599_3215# VGND 0.40099f
C20809 a_2148_3138# VGND 0
C20810 a_2697_3529# VGND 0
C20811 a_2859_3260# VGND 0.21326f
C20812 a_2757_3117# VGND 0.45444f
C20813 a_2340_3456# VGND 1.75276f
C20814 a_2054_3138# VGND 0.21034f
C20815 a_2314_3361# VGND 0.08513f
C20816 a_1672_3176# VGND 0.20362f
C20817 a_1290_3206# VGND 0.14578f
C20818 a_1158_3142# VGND 0.2034f
C20819 a_902_3142# VGND 0.34588f
C20820 a_424_3270# VGND 0.12004f ; **FLOATING
C20821 a_19616_3986# VGND 0.04296f ; **FLOATING
C20822 a_17595_3947# VGND 0
C20823 a_20392_3900# VGND 0.224f
C20824 a_20008_3900# VGND 0.23125f
C20825 sg13cmos5l_inv_1_5.A VGND 0.48172f
C20826 a_18363_4270# VGND 0.96697f
C20827 a_18146_4338# VGND 0
C20828 a_16462_4023# VGND 0
C20829 a_17399_3947# VGND 0.20493f
C20830 a_17493_3947# VGND 0.08631f
C20831 a_17750_4325# VGND 0
C20832 a_17354_4180# VGND 0.03881f
C20833 a_16703_3871# VGND 0.45815f
C20834 a_14814_3876# VGND 0.00389f
C20835 a_16551_3987# VGND 0.19834f
C20836 a_16462_4338# VGND 0.11529f
C20837 a_16298_4338# VGND 0.00361f
C20838 sg13cmos5l_dfrbp_1_6.Q_N VGND 0.10466f
C20839 a_13017_4023# VGND 0.00173f
C20840 a_16572_4261# VGND 1.74631f
C20841 a_16204_4338# VGND 0.27083f
C20842 a_15821_3864# VGND 0.39793f
C20843 a_15702_4187# VGND 0.2943f
C20844 a_15062_4292# VGND 0
C20845 sg13cmos5l_a22oi_1_1.Y VGND 0.1554f
C20846 a_14814_4292# VGND 0.00601f
C20847 sg13cmos5l_o21ai_1_0.B1 VGND 0.32704f
C20848 a_14458_4270# VGND 0.01019f
C20849 sg13cmos5l_buf_1_7.A VGND 0.33566f
C20850 sg13cmos5l_a22oi_1_1.A1 VGND 1.17435f
C20851 sg13cmos5l_nand2_1_1.A VGND 0.60457f
C20852 sg13cmos5l_dfrbp_1_2.Q_N VGND 0.10481f
C20853 a_11913_3947# VGND 0
C20854 a_10783_3876# VGND 0.00414f
C20855 a_13234_4338# VGND 0.004f
C20856 a_12721_4261# VGND 0.12538f
C20857 a_13652_3900# VGND 0.29892f
C20858 a_12815_4261# VGND 0.419f
C20859 a_13072_4142# VGND 0.27412f
C20860 a_12075_3911# VGND 0.20637f
C20861 sg13cmos5l_dfrbp_1_0.CLK VGND 1.30574f
C20862 a_11844_4325# VGND 0.03895f
C20863 a_11782_4325# VGND 0
C20864 a_10331_3900# VGND 0.00866f
C20865 a_11973_3911# VGND 0.45213f
C20866 a_11556_3904# VGND 1.75744f
C20867 a_11530_3868# VGND 0.08583f
C20868 a_11364_4338# VGND 0
C20869 a_11270_4338# VGND 0.24468f
C20870 sg13cmos5l_dfrbp_1_0.RESET_B VGND 3.72844f
C20871 a_11054_4292# VGND 0.00601f
C20872 a_10783_4292# VGND 0
C20873 a_10433_4248# VGND 0.01188f
C20874 sg13cmos5l_a22oi_1_1.B1 VGND 0.45773f
C20875 sg13cmos5l_dfrbp_1_10.Q VGND 0.60075f
C20876 sg13cmos5l_nand2_1_1.B VGND 1.84447f
C20877 sg13cmos5l_dfrbp_1_2.D VGND 0.36991f
C20878 sg13cmos5l_nand2_1_0.A VGND 1.29864f
C20879 sg13cmos5l_a22oi_1_0.B1 VGND 0.29115f
C20880 sg13cmos5l_a22oi_1_0.Y VGND 0.31651f
C20881 a_8296_3986# VGND 0.08672f ; **FLOATING
C20882 a_7257_4023# VGND 0
C20883 a_8972_3864# VGND 0.25286f
C20884 a_8588_3864# VGND 0.20747f
C20885 a_6153_3947# VGND 0
C20886 a_7474_4338# VGND 0.0035f
C20887 a_6961_4261# VGND 0.11651f
C20888 a_7892_3900# VGND 0.2925f
C20889 a_7055_4261# VGND 0.40798f
C20890 a_7312_4142# VGND 0.269f
C20891 a_6315_3911# VGND 0.19853f
C20892 a_6084_4325# VGND 0.0391f
C20893 a_6022_4325# VGND 0
C20894 a_5408_3986# VGND 0.04f ; **FLOATING
C20895 a_6213_3911# VGND 0.42605f
C20896 a_5796_3904# VGND 1.74617f
C20897 a_5770_3868# VGND 0.08511f
C20898 a_5604_4338# VGND 0
C20899 a_5510_4338# VGND 0.22136f
C20900 sg13cmos5l_buf_1_44.A VGND 0.35691f
C20901 a_4640_3986# VGND 0.04653f ; **FLOATING
C20902 a_3609_4023# VGND 0
C20903 sg13cmos5l_buf_1_38.A VGND 0.35979f
C20904 a_5132_3864# VGND 0.21104f
C20905 sg13cmos5l_dfrbp_1_9.Q_N VGND 0.10686f
C20906 a_2505_3947# VGND 0
C20907 a_3826_4338# VGND 0.0039f
C20908 a_3313_4261# VGND 0.11803f
C20909 a_4244_3900# VGND 0.29351f
C20910 a_3407_4261# VGND 0.40248f
C20911 a_3664_4142# VGND 0.27045f
C20912 a_2667_3911# VGND 0.2181f
C20913 a_2436_4325# VGND 0.03855f
C20914 a_2374_4325# VGND 0
C20915 a_1760_3986# VGND 0.04181f ; **FLOATING
C20916 a_650_3900# VGND 0
C20917 a_2565_3911# VGND 0.46231f
C20918 a_2148_3904# VGND 1.75605f
C20919 a_2122_3868# VGND 0.08851f
C20920 a_1956_4338# VGND 0
C20921 a_1862_4338# VGND 0.21329f
C20922 a_1121_4166# VGND 0.19527f
C20923 sg13cmos5l_dlygate4sd3_1_0.X VGND 0.42076f
C20924 a_416_3986# VGND 0.07986f ; **FLOATING
C20925 sg13cmos5l_dlygate4sd2_1_0.X VGND 0.27723f
C20926 a_1402_3864# VGND 0.33423f
C20927 a_1006_4167# VGND 0.21525f
C20928 sg13cmos5l_nor2_1_2.A VGND 0.39705f
C20929 a_20672_4782# VGND 0.07591f ; **FLOATING
C20930 a_20488_4782# VGND 0.07976f ; **FLOATING
C20931 a_19227_4654# VGND 1.04404f
C20932 sg13cmos5l_buf_1_0.A VGND 0.59192f
C20933 sg13cmos5l_buf_8_0.A VGND 0.40304f
C20934 a_18574_5028# VGND 0
C20935 a_18368_4782# VGND 0.04606f ; **FLOATING
C20936 a_17554_4650# VGND 0.00403f
C20937 sg13cmos5l_buf_8_1.A VGND 0.6284f
C20938 sg13cmos5l_dfrbp_1_8.Q_N VGND 0.10704f
C20939 a_17041_4727# VGND 0.12168f
C20940 a_16102_4663# VGND 0
C20941 a_16164_4663# VGND 0.04217f
C20942 a_17337_4965# VGND 0
C20943 a_18480_5028# VGND 0.45408f
C20944 sg13cmos5l_or2_1_0.A VGND 1.58638f
C20945 sg13cmos5l_dfrbp_1_0.D VGND 0.87752f
C20946 a_17972_4948# VGND 0.30838f
C20947 a_17392_4870# VGND 0.2848f
C20948 a_17135_4727# VGND 0.43878f
C20949 a_15684_4650# VGND 0
C20950 a_16233_5041# VGND 0
C20951 a_16395_4772# VGND 0.21098f
C20952 a_16293_4629# VGND 0.47722f
C20953 a_15876_4968# VGND 1.76929f
C20954 a_15590_4650# VGND 0.24487f
C20955 a_15850_4873# VGND 0.08861f
C20956 a_13520_4696# VGND 0.00516f
C20957 a_13418_4696# VGND 0.00234f
C20958 sg13cmos5l_buf_1_2.A VGND 0.60379f
C20959 a_13036_4948# VGND 0.00175f
C20960 a_12704_4782# VGND 0.03698f ; **FLOATING
C20961 a_12520_4782# VGND 0.07984f ; **FLOATING
C20962 a_11488_4676# VGND 0.00196f
C20963 a_11182_4676# VGND 0.00185f
C20964 a_10789_4654# VGND 0.00971f
C20965 a_9940_4636# VGND 0.00825f
C20966 a_9660_4686# VGND 0.00402f
C20967 a_9457_4642# VGND 0
C20968 a_13324_4696# VGND 0.17358f
C20969 sg13cmos5l_and3_1_0.C VGND 0.4517f
C20970 a_12814_4692# VGND 0.23149f
C20971 a_11980_4948# VGND 0
C20972 sg13cmos5l_o21ai_1_0.A1 VGND 0.83038f
C20973 a_11394_4948# VGND 0
C20974 a_11182_4948# VGND 0.0016f
C20975 sg13cmos5l_nand2_1_0.B VGND 0.50173f
C20976 sg13cmos5l_dlhr_1_20.Q_N VGND 0.25099f
C20977 sg13cmos5l_buf_1_46.A VGND 0.54238f
C20978 a_8050_4650# VGND 0.00403f
C20979 a_9638_5088# VGND 0
C20980 a_9456_4972# VGND 0
C20981 sg13cmos5l_inv_1_0.Y VGND 0.36432f
C20982 a_10587_4692# VGND 0.2336f
C20983 a_10230_4632# VGND 0.32045f
C20984 a_9524_4972# VGND 0.19571f
C20985 a_9705_4650# VGND 0.53341f
C20986 a_9242_4660# VGND 0.09853f
C20987 a_8905_4704# VGND 0.17207f
C20988 a_9111_4666# VGND 0.81904f
C20989 sg13cmos5l_dfrbp_1_12.Q_N VGND 0.47658f
C20990 sg13cmos5l_dfrbp_1_11.Q_N VGND 0.1052f
C20991 a_7537_4727# VGND 0.12167f
C20992 a_6598_4663# VGND 0
C20993 a_6660_4663# VGND 0.04244f
C20994 a_7833_4965# VGND 0
C20995 a_8468_4948# VGND 0.30087f
C20996 a_7888_4870# VGND 0.27805f
C20997 a_7631_4727# VGND 0.41919f
C20998 a_6180_4650# VGND 0
C20999 a_5266_4650# VGND 0.00403f
C21000 a_6729_5041# VGND 0
C21001 a_6891_4772# VGND 0.21643f
C21002 a_6789_4629# VGND 0.45394f
C21003 a_6372_4968# VGND 1.7671f
C21004 a_6086_4650# VGND 0.21109f
C21005 a_6346_4873# VGND 0.08885f
C21006 sg13cmos5l_dlhr_1_0.GATE VGND 0.94103f
C21007 sg13cmos5l_dfrbp_1_14.Q_N VGND 0.10901f
C21008 a_4753_4727# VGND 0.12156f
C21009 a_3814_4663# VGND 0
C21010 a_3876_4663# VGND 0.04527f
C21011 a_5049_4965# VGND 0
C21012 a_5684_4948# VGND 0.29535f
C21013 a_5104_4870# VGND 0.27627f
C21014 a_4847_4727# VGND 0.41324f
C21015 a_3396_4650# VGND 0
C21016 a_2644_4636# VGND 0.00847f
C21017 a_2364_4686# VGND 0.00388f
C21018 a_2161_4642# VGND 0
C21019 a_3945_5041# VGND 0
C21020 a_4107_4772# VGND 0.21228f
C21021 a_4005_4629# VGND 0.46649f
C21022 a_3588_4968# VGND 1.77425f
C21023 a_3302_4650# VGND 0.21987f
C21024 sg13cmos5l_dfrbp_1_9.Q VGND 0.79273f
C21025 a_3562_4873# VGND 0.09194f
C21026 sg13cmos5l_dlhr_1_1.Q_N VGND 0.23528f
C21027 a_2160_4972# VGND 0
C21028 a_1472_4782# VGND 0.04352f ; **FLOATING
C21029 a_1210_4654# VGND 0.01046f
C21030 a_2934_4632# VGND 0.35228f
C21031 a_2228_4972# VGND 0.19201f
C21032 a_2409_4650# VGND 0.54187f
C21033 a_1946_4660# VGND 0.09548f
C21034 a_1609_4704# VGND 0.18939f
C21035 a_1815_4666# VGND 0.81319f
C21036 sg13cmos5l_dlygate4sd2_1_0.A VGND 0.33203f
C21037 sg13cmos5l_nand2_1_2.B VGND 0.61253f
C21038 sg13cmos5l_inv_1_8.Y VGND 0.53627f
C21039 sg13cmos5l_inv_1_9.Y VGND 0.49793f
C21040 sg13cmos5l_buf_1_43.A VGND 0.89446f
C21041 a_524_4614# VGND 0.25173f
C21042 a_20672_5498# VGND 0.07452f ; **FLOATING
C21043 a_20488_5498# VGND 0.07672f ; **FLOATING
C21044 a_19142_5412# VGND 0
C21045 a_18960_5412# VGND 0
C21046 a_20204_5376# VGND 0.24334f
C21047 sg13cmos5l_dlhr_1_16.Q_N VGND 0.22882f
C21048 sg13cmos5l_dlhr_1_16.Q VGND 0.35605f
C21049 a_19444_5800# VGND 0.0078f
C21050 a_19164_5814# VGND 0.00396f
C21051 a_19734_5842# VGND 0.32072f
C21052 a_19209_5769# VGND 0.51873f
C21053 a_19028_5412# VGND 0.18809f
C21054 a_18961_5814# VGND 0
C21055 a_15110_5412# VGND 0
C21056 a_14928_5412# VGND 0
C21057 a_18746_5776# VGND 0.09448f
C21058 a_18409_5770# VGND 0.22065f
C21059 a_18615_5770# VGND 0.81425f
C21060 sg13cmos5l_dlhr_1_19.Q_N VGND 0.23106f
C21061 a_15412_5800# VGND 0.00785f
C21062 a_15132_5814# VGND 0.00409f
C21063 a_15702_5842# VGND 0.32076f
C21064 a_15177_5769# VGND 0.52418f
C21065 a_14996_5412# VGND 0.19014f
C21066 a_14929_5814# VGND 0
C21067 a_14152_5498# VGND 0.09441f ; **FLOATING
C21068 a_13698_5412# VGND 0.0019f
C21069 a_13486_5412# VGND 0.00236f
C21070 a_13034_5412# VGND 0.0011f
C21071 a_14714_5776# VGND 0.10858f
C21072 a_14377_5770# VGND 0.17668f
C21073 a_14583_5770# VGND 0.83899f
C21074 a_13792_5760# VGND 0.00174f
C21075 sg13cmos5l_a22oi_1_1.B2 VGND 0.95892f
C21076 a_13486_5760# VGND 0.00191f
C21077 sg13cmos5l_and3_1_0.X VGND 0.31558f
C21078 a_12800_5498# VGND 0.03815f ; **FLOATING
C21079 a_12616_5498# VGND 0.0776f ; **FLOATING
C21080 a_11771_5412# VGND 0.00809f
C21081 a_10420_5412# VGND 0.00172f
C21082 a_10318_5412# VGND 0.00177f
C21083 a_13076_5376# VGND 0.20703f
C21084 a_11873_5760# VGND 0.01159f
C21085 sg13cmos5l_a221oi_1_0.B2 VGND 0.20155f
C21086 a_11370_5760# VGND 0.00115f
C21087 a_11268_5760# VGND 0.00381f
C21088 sg13cmos5l_a221oi_1_0.B1 VGND 0.28888f
C21089 sg13cmos5l_nor2b_1_0.Y VGND 1.55646f
C21090 sg13cmos5l_inv_1_0.A VGND 1.66101f
C21091 a_10726_5760# VGND 0.00161f
C21092 a_10420_5760# VGND 0.00162f
C21093 a_10024_5498# VGND 0.08254f ; **FLOATING
C21094 a_8774_5412# VGND 0
C21095 a_8592_5412# VGND 0
C21096 sg13cmos5l_a22oi_1_2.B2 VGND 0.86395f
C21097 a_11072_5347# VGND 0.11699f
C21098 sg13cmos5l_a221oi_1_0.C1 VGND 0.85773f
C21099 sg13cmos5l_a221oi_1_1.C1 VGND 0.30247f
C21100 sg13cmos5l_or2_1_1.B VGND 0.76339f
C21101 a_12216_5728# VGND 0.463f
C21102 sg13cmos5l_nor2_1_0.A VGND 2.68988f
C21103 sg13cmos5l_dlhr_1_17.Q_N VGND 0.2307f
C21104 sg13cmos5l_buf_1_45.A VGND 0.45988f
C21105 a_9076_5800# VGND 0.00784f
C21106 a_6843_5459# VGND 0
C21107 a_8796_5814# VGND 0.00409f
C21108 a_9366_5842# VGND 0.31869f
C21109 a_8841_5769# VGND 0.52253f
C21110 a_8660_5412# VGND 0.18939f
C21111 a_8593_5814# VGND 0
C21112 sg13cmos5l_a221oi_1_0.A2 VGND 0.84238f
C21113 a_8378_5776# VGND 0.09523f
C21114 a_8041_5770# VGND 0.18931f
C21115 a_8247_5770# VGND 0.80993f
C21116 a_7394_5850# VGND 0
C21117 a_5710_5535# VGND 0
C21118 a_6647_5459# VGND 0.24832f
C21119 a_6741_5459# VGND 0.08841f
C21120 a_6998_5837# VGND 0
C21121 a_6602_5692# VGND 0.03781f
C21122 sg13cmos5l_dfrbp_1_11.Q VGND 1.02802f
C21123 a_5951_5383# VGND 0.44234f
C21124 a_5799_5499# VGND 0.19594f
C21125 a_5710_5850# VGND 0.11563f
C21126 a_5546_5850# VGND 0.00365f
C21127 sg13cmos5l_dfrbp_1_29.Q_N VGND 0.10436f
C21128 a_4736_5498# VGND 0.06059f ; **FLOATING
C21129 a_5820_5773# VGND 1.74209f
C21130 a_5452_5850# VGND 0.26769f
C21131 a_5069_5376# VGND 0.40664f
C21132 a_4950_5699# VGND 0.29634f
C21133 a_2169_5535# VGND 0
C21134 a_4076_5376# VGND 0.2637f
C21135 sg13cmos5l_dlhr_1_1.Q VGND 0.44304f
C21136 sg13cmos5l_dlhr_1_1.D VGND 0.2848f
C21137 a_1065_5459# VGND 0
C21138 a_2386_5850# VGND 0.00348f
C21139 a_1873_5773# VGND 0.11582f
C21140 a_3308_5376# VGND 0.25344f
C21141 a_2804_5412# VGND 0.31269f
C21142 a_1967_5773# VGND 0.40249f
C21143 a_2224_5654# VGND 0.26836f
C21144 a_1227_5423# VGND 0.19698f
C21145 a_996_5837# VGND 0.03806f
C21146 a_934_5837# VGND 0
C21147 a_1125_5423# VGND 0.44587f
C21148 a_708_5416# VGND 1.74345f
C21149 a_682_5380# VGND 0.08705f
C21150 a_516_5850# VGND 0
C21151 a_422_5850# VGND 0.22647f
C21152 a_20672_6294# VGND 0.07503f ; **FLOATING
C21153 a_20488_6294# VGND 0.07793f ; **FLOATING
C21154 a_19828_6148# VGND 0.00766f
C21155 a_19548_6198# VGND 0.00394f
C21156 a_19345_6154# VGND 0
C21157 sg13cmos5l_dlhr_1_10.Q_N VGND 0.28084f
C21158 a_17938_6162# VGND 0.00361f
C21159 a_19344_6484# VGND 0
C21160 a_20118_6144# VGND 0.31823f
C21161 a_19412_6484# VGND 0.1871f
C21162 a_19593_6162# VGND 0.54073f
C21163 a_19130_6172# VGND 0.09095f
C21164 a_18793_6216# VGND 0.16879f
C21165 a_18999_6178# VGND 0.80933f
C21166 sg13cmos5l_dfrbp_1_21.Q VGND 0.91816f
C21167 sg13cmos5l_dfrbp_1_21.Q_N VGND 0.35429f
C21168 a_17425_6239# VGND 0.11539f
C21169 a_16486_6175# VGND 0
C21170 a_16548_6175# VGND 0.03734f
C21171 a_17721_6477# VGND 0
C21172 a_18356_6460# VGND 0.29416f
C21173 a_17776_6382# VGND 0.2682f
C21174 a_17519_6239# VGND 0.40057f
C21175 a_16068_6162# VGND 0
C21176 a_16779_6284# VGND 0.19715f
C21177 a_16677_6141# VGND 0.43833f
C21178 a_16260_6480# VGND 1.73759f
C21179 a_15974_6162# VGND 0.20007f
C21180 a_16234_6385# VGND 0.08294f
C21181 sg13cmos5l_buf_1_4.A VGND 0.87768f
C21182 a_15016_6294# VGND 0.08228f ; **FLOATING
C21183 a_14194_6162# VGND 0.00356f
C21184 sg13cmos5l_dfrbp_1_23.Q_N VGND 0.28345f
C21185 a_13681_6239# VGND 0.11642f
C21186 a_12742_6175# VGND 0
C21187 a_12804_6175# VGND 0.04638f
C21188 a_13977_6477# VGND 0
C21189 a_15592_6200# VGND 0.20336f
C21190 sg13cmos5l_buf_1_116.A VGND 0.35313f
C21191 a_15208_6200# VGND 0.2097f
C21192 a_14612_6460# VGND 0.2901f
C21193 a_14032_6382# VGND 0.27283f
C21194 a_13775_6239# VGND 0.41093f
C21195 a_12324_6162# VGND 0
C21196 a_12873_6553# VGND 0
C21197 a_13035_6284# VGND 0.20541f
C21198 a_12933_6141# VGND 0.45384f
C21199 a_12516_6480# VGND 1.75455f
C21200 a_12230_6162# VGND 0.24642f
C21201 a_12490_6385# VGND 0.09716f
C21202 a_11752_6294# VGND 0.10157f ; **FLOATING
C21203 sg13cmos5l_inv_1_29.Y VGND 0.40912f
C21204 a_9268_6148# VGND 0.00765f
C21205 a_8988_6198# VGND 0.00404f
C21206 a_8785_6154# VGND 0
C21207 sg13cmos5l_buf_1_29.A VGND 0.92028f
C21208 sg13cmos5l_dlhr_1_6.Q_N VGND 0.2271f
C21209 a_7378_6162# VGND 0.00361f
C21210 a_8784_6484# VGND 0
C21211 a_10412_6126# VGND 0.24988f
C21212 sg13cmos5l_buf_1_56.A VGND 0.28371f
C21213 a_10028_6126# VGND 0.20557f
C21214 a_9558_6144# VGND 0.31922f
C21215 a_8852_6484# VGND 0.1876f
C21216 a_9033_6162# VGND 0.51815f
C21217 a_8570_6172# VGND 0.08953f
C21218 a_8233_6216# VGND 0.16573f
C21219 a_8439_6178# VGND 0.80748f
C21220 sg13cmos5l_dlhr_1_6.D VGND 0.95926f
C21221 a_6865_6239# VGND 0.11535f
C21222 a_5926_6175# VGND 0
C21223 a_5988_6175# VGND 0.03753f
C21224 a_7161_6477# VGND 0
C21225 a_7796_6460# VGND 0.29321f
C21226 a_7216_6382# VGND 0.2684f
C21227 a_6959_6239# VGND 0.39938f
C21228 a_5508_6162# VGND 0
C21229 a_6219_6284# VGND 0.20541f
C21230 a_6117_6141# VGND 0.45744f
C21231 a_5700_6480# VGND 1.74003f
C21232 a_5414_6162# VGND 0.22485f
C21233 a_5312_6294# VGND 0.05577f ; **FLOATING
C21234 a_4322_6162# VGND 0
C21235 a_5674_6385# VGND 0.09744f
C21236 a_2638_6162# VGND 0.12665f
C21237 a_2474_6162# VGND 0.00375f
C21238 a_3530_6320# VGND 0.03965f
C21239 a_4652_6126# VGND 0.24938f
C21240 a_3771_6553# VGND 0
C21241 a_3669_6320# VGND 0.08672f
C21242 a_3575_6553# VGND 0.20556f
C21243 a_2748_6126# VGND 1.76985f
C21244 a_2638_6477# VGND 0
C21245 a_2727_6380# VGND 0.21033f
C21246 a_2380_6162# VGND 0.26855f
C21247 a_2879_6432# VGND 0.462f
C21248 sg13cmos5l_dfrbp_1_15.Q_N VGND 0.10303f
C21249 a_1280_6294# VGND 0.03846f ; **FLOATING
C21250 a_1096_6294# VGND 0.1193f ; **FLOATING
C21251 a_1997_6126# VGND 0.40523f
C21252 a_1878_6337# VGND 0.29191f
C21253 a_1484_6126# VGND 0.2085f
C21254 a_20288_7010# VGND 0.05844f ; **FLOATING
C21255 a_20392_6924# VGND 0.23637f
C21256 a_19424_7010# VGND 0.04236f ; **FLOATING
C21257 sg13cmos5l_dlhr_1_10.Q VGND 0.34212f
C21258 a_19528_6924# VGND 0.23732f
C21259 a_18568_7010# VGND 0.08598f ; **FLOATING
C21260 a_18860_6888# VGND 0.22435f
C21261 sg13cmos5l_dfrbp_1_8.D VGND 1.22772f
C21262 sg13cmos5l_dfrbp_1_22.Q_N VGND 0.10205f
C21263 a_17746_7362# VGND 0.00348f
C21264 a_17233_7285# VGND 0.11471f
C21265 a_18164_6924# VGND 0.28827f
C21266 a_17327_7285# VGND 0.39516f
C21267 a_17584_7166# VGND 0.26614f
C21268 a_16587_6935# VGND 0.19358f
C21269 a_16356_7349# VGND 0.03666f
C21270 a_14640_6924# VGND 0
C21271 a_16485_6935# VGND 0.43968f
C21272 a_16068_6928# VGND 1.7354f
C21273 a_16042_6892# VGND 0.08278f
C21274 a_15876_7362# VGND 0
C21275 a_15782_7362# VGND 0.19874f
C21276 sg13cmos5l_dlhr_1_13.Q_N VGND 0.22626f
C21277 sg13cmos5l_buf_1_89.A VGND 0.28768f
C21278 a_15124_7312# VGND 0.00751f
C21279 a_13094_6924# VGND 0
C21280 a_12912_6924# VGND 0
C21281 a_14844_7326# VGND 0.00388f
C21282 a_15414_7354# VGND 0.31277f
C21283 a_14889_7281# VGND 0.51389f
C21284 a_14708_6924# VGND 0.18173f
C21285 a_14641_7326# VGND 0
C21286 sg13cmos5l_dfrbp_1_23.Q VGND 0.55804f
C21287 a_14426_7288# VGND 0.09115f
C21288 a_14089_7282# VGND 0.16319f
C21289 a_14295_7282# VGND 0.80737f
C21290 sg13cmos5l_dlhr_1_11.Q_N VGND 0.24612f
C21291 a_13396_7312# VGND 0.00796f
C21292 a_13116_7326# VGND 0.00423f
C21293 a_13686_7354# VGND 0.31978f
C21294 a_13161_7281# VGND 0.52187f
C21295 a_12980_6924# VGND 0.20193f
C21296 a_12913_7326# VGND 0.00171f
C21297 a_12698_7288# VGND 0.11462f
C21298 a_12361_7282# VGND 0.18696f
C21299 a_12567_7282# VGND 0.8216f
C21300 a_11560_7010# VGND 0.09279f ; **FLOATING
C21301 sg13cmos5l_dlhr_1_18.Q_N VGND 0.23963f
C21302 a_10900_7312# VGND 0.00751f
C21303 a_10620_7326# VGND 0.00388f
C21304 a_11190_7354# VGND 0.31661f
C21305 a_10665_7281# VGND 0.53982f
C21306 a_10484_6924# VGND 0.19987f
C21307 a_10417_7326# VGND 0
C21308 a_10202_7288# VGND 0.08788f
C21309 a_9865_7282# VGND 0.16211f
C21310 a_10071_7282# VGND 0.80383f
C21311 a_9344_7010# VGND 0.0422f ; **FLOATING
C21312 sg13cmos5l_buf_1_31.X VGND 0.90932f
C21313 a_9448_6924# VGND 0.20927f
C21314 sg13cmos5l_dlhr_1_5.Q_N VGND 0.24764f
C21315 sg13cmos5l_dlhr_1_5.Q VGND 0.33414f
C21316 a_8692_7312# VGND 0.00751f
C21317 a_8412_7326# VGND 0.00388f
C21318 a_8982_7354# VGND 0.31457f
C21319 a_8457_7281# VGND 0.51653f
C21320 a_8276_6924# VGND 0.18643f
C21321 a_8209_7326# VGND 0
C21322 a_7520_7010# VGND 0.03812f ; **FLOATING
C21323 a_7336_7010# VGND 0.11883f ; **FLOATING
C21324 a_4358_6924# VGND 0
C21325 a_4176_6924# VGND 0
C21326 sg13cmos5l_dlhr_1_5.D VGND 0.24064f
C21327 a_7994_7288# VGND 0.08791f
C21328 a_7657_7282# VGND 0.18896f
C21329 a_7863_7282# VGND 0.80445f
C21330 sg13cmos5l_dlhr_1_7.Q_N VGND 0.32805f
C21331 sg13cmos5l_buf_1_59.A VGND 0.32456f
C21332 a_4660_7312# VGND 0.0076f
C21333 a_4380_7326# VGND 0.00401f
C21334 a_4950_7354# VGND 0.3586f
C21335 a_4425_7281# VGND 0.52968f
C21336 a_4244_6924# VGND 0.18978f
C21337 a_4177_7326# VGND 0
C21338 a_3488_7010# VGND 0.04479f ; **FLOATING
C21339 a_3962_7288# VGND 0.0932f
C21340 a_3625_7282# VGND 0.17029f
C21341 a_3831_7282# VGND 0.80743f
C21342 sg13cmos5l_buf_1_41.A VGND 0.71326f
C21343 sg13cmos5l_dfrbp_1_16.Q VGND 0.78678f
C21344 a_2386_7362# VGND 0.00348f
C21345 a_1873_7285# VGND 0.11471f
C21346 a_2804_6924# VGND 0.30659f
C21347 a_1967_7285# VGND 0.39925f
C21348 a_2224_7166# VGND 0.26815f
C21349 a_1227_6935# VGND 0.19277f
C21350 a_996_7349# VGND 0.03666f
C21351 a_1125_6935# VGND 0.44464f
C21352 a_708_6928# VGND 1.73685f
C21353 a_682_6892# VGND 0.08465f
C21354 a_516_7362# VGND 0
C21355 a_422_7362# VGND 0.22285f
C21356 a_19904_7806# VGND 0.04341f ; **FLOATING
C21357 a_18580_7660# VGND 0.00751f
C21358 a_18300_7710# VGND 0.00388f
C21359 a_18097_7666# VGND 0
C21360 a_20392_7712# VGND 0.21924f
C21361 sg13cmos5l_buf_8_0.X VGND 1.48791f
C21362 a_20008_7712# VGND 0.21035f
C21363 sg13cmos5l_buf_1_18.A VGND 0.72044f
C21364 sg13cmos5l_dlhr_1_15.Q_N VGND 0.24784f
C21365 a_16690_7674# VGND 0.00348f
C21366 a_19240_7712# VGND 0.20486f
C21367 sg13cmos5l_dlhr_1_15.Q VGND 0.33124f
C21368 a_18870_7656# VGND 0.3179f
C21369 a_18164_7996# VGND 0.1861f
C21370 a_18345_7674# VGND 0.52133f
C21371 a_17882_7684# VGND 0.08951f
C21372 a_17545_7728# VGND 0.16647f
C21373 a_17751_7690# VGND 0.80764f
C21374 sg13cmos5l_dlhr_1_15.D VGND 0.91594f
C21375 a_16177_7751# VGND 0.11471f
C21376 a_15300_7687# VGND 0.03666f
C21377 a_17108_7972# VGND 0.29151f
C21378 a_16528_7894# VGND 0.26642f
C21379 a_16271_7751# VGND 0.39913f
C21380 a_14820_7674# VGND 0
C21381 a_15531_7796# VGND 0.19316f
C21382 a_15429_7653# VGND 0.43745f
C21383 a_15012_7992# VGND 1.7346f
C21384 a_14726_7674# VGND 0.20462f
C21385 a_14536_7806# VGND 0.08024f ; **FLOATING
C21386 a_13876_7660# VGND 0.00771f
C21387 a_13596_7710# VGND 0.00398f
C21388 a_13393_7666# VGND 0
C21389 a_14986_7897# VGND 0.08176f
C21390 sg13cmos5l_dlhr_1_14.Q_N VGND 0.23801f
C21391 a_11986_7674# VGND 0.00348f
C21392 a_13574_8112# VGND 0
C21393 a_13392_7996# VGND 0
C21394 a_14166_7656# VGND 0.31564f
C21395 a_13460_7996# VGND 0.19013f
C21396 a_13641_7674# VGND 0.52569f
C21397 a_13178_7684# VGND 0.09495f
C21398 a_12841_7728# VGND 0.18198f
C21399 a_13047_7690# VGND 0.81754f
C21400 sg13cmos5l_inv_1_29.A VGND 0.86716f
C21401 sg13cmos5l_dlhr_1_11.D VGND 0.32271f
C21402 a_11473_7751# VGND 0.11475f
C21403 a_10596_7687# VGND 0.03666f
C21404 a_12404_7972# VGND 0.29196f
C21405 a_11824_7894# VGND 0.26826f
C21406 a_11567_7751# VGND 0.4013f
C21407 a_10116_7674# VGND 0
C21408 a_9202_7674# VGND 0.00348f
C21409 a_10827_7796# VGND 0.19591f
C21410 a_10725_7653# VGND 0.44989f
C21411 a_10308_7992# VGND 1.73435f
C21412 a_10022_7674# VGND 0.19952f
C21413 sg13cmos5l_buf_1_57.X VGND 0.96571f
C21414 a_10282_7897# VGND 0.08196f
C21415 sg13cmos5l_dfrbp_1_20.Q VGND 0.72443f
C21416 a_8689_7751# VGND 0.11471f
C21417 a_7812_7687# VGND 0.03666f
C21418 a_9620_7972# VGND 0.28964f
C21419 a_9040_7894# VGND 0.2677f
C21420 a_8783_7751# VGND 0.39934f
C21421 a_7332_7674# VGND 0
C21422 a_4514_7666# VGND 0
C21423 a_4311_7710# VGND 0.00402f
C21424 a_8043_7796# VGND 0.19335f
C21425 a_7941_7653# VGND 0.43745f
C21426 a_7524_7992# VGND 1.73648f
C21427 a_7238_7674# VGND 0.22993f
C21428 sg13cmos5l_dfrbp_1_6.D VGND 3.33896f
C21429 a_7498_7897# VGND 0.08207f
C21430 a_4034_7660# VGND 0.00778f
C21431 sg13cmos5l_buf_1_30.A VGND 0.87454f
C21432 sg13cmos5l_buf_1_24.A VGND 0.79941f
C21433 a_6380_7638# VGND 0.21848f
C21434 a_2786_7666# VGND 0
C21435 a_2583_7710# VGND 0.00421f
C21436 sg13cmos5l_dlhr_1_9.D VGND 0.83666f
C21437 sg13cmos5l_dlhr_1_1.GATE VGND 0.94037f
C21438 a_4518_7996# VGND 0
C21439 a_4282_8112# VGND 0
C21440 sg13cmos5l_dlhr_1_9.Q VGND 0.58362f
C21441 a_2306_7660# VGND 0.00751f
C21442 sg13cmos5l_dlhr_1_9.Q_N VGND 0.24816f
C21443 sg13cmos5l_dfrbp_1_16.Q_N VGND 0.47956f
C21444 a_4559_7630# VGND 0.21552f
C21445 a_4349_7636# VGND 0.80692f
C21446 a_4324_7996# VGND 0.09253f
C21447 a_4076_7624# VGND 0.1874f
C21448 a_3676_7964# VGND 0.52039f
C21449 a_3574_7850# VGND 0.32028f
C21450 a_2790_7996# VGND 0
C21451 a_2554_8112# VGND 0
C21452 sg13cmos5l_buf_1_58.A VGND 0.4137f
C21453 a_1664_7806# VGND 0.03787f ; **FLOATING
C21454 a_1480_7806# VGND 0.07409f ; **FLOATING
C21455 sg13cmos5l_dlhr_1_8.Q_N VGND 0.2549f
C21456 a_2831_7630# VGND 0.17371f
C21457 a_2621_7636# VGND 0.82976f
C21458 a_2596_7996# VGND 0.11414f
C21459 a_2348_7624# VGND 0.18851f
C21460 a_1948_7964# VGND 0.51832f
C21461 a_1846_7850# VGND 0.31555f
C21462 a_1088_7806# VGND 0.03879f ; **FLOATING
C21463 a_904_7806# VGND 0.07707f ; **FLOATING
C21464 a_416_7806# VGND 0.08103f ; **FLOATING
C21465 sg13cmos5l_buf_1_40.A VGND 0.80617f
C21466 a_620_7638# VGND 0.21219f
C21467 sg13cmos5l_buf_1_86.A VGND 0.31084f
C21468 sg13cmos5l_inv_1_6.A VGND 0.79129f
C21469 sg13cmos5l_buf_1_104.X VGND 0.29585f
C21470 sg13cmos5l_buf_1_19.A VGND 0.77529f
C21471 a_20492_8400# VGND 0.26074f
C21472 a_20008_8436# VGND 0.20599f
C21473 a_19624_8436# VGND 0.20764f
C21474 a_19340_8400# VGND 0.20902f
C21475 a_18856_8436# VGND 0.2055f
C21476 sg13cmos5l_dlhr_1_12.Q_N VGND 0.24784f
C21477 sg13cmos5l_buf_1_105.A VGND 0.30663f
C21478 a_18196_8824# VGND 0.00751f
C21479 a_17916_8838# VGND 0.00388f
C21480 a_18486_8866# VGND 0.31808f
C21481 a_17961_8793# VGND 0.51746f
C21482 a_17780_8436# VGND 0.18691f
C21483 a_17713_8838# VGND 0
C21484 sg13cmos5l_dlhr_1_12.D VGND 0.25698f
C21485 a_17498_8800# VGND 0.08937f
C21486 a_17161_8794# VGND 0.1655f
C21487 a_17367_8794# VGND 0.81217f
C21488 sg13cmos5l_dfrbp_1_22.D VGND 0.72119f
C21489 sg13cmos5l_dfrbp_1_25.Q_N VGND 0.10205f
C21490 a_16306_8874# VGND 0.00348f
C21491 a_15793_8797# VGND 0.11471f
C21492 a_16724_8436# VGND 0.29145f
C21493 a_15887_8797# VGND 0.40258f
C21494 a_16144_8678# VGND 0.26662f
C21495 a_15147_8447# VGND 0.19402f
C21496 a_14916_8861# VGND 0.03666f
C21497 a_14152_8522# VGND 0.08066f ; **FLOATING
C21498 a_15045_8447# VGND 0.44878f
C21499 a_14628_8440# VGND 1.73773f
C21500 a_14602_8404# VGND 0.08263f
C21501 a_14436_8874# VGND 0
C21502 a_14342_8874# VGND 0.20557f
C21503 sg13cmos5l_buf_1_98.A VGND 0.31095f
C21504 sg13cmos5l_dlhr_1_11.Q VGND 0.37844f
C21505 sg13cmos5l_buf_1_5.A VGND 1.34797f
C21506 sg13cmos5l_buf_1_10.A VGND 0.82634f
C21507 sg13cmos5l_inv_1_7.A VGND 2.43271f
C21508 a_11272_8522# VGND 0.08487f ; **FLOATING
C21509 sg13cmos5l_buf_1_96.A VGND 0.42721f
C21510 a_13768_8436# VGND 0.20775f
C21511 a_13484_8400# VGND 0.20974f
C21512 a_13100_8400# VGND 0.21141f
C21513 a_12716_8400# VGND 0.21391f
C21514 a_12232_8436# VGND 0.20487f
C21515 a_11848_8436# VGND 0.20368f
C21516 a_11464_8436# VGND 0.20954f
C21517 sg13cmos5l_dfrbp_1_27.Q_N VGND 0.10205f
C21518 a_10450_8874# VGND 0.00348f
C21519 a_9937_8797# VGND 0.11471f
C21520 a_10868_8436# VGND 0.28907f
C21521 a_10031_8797# VGND 0.39529f
C21522 a_10288_8678# VGND 0.26606f
C21523 a_9291_8447# VGND 0.19481f
C21524 a_9060_8861# VGND 0.03666f
C21525 a_9189_8447# VGND 0.449f
C21526 a_8772_8440# VGND 1.73711f
C21527 a_8746_8404# VGND 0.08176f
C21528 a_8580_8874# VGND 0
C21529 a_8486_8874# VGND 0.19952f
C21530 sg13cmos5l_dfrbp_1_18.Q_N VGND 0.10205f
C21531 a_7666_8874# VGND 0.00348f
C21532 a_7153_8797# VGND 0.11471f
C21533 a_8084_8436# VGND 0.29054f
C21534 a_7247_8797# VGND 0.40154f
C21535 a_7504_8678# VGND 0.26636f
C21536 a_6507_8447# VGND 0.19443f
C21537 a_6276_8861# VGND 0.03666f
C21538 a_5600_8522# VGND 0.04408f ; **FLOATING
C21539 a_3609_8559# VGND 0
C21540 a_6405_8447# VGND 0.45053f
C21541 a_5988_8440# VGND 1.73642f
C21542 a_5962_8404# VGND 0.09354f
C21543 a_5796_8874# VGND 0
C21544 a_5702_8874# VGND 0.22204f
C21545 sg13cmos5l_dlhr_1_5.GATE VGND 1.09396f
C21546 sg13cmos5l_dfrbp_1_15.D VGND 0.93705f
C21547 sg13cmos5l_dfrbp_1_17.Q_N VGND 0.10326f
C21548 a_2505_8483# VGND 0
C21549 a_3826_8874# VGND 0.00366f
C21550 a_3313_8797# VGND 0.11623f
C21551 a_4244_8436# VGND 0.2925f
C21552 a_3407_8797# VGND 0.40672f
C21553 a_3664_8678# VGND 0.26766f
C21554 a_2667_8447# VGND 0.22096f
C21555 a_2436_8861# VGND 0.03932f
C21556 a_2565_8447# VGND 0.47087f
C21557 a_2148_8440# VGND 1.7508f
C21558 a_2122_8404# VGND 0.08368f
C21559 a_1956_8874# VGND 0
C21560 a_1862_8874# VGND 0.21601f
C21561 sg13cmos5l_dfrbp_1_17.D VGND 0.128f
C21562 a_1662_8374# VGND 0.06781f
C21563 a_1463_8741# VGND 0.10617f
C21564 sg13cmos5l_buf_1_63.A VGND 0.24401f
C21565 sg13cmos5l_buf_1_63.X VGND 0.34538f
C21566 a_1463_8511# VGND 0.12604f
C21567 a_1196_8400# VGND 0.20542f
C21568 a_424_8436# VGND 0.25991f
C21569 sg13cmos5l_buf_1_104.A VGND 0.42352f
C21570 sg13cmos5l_buf_8_2.X VGND 1.11184f
C21571 a_19136_9318# VGND 0.04305f ; **FLOATING
C21572 sg13cmos5l_buf_1_87.A VGND 0.4057f
C21573 a_18272_9318# VGND 0.04501f ; **FLOATING
C21574 sg13cmos5l_buf_1_107.X VGND 0.40522f
C21575 a_17792_9318# VGND 0.04318f ; **FLOATING
C21576 a_16160_9318# VGND 0.04447f ; **FLOATING
C21577 a_13810_9186# VGND 0.00366f
C21578 sg13cmos5l_dfrbp_1_23.CLK VGND 0.92114f
C21579 sg13cmos5l_dfrbp_1_24.Q_N VGND 0.10352f
C21580 a_13297_9263# VGND 0.1169f
C21581 a_12420_9199# VGND 0.03802f
C21582 a_13593_9501# VGND 0
C21583 sg13cmos5l_buf_1_3.A VGND 1.1933f
C21584 a_19227_9190# VGND 1.00835f
C21585 sg13cmos5l_buf_1_101.X VGND 0.35359f
C21586 a_18860_9150# VGND 0.21375f
C21587 a_18376_9224# VGND 0.21077f
C21588 sg13cmos5l_buf_1_111.A VGND 0.58251f
C21589 a_17896_9224# VGND 0.21171f
C21590 sg13cmos5l_inv_1_26.Y VGND 0.60768f
C21591 sg13cmos5l_buf_1_103.A VGND 0.26462f
C21592 a_17516_9150# VGND 0.21329f
C21593 sg13cmos5l_buf_1_94.X VGND 0.23336f
C21594 a_17132_9150# VGND 0.20898f
C21595 sg13cmos5l_buf_1_93.X VGND 0.39446f
C21596 a_16748_9150# VGND 0.2085f
C21597 a_16264_9224# VGND 0.21222f
C21598 sg13cmos5l_inv_1_1.A VGND 0.74449f
C21599 a_15784_9224# VGND 0.20831f
C21600 sg13cmos5l_buf_1_110.A VGND 0.49339f
C21601 sg13cmos5l_buf_1_95.X VGND 0.46764f
C21602 a_15500_9150# VGND 0.21036f
C21603 a_15016_9224# VGND 0.20722f
C21604 sg13cmos5l_inv_1_3.A VGND 0.96058f
C21605 a_14632_9224# VGND 0.20759f
C21606 sg13cmos5l_inv_1_27.Y VGND 0.48757f
C21607 a_14228_9484# VGND 0.29442f
C21608 a_13648_9406# VGND 0.2728f
C21609 a_13391_9263# VGND 0.42057f
C21610 a_11940_9186# VGND 0
C21611 a_12489_9577# VGND 0
C21612 a_12651_9308# VGND 0.21864f
C21613 a_12549_9165# VGND 0.4777f
C21614 a_12132_9504# VGND 1.74558f
C21615 a_11846_9186# VGND 0.20363f
C21616 sg13cmos5l_dlhr_1_11.GATE VGND 0.99577f
C21617 sg13cmos5l_dfrbp_1_8.RESET_B VGND 7.42214f
C21618 a_12106_9409# VGND 0.08792f
C21619 sg13cmos5l_buf_1_90.X VGND 0.50369f
C21620 a_11360_9318# VGND 0.04398f ; **FLOATING
C21621 a_10708_9172# VGND 0.00751f
C21622 a_10428_9222# VGND 0.00388f
C21623 a_10225_9178# VGND 0
C21624 sg13cmos5l_dlhr_1_21.Q_N VGND 0.24764f
C21625 sg13cmos5l_buf_1_97.A VGND 0.38959f
C21626 a_11464_9224# VGND 0.20883f
C21627 sg13cmos5l_inv_1_28.Y VGND 0.43627f
C21628 a_10998_9168# VGND 0.31763f
C21629 sg13cmos5l_dfrbp_1_6.RESET_B VGND 13.4442f
C21630 a_10292_9508# VGND 0.19057f
C21631 a_10473_9186# VGND 0.53024f
C21632 a_10010_9196# VGND 0.0934f
C21633 a_9673_9240# VGND 0.16985f
C21634 a_9879_9202# VGND 0.81816f
C21635 sg13cmos5l_dfrbp_1_18.Q VGND 0.87389f
C21636 sg13cmos5l_dfrbp_1_20.Q_N VGND 0.33685f
C21637 sg13cmos5l_buf_1_79.X VGND 0.41035f
C21638 sg13cmos5l_inv_1_2.A VGND 2.20895f
C21639 sg13cmos5l_buf_1_78.X VGND 0.32362f
C21640 a_9256_9224# VGND 0.20985f
C21641 sg13cmos5l_inv_1_18.A VGND 1.02308f
C21642 sg13cmos5l_buf_1_77.A VGND 0.61464f
C21643 a_8972_9150# VGND 0.2091f
C21644 a_8488_9224# VGND 0.2086f
C21645 sg13cmos5l_buf_1_45.X VGND 0.89944f
C21646 a_8204_9150# VGND 0.21145f
C21647 sg13cmos5l_buf_1_73.A VGND 0.41598f
C21648 a_7820_9150# VGND 0.20895f
C21649 a_7336_9224# VGND 0.21067f
C21650 sg13cmos5l_buf_1_77.X VGND 0.23185f
C21651 sg13cmos5l_inv_1_14.A VGND 0.93678f
C21652 a_7052_9150# VGND 0.21059f
C21653 a_6568_9224# VGND 0.20722f
C21654 sg13cmos5l_buf_1_74.X VGND 0.24f
C21655 a_6184_9224# VGND 0.2092f
C21656 sg13cmos5l_buf_1_78.A VGND 0.42372f
C21657 a_5800_9224# VGND 0.20672f
C21658 sg13cmos5l_buf_1_73.X VGND 0.40163f
C21659 a_5416_9224# VGND 0.21226f
C21660 sg13cmos5l_buf_1_76.X VGND 0.25602f
C21661 sg13cmos5l_buf_1_44.X VGND 1.0092f
C21662 a_5132_9150# VGND 0.20929f
C21663 a_3016_9318# VGND 0.09563f ; **FLOATING
C21664 sg13cmos5l_inv_1_8.A VGND 2.54473f
C21665 a_1760_9318# VGND 0.04363f ; **FLOATING
C21666 a_424_9318# VGND 0.12269f ; **FLOATING
C21667 sg13cmos5l_buf_1_34.X VGND 1.03011f
C21668 sg13cmos5l_buf_1_60.A VGND 0.2704f
C21669 a_4460_9150# VGND 0.21031f
C21670 a_3976_9224# VGND 0.21218f
C21671 sg13cmos5l_buf_1_64.A VGND 0.26574f
C21672 sg13cmos5l_inv_1_17.A VGND 1.19392f
C21673 a_3692_9150# VGND 0.21233f
C21674 sg13cmos5l_buf_1_65.X VGND 0.77256f
C21675 a_3308_9150# VGND 0.21133f
C21676 sg13cmos5l_inv_1_20.Y VGND 0.48693f
C21677 a_2732_9150# VGND 0.22199f
C21678 a_2248_9224# VGND 0.20823f
C21679 sg13cmos5l_buf_1_60.X VGND 0.54792f
C21680 a_1864_9224# VGND 0.21142f
C21681 sg13cmos5l_buf_1_62.X VGND 0.32005f
C21682 sg13cmos5l_inv_1_19.A VGND 1.31866f
C21683 a_1484_9150# VGND 0.2131f
C21684 a_1000_9224# VGND 0.20915f
C21685 sg13cmos5l_buf_1_61.X VGND 0.25294f
C21686 a_616_9224# VGND 0.24804f
C21687 sg13cmos5l_buf_1_68.X VGND 0.24919f
.ends
