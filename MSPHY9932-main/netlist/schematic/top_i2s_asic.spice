* NGSPICE file created from top_i2s_asic.ext - technology: ihp-sg13cmos5l

.subckt top_i2s_asic VSS VDD i2s_bclk i2s_lrck i2s_sdata rst_n sd_clk sd_out
XFILLER_27_417 VDD VSS sg13cmos5l_fill_1
XFILLER_27_428 VDD VSS sg13cmos5l_fill_1
X_6914_ _6918_/B _6914_/A VDD VSS sg13cmos5l_inv_1
XFILLER_23_667 VDD VSS sg13cmos5l_fill_1
XFILLER_35_483 VDD VSS sg13cmos5l_decap_4
X_3988_ _3990_/B _6675_/B _4001_/B _3986_/X VDD VSS sg13cmos5l_a21oi_1
X_5727_ _5756_/A _5728_/A _5728_/B VDD VSS sg13cmos5l_nor2_1
X_6845_ _6845_/Y _6871_/A _6844_/B _6990_/A VDD VSS sg13cmos5l_a21oi_1
X_6776_ _6776_/Y _7007_/Q _6777_/B VDD VSS sg13cmos5l_nand2_1
X_4609_ _7079_/D _4635_/B _4607_/Y _4608_/Y VDD VSS sg13cmos5l_a21oi_1
X_5589_ _5589_/Y _5588_/A _5588_/B _6480_/A VDD VSS sg13cmos5l_a21oi_1
X_5658_ _5701_/A _5660_/A _5660_/B VDD VSS sg13cmos5l_nor2_1
X_7259_ _7260_/D _7266_/CLK _7259_/D _6584_/B1 VDD VSS sg13cmos5l_dfrbpq_1
XFILLER_26_494 VDD VSS sg13cmos5l_fill_1
XFILLER_24_409 VDD VSS sg13cmos5l_fill_1
XFILLER_36_269 VDD VSS sg13cmos5l_fill_1
X_3842_ _3846_/C _3847_/A _3874_/A _3843_/B VDD VSS sg13cmos5l_a21oi_1
X_3911_ _3912_/B _5787_/B _4154_/B _5124_/A VDD VSS sg13cmos5l_o21ai_1
X_4891_ _4924_/B _4891_/A _4924_/A _4891_/C VDD VSS sg13cmos5l_nand3_1
X_4960_ _4984_/A _7088_/Q _4948_/B _4946_/X VDD VSS sg13cmos5l_a21oi_1
X_6630_ _6631_/C _6647_/B _6629_/A VDD VSS sg13cmos5l_nor2b_1
X_6561_ _6563_/B _6562_/A _6562_/B VDD VSS sg13cmos5l_and2_1
XFILLER_8_170 VDD VSS sg13cmos5l_fill_2
X_3773_ _3868_/B _3834_/A _3834_/B VDD VSS sg13cmos5l_and2_1
X_5374_ _5374_/X _5374_/A _5374_/B _5374_/C VDD VSS sg13cmos5l_and3_1
X_5443_ _5443_/Y _7083_/Q _5444_/B VDD VSS sg13cmos5l_nand2_1
X_5512_ _5547_/B _5513_/A _5513_/B _5513_/C VDD VSS sg13cmos5l_a21o_1
X_6492_ _6492_/Y _6480_/C _6489_/X _6488_/Y VDD VSS sg13cmos5l_a21oi_1
X_4187_ _4189_/B _7063_/Q _4186_/C _4183_/Y VDD VSS sg13cmos5l_a21oi_1
X_4256_ _4257_/C _4256_/A _4256_/B VDD VSS sg13cmos5l_xnor2_1
X_4325_ _4328_/C _4325_/A _4325_/B _4325_/C VDD VSS sg13cmos5l_or3_1
Xfanout105 _5381_/B _3797_/Y VDD VSS sg13cmos5l_buf_1
Xfanout116 _5330_/C _3809_/X VDD VSS sg13cmos5l_buf_1
Xfanout127 _6469_/A _5294_/B VDD VSS sg13cmos5l_buf_1
Xfanout138 _6436_/A _6925_/B1 VDD VSS sg13cmos5l_buf_1
Xfanout149 _6985_/A fanout166/X VDD VSS sg13cmos5l_buf_1
X_7113_ _7113_/Q _7243_/CLK _7113_/D _7113_/RESET_B VDD VSS sg13cmos5l_dfrbpq_1
X_7044_ _7044_/Q clkload7/A _7044_/D _7044_/RESET_B VDD VSS sg13cmos5l_dfrbpq_1
XFILLER_35_280 VDD VSS sg13cmos5l_fill_1
XFILLER_10_136 VDD VSS sg13cmos5l_fill_2
XFILLER_23_486 VDD VSS sg13cmos5l_fill_2
X_6828_ _6828_/Y _6830_/B _6827_/X _5212_/A VDD VSS sg13cmos5l_o21ai_1
X_6759_ _7033_/D _6742_/Y _6760_/B _6758_/Y VDD VSS sg13cmos5l_a21oi_1
XFILLER_19_704 VDD VSS sg13cmos5l_fill_1
X_4041_ _4041_/Y _4077_/A _4077_/B VDD VSS sg13cmos5l_nand2_1
X_4110_ _4127_/A _4111_/B _4111_/A VDD VSS sg13cmos5l_nand2b_1
X_5090_ _5092_/B _5090_/A _5090_/B VDD VSS sg13cmos5l_xnor2_1
XFILLER_37_523 VDD VSS sg13cmos5l_decap_4
X_4943_ _4977_/B _4944_/A _4944_/C _4997_/A VDD VSS sg13cmos5l_a21oi_1
X_5992_ _5992_/Y _7168_/Q _5992_/B VDD VSS sg13cmos5l_nor2_1
XFILLER_32_294 VDD VSS sg13cmos5l_fill_1
X_3756_ _3836_/C _7120_/Q _3756_/B _3756_/C VDD VSS sg13cmos5l_nor3_1
X_3825_ _3825_/X _4611_/A _4611_/C VDD VSS sg13cmos5l_and2_1
X_4874_ _4875_/B _4758_/Y _4920_/A _4872_/X VDD VSS sg13cmos5l_a21oi_1
X_6613_ _6613_/Y _6614_/A _6614_/B VDD VSS sg13cmos5l_nand2_1
X_6544_ _6546_/A _6544_/A _6569_/A _6544_/C VDD VSS sg13cmos5l_nor3_1
X_3687_ _3782_/A _7159_/Q _7158_/Q VDD VSS sg13cmos5l_nand2_1
X_5357_ _5359_/B _5357_/A _5357_/B VDD VSS sg13cmos5l_xor2_1
X_5426_ _7109_/D _5450_/A _5424_/B _5425_/Y VDD VSS sg13cmos5l_a21oi_1
X_6475_ _6475_/Y _6476_/A _6476_/B VDD VSS sg13cmos5l_nor2_1
XFILLER_28_523 VDD VSS sg13cmos5l_fill_2
X_4239_ _6179_/A _4239_/A _6528_/A VDD VSS sg13cmos5l_nor2_1
X_4308_ _4449_/B _7033_/Q _4308_/B _4308_/C VDD VSS sg13cmos5l_and3_1
X_5288_ _5321_/A _5286_/Y _5288_/B VDD VSS sg13cmos5l_nand2b_1
X_7027_ _7027_/Q _7224_/CLK _7027_/D _7027_/RESET_B VDD VSS sg13cmos5l_dfrbpq_1
X_7188__205 _7188_/RESET_B VDD VSS sg13cmos5l_tiehi
XFILLER_7_416 VDD VSS sg13cmos5l_fill_2
XFILLER_0_57 VDD VSS sg13cmos5l_fill_1
XFILLER_19_512 VDD VSS sg13cmos5l_decap_4
XFILLER_34_548 VDD VSS sg13cmos5l_fill_2
XFILLER_15_762 VDD VSS sg13cmos5l_fill_2
XFILLER_30_710 VDD VSS sg13cmos5l_fill_1
XFILLER_30_754 VDD VSS sg13cmos5l_fill_2
XFILLER_30_787 VDD VSS sg13cmos5l_fill_1
X_4590_ _4592_/B _7050_/Q _4577_/B _4575_/Y VDD VSS sg13cmos5l_a21oi_1
X_5211_ _5212_/B _5211_/A _5211_/B VDD VSS sg13cmos5l_or2_1
X_6191_ _6993_/D _6191_/A _6190_/Y VDD VSS sg13cmos5l_nor2b_1
X_6260_ _6260_/Y _6270_/B VDD VSS sg13cmos5l_inv_1
XFILLER_37_320 VDD VSS sg13cmos5l_fill_1
X_4024_ _4026_/B _4024_/A _4024_/B VDD VSS sg13cmos5l_xnor2_1
X_5073_ _7091_/D _5073_/A _5073_/B VDD VSS sg13cmos5l_nor2_1
X_5142_ _5176_/C _5142_/A _5142_/B _5142_/C VDD VSS sg13cmos5l_and3_1
X_7219__448 _7219_/RESET_B VDD VSS sg13cmos5l_tiehi
X_4926_ _4973_/A _5671_/A _4926_/B VDD VSS sg13cmos5l_nor2_1
X_5975_ _7164_/D _7164_/Q _5975_/A2 _5974_/Y VDD VSS sg13cmos5l_a21o_1
XFILLER_20_231 VDD VSS sg13cmos5l_fill_1
XFILLER_4_419 VDD VSS sg13cmos5l_fill_1
X_3739_ _3847_/A _7123_/Q _3898_/B VDD VSS sg13cmos5l_nand2_1
X_3808_ _3808_/Y _3808_/A _5267_/A VDD VSS sg13cmos5l_nand2_1
X_4788_ _4790_/B _7056_/Q _4745_/B _4743_/Y VDD VSS sg13cmos5l_a21o_1
X_4857_ _4858_/C _4812_/A _4812_/B _4810_/Y VDD VSS sg13cmos5l_o21ai_1
X_6527_ _6528_/B _6547_/A _6527_/B VDD VSS sg13cmos5l_nand2b_1
X_5409_ _5410_/B _5536_/A _5435_/A VDD VSS sg13cmos5l_nand2_1
X_6458_ _6458_/Y _6452_/Y _6457_/X _6436_/A VDD VSS sg13cmos5l_o21ai_1
X_6389_ _6409_/A _7011_/Q _6415_/B VDD VSS sg13cmos5l_nand2_1
XFILLER_16_526 VDD VSS sg13cmos5l_fill_1
XFILLER_16_548 VDD VSS sg13cmos5l_decap_8
XFILLER_22_507 VDD VSS sg13cmos5l_fill_1
XFILLER_34_356 VDD VSS sg13cmos5l_fill_1
X_5760_ _5760_/X _5760_/A _5760_/B VDD VSS sg13cmos5l_or2_1
X_4573_ _4587_/A _7077_/Q _4574_/B VDD VSS sg13cmos5l_nor2_1
X_4642_ _6593_/A _5330_/A _5330_/B _5381_/B VDD VSS sg13cmos5l_o21ai_1
X_4711_ _4744_/A _4696_/A _4696_/B _4694_/Y VDD VSS sg13cmos5l_o21ai_1
X_5691_ _5692_/C _5690_/B _5690_/C _7091_/Q VDD VSS sg13cmos5l_a21oi_1
X_6174_ _6991_/D _6174_/A _6172_/Y VDD VSS sg13cmos5l_nor2b_1
X_6243_ _6252_/B _6251_/A _6251_/B VDD VSS sg13cmos5l_nand2_1
X_7292_ _7292_/Q _7308_/CLK _7292_/D _7292_/RESET_B VDD VSS sg13cmos5l_dfrbpq_1
Xfanout7 _6907_/B _6860_/B VDD VSS sg13cmos5l_buf_1
X_7178__215 _7178_/RESET_B VDD VSS sg13cmos5l_tiehi
X_6312_ _6313_/B _7005_/Q _6707_/A VDD VSS sg13cmos5l_xnor2_1
XFILLER_37_150 VDD VSS sg13cmos5l_fill_2
X_4007_ _4617_/A _4239_/A _4681_/A VDD VSS sg13cmos5l_and2_1
X_5056_ _5059_/C _5056_/A _5056_/B _5098_/B VDD VSS sg13cmos5l_nand3_1
X_5125_ _5150_/B _5127_/A _5127_/B _5127_/C VDD VSS sg13cmos5l_a21oi_1
X_4909_ _4909_/Y _4910_/B _4910_/A VDD VSS sg13cmos5l_nor2b_1
X_5889_ _7137_/D _5901_/A _5889_/B VDD VSS sg13cmos5l_nor2_1
X_5958_ _5958_/Y _5956_/Y _5957_/Y _5983_/A2 VDD VSS sg13cmos5l_a21oi_1
X_7185__208 _7185_/RESET_B VDD VSS sg13cmos5l_tiehi
X_7317__391 _7317_/RESET_B VDD VSS sg13cmos5l_tiehi
X_7092__302 _7092_/RESET_B VDD VSS sg13cmos5l_tiehi
XFILLER_12_540 VDD VSS sg13cmos5l_decap_8
XANTENNA_5 _7147_/D VDD VSS sg13cmos5l_antennanp
XFILLER_35_610 VDD VSS sg13cmos5l_fill_2
X_6930_ _6931_/B _6930_/A _6930_/B VDD VSS sg13cmos5l_nand2_1
XFILLER_34_142 VDD VSS sg13cmos5l_fill_2
XFILLER_35_665 VDD VSS sg13cmos5l_fill_1
X_5743_ _5745_/B _5744_/B _5744_/C _5770_/A VDD VSS sg13cmos5l_a21o_1
X_5812_ _5812_/Y _5812_/A _5812_/B _5812_/C VDD VSS sg13cmos5l_nand3_1
X_6861_ _6863_/B _7039_/Q _6860_/B _4470_/A VDD VSS sg13cmos5l_a21oi_1
X_6792_ _6794_/B _7035_/Q _6792_/B VDD VSS sg13cmos5l_xnor2_1
X_4556_ _4556_/X _4556_/A _4556_/B VDD VSS sg13cmos5l_xor2_1
X_4625_ _4627_/B _4625_/A _4625_/B VDD VSS sg13cmos5l_xnor2_1
X_5674_ _5715_/B _5735_/A _5674_/B VDD VSS sg13cmos5l_xnor2_1
X_4487_ _4503_/B _7041_/Q _4488_/B VDD VSS sg13cmos5l_nand2_1
X_5108_ _5108_/Y _5109_/A _5109_/B VDD VSS sg13cmos5l_nor2_1
X_6157_ _7304_/D _7304_/Q _7272_/Q _6164_/S VDD VSS sg13cmos5l_mux2_1
X_6226_ _6229_/A _6226_/A _6226_/B VDD VSS sg13cmos5l_xnor2_1
X_7275_ _7275_/Q _7308_/CLK _7275_/D _7275_/RESET_B VDD VSS sg13cmos5l_dfrbpq_1
XFILLER_25_175 VDD VSS sg13cmos5l_fill_1
XFILLER_26_621 VDD VSS sg13cmos5l_fill_1
XFILLER_26_687 VDD VSS sg13cmos5l_fill_2
XFILLER_38_470 VDD VSS sg13cmos5l_fill_2
X_5039_ _5045_/A _5154_/A _5006_/B _5004_/Y VDD VSS sg13cmos5l_a21oi_1
X_6088_ _7197_/D _6066_/X _7197_/Q _6090_/S VDD VSS sg13cmos5l_mux2_1
XFILLER_5_514 VDD VSS sg13cmos5l_fill_1
XFILLER_17_665 VDD VSS sg13cmos5l_fill_2
XFILLER_31_112 VDD VSS sg13cmos5l_fill_1
X_4410_ _4412_/B _4410_/A _4410_/B _4410_/C VDD VSS sg13cmos5l_or3_1
X_5390_ _5393_/B _5492_/A _5390_/B VDD VSS sg13cmos5l_xnor2_1
X_4272_ _4272_/Y _4266_/A _4269_/Y _4271_/X VDD VSS sg13cmos5l_o21ai_1
X_4341_ _4352_/A _7030_/Q _4341_/B VDD VSS sg13cmos5l_xnor2_1
X_6011_ _6011_/Y _6011_/A _6010_/Y VDD VSS sg13cmos5l_nor2b_1
X_7060_ _7060_/Q _7104_/CLK _7060_/D _7060_/RESET_B VDD VSS sg13cmos5l_dfrbpq_1
XFILLER_23_624 VDD VSS sg13cmos5l_fill_2
XFILLER_27_407 VDD VSS sg13cmos5l_fill_2
XFILLER_39_278 VDD VSS sg13cmos5l_fill_1
X_7175__218 _7175_/RESET_B VDD VSS sg13cmos5l_tiehi
X_6913_ _6914_/A _6913_/A _6912_/Y VDD VSS sg13cmos5l_nor2b_1
X_3987_ _4001_/B _3987_/A _3987_/B VDD VSS sg13cmos5l_xor2_1
X_5726_ _5728_/B _7091_/Q _5690_/C _5687_/Y VDD VSS sg13cmos5l_a21oi_1
X_6844_ _6857_/B _6871_/A _6844_/B VDD VSS sg13cmos5l_nor2_1
X_6775_ _6777_/B _6775_/A _6775_/B VDD VSS sg13cmos5l_xor2_1
X_4539_ _4540_/B _4539_/A _4539_/B VDD VSS sg13cmos5l_xnor2_1
X_4608_ _4608_/Y _4635_/B _4607_/Y _5376_/A VDD VSS sg13cmos5l_o21ai_1
X_5588_ _5590_/A _5588_/A _5588_/B VDD VSS sg13cmos5l_nor2_1
X_5657_ _5660_/B _5657_/A _5657_/B VDD VSS sg13cmos5l_nor2_1
X_7258_ _7259_/D _7266_/CLK _7258_/D _6610_/A VDD VSS sg13cmos5l_dfrbpq_1
X_7082__312 _7082_/RESET_B VDD VSS sg13cmos5l_tiehi
X_6209_ _6210_/B _6209_/A _6209_/B VDD VSS sg13cmos5l_xor2_1
X_7189_ _7189_/Q _7220_/CLK _7189_/D _7189_/RESET_B VDD VSS sg13cmos5l_dfrbpq_1
XFILLER_13_123 VDD VSS sg13cmos5l_fill_1
XFILLER_14_613 VDD VSS sg13cmos5l_fill_2
XFILLER_26_440 VDD VSS sg13cmos5l_decap_4
XFILLER_9_105 VDD VSS sg13cmos5l_fill_2
X_7314__394 _7314_/RESET_B VDD VSS sg13cmos5l_tiehi
XFILLER_5_311 VDD VSS sg13cmos5l_fill_2
XFILLER_36_226 VDD VSS sg13cmos5l_fill_2
XFILLER_36_237 VDD VSS sg13cmos5l_fill_2
XFILLER_32_498 VDD VSS sg13cmos5l_fill_1
X_3772_ _3834_/B _3768_/B _3768_/C _3768_/A VDD VSS sg13cmos5l_o21ai_1
X_3841_ _3843_/B _5159_/A _7124_/Q VDD VSS sg13cmos5l_nor2_1
X_3910_ _4140_/A _6745_/A _4133_/B _3909_/A VDD VSS sg13cmos5l_a21oi_1
X_4890_ _4891_/C _4889_/B _4889_/C _4889_/A VDD VSS sg13cmos5l_o21ai_1
X_5511_ _5513_/C _5511_/A _5511_/B VDD VSS sg13cmos5l_xnor2_1
X_6560_ _6562_/B _6560_/A _6560_/B VDD VSS sg13cmos5l_or2_1
X_4324_ _6972_/A _4325_/A _4325_/B _4325_/C VDD VSS sg13cmos5l_nor3_1
X_5373_ _5451_/A _5374_/A _5374_/B _5374_/C VDD VSS sg13cmos5l_nand3_1
X_5442_ _5444_/B _5442_/A _5442_/B VDD VSS sg13cmos5l_xor2_1
X_7112_ _7112_/Q _7244_/CLK _7112_/D _7112_/RESET_B VDD VSS sg13cmos5l_dfrbpq_1
X_6491_ _7020_/D _6480_/C _6489_/X _6490_/Y VDD VSS sg13cmos5l_a21oi_1
X_4186_ _4410_/A _7063_/Q _4186_/B _4186_/C VDD VSS sg13cmos5l_and3_1
X_4255_ _4255_/Y _4258_/B _4258_/A VDD VSS sg13cmos5l_nand2b_1
Xfanout106 _6205_/A _3797_/Y VDD VSS sg13cmos5l_buf_1
Xfanout117 _6185_/A _3809_/X VDD VSS sg13cmos5l_buf_1
Xfanout128 _5294_/B _3816_/X VDD VSS sg13cmos5l_buf_1
Xfanout139 _6925_/B1 _5224_/A VDD VSS sg13cmos5l_buf_1
X_7043_ _7043_/Q clkload7/A _7043_/D _7043_/RESET_B VDD VSS sg13cmos5l_dfrbpq_1
X_6827_ _6827_/X _6827_/A _6827_/B VDD VSS sg13cmos5l_or2_1
X_5709_ _5710_/A _5647_/A _5707_/B _5705_/Y VDD VSS sg13cmos5l_a21o_1
X_6758_ _6758_/Y _6742_/Y _6760_/B _6740_/A VDD VSS sg13cmos5l_o21ai_1
X_6689_ _6765_/A _6689_/A _6689_/B VDD VSS sg13cmos5l_xor2_1
XFILLER_27_760 VDD VSS sg13cmos5l_fill_1
XFILLER_26_270 VDD VSS sg13cmos5l_fill_1
XFILLER_10_660 VDD VSS sg13cmos5l_fill_1
X_4040_ _4077_/B _6226_/A _4040_/B VDD VSS sg13cmos5l_xnor2_1
X_4942_ _4944_/C _4942_/A _4942_/B VDD VSS sg13cmos5l_nor2_1
X_5991_ _5992_/B _6091_/A _6091_/C _6091_/D VDD VSS sg13cmos5l_nand3_1
X_7072__322 _7072_/RESET_B VDD VSS sg13cmos5l_tiehi
XFILLER_20_435 VDD VSS sg13cmos5l_fill_2
X_3686_ _3781_/A _7159_/Q _7158_/Q VDD VSS sg13cmos5l_and2_1
X_3755_ _3755_/Y _3756_/B _3756_/C _7120_/Q VDD VSS sg13cmos5l_o21ai_1
X_3824_ _4611_/C _3824_/A _3824_/B _3824_/C VDD VSS sg13cmos5l_nand3_1
X_4873_ _4920_/A _4873_/A _4873_/B VDD VSS sg13cmos5l_nor2_1
X_6612_ _6614_/B _6612_/A _6612_/B VDD VSS sg13cmos5l_xnor2_1
X_6543_ _6544_/C _4611_/A _4611_/C _6196_/A VDD VSS sg13cmos5l_a21oi_1
X_6474_ _6476_/B _7019_/Q _6474_/B VDD VSS sg13cmos5l_xnor2_1
X_4307_ _4308_/C _4306_/B _4306_/C _4306_/A VDD VSS sg13cmos5l_o21ai_1
X_5287_ _5288_/B _5287_/A _5287_/B _5287_/C VDD VSS sg13cmos5l_nand3_1
X_5356_ _5357_/B _5481_/B _5355_/B _5356_/S VDD VSS sg13cmos5l_mux2_1
X_5425_ _5425_/Y _5450_/A _5424_/B _5528_/A VDD VSS sg13cmos5l_o21ai_1
X_4169_ _4171_/B _4169_/A _4169_/B VDD VSS sg13cmos5l_nand2_1
X_4238_ _4238_/Y _6469_/A _6467_/B VDD VSS sg13cmos5l_nand2_1
X_7026_ _7026_/Q _7224_/CLK _7026_/D _7026_/RESET_B VDD VSS sg13cmos5l_dfrbpq_1
X_7311__397 _7311_/RESET_B VDD VSS sg13cmos5l_tiehi
XFILLER_3_656 VDD VSS sg13cmos5l_fill_1
XFILLER_30_700 VDD VSS sg13cmos5l_fill_1
XFILLER_9_34 VDD VSS sg13cmos5l_fill_1
X_5141_ _5176_/B _5142_/B _5142_/C _5142_/A VDD VSS sg13cmos5l_a21oi_1
X_5210_ _5222_/B _5211_/A _5211_/B VDD VSS sg13cmos5l_nor2_1
X_6190_ _6190_/Y _6189_/A _6189_/B _6563_/A VDD VSS sg13cmos5l_a21oi_1
XFILLER_25_516 VDD VSS sg13cmos5l_fill_1
X_4023_ _4026_/A _4053_/C _6495_/B VDD VSS sg13cmos5l_nor2_1
X_5072_ _5073_/B _5072_/A _5072_/B VDD VSS sg13cmos5l_nand2_1
X_4856_ _4858_/B _4855_/B _4855_/C _4855_/A VDD VSS sg13cmos5l_a21o_1
X_4925_ _6746_/A _6720_/A _6720_/B VDD VSS sg13cmos5l_nand2b_1
X_5974_ _5974_/Y _5972_/Y _5973_/Y _5983_/A2 VDD VSS sg13cmos5l_a21oi_1
XFILLER_21_766 VDD VSS sg13cmos5l_fill_2
X_3669_ _4865_/A _7086_/Q VDD VSS sg13cmos5l_inv_1
X_3738_ _3898_/B _3891_/A _3738_/B VDD VSS sg13cmos5l_nand2_1
X_3807_ _3864_/A _3808_/A _5351_/B VDD VSS sg13cmos5l_nor2_1
X_4787_ _4790_/A _7057_/Q _4787_/B VDD VSS sg13cmos5l_xnor2_1
X_6526_ _6527_/B _6525_/A _6525_/B _6525_/C VDD VSS sg13cmos5l_o21ai_1
X_6457_ _6457_/X _6457_/A _6457_/B VDD VSS sg13cmos5l_xor2_1
X_5339_ _5341_/B _5339_/A _5339_/B VDD VSS sg13cmos5l_xnor2_1
X_5408_ _5436_/B _5435_/B VDD VSS sg13cmos5l_inv_1
X_6388_ _7010_/D _6396_/B _6386_/Y _6387_/Y VDD VSS sg13cmos5l_a21oi_1
X_7009_ _7009_/Q clkload6/A _7009_/D _7009_/RESET_B VDD VSS sg13cmos5l_dfrbpq_1
XFILLER_24_582 VDD VSS sg13cmos5l_decap_8
XFILLER_7_214 VDD VSS sg13cmos5l_fill_2
X_4710_ _7082_/D _5376_/A _4710_/B _4710_/C VDD VSS sg13cmos5l_and3_1
X_5690_ _5692_/B _7091_/Q _5690_/B _5690_/C VDD VSS sg13cmos5l_and3_1
X_4572_ _7076_/D _4569_/Y _4570_/Y _4571_/Y VDD VSS sg13cmos5l_a21oi_1
X_4641_ _4652_/A _4618_/A _4618_/B _4616_/Y VDD VSS sg13cmos5l_a21oi_1
X_7291_ _7291_/Q _7308_/CLK _7291_/D _7291_/RESET_B VDD VSS sg13cmos5l_dfrbpq_1
Xfanout8 _6860_/B _5833_/B VDD VSS sg13cmos5l_buf_1
X_6311_ _6311_/Y _7005_/Q _6707_/A VDD VSS sg13cmos5l_nand2_1
X_5124_ _5127_/C _5124_/A _5124_/B VDD VSS sg13cmos5l_xnor2_1
X_6173_ _6174_/A _6991_/Q _6172_/B _6584_/B1 VDD VSS sg13cmos5l_o21ai_1
X_6242_ _6998_/D _6610_/A _6242_/B _6251_/B VDD VSS sg13cmos5l_and3_1
X_7225__442 _7225_/RESET_B VDD VSS sg13cmos5l_tiehi
XFILLER_37_184 VDD VSS sg13cmos5l_fill_1
XFILLER_38_652 VDD VSS sg13cmos5l_fill_2
X_4006_ _4681_/A _5351_/B _5330_/C VDD VSS sg13cmos5l_xnor2_1
X_5055_ _5059_/B _5056_/A _5056_/B _5098_/B VDD VSS sg13cmos5l_a21o_1
X_4839_ _4839_/Y _4613_/A _4733_/B _4806_/B _4806_/A VDD VSS sg13cmos5l_a22oi_1
X_4908_ _4910_/B _4908_/A _4908_/B VDD VSS sg13cmos5l_xnor2_1
X_5888_ _5889_/B _7137_/Q _5896_/A2 _5896_/B1 _7136_/Q VDD VSS sg13cmos5l_a22oi_1
X_5957_ _5957_/Y _7223_/Q _5981_/A2 _5961_/B1 _7193_/Q VDD VSS sg13cmos5l_a22oi_1
X_6509_ _6511_/B _7022_/Q _6509_/B VDD VSS sg13cmos5l_xnor2_1
XFILLER_31_305 VDD VSS sg13cmos5l_fill_1
XFILLER_12_574 VDD VSS sg13cmos5l_fill_2
Xclkbuf_leaf_14_sd_clk clkload9/A clkload1/A VDD VSS sg13cmos5l_buf_8
X_6860_ _6863_/A _7040_/Q _6860_/B VDD VSS sg13cmos5l_xnor2_1
XFILLER_22_316 VDD VSS sg13cmos5l_fill_2
X_5673_ _5674_/B _5673_/A _5673_/B VDD VSS sg13cmos5l_xor2_1
X_5742_ _5759_/A _5744_/B _5744_/C _5770_/A VDD VSS sg13cmos5l_a21oi_1
X_5811_ _5824_/A _5811_/A _5811_/B VDD VSS sg13cmos5l_nor2_1
X_6791_ _6792_/B _6791_/A _6791_/B VDD VSS sg13cmos5l_nor2_1
X_4486_ _4488_/B _4486_/A _4486_/B VDD VSS sg13cmos5l_xor2_1
X_4555_ _4555_/Y _4556_/A _4556_/B VDD VSS sg13cmos5l_nor2_1
X_4624_ _4625_/B _4622_/X _4624_/B VDD VSS sg13cmos5l_nand2b_1
X_7274_ _7274_/Q _7308_/CLK _7274_/D _7274_/RESET_B VDD VSS sg13cmos5l_dfrbpq_1
X_5107_ _5109_/B _7092_/Q _5107_/B VDD VSS sg13cmos5l_xnor2_1
X_6087_ _7196_/D _6061_/Y _7196_/Q _6087_/S VDD VSS sg13cmos5l_mux2_1
X_6156_ _7303_/D _7303_/Q _7271_/Q _6164_/S VDD VSS sg13cmos5l_mux2_1
X_6225_ _6226_/B _6997_/Q _6573_/A VDD VSS sg13cmos5l_xnor2_1
X_5038_ _5046_/A _5818_/C _5094_/A VDD VSS sg13cmos5l_nand2_1
X_7191__202 _7191_/RESET_B VDD VSS sg13cmos5l_tiehi
X_6989_ _6990_/C _6989_/A _4463_/B VDD VSS sg13cmos5l_nor2b_1
XFILLER_21_360 VDD VSS sg13cmos5l_fill_2
XFILLER_16_154 VDD VSS sg13cmos5l_fill_2
XFILLER_31_135 VDD VSS sg13cmos5l_fill_1
XFILLER_32_625 VDD VSS sg13cmos5l_fill_1
X_7215__452 _7215_/RESET_B VDD VSS sg13cmos5l_tiehi
XFILLER_8_397 VDD VSS sg13cmos5l_fill_1
X_4340_ _6965_/B _4340_/A _4340_/B VDD VSS sg13cmos5l_xnor2_1
Xclkbuf_leaf_1_sd_clk _7316_/CLK clkbuf_leaf_2_sd_clk/A VDD VSS sg13cmos5l_buf_8
XFILLER_39_235 VDD VSS sg13cmos5l_fill_2
X_4271_ _4271_/X _4271_/A _4271_/B VDD VSS sg13cmos5l_and2_1
X_6010_ _6010_/Y _6010_/A _6010_/B _6010_/C VDD VSS sg13cmos5l_nand3_1
X_7222__445 _7222_/RESET_B VDD VSS sg13cmos5l_tiehi
X_6912_ _6912_/Y _6912_/A _6912_/B _6912_/C VDD VSS sg13cmos5l_nand3_1
X_6843_ _6844_/B _6857_/A _6843_/B VDD VSS sg13cmos5l_nand2b_1
X_3986_ _3986_/X _3987_/A _3987_/B VDD VSS sg13cmos5l_and2_1
X_4607_ _4607_/Y _4607_/A _4596_/C VDD VSS sg13cmos5l_nor2b_1
X_5656_ _5660_/A _7090_/Q _5656_/B VDD VSS sg13cmos5l_xnor2_1
X_5725_ _5728_/A _7092_/Q _5725_/B VDD VSS sg13cmos5l_xnor2_1
X_6774_ _6775_/B _7034_/Q _6774_/B VDD VSS sg13cmos5l_xnor2_1
X_4469_ _4470_/B _6440_/A _6415_/B VDD VSS sg13cmos5l_nor2_1
X_4538_ _4546_/A _4539_/B _4539_/A VDD VSS sg13cmos5l_nor2b_1
X_5587_ _5588_/B _5662_/A VDD VSS sg13cmos5l_inv_1
X_6208_ _6208_/Y _6208_/A VDD VSS sg13cmos5l_inv_1
X_7257_ _7258_/D _7266_/CLK _7257_/D _6610_/A VDD VSS sg13cmos5l_dfrbpq_1
X_6139_ _7286_/D _7286_/Q _7148_/Q _6139_/S VDD VSS sg13cmos5l_mux2_1
X_7188_ _7188_/Q clkload4/A _7188_/D _7188_/RESET_B VDD VSS sg13cmos5l_dfrbpq_1
X_7128__265 _7128_/RESET_B VDD VSS sg13cmos5l_tiehi
XFILLER_17_452 VDD VSS sg13cmos5l_fill_1
X_3771_ _3868_/A _7117_/Q _6592_/A VDD VSS sg13cmos5l_and2_1
X_3840_ _3874_/A _3848_/B _3853_/A _3848_/A VDD VSS sg13cmos5l_o21ai_1
X_5510_ _5547_/A _5510_/A VDD VSS sg13cmos5l_inv_1
X_6490_ _6490_/Y _6480_/C _6489_/X _6930_/A VDD VSS sg13cmos5l_o21ai_1
X_4323_ _4325_/C _7031_/Q _4337_/B _4321_/Y VDD VSS sg13cmos5l_a21oi_1
X_5372_ _5374_/C _5372_/A _5372_/B _5372_/C VDD VSS sg13cmos5l_nand3_1
X_5441_ _5442_/B _7110_/Q _5441_/B VDD VSS sg13cmos5l_xnor2_1
Xfanout107 _5896_/A2 _5875_/B VDD VSS sg13cmos5l_buf_1
Xfanout118 _5961_/B1 _5930_/Y VDD VSS sg13cmos5l_buf_1
Xfanout129 _5901_/A _5907_/A VDD VSS sg13cmos5l_buf_1
X_7181__212 _7181_/RESET_B VDD VSS sg13cmos5l_tiehi
X_7111_ _7111_/Q _7244_/CLK _7111_/D _7111_/RESET_B VDD VSS sg13cmos5l_dfrbpq_1
X_7042_ _7042_/Q clkload6/A _7042_/D _7042_/RESET_B VDD VSS sg13cmos5l_dfrbpq_1
X_4185_ _4186_/C _5820_/A _4185_/B _4185_/C VDD VSS sg13cmos5l_nand3_1
X_4254_ _4258_/B _7020_/Q _4254_/B VDD VSS sg13cmos5l_xnor2_1
XFILLER_23_488 VDD VSS sg13cmos5l_fill_1
X_6826_ _6830_/B _6826_/A _6825_/Y VDD VSS sg13cmos5l_nor2b_1
X_6757_ _6760_/B _6757_/A _6757_/B VDD VSS sg13cmos5l_xor2_1
X_3969_ _3976_/A _5534_/A _3977_/B _3967_/Y VDD VSS sg13cmos5l_a21oi_1
X_5639_ _5639_/Y _5639_/A _5639_/B _5639_/C VDD VSS sg13cmos5l_nand3_1
X_5708_ _5718_/A _5566_/A _5566_/B _5707_/Y VDD VSS sg13cmos5l_a21o_1
X_6688_ _6737_/A _6687_/A _6687_/B _6689_/A VDD VSS sg13cmos5l_a21oi_1
X_7309_ _7309_/Q clkload4/A _7309_/D _7309_/RESET_B VDD VSS sg13cmos5l_dfrbpq_1
X_7212__455 _7212_/RESET_B VDD VSS sg13cmos5l_tiehi
XFILLER_37_558 VDD VSS sg13cmos5l_decap_4
X_3823_ _3869_/B _3822_/A _3799_/Y _3802_/Y VDD VSS sg13cmos5l_o21ai_1
X_4872_ _4872_/X _4828_/A _4825_/Y _4826_/Y VDD VSS sg13cmos5l_a21o_1
X_4941_ _4997_/A _4941_/A _4941_/B VDD VSS sg13cmos5l_xor2_1
X_5990_ _7169_/D _7169_/Q _6107_/B VDD VSS sg13cmos5l_xnor2_1
X_6611_ _6621_/A _4288_/A _6598_/B _6599_/Y VDD VSS sg13cmos5l_o21ai_1
X_3685_ _3763_/A _7162_/Q _7161_/Q VDD VSS sg13cmos5l_xnor2_1
X_3754_ _3836_/B _3929_/A _3929_/B _3634_/Y VDD VSS sg13cmos5l_a21oi_1
X_5424_ _5427_/B _5450_/A _5424_/B VDD VSS sg13cmos5l_nor2_1
X_6542_ _6552_/A _4331_/A _6528_/B _6529_/Y VDD VSS sg13cmos5l_o21ai_1
X_6473_ _6479_/A _6473_/A _6473_/B VDD VSS sg13cmos5l_and2_1
X_4237_ _4243_/A _7047_/Q _6474_/B VDD VSS sg13cmos5l_xnor2_1
X_4306_ _4308_/B _4306_/A _4306_/B _4306_/C VDD VSS sg13cmos5l_or3_1
X_5286_ _5286_/Y _5287_/A _5287_/B _5287_/C VDD VSS sg13cmos5l_a21oi_1
X_5355_ _5481_/B _5355_/A _5355_/B VDD VSS sg13cmos5l_xnor2_1
X_7025_ _7025_/Q _7266_/CLK _7025_/D _7025_/RESET_B VDD VSS sg13cmos5l_dfrbpq_1
XFILLER_28_514 VDD VSS sg13cmos5l_decap_4
X_4099_ _4101_/B _6656_/B _4887_/B _4927_/B VDD VSS sg13cmos5l_a21oi_1
X_4168_ _4169_/B _7064_/Q _4169_/A _4168_/C VDD VSS sg13cmos5l_nand3_1
XFILLER_11_403 VDD VSS sg13cmos5l_fill_2
XFILLER_36_591 VDD VSS sg13cmos5l_fill_1
XFILLER_7_407 VDD VSS sg13cmos5l_fill_1
X_6809_ _6811_/B _7008_/Q _6795_/B _6793_/Y VDD VSS sg13cmos5l_a21oi_1
XFILLER_0_26 VDD VSS sg13cmos5l_fill_2
X_7171__222 _7171_/RESET_B VDD VSS sg13cmos5l_tiehi
X_5071_ _5072_/B _5070_/A _5070_/B _5076_/C VDD VSS sg13cmos5l_o21ai_1
X_5140_ _5142_/C _5139_/B _5139_/C _7066_/Q VDD VSS sg13cmos5l_a21o_1
X_4022_ _6495_/B _5267_/A _4239_/A VDD VSS sg13cmos5l_xnor2_1
X_5973_ _5973_/Y _7227_/Q _5981_/A2 _5980_/B1 _7212_/Q VDD VSS sg13cmos5l_a22oi_1
XFILLER_33_583 VDD VSS sg13cmos5l_decap_8
X_3806_ _3806_/X _3806_/A _3806_/B VDD VSS sg13cmos5l_xor2_1
X_4786_ _4787_/B _4786_/A _4786_/B VDD VSS sg13cmos5l_xor2_1
X_4855_ _4858_/A _4855_/A _4855_/B _4855_/C VDD VSS sg13cmos5l_nand3_1
X_4924_ _4936_/A _4924_/A _4924_/B VDD VSS sg13cmos5l_and2_1
X_3668_ _5473_/A _7084_/Q VDD VSS sg13cmos5l_inv_1
X_3737_ _3737_/X _3891_/A _3738_/B VDD VSS sg13cmos5l_and2_1
X_5407_ _5435_/B _5534_/A _5407_/B VDD VSS sg13cmos5l_xnor2_1
X_6525_ _6547_/A _6525_/A _6525_/B _6525_/C VDD VSS sg13cmos5l_nor3_1
X_6456_ _6456_/Y _6457_/A _6457_/B VDD VSS sg13cmos5l_nand2b_1
X_6387_ _6387_/Y _6396_/B _6386_/Y _6925_/B1 VDD VSS sg13cmos5l_o21ai_1
XFILLER_28_333 VDD VSS sg13cmos5l_fill_2
X_5269_ _5287_/A _5270_/B _5270_/A VDD VSS sg13cmos5l_nand2b_1
X_5338_ _5339_/B _5338_/A _5338_/B VDD VSS sg13cmos5l_xnor2_1
X_7044__266 _7044_/RESET_B VDD VSS sg13cmos5l_tiehi
X_7008_ _7008_/Q clkload5/A _7008_/D _7008_/RESET_B VDD VSS sg13cmos5l_dfrbpq_1
XFILLER_24_572 VDD VSS sg13cmos5l_fill_2
XFILLER_28_377 VDD VSS sg13cmos5l_fill_2
XFILLER_34_43 VDD VSS sg13cmos5l_fill_1
XFILLER_3_498 VDD VSS sg13cmos5l_fill_2
XFILLER_19_366 VDD VSS sg13cmos5l_fill_2
XFILLER_15_561 VDD VSS sg13cmos5l_fill_2
X_4640_ _4660_/A _4625_/A _4624_/B _4622_/X VDD VSS sg13cmos5l_a21oi_1
X_4571_ _4571_/Y _4569_/Y _4570_/Y _4596_/A VDD VSS sg13cmos5l_o21ai_1
X_6241_ _6251_/B _6240_/A _6240_/B _6240_/C VDD VSS sg13cmos5l_a21o_1
X_7290_ _7290_/Q _7308_/CLK _7290_/D _7290_/RESET_B VDD VSS sg13cmos5l_dfrbpq_1
Xfanout9 _6804_/B _5833_/B VDD VSS sg13cmos5l_buf_1
X_6310_ _7004_/D _6307_/Y _6308_/Y _6309_/Y VDD VSS sg13cmos5l_a21oi_1
XFILLER_34_0 VDD VSS sg13cmos5l_fill_2
X_5054_ _5098_/B _5054_/A _5054_/B VDD VSS sg13cmos5l_xnor2_1
X_5123_ _5124_/B _5123_/A _5123_/B VDD VSS sg13cmos5l_xnor2_1
X_6172_ _6172_/Y _6991_/Q _6172_/B VDD VSS sg13cmos5l_nand2_1
XFILLER_25_369 VDD VSS sg13cmos5l_fill_1
X_4005_ _4719_/B _5351_/B _5253_/A VDD VSS sg13cmos5l_nor2_1
X_5956_ _5956_/Y _7178_/Q _5969_/A2 _5980_/B1 _7208_/Q VDD VSS sg13cmos5l_a22oi_1
X_4769_ _4771_/B _4769_/A _4769_/B VDD VSS sg13cmos5l_xor2_1
X_4838_ _4851_/A _5787_/B _4963_/S VDD VSS sg13cmos5l_xnor2_1
X_4907_ _4908_/B _5684_/A _4907_/B VDD VSS sg13cmos5l_xnor2_1
X_5887_ _7136_/D _5901_/A _5887_/B VDD VSS sg13cmos5l_nor2_1
X_6508_ _6508_/Y _7022_/Q _6509_/B VDD VSS sg13cmos5l_nand2_1
X_6439_ _6440_/B _7015_/Q _6772_/A VDD VSS sg13cmos5l_xnor2_1
XFILLER_29_32 VDD VSS sg13cmos5l_fill_2
XFILLER_29_87 VDD VSS sg13cmos5l_fill_2
XFILLER_12_520 VDD VSS sg13cmos5l_fill_2
X_7244__329 _7244_/RESET_B VDD VSS sg13cmos5l_tiehi
XFILLER_19_152 VDD VSS sg13cmos5l_fill_2
XFILLER_35_601 VDD VSS sg13cmos5l_decap_4
XFILLER_35_612 VDD VSS sg13cmos5l_fill_1
X_5810_ _5829_/B _5810_/A _5810_/B _5810_/C VDD VSS sg13cmos5l_nor3_1
X_7138__245 _7138_/RESET_B VDD VSS sg13cmos5l_tiehi
X_6790_ _6791_/B _6789_/B _6789_/C _6789_/A VDD VSS sg13cmos5l_a21oi_1
X_4623_ _4624_/B _4623_/A _4623_/B VDD VSS sg13cmos5l_or2_1
X_5672_ _5672_/Y _5673_/A _5673_/B VDD VSS sg13cmos5l_nor2_1
X_5741_ _5744_/C _5741_/A _5741_/B _5760_/B VDD VSS sg13cmos5l_or3_1
X_4485_ _4503_/A _4486_/A _4486_/B VDD VSS sg13cmos5l_or2_1
X_4554_ _4556_/B _7048_/Q _4554_/B VDD VSS sg13cmos5l_xnor2_1
X_6224_ _6224_/Y _6997_/Q _6573_/A VDD VSS sg13cmos5l_nand2_1
X_7273_ _7273_/Q _7305_/CLK _7273_/D _7273_/RESET_B VDD VSS sg13cmos5l_dfrbpq_1
XFILLER_38_472 VDD VSS sg13cmos5l_fill_1
X_5037_ _5048_/A _5009_/A _5009_/B _5007_/Y VDD VSS sg13cmos5l_o21ai_1
X_5106_ _5107_/B _5106_/A _5106_/B VDD VSS sg13cmos5l_xnor2_1
X_6086_ _7195_/D _6055_/X _7195_/Q _6087_/S VDD VSS sg13cmos5l_mux2_1
X_6155_ _7302_/D _7302_/Q _7148_/Q _6170_/S VDD VSS sg13cmos5l_mux2_1
XFILLER_13_328 VDD VSS sg13cmos5l_fill_1
XFILLER_15_23 VDD VSS sg13cmos5l_fill_1
XFILLER_25_100 VDD VSS sg13cmos5l_fill_2
XFILLER_26_656 VDD VSS sg13cmos5l_fill_1
X_5939_ _5939_/Y _7218_/Q _5921_/B _5961_/B1 _7188_/Q VDD VSS sg13cmos5l_a22oi_1
X_6988_ _7064_/D _4453_/A _6986_/Y _6987_/Y VDD VSS sg13cmos5l_a21oi_1
XFILLER_21_350 VDD VSS sg13cmos5l_fill_1
Xclkbuf_leaf_20_sd_clk _7305_/CLK clkbuf_leaf_2_sd_clk/A VDD VSS sg13cmos5l_buf_8
XFILLER_29_483 VDD VSS sg13cmos5l_fill_2
XFILLER_8_343 VDD VSS sg13cmos5l_fill_2
X_4270_ _4271_/B _4270_/A _6938_/A VDD VSS sg13cmos5l_nand2_1
XFILLER_23_626 VDD VSS sg13cmos5l_fill_1
XFILLER_23_648 VDD VSS sg13cmos5l_decap_8
XFILLER_35_464 VDD VSS sg13cmos5l_decap_8
X_3985_ _3987_/B _3985_/A _3985_/B VDD VSS sg13cmos5l_xor2_1
X_6911_ _6913_/A _6912_/A _6912_/B _6912_/C VDD VSS sg13cmos5l_a21oi_1
X_6842_ _6843_/B _6842_/A _6842_/B _6842_/C VDD VSS sg13cmos5l_nand3_1
X_6773_ _6773_/X _7034_/Q _6774_/B VDD VSS sg13cmos5l_and2_1
X_4606_ _4635_/B _4604_/Y _4606_/B VDD VSS sg13cmos5l_nand2b_1
X_5586_ _5662_/A _5586_/A _5586_/B VDD VSS sg13cmos5l_xnor2_1
X_5655_ _5656_/B _5655_/A _5655_/B VDD VSS sg13cmos5l_xor2_1
X_5724_ _5725_/B _5724_/A _5724_/B VDD VSS sg13cmos5l_xor2_1
X_4399_ _4403_/C _4399_/A _4399_/B _4399_/C VDD VSS sg13cmos5l_nor3_1
X_4468_ _4468_/Y _4468_/A _6415_/B VDD VSS sg13cmos5l_nand2_1
X_4537_ _4539_/B _7046_/Q _7073_/Q VDD VSS sg13cmos5l_xnor2_1
X_6138_ _7285_/D _7285_/Q _7147_/Q _6139_/S VDD VSS sg13cmos5l_mux2_1
X_6207_ _6208_/A _6209_/A _6209_/B VDD VSS sg13cmos5l_nand2_1
X_7256_ _7257_/D _7266_/CLK _7256_/D _6610_/A VDD VSS sg13cmos5l_dfrbpq_1
X_7187_ _7187_/Q _7308_/CLK _7187_/D _7187_/RESET_B VDD VSS sg13cmos5l_dfrbpq_1
XFILLER_14_604 VDD VSS sg13cmos5l_fill_1
XFILLER_26_453 VDD VSS sg13cmos5l_fill_2
X_6069_ _6071_/A _7318_/Q _7302_/Q VDD VSS sg13cmos5l_xnor2_1
XFILLER_14_615 VDD VSS sg13cmos5l_fill_1
XFILLER_26_88 VDD VSS sg13cmos5l_fill_1
XFILLER_9_107 VDD VSS sg13cmos5l_fill_1
XFILLER_5_368 VDD VSS sg13cmos5l_fill_2
XFILLER_3_37 VDD VSS sg13cmos5l_fill_1
XFILLER_17_431 VDD VSS sg13cmos5l_fill_2
XFILLER_36_228 VDD VSS sg13cmos5l_fill_1
XFILLER_36_239 VDD VSS sg13cmos5l_fill_1
XFILLER_9_663 VDD VSS sg13cmos5l_fill_2
X_3770_ _5351_/A _3770_/A _3770_/B VDD VSS sg13cmos5l_xnor2_1
X_5440_ _5441_/B _5492_/A _5440_/B VDD VSS sg13cmos5l_xor2_1
X_4253_ _4258_/A _4256_/A _4256_/B VDD VSS sg13cmos5l_nand2_1
X_4322_ _4337_/B _4322_/A _4322_/B VDD VSS sg13cmos5l_xor2_1
X_5371_ _5374_/B _5322_/Y _5372_/C VDD VSS sg13cmos5l_nand2b_1
Xfanout108 _5881_/C _5875_/B VDD VSS sg13cmos5l_buf_1
Xfanout119 _5981_/B1 _5930_/Y VDD VSS sg13cmos5l_buf_1
X_7110_ _7110_/Q _7244_/CLK _7110_/D _7110_/RESET_B VDD VSS sg13cmos5l_dfrbpq_1
X_7041_ _7041_/Q clkload6/A _7041_/D _7041_/RESET_B VDD VSS sg13cmos5l_dfrbpq_1
X_4184_ _4186_/B _4185_/B _4185_/C _5820_/A VDD VSS sg13cmos5l_a21o_1
X_3968_ _3977_/B _3968_/A _3968_/B VDD VSS sg13cmos5l_xnor2_1
X_5707_ _5707_/Y _5707_/A _5707_/B VDD VSS sg13cmos5l_nand2_1
X_6825_ _6825_/Y _6825_/A _6825_/B _6825_/C VDD VSS sg13cmos5l_nand3_1
X_6756_ _6766_/B _6757_/A _6757_/B VDD VSS sg13cmos5l_nor2_1
X_3899_ _4154_/B _7165_/Q _3890_/B _5845_/A VDD VSS sg13cmos5l_a21oi_1
X_5569_ _5569_/Y _5570_/A _5570_/B VDD VSS sg13cmos5l_nor2_1
X_5638_ _5679_/A _5639_/A _5639_/B _5639_/C VDD VSS sg13cmos5l_a21oi_1
X_7308_ _7308_/Q _7308_/CLK _7308_/D _7308_/RESET_B VDD VSS sg13cmos5l_dfrbpq_1
X_6687_ _6689_/B _6687_/A _6687_/B VDD VSS sg13cmos5l_nand2_1
X_7239_ _7240_/D clkload8/A _7239_/D input4/X VDD VSS sg13cmos5l_dfrbpq_1
X_7054__246 _7054_/RESET_B VDD VSS sg13cmos5l_tiehi
XFILLER_24_209 VDD VSS sg13cmos5l_fill_1
XFILLER_20_437 VDD VSS sg13cmos5l_fill_1
X_3822_ _3869_/A _3822_/A _3822_/B _3822_/C _3822_/D VDD VSS sg13cmos5l_nor4_1
X_4871_ _4918_/A _4871_/A _4871_/B VDD VSS sg13cmos5l_xnor2_1
X_4940_ _4977_/A _4940_/A VDD VSS sg13cmos5l_inv_1
X_6610_ _7026_/D _6610_/A _6610_/B _6628_/B VDD VSS sg13cmos5l_and3_1
X_6541_ _7023_/D _6538_/Y _6539_/Y _6540_/Y VDD VSS sg13cmos5l_a21oi_1
X_3684_ _3758_/A _7163_/Q _7162_/Q VDD VSS sg13cmos5l_xnor2_1
X_3753_ _4800_/A _3756_/B _3756_/C VDD VSS sg13cmos5l_nor2_1
X_5354_ _5385_/S _5354_/A _5354_/B _5355_/B VDD VSS sg13cmos5l_nor3_1
X_5423_ _5424_/B _5451_/A _5451_/B _5421_/Y VDD VSS sg13cmos5l_a21oi_1
X_6472_ _7018_/D _6472_/A _6473_/B VDD VSS sg13cmos5l_nor2b_1
X_4167_ _4189_/A _7064_/Q _4169_/A _4168_/C VDD VSS sg13cmos5l_and3_1
X_4236_ _4236_/Y _6177_/A _5267_/B VDD VSS sg13cmos5l_xnor2_1
X_4305_ _4449_/A _4306_/A _4306_/B _4306_/C VDD VSS sg13cmos5l_nor3_1
X_5285_ _5287_/C _5285_/A _5285_/B VDD VSS sg13cmos5l_xnor2_1
X_7024_ _7024_/Q _7266_/CLK _7024_/D _7024_/RESET_B VDD VSS sg13cmos5l_dfrbpq_1
X_4098_ _4101_/A _6612_/A _4931_/A VDD VSS sg13cmos5l_xnor2_1
X_7118__276 _7118_/RESET_B VDD VSS sg13cmos5l_tiehi
XFILLER_11_437 VDD VSS sg13cmos5l_fill_2
XFILLER_24_787 VDD VSS sg13cmos5l_fill_1
X_6808_ _6811_/A _7009_/Q _6808_/B VDD VSS sg13cmos5l_xnor2_1
X_6739_ _6742_/B _6739_/A _6739_/B VDD VSS sg13cmos5l_or2_1
X_7125__269 _7125_/RESET_B VDD VSS sg13cmos5l_tiehi
XFILLER_15_732 VDD VSS sg13cmos5l_fill_1
XFILLER_15_787 VDD VSS sg13cmos5l_fill_1
Xfanout90 _6226_/A _4613_/A VDD VSS sg13cmos5l_buf_1
X_4021_ _6506_/A _6196_/A _4239_/A VDD VSS sg13cmos5l_and2_1
X_5070_ _5073_/A _5070_/A _5070_/B _5076_/C VDD VSS sg13cmos5l_nor3_1
XFILLER_37_356 VDD VSS sg13cmos5l_fill_2
X_4923_ _4950_/A _4908_/A _4908_/B _4906_/Y VDD VSS sg13cmos5l_o21ai_1
X_5972_ _5972_/Y _7182_/Q _5980_/A2 _5981_/B1 _7197_/Q VDD VSS sg13cmos5l_a22oi_1
XFILLER_20_289 VDD VSS sg13cmos5l_fill_1
XFILLER_21_768 VDD VSS sg13cmos5l_fill_1
XFILLER_33_562 VDD VSS sg13cmos5l_fill_2
X_3736_ _3738_/B _3679_/X _3742_/A _3890_/B VDD VSS sg13cmos5l_o21ai_1
X_3805_ _5266_/A _3806_/A _3806_/B VDD VSS sg13cmos5l_xnor2_1
X_4785_ _4785_/Y _4786_/A _4786_/B VDD VSS sg13cmos5l_nor2_1
X_4854_ _4855_/C _4853_/B _4853_/C _4853_/A VDD VSS sg13cmos5l_o21ai_1
X_7148__225 _7148_/RESET_B VDD VSS sg13cmos5l_tiehi
X_6524_ _6525_/C _6506_/A _6504_/Y _6505_/A VDD VSS sg13cmos5l_a21oi_1
X_3667_ _4696_/A _7082_/Q VDD VSS sg13cmos5l_inv_1
X_5337_ _5337_/Y _5338_/A _5338_/B VDD VSS sg13cmos5l_nand2_1
X_5406_ _5431_/A _5534_/A _5407_/B VDD VSS sg13cmos5l_nand2_1
X_7306__402 _7306_/RESET_B VDD VSS sg13cmos5l_tiehi
X_6455_ _6455_/Y _6457_/B VDD VSS sg13cmos5l_inv_1
X_6386_ _6386_/Y _6386_/A _6386_/B VDD VSS sg13cmos5l_nor2_1
X_4219_ _4574_/B _4219_/A _4219_/B VDD VSS sg13cmos5l_xnor2_1
X_5199_ _5199_/Y _5200_/A _5200_/B VDD VSS sg13cmos5l_nor2_1
X_5268_ _5270_/B _7102_/Q _5268_/B VDD VSS sg13cmos5l_xnor2_1
X_7007_ _7007_/Q _7318_/CLK _7007_/D _7007_/RESET_B VDD VSS sg13cmos5l_dfrbpq_1
XFILLER_18_78 VDD VSS sg13cmos5l_fill_1
XFILLER_7_216 VDD VSS sg13cmos5l_fill_1
XFILLER_19_345 VDD VSS sg13cmos5l_fill_2
X_4570_ _4570_/Y _4547_/C _4556_/X _4555_/Y VDD VSS sg13cmos5l_a21oi_1
X_6171_ _7318_/D _7318_/Q _7286_/Q _7126_/D VDD VSS sg13cmos5l_mux2_1
X_6240_ _6242_/B _6240_/A _6240_/B _6240_/C VDD VSS sg13cmos5l_nand3_1
X_4004_ _4024_/A _5308_/A _4647_/A VDD VSS sg13cmos5l_xnor2_1
X_5053_ _5053_/Y _5054_/A _5054_/B VDD VSS sg13cmos5l_nand2b_1
X_5122_ _5122_/Y _5123_/A _5123_/B VDD VSS sg13cmos5l_nand2_1
X_7108__286 _7108_/RESET_B VDD VSS sg13cmos5l_tiehi
XFILLER_40_329 VDD VSS sg13cmos5l_fill_2
X_4906_ _4906_/Y _5684_/A _4907_/B VDD VSS sg13cmos5l_nand2_1
X_5886_ _5887_/B _7136_/Q _5896_/A2 _5896_/B1 _7135_/Q VDD VSS sg13cmos5l_a22oi_1
X_5955_ _7159_/D _7159_/Q _5967_/A2 _5954_/Y VDD VSS sg13cmos5l_a21o_1
XFILLER_21_543 VDD VSS sg13cmos5l_fill_2
X_3719_ _3719_/Y _3763_/A _3770_/B VDD VSS sg13cmos5l_nor2_1
X_4699_ _4747_/B _4700_/A _4700_/B VDD VSS sg13cmos5l_or2_1
X_4768_ _4769_/B _5534_/B _3991_/B _4768_/S VDD VSS sg13cmos5l_mux2_1
X_4837_ _4895_/A _5787_/B _4963_/S VDD VSS sg13cmos5l_nor2_1
X_7115__279 _7115_/RESET_B VDD VSS sg13cmos5l_tiehi
X_6507_ _6509_/B _6528_/A _6507_/B VDD VSS sg13cmos5l_xnor2_1
X_6438_ _6438_/Y _6772_/A _7015_/Q VDD VSS sg13cmos5l_nor2b_1
X_6369_ _6396_/A _6386_/A _6369_/B VDD VSS sg13cmos5l_nand2b_1
XFILLER_16_337 VDD VSS sg13cmos5l_fill_2
XFILLER_29_610 VDD VSS sg13cmos5l_fill_1
XFILLER_29_687 VDD VSS sg13cmos5l_decap_8
XFILLER_12_554 VDD VSS sg13cmos5l_decap_8
XFILLER_12_576 VDD VSS sg13cmos5l_fill_1
XFILLER_6_37 VDD VSS sg13cmos5l_fill_2
XFILLER_39_429 VDD VSS sg13cmos5l_fill_2
XFILLER_19_164 VDD VSS sg13cmos5l_fill_1
XFILLER_22_318 VDD VSS sg13cmos5l_fill_1
X_5740_ _5744_/B _5741_/A _5741_/B _5760_/B VDD VSS sg13cmos5l_o21ai_1
X_4553_ _4568_/B _7048_/Q _4554_/B VDD VSS sg13cmos5l_nand2_1
X_4622_ _4622_/X _4623_/A _4623_/B VDD VSS sg13cmos5l_and2_1
X_5671_ _5673_/B _5671_/A _5671_/B VDD VSS sg13cmos5l_xnor2_1
X_4484_ _4486_/B _7067_/Q _6804_/B _4470_/A VDD VSS sg13cmos5l_a21oi_1
X_6154_ _7301_/D _7301_/Q _7147_/Q _6168_/S VDD VSS sg13cmos5l_mux2_1
X_6223_ _6996_/D _6223_/A VDD VSS sg13cmos5l_inv_1
X_7272_ _7272_/Q _7305_/CLK _7272_/D _7272_/RESET_B VDD VSS sg13cmos5l_dfrbpq_1
X_7303__405 _7303_/RESET_B VDD VSS sg13cmos5l_tiehi
XFILLER_38_462 VDD VSS sg13cmos5l_fill_2
X_5036_ _5062_/A _7090_/Q _5020_/B _5018_/Y VDD VSS sg13cmos5l_a21oi_1
X_5105_ _5105_/Y _5820_/A _5106_/B VDD VSS sg13cmos5l_nor2_1
X_6085_ _7194_/D _6049_/Y _7194_/Q _6090_/S VDD VSS sg13cmos5l_mux2_1
XFILLER_21_362 VDD VSS sg13cmos5l_fill_1
XFILLER_41_638 VDD VSS sg13cmos5l_fill_2
X_5869_ _5869_/Y _7128_/Q _5902_/B1 _6402_/A VDD VSS sg13cmos5l_o21ai_1
X_5938_ _5938_/Y _7173_/Q _5969_/A2 _5977_/B1 _7203_/Q VDD VSS sg13cmos5l_a22oi_1
X_6987_ _6987_/Y _4453_/A _6986_/Y _5212_/A VDD VSS sg13cmos5l_o21ai_1
XFILLER_31_45 VDD VSS sg13cmos5l_fill_2
XFILLER_31_78 VDD VSS sg13cmos5l_fill_1
XFILLER_16_156 VDD VSS sg13cmos5l_fill_1
X_7064__226 _7064_/RESET_B VDD VSS sg13cmos5l_tiehi
X_7105__289 _7105_/RESET_B VDD VSS sg13cmos5l_tiehi
X_6910_ _6912_/C _7016_/Q _6910_/B VDD VSS sg13cmos5l_xnor2_1
XFILLER_22_148 VDD VSS sg13cmos5l_fill_1
XFILLER_35_487 VDD VSS sg13cmos5l_fill_2
X_3984_ _3987_/A _3997_/B _3997_/A VDD VSS sg13cmos5l_nor2b_1
X_5723_ _5723_/Y _5724_/A _5724_/B VDD VSS sg13cmos5l_nor2_1
X_6841_ _6857_/A _6842_/A _6842_/B _6842_/C VDD VSS sg13cmos5l_a21oi_1
X_6772_ _6774_/B _6772_/A _6772_/B VDD VSS sg13cmos5l_xnor2_1
X_4536_ _4543_/A _7046_/Q _7073_/Q VDD VSS sg13cmos5l_nor2_1
X_4605_ _4606_/B _4605_/A _4605_/B _4605_/C VDD VSS sg13cmos5l_nand3_1
X_5585_ _5585_/Y _5586_/A _5586_/B VDD VSS sg13cmos5l_nor2_1
X_5654_ _5654_/Y _5655_/A _5655_/B VDD VSS sg13cmos5l_nor2_1
X_4398_ _4399_/C _4363_/Y _4376_/Y _4395_/A _6953_/A _4364_/Y VDD VSS sg13cmos5l_a221oi_1
X_4467_ _4467_/Y _6428_/A _4468_/A VDD VSS sg13cmos5l_nor2b_1
X_6137_ _7284_/D _7284_/Q _7146_/Q _6139_/S VDD VSS sg13cmos5l_mux2_1
X_6206_ _6209_/B _5267_/A _6196_/B _6194_/Y VDD VSS sg13cmos5l_o21ai_1
X_7255_ _7256_/D clkload9/A _7255_/D _6610_/A VDD VSS sg13cmos5l_dfrbpq_1
X_7186_ _7186_/Q clkload4/A _7186_/D _7186_/RESET_B VDD VSS sg13cmos5l_dfrbpq_1
XFILLER_26_432 VDD VSS sg13cmos5l_fill_2
XFILLER_39_760 VDD VSS sg13cmos5l_fill_1
X_5019_ _5020_/B _5579_/A _5019_/B VDD VSS sg13cmos5l_xnor2_1
X_6068_ _6068_/Y _7318_/Q _7302_/Q VDD VSS sg13cmos5l_nand2_1
XFILLER_29_270 VDD VSS sg13cmos5l_fill_1
Xclkbuf_2_1__f_sd_clk clkload0/A clkbuf_0_sd_clk/X VDD VSS sg13cmos5l_buf_8
X_5370_ _5372_/C _5370_/A _5347_/C VDD VSS sg13cmos5l_nor2b_1
X_4183_ _4183_/Y _4185_/B _4185_/C _5820_/A VDD VSS sg13cmos5l_a21oi_1
X_4252_ _4256_/B _4252_/A _6172_/B VDD VSS sg13cmos5l_xnor2_1
X_4321_ _4321_/Y _4322_/A _4322_/B VDD VSS sg13cmos5l_nor2_1
X_7300__408 _7300_/RESET_B VDD VSS sg13cmos5l_tiehi
Xfanout109 _5875_/B _5866_/X VDD VSS sg13cmos5l_buf_1
X_7040_ _7040_/Q clkload6/A _7040_/D _7040_/RESET_B VDD VSS sg13cmos5l_dfrbpq_1
XFILLER_23_424 VDD VSS sg13cmos5l_fill_1
XFILLER_35_295 VDD VSS sg13cmos5l_fill_2
X_3898_ _5124_/A _5159_/A _3898_/B VDD VSS sg13cmos5l_nand2_1
X_3967_ _3967_/Y _3968_/A _3968_/B VDD VSS sg13cmos5l_nor2b_1
X_5706_ _5707_/B _5706_/A _5706_/B VDD VSS sg13cmos5l_nor2_1
X_6824_ _6826_/A _6825_/A _6825_/B _6825_/C VDD VSS sg13cmos5l_a21oi_1
X_6755_ _6757_/B _7006_/Q _6755_/B VDD VSS sg13cmos5l_xnor2_1
X_6686_ _6689_/A _6686_/A _6686_/B VDD VSS sg13cmos5l_xnor2_1
X_4519_ _4520_/B _4519_/A _4519_/B _4519_/C VDD VSS sg13cmos5l_nand3_1
X_5499_ _5500_/B _5499_/A VDD VSS sg13cmos5l_inv_1
X_5568_ _5570_/B _5568_/A _5597_/B VDD VSS sg13cmos5l_xnor2_1
X_5637_ _5639_/C _5637_/A _5637_/B VDD VSS sg13cmos5l_xnor2_1
X_7238_ _7238_/Q _7238_/CLK _7238_/D fanout144/X VDD VSS sg13cmos5l_dfrbpq_1
X_7307_ _7307_/Q _7308_/CLK _7307_/D _7307_/RESET_B VDD VSS sg13cmos5l_dfrbpq_1
XFILLER_19_719 VDD VSS sg13cmos5l_fill_2
X_7169_ _7169_/Q _7238_/CLK _7169_/D _6091_/C VDD VSS sg13cmos5l_dfrbpq_1
XFILLER_14_457 VDD VSS sg13cmos5l_fill_1
XFILLER_37_527 VDD VSS sg13cmos5l_fill_2
XFILLER_9_450 VDD VSS sg13cmos5l_fill_1
X_3752_ _5597_/A _3929_/A _3929_/B VDD VSS sg13cmos5l_nand2_1
X_3821_ _3822_/D _3808_/Y _3820_/X _3864_/A VDD VSS sg13cmos5l_a21oi_1
X_4870_ _4915_/A _4871_/A _4871_/B VDD VSS sg13cmos5l_nor2_1
X_6540_ _6540_/Y _6538_/Y _6539_/Y _6584_/B1 VDD VSS sg13cmos5l_o21ai_1
X_3683_ _3759_/A _7163_/Q _7162_/Q VDD VSS sg13cmos5l_xor2_1
X_4304_ _4306_/C _4437_/A _4303_/C _7060_/Q VDD VSS sg13cmos5l_a21oi_1
X_5353_ _5353_/Y _5355_/B VDD VSS sg13cmos5l_inv_1
X_5422_ _5451_/B _5422_/A _5422_/B VDD VSS sg13cmos5l_nor2_1
X_6471_ _6472_/A _6991_/Q _6470_/B _6930_/A VDD VSS sg13cmos5l_o21ai_1
X_4166_ _4168_/C _4165_/B _4165_/C _5106_/A VDD VSS sg13cmos5l_a21o_1
X_4235_ _6474_/B _4235_/A _5267_/B VDD VSS sg13cmos5l_xnor2_1
X_5284_ _5301_/B _5285_/A _5285_/B VDD VSS sg13cmos5l_or2_1
X_7023_ _7023_/Q _7103_/CLK _7023_/D _7023_/RESET_B VDD VSS sg13cmos5l_dfrbpq_1
XFILLER_36_560 VDD VSS sg13cmos5l_fill_2
X_4097_ _4097_/Y _5787_/B _5735_/B VDD VSS sg13cmos5l_xnor2_1
X_6807_ _6825_/B _7009_/Q _6808_/B VDD VSS sg13cmos5l_nand2_1
XFILLER_23_298 VDD VSS sg13cmos5l_fill_1
X_4999_ _5017_/A _4999_/A _4999_/B VDD VSS sg13cmos5l_nor2_1
X_6738_ _6739_/B _6716_/B _6761_/B _6761_/A VDD VSS sg13cmos5l_o21ai_1
X_6669_ _6669_/Y _6670_/B _6654_/Y VDD VSS sg13cmos5l_nor2b_1
XFILLER_19_516 VDD VSS sg13cmos5l_fill_2
XFILLER_19_538 VDD VSS sg13cmos5l_decap_4
XFILLER_27_582 VDD VSS sg13cmos5l_decap_4
Xfanout91 _5597_/B _6612_/B VDD VSS sg13cmos5l_buf_1
Xfanout80 _5983_/A2 _5975_/A2 VDD VSS sg13cmos5l_buf_1
XFILLER_29_4 VDD VSS sg13cmos5l_fill_1
X_4020_ _4053_/C _5330_/C _6177_/A VDD VSS sg13cmos5l_nand2_1
XFILLER_21_703 VDD VSS sg13cmos5l_fill_2
X_4922_ _4957_/A _4921_/B _4920_/Y _4921_/X _4757_/A VDD VSS sg13cmos5l_a22oi_1
X_5971_ _7163_/D _7163_/Q _5983_/A2 _5970_/Y VDD VSS sg13cmos5l_a21o_1
Xclkbuf_leaf_7_sd_clk clkload8/A clkload0/A VDD VSS sg13cmos5l_buf_8
XFILLER_20_213 VDD VSS sg13cmos5l_fill_2
X_3735_ _3890_/B _3744_/A _3744_/B _3679_/X VDD VSS sg13cmos5l_a21o_1
X_3804_ _3806_/B _3810_/A _3810_/B _3699_/A VDD VSS sg13cmos5l_o21ai_1
X_4784_ _4786_/B _7084_/Q _4784_/B VDD VSS sg13cmos5l_xnor2_1
X_4853_ _4855_/B _4853_/A _4853_/B _4853_/C VDD VSS sg13cmos5l_or3_1
X_6523_ _6525_/B _4052_/A _4052_/B _5330_/C VDD VSS sg13cmos5l_a21oi_1
X_6454_ _6457_/B _7016_/Q _6877_/B VDD VSS sg13cmos5l_xnor2_1
X_3666_ _5396_/A _7081_/Q VDD VSS sg13cmos5l_inv_1
X_5267_ _5268_/B _5267_/A _5267_/B VDD VSS sg13cmos5l_xnor2_1
X_5336_ _5338_/B _5357_/A _5336_/B VDD VSS sg13cmos5l_nor2_1
X_5405_ _5411_/A _5387_/A _5387_/B _5382_/Y VDD VSS sg13cmos5l_o21ai_1
X_7124__270 _7124_/RESET_B VDD VSS sg13cmos5l_tiehi
X_6385_ _6396_/B _6385_/A VDD VSS sg13cmos5l_inv_1
XFILLER_28_335 VDD VSS sg13cmos5l_fill_1
X_4149_ _4151_/B _5821_/A _4149_/B _4149_/C VDD VSS sg13cmos5l_or3_1
X_4218_ _4273_/A _7024_/Q _4218_/B VDD VSS sg13cmos5l_xnor2_1
X_5198_ _5200_/B _7095_/Q _5187_/B _5185_/Y VDD VSS sg13cmos5l_a21oi_1
X_7006_ _7006_/Q _7224_/CLK _7006_/D _7006_/RESET_B VDD VSS sg13cmos5l_dfrbpq_1
XFILLER_24_541 VDD VSS sg13cmos5l_fill_1
XFILLER_34_78 VDD VSS sg13cmos5l_fill_2
Xclkload0 clkload0/X clkload0/A VDD VSS sg13cmos5l_buf_8
XFILLER_3_456 VDD VSS sg13cmos5l_fill_1
XFILLER_15_563 VDD VSS sg13cmos5l_fill_1
XFILLER_19_368 VDD VSS sg13cmos5l_fill_1
XFILLER_30_511 VDD VSS sg13cmos5l_fill_2
X_5121_ _5123_/B _5154_/A _5121_/B VDD VSS sg13cmos5l_xnor2_1
X_6170_ _7317_/D _7317_/Q _7285_/Q _6170_/S VDD VSS sg13cmos5l_mux2_1
X_4003_ _4342_/B _4003_/A _4003_/B VDD VSS sg13cmos5l_nand2_1
X_5052_ _5052_/Y _5054_/B _5054_/A VDD VSS sg13cmos5l_nor2b_1
X_4836_ _6701_/A _5787_/B _6612_/A VDD VSS sg13cmos5l_nor2_1
X_4905_ _4907_/B _4861_/Y _4901_/Y _4903_/Y _4862_/A _4942_/B VDD VSS sg13cmos5l_a221oi_1
X_5885_ _7135_/D _5901_/A _5885_/B VDD VSS sg13cmos5l_nor2_1
X_5954_ _5954_/Y _5952_/Y _5953_/Y _5983_/A2 VDD VSS sg13cmos5l_a21oi_1
XFILLER_21_566 VDD VSS sg13cmos5l_fill_2
XFILLER_21_577 VDD VSS sg13cmos5l_fill_2
X_3649_ _4366_/A _7028_/Q VDD VSS sg13cmos5l_inv_1
X_3718_ _3763_/C _3714_/A _3714_/B _3769_/B VDD VSS sg13cmos5l_o21ai_1
X_4698_ _4700_/B _4698_/A _4698_/B VDD VSS sg13cmos5l_xor2_1
X_4767_ _4767_/Y _5534_/B _4768_/S VDD VSS sg13cmos5l_nor2_1
X_6506_ _6507_/B _6506_/A _6506_/B VDD VSS sg13cmos5l_xnor2_1
X_6437_ _7014_/D _6437_/A _6437_/B VDD VSS sg13cmos5l_nor2_1
X_5319_ _5320_/B _5319_/A _5319_/B _5319_/C VDD VSS sg13cmos5l_nand3_1
X_6368_ _6369_/B _6368_/A _6368_/B _6368_/C VDD VSS sg13cmos5l_nand3_1
X_6299_ _6300_/B _6299_/A _6308_/B VDD VSS sg13cmos5l_nand2_1
XFILLER_12_522 VDD VSS sg13cmos5l_fill_1
X_7207__186 _7207_/RESET_B VDD VSS sg13cmos5l_tiehi
X_5670_ _5712_/B _5671_/A _5671_/B VDD VSS sg13cmos5l_nor2_1
X_4483_ _4486_/A _7068_/Q _6877_/B VDD VSS sg13cmos5l_xnor2_1
X_4552_ _4554_/B _4552_/A _4552_/B VDD VSS sg13cmos5l_xnor2_1
X_4621_ _4623_/B _4621_/A _4621_/B VDD VSS sg13cmos5l_xnor2_1
X_7271_ _7271_/Q clkload3/A _7271_/D _7271_/RESET_B VDD VSS sg13cmos5l_dfrbpq_1
X_7114__280 _7114_/RESET_B VDD VSS sg13cmos5l_tiehi
X_5104_ _5106_/B _5130_/B _5104_/B VDD VSS sg13cmos5l_nand2b_1
X_6084_ _7193_/D _6045_/Y _7193_/Q _6087_/S VDD VSS sg13cmos5l_mux2_1
X_6153_ _7300_/D _7300_/Q _7146_/Q _6168_/S VDD VSS sg13cmos5l_mux2_1
X_6222_ _6223_/A _6213_/Y _6220_/X _6221_/Y VDD VSS sg13cmos5l_o21ai_1
XFILLER_26_603 VDD VSS sg13cmos5l_fill_1
X_5035_ _5067_/A _7063_/Q _5023_/B _5021_/Y VDD VSS sg13cmos5l_a21o_1
X_7121__273 _7121_/RESET_B VDD VSS sg13cmos5l_tiehi
X_6986_ _6986_/Y _6986_/A _6985_/C VDD VSS sg13cmos5l_nor2b_1
XFILLER_15_69 VDD VSS sg13cmos5l_fill_2
XFILLER_21_396 VDD VSS sg13cmos5l_fill_2
X_4819_ _4819_/Y _5652_/A _4820_/B VDD VSS sg13cmos5l_nor2_1
X_5799_ _5800_/C _5826_/A _5798_/C _7095_/Q VDD VSS sg13cmos5l_a21o_1
X_5868_ _5868_/Y _5868_/A _5881_/C VDD VSS sg13cmos5l_nor2_1
X_5937_ _7154_/D _7154_/Q _5943_/S _5936_/Y VDD VSS sg13cmos5l_a21o_1
XFILLER_31_68 VDD VSS sg13cmos5l_fill_2
XFILLER_8_345 VDD VSS sg13cmos5l_fill_1
X_6840_ _6842_/C _7011_/Q _6840_/B VDD VSS sg13cmos5l_xnor2_1
XFILLER_23_617 VDD VSS sg13cmos5l_decap_8
XFILLER_31_672 VDD VSS sg13cmos5l_decap_8
X_3983_ _3997_/B _5330_/C _3991_/B _4733_/B VDD VSS sg13cmos5l_a21oi_1
X_5653_ _5655_/B _7117_/Q _5653_/B VDD VSS sg13cmos5l_xnor2_1
X_5722_ _5724_/B _7119_/Q _5722_/B VDD VSS sg13cmos5l_xnor2_1
X_6771_ _6772_/B _6771_/A _6771_/B VDD VSS sg13cmos5l_xor2_1
X_4466_ _4479_/A _4466_/A _4506_/A VDD VSS sg13cmos5l_nand2_1
X_4535_ _7072_/D _4535_/A _4539_/A VDD VSS sg13cmos5l_nor2b_1
X_4604_ _4604_/Y _4605_/A _4605_/B _4605_/C VDD VSS sg13cmos5l_a21oi_1
X_5584_ _5586_/B _7087_/Q _5554_/B _5552_/Y VDD VSS sg13cmos5l_a21oi_1
X_7254_ _7255_/D clkload9/A _7254_/D _6253_/A VDD VSS sg13cmos5l_dfrbpq_1
X_4397_ _6953_/A _4389_/B _6949_/A _4387_/Y VDD VSS sg13cmos5l_a21o_1
X_6067_ _7182_/D _7182_/Q _6066_/X _6074_/S VDD VSS sg13cmos5l_mux2_1
X_6136_ _7283_/D _7283_/Q _7145_/Q _6139_/S VDD VSS sg13cmos5l_mux2_1
X_6205_ _6209_/A _6205_/A _6205_/B VDD VSS sg13cmos5l_xnor2_1
X_7185_ _7185_/Q _7238_/CLK _7185_/D _7185_/RESET_B VDD VSS sg13cmos5l_dfrbpq_1
XFILLER_14_639 VDD VSS sg13cmos5l_fill_2
XFILLER_26_400 VDD VSS sg13cmos5l_fill_1
XFILLER_26_444 VDD VSS sg13cmos5l_fill_1
X_5018_ _5018_/Y _5018_/A _5019_/B VDD VSS sg13cmos5l_nor2_1
X_6969_ _6971_/B _6969_/A _6970_/A VDD VSS sg13cmos5l_nor2b_1
X_7204__189 _7204_/RESET_B VDD VSS sg13cmos5l_tiehi
XFILLER_17_433 VDD VSS sg13cmos5l_fill_1
X_7104__290 _7104_/RESET_B VDD VSS sg13cmos5l_tiehi
XFILLER_32_447 VDD VSS sg13cmos5l_fill_1
XFILLER_9_665 VDD VSS sg13cmos5l_fill_1
X_4320_ _4322_/B _7058_/Q _4320_/B VDD VSS sg13cmos5l_xnor2_1
X_7111__283 _7111_/RESET_B VDD VSS sg13cmos5l_tiehi
X_4182_ _4185_/C _4182_/A _4182_/B _4182_/C VDD VSS sg13cmos5l_or3_1
X_4251_ _4251_/Y _4260_/A _4260_/B VDD VSS sg13cmos5l_nor2_1
XFILLER_35_241 VDD VSS sg13cmos5l_fill_1
X_6823_ _6825_/C _7010_/Q _6823_/B VDD VSS sg13cmos5l_xnor2_1
X_3897_ _4125_/B _6700_/B _5812_/B _5154_/B VDD VSS sg13cmos5l_a21oi_1
X_3966_ _3968_/B _3966_/A _3966_/B VDD VSS sg13cmos5l_xor2_1
X_5636_ _5637_/B _5636_/A _5636_/B VDD VSS sg13cmos5l_xnor2_1
X_5705_ _5705_/Y _5642_/A _5678_/Y _5677_/Y VDD VSS sg13cmos5l_o21ai_1
X_6754_ _6755_/B _6754_/A _6754_/B VDD VSS sg13cmos5l_xor2_1
X_6685_ _6712_/B _6686_/A _6686_/B VDD VSS sg13cmos5l_or2_1
X_4449_ _4450_/C _4449_/A _4449_/B VDD VSS sg13cmos5l_nor2_1
X_4518_ _4524_/B _4519_/A _4519_/B _4519_/C VDD VSS sg13cmos5l_a21oi_1
X_5498_ _5499_/A _5497_/A _5497_/B _5497_/C VDD VSS sg13cmos5l_a21oi_1
X_5567_ _5573_/A _5637_/A _5538_/B _5536_/Y VDD VSS sg13cmos5l_a21oi_1
X_7237_ _7237_/Q _7238_/CLK _7237_/D _6299_/A VDD VSS sg13cmos5l_dfrbpq_1
X_7306_ _7306_/Q _7308_/CLK _7306_/D _7306_/RESET_B VDD VSS sg13cmos5l_dfrbpq_1
XFILLER_27_753 VDD VSS sg13cmos5l_fill_2
XFILLER_37_67 VDD VSS sg13cmos5l_fill_2
X_6119_ _7226_/D _7226_/Q _6061_/Y _6122_/S VDD VSS sg13cmos5l_mux2_1
X_7168_ _7168_/Q _7238_/CLK _7168_/D _6091_/C VDD VSS sg13cmos5l_dfrbpq_1
X_7099_ _7099_/Q _7270_/CLK _7099_/D _7099_/RESET_B VDD VSS sg13cmos5l_dfrbpq_1
X_6997__383 _6997_/RESET_B VDD VSS sg13cmos5l_tiehi
XFILLER_5_167 VDD VSS sg13cmos5l_fill_2
XFILLER_1_395 VDD VSS sg13cmos5l_fill_1
XFILLER_37_506 VDD VSS sg13cmos5l_decap_4
XFILLER_37_539 VDD VSS sg13cmos5l_decap_4
XFILLER_32_277 VDD VSS sg13cmos5l_fill_1
X_3682_ _3749_/A _7163_/Q _7162_/Q VDD VSS sg13cmos5l_nand2_1
X_3751_ _3929_/B _3748_/A _3748_/B _3748_/C VDD VSS sg13cmos5l_o21ai_1
X_3820_ _3820_/X _3863_/B _3865_/B _3863_/A VDD VSS sg13cmos5l_a21o_1
X_6470_ _6473_/B _6991_/Q _6470_/B VDD VSS sg13cmos5l_nand2_1
X_4303_ _4437_/B _7060_/Q _4437_/A _4303_/C VDD VSS sg13cmos5l_nand3_1
X_5283_ _5285_/B _5283_/A _5283_/B VDD VSS sg13cmos5l_xor2_1
X_5352_ _5355_/B _5352_/A _6196_/A VDD VSS sg13cmos5l_xnor2_1
X_5421_ _5421_/Y _5401_/A _5398_/Y _5400_/B VDD VSS sg13cmos5l_o21ai_1
X_7022_ _7022_/Q _7103_/CLK _7022_/D _7022_/RESET_B VDD VSS sg13cmos5l_dfrbpq_1
X_4096_ _4931_/A _6675_/A _6720_/B VDD VSS sg13cmos5l_xnor2_1
X_4165_ _4169_/A _5106_/A _4165_/B _4165_/C VDD VSS sg13cmos5l_nand3_1
X_4234_ _4234_/Y _6177_/A _5267_/B VDD VSS sg13cmos5l_nand2_1
XFILLER_11_439 VDD VSS sg13cmos5l_fill_1
XFILLER_24_778 VDD VSS sg13cmos5l_fill_1
X_4998_ _4999_/B _4944_/A _4944_/C _4997_/X VDD VSS sg13cmos5l_a21oi_1
X_6806_ _6808_/B _6806_/A _6806_/B VDD VSS sg13cmos5l_xnor2_1
X_3949_ _3949_/Y _3951_/A _3951_/B VDD VSS sg13cmos5l_nand2_1
X_5619_ _5621_/C _5618_/B _5618_/C _5618_/A VDD VSS sg13cmos5l_a21oi_1
X_6737_ _6761_/B _6737_/A _6737_/B VDD VSS sg13cmos5l_or2_1
X_6668_ _6670_/B _7002_/Q _6668_/B VDD VSS sg13cmos5l_xnor2_1
X_6599_ _6599_/Y _7026_/Q _6600_/B VDD VSS sg13cmos5l_nand2_1
X_7101__293 _7101_/RESET_B VDD VSS sg13cmos5l_tiehi
XFILLER_30_715 VDD VSS sg13cmos5l_fill_2
XFILLER_30_748 VDD VSS sg13cmos5l_fill_1
Xfanout92 _5308_/B _6612_/B VDD VSS sg13cmos5l_buf_1
Xfanout81 _5975_/A2 _5979_/A2 VDD VSS sg13cmos5l_buf_1
Xfanout70 _5534_/A _3758_/Y VDD VSS sg13cmos5l_buf_1
XFILLER_37_358 VDD VSS sg13cmos5l_fill_1
XFILLER_33_553 VDD VSS sg13cmos5l_fill_1
X_3803_ _3865_/A _3822_/A _3822_/B _3822_/C VDD VSS sg13cmos5l_nor3_1
X_4852_ _4852_/Y _4853_/A _4853_/B _4853_/C VDD VSS sg13cmos5l_nor3_1
X_4921_ _4921_/X _4921_/A _4921_/B VDD VSS sg13cmos5l_and2_1
X_5970_ _5970_/Y _5968_/Y _5969_/Y _5983_/A2 VDD VSS sg13cmos5l_a21oi_1
X_3665_ _5285_/A _7076_/Q VDD VSS sg13cmos5l_inv_1
X_3734_ _3742_/A _7165_/Q _5845_/A VDD VSS sg13cmos5l_xor2_1
X_4783_ _4784_/B _5652_/A _4783_/B VDD VSS sg13cmos5l_xnor2_1
X_5404_ _7108_/D _5404_/A _5404_/B VDD VSS sg13cmos5l_nor2_1
X_6522_ _6532_/A _5652_/A _6507_/B _6508_/Y VDD VSS sg13cmos5l_o21ai_1
X_6453_ _6457_/A _4468_/A _6440_/B _6438_/Y VDD VSS sg13cmos5l_a21o_1
X_4217_ _4276_/B _4217_/A _4217_/B _4217_/C VDD VSS sg13cmos5l_nand3_1
X_5266_ _5266_/X _5266_/A _5267_/B VDD VSS sg13cmos5l_and2_1
X_5335_ _5336_/B _5335_/A _5456_/B VDD VSS sg13cmos5l_nor2_1
X_7005_ _7005_/Q _7220_/CLK _7005_/D _7005_/RESET_B VDD VSS sg13cmos5l_dfrbpq_1
X_6384_ _6385_/A _6384_/A _6383_/Y VDD VSS sg13cmos5l_nor2b_1
XFILLER_28_358 VDD VSS sg13cmos5l_fill_2
X_4079_ _4354_/B _4029_/Y _4368_/A _4367_/B VDD VSS sg13cmos5l_o21ai_1
X_4148_ _4148_/Y _5821_/A _4149_/B _4149_/C VDD VSS sg13cmos5l_nor3_1
X_5197_ _5200_/A _7096_/Q _6804_/B VDD VSS sg13cmos5l_xnor2_1
XFILLER_11_258 VDD VSS sg13cmos5l_fill_2
XFILLER_24_553 VDD VSS sg13cmos5l_decap_4
Xclkload1 clkload1/X clkload1/A VDD VSS sg13cmos5l_buf_8
X_6994__386 _6994_/RESET_B VDD VSS sg13cmos5l_tiehi
XFILLER_27_380 VDD VSS sg13cmos5l_fill_1
XFILLER_27_391 VDD VSS sg13cmos5l_fill_1
X_5051_ _5054_/B _5012_/A _5012_/B _5010_/Y VDD VSS sg13cmos5l_o21ai_1
X_5120_ _5121_/B _5154_/B _5153_/C VDD VSS sg13cmos5l_nor2_1
XFILLER_38_667 VDD VSS sg13cmos5l_fill_2
X_4002_ _4002_/Y _4003_/A _4003_/B VDD VSS sg13cmos5l_nor2_1
XFILLER_21_545 VDD VSS sg13cmos5l_fill_1
XFILLER_33_350 VDD VSS sg13cmos5l_fill_1
XFILLER_33_372 VDD VSS sg13cmos5l_fill_2
X_4766_ _4771_/A _4766_/A _4766_/B VDD VSS sg13cmos5l_nand2_1
X_4835_ _4853_/A _4802_/Y _4809_/B _4807_/Y VDD VSS sg13cmos5l_a21oi_1
X_4904_ _4944_/A _4834_/A _4834_/B _4903_/Y VDD VSS sg13cmos5l_o21ai_1
X_5884_ _5885_/B _7135_/Q _5896_/A2 _5896_/B1 _7134_/Q VDD VSS sg13cmos5l_a22oi_1
X_5953_ _5953_/Y _7177_/Q _5969_/A2 _5961_/B1 _7192_/Q VDD VSS sg13cmos5l_a22oi_1
X_3648_ _4256_/A _7019_/Q VDD VSS sg13cmos5l_inv_1
X_3717_ _3770_/B _7161_/Q _7160_/Q VDD VSS sg13cmos5l_xnor2_1
X_4697_ _4747_/A _4698_/B _4698_/A VDD VSS sg13cmos5l_nand2b_1
X_6505_ _6506_/B _6505_/A _6504_/Y VDD VSS sg13cmos5l_nor2b_1
X_6436_ _6437_/B _6436_/A _6436_/B VDD VSS sg13cmos5l_nand2_1
X_6367_ _6386_/A _6368_/A _6368_/B _6368_/C VDD VSS sg13cmos5l_a21oi_1
X_5249_ _7100_/D _6563_/A _5249_/B _5249_/C VDD VSS sg13cmos5l_nor3_1
X_5318_ _5347_/A _5319_/A _5319_/B _5319_/C VDD VSS sg13cmos5l_a21oi_1
X_6298_ _6308_/B _6318_/A _6298_/B VDD VSS sg13cmos5l_nand2b_1
XFILLER_12_512 VDD VSS sg13cmos5l_fill_2
XFILLER_12_567 VDD VSS sg13cmos5l_fill_2
X_4620_ _4659_/A _4621_/A _4621_/B VDD VSS sg13cmos5l_nor2b_1
X_4482_ _4491_/A _7040_/Q _4475_/B _4473_/Y VDD VSS sg13cmos5l_a21oi_1
X_4551_ _4568_/A _4552_/A _4552_/B VDD VSS sg13cmos5l_nand2b_1
X_6221_ _6221_/Y _6213_/Y _6220_/X _6563_/A VDD VSS sg13cmos5l_a21oi_1
X_7270_ _7270_/Q _7270_/CLK _7270_/D _4596_/A VDD VSS sg13cmos5l_dfrbpq_1
XFILLER_32_0 VDD VSS sg13cmos5l_fill_1
X_5034_ _7090_/D _6971_/A _5034_/B _5070_/B VDD VSS sg13cmos5l_nor3_1
X_5103_ _5104_/B _5103_/A _5103_/B _5103_/C VDD VSS sg13cmos5l_nand3_1
X_6083_ _7192_/D _6038_/Y _7192_/Q _6087_/S VDD VSS sg13cmos5l_mux2_1
X_6152_ _7299_/D _7299_/Q _7145_/Q _6168_/S VDD VSS sg13cmos5l_mux2_1
XFILLER_25_158 VDD VSS sg13cmos5l_fill_2
XFILLER_26_648 VDD VSS sg13cmos5l_fill_2
XFILLER_38_464 VDD VSS sg13cmos5l_fill_1
X_5936_ _5936_/Y _5934_/Y _5935_/Y _5975_/A2 VDD VSS sg13cmos5l_a21oi_1
X_6985_ _7063_/D _6985_/A _6985_/B _6985_/C VDD VSS sg13cmos5l_and3_1
X_4749_ _4749_/Y _4755_/A _4710_/C VDD VSS sg13cmos5l_nor2b_1
X_4818_ _4820_/B _4818_/A _4818_/B VDD VSS sg13cmos5l_xor2_1
X_5798_ _5826_/B _7095_/Q _5826_/A _5798_/C VDD VSS sg13cmos5l_nand3_1
X_5867_ _5867_/Y _5881_/C VDD VSS sg13cmos5l_inv_1
X_6991__389 _6991_/RESET_B VDD VSS sg13cmos5l_tiehi
X_6419_ _6434_/A _6420_/A _6420_/B _6420_/C VDD VSS sg13cmos5l_a21oi_1
XFILLER_39_217 VDD VSS sg13cmos5l_fill_1
X_3982_ _3991_/B _4733_/B _4645_/B VDD VSS sg13cmos5l_nor2_1
X_6770_ _6789_/B _6771_/A _6771_/B VDD VSS sg13cmos5l_nand2_1
X_4603_ _4605_/C _7052_/Q _4603_/B VDD VSS sg13cmos5l_xnor2_1
X_5583_ _5586_/A _7088_/Q _5583_/B VDD VSS sg13cmos5l_xnor2_1
X_5652_ _5653_/B _5652_/A _5652_/B VDD VSS sg13cmos5l_xnor2_1
X_5721_ _5722_/B _5820_/A _5721_/B VDD VSS sg13cmos5l_xnor2_1
X_4396_ _4403_/B _6952_/A _4399_/A _4399_/B _4396_/D VDD VSS sg13cmos5l_nor4_1
X_4465_ _4506_/A _4176_/Y _4460_/A _4178_/B VDD VSS sg13cmos5l_a21oi_1
X_4534_ _4535_/A _7045_/Q _7072_/Q _6932_/B1 VDD VSS sg13cmos5l_o21ai_1
X_6204_ _6205_/B _6995_/Q _6528_/A VDD VSS sg13cmos5l_xnor2_1
X_7253_ _7254_/D clkload9/A _7253_/D _6253_/A VDD VSS sg13cmos5l_dfrbpq_1
X_7184_ _7184_/Q _7318_/CLK _7184_/D _7184_/RESET_B VDD VSS sg13cmos5l_dfrbpq_1
X_5017_ _5019_/B _5017_/A _5098_/A VDD VSS sg13cmos5l_xor2_1
X_6066_ _6066_/X _6066_/A _6066_/B VDD VSS sg13cmos5l_xor2_1
X_6135_ _7282_/D _7282_/Q _7144_/Q _6139_/S VDD VSS sg13cmos5l_mux2_1
XFILLER_26_36 VDD VSS sg13cmos5l_fill_1
XFILLER_26_434 VDD VSS sg13cmos5l_fill_1
X_5919_ _7149_/D _5926_/A _5943_/S VDD VSS sg13cmos5l_xnor2_1
X_6968_ _6969_/A _6965_/B _6964_/B _4400_/Y VDD VSS sg13cmos5l_o21ai_1
X_6899_ _6901_/A _6899_/A _6899_/B VDD VSS sg13cmos5l_nor2_1
XFILLER_1_599 VDD VSS sg13cmos5l_fill_2
XFILLER_17_412 VDD VSS sg13cmos5l_fill_2
XFILLER_29_294 VDD VSS sg13cmos5l_fill_2
XFILLER_32_404 VDD VSS sg13cmos5l_fill_1
XFILLER_12_183 VDD VSS sg13cmos5l_fill_2
XFILLER_32_426 VDD VSS sg13cmos5l_fill_2
X_4250_ _4260_/B _7021_/Q _4250_/B VDD VSS sg13cmos5l_xnor2_1
X_4181_ _4185_/B _4182_/A _4182_/C _4182_/B VDD VSS sg13cmos5l_o21ai_1
X_3965_ _3972_/A _3966_/A _3966_/B VDD VSS sg13cmos5l_nand2_1
X_6822_ _6842_/B _7010_/Q _6823_/B VDD VSS sg13cmos5l_nand2_1
X_6753_ _6753_/Y _6754_/A _6754_/B VDD VSS sg13cmos5l_nor2_1
X_3896_ _5812_/B _5153_/A _6745_/B VDD VSS sg13cmos5l_xnor2_1
X_5566_ _5577_/A _5566_/A _5566_/B VDD VSS sg13cmos5l_nand2_1
X_5635_ _5635_/Y _5636_/A _5636_/B VDD VSS sg13cmos5l_nor2b_1
X_5704_ _5724_/A _7118_/Q _5685_/C _5682_/Y VDD VSS sg13cmos5l_a21oi_1
X_6684_ _6686_/B _6684_/A _6684_/B VDD VSS sg13cmos5l_xor2_1
X_4379_ _4395_/A _4379_/A _6954_/B VDD VSS sg13cmos5l_nor2_1
X_4448_ _4450_/B _4445_/A _4442_/C _7034_/Q VDD VSS sg13cmos5l_a21oi_1
X_4517_ _4519_/C _7043_/Q _4517_/B VDD VSS sg13cmos5l_xnor2_1
X_5497_ _5500_/A _5497_/A _5497_/B _5497_/C VDD VSS sg13cmos5l_nand3_1
X_7236_ _7236_/Q _7238_/CLK _7236_/D _6299_/A VDD VSS sg13cmos5l_dfrbpq_1
X_7305_ _7305_/Q _7305_/CLK _7305_/D _7305_/RESET_B VDD VSS sg13cmos5l_dfrbpq_1
X_7167_ _7167_/Q _7238_/CLK _7167_/D _6091_/C VDD VSS sg13cmos5l_dfrbpq_1
X_6049_ _6049_/Y _6049_/A _6049_/B VDD VSS sg13cmos5l_xnor2_1
X_6118_ _7225_/D _7225_/Q _6055_/X _6122_/S VDD VSS sg13cmos5l_mux2_1
X_7203__190 _7203_/RESET_B VDD VSS sg13cmos5l_tiehi
X_7098_ _7098_/Q clkload7/A _7098_/D _7098_/RESET_B VDD VSS sg13cmos5l_dfrbpq_1
X_7210__183 _7210_/RESET_B VDD VSS sg13cmos5l_tiehi
XFILLER_1_385 VDD VSS sg13cmos5l_fill_2
XFILLER_18_787 VDD VSS sg13cmos5l_fill_1
XFILLER_13_481 VDD VSS sg13cmos5l_fill_2
X_3681_ _3748_/A _7163_/Q _7162_/Q VDD VSS sg13cmos5l_and2_1
X_3750_ _3756_/C _3749_/A _3749_/B _3749_/C VDD VSS sg13cmos5l_a21oi_1
X_5420_ _5450_/A _5420_/A _5420_/B VDD VSS sg13cmos5l_xor2_1
X_4233_ _4270_/A _4233_/A _4233_/B _4233_/C VDD VSS sg13cmos5l_nand3_1
X_4302_ _4306_/B _7060_/Q _4437_/A _4303_/C VDD VSS sg13cmos5l_and3_1
X_5282_ _5301_/A _5283_/B _5283_/A VDD VSS sg13cmos5l_nand2b_1
X_5351_ _5384_/A _5351_/A _5351_/B VDD VSS sg13cmos5l_nor2_1
X_7021_ _7021_/Q _7103_/CLK _7021_/D _7021_/RESET_B VDD VSS sg13cmos5l_dfrbpq_1
X_4095_ _5153_/C _5787_/B _4800_/A VDD VSS sg13cmos5l_nor2_1
X_4164_ _4165_/C _4164_/A _4164_/B _4164_/C VDD VSS sg13cmos5l_or3_1
XFILLER_11_418 VDD VSS sg13cmos5l_fill_2
X_3948_ _3951_/B _6675_/A _4086_/B _3946_/Y VDD VSS sg13cmos5l_a21oi_1
X_4997_ _4997_/X _4997_/A _4997_/B VDD VSS sg13cmos5l_or2_1
X_6805_ _6825_/A _6806_/A _6806_/B VDD VSS sg13cmos5l_nand2b_1
X_6736_ _6739_/A _6736_/A _6736_/B VDD VSS sg13cmos5l_xor2_1
X_3879_ _3880_/B _7231_/Q _7232_/Q _7233_/Q VDD VSS sg13cmos5l_a21o_1
X_5549_ _5549_/Y _5549_/A _5550_/B VDD VSS sg13cmos5l_nor2_1
X_5618_ _5623_/B _5618_/A _5618_/B _5618_/C VDD VSS sg13cmos5l_nand3_1
X_6667_ _6687_/B _7002_/Q _6668_/B VDD VSS sg13cmos5l_nand2_1
X_6598_ _6600_/B _6663_/A _6598_/B VDD VSS sg13cmos5l_xnor2_1
X_7219_ _7219_/Q _7220_/CLK _7219_/D _7219_/RESET_B VDD VSS sg13cmos5l_dfrbpq_1
XFILLER_15_702 VDD VSS sg13cmos5l_fill_2
Xfanout93 _6612_/B _3825_/X VDD VSS sg13cmos5l_buf_1
Xfanout82 _5943_/S _5967_/A2 VDD VSS sg13cmos5l_buf_1
Xfanout71 _6745_/B _6675_/A VDD VSS sg13cmos5l_buf_1
Xfanout60 _6115_/S _6107_/Y VDD VSS sg13cmos5l_buf_1
XFILLER_18_584 VDD VSS sg13cmos5l_fill_2
XFILLER_20_215 VDD VSS sg13cmos5l_fill_1
XFILLER_21_705 VDD VSS sg13cmos5l_fill_1
X_3802_ _3802_/Y _7114_/Q _4052_/A _4052_/B VDD VSS sg13cmos5l_nand3_1
X_4782_ _4782_/X _4863_/A _4783_/B VDD VSS sg13cmos5l_and2_1
X_4851_ _4853_/C _4851_/A _4851_/B _4851_/C VDD VSS sg13cmos5l_and3_1
X_4920_ _4920_/Y _4920_/A _4920_/B VDD VSS sg13cmos5l_nand2_1
X_3664_ _5272_/A _7075_/Q VDD VSS sg13cmos5l_inv_1
X_3733_ _3733_/Y _7165_/Q _5845_/A VDD VSS sg13cmos5l_nor2_1
X_5403_ _5404_/B _5528_/A _5403_/B VDD VSS sg13cmos5l_nand2_1
X_6521_ _7022_/D _6521_/A _6521_/B _6521_/C VDD VSS sg13cmos5l_and3_1
X_6452_ _6452_/Y _6452_/A _6452_/B VDD VSS sg13cmos5l_nor2_1
X_6383_ _6383_/Y _6383_/A _6383_/B _6383_/C VDD VSS sg13cmos5l_nand3_1
X_4147_ _4149_/C _4146_/A _4165_/B _4146_/C VDD VSS sg13cmos5l_a21oi_1
X_4216_ _4216_/Y _4276_/A VDD VSS sg13cmos5l_inv_1
X_5196_ _7095_/D _5193_/X _5194_/Y _5195_/Y VDD VSS sg13cmos5l_a21oi_1
X_5265_ _5270_/A _7101_/Q _6483_/B _5251_/X VDD VSS sg13cmos5l_a21o_1
X_5334_ _5456_/B _5334_/A _5334_/B VDD VSS sg13cmos5l_xnor2_1
X_7004_ _7004_/Q _7220_/CLK _7004_/D _7004_/RESET_B VDD VSS sg13cmos5l_dfrbpq_1
XFILLER_24_510 VDD VSS sg13cmos5l_fill_1
XFILLER_28_348 VDD VSS sg13cmos5l_fill_1
X_4078_ _4368_/A _4207_/A _4207_/B _4041_/Y VDD VSS sg13cmos5l_o21ai_1
X_7200__193 _7200_/RESET_B VDD VSS sg13cmos5l_tiehi
XFILLER_12_738 VDD VSS sg13cmos5l_fill_1
XFILLER_24_598 VDD VSS sg13cmos5l_fill_1
Xclkload2 clkload2/X clkload2/A VDD VSS sg13cmos5l_buf_8
X_6719_ _6732_/A _7031_/Q _6708_/B _6706_/Y VDD VSS sg13cmos5l_a21oi_1
XFILLER_15_532 VDD VSS sg13cmos5l_fill_2
XFILLER_30_513 VDD VSS sg13cmos5l_fill_1
XFILLER_30_557 VDD VSS sg13cmos5l_fill_1
XFILLER_30_579 VDD VSS sg13cmos5l_fill_1
X_4001_ _4003_/B _6675_/B _4001_/B VDD VSS sg13cmos5l_xnor2_1
X_5050_ _5054_/A _5050_/A _5050_/B VDD VSS sg13cmos5l_xnor2_1
XFILLER_18_381 VDD VSS sg13cmos5l_fill_2
X_4903_ _4903_/Y _4903_/A _4903_/B _4942_/A _4903_/D VDD VSS sg13cmos5l_nor4_1
X_5952_ _5952_/Y _7222_/Q _5921_/B _5980_/B1 _7207_/Q VDD VSS sg13cmos5l_a22oi_1
XFILLER_21_568 VDD VSS sg13cmos5l_fill_1
X_3716_ _3769_/B _7161_/Q _7160_/Q VDD VSS sg13cmos5l_xor2_1
X_4765_ _4772_/A _5535_/A _4885_/B VDD VSS sg13cmos5l_xnor2_1
X_4834_ _4862_/A _4834_/A _4834_/B VDD VSS sg13cmos5l_or2_1
X_5883_ _7134_/D _5901_/A _5883_/B VDD VSS sg13cmos5l_nor2_1
X_6504_ _6504_/Y _4046_/A _4046_/B _4235_/A VDD VSS sg13cmos5l_o21ai_1
XFILLER_20_27 VDD VSS sg13cmos5l_fill_2
X_3647_ _6711_/A _7004_/Q VDD VSS sg13cmos5l_inv_1
X_4696_ _4698_/B _4696_/A _4696_/B VDD VSS sg13cmos5l_xnor2_1
X_5317_ _5319_/C _7078_/Q _5317_/B VDD VSS sg13cmos5l_xnor2_1
X_6435_ _6436_/B _6434_/A _6434_/B _6447_/B VDD VSS sg13cmos5l_o21ai_1
X_6366_ _6368_/C _6381_/A _6366_/B VDD VSS sg13cmos5l_xnor2_1
XFILLER_29_624 VDD VSS sg13cmos5l_fill_2
XFILLER_29_679 VDD VSS sg13cmos5l_fill_1
X_5179_ _5179_/Y _5179_/A _5194_/B VDD VSS sg13cmos5l_nand2_1
X_5248_ _5249_/C _5248_/A _5248_/B VDD VSS sg13cmos5l_nor2_1
X_6297_ _6300_/A _6298_/B _6318_/A VDD VSS sg13cmos5l_nor2b_1
XFILLER_24_373 VDD VSS sg13cmos5l_fill_2
XFILLER_20_590 VDD VSS sg13cmos5l_fill_1
XFILLER_4_712 VDD VSS sg13cmos5l_fill_2
XFILLER_3_277 VDD VSS sg13cmos5l_fill_1
XFILLER_35_605 VDD VSS sg13cmos5l_fill_1
XFILLER_35_649 VDD VSS sg13cmos5l_fill_1
X_4481_ _7067_/D _4481_/A _4480_/Y VDD VSS sg13cmos5l_nor2b_1
X_4550_ _4552_/B _4541_/A _6172_/B _4238_/Y VDD VSS sg13cmos5l_o21ai_1
X_6151_ _7298_/D _7298_/Q _7144_/Q _6170_/S VDD VSS sg13cmos5l_mux2_1
X_6220_ _6220_/X _6220_/A _6220_/B VDD VSS sg13cmos5l_xor2_1
XFILLER_25_0 VDD VSS sg13cmos5l_fill_2
X_5033_ _5070_/B _5033_/A _5033_/B VDD VSS sg13cmos5l_nor2_1
X_5102_ _5130_/B _5103_/B _5103_/C _5103_/A VDD VSS sg13cmos5l_a21oi_1
X_6082_ _7191_/D _6034_/Y _7191_/Q _6087_/S VDD VSS sg13cmos5l_mux2_1
X_5866_ _5866_/X _6123_/C _5866_/B VDD VSS sg13cmos5l_or2_1
X_5935_ _5935_/Y _7172_/Q _5969_/A2 _5961_/B1 _7187_/Q VDD VSS sg13cmos5l_a22oi_1
X_6984_ _6985_/C _6983_/B _6984_/B VDD VSS sg13cmos5l_nand2b_1
XFILLER_21_398 VDD VSS sg13cmos5l_fill_1
X_4679_ _4686_/A _6247_/A _4733_/B VDD VSS sg13cmos5l_xnor2_1
X_4748_ _4753_/D _4756_/A _4755_/B VDD VSS sg13cmos5l_nand2_1
X_4817_ _4818_/B _4817_/A _4817_/B VDD VSS sg13cmos5l_nand2_1
X_5797_ _5798_/C _5811_/B _5796_/C _5796_/A VDD VSS sg13cmos5l_o21ai_1
XFILLER_0_203 VDD VSS sg13cmos5l_fill_1
X_6418_ _6420_/C _6440_/A _6418_/B VDD VSS sg13cmos5l_xnor2_1
X_6349_ _6349_/Y _6402_/A _6349_/B VDD VSS sg13cmos5l_nand2_1
XFILLER_29_476 VDD VSS sg13cmos5l_fill_2
XFILLER_12_343 VDD VSS sg13cmos5l_fill_2
XFILLER_12_365 VDD VSS sg13cmos5l_fill_2
XFILLER_24_181 VDD VSS sg13cmos5l_fill_2
X_3981_ _4645_/B _4052_/A _4052_/B _5381_/B VDD VSS sg13cmos5l_a21oi_1
X_5720_ _5720_/X _5770_/A _5721_/B VDD VSS sg13cmos5l_and2_1
XFILLER_31_663 VDD VSS sg13cmos5l_fill_1
X_4533_ _4539_/A _7045_/Q _7072_/Q VDD VSS sg13cmos5l_nand2_1
X_4602_ _4633_/B _7052_/Q _4603_/B VDD VSS sg13cmos5l_nand2_1
X_5582_ _5583_/B _5582_/A _5582_/B VDD VSS sg13cmos5l_xor2_1
X_5651_ _5651_/Y _5684_/A _5652_/B VDD VSS sg13cmos5l_nor2_1
X_4395_ _4396_/D _4395_/A _4395_/B VDD VSS sg13cmos5l_nand2_1
X_4464_ _4466_/A _6989_/A _4464_/B VDD VSS sg13cmos5l_nand2_1
X_6134_ _7281_/D _7281_/Q _7143_/Q _6139_/S VDD VSS sg13cmos5l_mux2_1
X_6203_ _6203_/Y _6995_/Q _6528_/A VDD VSS sg13cmos5l_nand2_1
X_7252_ _7253_/D clkload9/A _7252_/D _6253_/A VDD VSS sg13cmos5l_dfrbpq_1
X_7183_ _7183_/Q _7224_/CLK _7183_/D _7183_/RESET_B VDD VSS sg13cmos5l_dfrbpq_1
X_5016_ _5056_/B _4999_/A _4999_/B _5098_/A VDD VSS sg13cmos5l_o21ai_1
X_6065_ _6066_/B _6061_/A _6059_/Y _6058_/Y VDD VSS sg13cmos5l_o21ai_1
XFILLER_22_652 VDD VSS sg13cmos5l_fill_2
X_5849_ _5850_/B _5849_/A _5849_/B VDD VSS sg13cmos5l_xnor2_1
X_5918_ _5921_/A _5943_/S VDD VSS sg13cmos5l_inv_1
X_6967_ _7058_/D _6967_/A _6967_/B _6967_/C VDD VSS sg13cmos5l_and3_1
X_6898_ _6898_/X _6898_/A _6899_/B VDD VSS sg13cmos5l_or2_1
XFILLER_1_523 VDD VSS sg13cmos5l_fill_1
XFILLER_17_479 VDD VSS sg13cmos5l_fill_2
X_4180_ _4182_/C _4299_/A _4121_/Y _4123_/Y _4421_/B _4404_/B VDD VSS sg13cmos5l_a221oi_1
XFILLER_35_210 VDD VSS sg13cmos5l_fill_1
XFILLER_35_221 VDD VSS sg13cmos5l_fill_1
XFILLER_36_700 VDD VSS sg13cmos5l_fill_1
XFILLER_31_460 VDD VSS sg13cmos5l_fill_1
XFILLER_31_471 VDD VSS sg13cmos5l_fill_2
XFILLER_35_265 VDD VSS sg13cmos5l_fill_2
X_3895_ _5154_/B _5153_/A _5787_/B VDD VSS sg13cmos5l_nor2_1
X_3964_ _3966_/B _6565_/C _3956_/B _4724_/A VDD VSS sg13cmos5l_o21ai_1
X_5703_ _5781_/A _5729_/A _5729_/B VDD VSS sg13cmos5l_nor2_1
Xclkbuf_0_sd_clk clkbuf_0_sd_clk/X sd_clk VDD VSS sg13cmos5l_buf_8
X_6821_ _6823_/B _6821_/A _6821_/B VDD VSS sg13cmos5l_xnor2_1
X_6752_ _6754_/B _6752_/A _6752_/B VDD VSS sg13cmos5l_xnor2_1
X_6683_ _6712_/A _6684_/B _6684_/A VDD VSS sg13cmos5l_nand2b_1
X_4516_ _4517_/B _4516_/A _4516_/B VDD VSS sg13cmos5l_xor2_1
X_5496_ _5497_/C _7085_/Q _5496_/B VDD VSS sg13cmos5l_xnor2_1
X_5565_ _5582_/A _7114_/Q _5551_/B _5549_/Y VDD VSS sg13cmos5l_a21oi_1
X_5634_ _5636_/B _6700_/A _6656_/B VDD VSS sg13cmos5l_xnor2_1
X_7304_ _7304_/Q _7305_/CLK _7304_/D _7304_/RESET_B VDD VSS sg13cmos5l_dfrbpq_1
X_4378_ _6954_/B _4376_/Y _4378_/B VDD VSS sg13cmos5l_nand2b_1
X_4447_ _6981_/B _4446_/A _4447_/B VDD VSS sg13cmos5l_nand2b_1
X_6117_ _7224_/D _7224_/Q _6049_/Y _6122_/S VDD VSS sg13cmos5l_mux2_1
X_7235_ _7235_/Q _7238_/CLK _7235_/D _6299_/A VDD VSS sg13cmos5l_dfrbpq_1
X_7166_ _7166_/Q _7318_/CLK _7166_/D _6784_/A VDD VSS sg13cmos5l_dfrbpq_1
X_7097_ _7097_/Q clkload7/A _7097_/D _7097_/RESET_B VDD VSS sg13cmos5l_dfrbpq_1
XFILLER_26_276 VDD VSS sg13cmos5l_fill_1
X_6048_ _6049_/B _7314_/Q _7298_/Q VDD VSS sg13cmos5l_xnor2_1
XFILLER_5_169 VDD VSS sg13cmos5l_fill_1
X_3680_ _3744_/A _7165_/Q _7164_/Q VDD VSS sg13cmos5l_xor2_1
X_5350_ _5362_/A _5339_/A _5339_/B _5337_/Y VDD VSS sg13cmos5l_o21ai_1
X_4163_ _4176_/A _7039_/Q _4163_/B VDD VSS sg13cmos5l_xnor2_1
X_4232_ _4233_/C _7023_/Q _4232_/B VDD VSS sg13cmos5l_xnor2_1
X_4301_ _4303_/C _4423_/B _4300_/C _6750_/A VDD VSS sg13cmos5l_o21ai_1
X_5281_ _5283_/B _7103_/Q _5281_/B VDD VSS sg13cmos5l_xnor2_1
X_7020_ _7020_/Q _7103_/CLK _7020_/D _7020_/RESET_B VDD VSS sg13cmos5l_dfrbpq_1
XFILLER_36_574 VDD VSS sg13cmos5l_fill_2
X_4094_ _5812_/C _6745_/B _4800_/A VDD VSS sg13cmos5l_nand2_1
XFILLER_31_290 VDD VSS sg13cmos5l_fill_2
X_3878_ _3882_/B _7231_/Q _7232_/Q _7233_/Q VDD VSS sg13cmos5l_nand3_1
X_3947_ _4086_/B _3947_/A _3947_/B VDD VSS sg13cmos5l_xor2_1
X_4996_ _4999_/A _4975_/A _4975_/B _4995_/X VDD VSS sg13cmos5l_o21ai_1
X_6804_ _6806_/B _7036_/Q _6804_/B VDD VSS sg13cmos5l_xnor2_1
X_6735_ _6742_/A _6736_/A _6736_/B VDD VSS sg13cmos5l_nand2b_1
X_6666_ _6668_/B _6666_/A _6666_/B VDD VSS sg13cmos5l_xnor2_1
X_5479_ _7111_/D _6480_/A _5479_/B _5501_/B VDD VSS sg13cmos5l_nor3_1
X_5548_ _5550_/B _5566_/B _5548_/B VDD VSS sg13cmos5l_nand2_1
X_5617_ _5657_/A _5617_/A _5632_/B _5617_/C VDD VSS sg13cmos5l_nor3_1
X_7218_ _7218_/Q clkload4/A _7218_/D _7218_/RESET_B VDD VSS sg13cmos5l_dfrbpq_1
X_6597_ _6598_/B _6597_/A _6597_/B VDD VSS sg13cmos5l_xnor2_1
X_7149_ _7149_/Q _7220_/CLK _7149_/D fanout144/X VDD VSS sg13cmos5l_dfrbpq_1
XFILLER_6_445 VDD VSS sg13cmos5l_fill_2
Xfanout94 _6592_/B _5535_/B VDD VSS sg13cmos5l_buf_1
Xfanout83 _5967_/A2 _5979_/A2 VDD VSS sg13cmos5l_buf_1
Xfanout72 _6675_/A _5596_/A VDD VSS sg13cmos5l_buf_1
Xfanout61 _6122_/S _6107_/Y VDD VSS sg13cmos5l_buf_1
Xfanout50 _5671_/A _3737_/X VDD VSS sg13cmos5l_buf_1
XFILLER_18_541 VDD VSS sg13cmos5l_fill_1
XFILLER_18_596 VDD VSS sg13cmos5l_fill_1
XFILLER_33_522 VDD VSS sg13cmos5l_fill_1
X_3732_ _3732_/Y _3744_/A _3744_/B VDD VSS sg13cmos5l_nand2_1
X_3801_ _3822_/C _7114_/Q _4052_/A _4052_/B VDD VSS sg13cmos5l_and3_1
X_4781_ _4783_/B _4796_/B _4780_/Y VDD VSS sg13cmos5l_nor2b_1
X_4850_ _4853_/B _4851_/B _4851_/C _4851_/A VDD VSS sg13cmos5l_a21oi_1
X_6520_ _6521_/C _6520_/A _6520_/B VDD VSS sg13cmos5l_nand2_1
X_3663_ _4541_/A _7074_/Q VDD VSS sg13cmos5l_inv_1
X_5333_ _5356_/S _5334_/A _5355_/A _5333_/C VDD VSS sg13cmos5l_nor3_1
X_5402_ _5404_/A _5401_/A _5401_/B _5422_/B VDD VSS sg13cmos5l_a21oi_1
X_6451_ _7015_/D _6452_/B _6451_/B VDD VSS sg13cmos5l_nor2_1
X_6382_ _6384_/A _6383_/A _6383_/B _6383_/C VDD VSS sg13cmos5l_a21oi_1
X_4146_ _4149_/B _4146_/A _4165_/B _4146_/C VDD VSS sg13cmos5l_and3_1
X_4215_ _4276_/A _4217_/A _4217_/B _4217_/C VDD VSS sg13cmos5l_a21o_1
X_5195_ _5195_/Y _5193_/X _5194_/Y _5179_/A VDD VSS sg13cmos5l_o21ai_1
X_5264_ _5274_/A _7074_/Q _5257_/B _5255_/Y VDD VSS sg13cmos5l_a21oi_1
X_7003_ _7003_/Q _7238_/CLK _7003_/D _7003_/RESET_B VDD VSS sg13cmos5l_dfrbpq_1
X_4077_ _4207_/B _4077_/A _4077_/B VDD VSS sg13cmos5l_xnor2_1
X_4979_ _4981_/C _5018_/A _4979_/B _4979_/C VDD VSS sg13cmos5l_and3_1
Xclkload3 clkload3/Y clkload3/A VDD VSS sg13cmos5l_inv_1
X_6718_ _7031_/D _6765_/B _6716_/Y _6717_/Y VDD VSS sg13cmos5l_a21oi_1
X_6649_ _6650_/B _6605_/Y _6627_/A _6691_/C _6590_/X _6625_/Y VDD VSS sg13cmos5l_a221oi_1
XFILLER_30_547 VDD VSS sg13cmos5l_fill_2
X_4000_ _4003_/A _6592_/A _4015_/B _3998_/Y VDD VSS sg13cmos5l_a21oi_1
XFILLER_18_360 VDD VSS sg13cmos5l_fill_2
X_4902_ _4942_/B _4903_/D _4903_/A VDD VSS sg13cmos5l_nor2b_1
X_5882_ _5883_/B _7134_/Q _5896_/A2 _5896_/B1 _7242_/Q VDD VSS sg13cmos5l_a22oi_1
X_5951_ _7158_/D _7158_/Q _5967_/A2 _5950_/Y VDD VSS sg13cmos5l_a21o_1
X_3715_ _3763_/B _7161_/Q _7160_/Q VDD VSS sg13cmos5l_nand2_1
X_4695_ _4696_/B _4863_/A _4695_/B VDD VSS sg13cmos5l_xnor2_1
X_4764_ _4812_/A _5534_/A _4885_/B VDD VSS sg13cmos5l_nand2_1
X_4833_ _4834_/B _4796_/A _4813_/Y _4814_/Y VDD VSS sg13cmos5l_a21o_1
X_6503_ _7021_/D _6492_/Y _6501_/Y _6502_/Y VDD VSS sg13cmos5l_a21oi_1
X_6434_ _6437_/A _6434_/A _6434_/B _6447_/B VDD VSS sg13cmos5l_nor3_1
X_3646_ _6686_/A _7003_/Q VDD VSS sg13cmos5l_inv_1
X_5247_ _5249_/B _5248_/A _5248_/B VDD VSS sg13cmos5l_and2_1
X_5316_ _5344_/B _7078_/Q _5317_/B VDD VSS sg13cmos5l_nand2_1
X_6365_ _6383_/B _6381_/A _6366_/B VDD VSS sg13cmos5l_nand2_1
X_6296_ _6298_/B _6272_/Y _6295_/Y _6337_/A VDD VSS sg13cmos5l_o21ai_1
X_4129_ _4182_/A _4130_/A _4130_/B _4130_/C VDD VSS sg13cmos5l_a21oi_1
X_5178_ _5194_/B _5205_/A _5178_/B VDD VSS sg13cmos5l_or2_1
XFILLER_12_514 VDD VSS sg13cmos5l_fill_1
XFILLER_12_547 VDD VSS sg13cmos5l_decap_8
XFILLER_24_330 VDD VSS sg13cmos5l_fill_2
XFILLER_19_146 VDD VSS sg13cmos5l_fill_1
X_4480_ _4480_/Y _4479_/A _4479_/B _6905_/A VDD VSS sg13cmos5l_a21oi_1
X_5101_ _5103_/C _5150_/A VDD VSS sg13cmos5l_inv_1
X_6150_ _7297_/D _7297_/Q _7143_/Q _6168_/S VDD VSS sg13cmos5l_mux2_1
X_5032_ _5034_/B _5033_/A _5033_/B VDD VSS sg13cmos5l_and2_1
X_6081_ _7190_/D _6029_/Y _7190_/Q _6090_/S VDD VSS sg13cmos5l_mux2_1
X_4816_ _4817_/B _4816_/A _4816_/B VDD VSS sg13cmos5l_nand2_1
X_5865_ _5866_/B _5868_/A _5865_/B VDD VSS sg13cmos5l_nor2_1
X_5934_ _5934_/Y _7217_/Q _5921_/B _5977_/B1 _7202_/Q VDD VSS sg13cmos5l_a22oi_1
X_6983_ _6985_/B _6984_/B _6983_/B VDD VSS sg13cmos5l_nand2b_1
X_4678_ _6614_/A _6247_/A _6592_/B VDD VSS sg13cmos5l_nor2_1
X_4747_ _4755_/B _4747_/A _4747_/B _4747_/C VDD VSS sg13cmos5l_nand3_1
X_5796_ _5826_/A _5796_/A _5811_/B _5796_/C VDD VSS sg13cmos5l_or3_1
X_6417_ _6432_/B _6440_/A _6418_/B VDD VSS sg13cmos5l_nand2_1
X_6348_ _6349_/B _6371_/A _6348_/B VDD VSS sg13cmos5l_or2_1
X_6279_ _6281_/B _6633_/A _6266_/B _6264_/Y VDD VSS sg13cmos5l_o21ai_1
XFILLER_12_388 VDD VSS sg13cmos5l_fill_1
XFILLER_24_193 VDD VSS sg13cmos5l_fill_2
XFILLER_4_510 VDD VSS sg13cmos5l_fill_1
XFILLER_4_521 VDD VSS sg13cmos5l_fill_1
XFILLER_16_672 VDD VSS sg13cmos5l_fill_1
XFILLER_22_108 VDD VSS sg13cmos5l_fill_2
X_3980_ _4805_/S _5534_/B _5381_/B VDD VSS sg13cmos5l_nand2_1
X_5650_ _5652_/B _5680_/B _5650_/B VDD VSS sg13cmos5l_nand2b_1
XFILLER_30_152 VDD VSS sg13cmos5l_fill_2
X_4463_ _4464_/B _4463_/A _4463_/B VDD VSS sg13cmos5l_nor2_1
X_4532_ _7071_/D _4525_/Y _4530_/Y _4531_/Y VDD VSS sg13cmos5l_a21oi_1
X_4601_ _4603_/B _4601_/A _4601_/B VDD VSS sg13cmos5l_xor2_1
X_5581_ _5581_/Y _5582_/A _5582_/B VDD VSS sg13cmos5l_nor2_1
X_7251_ _7252_/D clkload9/A _7251_/D _6253_/A VDD VSS sg13cmos5l_dfrbpq_1
X_4394_ _4395_/B _4394_/A _6946_/B VDD VSS sg13cmos5l_nor2_1
X_6064_ _6066_/A _7317_/Q _7301_/Q VDD VSS sg13cmos5l_xor2_1
X_6133_ _7280_/D _7280_/Q _7142_/Q _6139_/S VDD VSS sg13cmos5l_mux2_1
X_6202_ _6210_/A _6192_/X _6199_/Y _6197_/X VDD VSS sg13cmos5l_a21o_1
X_7182_ _7182_/Q _7298_/CLK _7182_/D _7182_/RESET_B VDD VSS sg13cmos5l_dfrbpq_1
XFILLER_39_731 VDD VSS sg13cmos5l_fill_2
X_5015_ _5098_/A _5015_/A _5015_/B VDD VSS sg13cmos5l_xor2_1
X_6966_ _6967_/C _6965_/B _6966_/B VDD VSS sg13cmos5l_nand2b_1
XFILLER_21_152 VDD VSS sg13cmos5l_fill_2
XFILLER_34_480 VDD VSS sg13cmos5l_fill_2
X_5779_ _5808_/B _5756_/A _5780_/C _5753_/Y VDD VSS sg13cmos5l_a21oi_1
X_5848_ _5849_/B _7098_/Q _5848_/B VDD VSS sg13cmos5l_xnor2_1
X_5917_ _5917_/Y _7238_/Q _5917_/B _5917_/C VDD VSS sg13cmos5l_nand3_1
X_6897_ _6899_/B _6897_/A _6897_/B VDD VSS sg13cmos5l_or2_1
XFILLER_13_631 VDD VSS sg13cmos5l_fill_2
XFILLER_32_428 VDD VSS sg13cmos5l_fill_1
X_6820_ _6842_/A _6821_/A _6821_/B VDD VSS sg13cmos5l_nand2b_1
XFILLER_31_450 VDD VSS sg13cmos5l_decap_4
XFILLER_31_494 VDD VSS sg13cmos5l_decap_8
X_3894_ _4125_/A _6720_/B _5154_/A VDD VSS sg13cmos5l_xnor2_1
X_3963_ _3966_/A _6592_/B _4769_/A VDD VSS sg13cmos5l_xnor2_1
X_5633_ _5673_/A _6303_/A _6656_/B VDD VSS sg13cmos5l_nand2_1
X_5702_ _5729_/B _5702_/A _5702_/B _5702_/C VDD VSS sg13cmos5l_nand3_1
X_6751_ _6751_/Y _6752_/A _6752_/B VDD VSS sg13cmos5l_nor2_1
X_6682_ _6684_/B _7030_/Q _6682_/B VDD VSS sg13cmos5l_xnor2_1
X_4446_ _4446_/Y _4446_/A _4447_/B VDD VSS sg13cmos5l_nor2b_1
X_4515_ _4515_/Y _4516_/A _4516_/B VDD VSS sg13cmos5l_nor2_1
X_5495_ _5496_/B _5495_/A _5495_/B VDD VSS sg13cmos5l_xnor2_1
X_5564_ _5588_/A _5563_/B _5562_/Y _5563_/X _5453_/A VDD VSS sg13cmos5l_a22oi_1
X_7234_ _7234_/Q _7238_/CLK _7234_/D _6299_/A VDD VSS sg13cmos5l_dfrbpq_1
X_7303_ _7303_/Q _7305_/CLK _7303_/D _7303_/RESET_B VDD VSS sg13cmos5l_dfrbpq_1
X_4377_ _4378_/B _4377_/A _4377_/B _4377_/C VDD VSS sg13cmos5l_nand3_1
X_6047_ _6049_/A _6041_/Y _6045_/B _6040_/Y VDD VSS sg13cmos5l_o21ai_1
X_6116_ _7223_/D _7223_/Q _6045_/Y _6122_/S VDD VSS sg13cmos5l_mux2_1
Xclkbuf_leaf_15_sd_clk _7224_/CLK clkload1/A VDD VSS sg13cmos5l_buf_8
X_7165_ _7165_/Q clkload5/A _7165_/D _5179_/A VDD VSS sg13cmos5l_dfrbpq_1
X_7096_ _7096_/Q clkload8/A _7096_/D _7096_/RESET_B VDD VSS sg13cmos5l_dfrbpq_1
X_7134__253 _7134_/RESET_B VDD VSS sg13cmos5l_tiehi
X_6949_ _6949_/Y _6949_/A _6947_/B VDD VSS sg13cmos5l_nor2b_1
XFILLER_22_483 VDD VSS sg13cmos5l_fill_1
X_4300_ _4437_/A _6750_/A _4423_/B _4300_/C VDD VSS sg13cmos5l_or3_1
X_5280_ _5281_/B _5280_/A _5338_/A VDD VSS sg13cmos5l_xnor2_1
X_4093_ _4122_/B _5788_/A _3937_/B _3935_/Y VDD VSS sg13cmos5l_a21oi_1
X_4162_ _4477_/B _7039_/Q _4163_/B VDD VSS sg13cmos5l_nand2_1
X_4231_ _4233_/B _7022_/Q _4262_/B VDD VSS sg13cmos5l_nand2_1
XFILLER_23_236 VDD VSS sg13cmos5l_fill_2
XFILLER_24_704 VDD VSS sg13cmos5l_fill_1
X_4995_ _4995_/X _4975_/A _4975_/B _4940_/A VDD VSS sg13cmos5l_a21o_1
X_6803_ _6806_/A _7035_/Q _6789_/Y _6791_/B VDD VSS sg13cmos5l_a21oi_1
X_3877_ _7232_/D _7231_/Q _7232_/Q VDD VSS sg13cmos5l_xor2_1
X_3946_ _3946_/Y _3947_/A _3947_/B VDD VSS sg13cmos5l_nor2_1
X_5616_ _5618_/C _5632_/A _5613_/C _5613_/A VDD VSS sg13cmos5l_o21ai_1
Xclkbuf_leaf_2_sd_clk _7318_/CLK clkbuf_leaf_2_sd_clk/A VDD VSS sg13cmos5l_buf_8
X_6734_ _6736_/B _6711_/A _6711_/B _6709_/Y VDD VSS sg13cmos5l_o21ai_1
X_6665_ _6687_/A _6666_/B _6666_/A VDD VSS sg13cmos5l_nand2b_1
X_6596_ _6597_/B _6568_/Y _6571_/B _6567_/Y VDD VSS sg13cmos5l_o21ai_1
X_4429_ _4431_/B _7062_/Q _4429_/B VDD VSS sg13cmos5l_xnor2_1
X_5478_ _5501_/B _5478_/A _5525_/A VDD VSS sg13cmos5l_nor2_1
X_5547_ _5548_/B _5547_/A _5547_/B _5547_/C VDD VSS sg13cmos5l_nand3_1
X_7217_ _7217_/Q _7308_/CLK _7217_/D _7217_/RESET_B VDD VSS sg13cmos5l_dfrbpq_1
X_7148_ _7148_/Q _7318_/CLK _7148_/D _7148_/RESET_B VDD VSS sg13cmos5l_dfrbpq_1
X_7079_ _7079_/Q _7104_/CLK _7079_/D _7079_/RESET_B VDD VSS sg13cmos5l_dfrbpq_1
XFILLER_15_704 VDD VSS sg13cmos5l_fill_1
XFILLER_27_575 VDD VSS sg13cmos5l_decap_8
XFILLER_27_586 VDD VSS sg13cmos5l_fill_1
XFILLER_27_597 VDD VSS sg13cmos5l_fill_2
XFILLER_30_729 VDD VSS sg13cmos5l_fill_1
Xfanout73 _5596_/A _3744_/X VDD VSS sg13cmos5l_buf_1
Xfanout62 _5596_/B _5354_/A VDD VSS sg13cmos5l_buf_1
Xfanout51 _5787_/C _4926_/B VDD VSS sg13cmos5l_buf_1
Xfanout40 _4370_/A fanout48/X VDD VSS sg13cmos5l_buf_1
Xfanout95 _6247_/A _5351_/A VDD VSS sg13cmos5l_buf_1
Xfanout84 _5979_/A2 _5917_/Y VDD VSS sg13cmos5l_buf_1
X_7297__411 _7297_/RESET_B VDD VSS sg13cmos5l_tiehi
XFILLER_18_520 VDD VSS sg13cmos5l_fill_1
X_3662_ _3662_/Y _7124_/Q VDD VSS sg13cmos5l_inv_1
X_3731_ _3744_/B _3722_/A _3729_/B _3730_/Y VDD VSS sg13cmos5l_o21ai_1
X_3800_ _3822_/B _7113_/Q _6205_/A VDD VSS sg13cmos5l_xnor2_1
X_4780_ _4780_/Y _4780_/A _4780_/B _4780_/C VDD VSS sg13cmos5l_nand3_1
Xclkload10 clkload10/Y _7224_/CLK VDD VSS sg13cmos5l_inv_2
X_6450_ _6451_/B _6444_/A _6448_/Y _6436_/A VDD VSS sg13cmos5l_o21ai_1
X_5263_ _5263_/Y _5249_/C _5260_/X _5259_/Y VDD VSS sg13cmos5l_a21oi_1
X_5332_ _5357_/A _5335_/A _5334_/B VDD VSS sg13cmos5l_and2_1
X_5401_ _5403_/B _5401_/A _5401_/B _5422_/B VDD VSS sg13cmos5l_nand3_1
X_6381_ _6383_/C _6381_/A _6381_/B VDD VSS sg13cmos5l_xnor2_1
X_4076_ _4207_/A _4201_/A _4069_/B _4071_/Y _4075_/X _4063_/Y VDD VSS sg13cmos5l_a221oi_1
X_4145_ _4146_/C _4145_/A _4145_/B VDD VSS sg13cmos5l_xnor2_1
X_4214_ _4217_/C _7025_/Q _4214_/B VDD VSS sg13cmos5l_xnor2_1
X_5194_ _5194_/Y _5207_/A _5194_/B VDD VSS sg13cmos5l_nand2b_1
X_7002_ _7002_/Q clkload9/A _7002_/D _7002_/RESET_B VDD VSS sg13cmos5l_dfrbpq_1
XFILLER_34_16 VDD VSS sg13cmos5l_fill_2
X_4978_ _4994_/A _4979_/B _4979_/C _5018_/A VDD VSS sg13cmos5l_a21oi_1
X_3929_ _4887_/B _3929_/A _3929_/B _6633_/A VDD VSS sg13cmos5l_nand3_1
X_7246__332 _7246_/RESET_B VDD VSS sg13cmos5l_tiehi
Xclkload4 clkload4/Y clkload4/A VDD VSS sg13cmos5l_inv_2
X_6717_ _6717_/Y _6765_/B _6716_/Y _6967_/A VDD VSS sg13cmos5l_o21ai_1
X_6648_ _6692_/B _6605_/Y _6627_/A _6625_/Y VDD VSS sg13cmos5l_a21oi_1
X_6579_ _6589_/A _6579_/A _6579_/B _6579_/C VDD VSS sg13cmos5l_nand3_1
XFILLER_3_438 VDD VSS sg13cmos5l_fill_2
X_7099__295 _7099_/RESET_B VDD VSS sg13cmos5l_tiehi
XFILLER_18_383 VDD VSS sg13cmos5l_fill_1
XFILLER_25_309 VDD VSS sg13cmos5l_fill_2
XFILLER_33_320 VDD VSS sg13cmos5l_fill_1
XFILLER_33_331 VDD VSS sg13cmos5l_fill_1
X_4832_ _4834_/A _4780_/A _4780_/B _4817_/A _4817_/B _4780_/C VDD VSS sg13cmos5l_a221oi_1
X_4901_ _4901_/Y _4903_/A _4901_/B VDD VSS sg13cmos5l_nor2_1
X_5881_ _7133_/D _7133_/Q _6784_/A _5881_/C VDD VSS sg13cmos5l_and3_1
X_5950_ _5950_/Y _5948_/Y _5949_/Y _5975_/A2 VDD VSS sg13cmos5l_a21oi_1
X_3645_ _6643_/A _7001_/Q VDD VSS sg13cmos5l_inv_1
X_3714_ _3770_/A _3714_/A _3714_/B VDD VSS sg13cmos5l_nor2_1
X_4694_ _4694_/Y _4863_/A _4695_/B VDD VSS sg13cmos5l_nand2_1
X_4763_ _6658_/A _5734_/S _6633_/B VDD VSS sg13cmos5l_nand2_1
X_7050__254 _7050_/RESET_B VDD VSS sg13cmos5l_tiehi
X_6502_ _6502_/Y _6492_/Y _6501_/Y _6584_/B1 VDD VSS sg13cmos5l_o21ai_1
X_6433_ _6447_/B _6433_/A _6432_/Y VDD VSS sg13cmos5l_nor2b_1
X_5246_ _5248_/B _7073_/Q _5246_/B VDD VSS sg13cmos5l_xnor2_1
X_5315_ _5317_/B _5315_/A _5315_/B VDD VSS sg13cmos5l_xnor2_1
X_6364_ _6366_/B _7009_/Q _6428_/A VDD VSS sg13cmos5l_xnor2_1
X_6295_ _6295_/Y _6336_/B VDD VSS sg13cmos5l_inv_1
XFILLER_28_169 VDD VSS sg13cmos5l_fill_1
XFILLER_29_626 VDD VSS sg13cmos5l_fill_1
XFILLER_37_670 VDD VSS sg13cmos5l_fill_1
X_4059_ _4061_/D _4619_/B _4058_/C _4058_/A VDD VSS sg13cmos5l_a21o_1
X_4128_ _4130_/C _6745_/A _4128_/B VDD VSS sg13cmos5l_xnor2_1
X_5177_ _5178_/B _5081_/Y _5206_/A _5175_/Y VDD VSS sg13cmos5l_a21oi_1
XFILLER_12_504 VDD VSS sg13cmos5l_fill_2
XFILLER_24_375 VDD VSS sg13cmos5l_fill_1
X_7287__421 _7287_/RESET_B VDD VSS sg13cmos5l_tiehi
XFILLER_19_114 VDD VSS sg13cmos5l_fill_2
X_7294__414 _7294_/RESET_B VDD VSS sg13cmos5l_tiehi
XFILLER_30_334 VDD VSS sg13cmos5l_fill_2
XFILLER_30_345 VDD VSS sg13cmos5l_fill_1
XFILLER_30_378 VDD VSS sg13cmos5l_fill_1
X_5031_ _5033_/B _4957_/A _5074_/B _5076_/B VDD VSS sg13cmos5l_a21oi_1
X_5100_ _5150_/A _5056_/A _5053_/Y _5052_/Y VDD VSS sg13cmos5l_a21oi_1
X_6080_ _7189_/D _6023_/Y _7189_/Q _6090_/S VDD VSS sg13cmos5l_mux2_1
XFILLER_25_139 VDD VSS sg13cmos5l_fill_2
XFILLER_38_412 VDD VSS sg13cmos5l_fill_2
X_6982_ _6984_/B _6982_/A _6982_/B VDD VSS sg13cmos5l_or2_1
XFILLER_33_194 VDD VSS sg13cmos5l_fill_2
XFILLER_34_651 VDD VSS sg13cmos5l_fill_2
XFILLER_34_684 VDD VSS sg13cmos5l_fill_1
X_4815_ _4817_/A _4816_/A _4816_/B VDD VSS sg13cmos5l_or2_1
X_5795_ _5796_/C _5794_/B _5794_/C _7122_/Q VDD VSS sg13cmos5l_a21oi_1
X_5864_ _7127_/D _5862_/A _6123_/C _5863_/Y VDD VSS sg13cmos5l_a21oi_1
X_5933_ _7153_/D _7153_/Q _5943_/S _5932_/Y VDD VSS sg13cmos5l_a21o_1
X_4677_ _4688_/A _4677_/A _4677_/B VDD VSS sg13cmos5l_nor2_1
X_4746_ _4756_/A _4747_/A _4747_/B _4747_/C VDD VSS sg13cmos5l_a21o_1
X_6416_ _6418_/B _7013_/Q _6428_/A VDD VSS sg13cmos5l_xnor2_1
X_6347_ _6348_/B _6360_/A _6347_/B VDD VSS sg13cmos5l_nand2b_1
X_5229_ _5231_/A _7071_/Q _7098_/Q VDD VSS sg13cmos5l_xnor2_1
X_6278_ _6281_/A _6720_/B _6278_/B VDD VSS sg13cmos5l_xnor2_1
X_7096__298 _7096_/RESET_B VDD VSS sg13cmos5l_tiehi
XFILLER_12_345 VDD VSS sg13cmos5l_fill_1
XFILLER_12_356 VDD VSS sg13cmos5l_fill_1
XFILLER_8_327 VDD VSS sg13cmos5l_fill_2
X_7144__233 _7144_/RESET_B VDD VSS sg13cmos5l_tiehi
XFILLER_16_662 VDD VSS sg13cmos5l_fill_1
X_4600_ _4633_/A _4601_/A _4601_/B VDD VSS sg13cmos5l_nand2_1
XFILLER_30_186 VDD VSS sg13cmos5l_fill_1
X_4462_ _7066_/D _4463_/A _4460_/Y _4461_/Y VDD VSS sg13cmos5l_a21oi_1
X_4531_ _4531_/Y _4525_/Y _4530_/Y _5212_/A VDD VSS sg13cmos5l_o21ai_1
X_5580_ _5582_/B _7115_/Q _5580_/B VDD VSS sg13cmos5l_xnor2_1
X_6201_ _6994_/D _6192_/X _6199_/Y _6200_/Y VDD VSS sg13cmos5l_a21oi_1
X_7250_ _7251_/D clkload9/A _7250_/D _6253_/A VDD VSS sg13cmos5l_dfrbpq_1
X_4393_ _6946_/B _6949_/A _4393_/B VDD VSS sg13cmos5l_nand2b_1
X_5014_ _5056_/A _5015_/A _5015_/B VDD VSS sg13cmos5l_nand2_1
X_6063_ _6063_/X _7317_/Q _7301_/Q VDD VSS sg13cmos5l_and2_1
X_6132_ _7279_/D _7279_/Q _7141_/Q _6132_/S VDD VSS sg13cmos5l_mux2_1
X_7277__431 _7277_/RESET_B VDD VSS sg13cmos5l_tiehi
X_7181_ _7181_/Q _7298_/CLK _7181_/D _7181_/RESET_B VDD VSS sg13cmos5l_dfrbpq_1
XFILLER_26_17 VDD VSS sg13cmos5l_fill_2
X_5916_ _5917_/C _5916_/A _5984_/C VDD VSS sg13cmos5l_nand2_1
X_6965_ _6967_/B _6966_/B _6965_/B VDD VSS sg13cmos5l_nand2b_1
XFILLER_22_654 VDD VSS sg13cmos5l_fill_1
X_4729_ _4731_/C _4762_/A _4728_/C _4728_/A VDD VSS sg13cmos5l_a21oi_1
X_5778_ _5808_/A _5778_/A _5778_/B VDD VSS sg13cmos5l_xor2_1
X_5847_ _5848_/B _3676_/A _3875_/C _3844_/Y VDD VSS sg13cmos5l_o21ai_1
X_7284__424 _7284_/RESET_B VDD VSS sg13cmos5l_tiehi
X_6896_ _6918_/A _6896_/A _6896_/B VDD VSS sg13cmos5l_xnor2_1
X_7291__417 _7291_/RESET_B VDD VSS sg13cmos5l_tiehi
XFILLER_25_492 VDD VSS sg13cmos5l_fill_1
XFILLER_32_82 VDD VSS sg13cmos5l_fill_1
XFILLER_9_636 VDD VSS sg13cmos5l_fill_1
XFILLER_35_201 VDD VSS sg13cmos5l_fill_1
XFILLER_35_267 VDD VSS sg13cmos5l_fill_1
X_6750_ _6752_/B _6750_/A _6750_/B VDD VSS sg13cmos5l_xnor2_1
XFILLER_31_473 VDD VSS sg13cmos5l_fill_1
X_3893_ _5154_/A _3732_/Y _3733_/Y _4155_/A VDD VSS sg13cmos5l_a21oi_1
X_3962_ _3968_/A _3985_/A _3985_/B VDD VSS sg13cmos5l_nand2_1
X_5563_ _5563_/X _5563_/A _5563_/B VDD VSS sg13cmos5l_and2_1
X_5632_ _5655_/A _5632_/A _5632_/B VDD VSS sg13cmos5l_nor2_1
X_5701_ _5702_/C _5701_/A _5701_/B VDD VSS sg13cmos5l_nand2_1
X_6681_ _6682_/B _6707_/A _6681_/B VDD VSS sg13cmos5l_xor2_1
X_4376_ _4376_/Y _4377_/B _4377_/C _4377_/A VDD VSS sg13cmos5l_a21oi_1
X_4445_ _4447_/B _4445_/A _4445_/B _4445_/C VDD VSS sg13cmos5l_nand3_1
X_4514_ _4516_/B _7070_/Q _6907_/B VDD VSS sg13cmos5l_xnor2_1
X_5494_ _5494_/Y _5495_/B _5495_/A VDD VSS sg13cmos5l_nor2b_1
X_7233_ _7233_/Q clkload9/A _7233_/D _6672_/B1 VDD VSS sg13cmos5l_dfrbpq_1
X_7302_ _7302_/Q _7318_/CLK _7302_/D _7302_/RESET_B VDD VSS sg13cmos5l_dfrbpq_1
X_7164_ _7164_/Q clkload5/A _7164_/D _6091_/C VDD VSS sg13cmos5l_dfrbpq_1
X_6046_ _7178_/D _7178_/Q _6045_/Y _6062_/S VDD VSS sg13cmos5l_mux2_1
X_6115_ _7222_/D _7222_/Q _6038_/Y _6115_/S VDD VSS sg13cmos5l_mux2_1
X_7095_ _7095_/Q clkload8/A _7095_/D _7095_/RESET_B VDD VSS sg13cmos5l_dfrbpq_1
XFILLER_22_462 VDD VSS sg13cmos5l_fill_2
X_6948_ _7053_/D _6952_/A _6946_/B _6947_/Y VDD VSS sg13cmos5l_a21oi_1
X_6879_ _6879_/Y _6880_/A _6880_/B VDD VSS sg13cmos5l_nor2_1
XFILLER_33_738 VDD VSS sg13cmos5l_fill_2
X_4230_ _4262_/B _4230_/A _4230_/B VDD VSS sg13cmos5l_xnor2_1
XFILLER_36_510 VDD VSS sg13cmos5l_fill_2
X_4092_ _4299_/A _4091_/Y _4092_/B _4092_/C VDD VSS sg13cmos5l_nand3b_1
X_4161_ _4163_/B _4161_/A _4161_/B VDD VSS sg13cmos5l_xor2_1
X_7274__434 _7274_/RESET_B VDD VSS sg13cmos5l_tiehi
XFILLER_23_204 VDD VSS sg13cmos5l_fill_2
X_3945_ _3947_/B _3945_/A _3945_/B VDD VSS sg13cmos5l_xnor2_1
X_4994_ _5022_/A _4994_/A _4994_/B VDD VSS sg13cmos5l_nor2_1
X_6802_ _7035_/D _6905_/A _6802_/B _6802_/C VDD VSS sg13cmos5l_nor3_1
X_6733_ _6736_/A _7005_/Q _6733_/B VDD VSS sg13cmos5l_xnor2_1
X_3876_ _3876_/Y _5516_/A VDD VSS sg13cmos5l_inv_1
X_5546_ _5566_/B _5547_/A _5547_/B _5547_/C VDD VSS sg13cmos5l_a21o_1
X_5615_ _5617_/C _5614_/B _5614_/C _7116_/Q VDD VSS sg13cmos5l_a21oi_1
X_7281__427 _7281_/RESET_B VDD VSS sg13cmos5l_tiehi
X_6664_ _6666_/B _7029_/Q _6664_/B VDD VSS sg13cmos5l_xnor2_1
X_6595_ _6597_/A _6595_/A _6594_/X VDD VSS sg13cmos5l_nor2b_1
X_4359_ _4359_/Y _4360_/B _4360_/A VDD VSS sg13cmos5l_nand2b_1
X_4428_ _4431_/A _7061_/Q _4427_/C _4424_/Y VDD VSS sg13cmos5l_a21oi_1
X_5477_ _5479_/B _5478_/A _5525_/A VDD VSS sg13cmos5l_and2_1
X_7216_ _7216_/Q clkload4/A _7216_/D _7216_/RESET_B VDD VSS sg13cmos5l_dfrbpq_1
X_7147_ _7147_/Q _7318_/CLK _7147_/D _7147_/RESET_B VDD VSS sg13cmos5l_dfrbpq_1
X_7060__234 _7060_/RESET_B VDD VSS sg13cmos5l_tiehi
XFILLER_27_532 VDD VSS sg13cmos5l_decap_4
X_6029_ _6029_/Y _6029_/A _6029_/B VDD VSS sg13cmos5l_xnor2_1
X_7078_ _7078_/Q _7104_/CLK _7078_/D _7078_/RESET_B VDD VSS sg13cmos5l_dfrbpq_1
XFILLER_10_432 VDD VSS sg13cmos5l_fill_2
XFILLER_13_40 VDD VSS sg13cmos5l_fill_1
XFILLER_30_708 VDD VSS sg13cmos5l_fill_2
Xfanout96 _6592_/A _5352_/A VDD VSS sg13cmos5l_buf_1
Xfanout85 _6164_/S _7126_/D VDD VSS sg13cmos5l_buf_1
Xfanout74 _6132_/S _6123_/Y VDD VSS sg13cmos5l_buf_1
Xfanout63 _6633_/B _5595_/B VDD VSS sg13cmos5l_buf_1
Xfanout52 _6720_/B _5568_/A VDD VSS sg13cmos5l_buf_1
Xfanout41 _6467_/B fanout48/X VDD VSS sg13cmos5l_buf_1
Xfanout30 _6277_/B _6663_/A VDD VSS sg13cmos5l_buf_1
XFILLER_6_414 VDD VSS sg13cmos5l_fill_2
XFILLER_2_664 VDD VSS sg13cmos5l_fill_2
X_3661_ _4985_/A _7062_/Q VDD VSS sg13cmos5l_inv_1
X_3730_ _3730_/Y _3730_/A _3728_/Y VDD VSS sg13cmos5l_nor2b_1
X_5400_ _5422_/B _5400_/A _5400_/B VDD VSS sg13cmos5l_nand2_1
Xclkload11 clkload11/Y _7243_/CLK VDD VSS sg13cmos5l_inv_4
X_6380_ _6394_/B _6381_/A _6381_/B VDD VSS sg13cmos5l_nand2_1
X_4213_ _4392_/B _7025_/Q _4214_/B VDD VSS sg13cmos5l_nand2_1
X_5193_ _5193_/X _5193_/A _5193_/B VDD VSS sg13cmos5l_xor2_1
X_5262_ _7101_/D _5249_/C _5260_/X _5261_/Y VDD VSS sg13cmos5l_a21oi_1
X_5331_ _5334_/B _5355_/A _5333_/C VDD VSS sg13cmos5l_nor2_1
X_7001_ _7001_/Q clkload9/A _7001_/D _7001_/RESET_B VDD VSS sg13cmos5l_dfrbpq_1
X_4075_ _4075_/X _4075_/A _4075_/B VDD VSS sg13cmos5l_and2_1
X_4144_ _4145_/B _4144_/A _4144_/B VDD VSS sg13cmos5l_and2_1
XFILLER_24_557 VDD VSS sg13cmos5l_fill_2
XFILLER_36_384 VDD VSS sg13cmos5l_fill_2
X_3928_ _4926_/B _3756_/B _3756_/C _6700_/B VDD VSS sg13cmos5l_o21ai_1
X_4977_ _4979_/C _4977_/A _4977_/B _4997_/B VDD VSS sg13cmos5l_or3_1
Xclkload5 clkload5/Y clkload5/A VDD VSS sg13cmos5l_inv_2
X_6716_ _6716_/Y _6737_/A _6716_/B VDD VSS sg13cmos5l_nor2_1
X_3859_ _3861_/C _7104_/Q _7103_/Q _7106_/Q _7105_/Q VDD VSS sg13cmos5l_nand4_1
X_5529_ _7113_/D _5560_/A _5527_/B _5528_/Y VDD VSS sg13cmos5l_a21oi_1
X_6647_ _6691_/C _6647_/A _6647_/B VDD VSS sg13cmos5l_nor2_1
X_6578_ _6579_/C _6998_/Q _6578_/B VDD VSS sg13cmos5l_xnor2_1
XFILLER_11_774 VDD VSS sg13cmos5l_fill_2
XFILLER_6_211 VDD VSS sg13cmos5l_fill_1
XFILLER_18_340 VDD VSS sg13cmos5l_fill_1
X_7271__437 _7271_/RESET_B VDD VSS sg13cmos5l_tiehi
XFILLER_21_527 VDD VSS sg13cmos5l_fill_1
X_4762_ _4774_/A _4762_/A _4762_/B VDD VSS sg13cmos5l_and2_1
X_4831_ _4867_/A _7085_/Q _4821_/B _4819_/Y VDD VSS sg13cmos5l_a21oi_1
X_4900_ _4901_/B _4942_/A _4903_/D VDD VSS sg13cmos5l_nor2_1
X_5880_ _7132_/D _5907_/A _5880_/B VDD VSS sg13cmos5l_nor2_1
X_3644_ _6604_/A _6999_/Q VDD VSS sg13cmos5l_inv_1
X_3713_ _3714_/B _3711_/Y _3713_/B VDD VSS sg13cmos5l_nand2b_1
X_4693_ _4695_/B _4761_/A _4761_/B VDD VSS sg13cmos5l_xor2_1
X_6501_ _6501_/Y _6501_/A _6501_/B VDD VSS sg13cmos5l_xnor2_1
X_6432_ _6432_/Y _6432_/A _6432_/B _6432_/C VDD VSS sg13cmos5l_nand3_1
X_6363_ _6383_/A _7009_/Q _6415_/B VDD VSS sg13cmos5l_nand2_1
X_5176_ _5206_/A _5176_/A _5176_/B _5176_/C VDD VSS sg13cmos5l_nor3_1
X_5245_ _5246_/B _5245_/A _5245_/B VDD VSS sg13cmos5l_xor2_1
X_5314_ _5344_/A _5315_/A _5315_/B VDD VSS sg13cmos5l_nand2b_1
X_6294_ _6336_/B _6294_/A _6294_/B VDD VSS sg13cmos5l_nor2_1
XFILLER_24_332 VDD VSS sg13cmos5l_fill_1
XFILLER_28_115 VDD VSS sg13cmos5l_fill_2
X_4058_ _4610_/A _4058_/A _4619_/B _4058_/C VDD VSS sg13cmos5l_nand3_1
X_4127_ _4128_/B _4127_/A _4127_/B VDD VSS sg13cmos5l_xor2_1
X_7198__195 _7198_/RESET_B VDD VSS sg13cmos5l_tiehi
XFILLER_3_203 VDD VSS sg13cmos5l_fill_2
XFILLER_4_759 VDD VSS sg13cmos5l_fill_2
XFILLER_28_671 VDD VSS sg13cmos5l_fill_1
X_7038__342 _7038_/RESET_B VDD VSS sg13cmos5l_tiehi
X_5030_ _5074_/B _5030_/A _5030_/B _5030_/C VDD VSS sg13cmos5l_nor3_1
X_5932_ _5932_/Y _5929_/Y _5931_/Y _5975_/A2 VDD VSS sg13cmos5l_a21oi_1
X_6981_ _6982_/B _6981_/A _6981_/B _6981_/C VDD VSS sg13cmos5l_nor3_1
XFILLER_34_696 VDD VSS sg13cmos5l_fill_2
X_4745_ _4747_/C _7056_/Q _4745_/B VDD VSS sg13cmos5l_xnor2_1
X_4814_ _4814_/Y _4816_/A _4816_/B VDD VSS sg13cmos5l_nor2b_1
X_5794_ _5811_/B _7122_/Q _5794_/B _5794_/C VDD VSS sg13cmos5l_and3_1
X_5863_ _5863_/Y _7244_/Q _6123_/C _6402_/A VDD VSS sg13cmos5l_o21ai_1
X_4676_ _4691_/A _4676_/A _4676_/B VDD VSS sg13cmos5l_and2_1
X_6415_ _6432_/A _7013_/Q _6415_/B VDD VSS sg13cmos5l_nand2_1
X_6346_ _6347_/B _6346_/A _6346_/B _6346_/C VDD VSS sg13cmos5l_nand3_1
X_5159_ _5159_/Y _5159_/A _5160_/B VDD VSS sg13cmos5l_nand2_1
X_5228_ _5232_/A _7070_/Q _5219_/B _5217_/Y VDD VSS sg13cmos5l_a21oi_1
X_6277_ _6278_/B _7002_/Q _6277_/B VDD VSS sg13cmos5l_xnor2_1
XFILLER_16_107 VDD VSS sg13cmos5l_fill_1
XFILLER_16_118 VDD VSS sg13cmos5l_fill_2
X_7068__335 _7068_/RESET_B VDD VSS sg13cmos5l_tiehi
XFILLER_4_567 VDD VSS sg13cmos5l_fill_1
XFILLER_30_154 VDD VSS sg13cmos5l_fill_1
XFILLER_30_165 VDD VSS sg13cmos5l_fill_2
XFILLER_31_611 VDD VSS sg13cmos5l_fill_2
XFILLER_31_644 VDD VSS sg13cmos5l_decap_4
XFILLER_31_688 VDD VSS sg13cmos5l_decap_4
XFILLER_7_372 VDD VSS sg13cmos5l_fill_1
X_4392_ _4393_/B _4392_/A _4392_/B _4392_/C VDD VSS sg13cmos5l_nand3_1
X_4461_ _4461_/Y _4463_/A _4460_/Y _5212_/A VDD VSS sg13cmos5l_o21ai_1
X_4530_ _4530_/Y _4530_/A _4530_/B VDD VSS sg13cmos5l_xnor2_1
X_6131_ _7278_/D _7278_/Q _7140_/Q _6139_/S VDD VSS sg13cmos5l_mux2_1
X_6200_ _6200_/Y _6192_/X _6199_/Y _6584_/B1 VDD VSS sg13cmos5l_o21ai_1
X_7180_ _7180_/Q _7298_/CLK _7180_/D _7180_/RESET_B VDD VSS sg13cmos5l_dfrbpq_1
XFILLER_23_0 VDD VSS sg13cmos5l_fill_2
X_5013_ _5015_/B _4973_/A _4973_/B _4971_/Y VDD VSS sg13cmos5l_a21o_1
X_6062_ _7181_/D _7181_/Q _6061_/Y _6062_/S VDD VSS sg13cmos5l_mux2_1
XFILLER_34_482 VDD VSS sg13cmos5l_fill_1
X_5846_ _5849_/A _3662_/Y _6804_/B _5845_/Y VDD VSS sg13cmos5l_o21ai_1
X_5915_ _5984_/C _7169_/Q _7151_/Q VDD VSS sg13cmos5l_xnor2_1
X_7195__198 _7195_/RESET_B VDD VSS sg13cmos5l_tiehi
X_6964_ _6966_/B _4351_/Y _6964_/B VDD VSS sg13cmos5l_nand2b_1
X_6895_ _6915_/A _6896_/A _6896_/B VDD VSS sg13cmos5l_nor2_1
XFILLER_21_154 VDD VSS sg13cmos5l_fill_1
X_4659_ _4660_/B _4659_/A _4659_/B VDD VSS sg13cmos5l_xnor2_1
X_4728_ _4762_/B _4728_/A _4762_/A _4728_/C VDD VSS sg13cmos5l_nand3_1
X_5777_ _5803_/A _5778_/A _5778_/B VDD VSS sg13cmos5l_nor2b_1
X_7028__352 _7028_/RESET_B VDD VSS sg13cmos5l_tiehi
X_6329_ _6329_/Y _6330_/B _6327_/Y VDD VSS sg13cmos5l_nor2b_1
XFILLER_29_243 VDD VSS sg13cmos5l_fill_1
XFILLER_13_633 VDD VSS sg13cmos5l_fill_1
XFILLER_25_482 VDD VSS sg13cmos5l_fill_2
XFILLER_9_604 VDD VSS sg13cmos5l_fill_1
X_7035__345 _7035_/RESET_B VDD VSS sg13cmos5l_tiehi
XFILLER_4_342 VDD VSS sg13cmos5l_fill_2
X_7042__338 _7042_/RESET_B VDD VSS sg13cmos5l_tiehi
X_3961_ _3985_/B _4841_/B _3961_/B VDD VSS sg13cmos5l_nand2_1
X_5700_ _5702_/B _5700_/A _5700_/B _5702_/A _5701_/B VDD VSS sg13cmos5l_nand4_1
XFILLER_31_430 VDD VSS sg13cmos5l_fill_1
X_3892_ _5094_/A _5818_/C _3892_/B VDD VSS sg13cmos5l_nand2_1
X_4513_ _4516_/A _7069_/Q _6877_/B _4467_/Y VDD VSS sg13cmos5l_a21oi_1
X_5562_ _5562_/Y _5562_/A _5562_/B VDD VSS sg13cmos5l_nand2_1
X_5631_ _7116_/D _5628_/X _5629_/Y _5630_/Y VDD VSS sg13cmos5l_a21oi_1
X_7301_ _7301_/Q _7318_/CLK _7301_/D _7301_/RESET_B VDD VSS sg13cmos5l_dfrbpq_1
X_6680_ _6680_/X _6707_/A _6681_/B VDD VSS sg13cmos5l_and2_1
X_4375_ _4377_/C _7027_/Q _4386_/B VDD VSS sg13cmos5l_nand2_1
X_4444_ _4446_/A _4445_/A _4445_/B _4445_/C VDD VSS sg13cmos5l_a21oi_1
X_5493_ _5495_/B _7112_/Q _5493_/B VDD VSS sg13cmos5l_xnor2_1
X_6114_ _7221_/D _7221_/Q _6034_/Y _6115_/S VDD VSS sg13cmos5l_mux2_1
X_7232_ _7232_/Q clkload9/A _7232_/D _6672_/B1 VDD VSS sg13cmos5l_dfrbpq_1
X_7163_ _7163_/Q clkload5/A _7163_/D _6091_/C VDD VSS sg13cmos5l_dfrbpq_1
X_7094_ _7094_/Q clkload8/A _7094_/D _7094_/RESET_B VDD VSS sg13cmos5l_dfrbpq_1
XFILLER_37_39 VDD VSS sg13cmos5l_fill_1
XFILLER_39_574 VDD VSS sg13cmos5l_decap_4
X_6045_ _6045_/Y _6045_/A _6045_/B VDD VSS sg13cmos5l_xnor2_1
XFILLER_14_408 VDD VSS sg13cmos5l_fill_2
XFILLER_26_268 VDD VSS sg13cmos5l_fill_2
X_5829_ _5831_/B _5829_/A _5829_/B _5829_/C VDD VSS sg13cmos5l_and3_1
X_6947_ _6947_/Y _6947_/A _6947_/B VDD VSS sg13cmos5l_nand2_1
X_6878_ _6880_/B _7040_/Q _6877_/B _4470_/A VDD VSS sg13cmos5l_a21oi_1
XFILLER_32_238 VDD VSS sg13cmos5l_fill_1
X_4160_ _4477_/A _4161_/A _4161_/B VDD VSS sg13cmos5l_or2_1
X_4091_ _4091_/Y _4285_/A _4091_/B VDD VSS sg13cmos5l_nand2b_1
XFILLER_23_238 VDD VSS sg13cmos5l_fill_1
X_3875_ _3875_/X _3875_/A _3875_/B _3875_/C VDD VSS sg13cmos5l_and3_1
X_3944_ _3947_/A _3970_/A _3970_/B VDD VSS sg13cmos5l_nand2_1
X_4993_ _7089_/D _6971_/A _4993_/B _4993_/C VDD VSS sg13cmos5l_nor3_1
X_7018__362 _7018_/RESET_B VDD VSS sg13cmos5l_tiehi
X_6801_ _6802_/C _6831_/B _6800_/A VDD VSS sg13cmos5l_nor2b_1
X_6732_ _6733_/B _6732_/A _6732_/B VDD VSS sg13cmos5l_xor2_1
X_6663_ _6664_/B _6663_/A _6663_/B VDD VSS sg13cmos5l_xor2_1
X_5476_ _5525_/A _5476_/A _5476_/B VDD VSS sg13cmos5l_xor2_1
X_5545_ _5545_/Y _5547_/A _5547_/B _5547_/C VDD VSS sg13cmos5l_a21oi_1
X_5614_ _5618_/B _7116_/Q _5614_/B _5614_/C VDD VSS sg13cmos5l_nand3_1
X_6594_ _6594_/X _6633_/B _5381_/B _6592_/Y VDD VSS sg13cmos5l_a21o_1
X_4289_ _4292_/B _7059_/Q _4289_/B _4289_/C VDD VSS sg13cmos5l_and3_1
X_4358_ _4360_/B _7055_/Q _4358_/B VDD VSS sg13cmos5l_xnor2_1
X_4427_ _4439_/A _7061_/Q _4427_/B _4427_/C VDD VSS sg13cmos5l_nand3_1
X_7215_ _7215_/Q _7238_/CLK _7215_/D _7215_/RESET_B VDD VSS sg13cmos5l_dfrbpq_1
X_7146_ _7146_/Q _7318_/CLK _7146_/D _7146_/RESET_B VDD VSS sg13cmos5l_dfrbpq_1
X_7077_ _7077_/Q _7104_/CLK _7077_/D _7077_/RESET_B VDD VSS sg13cmos5l_dfrbpq_1
X_7025__355 _7025_/RESET_B VDD VSS sg13cmos5l_tiehi
XFILLER_14_227 VDD VSS sg13cmos5l_fill_2
XFILLER_27_500 VDD VSS sg13cmos5l_decap_4
X_6028_ _6029_/B _6021_/B _6023_/B _6019_/X VDD VSS sg13cmos5l_a21oi_1
Xfanout97 _6656_/B _5352_/A VDD VSS sg13cmos5l_buf_1
Xfanout86 _6161_/S _7126_/D VDD VSS sg13cmos5l_buf_1
Xfanout75 _6139_/S _6123_/Y VDD VSS sg13cmos5l_buf_1
Xfanout64 _6675_/B _5380_/A VDD VSS sg13cmos5l_buf_1
Xfanout53 _5735_/B _5568_/A VDD VSS sg13cmos5l_buf_1
Xfanout42 _5267_/B fanout48/X VDD VSS sg13cmos5l_buf_1
Xfanout31 _6663_/A _4317_/A VDD VSS sg13cmos5l_buf_1
Xfanout20 _5652_/A _7230_/D VDD VSS sg13cmos5l_buf_1
X_7071__331 _7071_/RESET_B VDD VSS sg13cmos5l_tiehi
X_7032__348 _7032_/RESET_B VDD VSS sg13cmos5l_tiehi
XFILLER_33_569 VDD VSS sg13cmos5l_fill_1
X_3660_ _4700_/A _7055_/Q VDD VSS sg13cmos5l_inv_1
X_5330_ _5333_/C _5330_/A _5330_/B _5330_/C VDD VSS sg13cmos5l_nor3_1
Xclkload12 clkload12/Y _7244_/CLK VDD VSS sg13cmos5l_inv_4
X_4143_ _4145_/A _5153_/A _5001_/B _5154_/A VDD VSS sg13cmos5l_o21ai_1
X_4212_ _4214_/B _4212_/A _4212_/B VDD VSS sg13cmos5l_xor2_1
X_5192_ _5207_/B _5193_/A _5193_/B VDD VSS sg13cmos5l_nand2_1
X_5261_ _5261_/Y _5249_/C _5260_/X _6932_/B1 VDD VSS sg13cmos5l_o21ai_1
X_7000_ _7000_/Q clkload9/A _7000_/D _7000_/RESET_B VDD VSS sg13cmos5l_dfrbpq_1
XFILLER_28_308 VDD VSS sg13cmos5l_fill_2
XFILLER_36_396 VDD VSS sg13cmos5l_fill_2
X_4074_ _4075_/B _5280_/A _4645_/C VDD VSS sg13cmos5l_nor2_1
XFILLER_24_547 VDD VSS sg13cmos5l_fill_2
X_3858_ _3861_/B _7108_/Q _7107_/Q VDD VSS sg13cmos5l_nand2_1
X_3927_ _4927_/B _4800_/A _6633_/A VDD VSS sg13cmos5l_nor2_1
X_4976_ _4979_/B _4977_/A _4977_/B _4997_/B VDD VSS sg13cmos5l_o21ai_1
Xclkload6 clkload6/Y clkload6/A VDD VSS sg13cmos5l_inv_2
X_6715_ _6765_/B _6761_/A _6715_/B VDD VSS sg13cmos5l_nand2_1
X_6646_ _6692_/A _6653_/A _6646_/B VDD VSS sg13cmos5l_nand2b_1
X_3789_ _4053_/A _3789_/A _3789_/B _4046_/A VDD VSS sg13cmos5l_nor3_1
X_5459_ _5461_/B _5459_/A _5459_/B VDD VSS sg13cmos5l_xor2_1
X_5528_ _5528_/Y _5528_/A _5530_/B VDD VSS sg13cmos5l_nand2_1
X_6577_ _6606_/B _6998_/Q _6578_/B VDD VSS sg13cmos5l_nand2_1
X_7129_ _7129_/Q clkload6/A _7129_/D _7129_/RESET_B VDD VSS sg13cmos5l_dfrbpq_1
XFILLER_27_330 VDD VSS sg13cmos5l_fill_1
XFILLER_27_396 VDD VSS sg13cmos5l_fill_2
XFILLER_23_580 VDD VSS sg13cmos5l_fill_1
X_7008__372 _7008_/RESET_B VDD VSS sg13cmos5l_tiehi
XFILLER_33_311 VDD VSS sg13cmos5l_fill_2
XFILLER_38_617 VDD VSS sg13cmos5l_fill_1
XFILLER_33_399 VDD VSS sg13cmos5l_decap_8
X_3712_ _3713_/B _7160_/Q _7158_/Q _7159_/Q VDD VSS sg13cmos5l_o21ai_1
X_4692_ _4761_/B _4660_/A _4658_/Y _4657_/Y VDD VSS sg13cmos5l_o21ai_1
X_4761_ _4780_/B _4761_/A _4761_/B _4761_/C _4761_/D VDD VSS sg13cmos5l_nand4_1
X_4830_ _7085_/D _4873_/B _4828_/Y _4829_/Y VDD VSS sg13cmos5l_a21oi_1
X_7015__365 _7015_/RESET_B VDD VSS sg13cmos5l_tiehi
X_6500_ _6500_/X _6501_/A _6501_/B VDD VSS sg13cmos5l_or2_1
X_3643_ _5360_/A _7107_/Q VDD VSS sg13cmos5l_inv_1
X_5313_ _5315_/B _7105_/Q _5313_/B VDD VSS sg13cmos5l_xnor2_1
X_6431_ _6433_/A _6432_/A _6432_/B _6432_/C VDD VSS sg13cmos5l_a21oi_1
X_6362_ _7008_/D _6359_/Y _6360_/Y _6361_/Y VDD VSS sg13cmos5l_a21oi_1
X_6293_ _6337_/A _6281_/A _6281_/B _6292_/Y VDD VSS sg13cmos5l_a21oi_1
X_4126_ _4126_/Y _4127_/A _4127_/B VDD VSS sg13cmos5l_nor2_1
X_5175_ _5175_/Y _5176_/B _5175_/B VDD VSS sg13cmos5l_nor2_1
X_5244_ _5244_/Y _5245_/A _5245_/B VDD VSS sg13cmos5l_nor2_1
X_7022__358 _7022_/RESET_B VDD VSS sg13cmos5l_tiehi
XFILLER_12_506 VDD VSS sg13cmos5l_fill_1
X_4057_ _4060_/C _4619_/B _4058_/C VDD VSS sg13cmos5l_nand2_1
X_4959_ _4988_/A _7061_/Q _4951_/B _4949_/Y VDD VSS sg13cmos5l_a21o_1
X_6629_ _6631_/B _6629_/A _6647_/B VDD VSS sg13cmos5l_nor2b_1
XFILLER_27_171 VDD VSS sg13cmos5l_fill_1
XFILLER_11_550 VDD VSS sg13cmos5l_fill_1
XFILLER_30_358 VDD VSS sg13cmos5l_fill_2
XFILLER_7_587 VDD VSS sg13cmos5l_fill_2
XFILLER_34_653 VDD VSS sg13cmos5l_fill_1
X_5862_ _5862_/Y _5862_/A _6123_/B _6123_/C VDD VSS sg13cmos5l_nor3_1
X_5931_ _5931_/Y _7171_/Q _5969_/A2 _5961_/B1 _7186_/Q VDD VSS sg13cmos5l_a22oi_1
X_6980_ _7062_/D _4446_/Y _6978_/X _6979_/Y VDD VSS sg13cmos5l_a21oi_1
XFILLER_33_196 VDD VSS sg13cmos5l_fill_1
X_4675_ _4698_/A _5396_/A _4663_/B _4661_/Y VDD VSS sg13cmos5l_o21ai_1
X_4744_ _4745_/B _4744_/A _4744_/B VDD VSS sg13cmos5l_xnor2_1
X_4813_ _4813_/Y _4816_/B _4816_/A VDD VSS sg13cmos5l_nand2b_1
X_5793_ _5794_/C _5819_/A _5792_/C _5792_/A VDD VSS sg13cmos5l_a21o_1
X_5227_ _5227_/Y _5221_/A _5221_/B _5226_/Y _5212_/B VDD VSS sg13cmos5l_a22oi_1
X_6276_ _6276_/Y _7002_/Q _6277_/B VDD VSS sg13cmos5l_nand2_1
X_6414_ _7012_/D _6422_/C _6412_/Y _6413_/Y VDD VSS sg13cmos5l_a21oi_1
X_6345_ _6360_/A _6346_/A _6346_/B _6346_/C VDD VSS sg13cmos5l_a21oi_1
XFILLER_29_469 VDD VSS sg13cmos5l_decap_8
X_4109_ _4111_/B _6675_/B _4097_/Y _5153_/C VDD VSS sg13cmos5l_a21oi_1
X_5089_ _5090_/B _5089_/A _5089_/B VDD VSS sg13cmos5l_xor2_1
X_5158_ _5160_/B _5158_/A _5158_/B VDD VSS sg13cmos5l_xnor2_1
XFILLER_25_686 VDD VSS sg13cmos5l_fill_1
XFILLER_25_697 VDD VSS sg13cmos5l_fill_2
XFILLER_37_480 VDD VSS sg13cmos5l_decap_4
Xclkbuf_leaf_8_sd_clk _7243_/CLK clkload2/A VDD VSS sg13cmos5l_buf_8
XFILLER_20_391 VDD VSS sg13cmos5l_fill_2
X_7005__375 _7005_/RESET_B VDD VSS sg13cmos5l_tiehi
XFILLER_16_686 VDD VSS sg13cmos5l_fill_2
X_7012__368 _7012_/RESET_B VDD VSS sg13cmos5l_tiehi
X_4391_ _6949_/A _4392_/A _4392_/B _4392_/C VDD VSS sg13cmos5l_a21oi_1
X_4460_ _4460_/Y _4460_/A _6990_/B VDD VSS sg13cmos5l_nor2_1
X_6130_ _7277_/D _7277_/Q _7139_/Q _6132_/S VDD VSS sg13cmos5l_mux2_1
XFILLER_16_0 VDD VSS sg13cmos5l_fill_1
X_5012_ _5015_/A _5012_/A _5012_/B VDD VSS sg13cmos5l_xor2_1
X_6061_ _6061_/Y _6061_/A _6061_/B VDD VSS sg13cmos5l_xnor2_1
XFILLER_21_111 VDD VSS sg13cmos5l_fill_1
XFILLER_34_461 VDD VSS sg13cmos5l_fill_1
X_5845_ _5845_/Y _5845_/A _6772_/A VDD VSS sg13cmos5l_nand2_1
X_5914_ _5916_/A _5984_/A _5984_/B VDD VSS sg13cmos5l_nor2_1
X_6963_ _7057_/D _6967_/A _6963_/B _6964_/B VDD VSS sg13cmos5l_and3_1
X_6894_ _6896_/B _7014_/Q _6881_/B _6879_/Y VDD VSS sg13cmos5l_a21oi_1
X_4658_ _4658_/Y _4676_/B _4657_/C _4659_/A VDD VSS sg13cmos5l_a21oi_1
X_4727_ _4731_/B _4728_/A _4762_/A _4728_/C VDD VSS sg13cmos5l_and3_1
X_5776_ _5778_/B _5776_/A _5776_/B VDD VSS sg13cmos5l_nand2_1
X_4589_ _4592_/A _7051_/Q _4589_/B VDD VSS sg13cmos5l_xnor2_1
X_6259_ _6270_/B _6257_/X _6259_/B VDD VSS sg13cmos5l_nand2b_1
X_6328_ _6330_/B _6720_/A _6313_/B _6311_/Y VDD VSS sg13cmos5l_o21ai_1
XFILLER_40_453 VDD VSS sg13cmos5l_fill_2
XFILLER_9_616 VDD VSS sg13cmos5l_fill_2
X_3891_ _4155_/A _3891_/A _3890_/B VDD VSS sg13cmos5l_nor2b_1
X_3960_ _3961_/B _6196_/A _4683_/A VDD VSS sg13cmos5l_nand2_1
XFILLER_7_170 VDD VSS sg13cmos5l_fill_1
X_4512_ _7069_/D _4512_/A _4512_/B VDD VSS sg13cmos5l_and2_1
X_5492_ _5493_/B _5492_/A _5492_/B VDD VSS sg13cmos5l_xor2_1
X_5561_ _5563_/B _5522_/Y _5556_/Y _5562_/B _5524_/X _5555_/Y VDD VSS sg13cmos5l_a221oi_1
X_5630_ _5630_/Y _5628_/X _5629_/Y _5072_/A VDD VSS sg13cmos5l_o21ai_1
X_7231_ _7231_/Q clkload9/A _7231_/D _6672_/B1 VDD VSS sg13cmos5l_dfrbpq_1
X_7300_ _7300_/Q _7316_/CLK _7300_/D _7300_/RESET_B VDD VSS sg13cmos5l_dfrbpq_1
XFILLER_39_520 VDD VSS sg13cmos5l_fill_2
X_4374_ _4386_/B _4374_/A _4374_/B VDD VSS sg13cmos5l_xnor2_1
X_4443_ _4445_/C _7035_/Q _4443_/B VDD VSS sg13cmos5l_xnor2_1
X_6044_ _6045_/B _7312_/Q _7296_/Q _6043_/X VDD VSS sg13cmos5l_o21ai_1
X_6113_ _7220_/D _7220_/Q _6029_/Y _6115_/S VDD VSS sg13cmos5l_mux2_1
X_7162_ _7162_/Q _7224_/CLK _7162_/D _6740_/A VDD VSS sg13cmos5l_dfrbpq_1
X_7093_ _7093_/Q clkload8/A _7093_/D _7093_/RESET_B VDD VSS sg13cmos5l_dfrbpq_1
XFILLER_26_258 VDD VSS sg13cmos5l_fill_2
XFILLER_39_531 VDD VSS sg13cmos5l_fill_2
X_6946_ _6947_/B _6952_/A _6946_/B VDD VSS sg13cmos5l_or2_1
XFILLER_22_464 VDD VSS sg13cmos5l_fill_1
X_5759_ _5774_/A _5759_/A _5759_/B VDD VSS sg13cmos5l_nor2_1
X_5828_ _5829_/C _5828_/A _5828_/B VDD VSS sg13cmos5l_xnor2_1
X_6877_ _6880_/A _7041_/Q _6877_/B VDD VSS sg13cmos5l_xnor2_1
X_7002__378 _7002_/RESET_B VDD VSS sg13cmos5l_tiehi
XFILLER_40_283 VDD VSS sg13cmos5l_fill_1
XFILLER_5_630 VDD VSS sg13cmos5l_fill_1
XFILLER_5_652 VDD VSS sg13cmos5l_fill_2
XFILLER_36_556 VDD VSS sg13cmos5l_decap_4
X_4090_ _4285_/C _4092_/C _4092_/B _4091_/B VDD VSS sg13cmos5l_and3_1
X_6800_ _6802_/B _6800_/A _6831_/B VDD VSS sg13cmos5l_nor2b_1
XFILLER_23_206 VDD VSS sg13cmos5l_fill_1
XFILLER_31_261 VDD VSS sg13cmos5l_fill_1
XFILLER_31_283 VDD VSS sg13cmos5l_fill_2
XFILLER_36_589 VDD VSS sg13cmos5l_fill_2
X_3874_ _3875_/C _3874_/A _3874_/B _3874_/C _3874_/D VDD VSS sg13cmos5l_nand4_1
X_3943_ _3970_/B _6592_/B _3942_/B _4929_/B VDD VSS sg13cmos5l_o21ai_1
X_4992_ _4993_/C _4992_/A _4991_/A VDD VSS sg13cmos5l_nor2b_1
X_5613_ _5632_/B _5613_/A _5632_/A _5613_/C VDD VSS sg13cmos5l_nor3_1
X_7088__306 _7088_/RESET_B VDD VSS sg13cmos5l_tiehi
X_6731_ _6731_/Y _6732_/A _6732_/B VDD VSS sg13cmos5l_nor2_1
X_6662_ _6662_/X _6663_/A _6663_/B VDD VSS sg13cmos5l_and2_1
X_4426_ _4427_/C _5106_/A _4426_/B _4426_/C VDD VSS sg13cmos5l_nand3_1
X_5475_ _5501_/A _5476_/A _5476_/B VDD VSS sg13cmos5l_nor2b_1
X_5544_ _5547_/C _5544_/A VDD VSS sg13cmos5l_inv_1
X_7214_ _7214_/Q _7298_/CLK _7214_/D _7214_/RESET_B VDD VSS sg13cmos5l_dfrbpq_1
X_6593_ _6595_/A _6593_/A _6592_/Y VDD VSS sg13cmos5l_nor2b_1
X_4288_ _4289_/C _4288_/A _4288_/B _4288_/C VDD VSS sg13cmos5l_nand3_1
X_4357_ _4360_/A _4372_/A _4372_/B _4355_/Y VDD VSS sg13cmos5l_o21ai_1
X_6027_ _6029_/A _7310_/Q _7294_/Q VDD VSS sg13cmos5l_xor2_1
X_7145_ _7145_/Q _7316_/CLK _7145_/D _7145_/RESET_B VDD VSS sg13cmos5l_dfrbpq_1
X_7076_ _7076_/Q _7103_/CLK _7076_/D _7076_/RESET_B VDD VSS sg13cmos5l_dfrbpq_1
Xfanout10 _5833_/B _4470_/Y VDD VSS sg13cmos5l_buf_1
Xfanout21 _7230_/D _3876_/Y VDD VSS sg13cmos5l_buf_1
X_6929_ _6931_/A _7018_/Q _7045_/Q _4257_/C VDD VSS sg13cmos5l_a21oi_1
Xfanout98 _6106_/S _6105_/S VDD VSS sg13cmos5l_buf_1
Xfanout87 _6168_/S _6170_/S VDD VSS sg13cmos5l_buf_1
Xfanout76 _6087_/S _6090_/S VDD VSS sg13cmos5l_buf_1
Xfanout65 _6612_/A _3765_/X VDD VSS sg13cmos5l_buf_1
Xfanout54 _5568_/A _5597_/A VDD VSS sg13cmos5l_buf_1
Xfanout43 _4863_/A _5549_/A VDD VSS sg13cmos5l_buf_1
Xfanout32 _6573_/A _6216_/B VDD VSS sg13cmos5l_buf_1
XFILLER_2_666 VDD VSS sg13cmos5l_fill_1
XFILLER_2_699 VDD VSS sg13cmos5l_fill_1
XFILLER_9_221 VDD VSS sg13cmos5l_fill_1
XFILLER_9_276 VDD VSS sg13cmos5l_fill_2
X_5260_ _5260_/X _5260_/A _5260_/B VDD VSS sg13cmos5l_xor2_1
Xclkload13 clkload13/Y _7104_/CLK VDD VSS sg13cmos5l_inv_8
X_4073_ _4645_/C _4680_/A _4073_/B VDD VSS sg13cmos5l_or2_1
X_4142_ _5001_/B _5812_/A _6745_/B VDD VSS sg13cmos5l_and2_1
X_4211_ _4392_/A _4212_/A _4212_/B VDD VSS sg13cmos5l_or2_1
X_5191_ _5193_/B _7068_/Q _5191_/B VDD VSS sg13cmos5l_xnor2_1
XFILLER_36_386 VDD VSS sg13cmos5l_fill_1
X_4975_ _4997_/B _4975_/A _4975_/B VDD VSS sg13cmos5l_xnor2_1
X_3788_ _3790_/C _3796_/A _3796_/B _3796_/C VDD VSS sg13cmos5l_o21ai_1
X_3857_ _3871_/B _3857_/A _3857_/B VDD VSS sg13cmos5l_or2_1
X_3926_ _3936_/A _3945_/A _3945_/B VDD VSS sg13cmos5l_nand2_1
Xclkload7 clkload7/Y clkload7/A VDD VSS sg13cmos5l_inv_2
X_7131__259 _7131_/RESET_B VDD VSS sg13cmos5l_tiehi
X_6714_ _6715_/B _6737_/B VDD VSS sg13cmos5l_inv_1
X_6645_ _6646_/B _6645_/A _6645_/B _6645_/C VDD VSS sg13cmos5l_nand3_1
X_6576_ _6578_/B _6576_/A _6576_/B VDD VSS sg13cmos5l_xnor2_1
X_4409_ _4409_/Y _4410_/A _4410_/B _4410_/C VDD VSS sg13cmos5l_nor3_1
X_5389_ _5415_/A _5492_/A _5390_/B VDD VSS sg13cmos5l_nand2_1
X_5458_ _5486_/A _5459_/A _5459_/B VDD VSS sg13cmos5l_nor2_1
X_5527_ _5530_/B _5560_/A _5527_/B VDD VSS sg13cmos5l_or2_1
X_7128_ _7128_/Q clkload6/A _7128_/D _7128_/RESET_B VDD VSS sg13cmos5l_dfrbpq_1
X_7059_ _7059_/Q _7104_/CLK _7059_/D _7059_/RESET_B VDD VSS sg13cmos5l_dfrbpq_1
XFILLER_15_504 VDD VSS sg13cmos5l_fill_2
XFILLER_11_787 VDD VSS sg13cmos5l_fill_1
X_7078__316 _7078_/RESET_B VDD VSS sg13cmos5l_tiehi
X_3642_ _3642_/Y _7105_/Q VDD VSS sg13cmos5l_inv_1
X_3711_ _3711_/Y _3824_/A _3781_/B _3824_/C VDD VSS sg13cmos5l_nor3_1
X_4691_ _4761_/A _4691_/A _4691_/B VDD VSS sg13cmos5l_xor2_1
X_4760_ _4780_/A _4690_/Y _4761_/D _4735_/Y VDD VSS sg13cmos5l_a21oi_1
X_7085__309 _7085_/RESET_B VDD VSS sg13cmos5l_tiehi
X_6430_ _6432_/C _6440_/A _6430_/B VDD VSS sg13cmos5l_xnor2_1
X_5243_ _5245_/B _7100_/Q _6474_/B VDD VSS sg13cmos5l_xnor2_1
X_5312_ _5313_/B _5338_/A _5429_/B VDD VSS sg13cmos5l_xnor2_1
X_6361_ _6361_/Y _6359_/Y _6360_/Y _6402_/A VDD VSS sg13cmos5l_o21ai_1
X_6292_ _6292_/Y _6292_/A _6292_/B VDD VSS sg13cmos5l_nor2_1
XFILLER_28_117 VDD VSS sg13cmos5l_fill_1
X_4056_ _4058_/C _4055_/B _4055_/C _4055_/A VDD VSS sg13cmos5l_o21ai_1
X_4125_ _4127_/B _4125_/A _4125_/B VDD VSS sg13cmos5l_xnor2_1
X_5174_ _5175_/B _5174_/A _5176_/C VDD VSS sg13cmos5l_nor2_1
X_4958_ _7088_/D _5072_/A _4958_/B _4990_/B VDD VSS sg13cmos5l_and3_1
X_3909_ _4133_/B _3909_/A _3908_/Y VDD VSS sg13cmos5l_nor2b_1
X_4889_ _4924_/A _4889_/A _4889_/B _4889_/C VDD VSS sg13cmos5l_or3_1
X_6628_ _6629_/A _6605_/Y _6628_/B VDD VSS sg13cmos5l_nand2b_1
X_6559_ _6560_/B _6520_/A _6520_/B _6558_/X VDD VSS sg13cmos5l_a21oi_1
XFILLER_3_238 VDD VSS sg13cmos5l_fill_2
XFILLER_34_698 VDD VSS sg13cmos5l_fill_1
X_4812_ _4816_/B _4812_/A _4812_/B VDD VSS sg13cmos5l_xor2_1
X_5792_ _5794_/B _5792_/A _5819_/A _5792_/C VDD VSS sg13cmos5l_nand3_1
X_5861_ _6123_/C _7247_/Q _7247_/D VDD VSS sg13cmos5l_nand2b_1
X_5930_ _5930_/Y _7150_/Q _5926_/A VDD VSS sg13cmos5l_nor2b_1
XFILLER_21_348 VDD VSS sg13cmos5l_fill_2
X_4674_ _7081_/D _4704_/B _4672_/X _4673_/Y VDD VSS sg13cmos5l_a21oi_1
X_4743_ _4743_/Y _4744_/B _4744_/A VDD VSS sg13cmos5l_nor2b_1
X_6413_ _6413_/Y _6422_/C _6412_/Y _6402_/A VDD VSS sg13cmos5l_o21ai_1
X_5226_ _5226_/Y _5226_/A _5226_/B VDD VSS sg13cmos5l_nor2_1
X_6275_ _6275_/Y _6294_/A _6272_/Y _6292_/A VDD VSS sg13cmos5l_o21ai_1
X_6344_ _6346_/C _6381_/A _6344_/B VDD VSS sg13cmos5l_xnor2_1
XFILLER_29_426 VDD VSS sg13cmos5l_fill_1
XFILLER_29_448 VDD VSS sg13cmos5l_decap_4
X_4039_ _4077_/A _4039_/A _4075_/A VDD VSS sg13cmos5l_nand2_1
X_4108_ _4111_/A _6633_/A _5812_/B VDD VSS sg13cmos5l_xnor2_1
X_5088_ _5089_/B _5042_/A _5042_/B _5040_/Y VDD VSS sg13cmos5l_a21oi_1
X_5157_ _5157_/Y _5158_/A _5158_/B VDD VSS sg13cmos5l_nand2b_1
XFILLER_28_470 VDD VSS sg13cmos5l_fill_1
X_7075__319 _7075_/RESET_B VDD VSS sg13cmos5l_tiehi
X_4390_ _4392_/C _7026_/Q _4390_/B VDD VSS sg13cmos5l_xor2_1
X_6060_ _6061_/B _7316_/Q _7300_/Q VDD VSS sg13cmos5l_xor2_1
XFILLER_23_2 VDD VSS sg13cmos5l_fill_1
X_5011_ _5012_/B _5011_/A _5011_/B VDD VSS sg13cmos5l_xnor2_1
X_6962_ _6964_/B _6961_/B _6962_/B VDD VSS sg13cmos5l_nand2b_1
X_5775_ _5778_/A _7094_/Q _5775_/B VDD VSS sg13cmos5l_xnor2_1
X_5844_ _5850_/A _7097_/Q _5837_/B _5835_/Y VDD VSS sg13cmos5l_a21oi_1
X_5913_ _5984_/B _7168_/Q _7150_/Q VDD VSS sg13cmos5l_xor2_1
X_6893_ _6896_/A _7015_/Q _6893_/B VDD VSS sg13cmos5l_xnor2_1
X_4588_ _4605_/B _7051_/Q _4589_/B VDD VSS sg13cmos5l_nand2_1
X_4657_ _4657_/Y _4659_/A _4676_/B _4657_/C VDD VSS sg13cmos5l_nand3_1
X_4726_ _4728_/C _4723_/Y _4726_/B _4726_/C VDD VSS sg13cmos5l_nand3b_1
X_6327_ _6327_/Y _6745_/A _6327_/B VDD VSS sg13cmos5l_xnor2_1
X_5209_ _5211_/B _5175_/Y _5206_/B _5206_/X _5081_/Y _5208_/Y VDD VSS sg13cmos5l_a221oi_1
X_6189_ _6191_/A _6189_/A _6189_/B VDD VSS sg13cmos5l_nor2_1
X_6258_ _6259_/B _6257_/A _6257_/B _6257_/C VDD VSS sg13cmos5l_a21o_1
XFILLER_25_473 VDD VSS sg13cmos5l_fill_2
Xclkbuf_leaf_10_sd_clk _7104_/CLK clkload2/A VDD VSS sg13cmos5l_buf_8
XFILLER_21_690 VDD VSS sg13cmos5l_fill_2
XFILLER_4_344 VDD VSS sg13cmos5l_fill_1
XFILLER_31_410 VDD VSS sg13cmos5l_fill_1
XFILLER_31_454 VDD VSS sg13cmos5l_fill_1
X_3890_ _3892_/B _7165_/Q _3890_/B VDD VSS sg13cmos5l_and2_1
XFILLER_8_650 VDD VSS sg13cmos5l_fill_1
X_4442_ _4445_/B _7034_/Q _4445_/A _4442_/C VDD VSS sg13cmos5l_nand3_1
X_4511_ _4512_/B _6905_/A _4521_/B VDD VSS sg13cmos5l_nor2_1
X_5491_ _5491_/X _5492_/A _5492_/B VDD VSS sg13cmos5l_and2_1
X_5560_ _5562_/B _5560_/A _5557_/X VDD VSS sg13cmos5l_nor2b_1
X_7230_ _7230_/Q _7244_/CLK _7230_/D _5528_/A VDD VSS sg13cmos5l_dfrbpq_1
XFILLER_39_510 VDD VSS sg13cmos5l_fill_2
XFILLER_39_543 VDD VSS sg13cmos5l_fill_1
X_4373_ _4377_/B _4374_/B _4374_/A VDD VSS sg13cmos5l_nand2b_1
X_6043_ _6043_/X _7312_/Q _7296_/Q _6038_/A VDD VSS sg13cmos5l_a21o_1
X_6112_ _7219_/D _7219_/Q _6023_/Y _6115_/S VDD VSS sg13cmos5l_mux2_1
X_7161_ _7161_/Q _7224_/CLK _7161_/D _6740_/A VDD VSS sg13cmos5l_dfrbpq_1
X_7092_ _7092_/Q clkload8/A _7092_/D _7092_/RESET_B VDD VSS sg13cmos5l_dfrbpq_1
XFILLER_35_760 VDD VSS sg13cmos5l_fill_1
XFILLER_39_554 VDD VSS sg13cmos5l_fill_2
X_6945_ _7052_/D _4275_/Y _4277_/B _6944_/Y VDD VSS sg13cmos5l_a21oi_1
X_4709_ _4710_/C _4753_/B _4709_/B VDD VSS sg13cmos5l_nand2b_1
X_5758_ _7120_/D _5755_/Y _5756_/Y _5757_/Y VDD VSS sg13cmos5l_a21oi_1
X_5827_ _5832_/A _5828_/A _5828_/B VDD VSS sg13cmos5l_nor2_1
X_6876_ _7040_/D _6897_/A _6873_/Y _6875_/Y VDD VSS sg13cmos5l_a21oi_1
X_5689_ _5690_/C _5688_/B _5688_/C _5688_/A VDD VSS sg13cmos5l_o21ai_1
X_7141__239 _7141_/RESET_B VDD VSS sg13cmos5l_tiehi
XFILLER_26_760 VDD VSS sg13cmos5l_fill_1
XFILLER_27_74 VDD VSS sg13cmos5l_fill_2
XFILLER_40_251 VDD VSS sg13cmos5l_fill_1
XFILLER_9_436 VDD VSS sg13cmos5l_fill_1
X_7228__439 _7228_/RESET_B VDD VSS sg13cmos5l_tiehi
X_7046__262 _7046_/RESET_B VDD VSS sg13cmos5l_tiehi
XFILLER_36_524 VDD VSS sg13cmos5l_fill_2
X_4991_ _4993_/B _4991_/A _4992_/A VDD VSS sg13cmos5l_nor2b_1
X_6730_ _6732_/B _7032_/Q _6730_/B VDD VSS sg13cmos5l_xnor2_1
X_3873_ _3874_/D _3873_/A _3873_/B _3873_/C VDD VSS sg13cmos5l_and3_1
X_3942_ _4769_/A _4801_/B _3942_/B VDD VSS sg13cmos5l_nor2_1
X_5543_ _5544_/A _5543_/A _5543_/B VDD VSS sg13cmos5l_xor2_1
X_5612_ _5614_/C _5612_/A _5612_/B _5612_/C VDD VSS sg13cmos5l_nand3_1
X_6661_ _6663_/B _6661_/A _6661_/B VDD VSS sg13cmos5l_xnor2_1
X_6592_ _6592_/Y _6592_/A _6592_/B VDD VSS sg13cmos5l_xnor2_1
X_4356_ _4372_/B _6216_/B _4356_/B VDD VSS sg13cmos5l_xnor2_1
X_4425_ _4427_/B _4426_/B _4426_/C _5106_/A VDD VSS sg13cmos5l_a21o_1
X_5474_ _5476_/B _5442_/A _5442_/B _5443_/Y VDD VSS sg13cmos5l_o21ai_1
X_7213_ _7213_/Q _7298_/CLK _7213_/D _7213_/RESET_B VDD VSS sg13cmos5l_dfrbpq_1
X_7144_ _7144_/Q _7316_/CLK _7144_/D _7144_/RESET_B VDD VSS sg13cmos5l_dfrbpq_1
X_4287_ _4289_/B _4288_/B _4288_/C _4288_/A VDD VSS sg13cmos5l_a21o_1
X_6026_ _6026_/Y _7310_/Q _7294_/Q VDD VSS sg13cmos5l_nor2_1
X_7075_ _7075_/Q _7103_/CLK _7075_/D _7075_/RESET_B VDD VSS sg13cmos5l_dfrbpq_1
XFILLER_14_207 VDD VSS sg13cmos5l_fill_2
XFILLER_14_229 VDD VSS sg13cmos5l_fill_1
XFILLER_27_557 VDD VSS sg13cmos5l_fill_1
Xfanout11 _4470_/A _4467_/Y VDD VSS sg13cmos5l_buf_1
Xfanout55 _5787_/B _6288_/A VDD VSS sg13cmos5l_buf_1
Xfanout44 _5492_/A _5516_/A VDD VSS sg13cmos5l_buf_1
Xfanout33 _6216_/B _4317_/A VDD VSS sg13cmos5l_buf_1
Xfanout22 _6428_/A _6772_/A VDD VSS sg13cmos5l_buf_1
X_6928_ _7045_/D _7018_/Q _7045_/Q _6927_/Y VDD VSS sg13cmos5l_a21oi_1
X_6859_ _7039_/D _6856_/Y _6857_/Y _6858_/Y VDD VSS sg13cmos5l_a21oi_1
XFILLER_22_295 VDD VSS sg13cmos5l_fill_1
Xfanout99 _6105_/S _6091_/Y VDD VSS sg13cmos5l_buf_1
Xfanout88 _6170_/S _7126_/D VDD VSS sg13cmos5l_buf_1
Xfanout77 _6090_/S _6075_/Y VDD VSS sg13cmos5l_buf_1
Xfanout66 _5671_/B _3765_/X VDD VSS sg13cmos5l_buf_1
XFILLER_2_623 VDD VSS sg13cmos5l_fill_1
XFILLER_38_62 VDD VSS sg13cmos5l_fill_1
X_7187__206 _7187_/RESET_B VDD VSS sg13cmos5l_tiehi
X_4210_ _4212_/B _4210_/A _4210_/B VDD VSS sg13cmos5l_xnor2_1
Xclkload14 clkload14/X _7103_/CLK VDD VSS sg13cmos5l_buf_8
X_4072_ _4073_/B _4072_/A _4072_/B VDD VSS sg13cmos5l_nor2_1
X_4141_ _4165_/B _4164_/A _4164_/B _4164_/C VDD VSS sg13cmos5l_o21ai_1
X_5190_ _5203_/B _7068_/Q _5191_/B VDD VSS sg13cmos5l_nand2_1
X_7094__300 _7094_/RESET_B VDD VSS sg13cmos5l_tiehi
XFILLER_36_365 VDD VSS sg13cmos5l_fill_2
X_3925_ _3945_/B _6226_/A _3924_/Y _4963_/S VDD VSS sg13cmos5l_o21ai_1
X_4974_ _4975_/B _4937_/A _4937_/B _4935_/Y VDD VSS sg13cmos5l_a21oi_1
X_6713_ _6737_/B _6712_/A _6712_/B _6712_/C VDD VSS sg13cmos5l_a21oi_1
XFILLER_32_593 VDD VSS sg13cmos5l_fill_2
X_3787_ _4046_/A _3697_/X _3698_/Y _3708_/D VDD VSS sg13cmos5l_a21oi_1
X_3856_ _3872_/B _3856_/A _3856_/B VDD VSS sg13cmos5l_nand2_1
X_5526_ _5527_/B _5454_/Y _5562_/A _5524_/X VDD VSS sg13cmos5l_a21oi_1
Xclkload8 clkload8/X clkload8/A VDD VSS sg13cmos5l_buf_8
X_6644_ _6653_/A _6645_/A _6645_/B _6645_/C VDD VSS sg13cmos5l_a21oi_1
X_6575_ _6606_/A _6576_/B _6576_/A VDD VSS sg13cmos5l_nand2b_1
X_4339_ _4339_/Y _4340_/A _4340_/B VDD VSS sg13cmos5l_nand2_1
X_4408_ _4410_/C _4186_/B _4186_/C _7063_/Q VDD VSS sg13cmos5l_a21oi_1
X_5388_ _5390_/B _5388_/A VDD VSS sg13cmos5l_inv_1
X_5457_ _5459_/B _5568_/A _5429_/B _5335_/A VDD VSS sg13cmos5l_a21oi_1
X_7127_ _7127_/Q _7318_/CLK _7127_/D _7127_/RESET_B VDD VSS sg13cmos5l_dfrbpq_1
XFILLER_27_321 VDD VSS sg13cmos5l_fill_2
X_6009_ _6011_/A _6010_/A _6010_/B _6010_/C VDD VSS sg13cmos5l_a21oi_1
X_7218__449 _7218_/RESET_B VDD VSS sg13cmos5l_tiehi
X_7058_ _7058_/Q _7104_/CLK _7058_/D _7058_/RESET_B VDD VSS sg13cmos5l_dfrbpq_1
XFILLER_24_31 VDD VSS sg13cmos5l_fill_1
XFILLER_27_398 VDD VSS sg13cmos5l_fill_1
XFILLER_10_287 VDD VSS sg13cmos5l_fill_2
XFILLER_40_74 VDD VSS sg13cmos5l_fill_2
XFILLER_2_486 VDD VSS sg13cmos5l_fill_2
XFILLER_1_79 VDD VSS sg13cmos5l_fill_1
X_3641_ _5339_/A _7106_/Q VDD VSS sg13cmos5l_inv_1
X_3710_ _3824_/C _7158_/Q _7156_/Q _7157_/Q VDD VSS sg13cmos5l_o21ai_1
X_4690_ _4690_/Y _4691_/A _4691_/B VDD VSS sg13cmos5l_nor2_1
X_6360_ _6360_/Y _6360_/A _6349_/B VDD VSS sg13cmos5l_nor2b_1
XFILLER_39_0 VDD VSS sg13cmos5l_fill_1
X_5173_ _5205_/A _5173_/A _5173_/B VDD VSS sg13cmos5l_xnor2_1
X_5242_ _5248_/A _5242_/A _5242_/B VDD VSS sg13cmos5l_and2_1
X_5311_ _5311_/Y _5338_/A _5429_/B VDD VSS sg13cmos5l_nand2_1
X_6291_ _6318_/A _6291_/A _6291_/B VDD VSS sg13cmos5l_xor2_1
XFILLER_29_608 VDD VSS sg13cmos5l_fill_2
X_4055_ _4619_/B _4055_/A _4055_/B _4055_/C VDD VSS sg13cmos5l_or3_1
X_4124_ _4404_/A _4299_/A _4121_/Y _4123_/Y _4421_/B VDD VSS sg13cmos5l_a22oi_1
Xinput1 input1/X i2s_bclk VDD VSS sg13cmos5l_buf_1
XFILLER_24_357 VDD VSS sg13cmos5l_fill_2
X_3908_ _3908_/Y _4125_/A _4125_/B _3907_/C VDD VSS sg13cmos5l_o21ai_1
X_4888_ _4889_/C _4926_/B _4887_/B _4887_/C _4887_/D VDD VSS sg13cmos5l_a22oi_1
X_4957_ _4990_/B _4957_/A _4957_/B VDD VSS sg13cmos5l_nand2_1
X_3839_ _3853_/A _3871_/A _3852_/B _3852_/C VDD VSS sg13cmos5l_a21oi_1
X_5509_ _5510_/A _5511_/A _5511_/B VDD VSS sg13cmos5l_and2_1
X_6627_ _6647_/B _6627_/A _6627_/B VDD VSS sg13cmos5l_nand2_1
X_6558_ _6558_/X _6514_/Y _6517_/B _6538_/A VDD VSS sg13cmos5l_a21o_1
X_6489_ _6489_/X _6489_/A _6489_/B VDD VSS sg13cmos5l_xor2_1
X_7177__216 _7177_/RESET_B VDD VSS sg13cmos5l_tiehi
XFILLER_28_641 VDD VSS sg13cmos5l_decap_8
X_7184__209 _7184_/RESET_B VDD VSS sg13cmos5l_tiehi
X_7084__310 _7084_/RESET_B VDD VSS sg13cmos5l_tiehi
XFILLER_19_630 VDD VSS sg13cmos5l_fill_2
XFILLER_19_641 VDD VSS sg13cmos5l_fill_2
XFILLER_38_405 VDD VSS sg13cmos5l_fill_2
Xclkbuf_2_0__f_sd_clk clkbuf_leaf_2_sd_clk/A clkbuf_0_sd_clk/X VDD VSS sg13cmos5l_buf_8
X_7091__303 _7091_/RESET_B VDD VSS sg13cmos5l_tiehi
XFILLER_14_390 VDD VSS sg13cmos5l_fill_2
XFILLER_33_132 VDD VSS sg13cmos5l_fill_1
X_4742_ _4744_/B _7083_/Q _4742_/B VDD VSS sg13cmos5l_xnor2_1
X_4811_ _4812_/B _4811_/A _4811_/B VDD VSS sg13cmos5l_xor2_1
X_5791_ _5811_/A _5792_/A _5819_/A _5792_/C VDD VSS sg13cmos5l_and3_1
X_5860_ _6123_/B _6784_/A _5860_/B _5865_/B VDD VSS sg13cmos5l_nand3_1
X_7316__392 _7316_/RESET_B VDD VSS sg13cmos5l_tiehi
X_4673_ _4673_/Y _4704_/B _4672_/X _5376_/A VDD VSS sg13cmos5l_o21ai_1
X_7243__328 _7243_/RESET_B VDD VSS sg13cmos5l_tiehi
X_6412_ _6412_/Y _6393_/Y _6412_/B VDD VSS sg13cmos5l_nand2b_1
X_6343_ _6355_/B _6381_/A _6344_/B VDD VSS sg13cmos5l_nand2_1
X_5156_ _5158_/B _5042_/A _5154_/Y _5155_/Y VDD VSS sg13cmos5l_o21ai_1
X_5225_ _7097_/D _5225_/A _5225_/B VDD VSS sg13cmos5l_nor2_1
X_6274_ _7001_/D _6294_/A _6272_/Y _6273_/Y VDD VSS sg13cmos5l_a21oi_1
XFILLER_25_622 VDD VSS sg13cmos5l_fill_1
XFILLER_25_633 VDD VSS sg13cmos5l_decap_4
XFILLER_25_655 VDD VSS sg13cmos5l_fill_1
X_4038_ _4075_/A _4071_/B _5534_/B VDD VSS sg13cmos5l_nand2b_1
X_4107_ _4119_/B _4107_/A _4107_/B VDD VSS sg13cmos5l_nand2_1
X_5087_ _5089_/A _5812_/B _5153_/C _5086_/Y VDD VSS sg13cmos5l_o21ai_1
XFILLER_20_393 VDD VSS sg13cmos5l_fill_1
XFILLER_25_699 VDD VSS sg13cmos5l_fill_1
X_5989_ _7168_/D _7168_/Q _6075_/C VDD VSS sg13cmos5l_xor2_1
XFILLER_15_187 VDD VSS sg13cmos5l_fill_2
XFILLER_16_677 VDD VSS sg13cmos5l_fill_1
XFILLER_7_397 VDD VSS sg13cmos5l_fill_2
X_5010_ _5010_/Y _5011_/A _5011_/B VDD VSS sg13cmos5l_nand2_1
X_5912_ _5984_/A _7167_/Q _5926_/A VDD VSS sg13cmos5l_xor2_1
X_7056__242 _7056_/RESET_B VDD VSS sg13cmos5l_tiehi
X_6961_ _6963_/B _6962_/B _6961_/B VDD VSS sg13cmos5l_nand2b_1
X_6892_ _6912_/B _7015_/Q _6893_/B VDD VSS sg13cmos5l_nand2_1
X_4725_ _4762_/A _4726_/C _4766_/B _4725_/C VDD VSS sg13cmos5l_nand3b_1
X_5774_ _5775_/B _5774_/A _5774_/B VDD VSS sg13cmos5l_xor2_1
X_5843_ _7124_/D _5841_/A _5841_/B _5842_/Y VDD VSS sg13cmos5l_a21oi_1
X_4587_ _4589_/B _4587_/A _4587_/B VDD VSS sg13cmos5l_xor2_1
X_4656_ _4659_/B _4676_/B _4657_/C VDD VSS sg13cmos5l_and2_1
X_6326_ _6346_/B _6392_/A _6327_/B VDD VSS sg13cmos5l_nand2_1
X_5139_ _5142_/B _7066_/Q _5139_/B _5139_/C VDD VSS sg13cmos5l_nand3_1
X_5208_ _5208_/Y _5193_/A _5193_/B _5207_/Y VDD VSS sg13cmos5l_o21ai_1
X_6188_ _6189_/B _6188_/A _6188_/B VDD VSS sg13cmos5l_xor2_1
X_6257_ _6257_/X _6257_/A _6257_/B _6257_/C VDD VSS sg13cmos5l_and3_1
X_7174__219 _7174_/RESET_B VDD VSS sg13cmos5l_tiehi
X_7074__320 _7074_/RESET_B VDD VSS sg13cmos5l_tiehi
XFILLER_40_455 VDD VSS sg13cmos5l_fill_1
X_7081__313 _7081_/RESET_B VDD VSS sg13cmos5l_tiehi
XFILLER_35_216 VDD VSS sg13cmos5l_fill_1
X_7313__395 _7313_/RESET_B VDD VSS sg13cmos5l_tiehi
X_4372_ _4374_/B _4372_/A _4372_/B VDD VSS sg13cmos5l_xnor2_1
X_4441_ _4450_/A _7034_/Q _4445_/A _4442_/C VDD VSS sg13cmos5l_and3_1
X_4510_ _4521_/B _4510_/A _4510_/B _4510_/C VDD VSS sg13cmos5l_nor3_1
X_5490_ _5492_/B _5513_/B _5490_/B VDD VSS sg13cmos5l_and2_1
X_6111_ _7218_/D _7218_/Q _6017_/Y _6115_/S VDD VSS sg13cmos5l_mux2_1
X_7160_ _7160_/Q _7224_/CLK _7160_/D _6740_/A VDD VSS sg13cmos5l_dfrbpq_1
XFILLER_39_522 VDD VSS sg13cmos5l_fill_1
X_6042_ _6045_/A _7313_/Q _7297_/Q VDD VSS sg13cmos5l_xor2_1
X_7091_ _7091_/Q _7243_/CLK _7091_/D _7091_/RESET_B VDD VSS sg13cmos5l_dfrbpq_1
XFILLER_34_271 VDD VSS sg13cmos5l_fill_1
X_6944_ _6944_/Y _4275_/Y _4277_/B _6947_/A VDD VSS sg13cmos5l_o21ai_1
X_6875_ _6875_/Y _6897_/A _6873_/Y _6436_/A VDD VSS sg13cmos5l_o21ai_1
X_4708_ _4710_/B _4709_/B _4753_/B VDD VSS sg13cmos5l_nand2b_1
X_5688_ _5690_/B _5688_/A _5688_/B _5688_/C VDD VSS sg13cmos5l_or3_1
X_5757_ _5757_/Y _5755_/Y _5756_/Y _5179_/A VDD VSS sg13cmos5l_o21ai_1
X_5826_ _5828_/B _5826_/A _5826_/B VDD VSS sg13cmos5l_and2_1
X_4639_ _7080_/D _6480_/A _4639_/B _4672_/B VDD VSS sg13cmos5l_nor3_1
X_7289_ _7289_/Q _7308_/CLK _7289_/D _7289_/RESET_B VDD VSS sg13cmos5l_dfrbpq_1
X_6309_ _6309_/Y _6307_/Y _6308_/Y _6299_/A VDD VSS sg13cmos5l_o21ai_1
XFILLER_24_709 VDD VSS sg13cmos5l_decap_4
XFILLER_32_720 VDD VSS sg13cmos5l_fill_1
X_3941_ _3942_/B _6592_/A _5330_/A _5330_/B VDD VSS sg13cmos5l_nor3_1
X_4990_ _4991_/A _5028_/A _4990_/B VDD VSS sg13cmos5l_nand2b_1
X_3872_ _3873_/C _3872_/A _3872_/B _3872_/C VDD VSS sg13cmos5l_nor3_1
X_5542_ _5566_/A _5543_/A _5543_/B VDD VSS sg13cmos5l_or2_1
X_5611_ _5613_/C _5684_/A _5612_/B _5612_/C VDD VSS sg13cmos5l_and3_1
X_6660_ _6661_/B _6637_/A _6637_/B _6634_/Y VDD VSS sg13cmos5l_a21oi_1
X_6591_ _6602_/A _7025_/Q _6574_/B _6572_/X VDD VSS sg13cmos5l_a21o_1
X_4355_ _4355_/Y _6216_/B _4356_/B VDD VSS sg13cmos5l_nand2_1
X_4424_ _4424_/Y _4426_/B _4426_/C _5106_/A VDD VSS sg13cmos5l_a21oi_1
X_5473_ _5476_/A _5473_/A _5473_/B VDD VSS sg13cmos5l_xnor2_1
X_7212_ _7212_/Q _7298_/CLK _7212_/D _7212_/RESET_B VDD VSS sg13cmos5l_dfrbpq_1
X_7143_ _7143_/Q _7316_/CLK _7143_/D _7143_/RESET_B VDD VSS sg13cmos5l_dfrbpq_1
X_7074_ _7074_/Q _7103_/CLK _7074_/D _7074_/RESET_B VDD VSS sg13cmos5l_dfrbpq_1
X_4286_ _4286_/Y _4288_/B _4288_/C _4288_/A VDD VSS sg13cmos5l_a21oi_1
X_6025_ _6025_/Y _7310_/Q _7294_/Q VDD VSS sg13cmos5l_nand2_1
XFILLER_22_230 VDD VSS sg13cmos5l_fill_1
X_5809_ _5810_/C _5809_/A _5803_/A VDD VSS sg13cmos5l_nor2b_1
Xfanout12 _6415_/B _6351_/B VDD VSS sg13cmos5l_buf_1
Xfanout89 _7126_/D _5862_/Y VDD VSS sg13cmos5l_buf_1
Xfanout78 _6062_/S _6074_/S VDD VSS sg13cmos5l_buf_1
Xfanout67 _6633_/A _5535_/A VDD VSS sg13cmos5l_buf_1
Xfanout56 _5153_/A _3742_/Y VDD VSS sg13cmos5l_buf_1
Xfanout45 _5516_/A _5338_/A VDD VSS sg13cmos5l_buf_1
Xfanout34 _5684_/A _5612_/A VDD VSS sg13cmos5l_buf_1
Xfanout23 _6772_/A _6789_/A VDD VSS sg13cmos5l_buf_1
X_6927_ _6927_/Y _7018_/Q _7045_/Q _6930_/A VDD VSS sg13cmos5l_o21ai_1
X_6858_ _6858_/Y _6856_/Y _6857_/Y _5212_/A VDD VSS sg13cmos5l_o21ai_1
X_7227__440 _7227_/RESET_B VDD VSS sg13cmos5l_tiehi
X_6789_ _6789_/Y _6789_/A _6789_/B _6789_/C VDD VSS sg13cmos5l_nand3_1
XFILLER_18_547 VDD VSS sg13cmos5l_fill_1
XFILLER_18_569 VDD VSS sg13cmos5l_fill_2
XFILLER_33_539 VDD VSS sg13cmos5l_fill_2
X_7310__398 _7310_/RESET_B VDD VSS sg13cmos5l_tiehi
X_4140_ _4164_/C _4140_/A _4140_/B VDD VSS sg13cmos5l_xor2_1
X_4071_ _4071_/Y _6592_/B _4071_/B VDD VSS sg13cmos5l_nand2_1
XFILLER_24_528 VDD VSS sg13cmos5l_fill_2
XFILLER_24_539 VDD VSS sg13cmos5l_fill_2
XFILLER_32_561 VDD VSS sg13cmos5l_fill_1
X_3924_ _3924_/Y _6675_/B _6656_/B VDD VSS sg13cmos5l_xnor2_1
X_4973_ _4975_/A _4973_/A _4973_/B VDD VSS sg13cmos5l_xnor2_1
X_6712_ _6761_/A _6712_/A _6712_/B _6712_/C VDD VSS sg13cmos5l_nand3_1
X_6643_ _6645_/C _6643_/A _6643_/B VDD VSS sg13cmos5l_xnor2_1
X_3786_ _5354_/A _5330_/A _5330_/B VDD VSS sg13cmos5l_nor2_1
X_3855_ _3856_/B _3855_/A _3855_/B _3855_/C VDD VSS sg13cmos5l_or3_1
X_5456_ _5459_/A _5596_/A _5456_/B VDD VSS sg13cmos5l_xnor2_1
X_5525_ _5562_/A _5525_/A _5525_/B VDD VSS sg13cmos5l_nor2_1
Xclkload9 clkload9/Y clkload9/A VDD VSS sg13cmos5l_inv_2
X_6574_ _6576_/B _7025_/Q _6574_/B VDD VSS sg13cmos5l_xnor2_1
X_4269_ _4269_/Y _4266_/B _6938_/C VDD VSS sg13cmos5l_nand2b_1
X_4338_ _4338_/Y _4340_/A _4340_/B VDD VSS sg13cmos5l_nor2_1
X_4407_ _4410_/B _7062_/Q _4429_/B _4405_/Y VDD VSS sg13cmos5l_a21oi_1
X_5387_ _5388_/A _5387_/A _5387_/B VDD VSS sg13cmos5l_xnor2_1
X_7126_ _7126_/Q clkload4/A _7126_/D _7126_/RESET_B VDD VSS sg13cmos5l_dfrbpq_1
X_7057_ _7057_/Q _7104_/CLK _7057_/D _7057_/RESET_B VDD VSS sg13cmos5l_dfrbpq_1
XFILLER_15_506 VDD VSS sg13cmos5l_fill_1
XFILLER_39_160 VDD VSS sg13cmos5l_fill_1
X_6008_ _6010_/C _7307_/Q _7291_/Q VDD VSS sg13cmos5l_xnor2_1
XFILLER_37_108 VDD VSS sg13cmos5l_fill_2
X_7193__200 _7193_/RESET_B VDD VSS sg13cmos5l_tiehi
XFILLER_21_509 VDD VSS sg13cmos5l_fill_2
X_3640_ _3640_/Y _7100_/Q VDD VSS sg13cmos5l_inv_1
X_5310_ _5429_/B _5310_/A _5310_/B VDD VSS sg13cmos5l_xnor2_1
X_7130__261 _7130_/RESET_B VDD VSS sg13cmos5l_tiehi
X_6290_ _6308_/A _6291_/A _6291_/B VDD VSS sg13cmos5l_nand2b_1
X_4123_ _4123_/Y _4421_/A _4297_/B VDD VSS sg13cmos5l_nand2_1
X_5172_ _5207_/A _5173_/A _5173_/B VDD VSS sg13cmos5l_nor2_1
X_5241_ _7099_/D _5241_/A _5242_/B VDD VSS sg13cmos5l_nor2b_1
XFILLER_24_314 VDD VSS sg13cmos5l_fill_2
X_4054_ _4055_/C _4052_/A _4052_/B _4681_/B VDD VSS sg13cmos5l_a21oi_1
Xinput2 input2/X i2s_lrck VDD VSS sg13cmos5l_buf_1
X_7217__450 _7217_/RESET_B VDD VSS sg13cmos5l_tiehi
X_3838_ _3852_/C _7122_/Q _5788_/A VDD VSS sg13cmos5l_xnor2_1
X_3907_ _3909_/A _4125_/A _4125_/B _3907_/C VDD VSS sg13cmos5l_nor3_1
X_4887_ _4889_/B _5787_/C _4887_/B _4887_/C _4887_/D VDD VSS sg13cmos5l_and4_1
X_4956_ _4958_/B _4957_/A _5030_/A VDD VSS sg13cmos5l_nand2b_1
X_6626_ _6627_/B _6624_/A _6624_/B _6624_/C VDD VSS sg13cmos5l_a21o_1
X_3769_ _5352_/A _3770_/A _3769_/B VDD VSS sg13cmos5l_xnor2_1
X_5439_ _5439_/X _5492_/A _5440_/B VDD VSS sg13cmos5l_and2_1
X_5508_ _5511_/B _5508_/A _5508_/B VDD VSS sg13cmos5l_xnor2_1
X_7224__443 _7224_/RESET_B VDD VSS sg13cmos5l_tiehi
X_6557_ _6562_/A _6583_/A _6588_/A VDD VSS sg13cmos5l_or2_1
X_6488_ _6488_/Y _6489_/A _6489_/B VDD VSS sg13cmos5l_nor2_1
X_7109_ _7109_/Q _7244_/CLK _7109_/D _7109_/RESET_B VDD VSS sg13cmos5l_dfrbpq_1
XFILLER_7_557 VDD VSS sg13cmos5l_fill_1
X_4672_ _4672_/X _4705_/A _4672_/B VDD VSS sg13cmos5l_or2_1
X_4741_ _4742_/B _4863_/A _4741_/B VDD VSS sg13cmos5l_xnor2_1
X_4810_ _4810_/Y _4811_/A _4811_/B VDD VSS sg13cmos5l_nand2b_1
X_5790_ _5792_/C _5790_/A _5790_/B _5790_/C VDD VSS sg13cmos5l_or3_1
X_6273_ _6273_/Y _6294_/A _6272_/Y _6672_/B1 VDD VSS sg13cmos5l_o21ai_1
X_6411_ _6422_/C _6411_/A _6411_/B VDD VSS sg13cmos5l_nor2_1
X_6342_ _6344_/B _7007_/Q _6789_/A VDD VSS sg13cmos5l_xnor2_1
X_4106_ _4423_/A _4122_/B _4105_/Y VDD VSS sg13cmos5l_nor2b_1
X_5086_ _5086_/Y _5153_/A _5153_/C VDD VSS sg13cmos5l_nand2_1
X_5155_ _5155_/Y _4155_/A _5042_/A _5154_/Y VDD VSS sg13cmos5l_o21ai_1
X_5224_ _5225_/B _5224_/A _5224_/B VDD VSS sg13cmos5l_nand2_1
XFILLER_24_144 VDD VSS sg13cmos5l_fill_1
XFILLER_40_626 VDD VSS sg13cmos5l_fill_2
X_4037_ _4071_/B _4680_/A _4036_/Y _4039_/A VDD VSS sg13cmos5l_o21ai_1
X_5988_ _6107_/B _7168_/Q _6075_/C VDD VSS sg13cmos5l_nand2_1
XFILLER_21_55 VDD VSS sg13cmos5l_fill_1
X_4939_ _4940_/A _4941_/A _4941_/B VDD VSS sg13cmos5l_nand2b_1
X_7183__210 _7183_/RESET_B VDD VSS sg13cmos5l_tiehi
X_6609_ _6628_/B _6647_/A _6691_/A _6691_/B VDD VSS sg13cmos5l_nand3b_1
X_7190__203 _7190_/RESET_B VDD VSS sg13cmos5l_tiehi
XFILLER_30_136 VDD VSS sg13cmos5l_fill_2
XFILLER_31_648 VDD VSS sg13cmos5l_fill_2
XFILLER_11_383 VDD VSS sg13cmos5l_fill_2
XFILLER_38_225 VDD VSS sg13cmos5l_fill_1
XFILLER_19_494 VDD VSS sg13cmos5l_fill_1
XFILLER_22_615 VDD VSS sg13cmos5l_fill_2
XFILLER_26_409 VDD VSS sg13cmos5l_fill_1
XFILLER_38_258 VDD VSS sg13cmos5l_fill_2
X_5842_ _5842_/Y _6985_/A _5852_/B VDD VSS sg13cmos5l_nand2_1
X_5911_ _7148_/D _6990_/A _5911_/B VDD VSS sg13cmos5l_nor2_1
X_7214__453 _7214_/RESET_B VDD VSS sg13cmos5l_tiehi
X_6960_ _6962_/B _6952_/A _4396_/D _4399_/C VDD VSS sg13cmos5l_o21ai_1
X_6891_ _6893_/B _6891_/A _6891_/B VDD VSS sg13cmos5l_xor2_1
X_4655_ _4657_/C _4676_/A _4654_/C _4654_/A VDD VSS sg13cmos5l_a21o_1
X_4724_ _4726_/B _4724_/A _4724_/B _4724_/C VDD VSS sg13cmos5l_nand3_1
X_5773_ _5773_/Y _5774_/A _5774_/B VDD VSS sg13cmos5l_nor2_1
X_4586_ _4605_/A _4587_/A _4587_/B VDD VSS sg13cmos5l_or2_1
X_6256_ _6257_/C _6612_/A _6256_/B VDD VSS sg13cmos5l_xnor2_1
X_7221__446 _7221_/RESET_B VDD VSS sg13cmos5l_tiehi
X_6325_ _6327_/B _7006_/Q _6789_/A VDD VSS sg13cmos5l_xnor2_1
X_5069_ _5076_/C _5074_/C _5074_/D VDD VSS sg13cmos5l_and2_1
X_5138_ _5139_/C _5137_/B _5137_/C _5137_/A VDD VSS sg13cmos5l_o21ai_1
X_5207_ _5207_/Y _5207_/A _5207_/B VDD VSS sg13cmos5l_nand2_1
X_6187_ _6187_/X _6188_/A _6188_/B VDD VSS sg13cmos5l_and2_1
XFILLER_25_497 VDD VSS sg13cmos5l_fill_2
XFILLER_40_434 VDD VSS sg13cmos5l_fill_1
XFILLER_21_681 VDD VSS sg13cmos5l_fill_1
XFILLER_21_692 VDD VSS sg13cmos5l_fill_1
XFILLER_35_239 VDD VSS sg13cmos5l_fill_2
X_4371_ _4374_/A _4381_/A _4381_/B _4369_/Y VDD VSS sg13cmos5l_o21ai_1
X_4440_ _4442_/C _4439_/A _4439_/C _4439_/B VDD VSS sg13cmos5l_a21o_1
X_6110_ _7217_/D _7217_/Q _6011_/Y _6115_/S VDD VSS sg13cmos5l_mux2_1
X_7090_ _7090_/Q _7243_/CLK _7090_/D _7090_/RESET_B VDD VSS sg13cmos5l_dfrbpq_1
XFILLER_14_0 VDD VSS sg13cmos5l_fill_2
XFILLER_39_512 VDD VSS sg13cmos5l_fill_1
XFILLER_39_556 VDD VSS sg13cmos5l_fill_1
X_6041_ _6041_/Y _7313_/Q _7297_/Q VDD VSS sg13cmos5l_nor2_1
X_7173__220 _7173_/RESET_B VDD VSS sg13cmos5l_tiehi
X_5825_ _5828_/A _7096_/Q _5825_/B VDD VSS sg13cmos5l_xnor2_1
X_6943_ _7051_/D _4272_/Y _4274_/Y _6942_/Y VDD VSS sg13cmos5l_a21oi_1
X_6874_ _6874_/Y _6871_/A _6898_/A _6899_/A VDD VSS sg13cmos5l_o21ai_1
X_4638_ _4672_/B _4638_/A _4753_/A VDD VSS sg13cmos5l_nor2_1
X_4707_ _4709_/B _4753_/A _4753_/C _4706_/Y VDD VSS sg13cmos5l_o21ai_1
X_5687_ _5687_/Y _5688_/A _5688_/B _5688_/C VDD VSS sg13cmos5l_nor3_1
X_5756_ _5756_/Y _5756_/A _5756_/B VDD VSS sg13cmos5l_nor2_1
X_7180__213 _7180_/RESET_B VDD VSS sg13cmos5l_tiehi
X_4569_ _4569_/Y _4567_/A _4569_/B VDD VSS sg13cmos5l_nand2b_1
X_6239_ _6240_/C _6239_/A _6239_/B VDD VSS sg13cmos5l_xnor2_1
X_7288_ _7288_/Q _7305_/CLK _7288_/D _7288_/RESET_B VDD VSS sg13cmos5l_dfrbpq_1
X_6308_ _6308_/Y _6308_/A _6308_/B VDD VSS sg13cmos5l_nand2_1
XFILLER_26_751 VDD VSS sg13cmos5l_fill_2
XFILLER_27_32 VDD VSS sg13cmos5l_fill_2
XFILLER_41_787 VDD VSS sg13cmos5l_fill_1
XFILLER_4_165 VDD VSS sg13cmos5l_fill_2
XFILLER_36_526 VDD VSS sg13cmos5l_fill_1
X_3871_ _3872_/C _3871_/A _3871_/B _3871_/C _3871_/D VDD VSS sg13cmos5l_nand4_1
X_3940_ _4929_/B _5330_/A _5330_/B _6592_/A VDD VSS sg13cmos5l_o21ai_1
XFILLER_31_275 VDD VSS sg13cmos5l_fill_2
X_5472_ _5497_/B _5473_/A _5473_/B VDD VSS sg13cmos5l_or2_1
X_5541_ _5541_/Y _5543_/A _5543_/B VDD VSS sg13cmos5l_nor2_1
X_5610_ _5614_/B _5612_/B _5612_/C _5612_/A VDD VSS sg13cmos5l_a21o_1
X_7211_ _7211_/Q _7298_/CLK _7211_/D _7211_/RESET_B VDD VSS sg13cmos5l_dfrbpq_1
X_6590_ _6590_/X _6691_/A _6691_/B VDD VSS sg13cmos5l_and2_1
X_4285_ _4288_/C _4285_/A _4285_/B _4285_/C VDD VSS sg13cmos5l_or3_1
X_4354_ _4356_/B _4354_/A _4354_/B VDD VSS sg13cmos5l_xnor2_1
X_4423_ _4426_/C _4423_/A _4423_/B _4423_/C VDD VSS sg13cmos5l_or3_1
X_6024_ _7174_/D _7174_/Q _6023_/Y _6074_/S VDD VSS sg13cmos5l_mux2_1
X_7142_ _7142_/Q clkload3/A _7142_/D _7142_/RESET_B VDD VSS sg13cmos5l_dfrbpq_1
X_7140__241 _7140_/RESET_B VDD VSS sg13cmos5l_tiehi
X_7073_ _7073_/Q _7270_/CLK _7073_/D _7073_/RESET_B VDD VSS sg13cmos5l_dfrbpq_1
XFILLER_14_209 VDD VSS sg13cmos5l_fill_1
X_6926_ _7044_/D _6919_/Y _6924_/Y _6925_/Y VDD VSS sg13cmos5l_a21oi_1
XFILLER_22_275 VDD VSS sg13cmos5l_fill_1
XFILLER_23_754 VDD VSS sg13cmos5l_fill_2
X_5739_ _5760_/B _5739_/A _5739_/B VDD VSS sg13cmos5l_xnor2_1
X_5808_ _5810_/B _5808_/A _5808_/B _5810_/A _5809_/A VDD VSS sg13cmos5l_nor4_1
Xfanout13 _6351_/B _7230_/D VDD VSS sg13cmos5l_buf_1
Xfanout79 _6074_/S _5992_/Y VDD VSS sg13cmos5l_buf_1
Xfanout68 _6700_/B _5734_/S VDD VSS sg13cmos5l_buf_1
Xfanout57 _6700_/A _3742_/Y VDD VSS sg13cmos5l_buf_1
Xfanout46 _5338_/A _5549_/A VDD VSS sg13cmos5l_buf_1
Xfanout35 _5612_/A _5018_/A VDD VSS sg13cmos5l_buf_1
Xfanout24 _6789_/A _6729_/A VDD VSS sg13cmos5l_buf_1
X_6857_ _6857_/Y _6857_/A _6857_/B VDD VSS sg13cmos5l_nor2_1
X_6788_ _6791_/A _6789_/A _6789_/B _6789_/C VDD VSS sg13cmos5l_and3_1
XFILLER_2_658 VDD VSS sg13cmos5l_fill_1
X_4070_ _4625_/A _4201_/A _4069_/B _4063_/Y VDD VSS sg13cmos5l_a21o_1
X_3854_ _3872_/A _3854_/A _3854_/B _3854_/C VDD VSS sg13cmos5l_nor3_1
X_3923_ _4806_/A _6612_/A _6656_/B VDD VSS sg13cmos5l_xnor2_1
X_4972_ _4973_/B _4972_/A _4972_/B VDD VSS sg13cmos5l_xnor2_1
X_7170__223 _7170_/RESET_B VDD VSS sg13cmos5l_tiehi
X_6711_ _6712_/C _6711_/A _6711_/B VDD VSS sg13cmos5l_xnor2_1
X_6642_ _6643_/B _6642_/A _6642_/B VDD VSS sg13cmos5l_xor2_1
X_3785_ _5595_/B _6565_/A _6565_/B VDD VSS sg13cmos5l_nand2_1
X_4406_ _4429_/B _5820_/A _4406_/B VDD VSS sg13cmos5l_xnor2_1
X_5455_ _5471_/A _7110_/Q _5441_/B _5439_/X VDD VSS sg13cmos5l_a21o_1
X_5524_ _5524_/X _5501_/A _5500_/A _5499_/A VDD VSS sg13cmos5l_a21o_1
X_6573_ _6574_/B _6573_/A _6573_/B VDD VSS sg13cmos5l_xor2_1
X_4268_ _6938_/C _4270_/A _4271_/A VDD VSS sg13cmos5l_and2_1
X_4337_ _4340_/B _7031_/Q _4337_/B VDD VSS sg13cmos5l_xnor2_1
X_5386_ _5387_/B _5356_/S _5353_/Y _5357_/B _5357_/A VDD VSS sg13cmos5l_a22oi_1
X_6007_ _7171_/D _7171_/Q _6006_/X _6062_/S VDD VSS sg13cmos5l_mux2_1
X_7125_ _7125_/Q clkload8/A _7125_/D _7125_/RESET_B VDD VSS sg13cmos5l_dfrbpq_1
X_7056_ _7056_/Q _7104_/CLK _7056_/D _7056_/RESET_B VDD VSS sg13cmos5l_dfrbpq_1
XFILLER_27_389 VDD VSS sg13cmos5l_fill_2
X_4199_ _4200_/B _7050_/Q _4585_/B VDD VSS sg13cmos5l_nand2_1
X_6909_ _6910_/B _6909_/A _6909_/B VDD VSS sg13cmos5l_xor2_1
XFILLER_24_55 VDD VSS sg13cmos5l_fill_1
XFILLER_6_249 VDD VSS sg13cmos5l_fill_2
XFILLER_18_367 VDD VSS sg13cmos5l_fill_2
Xclkbuf_leaf_16_sd_clk _7220_/CLK clkload1/A VDD VSS sg13cmos5l_buf_8
XFILLER_14_595 VDD VSS sg13cmos5l_fill_1
X_5240_ _5241_/A _7072_/Q _5239_/B _6932_/B1 VDD VSS sg13cmos5l_o21ai_1
X_4053_ _4055_/B _4053_/A _4053_/B _4053_/C VDD VSS sg13cmos5l_nor3_1
X_4122_ _4297_/B _4105_/Y _4122_/B VDD VSS sg13cmos5l_nand2b_1
X_5171_ _5173_/B _7066_/Q _5139_/C _5136_/Y VDD VSS sg13cmos5l_a21oi_1
XFILLER_24_359 VDD VSS sg13cmos5l_fill_1
XFILLER_37_676 VDD VSS sg13cmos5l_fill_2
X_4955_ _4957_/B _5030_/A VDD VSS sg13cmos5l_inv_1
Xinput3 input3/X i2s_sdata VDD VSS sg13cmos5l_buf_1
X_3768_ _3834_/A _3768_/A _3768_/B _3768_/C VDD VSS sg13cmos5l_or3_1
X_3837_ _3852_/B _7121_/Q _6675_/A _3854_/C _3836_/Y VDD VSS sg13cmos5l_a22oi_1
X_3906_ _3907_/C _3906_/A _3906_/B VDD VSS sg13cmos5l_xnor2_1
X_4886_ _4887_/D _4801_/B _3942_/B _4724_/A VDD VSS sg13cmos5l_o21ai_1
X_6625_ _6625_/Y _6624_/A _6624_/B _6624_/C VDD VSS sg13cmos5l_a21oi_1
X_6556_ _6588_/A _6556_/A _6556_/B _6556_/C VDD VSS sg13cmos5l_and3_1
X_3699_ _3796_/B _3699_/A _3699_/B VDD VSS sg13cmos5l_nand2_1
X_5369_ _5374_/A _5347_/A _5344_/Y _5345_/Y VDD VSS sg13cmos5l_a21oi_1
X_5438_ _5440_/B _5438_/A _5438_/B VDD VSS sg13cmos5l_xnor2_1
X_5507_ _5543_/A _5508_/B _5508_/A VDD VSS sg13cmos5l_nand2b_1
X_6487_ _6489_/B _6992_/Q _6477_/B _6475_/Y VDD VSS sg13cmos5l_a21oi_1
XFILLER_19_33 VDD VSS sg13cmos5l_fill_1
XFILLER_27_153 VDD VSS sg13cmos5l_fill_1
X_7108_ _7108_/Q _7244_/CLK _7108_/D _7108_/RESET_B VDD VSS sg13cmos5l_dfrbpq_1
X_7039_ _7039_/Q clkload6/A _7039_/D _7039_/RESET_B VDD VSS sg13cmos5l_dfrbpq_1
XFILLER_35_65 VDD VSS sg13cmos5l_fill_2
Xclkbuf_leaf_3_sd_clk _7298_/CLK clkload0/A VDD VSS sg13cmos5l_buf_8
XFILLER_19_610 VDD VSS sg13cmos5l_fill_2
XFILLER_19_632 VDD VSS sg13cmos5l_fill_1
XFILLER_33_101 VDD VSS sg13cmos5l_fill_1
XFILLER_34_635 VDD VSS sg13cmos5l_fill_1
X_4671_ _4704_/B _4671_/A _4705_/B VDD VSS sg13cmos5l_nor2_1
X_4740_ _4740_/Y _5652_/A _4741_/B VDD VSS sg13cmos5l_nor2_1
X_6410_ _6411_/B _6409_/A _6409_/B _6409_/C VDD VSS sg13cmos5l_a21oi_1
XFILLER_6_580 VDD VSS sg13cmos5l_fill_2
X_5223_ _5224_/B _5226_/A _5222_/B _5222_/C VDD VSS sg13cmos5l_o21ai_1
X_6272_ _6272_/Y _6252_/B _6335_/A _6336_/A VDD VSS sg13cmos5l_a21oi_1
X_6341_ _6355_/A _7007_/Q _6351_/B VDD VSS sg13cmos5l_nand2_1
XFILLER_29_407 VDD VSS sg13cmos5l_fill_1
X_4036_ _4036_/Y _4053_/C _4055_/A _4026_/A VDD VSS sg13cmos5l_a21oi_1
X_4105_ _4105_/Y _6720_/A _4105_/B VDD VSS sg13cmos5l_xnor2_1
X_5085_ _5085_/Y _5818_/C _5671_/A VDD VSS sg13cmos5l_nand2_1
X_5154_ _5154_/Y _5154_/A _5154_/B VDD VSS sg13cmos5l_nand2_1
XFILLER_37_484 VDD VSS sg13cmos5l_fill_1
X_4938_ _4941_/B _4938_/A _4938_/B VDD VSS sg13cmos5l_nand2_1
X_5987_ _7167_/D _6091_/A _6091_/D VDD VSS sg13cmos5l_xnor2_1
X_4869_ _4871_/B _7058_/Q _4824_/B _4822_/Y VDD VSS sg13cmos5l_a21oi_1
X_6608_ _6610_/B _6590_/X _6647_/A VDD VSS sg13cmos5l_nand2b_1
X_6539_ _6539_/Y _6517_/A _6516_/Y _6521_/C VDD VSS sg13cmos5l_o21ai_1
XFILLER_28_495 VDD VSS sg13cmos5l_fill_2
XFILLER_7_322 VDD VSS sg13cmos5l_fill_1
XFILLER_7_366 VDD VSS sg13cmos5l_fill_1
X_5772_ _5774_/B _7121_/Q _5772_/B VDD VSS sg13cmos5l_xnor2_1
X_5841_ _5852_/B _5841_/A _5841_/B VDD VSS sg13cmos5l_or2_1
X_5910_ _5911_/B _7148_/Q _5881_/C _5910_/B1 _7147_/Q VDD VSS sg13cmos5l_a22oi_1
X_6890_ _6912_/A _6891_/A _6891_/B VDD VSS sg13cmos5l_or2_1
X_4585_ _4587_/B _7078_/Q _4585_/B VDD VSS sg13cmos5l_xnor2_1
X_4654_ _4676_/B _4654_/A _4676_/A _4654_/C VDD VSS sg13cmos5l_nand3_1
X_4723_ _4723_/Y _4724_/A _4724_/B _4724_/C VDD VSS sg13cmos5l_a21oi_1
X_5206_ _5206_/X _5206_/A _5206_/B VDD VSS sg13cmos5l_and2_1
X_6186_ _6188_/B _4235_/A _6177_/B _6175_/Y VDD VSS sg13cmos5l_o21ai_1
X_6255_ _6256_/B _7000_/Q _6277_/B VDD VSS sg13cmos5l_xnor2_1
X_6324_ _6346_/A _7006_/Q _6351_/B VDD VSS sg13cmos5l_nand2_1
XFILLER_38_760 VDD VSS sg13cmos5l_fill_1
X_4019_ _4681_/B _5354_/B _5308_/A VDD VSS sg13cmos5l_nor2_1
X_5068_ _5074_/D _5111_/B _5067_/C _5067_/A VDD VSS sg13cmos5l_a21o_1
X_5137_ _5139_/B _5137_/A _5137_/B _5137_/C VDD VSS sg13cmos5l_or3_1
XFILLER_25_465 VDD VSS sg13cmos5l_fill_1
XFILLER_40_402 VDD VSS sg13cmos5l_fill_2
XFILLER_9_609 VDD VSS sg13cmos5l_fill_2
XFILLER_32_66 VDD VSS sg13cmos5l_fill_2
XFILLER_16_465 VDD VSS sg13cmos5l_fill_2
X_4370_ _4381_/B _4370_/A _4370_/B VDD VSS sg13cmos5l_xnor2_1
X_6040_ _6040_/Y _7313_/Q _7297_/Q VDD VSS sg13cmos5l_nand2_1
X_7127__267 _7127_/RESET_B VDD VSS sg13cmos5l_tiehi
X_6942_ _6942_/Y _4272_/Y _4274_/Y _6947_/A VDD VSS sg13cmos5l_o21ai_1
X_5755_ _5755_/Y _5780_/C _5755_/B VDD VSS sg13cmos5l_nand2_1
X_5824_ _5825_/B _5824_/A _5824_/B VDD VSS sg13cmos5l_xor2_1
X_6873_ _6873_/Y _6873_/A _6899_/A VDD VSS sg13cmos5l_nor2b_1
X_4568_ _4569_/B _4568_/A _4568_/B _4568_/C VDD VSS sg13cmos5l_nand3_1
X_4637_ _4639_/B _4638_/A _4753_/A VDD VSS sg13cmos5l_and2_1
X_4706_ _4706_/Y _4754_/A _4754_/B VDD VSS sg13cmos5l_nand2_1
X_5686_ _5688_/C _5685_/B _5685_/C _7118_/Q VDD VSS sg13cmos5l_a21oi_1
X_4499_ _4501_/B _4499_/A _4499_/B VDD VSS sg13cmos5l_xor2_1
X_6169_ _7316_/D _7316_/Q _7284_/Q _6170_/S VDD VSS sg13cmos5l_mux2_1
X_6238_ _6251_/A _6239_/A _6239_/B VDD VSS sg13cmos5l_nand2_1
X_7287_ _7287_/Q clkload3/A _7287_/D _7287_/RESET_B VDD VSS sg13cmos5l_dfrbpq_1
X_6307_ _6307_/Y _6318_/B VDD VSS sg13cmos5l_inv_1
XFILLER_40_210 VDD VSS sg13cmos5l_fill_1
X_7308__400 _7308_/RESET_B VDD VSS sg13cmos5l_tiehi
XFILLER_31_243 VDD VSS sg13cmos5l_fill_2
XFILLER_32_711 VDD VSS sg13cmos5l_fill_1
X_3870_ _3871_/D _3870_/A _3869_/X VDD VSS sg13cmos5l_nor2b_1
XFILLER_8_461 VDD VSS sg13cmos5l_fill_2
X_4422_ _4426_/B _4423_/A _4423_/B _4423_/C VDD VSS sg13cmos5l_o21ai_1
X_5471_ _5473_/B _5471_/A _5471_/B VDD VSS sg13cmos5l_xor2_1
X_5540_ _5543_/B _5540_/A _5540_/B VDD VSS sg13cmos5l_xor2_1
X_7210_ _7210_/Q _7298_/CLK _7210_/D _7210_/RESET_B VDD VSS sg13cmos5l_dfrbpq_1
X_4284_ _4288_/B _4285_/B _4285_/C _4285_/A VDD VSS sg13cmos5l_o21ai_1
X_4353_ _4399_/B _6965_/B _6961_/B VDD VSS sg13cmos5l_or2_1
X_6023_ _6023_/Y _6023_/A _6023_/B VDD VSS sg13cmos5l_xnor2_1
X_7141_ _7141_/Q clkload3/A _7141_/D _7141_/RESET_B VDD VSS sg13cmos5l_dfrbpq_1
X_7072_ _7072_/Q _7270_/CLK _7072_/D _7072_/RESET_B VDD VSS sg13cmos5l_dfrbpq_1
X_6925_ _6925_/Y _6919_/Y _6924_/Y _6925_/B1 VDD VSS sg13cmos5l_o21ai_1
X_3999_ _4015_/B _3999_/A _3999_/B VDD VSS sg13cmos5l_xnor2_1
X_5738_ _5739_/B _5738_/A _5738_/B VDD VSS sg13cmos5l_xor2_1
X_5807_ _5829_/A _5729_/A _5729_/B _5806_/Y VDD VSS sg13cmos5l_o21ai_1
Xfanout14 _5820_/A _7230_/D VDD VSS sg13cmos5l_buf_1
Xfanout69 _5734_/S _5534_/A VDD VSS sg13cmos5l_buf_1
Xfanout58 _5788_/A _6303_/A VDD VSS sg13cmos5l_buf_1
Xfanout47 _5549_/A fanout48/X VDD VSS sg13cmos5l_buf_1
Xfanout36 _5018_/A _4317_/A VDD VSS sg13cmos5l_buf_1
Xfanout25 _6707_/A _6729_/A VDD VSS sg13cmos5l_buf_1
X_6856_ _6856_/Y _6870_/B VDD VSS sg13cmos5l_inv_1
X_6787_ _6789_/C _5153_/A _5001_/B _3892_/B VDD VSS sg13cmos5l_a21oi_1
X_5669_ _5715_/A _7166_/Q _5637_/B _5635_/Y VDD VSS sg13cmos5l_a21oi_1
XFILLER_38_98 VDD VSS sg13cmos5l_fill_2
XFILLER_14_700 VDD VSS sg13cmos5l_fill_1
XFILLER_14_744 VDD VSS sg13cmos5l_fill_2
XFILLER_33_508 VDD VSS sg13cmos5l_fill_2
XFILLER_41_552 VDD VSS sg13cmos5l_decap_8
X_7117__277 _7117_/RESET_B VDD VSS sg13cmos5l_tiehi
XFILLER_13_298 VDD VSS sg13cmos5l_fill_2
XFILLER_24_508 VDD VSS sg13cmos5l_fill_2
X_4971_ _4971_/Y _4972_/A _4972_/B VDD VSS sg13cmos5l_nor2b_1
X_3784_ _6565_/B _3781_/A _3781_/C _3781_/B VDD VSS sg13cmos5l_o21ai_1
X_3853_ _3873_/B _3853_/A _3852_/Y VDD VSS sg13cmos5l_nor2b_1
X_3922_ _4963_/S _6675_/B _6656_/B VDD VSS sg13cmos5l_nand2_1
X_6710_ _6711_/B _6710_/A _6710_/B VDD VSS sg13cmos5l_xor2_1
X_6641_ _6641_/Y _6642_/B _6642_/A VDD VSS sg13cmos5l_nand2b_1
X_6572_ _6572_/X _6573_/A _6573_/B VDD VSS sg13cmos5l_and2_1
X_4336_ _4340_/A _7030_/Q _4341_/B _4334_/Y VDD VSS sg13cmos5l_a21oi_1
X_4405_ _4405_/Y _5106_/A _4406_/B VDD VSS sg13cmos5l_nor2_1
X_5385_ _5387_/A _5505_/B _5384_/B _5385_/S VDD VSS sg13cmos5l_mux2_1
X_5454_ _5454_/Y _5478_/A VDD VSS sg13cmos5l_inv_1
X_5523_ _5560_/A _5523_/A _5523_/B VDD VSS sg13cmos5l_xor2_1
X_7124_ _7124_/Q clkload8/A _7124_/D _7124_/RESET_B VDD VSS sg13cmos5l_dfrbpq_1
XFILLER_27_335 VDD VSS sg13cmos5l_fill_1
X_4198_ _4585_/B _5267_/B _4198_/B VDD VSS sg13cmos5l_xor2_1
X_4267_ _4271_/A _4233_/A _4233_/B _4233_/C VDD VSS sg13cmos5l_a21o_1
X_6006_ _6006_/X _6010_/B _6006_/B VDD VSS sg13cmos5l_and2_1
X_7055_ _7055_/Q _7104_/CLK _7055_/D _7055_/RESET_B VDD VSS sg13cmos5l_dfrbpq_1
X_6908_ _6908_/Y _6909_/A _6909_/B VDD VSS sg13cmos5l_nor2_1
X_6839_ _6852_/B _7011_/Q _6840_/B VDD VSS sg13cmos5l_nand2_1
XFILLER_10_202 VDD VSS sg13cmos5l_fill_1
XFILLER_10_246 VDD VSS sg13cmos5l_fill_1
XFILLER_10_257 VDD VSS sg13cmos5l_fill_2
X_7305__403 _7305_/RESET_B VDD VSS sg13cmos5l_tiehi
X_4052_ _6544_/A _4052_/A _4052_/B _5330_/C VDD VSS sg13cmos5l_nand3_1
X_4121_ _4121_/Y _4423_/A _4421_/A _4120_/Y VDD VSS sg13cmos5l_a21oi_1
X_5170_ _5173_/A _7067_/Q _5170_/B VDD VSS sg13cmos5l_xnor2_1
Xinput4 input4/X rst_n VDD VSS sg13cmos5l_buf_1
X_3905_ _3914_/A _3906_/A _3906_/B VDD VSS sg13cmos5l_or2_1
X_4954_ _5030_/A _4954_/A _4954_/B VDD VSS sg13cmos5l_xnor2_1
X_3767_ _3767_/Y _3768_/A _3768_/B _3768_/C VDD VSS sg13cmos5l_nor3_1
X_3836_ _3836_/Y _3836_/A _3836_/B _3836_/C _3836_/D VDD VSS sg13cmos5l_nor4_1
X_4885_ _4887_/C _6247_/A _4885_/B VDD VSS sg13cmos5l_nand2_1
X_5506_ _5508_/B _5481_/A _5481_/B _5385_/S VDD VSS sg13cmos5l_a21oi_1
X_6624_ _6627_/A _6624_/A _6624_/B _6624_/C VDD VSS sg13cmos5l_nand3_1
X_6555_ _6583_/A _6556_/A _6556_/B _6556_/C VDD VSS sg13cmos5l_a21oi_1
X_3698_ _3698_/Y _3705_/B _7154_/Q _7155_/Q VDD VSS sg13cmos5l_o21ai_1
X_4319_ _4322_/A _7057_/Q _4333_/B _4317_/X VDD VSS sg13cmos5l_a21oi_1
X_5299_ _5319_/B _7077_/Q _5300_/B VDD VSS sg13cmos5l_nand2_1
X_5368_ _5422_/A _5401_/A _5368_/B VDD VSS sg13cmos5l_nand2_1
X_5437_ _5438_/B _5411_/A _5411_/B _5435_/Y VDD VSS sg13cmos5l_a21oi_1
X_7107__287 _7107_/RESET_B VDD VSS sg13cmos5l_tiehi
X_7107_ _7107_/Q _7244_/CLK _7107_/D _7107_/RESET_B VDD VSS sg13cmos5l_dfrbpq_1
X_6486_ _6489_/A _6993_/Q _6486_/B VDD VSS sg13cmos5l_xnor2_1
XFILLER_27_121 VDD VSS sg13cmos5l_fill_1
XFILLER_28_655 VDD VSS sg13cmos5l_fill_1
XFILLER_28_699 VDD VSS sg13cmos5l_fill_2
X_7038_ _7038_/Q clkload6/A _7038_/D _7038_/RESET_B VDD VSS sg13cmos5l_dfrbpq_1
XFILLER_11_588 VDD VSS sg13cmos5l_fill_2
XFILLER_18_154 VDD VSS sg13cmos5l_fill_1
XFILLER_18_198 VDD VSS sg13cmos5l_fill_1
XFILLER_19_688 VDD VSS sg13cmos5l_fill_1
XFILLER_33_146 VDD VSS sg13cmos5l_fill_2
XFILLER_34_614 VDD VSS sg13cmos5l_fill_1
XFILLER_14_360 VDD VSS sg13cmos5l_fill_2
XFILLER_14_371 VDD VSS sg13cmos5l_fill_2
X_4670_ _4705_/B _4668_/A _4668_/B _4668_/C VDD VSS sg13cmos5l_a21oi_1
X_6340_ _6371_/A _6252_/B _6335_/X _6339_/X _6335_/D _6338_/Y VDD VSS sg13cmos5l_a221oi_1
XFILLER_37_0 VDD VSS sg13cmos5l_fill_1
X_5153_ _5158_/A _5153_/A _5154_/A _5153_/C VDD VSS sg13cmos5l_nand3_1
X_5222_ _5225_/A _5226_/A _5222_/B _5222_/C VDD VSS sg13cmos5l_nor3_1
X_6271_ _6336_/A _6261_/A _6257_/X _6259_/B VDD VSS sg13cmos5l_o21ai_1
XFILLER_25_603 VDD VSS sg13cmos5l_fill_2
X_4035_ _4055_/A _4239_/A _4681_/A VDD VSS sg13cmos5l_xnor2_1
X_4104_ _4107_/B _6720_/A _4105_/B VDD VSS sg13cmos5l_nand2b_1
X_5084_ _5090_/A _5818_/C _6720_/A VDD VSS sg13cmos5l_and2_1
X_7137__247 _7137_/RESET_B VDD VSS sg13cmos5l_tiehi
X_4868_ _4871_/A _7059_/Q _4868_/B VDD VSS sg13cmos5l_xnor2_1
X_4937_ _4941_/A _4937_/A _4937_/B VDD VSS sg13cmos5l_xnor2_1
X_5986_ _6075_/C _7167_/Q _6091_/D VDD VSS sg13cmos5l_and2_1
XFILLER_20_363 VDD VSS sg13cmos5l_fill_2
X_3819_ _3865_/B _5469_/A _5253_/A _5308_/A _3639_/Y VDD VSS sg13cmos5l_a22oi_1
X_4799_ _6677_/A _6720_/B _6656_/B VDD VSS sg13cmos5l_nand2_1
X_7302__406 _7302_/RESET_B VDD VSS sg13cmos5l_tiehi
X_6607_ _6647_/A _6605_/Y _6607_/B VDD VSS sg13cmos5l_nand2b_1
X_6538_ _6538_/Y _6538_/A _6560_/A VDD VSS sg13cmos5l_nor2_1
X_6469_ _6470_/B _6469_/A _6469_/B VDD VSS sg13cmos5l_xor2_1
XFILLER_15_102 VDD VSS sg13cmos5l_fill_2
XFILLER_15_113 VDD VSS sg13cmos5l_fill_2
XFILLER_16_647 VDD VSS sg13cmos5l_fill_1
XFILLER_30_138 VDD VSS sg13cmos5l_fill_1
XFILLER_39_706 VDD VSS sg13cmos5l_fill_2
XFILLER_34_422 VDD VSS sg13cmos5l_fill_2
X_4722_ _4725_/C _4885_/B _3956_/B _4724_/C VDD VSS sg13cmos5l_o21ai_1
X_5771_ _5772_/B _5792_/A _5771_/B VDD VSS sg13cmos5l_xnor2_1
X_5840_ _5841_/B _5840_/A _5840_/B VDD VSS sg13cmos5l_xnor2_1
X_4584_ _4597_/B _7078_/Q _4585_/B VDD VSS sg13cmos5l_nand2_1
X_4653_ _4654_/C _4677_/B _4652_/C _4652_/A VDD VSS sg13cmos5l_o21ai_1
X_6323_ _6323_/X _6323_/A _6323_/B VDD VSS sg13cmos5l_and2_1
X_5136_ _5136_/Y _5137_/A _5137_/B _5137_/C VDD VSS sg13cmos5l_nor3_1
X_5205_ _5206_/B _5205_/A _5193_/X VDD VSS sg13cmos5l_nor2b_1
X_6185_ _6188_/A _6185_/A _6185_/B VDD VSS sg13cmos5l_xnor2_1
X_6254_ _6254_/Y _7000_/Q _6277_/B VDD VSS sg13cmos5l_nand2_1
X_4018_ _4354_/A _4018_/A _4018_/B VDD VSS sg13cmos5l_xor2_1
X_5067_ _5074_/C _5067_/A _5111_/B _5067_/C VDD VSS sg13cmos5l_nand3_1
XFILLER_25_499 VDD VSS sg13cmos5l_fill_1
X_5969_ _5969_/Y _7181_/Q _5969_/A2 _5980_/B1 _7211_/Q VDD VSS sg13cmos5l_a22oi_1
X_6941_ _7050_/D _6941_/A _6941_/B VDD VSS sg13cmos5l_nor2_1
X_6872_ _6899_/A _6857_/A _6853_/A _6855_/B VDD VSS sg13cmos5l_a21oi_1
X_4705_ _4754_/B _4705_/A _4705_/B VDD VSS sg13cmos5l_or2_1
X_5685_ _5688_/B _7118_/Q _5685_/B _5685_/C VDD VSS sg13cmos5l_and3_1
X_5754_ _5755_/B _5754_/A _5754_/B _5754_/C VDD VSS sg13cmos5l_or3_1
X_5823_ _5823_/Y _5824_/A _5824_/B VDD VSS sg13cmos5l_nor2_1
X_4498_ _4519_/A _4499_/A _4499_/B VDD VSS sg13cmos5l_or2_1
X_4567_ _4567_/Y _4567_/A VDD VSS sg13cmos5l_inv_1
X_4636_ _4753_/A _4607_/A _4606_/B _4635_/Y _4595_/B _4604_/Y VDD VSS sg13cmos5l_a221oi_1
X_7286_ _7286_/Q _7318_/CLK _7286_/D _7286_/RESET_B VDD VSS sg13cmos5l_dfrbpq_1
X_6306_ _6318_/B _6304_/Y _6306_/B VDD VSS sg13cmos5l_nand2b_1
X_5119_ _5123_/A _5089_/A _5089_/B _5085_/Y VDD VSS sg13cmos5l_o21ai_1
X_6099_ _7207_/D _6038_/Y _7207_/Q _6106_/S VDD VSS sg13cmos5l_mux2_1
X_6168_ _7315_/D _7315_/Q _7283_/Q _6168_/S VDD VSS sg13cmos5l_mux2_1
X_6237_ _6239_/B _6226_/A _6226_/B _6224_/Y VDD VSS sg13cmos5l_o21ai_1
XFILLER_40_266 VDD VSS sg13cmos5l_fill_2
XFILLER_29_580 VDD VSS sg13cmos5l_decap_4
XFILLER_31_266 VDD VSS sg13cmos5l_fill_1
XFILLER_31_277 VDD VSS sg13cmos5l_fill_1
X_7053__248 _7053_/RESET_B VDD VSS sg13cmos5l_tiehi
XFILLER_8_484 VDD VSS sg13cmos5l_fill_2
XFILLER_8_495 VDD VSS sg13cmos5l_fill_2
X_4352_ _6961_/B _4352_/A _4352_/B VDD VSS sg13cmos5l_xor2_1
X_4421_ _4423_/C _4421_/A _4421_/B VDD VSS sg13cmos5l_nand2_1
X_5470_ _5497_/A _5471_/B _5471_/A VDD VSS sg13cmos5l_nand2b_1
X_7140_ _7140_/Q clkload3/A _7140_/D _7140_/RESET_B VDD VSS sg13cmos5l_dfrbpq_1
XFILLER_39_377 VDD VSS sg13cmos5l_fill_2
X_4283_ _4292_/A _7058_/Q _4320_/B _4281_/Y VDD VSS sg13cmos5l_a21oi_1
X_6022_ _6023_/B _6017_/A _6016_/A _6015_/Y VDD VSS sg13cmos5l_o21ai_1
X_7071_ _7071_/Q clkload7/A _7071_/D _7071_/RESET_B VDD VSS sg13cmos5l_dfrbpq_1
Xfanout15 _5792_/A _6750_/A VDD VSS sg13cmos5l_buf_1
Xfanout37 _4317_/A _3875_/X VDD VSS sg13cmos5l_buf_1
Xfanout26 _5821_/A _5106_/A VDD VSS sg13cmos5l_buf_1
X_6924_ _6924_/Y _6924_/A _6924_/B VDD VSS sg13cmos5l_xnor2_1
X_6855_ _6870_/B _6855_/A _6855_/B VDD VSS sg13cmos5l_nor2_1
X_3998_ _3998_/Y _3999_/A _3999_/B VDD VSS sg13cmos5l_nor2b_1
X_5668_ _5688_/A _7117_/Q _5653_/B _5651_/Y VDD VSS sg13cmos5l_a21oi_1
X_5737_ _5766_/A _5738_/A _5738_/B VDD VSS sg13cmos5l_and2_1
X_5806_ _5806_/Y _5808_/A _5806_/B _5810_/A _5809_/A VDD VSS sg13cmos5l_nor4_1
Xfanout59 _6303_/A _5481_/A VDD VSS sg13cmos5l_buf_1
Xfanout48 fanout48/X _3875_/X VDD VSS sg13cmos5l_buf_1
X_6786_ _6794_/A _6351_/B _6772_/B _6773_/X VDD VSS sg13cmos5l_a21oi_1
X_4619_ _4621_/B _4055_/B _4619_/B VDD VSS sg13cmos5l_nand2b_1
X_5599_ _5601_/B _5639_/A _5599_/B VDD VSS sg13cmos5l_and2_1
X_7269_ _7270_/D _7270_/CLK _7269_/D _6932_/B1 VDD VSS sg13cmos5l_dfrbpq_1
XFILLER_18_539 VDD VSS sg13cmos5l_fill_2
XFILLER_26_550 VDD VSS sg13cmos5l_decap_4
XFILLER_5_410 VDD VSS sg13cmos5l_fill_2
X_7239__325 _7239_/D VDD VSS sg13cmos5l_tiehi
X_3921_ _3945_/A _5596_/B _4844_/A VDD VSS sg13cmos5l_xnor2_1
X_4970_ _4972_/B _4970_/A _4970_/B VDD VSS sg13cmos5l_xor2_1
XFILLER_20_737 VDD VSS sg13cmos5l_fill_2
X_3783_ _5330_/B _3782_/A _4611_/A _3782_/B VDD VSS sg13cmos5l_a21oi_1
X_3852_ _3852_/Y _3871_/A _3852_/B _3852_/C VDD VSS sg13cmos5l_nand3_1
X_5522_ _5522_/Y _5523_/A _5523_/B VDD VSS sg13cmos5l_nor2b_1
X_6640_ _6642_/B _7028_/Q _6640_/B VDD VSS sg13cmos5l_xnor2_1
X_6571_ _6573_/B _6571_/A _6571_/B VDD VSS sg13cmos5l_xnor2_1
X_4335_ _4341_/B _4335_/A _4335_/B VDD VSS sg13cmos5l_xor2_1
X_4404_ _4406_/B _4404_/A _4404_/B VDD VSS sg13cmos5l_xor2_1
X_5384_ _5505_/B _5384_/A _5384_/B VDD VSS sg13cmos5l_xnor2_1
X_5453_ _5478_/A _5453_/A _5563_/A VDD VSS sg13cmos5l_and2_1
X_7209__184 _7209_/RESET_B VDD VSS sg13cmos5l_tiehi
X_7123_ _7123_/Q clkload8/A _7123_/D _7123_/RESET_B VDD VSS sg13cmos5l_dfrbpq_1
X_4197_ _4597_/A _6467_/B _4198_/B VDD VSS sg13cmos5l_nand2_1
X_4266_ _6938_/B _4266_/A _4266_/B VDD VSS sg13cmos5l_nor2_1
X_6005_ _6006_/B _6005_/A _6005_/B _6005_/C VDD VSS sg13cmos5l_or3_1
X_7054_ _7054_/Q _7103_/CLK _7054_/D _7054_/RESET_B VDD VSS sg13cmos5l_dfrbpq_1
XFILLER_23_597 VDD VSS sg13cmos5l_decap_4
X_6907_ _6909_/B _7043_/Q _6907_/B VDD VSS sg13cmos5l_xnor2_1
X_6838_ _6840_/B _6838_/A _6838_/B VDD VSS sg13cmos5l_xor2_1
X_7147__227 _7147_/RESET_B VDD VSS sg13cmos5l_tiehi
X_6769_ _6771_/B _6746_/A _6746_/B _6748_/Y VDD VSS sg13cmos5l_o21ai_1
X_7123__271 _7123_/RESET_B VDD VSS sg13cmos5l_tiehi
XFILLER_36_133 VDD VSS sg13cmos5l_fill_1
X_4051_ _6525_/A _4053_/A _4053_/B _5253_/A VDD VSS sg13cmos5l_nor3_1
X_4120_ _4120_/Y _4299_/B _4421_/B VDD VSS sg13cmos5l_nand2_1
XFILLER_36_199 VDD VSS sg13cmos5l_fill_2
X_3904_ _6771_/A _6745_/A _5812_/B _3903_/Y VDD VSS sg13cmos5l_a21oi_1
X_4884_ _4889_/A _4844_/A _4844_/C _4841_/Y VDD VSS sg13cmos5l_a21oi_1
X_4953_ _5028_/A _4954_/A _4954_/B VDD VSS sg13cmos5l_nor2_1
X_6623_ _6624_/C _7000_/Q _6623_/B VDD VSS sg13cmos5l_xnor2_1
X_3697_ _3697_/X _3810_/A _3810_/B _3806_/A VDD VSS sg13cmos5l_or3_1
X_3766_ _5380_/A _3768_/B _3768_/C VDD VSS sg13cmos5l_nor2_1
X_3835_ _3854_/C _5613_/A _5596_/B _3829_/Y _3830_/Y _3834_/Y VDD VSS sg13cmos5l_a221oi_1
X_5436_ _5462_/B _5435_/A _5436_/B VDD VSS sg13cmos5l_nand2b_1
X_5505_ _5508_/A _5671_/A _5505_/B VDD VSS sg13cmos5l_xor2_1
X_6554_ _6556_/C _6997_/Q _6554_/B VDD VSS sg13cmos5l_xnor2_1
X_6485_ _6486_/B _6485_/A _6485_/B VDD VSS sg13cmos5l_xnor2_1
X_4249_ _4264_/B _7021_/Q _4250_/B VDD VSS sg13cmos5l_nand2_1
X_4318_ _4333_/B _4331_/A _4318_/B VDD VSS sg13cmos5l_xnor2_1
X_5298_ _5300_/B _5298_/A _5298_/B VDD VSS sg13cmos5l_xnor2_1
X_5367_ _5368_/B _5367_/A _5367_/B _5367_/C VDD VSS sg13cmos5l_nand3_1
X_7106_ _7106_/Q _7244_/CLK _7106_/D _7106_/RESET_B VDD VSS sg13cmos5l_dfrbpq_1
X_7037_ _7037_/Q clkload5/A _7037_/D _7037_/RESET_B VDD VSS sg13cmos5l_dfrbpq_1
X_7229__324 _7229_/RESET_B VDD VSS sg13cmos5l_tiehi
X_4103_ _4105_/B _4103_/A _4103_/B VDD VSS sg13cmos5l_xnor2_1
X_5152_ _5162_/A _5124_/A _5124_/B _5122_/Y VDD VSS sg13cmos5l_o21ai_1
X_5221_ _5222_/C _5221_/A _5221_/B VDD VSS sg13cmos5l_xor2_1
X_6270_ _6335_/A _6270_/A _6270_/B VDD VSS sg13cmos5l_nor2_1
X_7206__187 _7206_/RESET_B VDD VSS sg13cmos5l_tiehi
XFILLER_37_431 VDD VSS sg13cmos5l_fill_1
X_4034_ _4039_/A _5351_/B _4680_/A VDD VSS sg13cmos5l_nand2_1
X_5083_ _5092_/A _5046_/A _5044_/X _5043_/X VDD VSS sg13cmos5l_o21ai_1
X_3818_ _3863_/B _3639_/Y _5308_/A _3817_/Y VDD VSS sg13cmos5l_o21ai_1
X_4867_ _4868_/B _4867_/A _4867_/B VDD VSS sg13cmos5l_xor2_1
X_4936_ _4937_/B _4936_/A _4936_/B VDD VSS sg13cmos5l_xor2_1
X_5985_ _6091_/D _5985_/A _7126_/Q VDD VSS sg13cmos5l_nor2b_1
X_7113__281 _7113_/RESET_B VDD VSS sg13cmos5l_tiehi
X_6606_ _6607_/B _6606_/A _6606_/B _6606_/C VDD VSS sg13cmos5l_nand3_1
X_3749_ _3929_/A _3749_/A _3749_/B _3749_/C VDD VSS sg13cmos5l_nand3_1
X_4798_ _4811_/A _4772_/A _4772_/B _4770_/X VDD VSS sg13cmos5l_a21oi_1
X_5419_ _5427_/A _5420_/A _5420_/B VDD VSS sg13cmos5l_nor2b_1
X_6537_ _6560_/A _6537_/A VDD VSS sg13cmos5l_inv_1
X_6468_ _6473_/A _6469_/A _6469_/B VDD VSS sg13cmos5l_nand2_1
X_6399_ _6422_/B _6371_/A _6398_/Y _6397_/Y VDD VSS sg13cmos5l_o21ai_1
X_7120__274 _7120_/RESET_B VDD VSS sg13cmos5l_tiehi
XFILLER_28_497 VDD VSS sg13cmos5l_fill_1
XFILLER_11_342 VDD VSS sg13cmos5l_fill_2
XFILLER_24_692 VDD VSS sg13cmos5l_fill_2
XFILLER_34_401 VDD VSS sg13cmos5l_decap_4
X_6999__381 _6999_/RESET_B VDD VSS sg13cmos5l_tiehi
XFILLER_15_681 VDD VSS sg13cmos5l_fill_2
X_4652_ _4676_/A _4652_/A _4677_/B _4652_/C VDD VSS sg13cmos5l_or3_1
X_4721_ _4766_/B _4724_/C _4724_/B _4724_/A VDD VSS sg13cmos5l_nand3b_1
X_5770_ _5770_/Y _5770_/A _5771_/B VDD VSS sg13cmos5l_nor2_1
X_4583_ _7077_/D _4580_/Y _4581_/Y _4582_/Y VDD VSS sg13cmos5l_a21oi_1
X_6253_ _6999_/D _6253_/A _6253_/B _6261_/B VDD VSS sg13cmos5l_and3_1
X_7063__228 _7063_/RESET_B VDD VSS sg13cmos5l_tiehi
X_6322_ _7005_/D _6334_/A _6320_/B _6321_/Y VDD VSS sg13cmos5l_a21oi_1
X_5066_ _5066_/X _5067_/A _5111_/B _5067_/C VDD VSS sg13cmos5l_and3_1
X_5135_ _5137_/C _5134_/B _5134_/C _7093_/Q VDD VSS sg13cmos5l_a21oi_1
X_5204_ _5211_/A _5226_/A _5204_/B VDD VSS sg13cmos5l_nand2b_1
X_6184_ _6185_/B _6993_/Q _6195_/B VDD VSS sg13cmos5l_xnor2_1
XFILLER_40_415 VDD VSS sg13cmos5l_fill_1
X_4017_ _4017_/X _4018_/A _4018_/B VDD VSS sg13cmos5l_and2_1
X_5968_ _5968_/Y _7226_/Q _5981_/A2 _5981_/B1 _7196_/Q VDD VSS sg13cmos5l_a22oi_1
X_4919_ _4921_/B _4915_/A _4913_/Y _4920_/B _4872_/X _4912_/Y VDD VSS sg13cmos5l_a221oi_1
X_5899_ _7142_/D _5901_/A _5899_/B VDD VSS sg13cmos5l_nor2_1
XFILLER_16_423 VDD VSS sg13cmos5l_fill_1
XFILLER_12_662 VDD VSS sg13cmos5l_fill_2
XFILLER_16_467 VDD VSS sg13cmos5l_fill_1
XFILLER_8_677 VDD VSS sg13cmos5l_fill_1
X_5822_ _5824_/B _7123_/Q _5822_/B VDD VSS sg13cmos5l_xnor2_1
X_7103__291 _7103_/RESET_B VDD VSS sg13cmos5l_tiehi
X_6940_ _6941_/B _6940_/A _6940_/B VDD VSS sg13cmos5l_nand2_1
X_6871_ _6873_/A _6871_/A _6898_/A VDD VSS sg13cmos5l_nor2_1
X_4635_ _4635_/Y _4635_/A _4635_/B VDD VSS sg13cmos5l_nor2_1
X_4704_ _4753_/C _4638_/A _4704_/B VDD VSS sg13cmos5l_nand2b_1
X_5684_ _5685_/C _5684_/A _5684_/B _5684_/C VDD VSS sg13cmos5l_nand3_1
X_5753_ _5753_/Y _5754_/A _5754_/B _5754_/C VDD VSS sg13cmos5l_nor3_1
X_7110__284 _7110_/RESET_B VDD VSS sg13cmos5l_tiehi
XFILLER_1_319 VDD VSS sg13cmos5l_fill_1
X_4497_ _4499_/B _7068_/Q _6877_/B _4467_/Y VDD VSS sg13cmos5l_a21oi_1
X_4566_ _4567_/A _4568_/A _4568_/B _4568_/C VDD VSS sg13cmos5l_a21oi_1
X_6236_ _6239_/A _6633_/B _6236_/B VDD VSS sg13cmos5l_xnor2_1
X_7285_ _7285_/Q _7318_/CLK _7285_/D _7285_/RESET_B VDD VSS sg13cmos5l_dfrbpq_1
X_6305_ _6306_/B _6304_/A _6304_/B _6304_/C VDD VSS sg13cmos5l_o21ai_1
XFILLER_27_24 VDD VSS sg13cmos5l_fill_2
X_5049_ _5096_/B _5050_/A _5050_/B VDD VSS sg13cmos5l_or2_1
X_5118_ _5137_/A _7092_/Q _5107_/B _5105_/Y VDD VSS sg13cmos5l_a21oi_1
X_6098_ _7206_/D _6034_/Y _7206_/Q _6105_/S VDD VSS sg13cmos5l_mux2_1
X_6167_ _7314_/D _7314_/Q _7282_/Q _6170_/S VDD VSS sg13cmos5l_mux2_1
Xclkbuf_leaf_9_sd_clk _7244_/CLK clkload2/A VDD VSS sg13cmos5l_buf_8
X_6996__384 _6996_/RESET_B VDD VSS sg13cmos5l_tiehi
XFILLER_31_256 VDD VSS sg13cmos5l_fill_1
X_4282_ _4320_/B _4288_/A _4282_/B VDD VSS sg13cmos5l_xnor2_1
X_4351_ _4351_/Y _4352_/A _4352_/B VDD VSS sg13cmos5l_nor2b_1
X_4420_ _4433_/B _4412_/B _4412_/C _7036_/Q VDD VSS sg13cmos5l_a21o_1
X_7070_ _7070_/Q clkload7/A _7070_/D _7070_/RESET_B VDD VSS sg13cmos5l_dfrbpq_1
X_6021_ _6023_/A _6019_/X _6021_/B VDD VSS sg13cmos5l_nand2b_1
XFILLER_22_212 VDD VSS sg13cmos5l_fill_2
XFILLER_23_702 VDD VSS sg13cmos5l_fill_2
XFILLER_23_735 VDD VSS sg13cmos5l_fill_1
XFILLER_35_540 VDD VSS sg13cmos5l_fill_1
XFILLER_35_573 VDD VSS sg13cmos5l_decap_4
X_3997_ _3999_/B _3997_/A _3997_/B VDD VSS sg13cmos5l_xnor2_1
X_5805_ _7122_/D _5802_/X _5803_/Y _5804_/Y VDD VSS sg13cmos5l_a21oi_1
Xfanout16 _6750_/A _7230_/D VDD VSS sg13cmos5l_buf_1
Xfanout49 _6720_/A _5671_/A VDD VSS sg13cmos5l_buf_1
Xfanout38 _6528_/A _4370_/A VDD VSS sg13cmos5l_buf_1
Xfanout27 _5106_/A _5770_/A VDD VSS sg13cmos5l_buf_1
X_6923_ _6924_/B _6923_/A _6923_/B VDD VSS sg13cmos5l_xnor2_1
X_6854_ _6855_/B _6852_/A _6852_/B _6852_/C VDD VSS sg13cmos5l_a21oi_1
X_6785_ _6798_/A _6775_/A _6775_/B _6776_/Y VDD VSS sg13cmos5l_o21ai_1
XFILLER_22_289 VDD VSS sg13cmos5l_fill_1
X_4618_ _4621_/A _4618_/A _4618_/B VDD VSS sg13cmos5l_xnor2_1
X_5598_ _5599_/B _5597_/A _5597_/B _5597_/C VDD VSS sg13cmos5l_a21o_1
X_5667_ _5692_/A _7090_/Q _5656_/B _5654_/Y VDD VSS sg13cmos5l_a21oi_1
X_5736_ _5738_/B _5735_/A _3931_/B _5735_/Y VDD VSS sg13cmos5l_a21oi_1
X_4549_ _4552_/A _7075_/Q _6474_/B VDD VSS sg13cmos5l_xnor2_1
X_6219_ _6232_/A _6220_/A _6219_/B VDD VSS sg13cmos5l_nor2_1
X_7268_ _7269_/D _7270_/CLK _7268_/D _6930_/A VDD VSS sg13cmos5l_dfrbpq_1
X_7199_ _7199_/Q _7318_/CLK _7199_/D _7199_/RESET_B VDD VSS sg13cmos5l_dfrbpq_1
XFILLER_5_488 VDD VSS sg13cmos5l_fill_1
XFILLER_17_562 VDD VSS sg13cmos5l_fill_1
XFILLER_32_554 VDD VSS sg13cmos5l_decap_8
X_3851_ _3873_/A _3851_/A _3851_/B VDD VSS sg13cmos5l_xnor2_1
X_3920_ _3920_/Y _4844_/A VDD VSS sg13cmos5l_inv_1
X_7100__294 _7100_/RESET_B VDD VSS sg13cmos5l_tiehi
XFILLER_9_761 VDD VSS sg13cmos5l_fill_2
X_3782_ _6565_/A _3782_/A _3782_/B _4611_/A VDD VSS sg13cmos5l_nand3_1
X_5452_ _5563_/A _5427_/A _5447_/B _5451_/C _5421_/Y _5445_/Y VDD VSS sg13cmos5l_a221oi_1
X_5521_ _5523_/B _7085_/Q _5496_/B _5494_/Y VDD VSS sg13cmos5l_a21o_1
X_6570_ _6571_/B _6547_/A _6545_/Y _6546_/A VDD VSS sg13cmos5l_a21oi_1
X_4265_ _4266_/B _6938_/A _4265_/B VDD VSS sg13cmos5l_nand2b_1
X_4334_ _4334_/Y _4335_/A _4335_/B VDD VSS sg13cmos5l_nor2_1
X_4403_ _6981_/A _4403_/A _4403_/B _4403_/C _4403_/D VDD VSS sg13cmos5l_nor4_1
X_5383_ _5435_/A _5384_/A _5384_/B VDD VSS sg13cmos5l_nand2_1
X_6004_ _6010_/B _6005_/A _6005_/B _6005_/C VDD VSS sg13cmos5l_o21ai_1
X_7122_ _7122_/Q clkload8/A _7122_/D _7122_/RESET_B VDD VSS sg13cmos5l_dfrbpq_1
X_7053_ _7053_/Q _7103_/CLK _7053_/D _7053_/RESET_B VDD VSS sg13cmos5l_dfrbpq_1
X_4196_ _4198_/B _4196_/A _4196_/B VDD VSS sg13cmos5l_xnor2_1
XFILLER_10_259 VDD VSS sg13cmos5l_fill_1
XFILLER_23_554 VDD VSS sg13cmos5l_fill_2
XFILLER_24_69 VDD VSS sg13cmos5l_fill_1
X_6906_ _6909_/A _7042_/Q _6907_/B _4470_/A VDD VSS sg13cmos5l_a21oi_1
X_6837_ _6852_/A _6838_/A _6838_/B VDD VSS sg13cmos5l_or2_1
X_6768_ _6775_/A _6750_/A _6750_/B _6751_/Y VDD VSS sg13cmos5l_a21oi_1
X_5719_ _5721_/B _5741_/B _5718_/Y VDD VSS sg13cmos5l_nor2b_1
X_6699_ _6710_/A _7030_/Q _6682_/B _6680_/X VDD VSS sg13cmos5l_a21o_1
XFILLER_26_370 VDD VSS sg13cmos5l_fill_1
XFILLER_33_318 VDD VSS sg13cmos5l_fill_2
XFILLER_33_329 VDD VSS sg13cmos5l_fill_2
X_6993__387 _6993_/RESET_B VDD VSS sg13cmos5l_tiehi
X_7245__330 _7245_/RESET_B VDD VSS sg13cmos5l_tiehi
XFILLER_6_786 VDD VSS sg13cmos5l_fill_2
X_4050_ _4063_/A _4195_/A _4196_/A VDD VSS sg13cmos5l_or2_1
X_3834_ _3834_/Y _3834_/A _3834_/B _3857_/B VDD VSS sg13cmos5l_nand3_1
X_3903_ _3903_/Y _6745_/A _5788_/A VDD VSS sg13cmos5l_nor2_1
X_4883_ _4891_/A _6303_/A _5004_/B VDD VSS sg13cmos5l_xnor2_1
X_4952_ _4954_/B _7060_/Q _4911_/B _4909_/Y VDD VSS sg13cmos5l_a21oi_1
X_6622_ _6645_/B _7000_/Q _6623_/B VDD VSS sg13cmos5l_nand2_1
XFILLER_20_579 VDD VSS sg13cmos5l_fill_2
X_3696_ _3796_/A _3810_/A _3810_/B _3806_/A VDD VSS sg13cmos5l_nor3_1
X_3765_ _3765_/X _3768_/B _3768_/C VDD VSS sg13cmos5l_or2_1
X_5435_ _5435_/Y _5435_/A _5435_/B VDD VSS sg13cmos5l_nor2_1
X_5504_ _5519_/A _7112_/Q _5493_/B _5491_/X VDD VSS sg13cmos5l_a21oi_1
X_6553_ _6579_/B _6997_/Q _6554_/B VDD VSS sg13cmos5l_nand2_1
X_6484_ _6484_/Y _6485_/B _6485_/A VDD VSS sg13cmos5l_nor2b_1
X_4248_ _4250_/B _4248_/A _4248_/B VDD VSS sg13cmos5l_xor2_1
X_4317_ _4317_/X _4317_/A _4318_/B VDD VSS sg13cmos5l_and2_1
X_5297_ _5319_/A _5298_/A _5298_/B VDD VSS sg13cmos5l_nand2b_1
X_5366_ _5401_/A _5367_/A _5367_/B _5367_/C VDD VSS sg13cmos5l_a21o_1
X_7105_ _7105_/Q _7244_/CLK _7105_/D _7105_/RESET_B VDD VSS sg13cmos5l_dfrbpq_1
X_7036_ _7036_/Q clkload5/A _7036_/D _7036_/RESET_B VDD VSS sg13cmos5l_dfrbpq_1
XFILLER_15_318 VDD VSS sg13cmos5l_fill_1
XFILLER_27_189 VDD VSS sg13cmos5l_fill_1
XFILLER_35_13 VDD VSS sg13cmos5l_fill_1
X_4179_ _4194_/B _4176_/B _4174_/C _7038_/Q VDD VSS sg13cmos5l_a21oi_1
XFILLER_23_351 VDD VSS sg13cmos5l_fill_1
XFILLER_23_373 VDD VSS sg13cmos5l_fill_2
XFILLER_3_701 VDD VSS sg13cmos5l_fill_2
XFILLER_33_126 VDD VSS sg13cmos5l_fill_1
XFILLER_34_627 VDD VSS sg13cmos5l_fill_2
XFILLER_10_590 VDD VSS sg13cmos5l_fill_1
X_5220_ _5226_/B _5221_/A _5221_/B VDD VSS sg13cmos5l_nor2_1
X_4033_ _4680_/A _5330_/C _4060_/B VDD VSS sg13cmos5l_nor2_1
X_4102_ _4107_/A _4103_/A _4103_/B VDD VSS sg13cmos5l_nand2b_1
X_5082_ _5109_/A _5082_/A _5082_/B VDD VSS sg13cmos5l_nor2_1
X_5151_ _5164_/A _5128_/A _5148_/Y _5150_/Y _5103_/B VDD VSS sg13cmos5l_a22oi_1
X_5984_ _5985_/A _5984_/A _5984_/B _5984_/C VDD VSS sg13cmos5l_nor3_1
XFILLER_20_321 VDD VSS sg13cmos5l_fill_2
X_3748_ _3756_/B _3748_/A _3748_/B _3748_/C VDD VSS sg13cmos5l_nor3_1
X_3817_ _3817_/Y _7109_/Q _6469_/A VDD VSS sg13cmos5l_nand2_1
X_4797_ _4816_/A _4775_/A _4775_/B _4773_/Y VDD VSS sg13cmos5l_a21oi_1
X_4866_ _4866_/Y _4867_/A _4867_/B VDD VSS sg13cmos5l_nor2_1
X_4935_ _4935_/Y _4936_/A _4936_/B VDD VSS sg13cmos5l_nor2_1
X_6605_ _6605_/Y _6606_/A _6606_/B _6606_/C VDD VSS sg13cmos5l_a21oi_1
X_6536_ _6537_/A _6536_/A _6536_/B _6536_/C VDD VSS sg13cmos5l_nand3_1
X_3679_ _3679_/X _7165_/Q _7164_/Q VDD VSS sg13cmos5l_and2_1
X_5349_ _7106_/D _5376_/A _5349_/B _5349_/C VDD VSS sg13cmos5l_and3_1
X_5418_ _5420_/B _5396_/A _5396_/B _5394_/Y VDD VSS sg13cmos5l_o21ai_1
X_6467_ _6469_/B _7018_/Q _6467_/B VDD VSS sg13cmos5l_xnor2_1
X_6398_ _6398_/Y _6371_/B _6398_/B VDD VSS sg13cmos5l_nand2b_1
X_7019_ _7019_/Q _7270_/CLK _7019_/D _7019_/RESET_B VDD VSS sg13cmos5l_dfrbpq_1
XFILLER_15_104 VDD VSS sg13cmos5l_fill_1
XFILLER_16_638 VDD VSS sg13cmos5l_fill_1
XFILLER_24_682 VDD VSS sg13cmos5l_decap_4
XFILLER_39_708 VDD VSS sg13cmos5l_fill_1
XFILLER_34_424 VDD VSS sg13cmos5l_fill_1
XFILLER_34_446 VDD VSS sg13cmos5l_fill_1
XFILLER_21_129 VDD VSS sg13cmos5l_fill_1
XFILLER_30_663 VDD VSS sg13cmos5l_fill_2
X_4651_ _4652_/C _4651_/A _4651_/B _4651_/C VDD VSS sg13cmos5l_and3_1
X_4720_ _4724_/C _4647_/A _4719_/B _4766_/A VDD VSS sg13cmos5l_o21ai_1
X_4582_ _4582_/Y _4580_/Y _4581_/Y _4596_/A VDD VSS sg13cmos5l_o21ai_1
X_5203_ _5204_/B _5203_/A _5203_/B _5203_/C VDD VSS sg13cmos5l_nand3_1
X_6183_ _6183_/Y _6993_/Q _6195_/B VDD VSS sg13cmos5l_nand2_1
X_6252_ _6261_/B _6270_/A _6252_/B VDD VSS sg13cmos5l_nand2b_1
X_6321_ _6321_/Y _6321_/A _6323_/B VDD VSS sg13cmos5l_nand2_1
XFILLER_29_207 VDD VSS sg13cmos5l_fill_2
XFILLER_37_240 VDD VSS sg13cmos5l_fill_2
X_4016_ _4016_/X _4018_/A _4018_/B VDD VSS sg13cmos5l_or2_1
X_5065_ _5067_/C _5111_/A _5064_/C _7064_/Q VDD VSS sg13cmos5l_a21o_1
X_5134_ _5137_/B _7093_/Q _5134_/B _5134_/C VDD VSS sg13cmos5l_and3_1
X_4918_ _4920_/B _4918_/A _4915_/C VDD VSS sg13cmos5l_nor2b_1
X_5967_ _7162_/D _7162_/Q _5967_/A2 _5966_/Y VDD VSS sg13cmos5l_a21o_1
XFILLER_21_674 VDD VSS sg13cmos5l_fill_1
X_4849_ _4851_/C _4846_/A _4849_/B _4849_/C VDD VSS sg13cmos5l_nand3b_1
X_5898_ _5899_/B _7142_/Q _5875_/B _5902_/B1 _7141_/Q VDD VSS sg13cmos5l_a22oi_1
X_6519_ _6521_/B _6520_/A _6520_/B VDD VSS sg13cmos5l_or2_1
XFILLER_0_578 VDD VSS sg13cmos5l_fill_2
XFILLER_0_589 VDD VSS sg13cmos5l_fill_1
XFILLER_16_457 VDD VSS sg13cmos5l_fill_2
XFILLER_28_284 VDD VSS sg13cmos5l_fill_2
X_5752_ _5780_/C _5754_/B _5754_/C _5754_/A VDD VSS sg13cmos5l_o21ai_1
X_5821_ _5822_/B _5821_/A _5821_/B VDD VSS sg13cmos5l_xnor2_1
X_6870_ _6898_/A _6844_/B _6870_/B VDD VSS sg13cmos5l_nand2b_1
X_4565_ _4568_/C _7049_/Q _4565_/B VDD VSS sg13cmos5l_xnor2_1
X_4634_ _4638_/A _4705_/A _4634_/B VDD VSS sg13cmos5l_nand2b_1
X_4703_ _4753_/B _4755_/A _4703_/B VDD VSS sg13cmos5l_nand2b_1
X_5683_ _5685_/B _5684_/B _5684_/C _5684_/A VDD VSS sg13cmos5l_a21o_1
X_4496_ _4499_/A _7069_/Q _6877_/B VDD VSS sg13cmos5l_xnor2_1
X_6166_ _7313_/D _7313_/Q _7281_/Q _6168_/S VDD VSS sg13cmos5l_mux2_1
X_6235_ _6236_/B _6998_/Q _6573_/A VDD VSS sg13cmos5l_xnor2_1
X_7284_ _7284_/Q _7316_/CLK _7284_/D _7284_/RESET_B VDD VSS sg13cmos5l_dfrbpq_1
X_6304_ _6304_/Y _6304_/A _6304_/B _6304_/C VDD VSS sg13cmos5l_nor3_1
XFILLER_26_711 VDD VSS sg13cmos5l_decap_4
X_5048_ _5050_/B _5048_/A _5048_/B VDD VSS sg13cmos5l_xnor2_1
X_5117_ _5142_/A _7065_/Q _5110_/B _5108_/Y VDD VSS sg13cmos5l_a21o_1
X_6097_ _7205_/D _6029_/Y _7205_/Q _6106_/S VDD VSS sg13cmos5l_mux2_1
XFILLER_21_482 VDD VSS sg13cmos5l_decap_8
XFILLER_40_268 VDD VSS sg13cmos5l_fill_1
X_6999_ _6999_/Q clkload9/A _6999_/D _6999_/RESET_B VDD VSS sg13cmos5l_dfrbpq_1
X_7202__191 _7202_/RESET_B VDD VSS sg13cmos5l_tiehi
XFILLER_16_243 VDD VSS sg13cmos5l_fill_2
XFILLER_12_460 VDD VSS sg13cmos5l_fill_1
XFILLER_12_493 VDD VSS sg13cmos5l_fill_1
X_4281_ _4281_/Y _4288_/A _4285_/C _4281_/C VDD VSS sg13cmos5l_nor3_1
X_4350_ _4352_/B _4348_/A _4348_/B _4349_/Y VDD VSS sg13cmos5l_o21ai_1
X_6020_ _6021_/B _7309_/Q _7293_/Q VDD VSS sg13cmos5l_or2_1
XFILLER_39_346 VDD VSS sg13cmos5l_fill_1
XFILLER_39_379 VDD VSS sg13cmos5l_fill_1
X_6922_ _6923_/B _7043_/Q _4468_/Y _4470_/B VDD VSS sg13cmos5l_a21oi_1
X_3996_ _3999_/A _4011_/A _4011_/B VDD VSS sg13cmos5l_nand2_1
X_5735_ _5735_/Y _5735_/A _5735_/B VDD VSS sg13cmos5l_nor2_1
X_5804_ _5804_/Y _5802_/X _5803_/Y _5179_/A VDD VSS sg13cmos5l_o21ai_1
Xfanout17 _4288_/A _5579_/A VDD VSS sg13cmos5l_buf_1
Xfanout39 _6195_/B _4370_/A VDD VSS sg13cmos5l_buf_1
Xfanout28 _5770_/A _6729_/A VDD VSS sg13cmos5l_buf_1
X_6853_ _6855_/A _6853_/A VDD VSS sg13cmos5l_inv_1
X_6784_ _7034_/D _6784_/A _6784_/B _6799_/B VDD VSS sg13cmos5l_and3_1
X_4548_ _4556_/A _7047_/Q _4544_/B _4542_/Y VDD VSS sg13cmos5l_a21oi_1
X_4617_ _4618_/B _4617_/A _4617_/B VDD VSS sg13cmos5l_xnor2_1
X_5597_ _5639_/A _5597_/A _5597_/B _5597_/C VDD VSS sg13cmos5l_nand3_1
X_5666_ _7117_/D _6971_/A _5666_/B _5695_/B VDD VSS sg13cmos5l_nor3_1
X_4479_ _4481_/A _4479_/A _4479_/B VDD VSS sg13cmos5l_nor2_1
X_6149_ _7296_/D _7296_/Q _7142_/Q _6168_/S VDD VSS sg13cmos5l_mux2_1
X_6218_ _6219_/B _6220_/B VDD VSS sg13cmos5l_inv_1
X_7267_ _7268_/D _7270_/CLK _7267_/D _6930_/A VDD VSS sg13cmos5l_dfrbpq_1
X_7198_ _7198_/Q clkload5/A _7198_/D _7198_/RESET_B VDD VSS sg13cmos5l_dfrbpq_1
X_7052__250 _7052_/RESET_B VDD VSS sg13cmos5l_tiehi
XFILLER_20_739 VDD VSS sg13cmos5l_fill_1
XFILLER_32_544 VDD VSS sg13cmos5l_decap_4
X_3781_ _5330_/A _3781_/A _3781_/B _3781_/C VDD VSS sg13cmos5l_nor3_1
X_3850_ _3851_/B _3850_/A _3856_/A VDD VSS sg13cmos5l_nand2_1
Xclkbuf_leaf_11_sd_clk _7103_/CLK clkload2/A VDD VSS sg13cmos5l_buf_8
X_4402_ _4403_/D _4399_/A _4400_/Y _4401_/Y VDD VSS sg13cmos5l_o21ai_1
X_5382_ _5382_/Y _5385_/S _5384_/B VDD VSS sg13cmos5l_nand2_1
X_5451_ _5453_/A _5451_/A _5451_/B _5451_/C VDD VSS sg13cmos5l_nand3_1
X_5520_ _5523_/A _7086_/Q _5520_/B VDD VSS sg13cmos5l_xnor2_1
X_4195_ _4196_/B _4195_/A _4195_/B VDD VSS sg13cmos5l_nand2_1
X_4264_ _4265_/B _4264_/A _4264_/B _4264_/C VDD VSS sg13cmos5l_nand3_1
X_4333_ _4335_/B _7057_/Q _4333_/B VDD VSS sg13cmos5l_xnor2_1
X_6003_ _6005_/C _7306_/Q _7290_/Q VDD VSS sg13cmos5l_xor2_1
X_7121_ _7121_/Q clkload8/A _7121_/D _7121_/RESET_B VDD VSS sg13cmos5l_dfrbpq_1
X_7052_ _7052_/Q _7104_/CLK _7052_/D _7052_/RESET_B VDD VSS sg13cmos5l_dfrbpq_1
XFILLER_23_511 VDD VSS sg13cmos5l_fill_2
XFILLER_27_349 VDD VSS sg13cmos5l_fill_1
XFILLER_35_382 VDD VSS sg13cmos5l_fill_2
X_6905_ _7042_/D _6905_/A _6905_/B _6915_/B VDD VSS sg13cmos5l_nor3_1
X_3979_ _4733_/B _4053_/A _4053_/B _6565_/C VDD VSS sg13cmos5l_nor3_1
X_5718_ _5718_/Y _5718_/A _5718_/B _5760_/A VDD VSS sg13cmos5l_nand3_1
X_6836_ _6838_/B _7037_/Q _6860_/B _4470_/A VDD VSS sg13cmos5l_a21oi_1
X_6767_ _6783_/A _6764_/Y _6765_/X _6766_/Y _6696_/B VDD VSS sg13cmos5l_a22oi_1
X_6698_ _7030_/D _6971_/A _6698_/B _6716_/B VDD VSS sg13cmos5l_nor3_1
X_5649_ _5650_/B _5706_/A _5649_/B _5649_/C VDD VSS sg13cmos5l_nand3_1
XFILLER_18_349 VDD VSS sg13cmos5l_fill_2
XFILLER_14_533 VDD VSS sg13cmos5l_fill_2
XFILLER_41_341 VDD VSS sg13cmos5l_fill_2
X_4951_ _4954_/A _7061_/Q _4951_/B VDD VSS sg13cmos5l_xnor2_1
X_3764_ _3768_/C _3763_/B _3763_/C _3763_/A VDD VSS sg13cmos5l_a21oi_1
X_3833_ _3857_/B _7117_/Q _6247_/A VDD VSS sg13cmos5l_xnor2_1
X_3902_ _3906_/B _6720_/B _5154_/A _4155_/A VDD VSS sg13cmos5l_a21oi_1
X_4882_ _4937_/A _6700_/A _5004_/B VDD VSS sg13cmos5l_nor2_1
X_6621_ _6623_/B _6621_/A _6621_/B VDD VSS sg13cmos5l_xnor2_1
X_6552_ _6554_/B _6552_/A _6552_/B VDD VSS sg13cmos5l_xnor2_1
X_3695_ _3806_/A _3705_/B _7155_/Q VDD VSS sg13cmos5l_xnor2_1
X_5365_ _5367_/C _7080_/Q _5365_/B VDD VSS sg13cmos5l_xor2_1
X_5434_ _5438_/A _5464_/A _5462_/A VDD VSS sg13cmos5l_nor2b_1
X_5503_ _7112_/D _5525_/B _5501_/Y _5502_/Y VDD VSS sg13cmos5l_a21oi_1
X_7104_ _7104_/Q _7104_/CLK _7104_/D _7104_/RESET_B VDD VSS sg13cmos5l_dfrbpq_1
X_6483_ _6485_/B _7020_/Q _6483_/B VDD VSS sg13cmos5l_xnor2_1
XFILLER_28_636 VDD VSS sg13cmos5l_fill_1
X_4178_ _4463_/A _4178_/A _4178_/B VDD VSS sg13cmos5l_or2_1
X_4247_ _4264_/A _4248_/A _4248_/B VDD VSS sg13cmos5l_nand2_1
X_4316_ _4318_/B _4316_/A _4316_/B VDD VSS sg13cmos5l_xnor2_1
X_5296_ _5298_/B _7104_/Q _5407_/B VDD VSS sg13cmos5l_xnor2_1
X_7035_ _7035_/Q clkload5/A _7035_/D _7035_/RESET_B VDD VSS sg13cmos5l_dfrbpq_1
XFILLER_28_669 VDD VSS sg13cmos5l_fill_2
X_6819_ _6821_/B _3651_/Y _6804_/B _5845_/Y VDD VSS sg13cmos5l_o21ai_1
XFILLER_23_385 VDD VSS sg13cmos5l_fill_2
X_4032_ _4060_/B _5308_/A _4239_/A VDD VSS sg13cmos5l_nand2b_1
X_4101_ _4103_/B _4101_/A _4101_/B VDD VSS sg13cmos5l_xor2_1
X_5081_ _5081_/Y _5080_/A _5081_/B _5081_/C VDD VSS sg13cmos5l_nand3b_1
X_5150_ _5150_/Y _5150_/A _5150_/B _5150_/C VDD VSS sg13cmos5l_nor3_1
X_4934_ _4936_/B _4934_/A _4934_/B VDD VSS sg13cmos5l_xnor2_1
X_5983_ _7166_/D _5845_/A _5983_/A2 _5982_/Y VDD VSS sg13cmos5l_a21o_1
X_3747_ _3855_/A _7121_/Q _6675_/A VDD VSS sg13cmos5l_xor2_1
X_3816_ _3816_/X _7153_/Q _7152_/Q VDD VSS sg13cmos5l_xor2_1
X_4796_ _4818_/A _4796_/A _4796_/B VDD VSS sg13cmos5l_nor2_1
X_4865_ _4867_/B _4865_/A _4865_/B VDD VSS sg13cmos5l_xnor2_1
X_6604_ _6606_/C _6604_/A _6604_/B VDD VSS sg13cmos5l_xnor2_1
X_6535_ _6538_/A _6536_/A _6536_/B _6536_/C VDD VSS sg13cmos5l_a21oi_1
X_3678_ _3891_/A _7165_/Q _5845_/A VDD VSS sg13cmos5l_nand2_1
X_5348_ _5349_/C _5347_/A _5347_/B _5347_/C VDD VSS sg13cmos5l_o21ai_1
X_5417_ _5420_/A _7082_/Q _5417_/B VDD VSS sg13cmos5l_xnor2_1
X_6466_ _6476_/A _7018_/Q _6467_/B VDD VSS sg13cmos5l_nor2_1
X_6397_ _6397_/Y _6386_/A _6383_/Y _6398_/B _6374_/B _6384_/A VDD VSS sg13cmos5l_a221oi_1
XFILLER_28_444 VDD VSS sg13cmos5l_fill_1
XFILLER_28_466 VDD VSS sg13cmos5l_decap_4
XFILLER_28_488 VDD VSS sg13cmos5l_decap_8
X_5279_ _5279_/X _6205_/A _5338_/A VDD VSS sg13cmos5l_and2_1
X_7018_ _7018_/Q _7270_/CLK _7018_/D _7018_/RESET_B VDD VSS sg13cmos5l_dfrbpq_1
XFILLER_11_344 VDD VSS sg13cmos5l_fill_1
XFILLER_24_694 VDD VSS sg13cmos5l_fill_1
XFILLER_2_0 VDD VSS sg13cmos5l_fill_2
XFILLER_15_672 VDD VSS sg13cmos5l_fill_1
XFILLER_19_444 VDD VSS sg13cmos5l_fill_2
XFILLER_36_90 VDD VSS sg13cmos5l_fill_2
XFILLER_15_683 VDD VSS sg13cmos5l_fill_1
X_4581_ _4581_/Y _4569_/Y _4570_/Y _4567_/Y VDD VSS sg13cmos5l_o21ai_1
X_4650_ _4677_/B _4651_/B _4651_/C _4651_/A VDD VSS sg13cmos5l_a21oi_1
X_6320_ _6323_/B _6334_/A _6320_/B VDD VSS sg13cmos5l_or2_1
X_5133_ _5134_/C _5821_/A _5133_/B _5133_/C VDD VSS sg13cmos5l_nand3_1
X_5202_ _5226_/A _5203_/A _5203_/B _5203_/C VDD VSS sg13cmos5l_a21oi_1
X_6182_ _6189_/A _6172_/Y _6179_/X _6178_/Y VDD VSS sg13cmos5l_o21ai_1
X_6251_ _6253_/B _6251_/A _6251_/B _6270_/A VDD VSS sg13cmos5l_nand3_1
X_4015_ _4018_/B _6592_/A _4015_/B VDD VSS sg13cmos5l_xnor2_1
X_5064_ _5111_/B _7064_/Q _5111_/A _5064_/C VDD VSS sg13cmos5l_nand3_1
X_4848_ _4851_/B _4849_/B _4849_/C _4839_/Y VDD VSS sg13cmos5l_a21o_1
X_4917_ _7087_/D _4917_/A _4917_/B _4917_/C VDD VSS sg13cmos5l_and3_1
X_5897_ _7141_/D _5901_/A _5897_/B VDD VSS sg13cmos5l_nor2_1
X_5966_ _5966_/Y _5964_/Y _5965_/Y _5983_/A2 VDD VSS sg13cmos5l_a21oi_1
XFILLER_32_48 VDD VSS sg13cmos5l_fill_1
X_4779_ _4796_/B _4780_/A _4780_/B _4780_/C VDD VSS sg13cmos5l_a21oi_1
X_6518_ _6520_/B _6492_/Y _6501_/Y _6500_/X VDD VSS sg13cmos5l_o21ai_1
X_6449_ _6452_/B _6424_/B _6446_/X _6447_/Y _6446_/B _6444_/Y VDD VSS sg13cmos5l_a221oi_1
XFILLER_28_296 VDD VSS sg13cmos5l_fill_2
XFILLER_31_406 VDD VSS sg13cmos5l_decap_4
XFILLER_12_664 VDD VSS sg13cmos5l_fill_1
XFILLER_7_134 VDD VSS sg13cmos5l_fill_1
X_7062__230 _7062_/RESET_B VDD VSS sg13cmos5l_tiehi
XFILLER_22_439 VDD VSS sg13cmos5l_fill_2
X_4702_ _4703_/B _4702_/A _4702_/B _4702_/C VDD VSS sg13cmos5l_nand3_1
X_5751_ _5754_/C _5776_/A _5750_/C _7093_/Q VDD VSS sg13cmos5l_a21oi_1
X_5820_ _5820_/X _5820_/A _5821_/B VDD VSS sg13cmos5l_and2_1
X_4564_ _4579_/B _7049_/Q _4565_/B VDD VSS sg13cmos5l_nand2_1
X_4633_ _4634_/B _4633_/A _4633_/B _4633_/C VDD VSS sg13cmos5l_nand3_1
X_5682_ _5682_/Y _5684_/B _5684_/C _5684_/A VDD VSS sg13cmos5l_a21oi_1
X_7283_ _7283_/Q _7316_/CLK _7283_/D _7283_/RESET_B VDD VSS sg13cmos5l_dfrbpq_1
X_6303_ _6304_/C _6303_/A _6303_/B VDD VSS sg13cmos5l_xnor2_1
X_4495_ _7068_/D _5212_/A _4495_/B _4495_/C VDD VSS sg13cmos5l_and3_1
X_5116_ _7092_/D _5144_/B _5115_/Y VDD VSS sg13cmos5l_nor2b_1
X_6096_ _7204_/D _6023_/Y _7204_/Q _6105_/S VDD VSS sg13cmos5l_mux2_1
X_6165_ _7312_/D _7312_/Q _7280_/Q _6168_/S VDD VSS sg13cmos5l_mux2_1
X_6234_ _6234_/Y _6998_/Q _6573_/A VDD VSS sg13cmos5l_nand2_1
XFILLER_26_734 VDD VSS sg13cmos5l_fill_1
XFILLER_27_26 VDD VSS sg13cmos5l_fill_1
XFILLER_38_594 VDD VSS sg13cmos5l_fill_2
X_5047_ _5096_/A _5048_/A _5048_/B VDD VSS sg13cmos5l_nand2_1
X_6998_ _6998_/Q _7266_/CLK _6998_/D _6998_/RESET_B VDD VSS sg13cmos5l_dfrbpq_1
X_5949_ _5949_/Y _7206_/Q _5977_/B1 _5961_/B1 _7191_/Q VDD VSS sg13cmos5l_a22oi_1
XFILLER_17_712 VDD VSS sg13cmos5l_fill_2
XFILLER_16_200 VDD VSS sg13cmos5l_fill_2
XFILLER_17_767 VDD VSS sg13cmos5l_fill_1
XFILLER_32_759 VDD VSS sg13cmos5l_fill_2
XFILLER_39_325 VDD VSS sg13cmos5l_fill_2
XFILLER_4_693 VDD VSS sg13cmos5l_fill_2
X_4280_ _4282_/B _4285_/C _4281_/C VDD VSS sg13cmos5l_nor2_1
X_6921_ _6923_/A _7017_/Q _7044_/Q VDD VSS sg13cmos5l_xor2_1
X_6852_ _6853_/A _6852_/A _6852_/B _6852_/C VDD VSS sg13cmos5l_nand3_1
XFILLER_22_214 VDD VSS sg13cmos5l_fill_1
XFILLER_22_258 VDD VSS sg13cmos5l_fill_2
X_3995_ _4011_/B _5308_/A _3994_/Y _4768_/S VDD VSS sg13cmos5l_o21ai_1
X_5665_ _5695_/B _5665_/A _5665_/B VDD VSS sg13cmos5l_nor2_1
X_5734_ _5738_/A _5735_/A _5712_/B _5734_/S VDD VSS sg13cmos5l_mux2_1
X_5803_ _5803_/Y _5803_/A _5803_/B VDD VSS sg13cmos5l_nor2_1
Xfanout29 _6729_/A _3875_/X VDD VSS sg13cmos5l_buf_1
Xfanout18 _4331_/A _5579_/A VDD VSS sg13cmos5l_buf_1
X_6783_ _6799_/B _6783_/A _6783_/B VDD VSS sg13cmos5l_nand2_1
XFILLER_1_107 VDD VSS sg13cmos5l_fill_1
X_4478_ _4479_/B _4478_/A _4477_/Y VDD VSS sg13cmos5l_nor2b_1
X_4547_ _7074_/D _6563_/A _4547_/B _4547_/C VDD VSS sg13cmos5l_nor3_1
X_4616_ _4616_/Y _4616_/A _4617_/B VDD VSS sg13cmos5l_nor2_1
X_5596_ _5597_/C _5596_/A _5596_/B VDD VSS sg13cmos5l_xnor2_1
X_7266_ _7267_/D _7266_/CLK _7266_/D _6521_/A VDD VSS sg13cmos5l_dfrbpq_1
X_6079_ _7188_/D _6017_/Y _7188_/Q _6087_/S VDD VSS sg13cmos5l_mux2_1
X_6148_ _7295_/D _7295_/Q _7141_/Q _6164_/S VDD VSS sg13cmos5l_mux2_1
X_6217_ _6220_/B _6592_/B _6217_/B VDD VSS sg13cmos5l_xnor2_1
X_7197_ _7197_/Q _7298_/CLK _7197_/D _7197_/RESET_B VDD VSS sg13cmos5l_dfrbpq_1
XFILLER_14_715 VDD VSS sg13cmos5l_fill_1
XFILLER_14_737 VDD VSS sg13cmos5l_fill_2
XFILLER_14_759 VDD VSS sg13cmos5l_fill_2
XFILLER_41_545 VDD VSS sg13cmos5l_decap_8
XFILLER_13_269 VDD VSS sg13cmos5l_fill_2
XFILLER_12_280 VDD VSS sg13cmos5l_fill_1
X_3780_ _4611_/A _3824_/B _3824_/C _3824_/A VDD VSS sg13cmos5l_a21o_1
X_4332_ _4335_/A _7056_/Q _4347_/B _4330_/X VDD VSS sg13cmos5l_a21oi_1
X_4401_ _4401_/Y _4401_/A _6972_/A VDD VSS sg13cmos5l_nand2_1
X_5381_ _5384_/B _5671_/B _5381_/B VDD VSS sg13cmos5l_xnor2_1
X_5450_ _5451_/C _5450_/A _5450_/B VDD VSS sg13cmos5l_nor2_1
X_7120_ _7120_/Q clkload8/A _7120_/D _7120_/RESET_B VDD VSS sg13cmos5l_dfrbpq_1
XFILLER_39_111 VDD VSS sg13cmos5l_fill_2
X_4194_ _4460_/A _4194_/A _4194_/B _4194_/C VDD VSS sg13cmos5l_nor3_1
X_4263_ _6938_/A _4264_/A _4264_/B _4264_/C VDD VSS sg13cmos5l_a21oi_1
X_6002_ _6010_/A _7306_/Q _7290_/Q VDD VSS sg13cmos5l_nand2_1
X_7051_ _7051_/Q _7104_/CLK _7051_/D _7051_/RESET_B VDD VSS sg13cmos5l_dfrbpq_1
XFILLER_23_556 VDD VSS sg13cmos5l_fill_1
XFILLER_24_49 VDD VSS sg13cmos5l_fill_1
XFILLER_27_328 VDD VSS sg13cmos5l_fill_2
XFILLER_35_394 VDD VSS sg13cmos5l_fill_2
X_6904_ _6915_/B _6918_/A _6903_/A VDD VSS sg13cmos5l_nor2b_1
X_6835_ _6838_/A _7038_/Q _6860_/B VDD VSS sg13cmos5l_xnor2_1
XFILLER_23_589 VDD VSS sg13cmos5l_fill_1
X_3978_ _3997_/A _5351_/B _4683_/A VDD VSS sg13cmos5l_xnor2_1
X_5648_ _5680_/B _5649_/B _5649_/C _5706_/A VDD VSS sg13cmos5l_a21oi_1
X_5717_ _5741_/B _5718_/A _5718_/B _5760_/A VDD VSS sg13cmos5l_a21oi_1
X_6766_ _6766_/Y _6766_/A _6766_/B _6766_/C _6766_/D VDD VSS sg13cmos5l_nor4_1
X_6697_ _6716_/B _6696_/B _6696_/C _6765_/A VDD VSS sg13cmos5l_a21oi_1
XFILLER_2_405 VDD VSS sg13cmos5l_fill_2
X_5579_ _5580_/B _5579_/A _5579_/B VDD VSS sg13cmos5l_xnor2_1
X_7249_ _7250_/D _7266_/CLK _7249_/D _6610_/A VDD VSS sg13cmos5l_dfrbpq_1
X_7318_ _7318_/Q _7318_/CLK _7318_/D _7318_/RESET_B VDD VSS sg13cmos5l_dfrbpq_1
XFILLER_30_92 VDD VSS sg13cmos5l_fill_1
XFILLER_37_615 VDD VSS sg13cmos5l_fill_1
XFILLER_39_90 VDD VSS sg13cmos5l_fill_2
XFILLER_37_637 VDD VSS sg13cmos5l_fill_2
X_3901_ _3906_/A _6745_/B _5042_/A VDD VSS sg13cmos5l_xnor2_1
X_4881_ _6722_/A _6303_/A _6700_/B VDD VSS sg13cmos5l_nand2_1
X_4950_ _4951_/B _4950_/A _4950_/B VDD VSS sg13cmos5l_xnor2_1
XFILLER_32_397 VDD VSS sg13cmos5l_decap_8
XFILLER_9_571 VDD VSS sg13cmos5l_fill_2
X_3694_ _3699_/B _3705_/B _7155_/Q VDD VSS sg13cmos5l_nand2_1
X_3763_ _3768_/B _3763_/A _3763_/B _3763_/C VDD VSS sg13cmos5l_and3_1
X_3832_ _3857_/A _5613_/A _5596_/B _3829_/Y _3830_/Y VDD VSS sg13cmos5l_a22oi_1
X_5502_ _5502_/Y _5525_/B _5501_/Y _5528_/A VDD VSS sg13cmos5l_o21ai_1
X_6620_ _6645_/A _6621_/B _6621_/A VDD VSS sg13cmos5l_nand2b_1
X_6551_ _6579_/A _6552_/B _6552_/A VDD VSS sg13cmos5l_nand2b_1
X_6482_ _6497_/B _7020_/Q _6483_/B VDD VSS sg13cmos5l_nand2_1
X_4315_ _4316_/B _4315_/A _4092_/C VDD VSS sg13cmos5l_nor2b_1
X_5295_ _5315_/A _7104_/Q _5407_/B VDD VSS sg13cmos5l_nor2_1
X_5364_ _5397_/B _7080_/Q _5364_/B VDD VSS sg13cmos5l_nand2_1
X_5433_ _5462_/A _5536_/A _5435_/B _5433_/C VDD VSS sg13cmos5l_or3_1
X_7103_ _7103_/Q _7103_/CLK _7103_/D _7103_/RESET_B VDD VSS sg13cmos5l_dfrbpq_1
XFILLER_19_49 VDD VSS sg13cmos5l_fill_1
XFILLER_28_604 VDD VSS sg13cmos5l_fill_2
XFILLER_28_626 VDD VSS sg13cmos5l_fill_1
XFILLER_28_648 VDD VSS sg13cmos5l_decap_8
X_4177_ _4178_/B _4176_/B _4176_/C _4176_/A VDD VSS sg13cmos5l_a21oi_1
X_4246_ _4248_/B _7048_/Q _4561_/B VDD VSS sg13cmos5l_xnor2_1
X_7034_ _7034_/Q clkload5/A _7034_/D _7034_/RESET_B VDD VSS sg13cmos5l_dfrbpq_1
XFILLER_11_548 VDD VSS sg13cmos5l_fill_2
XFILLER_36_681 VDD VSS sg13cmos5l_fill_2
X_6818_ _6821_/A _7037_/Q _6860_/B VDD VSS sg13cmos5l_xnor2_1
X_6749_ _6750_/B _6749_/A _6749_/B VDD VSS sg13cmos5l_xnor2_1
XFILLER_34_629 VDD VSS sg13cmos5l_fill_1
X_7247__438 _7247_/RESET_B VDD VSS sg13cmos5l_tiehi
XFILLER_37_401 VDD VSS sg13cmos5l_decap_4
XFILLER_37_445 VDD VSS sg13cmos5l_fill_1
X_4031_ _4072_/A _5308_/A _4239_/A VDD VSS sg13cmos5l_nor2b_1
X_4100_ _4113_/A _4101_/A _4101_/B VDD VSS sg13cmos5l_nor2_1
X_5080_ _5114_/A _5080_/A _5080_/B VDD VSS sg13cmos5l_nor2_1
XFILLER_32_183 VDD VSS sg13cmos5l_fill_2
X_4864_ _4865_/B _5549_/A _4864_/B VDD VSS sg13cmos5l_xnor2_1
X_4933_ _4934_/B _4933_/A _4933_/B VDD VSS sg13cmos5l_xnor2_1
X_5982_ _5982_/Y _5980_/Y _5981_/Y _5983_/A2 VDD VSS sg13cmos5l_a21oi_1
XFILLER_32_194 VDD VSS sg13cmos5l_fill_2
X_3677_ _3846_/B _5159_/A _7124_/Q VDD VSS sg13cmos5l_and2_1
X_3746_ _3836_/A _7121_/Q _6675_/A VDD VSS sg13cmos5l_nor2_1
X_3815_ _6177_/A _4235_/A VDD VSS sg13cmos5l_inv_1
X_4795_ _4823_/A _7084_/Q _4784_/B _4782_/X VDD VSS sg13cmos5l_a21oi_1
X_5416_ _5417_/B _5416_/A _5415_/Y VDD VSS sg13cmos5l_nor2b_1
X_6603_ _6624_/B _6604_/A _6604_/B VDD VSS sg13cmos5l_or2_1
X_6534_ _6536_/C _6996_/Q _6534_/B VDD VSS sg13cmos5l_xnor2_1
X_6465_ _7017_/D _6461_/Y _6463_/Y _6464_/Y VDD VSS sg13cmos5l_a21oi_1
X_4229_ _4233_/A _4230_/A _4230_/B VDD VSS sg13cmos5l_nand2b_1
X_5278_ _5283_/A _7102_/Q _5268_/B _5266_/X VDD VSS sg13cmos5l_a21o_1
X_5347_ _5349_/B _5347_/A _5347_/B _5347_/C VDD VSS sg13cmos5l_or3_1
X_7017_ _7017_/Q clkload7/A _7017_/D _7017_/RESET_B VDD VSS sg13cmos5l_dfrbpq_1
X_6396_ _6398_/B _6396_/A _6396_/B VDD VSS sg13cmos5l_nor2_1
XFILLER_28_434 VDD VSS sg13cmos5l_fill_1
X_7049__256 _7049_/RESET_B VDD VSS sg13cmos5l_tiehi
XFILLER_30_676 VDD VSS sg13cmos5l_fill_2
X_4580_ _4580_/Y _4580_/A _4579_/Y VDD VSS sg13cmos5l_nor2b_1
XFILLER_28_0 VDD VSS sg13cmos5l_fill_2
XFILLER_29_209 VDD VSS sg13cmos5l_fill_1
X_5132_ _5134_/B _5133_/B _5133_/C _5821_/A VDD VSS sg13cmos5l_a21o_1
X_5201_ _5203_/C _7069_/Q _5201_/B VDD VSS sg13cmos5l_xnor2_1
X_6181_ _6992_/D _6172_/Y _6179_/X _6180_/Y VDD VSS sg13cmos5l_a21oi_1
X_6250_ _6270_/A _6250_/A _6250_/B VDD VSS sg13cmos5l_xor2_1
XFILLER_37_264 VDD VSS sg13cmos5l_fill_2
X_4014_ _4018_/A _6633_/B _4028_/B _4012_/Y VDD VSS sg13cmos5l_a21oi_1
X_5063_ _5064_/C _5082_/B _5062_/C _5062_/A VDD VSS sg13cmos5l_o21ai_1
XFILLER_33_470 VDD VSS sg13cmos5l_decap_8
XFILLER_33_492 VDD VSS sg13cmos5l_decap_4
X_4847_ _4847_/Y _4849_/B _4849_/C _4846_/A VDD VSS sg13cmos5l_a21oi_1
X_4916_ _4917_/C _4915_/A _4915_/B _4915_/C VDD VSS sg13cmos5l_o21ai_1
X_5896_ _5897_/B _7141_/Q _5896_/A2 _5896_/B1 _7140_/Q VDD VSS sg13cmos5l_a22oi_1
X_5965_ _5965_/Y _7225_/Q _5981_/A2 _5980_/B1 _7210_/Q VDD VSS sg13cmos5l_a22oi_1
X_3729_ _3730_/A _3729_/A _3729_/B VDD VSS sg13cmos5l_nor2_1
X_4778_ _4780_/C _4778_/A _4778_/B VDD VSS sg13cmos5l_xor2_1
X_6517_ _6520_/A _6517_/A _6517_/B VDD VSS sg13cmos5l_xnor2_1
X_6448_ _6448_/Y _6424_/B _6446_/X _6447_/Y _6446_/B VDD VSS sg13cmos5l_a22oi_1
X_6379_ _6381_/B _7010_/Q _6428_/A VDD VSS sg13cmos5l_xnor2_1
XFILLER_16_459 VDD VSS sg13cmos5l_fill_1
XFILLER_8_625 VDD VSS sg13cmos5l_fill_1
XFILLER_34_201 VDD VSS sg13cmos5l_fill_1
XFILLER_35_713 VDD VSS sg13cmos5l_fill_2
XFILLER_35_735 VDD VSS sg13cmos5l_fill_2
XFILLER_15_481 VDD VSS sg13cmos5l_fill_2
X_4632_ _4705_/A _4633_/A _4633_/B _4633_/C VDD VSS sg13cmos5l_a21oi_1
X_4701_ _4755_/A _4702_/A _4702_/B _4702_/C VDD VSS sg13cmos5l_a21oi_1
X_5681_ _5684_/C _5680_/A _5680_/B _5706_/B VDD VSS sg13cmos5l_o21ai_1
X_5750_ _5776_/B _7093_/Q _5776_/A _5750_/C VDD VSS sg13cmos5l_nand3_1
X_4494_ _4495_/C _4493_/B _4494_/B VDD VSS sg13cmos5l_nand2b_1
X_4563_ _4565_/B _4563_/A _4563_/B VDD VSS sg13cmos5l_xor2_1
X_6233_ _6997_/D _6610_/A _6233_/B _6240_/B VDD VSS sg13cmos5l_and3_1
X_7282_ _7282_/Q _7316_/CLK _7282_/D _7282_/RESET_B VDD VSS sg13cmos5l_dfrbpq_1
X_6302_ _6303_/B _7004_/Q _6707_/A VDD VSS sg13cmos5l_xnor2_1
X_5046_ _5048_/B _5046_/A _5046_/B VDD VSS sg13cmos5l_xnor2_1
X_5115_ _5115_/Y _5114_/A _5176_/A _6977_/A VDD VSS sg13cmos5l_a21oi_1
X_6095_ _7203_/D _6017_/Y _7203_/Q _6105_/S VDD VSS sg13cmos5l_mux2_1
X_6164_ _7311_/D _7311_/Q _7279_/Q _6164_/S VDD VSS sg13cmos5l_mux2_1
XFILLER_13_429 VDD VSS sg13cmos5l_fill_1
X_5948_ _5948_/Y _7221_/Q _5921_/B _5969_/A2 _7176_/Q VDD VSS sg13cmos5l_a22oi_1
X_6997_ _6997_/Q _7266_/CLK _6997_/D _6997_/RESET_B VDD VSS sg13cmos5l_dfrbpq_1
XFILLER_21_440 VDD VSS sg13cmos5l_fill_2
X_5879_ _5880_/B _7132_/Q _5875_/B _5902_/B1 _5858_/A VDD VSS sg13cmos5l_a22oi_1
XFILLER_4_127 VDD VSS sg13cmos5l_fill_1
XFILLER_17_702 VDD VSS sg13cmos5l_fill_2
XFILLER_16_245 VDD VSS sg13cmos5l_fill_1
XFILLER_31_237 VDD VSS sg13cmos5l_fill_1
XFILLER_8_444 VDD VSS sg13cmos5l_fill_2
X_5802_ _5802_/X _5810_/A _5809_/A VDD VSS sg13cmos5l_or2_1
Xfanout19 _5579_/A _5652_/A VDD VSS sg13cmos5l_buf_1
X_6920_ _6924_/A _7016_/Q _6910_/B _6908_/Y VDD VSS sg13cmos5l_a21oi_1
X_6851_ _6852_/C _7012_/Q _6851_/B VDD VSS sg13cmos5l_xnor2_1
XFILLER_13_29 VDD VSS sg13cmos5l_fill_1
X_3994_ _3994_/Y _4647_/A VDD VSS sg13cmos5l_inv_1
X_4615_ _4617_/B _4647_/A _4647_/B VDD VSS sg13cmos5l_xnor2_1
X_5595_ _5636_/A _5596_/A _5595_/B VDD VSS sg13cmos5l_nand2_1
X_5664_ _5666_/B _5665_/A _5665_/B VDD VSS sg13cmos5l_and2_1
X_5733_ _5747_/A _7119_/Q _5722_/B _5720_/X VDD VSS sg13cmos5l_a21oi_1
X_6782_ _6784_/B _6783_/A _6831_/A VDD VSS sg13cmos5l_nand2b_1
X_4477_ _4477_/Y _4477_/A _4477_/B _4477_/C VDD VSS sg13cmos5l_nand3_1
X_4546_ _4547_/C _4546_/A _4546_/B VDD VSS sg13cmos5l_nor2_1
X_6216_ _6217_/B _6996_/Q _6216_/B VDD VSS sg13cmos5l_xnor2_1
X_7265_ _7266_/D _7270_/CLK _7265_/D _6932_/B1 VDD VSS sg13cmos5l_dfrbpq_1
X_7196_ _7196_/Q _7298_/CLK _7196_/D _7196_/RESET_B VDD VSS sg13cmos5l_dfrbpq_1
X_5029_ _5076_/B _5030_/B _5029_/B VDD VSS sg13cmos5l_nor2_1
X_6078_ _7187_/D _6011_/Y _7187_/Q _6087_/S VDD VSS sg13cmos5l_mux2_1
X_6147_ _7294_/D _7294_/Q _7140_/Q _6161_/S VDD VSS sg13cmos5l_mux2_1
XFILLER_41_502 VDD VSS sg13cmos5l_fill_2
XFILLER_41_513 VDD VSS sg13cmos5l_fill_2
XFILLER_9_219 VDD VSS sg13cmos5l_fill_2
X_4262_ _4264_/C _7022_/Q _4262_/B VDD VSS sg13cmos5l_xnor2_1
X_4331_ _4347_/B _4331_/A _4331_/B VDD VSS sg13cmos5l_xnor2_1
X_4400_ _4400_/Y _4339_/Y _4351_/Y _4338_/Y VDD VSS sg13cmos5l_a21oi_1
X_5380_ _5536_/A _5380_/A _5381_/B VDD VSS sg13cmos5l_nand2_1
X_7050_ _7050_/Q _7103_/CLK _7050_/D _7050_/RESET_B VDD VSS sg13cmos5l_dfrbpq_1
X_4193_ _4194_/C _4193_/A _4193_/B VDD VSS sg13cmos5l_and2_1
X_6001_ _7170_/D _7170_/Q _6000_/X _6074_/S VDD VSS sg13cmos5l_mux2_1
X_7296__412 _7296_/RESET_B VDD VSS sg13cmos5l_tiehi
XFILLER_23_513 VDD VSS sg13cmos5l_fill_1
X_3977_ _3990_/A _6633_/A _3977_/B VDD VSS sg13cmos5l_xnor2_1
X_6903_ _6905_/B _6903_/A _6918_/A VDD VSS sg13cmos5l_nor2b_1
X_6834_ _6871_/A _6783_/A _6831_/Y _6833_/Y VDD VSS sg13cmos5l_a21oi_1
X_6765_ _6765_/X _6765_/A _6765_/B _6765_/C VDD VSS sg13cmos5l_or3_1
X_5578_ _5578_/Y _5612_/A _5579_/B VDD VSS sg13cmos5l_nor2_1
X_5647_ _5649_/C _5647_/A VDD VSS sg13cmos5l_inv_1
X_5716_ _5760_/A _5716_/A _5716_/B VDD VSS sg13cmos5l_xor2_1
X_6696_ _6698_/B _6765_/A _6696_/B _6696_/C VDD VSS sg13cmos5l_and3_1
X_4529_ _4530_/B _4529_/A _4529_/B VDD VSS sg13cmos5l_xnor2_1
X_7248_ _7248_/Q _7270_/CLK _7248_/D _6932_/B1 VDD VSS sg13cmos5l_dfrbpq_1
X_7317_ _7317_/Q _7318_/CLK _7317_/D _7317_/RESET_B VDD VSS sg13cmos5l_dfrbpq_1
X_7179_ _7179_/Q _7224_/CLK _7179_/D _7179_/RESET_B VDD VSS sg13cmos5l_dfrbpq_1
XFILLER_1_494 VDD VSS sg13cmos5l_fill_2
XFILLER_37_649 VDD VSS sg13cmos5l_fill_2
X_7098__296 _7098_/RESET_B VDD VSS sg13cmos5l_tiehi
X_7059__236 _7059_/RESET_B VDD VSS sg13cmos5l_tiehi
X_3831_ _3831_/Y _7116_/Q _6633_/B VDD VSS sg13cmos5l_xnor2_1
X_3900_ _5042_/A _5845_/A _3898_/B _4154_/B VDD VSS sg13cmos5l_a21oi_1
X_4880_ _4893_/A _4851_/A _4847_/Y _4846_/Y VDD VSS sg13cmos5l_o21ai_1
XFILLER_20_527 VDD VSS sg13cmos5l_fill_2
X_3693_ _3810_/B _7154_/Q _7152_/Q _7153_/Q VDD VSS sg13cmos5l_o21ai_1
X_3762_ _3836_/D _7119_/Q _6700_/B VDD VSS sg13cmos5l_xnor2_1
X_5432_ _5464_/A _5537_/A _5436_/B _5431_/X VDD VSS sg13cmos5l_a21oi_1
X_5501_ _5501_/Y _5501_/A _5501_/B VDD VSS sg13cmos5l_nor2_1
X_6550_ _6552_/B _7024_/Q _6550_/B VDD VSS sg13cmos5l_xnor2_1
X_6481_ _6485_/A _4256_/A _4236_/Y _4234_/Y VDD VSS sg13cmos5l_o21ai_1
X_4245_ _4248_/A _3656_/Y _4236_/Y _4234_/Y VDD VSS sg13cmos5l_o21ai_1
X_4314_ _4325_/B _4294_/B _4294_/C _7032_/Q VDD VSS sg13cmos5l_a21oi_1
X_5294_ _5407_/B _5535_/B _5294_/B VDD VSS sg13cmos5l_xnor2_1
X_5363_ _5364_/B _5365_/B VDD VSS sg13cmos5l_inv_1
X_7102_ _7102_/Q _7103_/CLK _7102_/D _7102_/RESET_B VDD VSS sg13cmos5l_dfrbpq_1
X_7033_ _7033_/Q _7224_/CLK _7033_/D _7033_/RESET_B VDD VSS sg13cmos5l_dfrbpq_1
X_4176_ _4176_/Y _4176_/A _4176_/B _4176_/C VDD VSS sg13cmos5l_nand3_1
X_6817_ _7036_/D _6905_/A _6817_/B _6827_/B VDD VSS sg13cmos5l_nor3_1
X_6748_ _6748_/Y _6747_/A _6747_/B _6749_/A VDD VSS sg13cmos5l_o21ai_1
XFILLER_2_203 VDD VSS sg13cmos5l_fill_2
X_6679_ _6681_/B _6703_/A _6703_/B VDD VSS sg13cmos5l_xor2_1
XFILLER_26_192 VDD VSS sg13cmos5l_fill_2
XFILLER_6_531 VDD VSS sg13cmos5l_fill_1
X_7286__422 _7286_/RESET_B VDD VSS sg13cmos5l_tiehi
XFILLER_37_5 VDD VSS sg13cmos5l_fill_2
XFILLER_24_107 VDD VSS sg13cmos5l_fill_1
XFILLER_37_424 VDD VSS sg13cmos5l_fill_2
X_4030_ _4367_/B _4030_/A _4030_/B _4030_/C VDD VSS sg13cmos5l_nand3_1
X_5981_ _5981_/Y _7229_/Q _5981_/A2 _5981_/B1 _7199_/Q VDD VSS sg13cmos5l_a22oi_1
X_7293__415 _7293_/RESET_B VDD VSS sg13cmos5l_tiehi
XFILLER_20_335 VDD VSS sg13cmos5l_fill_2
XFILLER_24_129 VDD VSS sg13cmos5l_fill_1
XFILLER_32_151 VDD VSS sg13cmos5l_fill_2
X_3814_ _3814_/Y _3810_/B _3812_/X _3813_/X VDD VSS sg13cmos5l_o21ai_1
X_4794_ _4827_/A _7057_/Q _4787_/B _4785_/Y VDD VSS sg13cmos5l_a21oi_1
X_4863_ _4863_/Y _4863_/A _4864_/B VDD VSS sg13cmos5l_nand2_1
X_4932_ _4932_/Y _4933_/A _4933_/B VDD VSS sg13cmos5l_nor2b_1
X_6602_ _6604_/B _6602_/A _6602_/B VDD VSS sg13cmos5l_xor2_1
X_3676_ _3846_/A _3676_/A VDD VSS sg13cmos5l_inv_1
X_3745_ _6288_/A _6745_/B VDD VSS sg13cmos5l_inv_1
X_5415_ _5415_/Y _5415_/A _5415_/B _5415_/C VDD VSS sg13cmos5l_nand3_1
X_6533_ _6556_/B _6996_/Q _6534_/B VDD VSS sg13cmos5l_nand2_1
X_6464_ _6464_/Y _6461_/Y _6463_/Y _6436_/A VDD VSS sg13cmos5l_o21ai_1
X_6395_ _6395_/Y _6393_/Y _6395_/B VDD VSS sg13cmos5l_nand2b_1
X_4228_ _4230_/B _7049_/Q _4574_/B VDD VSS sg13cmos5l_xnor2_1
X_5277_ _5372_/A _5263_/Y _5274_/Y _5273_/X VDD VSS sg13cmos5l_o21ai_1
X_5346_ _5347_/C _5346_/A _5346_/B VDD VSS sg13cmos5l_xnor2_1
X_7016_ _7016_/Q clkload7/A _7016_/D _7016_/RESET_B VDD VSS sg13cmos5l_dfrbpq_1
XFILLER_24_652 VDD VSS sg13cmos5l_decap_8
X_4159_ _4161_/B _7066_/Q _4159_/B VDD VSS sg13cmos5l_xnor2_1
XFILLER_19_446 VDD VSS sg13cmos5l_fill_1
XFILLER_34_405 VDD VSS sg13cmos5l_fill_2
XFILLER_36_92 VDD VSS sg13cmos5l_fill_1
X_7095__299 _7095_/RESET_B VDD VSS sg13cmos5l_tiehi
X_4013_ _4028_/B _4013_/A _4013_/B VDD VSS sg13cmos5l_xor2_1
X_5062_ _5111_/A _5062_/A _5082_/B _5062_/C VDD VSS sg13cmos5l_or3_1
X_5131_ _5131_/Y _5133_/B _5133_/C _5821_/A VDD VSS sg13cmos5l_a21oi_1
X_5200_ _5201_/B _5200_/A _5200_/B VDD VSS sg13cmos5l_xor2_1
X_6180_ _6180_/Y _6172_/Y _6179_/X _6584_/B1 VDD VSS sg13cmos5l_o21ai_1
Xclkbuf_leaf_17_sd_clk _7238_/CLK clkload1/A VDD VSS sg13cmos5l_buf_8
XFILLER_25_449 VDD VSS sg13cmos5l_decap_4
X_5964_ _5964_/Y _7180_/Q _5969_/A2 _5981_/B1 _7195_/Q VDD VSS sg13cmos5l_a22oi_1
X_4777_ _4796_/A _4778_/A _4778_/B VDD VSS sg13cmos5l_nor2b_1
X_4846_ _4846_/Y _4846_/A _4849_/B _4849_/C VDD VSS sg13cmos5l_nand3_1
X_4915_ _4917_/B _4915_/A _4915_/B _4915_/C VDD VSS sg13cmos5l_or3_1
X_5895_ _7140_/D _5907_/A _5895_/B VDD VSS sg13cmos5l_nor2_1
X_6516_ _6516_/Y _6517_/B VDD VSS sg13cmos5l_inv_1
X_3659_ _4372_/A _7054_/Q VDD VSS sg13cmos5l_inv_1
X_3728_ _3728_/Y _7164_/Q _7162_/Q _7163_/Q VDD VSS sg13cmos5l_o21ai_1
X_5329_ _5355_/A _6565_/A _6565_/B _5354_/B VDD VSS sg13cmos5l_a21oi_1
X_6447_ _6447_/Y _6424_/A _6447_/B VDD VSS sg13cmos5l_nand2b_1
X_6378_ _6394_/A _7010_/Q _6415_/B VDD VSS sg13cmos5l_nand2_1
XFILLER_28_254 VDD VSS sg13cmos5l_fill_2
XFILLER_28_265 VDD VSS sg13cmos5l_fill_2
XFILLER_29_755 VDD VSS sg13cmos5l_fill_2
X_7276__432 _7276_/RESET_B VDD VSS sg13cmos5l_tiehi
XFILLER_11_132 VDD VSS sg13cmos5l_fill_1
XFILLER_16_416 VDD VSS sg13cmos5l_fill_2
XFILLER_28_276 VDD VSS sg13cmos5l_fill_2
XFILLER_28_298 VDD VSS sg13cmos5l_fill_1
X_7283__425 _7283_/RESET_B VDD VSS sg13cmos5l_tiehi
XFILLER_19_210 VDD VSS sg13cmos5l_fill_2
X_7290__418 _7290_/RESET_B VDD VSS sg13cmos5l_tiehi
XFILLER_30_463 VDD VSS sg13cmos5l_decap_4
X_4631_ _4633_/C _7053_/Q _4631_/B VDD VSS sg13cmos5l_xnor2_1
X_4700_ _4702_/C _4700_/A _4700_/B VDD VSS sg13cmos5l_xnor2_1
X_5680_ _5684_/B _5680_/A _5680_/B _5706_/B VDD VSS sg13cmos5l_or3_1
Xclkbuf_leaf_4_sd_clk clkload5/A clkload0/A VDD VSS sg13cmos5l_buf_8
XFILLER_40_0 VDD VSS sg13cmos5l_fill_1
X_4493_ _4495_/B _4494_/B _4493_/B VDD VSS sg13cmos5l_nand2b_1
X_4562_ _4579_/A _4563_/A _4563_/B VDD VSS sg13cmos5l_nand2_1
X_6232_ _6240_/B _6232_/A _6232_/B _6232_/C VDD VSS sg13cmos5l_or3_1
X_7281_ _7281_/Q _7316_/CLK _7281_/D _7281_/RESET_B VDD VSS sg13cmos5l_dfrbpq_1
X_6301_ _6301_/Y _7004_/Q _6707_/A VDD VSS sg13cmos5l_nand2_1
X_5045_ _5046_/B _5045_/A _5045_/B VDD VSS sg13cmos5l_xor2_1
X_5114_ _5144_/B _5114_/A _5176_/A VDD VSS sg13cmos5l_nor2_1
X_6094_ _7202_/D _6011_/Y _7202_/Q _6105_/S VDD VSS sg13cmos5l_mux2_1
X_6163_ _7310_/D _7310_/Q _7278_/Q _7126_/D VDD VSS sg13cmos5l_mux2_1
XFILLER_25_235 VDD VSS sg13cmos5l_fill_2
XFILLER_25_257 VDD VSS sg13cmos5l_fill_2
XFILLER_38_585 VDD VSS sg13cmos5l_fill_1
X_5947_ _7157_/D _7157_/Q _5943_/S _5946_/Y VDD VSS sg13cmos5l_a21o_1
X_6996_ _6996_/Q _7266_/CLK _6996_/D _6996_/RESET_B VDD VSS sg13cmos5l_dfrbpq_1
X_4829_ _4829_/Y _4873_/B _4828_/Y _4917_/A VDD VSS sg13cmos5l_o21ai_1
X_5878_ _7131_/D _5860_/B _5867_/Y _5875_/X _5856_/A _5907_/A VDD VSS sg13cmos5l_a221oi_1
XFILLER_17_714 VDD VSS sg13cmos5l_fill_1
XFILLER_29_541 VDD VSS sg13cmos5l_fill_2
XFILLER_29_552 VDD VSS sg13cmos5l_fill_1
XFILLER_33_71 VDD VSS sg13cmos5l_fill_2
X_7133__255 _7133_/RESET_B VDD VSS sg13cmos5l_tiehi
XFILLER_35_577 VDD VSS sg13cmos5l_fill_1
X_3993_ _4647_/A _6565_/C _6196_/A VDD VSS sg13cmos5l_xnor2_1
X_5732_ _5754_/A _7092_/Q _5725_/B _5723_/Y VDD VSS sg13cmos5l_a21oi_1
X_5801_ _5809_/A _5826_/B _5800_/C _5800_/A VDD VSS sg13cmos5l_a21oi_1
X_6850_ _6850_/Y _7012_/Q _6851_/B VDD VSS sg13cmos5l_nand2_1
X_6781_ _6783_/B _6831_/A VDD VSS sg13cmos5l_inv_1
X_4545_ _4547_/B _4546_/A _4546_/B VDD VSS sg13cmos5l_and2_1
X_4614_ _4648_/A _4647_/A _4647_/B VDD VSS sg13cmos5l_nand2_1
X_5594_ _5603_/A _5637_/A _5571_/B _5569_/Y VDD VSS sg13cmos5l_a21oi_1
X_5663_ _5665_/B _5588_/A _5698_/B _5700_/B VDD VSS sg13cmos5l_a21oi_1
X_4476_ _4478_/A _4477_/A _4477_/B _4477_/C VDD VSS sg13cmos5l_a21oi_1
X_6146_ _7293_/D _7293_/Q _7139_/Q _6161_/S VDD VSS sg13cmos5l_mux2_1
X_6215_ _6215_/Y _6996_/Q _6573_/A VDD VSS sg13cmos5l_nand2_1
X_7264_ _7265_/D _7270_/CLK _7264_/D _6930_/A VDD VSS sg13cmos5l_dfrbpq_1
X_7195_ _7195_/Q _7298_/CLK _7195_/D _7195_/RESET_B VDD VSS sg13cmos5l_dfrbpq_1
X_5028_ _5029_/B _5028_/A _5030_/C VDD VSS sg13cmos5l_nor2_1
X_6077_ _7186_/D _6006_/X _7186_/Q _6087_/S VDD VSS sg13cmos5l_mux2_1
X_7273__435 _7273_/RESET_B VDD VSS sg13cmos5l_tiehi
XFILLER_22_783 VDD VSS sg13cmos5l_fill_1
XFILLER_26_599 VDD VSS sg13cmos5l_decap_4
XFILLER_41_525 VDD VSS sg13cmos5l_fill_2
X_6979_ _6979_/Y _4446_/Y _6978_/X _6985_/A VDD VSS sg13cmos5l_o21ai_1
XFILLER_5_404 VDD VSS sg13cmos5l_fill_2
X_7280__428 _7280_/RESET_B VDD VSS sg13cmos5l_tiehi
XFILLER_9_787 VDD VSS sg13cmos5l_fill_1
X_4261_ _4266_/A _4259_/Y _4260_/X _4251_/Y VDD VSS sg13cmos5l_a21oi_1
X_4330_ _4330_/X _6216_/B _4331_/B VDD VSS sg13cmos5l_and2_1
X_6000_ _6000_/X _6000_/A _6000_/B VDD VSS sg13cmos5l_xor2_1
X_4192_ _4193_/B _7037_/Q _4193_/A _4192_/C VDD VSS sg13cmos5l_nand3_1
X_6902_ _6903_/A _6871_/A _6898_/X _6901_/Y VDD VSS sg13cmos5l_o21ai_1
X_3976_ _4092_/C _3976_/A _3976_/B VDD VSS sg13cmos5l_nand2_1
X_5715_ _5741_/A _5715_/A _5715_/B _5716_/B VDD VSS sg13cmos5l_nor3_1
X_6833_ _6833_/Y _6812_/Y _6831_/C _6832_/Y VDD VSS sg13cmos5l_o21ai_1
X_6764_ _6764_/Y _6766_/B _6766_/C _6766_/D VDD VSS sg13cmos5l_nor3_1
X_6695_ _6696_/C _6766_/A VDD VSS sg13cmos5l_inv_1
X_4528_ _4529_/B _7070_/Q _4468_/Y _4470_/B VDD VSS sg13cmos5l_a21oi_1
X_5577_ _5579_/B _5577_/A _5644_/A VDD VSS sg13cmos5l_xnor2_1
X_5646_ _5647_/A _5608_/A _5606_/A _5605_/Y VDD VSS sg13cmos5l_o21ai_1
X_7316_ _7316_/Q _7316_/CLK _7316_/D _7316_/RESET_B VDD VSS sg13cmos5l_dfrbpq_1
X_4459_ _6990_/B _4463_/B _6989_/A VDD VSS sg13cmos5l_nor2b_1
X_6129_ _7276_/D _7276_/Q _7138_/Q _6132_/S VDD VSS sg13cmos5l_mux2_1
X_7247_ _7247_/Q clkload7/A _7247_/D _7247_/RESET_B VDD VSS sg13cmos5l_dfrbpq_1
X_7178_ _7178_/Q _7220_/CLK _7178_/D _7178_/RESET_B VDD VSS sg13cmos5l_dfrbpq_1
XFILLER_14_525 VDD VSS sg13cmos5l_fill_2
XFILLER_26_330 VDD VSS sg13cmos5l_fill_2
XFILLER_41_333 VDD VSS sg13cmos5l_fill_2
XFILLER_17_330 VDD VSS sg13cmos5l_fill_1
XFILLER_37_639 VDD VSS sg13cmos5l_fill_1
XFILLER_39_92 VDD VSS sg13cmos5l_fill_1
XFILLER_17_385 VDD VSS sg13cmos5l_fill_1
XFILLER_20_506 VDD VSS sg13cmos5l_decap_4
X_3761_ _3854_/A _7119_/Q _6633_/A VDD VSS sg13cmos5l_xnor2_1
X_3830_ _3830_/Y _7116_/Q _6633_/B _5308_/B _7115_/Q VDD VSS sg13cmos5l_a22oi_1
X_3692_ _3810_/A _7155_/Q _7154_/Q VDD VSS sg13cmos5l_xnor2_1
X_5362_ _5365_/B _5362_/A _5362_/B VDD VSS sg13cmos5l_xor2_1
X_5431_ _5431_/X _5431_/A _5433_/C VDD VSS sg13cmos5l_xor2_1
X_5500_ _5525_/B _5500_/A _5500_/B VDD VSS sg13cmos5l_nand2_1
X_6480_ _7019_/D _6480_/A _6480_/B _6480_/C VDD VSS sg13cmos5l_nor3_1
X_4175_ _4178_/A _4176_/A _4176_/B _4176_/C VDD VSS sg13cmos5l_and3_1
X_4244_ _4260_/A _7020_/Q _4254_/B _4242_/Y VDD VSS sg13cmos5l_a21oi_1
X_4313_ _4313_/Y _4328_/A _4401_/A VDD VSS sg13cmos5l_nand2_1
X_5293_ _5310_/A _5534_/B _5294_/B VDD VSS sg13cmos5l_nand2_1
X_7101_ _7101_/Q _7103_/CLK _7101_/D _7101_/RESET_B VDD VSS sg13cmos5l_dfrbpq_1
X_7032_ _7032_/Q _7224_/CLK _7032_/D _7032_/RESET_B VDD VSS sg13cmos5l_dfrbpq_1
XFILLER_35_39 VDD VSS sg13cmos5l_fill_2
X_3959_ _4683_/A _6592_/B _6612_/B VDD VSS sg13cmos5l_xnor2_1
X_6816_ _6827_/B _6816_/A _6816_/B VDD VSS sg13cmos5l_nor2_1
X_6747_ _6749_/B _6747_/A _6747_/B VDD VSS sg13cmos5l_nor2_1
X_6678_ _6703_/B _6659_/Y _6661_/B _6657_/X VDD VSS sg13cmos5l_o21ai_1
X_5629_ _5629_/Y _5588_/A _5588_/B _5585_/Y VDD VSS sg13cmos5l_a21oi_1
XFILLER_19_617 VDD VSS sg13cmos5l_fill_2
X_7197__196 _7197_/RESET_B VDD VSS sg13cmos5l_tiehi
XFILLER_27_661 VDD VSS sg13cmos5l_fill_2
XFILLER_27_694 VDD VSS sg13cmos5l_fill_2
X_4931_ _4933_/B _4931_/A _4931_/B VDD VSS sg13cmos5l_xnor2_1
X_5980_ _5980_/Y _7184_/Q _5980_/A2 _5980_/B1 _7214_/Q VDD VSS sg13cmos5l_a22oi_1
X_7037__343 _7037_/RESET_B VDD VSS sg13cmos5l_tiehi
X_3744_ _3744_/X _3744_/A _3744_/B VDD VSS sg13cmos5l_xor2_1
X_3813_ _3813_/X _7154_/Q _7153_/Q VDD VSS sg13cmos5l_or2_1
X_4793_ _7084_/D _4791_/A _4873_/A _4792_/Y VDD VSS sg13cmos5l_a21oi_1
X_4862_ _4864_/B _4862_/A _4862_/B VDD VSS sg13cmos5l_xor2_1
X_6601_ _6624_/A _6602_/B _6602_/A VDD VSS sg13cmos5l_nand2b_1
X_6532_ _6534_/B _6532_/A _6532_/B VDD VSS sg13cmos5l_xnor2_1
X_3675_ _3676_/A _5159_/A _7125_/Q VDD VSS sg13cmos5l_xnor2_1
X_5345_ _5345_/Y _5344_/A _5344_/B _5346_/B VDD VSS sg13cmos5l_a21oi_1
X_5414_ _5416_/A _5415_/A _5415_/B _5415_/C VDD VSS sg13cmos5l_a21oi_1
X_6463_ _6463_/Y _7017_/Q _6463_/B VDD VSS sg13cmos5l_xnor2_1
X_6394_ _6395_/B _6394_/A _6394_/B _6394_/C VDD VSS sg13cmos5l_nand3_1
XFILLER_28_403 VDD VSS sg13cmos5l_fill_2
X_4158_ _4159_/B _6415_/B _4158_/B VDD VSS sg13cmos5l_xnor2_1
X_4227_ _4230_/A _7048_/Q _4561_/B VDD VSS sg13cmos5l_nor2_1
X_5276_ _7102_/D _5263_/Y _5274_/Y _5275_/Y VDD VSS sg13cmos5l_a21oi_1
X_7015_ _7015_/Q clkload7/A _7015_/D _7015_/RESET_B VDD VSS sg13cmos5l_dfrbpq_1
XFILLER_11_314 VDD VSS sg13cmos5l_fill_1
XFILLER_24_686 VDD VSS sg13cmos5l_fill_1
X_4089_ _4091_/B _4089_/A _4089_/B VDD VSS sg13cmos5l_xor2_1
XFILLER_3_524 VDD VSS sg13cmos5l_fill_2
XFILLER_30_601 VDD VSS sg13cmos5l_fill_2
XFILLER_30_678 VDD VSS sg13cmos5l_fill_1
XFILLER_30_689 VDD VSS sg13cmos5l_fill_1
X_7143__235 _7143_/RESET_B VDD VSS sg13cmos5l_tiehi
X_7067__336 _7067_/RESET_B VDD VSS sg13cmos5l_tiehi
X_4012_ _4012_/Y _4013_/A _4013_/B VDD VSS sg13cmos5l_nor2_1
X_5061_ _5062_/C _5060_/B _5060_/C _7091_/Q VDD VSS sg13cmos5l_a21oi_1
X_5130_ _5133_/C _5149_/A _5130_/B _5130_/C VDD VSS sg13cmos5l_or3_1
XFILLER_25_406 VDD VSS sg13cmos5l_fill_2
X_4914_ _4915_/C _4914_/A _4914_/B VDD VSS sg13cmos5l_xor2_1
X_5894_ _5895_/B _7140_/Q _5896_/A2 _5896_/B1 _7139_/Q VDD VSS sg13cmos5l_a22oi_1
X_5963_ _7161_/D _7161_/Q _5967_/A2 _5962_/Y VDD VSS sg13cmos5l_a21o_1
X_3727_ _3729_/B _3759_/A _3749_/C VDD VSS sg13cmos5l_nand2_1
X_4776_ _4778_/B _4776_/A _4776_/B VDD VSS sg13cmos5l_or2_1
X_4845_ _4849_/C _4844_/B _4844_/C _4844_/A VDD VSS sg13cmos5l_a21o_1
X_6515_ _6517_/B _6994_/Q _6499_/B _6498_/A VDD VSS sg13cmos5l_a21o_1
X_3658_ _4381_/A _7053_/Q VDD VSS sg13cmos5l_inv_1
X_5328_ _5341_/A _3642_/Y _5313_/B _5311_/Y VDD VSS sg13cmos5l_o21ai_1
X_6446_ _6446_/X _6446_/A _6446_/B VDD VSS sg13cmos5l_and2_1
X_6377_ _7009_/D _6396_/A _6375_/B _6376_/Y VDD VSS sg13cmos5l_a21oi_1
XFILLER_28_233 VDD VSS sg13cmos5l_fill_1
X_5259_ _5259_/Y _5260_/A _5260_/B VDD VSS sg13cmos5l_nor2_1
X_7194__199 _7194_/RESET_B VDD VSS sg13cmos5l_tiehi
XFILLER_12_612 VDD VSS sg13cmos5l_decap_4
XFILLER_12_689 VDD VSS sg13cmos5l_fill_1
XFILLER_24_494 VDD VSS sg13cmos5l_fill_1
XFILLER_3_310 VDD VSS sg13cmos5l_fill_1
X_7027__353 _7027_/RESET_B VDD VSS sg13cmos5l_tiehi
XFILLER_35_737 VDD VSS sg13cmos5l_fill_1
XFILLER_35_748 VDD VSS sg13cmos5l_fill_2
X_4561_ _4563_/B _7076_/Q _4561_/B VDD VSS sg13cmos5l_xnor2_1
X_4630_ _4668_/B _7053_/Q _4631_/B VDD VSS sg13cmos5l_nand2_1
X_7034__346 _7034_/RESET_B VDD VSS sg13cmos5l_tiehi
X_6300_ _7003_/D _6300_/A _6300_/B VDD VSS sg13cmos5l_nor2_1
XFILLER_33_0 VDD VSS sg13cmos5l_fill_1
X_4492_ _4493_/B _4479_/A _4479_/B _4478_/A VDD VSS sg13cmos5l_a21oi_1
X_5113_ _5176_/A _5113_/A _5113_/B VDD VSS sg13cmos5l_xnor2_1
X_6162_ _7309_/D _7309_/Q _7277_/Q _7126_/D VDD VSS sg13cmos5l_mux2_1
X_6231_ _6233_/B _6232_/A _6232_/C _6232_/B VDD VSS sg13cmos5l_o21ai_1
X_7280_ _7280_/Q clkload3/A _7280_/D _7280_/RESET_B VDD VSS sg13cmos5l_dfrbpq_1
XFILLER_26_704 VDD VSS sg13cmos5l_decap_8
X_5044_ _5044_/X _5045_/A _5045_/B VDD VSS sg13cmos5l_and2_1
X_6093_ _7201_/D _6006_/X _7201_/Q _6105_/S VDD VSS sg13cmos5l_mux2_1
X_7041__339 _7041_/RESET_B VDD VSS sg13cmos5l_tiehi
XFILLER_21_442 VDD VSS sg13cmos5l_fill_1
XFILLER_41_707 VDD VSS sg13cmos5l_fill_2
X_4828_ _4828_/Y _4828_/A _4792_/B VDD VSS sg13cmos5l_nor2b_1
X_5877_ _7130_/D _6905_/A _5877_/B _5877_/C VDD VSS sg13cmos5l_nor3_1
X_5946_ _5946_/Y _5944_/Y _5945_/Y _5967_/A2 VDD VSS sg13cmos5l_a21oi_1
X_6995_ _6995_/Q _7266_/CLK _6995_/D _6995_/RESET_B VDD VSS sg13cmos5l_dfrbpq_1
X_4759_ _4786_/A _7083_/Q _4742_/B _4740_/Y VDD VSS sg13cmos5l_a21oi_1
X_6429_ _6430_/B _7014_/Q _6772_/A VDD VSS sg13cmos5l_xnor2_1
XFILLER_8_435 VDD VSS sg13cmos5l_fill_1
XFILLER_8_446 VDD VSS sg13cmos5l_fill_1
XFILLER_22_228 VDD VSS sg13cmos5l_fill_2
X_3992_ _4768_/S _5381_/B _6196_/A VDD VSS sg13cmos5l_nand2_1
X_5731_ _7119_/D _6977_/A _5731_/B _5756_/B VDD VSS sg13cmos5l_nor3_1
X_5800_ _5810_/A _5800_/A _5826_/B _5800_/C VDD VSS sg13cmos5l_and3_1
X_6780_ _6831_/A _6780_/A _6780_/B VDD VSS sg13cmos5l_xnor2_1
XFILLER_30_294 VDD VSS sg13cmos5l_fill_1
X_4544_ _4546_/B _7047_/Q _4544_/B VDD VSS sg13cmos5l_xnor2_1
X_4613_ _4618_/A _4613_/A _4719_/B VDD VSS sg13cmos5l_xnor2_1
X_5593_ _5618_/A _7115_/Q _5580_/B _5578_/Y VDD VSS sg13cmos5l_a21o_1
X_5662_ _5698_/B _5662_/A _5662_/B _5662_/C VDD VSS sg13cmos5l_nor3_1
X_7263_ _7264_/D _7270_/CLK _7263_/D _6930_/A VDD VSS sg13cmos5l_dfrbpq_1
X_4475_ _4477_/C _7040_/Q _4475_/B VDD VSS sg13cmos5l_xnor2_1
X_6076_ _7185_/D _6000_/X _7185_/Q _6090_/S VDD VSS sg13cmos5l_mux2_1
X_6145_ _7292_/D _7292_/Q _7138_/Q _6161_/S VDD VSS sg13cmos5l_mux2_1
X_6214_ _6220_/A _6565_/C _6205_/B _6203_/Y VDD VSS sg13cmos5l_o21ai_1
X_7194_ _7194_/Q _7224_/CLK _7194_/D _7194_/RESET_B VDD VSS sg13cmos5l_dfrbpq_1
XFILLER_13_206 VDD VSS sg13cmos5l_fill_2
XFILLER_26_512 VDD VSS sg13cmos5l_fill_2
XFILLER_26_578 VDD VSS sg13cmos5l_fill_1
XFILLER_41_515 VDD VSS sg13cmos5l_fill_1
X_5027_ _5033_/A _5027_/A _5027_/B VDD VSS sg13cmos5l_xnor2_1
XFILLER_22_762 VDD VSS sg13cmos5l_fill_2
XFILLER_41_559 VDD VSS sg13cmos5l_decap_8
X_5929_ _5929_/Y _7216_/Q _5921_/B _5977_/B1 _7201_/Q VDD VSS sg13cmos5l_a22oi_1
X_7017__363 _7017_/RESET_B VDD VSS sg13cmos5l_tiehi
X_6978_ _6978_/X _6978_/A _6978_/B VDD VSS sg13cmos5l_or2_1
XFILLER_1_688 VDD VSS sg13cmos5l_fill_1
X_7024__356 _7024_/RESET_B VDD VSS sg13cmos5l_tiehi
XFILLER_29_394 VDD VSS sg13cmos5l_fill_2
XFILLER_32_548 VDD VSS sg13cmos5l_fill_1
XFILLER_9_711 VDD VSS sg13cmos5l_fill_2
XFILLER_40_592 VDD VSS sg13cmos5l_fill_2
XFILLER_8_243 VDD VSS sg13cmos5l_fill_2
X_7031__349 _7031_/RESET_B VDD VSS sg13cmos5l_tiehi
XFILLER_39_125 VDD VSS sg13cmos5l_fill_1
XFILLER_5_76 VDD VSS sg13cmos5l_fill_1
X_4191_ _4416_/A _7037_/Q _4193_/A _4192_/C VDD VSS sg13cmos5l_and3_1
X_4260_ _4260_/X _4260_/A _4260_/B VDD VSS sg13cmos5l_xor2_1
XFILLER_39_158 VDD VSS sg13cmos5l_fill_2
X_6901_ _6901_/Y _6901_/A _6900_/Y VDD VSS sg13cmos5l_nor2b_1
X_6832_ _6832_/Y _6827_/A _6825_/Y _6826_/A VDD VSS sg13cmos5l_a21oi_1
X_3975_ _4315_/A _3976_/A _3976_/B VDD VSS sg13cmos5l_nor2_1
X_5645_ _5649_/B _5541_/Y _5545_/Y _5707_/A VDD VSS sg13cmos5l_o21ai_1
X_5714_ _5716_/B _5714_/A _5714_/B VDD VSS sg13cmos5l_xnor2_1
Xclkbuf_2_3__f_sd_clk clkload2/A clkbuf_0_sd_clk/X VDD VSS sg13cmos5l_buf_8
X_6763_ _6766_/D _6757_/A _6757_/B _6742_/A VDD VSS sg13cmos5l_a21oi_1
X_6694_ _6766_/A _6692_/Y _6694_/B VDD VSS sg13cmos5l_nand2b_1
X_4458_ _4463_/B _4460_/A _4458_/B VDD VSS sg13cmos5l_nand2b_1
X_4527_ _4529_/A _7044_/Q _7071_/Q VDD VSS sg13cmos5l_xor2_1
X_5576_ _5608_/B _5541_/Y _5545_/Y _5644_/A VDD VSS sg13cmos5l_o21ai_1
X_7246_ _7247_/D clkload7/A _7246_/D _7246_/RESET_B VDD VSS sg13cmos5l_dfrbpq_1
X_7315_ _7315_/Q _7316_/CLK _7315_/D _7315_/RESET_B VDD VSS sg13cmos5l_dfrbpq_1
X_4389_ _4394_/A _4387_/Y _4389_/B VDD VSS sg13cmos5l_nand2b_1
X_6059_ _6059_/Y _7316_/Q _7300_/Q VDD VSS sg13cmos5l_nor2_1
X_6128_ _7275_/D _7275_/Q _7137_/Q _6132_/S VDD VSS sg13cmos5l_mux2_1
X_7177_ _7177_/Q clkload4/A _7177_/D _7177_/RESET_B VDD VSS sg13cmos5l_dfrbpq_1
XFILLER_14_515 VDD VSS sg13cmos5l_fill_1
XFILLER_41_356 VDD VSS sg13cmos5l_fill_2
XFILLER_10_787 VDD VSS sg13cmos5l_fill_1
XFILLER_22_581 VDD VSS sg13cmos5l_fill_1
XFILLER_36_128 VDD VSS sg13cmos5l_fill_1
XFILLER_13_592 VDD VSS sg13cmos5l_fill_2
XFILLER_20_529 VDD VSS sg13cmos5l_fill_1
XFILLER_32_367 VDD VSS sg13cmos5l_fill_1
X_3760_ _3850_/A _7119_/Q _6700_/B VDD VSS sg13cmos5l_nand2_1
X_3691_ _3699_/A _7155_/Q _7154_/Q VDD VSS sg13cmos5l_nand2_1
X_4312_ _4401_/A _4449_/B _4311_/C _4311_/A VDD VSS sg13cmos5l_o21ai_1
X_5292_ _5298_/A _7103_/Q _5281_/B _5279_/X VDD VSS sg13cmos5l_a21oi_1
X_5361_ _5397_/A _5362_/B _5362_/A VDD VSS sg13cmos5l_nand2b_1
X_5430_ _5461_/A _5431_/A _5433_/C VDD VSS sg13cmos5l_nor2_1
X_7100_ _7100_/Q _7270_/CLK _7100_/D _7100_/RESET_B VDD VSS sg13cmos5l_dfrbpq_1
X_4174_ _4176_/C _7038_/Q _4176_/B _4174_/C VDD VSS sg13cmos5l_nand3_1
X_4243_ _4254_/B _4243_/A _4243_/B VDD VSS sg13cmos5l_xnor2_1
X_7031_ _7031_/Q _7224_/CLK _7031_/D _7031_/RESET_B VDD VSS sg13cmos5l_dfrbpq_1
X_7007__373 _7007_/RESET_B VDD VSS sg13cmos5l_tiehi
X_6815_ _6817_/B _6816_/A _6816_/B VDD VSS sg13cmos5l_and2_1
X_3889_ _7238_/D _7238_/Q _5917_/B VDD VSS sg13cmos5l_xor2_1
X_3958_ _4841_/B _5534_/B _5597_/B VDD VSS sg13cmos5l_nand2_1
X_5628_ _5628_/X _5662_/B _5662_/C VDD VSS sg13cmos5l_or2_1
X_7014__366 _7014_/RESET_B VDD VSS sg13cmos5l_tiehi
X_6746_ _6749_/A _6746_/A _6746_/B VDD VSS sg13cmos5l_xor2_1
X_6677_ _6703_/A _6677_/A _6677_/B VDD VSS sg13cmos5l_xor2_1
XFILLER_2_205 VDD VSS sg13cmos5l_fill_1
X_5559_ _7114_/D _5530_/Y _5557_/X _5558_/Y VDD VSS sg13cmos5l_a21oi_1
X_7229_ _7229_/Q _7318_/CLK _7229_/D _7229_/RESET_B VDD VSS sg13cmos5l_dfrbpq_1
XFILLER_18_117 VDD VSS sg13cmos5l_fill_2
X_7021__359 _7021_/RESET_B VDD VSS sg13cmos5l_tiehi
XFILLER_18_651 VDD VSS sg13cmos5l_decap_4
XFILLER_18_695 VDD VSS sg13cmos5l_fill_2
XFILLER_33_654 VDD VSS sg13cmos5l_fill_2
X_4861_ _4861_/Y _4834_/A _4834_/B _4862_/B VDD VSS sg13cmos5l_o21ai_1
X_4930_ _4931_/B _3924_/Y _4929_/B _4929_/Y VDD VSS sg13cmos5l_a21oi_1
XFILLER_20_315 VDD VSS sg13cmos5l_fill_1
XFILLER_32_153 VDD VSS sg13cmos5l_fill_1
X_3674_ _7248_/D _7266_/D _7270_/Q VDD VSS sg13cmos5l_xnor2_1
X_3743_ _3848_/B _7122_/Q _5788_/A VDD VSS sg13cmos5l_and2_1
X_3812_ _3812_/X _7154_/Q _7152_/Q VDD VSS sg13cmos5l_and2_1
X_4792_ _4792_/Y _4917_/A _4792_/B VDD VSS sg13cmos5l_nand2_1
X_6600_ _6602_/B _7026_/Q _6600_/B VDD VSS sg13cmos5l_xnor2_1
X_6531_ _6556_/A _6532_/B _6532_/A VDD VSS sg13cmos5l_nand2b_1
X_6462_ _6463_/B _7016_/Q _4468_/Y _4470_/B VDD VSS sg13cmos5l_a21oi_1
X_5275_ _5275_/Y _5263_/Y _5274_/Y _4596_/A VDD VSS sg13cmos5l_o21ai_1
X_5344_ _5344_/Y _5344_/A _5344_/B _5346_/B VDD VSS sg13cmos5l_nand3_1
X_5413_ _5415_/C _7109_/Q _5413_/B VDD VSS sg13cmos5l_xnor2_1
X_6393_ _6393_/Y _6394_/A _6394_/B _6394_/C VDD VSS sg13cmos5l_a21oi_1
X_4088_ _4285_/B _4089_/A _4089_/B VDD VSS sg13cmos5l_nor2_1
X_4157_ _4157_/X _6772_/A _4158_/B VDD VSS sg13cmos5l_and2_1
X_4226_ _4561_/B _5253_/A _5294_/B VDD VSS sg13cmos5l_xnor2_1
X_7014_ _7014_/Q clkload6/A _7014_/D _7014_/RESET_B VDD VSS sg13cmos5l_dfrbpq_1
XFILLER_11_31 VDD VSS sg13cmos5l_fill_1
X_7242__327 _7242_/RESET_B VDD VSS sg13cmos5l_tiehi
X_6729_ _6730_/B _6729_/A _6729_/B VDD VSS sg13cmos5l_xnor2_1
XFILLER_3_547 VDD VSS sg13cmos5l_fill_2
XFILLER_37_201 VDD VSS sg13cmos5l_fill_2
X_4011_ _4013_/B _4011_/A _4011_/B VDD VSS sg13cmos5l_xnor2_1
X_5060_ _5082_/B _7091_/Q _5060_/B _5060_/C VDD VSS sg13cmos5l_and3_1
X_7004__376 _7004_/RESET_B VDD VSS sg13cmos5l_tiehi
XFILLER_33_440 VDD VSS sg13cmos5l_fill_1
X_4844_ _4849_/B _4844_/A _4844_/B _4844_/C VDD VSS sg13cmos5l_nand3_1
X_4913_ _4913_/Y _4914_/A _4914_/B VDD VSS sg13cmos5l_nand2_1
X_5893_ _7139_/D _5907_/A _5893_/B VDD VSS sg13cmos5l_nor2_1
X_5962_ _5962_/Y _5960_/Y _5961_/Y _5967_/A2 VDD VSS sg13cmos5l_a21oi_1
XFILLER_20_156 VDD VSS sg13cmos5l_fill_1
XFILLER_21_679 VDD VSS sg13cmos5l_fill_2
X_3657_ _4210_/A _7052_/Q VDD VSS sg13cmos5l_inv_1
X_3726_ _3748_/C _7164_/Q _7163_/Q VDD VSS sg13cmos5l_xnor2_1
X_4775_ _4778_/A _4775_/A _4775_/B VDD VSS sg13cmos5l_xnor2_1
X_7011__369 _7011_/RESET_B VDD VSS sg13cmos5l_tiehi
X_6514_ _6514_/Y _6517_/A VDD VSS sg13cmos5l_inv_1
X_6445_ _6446_/B _6434_/A _6432_/Y _6433_/A VDD VSS sg13cmos5l_a21oi_1
X_5258_ _5260_/B _7073_/Q _5246_/B _5244_/Y VDD VSS sg13cmos5l_a21oi_1
X_5327_ _5346_/A _5344_/A _5344_/B VDD VSS sg13cmos5l_nand2_1
X_6376_ _6376_/Y _6396_/A _6375_/B _6402_/A VDD VSS sg13cmos5l_o21ai_1
XFILLER_16_418 VDD VSS sg13cmos5l_fill_1
XFILLER_28_256 VDD VSS sg13cmos5l_fill_1
XFILLER_28_278 VDD VSS sg13cmos5l_fill_1
X_4209_ _4210_/B _4370_/A _4209_/B VDD VSS sg13cmos5l_xnor2_1
X_5189_ _5191_/B _5189_/A _5189_/B VDD VSS sg13cmos5l_xor2_1
XFILLER_24_473 VDD VSS sg13cmos5l_decap_8
XFILLER_19_212 VDD VSS sg13cmos5l_fill_1
XFILLER_19_223 VDD VSS sg13cmos5l_fill_1
Xfanout180 _3705_/B _7156_/Q VDD VSS sg13cmos5l_buf_1
XFILLER_19_289 VDD VSS sg13cmos5l_fill_2
X_4491_ _4494_/B _4491_/A _4491_/B VDD VSS sg13cmos5l_xor2_1
X_4560_ _4576_/A _7076_/Q _4561_/B VDD VSS sg13cmos5l_nor2_1
XFILLER_26_0 VDD VSS sg13cmos5l_fill_1
X_5112_ _5174_/A _5113_/A _5113_/B VDD VSS sg13cmos5l_nor2_1
X_6092_ _7200_/D _6000_/X _7200_/Q _6105_/S VDD VSS sg13cmos5l_mux2_1
X_6161_ _7308_/D _7308_/Q _7276_/Q _6161_/S VDD VSS sg13cmos5l_mux2_1
X_6230_ _6232_/C _6210_/A _6210_/B _6220_/A _6219_/B _6208_/Y VDD VSS sg13cmos5l_a221oi_1
XFILLER_25_237 VDD VSS sg13cmos5l_fill_1
XFILLER_38_565 VDD VSS sg13cmos5l_decap_4
X_5043_ _5043_/X _5045_/A _5045_/B VDD VSS sg13cmos5l_or2_1
X_6994_ _6994_/Q _7266_/CLK _6994_/D _6994_/RESET_B VDD VSS sg13cmos5l_dfrbpq_1
XFILLER_34_782 VDD VSS sg13cmos5l_fill_2
X_4827_ _4873_/B _4827_/A _4827_/B VDD VSS sg13cmos5l_xnor2_1
X_5876_ _5877_/C _7130_/Q _5875_/B _5902_/B1 _5875_/A VDD VSS sg13cmos5l_a22oi_1
X_5945_ _5945_/Y _7175_/Q _5980_/A2 _5961_/B1 _7190_/Q VDD VSS sg13cmos5l_a22oi_1
X_3709_ _3714_/A _3697_/X _3698_/Y _3708_/X VDD VSS sg13cmos5l_a21oi_1
X_4689_ _4691_/B _4689_/A _4689_/B VDD VSS sg13cmos5l_xnor2_1
X_4758_ _4758_/Y _4791_/A VDD VSS sg13cmos5l_inv_1
X_6428_ _6428_/Y _6428_/A _7014_/Q VDD VSS sg13cmos5l_nor2b_1
XFILLER_29_510 VDD VSS sg13cmos5l_fill_1
X_6359_ _6359_/Y _6370_/B VDD VSS sg13cmos5l_inv_1
XFILLER_17_738 VDD VSS sg13cmos5l_fill_2
XFILLER_29_565 VDD VSS sg13cmos5l_decap_8
XFILLER_3_141 VDD VSS sg13cmos5l_fill_1
XFILLER_35_546 VDD VSS sg13cmos5l_decap_4
X_7040__340 _7040_/RESET_B VDD VSS sg13cmos5l_tiehi
X_7001__379 _7001_/RESET_B VDD VSS sg13cmos5l_tiehi
XFILLER_30_273 VDD VSS sg13cmos5l_fill_2
X_3991_ _4011_/A _5253_/A _3991_/B VDD VSS sg13cmos5l_xnor2_1
X_5661_ _5700_/B _5585_/Y _5626_/Y _5662_/C VDD VSS sg13cmos5l_a21o_1
X_5730_ _5756_/B _5781_/A _5780_/B VDD VSS sg13cmos5l_nor2b_1
X_4474_ _4475_/B _4474_/A _4474_/B VDD VSS sg13cmos5l_xor2_1
X_4543_ _4544_/B _4543_/A _4543_/B VDD VSS sg13cmos5l_xor2_1
X_4612_ _4654_/A _5308_/B _4719_/B VDD VSS sg13cmos5l_and2_1
X_5592_ _5617_/A _7115_/Q _5580_/B _5578_/Y VDD VSS sg13cmos5l_a21oi_1
X_6213_ _6213_/Y _6210_/A _6210_/B _6208_/Y VDD VSS sg13cmos5l_a21oi_1
X_7262_ _7263_/D _7270_/CLK _7262_/D _6521_/A VDD VSS sg13cmos5l_dfrbpq_1
X_5026_ _5076_/A _5027_/A _5027_/B VDD VSS sg13cmos5l_xor2_1
X_6075_ _6075_/Y _7168_/Q _6091_/C _6075_/C VDD VSS sg13cmos5l_nand3b_1
X_6144_ _7291_/D _7291_/Q _7137_/Q _6161_/S VDD VSS sg13cmos5l_mux2_1
X_7193_ _7193_/Q _7298_/CLK _7193_/D _7193_/RESET_B VDD VSS sg13cmos5l_dfrbpq_1
XFILLER_26_535 VDD VSS sg13cmos5l_fill_2
XFILLER_38_362 VDD VSS sg13cmos5l_fill_2
XFILLER_41_527 VDD VSS sg13cmos5l_fill_1
X_5928_ _7152_/D _5927_/X _7152_/Q _5943_/S VDD VSS sg13cmos5l_mux2_1
X_6977_ _7061_/D _6977_/A _6977_/B _6978_/B VDD VSS sg13cmos5l_nor3_1
XFILLER_22_741 VDD VSS sg13cmos5l_fill_2
X_5859_ _5865_/B _7133_/Q _7132_/Q VDD VSS sg13cmos5l_nor2_1
X_7087__307 _7087_/RESET_B VDD VSS sg13cmos5l_tiehi
XFILLER_28_95 VDD VSS sg13cmos5l_fill_2
X_7070__333 _7070_/RESET_B VDD VSS sg13cmos5l_tiehi
X_4190_ _4192_/C _4189_/A _4189_/C _4189_/B VDD VSS sg13cmos5l_o21ai_1
XFILLER_23_505 VDD VSS sg13cmos5l_fill_1
X_6900_ _6900_/Y _6867_/Y _6884_/B _6882_/Y VDD VSS sg13cmos5l_a21oi_1
X_6831_ _6831_/Y _6831_/A _6831_/B _6831_/C VDD VSS sg13cmos5l_nor3_1
XFILLER_16_590 VDD VSS sg13cmos5l_fill_2
X_3974_ _3976_/B _5568_/A _3974_/B VDD VSS sg13cmos5l_xnor2_1
X_5644_ _5707_/A _5644_/A _5644_/B VDD VSS sg13cmos5l_and2_1
X_5713_ _5739_/A _5714_/A _5714_/B VDD VSS sg13cmos5l_nor2_1
X_6762_ _6766_/C _6765_/C _6762_/B VDD VSS sg13cmos5l_nor2_1
X_6693_ _6694_/B _6653_/A _6671_/B _6669_/Y VDD VSS sg13cmos5l_a21oi_1
X_4457_ _4458_/B _4194_/A _4194_/B _4194_/C VDD VSS sg13cmos5l_o21ai_1
X_4526_ _4530_/A _7043_/Q _4517_/B _4515_/Y VDD VSS sg13cmos5l_a21oi_1
X_5575_ _5644_/A _5575_/A _5575_/B VDD VSS sg13cmos5l_xor2_1
X_7245_ _7246_/D clkload7/A input1/X _7245_/RESET_B VDD VSS sg13cmos5l_dfrbpq_1
X_7314_ _7314_/Q _7316_/CLK _7314_/D _7314_/RESET_B VDD VSS sg13cmos5l_dfrbpq_1
X_7176_ _7176_/Q clkload4/A _7176_/D _7176_/RESET_B VDD VSS sg13cmos5l_dfrbpq_1
X_4388_ _4389_/B _4388_/A _4388_/B _4388_/C VDD VSS sg13cmos5l_nand3_1
X_5009_ _5011_/B _5009_/A _5009_/B VDD VSS sg13cmos5l_xor2_1
X_6058_ _6058_/Y _7316_/Q _7300_/Q VDD VSS sg13cmos5l_nand2_1
X_6127_ _7274_/D _7274_/Q _7136_/Q _6132_/S VDD VSS sg13cmos5l_mux2_1
XFILLER_10_700 VDD VSS sg13cmos5l_fill_2
XFILLER_14_527 VDD VSS sg13cmos5l_fill_1
XFILLER_26_332 VDD VSS sg13cmos5l_fill_1
XFILLER_26_354 VDD VSS sg13cmos5l_fill_1
XFILLER_26_398 VDD VSS sg13cmos5l_fill_2
XFILLER_41_335 VDD VSS sg13cmos5l_fill_1
X_7030__350 _7030_/RESET_B VDD VSS sg13cmos5l_tiehi
XFILLER_39_50 VDD VSS sg13cmos5l_fill_2
XFILLER_17_354 VDD VSS sg13cmos5l_fill_2
XFILLER_9_531 VDD VSS sg13cmos5l_fill_1
X_3690_ _3781_/B _7160_/Q _7159_/Q VDD VSS sg13cmos5l_xnor2_1
XFILLER_9_597 VDD VSS sg13cmos5l_fill_2
X_4242_ _4242_/Y _4243_/A _4243_/B VDD VSS sg13cmos5l_nor2b_1
X_4311_ _4328_/A _4311_/A _4449_/B _4311_/C VDD VSS sg13cmos5l_or3_1
X_5291_ _5303_/A _5301_/A _5301_/B VDD VSS sg13cmos5l_nand2_1
X_5360_ _5362_/B _5360_/A _5360_/B VDD VSS sg13cmos5l_xnor2_1
X_7030_ _7030_/Q _7224_/CLK _7030_/D _7030_/RESET_B VDD VSS sg13cmos5l_dfrbpq_1
X_4173_ _4194_/A _7038_/Q _4176_/B _4174_/C VDD VSS sg13cmos5l_and3_1
X_7077__317 _7077_/RESET_B VDD VSS sg13cmos5l_tiehi
X_3957_ _3985_/A _6565_/C _3957_/B VDD VSS sg13cmos5l_xnor2_1
X_6814_ _6816_/B _6779_/Y _6796_/Y _6813_/Y _6783_/A _6797_/Y VDD VSS sg13cmos5l_a221oi_1
X_6745_ _6746_/B _6745_/A _6745_/B VDD VSS sg13cmos5l_xnor2_1
X_3888_ _7237_/D _5917_/B _3888_/B VDD VSS sg13cmos5l_nor2_1
X_5558_ _5558_/Y _5530_/Y _5557_/X _5528_/A VDD VSS sg13cmos5l_o21ai_1
X_5627_ _5662_/C _5627_/A _5657_/B _5627_/C VDD VSS sg13cmos5l_nor3_1
X_7309__399 _7309_/RESET_B VDD VSS sg13cmos5l_tiehi
X_6676_ _6676_/Y _6677_/A _6677_/B VDD VSS sg13cmos5l_nor2_1
X_4509_ _4512_/A _4510_/B _4510_/C _4510_/A VDD VSS sg13cmos5l_o21ai_1
X_5489_ _5490_/B _5489_/A _5489_/B _5489_/C VDD VSS sg13cmos5l_or3_1
X_7228_ _7228_/Q clkload5/A _7228_/D _7228_/RESET_B VDD VSS sg13cmos5l_dfrbpq_1
X_7159_ _7159_/Q _7224_/CLK _7159_/D _6740_/A VDD VSS sg13cmos5l_dfrbpq_1
XFILLER_19_619 VDD VSS sg13cmos5l_fill_1
XFILLER_27_663 VDD VSS sg13cmos5l_fill_1
XFILLER_27_674 VDD VSS sg13cmos5l_fill_2
XFILLER_27_696 VDD VSS sg13cmos5l_fill_1
XFILLER_39_490 VDD VSS sg13cmos5l_fill_2
XFILLER_41_176 VDD VSS sg13cmos5l_fill_2
XFILLER_37_405 VDD VSS sg13cmos5l_fill_1
XFILLER_37_438 VDD VSS sg13cmos5l_decap_8
XFILLER_17_140 VDD VSS sg13cmos5l_fill_2
XFILLER_17_184 VDD VSS sg13cmos5l_fill_1
XFILLER_18_641 VDD VSS sg13cmos5l_fill_2
X_3811_ _3863_/A _5469_/A _5253_/A VDD VSS sg13cmos5l_nor2_1
X_4860_ _4862_/B _4903_/A _4903_/B VDD VSS sg13cmos5l_nor2_1
X_3673_ _7249_/D _7248_/Q VDD VSS sg13cmos5l_inv_1
X_3742_ _3742_/Y _3742_/A _3890_/B VDD VSS sg13cmos5l_xnor2_1
X_4791_ _4792_/B _4791_/A _4873_/A VDD VSS sg13cmos5l_or2_1
X_5412_ _5442_/A _7109_/Q _5413_/B VDD VSS sg13cmos5l_nor2b_1
X_6530_ _6532_/B _7023_/Q _6530_/B VDD VSS sg13cmos5l_xnor2_1
X_6461_ _6461_/Y _6452_/B _6460_/X _6456_/Y VDD VSS sg13cmos5l_o21ai_1
X_6392_ _6394_/C _6392_/A _6392_/B VDD VSS sg13cmos5l_xnor2_1
X_4225_ _4225_/Y _4273_/A _4273_/B VDD VSS sg13cmos5l_nor2_1
X_5274_ _5274_/Y _5274_/A _5274_/B VDD VSS sg13cmos5l_xnor2_1
X_5343_ _5346_/B _7079_/Q _5343_/B VDD VSS sg13cmos5l_xnor2_1
X_7013_ _7013_/Q clkload6/A _7013_/D _7013_/RESET_B VDD VSS sg13cmos5l_dfrbpq_1
X_4087_ _4089_/B _4087_/A _4087_/B VDD VSS sg13cmos5l_and2_1
X_4156_ _4158_/B _4165_/B _4146_/C _4155_/Y VDD VSS sg13cmos5l_o21ai_1
X_7020__360 _7020_/RESET_B VDD VSS sg13cmos5l_tiehi
X_4989_ _4992_/A _5030_/B _5030_/C VDD VSS sg13cmos5l_or2_1
X_6728_ _6728_/Y _6750_/A _6729_/B VDD VSS sg13cmos5l_nor2_1
X_6659_ _6659_/Y _6661_/A VDD VSS sg13cmos5l_inv_1
XFILLER_27_460 VDD VSS sg13cmos5l_decap_4
XFILLER_30_647 VDD VSS sg13cmos5l_decap_4
XFILLER_6_386 VDD VSS sg13cmos5l_fill_1
X_4010_ _4013_/A _4024_/B _4024_/A VDD VSS sg13cmos5l_nand2b_1
X_5961_ _5961_/Y _7209_/Q _5980_/B1 _5961_/B1 _7194_/Q VDD VSS sg13cmos5l_a22oi_1
XFILLER_21_603 VDD VSS sg13cmos5l_fill_1
XFILLER_21_647 VDD VSS sg13cmos5l_decap_8
XFILLER_33_463 VDD VSS sg13cmos5l_decap_8
XFILLER_33_496 VDD VSS sg13cmos5l_fill_1
X_4774_ _4775_/B _4774_/A _4774_/B VDD VSS sg13cmos5l_xor2_1
X_4843_ _4844_/C _4885_/B _3956_/B _4841_/B VDD VSS sg13cmos5l_o21ai_1
X_4912_ _4912_/Y _4914_/A _4914_/B VDD VSS sg13cmos5l_nor2_1
X_5892_ _5893_/B _7139_/Q _5896_/A2 _5896_/B1 _7138_/Q VDD VSS sg13cmos5l_a22oi_1
X_3656_ _3656_/Y _7047_/Q VDD VSS sg13cmos5l_inv_1
X_3725_ _3749_/C _7164_/Q _7163_/Q VDD VSS sg13cmos5l_xor2_1
X_6513_ _6517_/A _6995_/Q _6513_/B VDD VSS sg13cmos5l_xnor2_1
X_6444_ _6444_/Y _6444_/A VDD VSS sg13cmos5l_inv_1
X_6375_ _6386_/B _6396_/A _6375_/B VDD VSS sg13cmos5l_nor2_1
X_4208_ _4208_/Y _4370_/A _4209_/B VDD VSS sg13cmos5l_nand2_1
X_5188_ _5203_/A _5189_/A _5189_/B VDD VSS sg13cmos5l_or2_1
X_5257_ _5260_/A _7074_/Q _5257_/B VDD VSS sg13cmos5l_xnor2_1
X_5326_ _7105_/D _5370_/A _5324_/B _5325_/Y VDD VSS sg13cmos5l_a21oi_1
X_4139_ _4164_/B _4135_/A _4135_/B _4138_/Y VDD VSS sg13cmos5l_o21ai_1
Xfanout170 _4468_/A _5160_/A VDD VSS sg13cmos5l_buf_1
Xfanout181 _5926_/A _7149_/Q VDD VSS sg13cmos5l_buf_1
XFILLER_27_290 VDD VSS sg13cmos5l_fill_1
X_4490_ _4490_/Y _4491_/A _4491_/B VDD VSS sg13cmos5l_nor2_1
X_7010__370 _7010_/RESET_B VDD VSS sg13cmos5l_tiehi
X_5042_ _5045_/B _5042_/A _5042_/B VDD VSS sg13cmos5l_xnor2_1
X_5111_ _5113_/B _5111_/A _5111_/B VDD VSS sg13cmos5l_and2_1
X_6091_ _6091_/Y _6091_/A _7168_/Q _6091_/C _6091_/D VDD VSS sg13cmos5l_nand4_1
X_6160_ _7307_/D _7307_/Q _7275_/Q _6161_/S VDD VSS sg13cmos5l_mux2_1
XFILLER_19_0 VDD VSS sg13cmos5l_fill_1
X_5944_ _5944_/Y _7220_/Q _5921_/B _5980_/B1 _7205_/Q VDD VSS sg13cmos5l_a22oi_1
X_6993_ _6993_/Q _7266_/CLK _6993_/D _6993_/RESET_B VDD VSS sg13cmos5l_dfrbpq_1
X_4757_ _4791_/A _4757_/A _4921_/A VDD VSS sg13cmos5l_and2_1
X_4826_ _4826_/Y _4827_/A _4827_/B VDD VSS sg13cmos5l_nor2_1
X_5875_ _5875_/X _5875_/A _5875_/B VDD VSS sg13cmos5l_or2_1
X_7189__204 _7189_/RESET_B VDD VSS sg13cmos5l_tiehi
X_3639_ _3639_/Y _7110_/Q VDD VSS sg13cmos5l_inv_1
X_3708_ _3708_/X _3824_/A _3781_/B _3790_/A _3708_/D VDD VSS sg13cmos5l_or4_1
X_4688_ _4689_/B _4688_/A _4688_/B VDD VSS sg13cmos5l_xnor2_1
X_5309_ _5335_/A _5310_/A _5310_/B VDD VSS sg13cmos5l_nor2b_1
X_6427_ _7013_/D _6427_/A _6427_/B VDD VSS sg13cmos5l_and2_1
X_6358_ _6370_/B _6358_/A _6358_/B VDD VSS sg13cmos5l_nor2_1
X_6289_ _6291_/B _4800_/A _6278_/B _6276_/Y VDD VSS sg13cmos5l_o21ai_1
XFILLER_25_750 VDD VSS sg13cmos5l_fill_2
XFILLER_33_52 VDD VSS sg13cmos5l_fill_1
XFILLER_40_731 VDD VSS sg13cmos5l_fill_2
XFILLER_35_525 VDD VSS sg13cmos5l_decap_4
XFILLER_35_536 VDD VSS sg13cmos5l_decap_4
X_3990_ _4329_/A _3990_/A _3990_/B VDD VSS sg13cmos5l_xor2_1
X_4611_ _6569_/A _4611_/A _6196_/A _4611_/C VDD VSS sg13cmos5l_and3_1
X_5591_ _5627_/A _7088_/Q _5583_/B _5581_/Y VDD VSS sg13cmos5l_a21oi_1
X_5660_ _5665_/A _5660_/A _5660_/B VDD VSS sg13cmos5l_xnor2_1
XFILLER_7_470 VDD VSS sg13cmos5l_fill_1
X_4473_ _4473_/Y _4474_/A _4474_/B VDD VSS sg13cmos5l_nor2_1
X_4542_ _4542_/Y _4543_/A _4543_/B VDD VSS sg13cmos5l_nor2_1
X_6212_ _6995_/D _6212_/A _6211_/Y VDD VSS sg13cmos5l_nor2b_1
X_7261_ _7262_/D _7266_/CLK _7261_/D _6521_/A VDD VSS sg13cmos5l_dfrbpq_1
X_7192_ _7192_/Q _7316_/CLK _7192_/D _7192_/RESET_B VDD VSS sg13cmos5l_dfrbpq_1
X_5025_ _5070_/A _5027_/A _5027_/B VDD VSS sg13cmos5l_nor2_1
X_6074_ _7184_/D _7184_/Q _6073_/Y _6074_/S VDD VSS sg13cmos5l_mux2_1
X_6143_ _7290_/D _7290_/Q _7136_/Q _6161_/S VDD VSS sg13cmos5l_mux2_1
XFILLER_13_208 VDD VSS sg13cmos5l_fill_1
X_5927_ _5927_/X _7170_/Q _7185_/Q _7200_/Q _7215_/Q _5926_/A _7150_/Q VDD VSS sg13cmos5l_mux4_1
X_6976_ _6978_/B _6981_/A _6981_/C VDD VSS sg13cmos5l_nor2_1
X_4809_ _4811_/B _4809_/A _4809_/B VDD VSS sg13cmos5l_xnor2_1
X_5789_ _5819_/A _5790_/A _5790_/B _5790_/C VDD VSS sg13cmos5l_o21ai_1
X_5858_ _5860_/B _5858_/A _5868_/A VDD VSS sg13cmos5l_or2_1
XFILLER_0_134 VDD VSS sg13cmos5l_fill_1
XFILLER_0_167 VDD VSS sg13cmos5l_fill_2
XFILLER_17_503 VDD VSS sg13cmos5l_fill_2
XFILLER_17_547 VDD VSS sg13cmos5l_fill_1
X_7000__380 _7000_/RESET_B VDD VSS sg13cmos5l_tiehi
XFILLER_32_517 VDD VSS sg13cmos5l_fill_2
XFILLER_40_583 VDD VSS sg13cmos5l_fill_1
X_7179__214 _7179_/RESET_B VDD VSS sg13cmos5l_tiehi
X_3973_ _4087_/B _5568_/A _3974_/B VDD VSS sg13cmos5l_nand2_1
X_5712_ _5714_/B _5734_/S _5712_/B VDD VSS sg13cmos5l_xnor2_1
X_6830_ _6831_/C _6816_/A _6830_/B VDD VSS sg13cmos5l_nand2b_1
X_6761_ _6762_/B _6761_/A _6761_/B VDD VSS sg13cmos5l_nand2_1
XFILLER_31_561 VDD VSS sg13cmos5l_fill_1
X_4525_ _4525_/Y _4521_/B _4524_/X _4520_/B VDD VSS sg13cmos5l_o21ai_1
X_5574_ _5608_/A _5575_/A _5575_/B VDD VSS sg13cmos5l_nand2_1
X_5643_ _5706_/A _5643_/A _5643_/B VDD VSS sg13cmos5l_xnor2_1
X_7313_ _7313_/Q _7316_/CLK _7313_/D _7313_/RESET_B VDD VSS sg13cmos5l_dfrbpq_1
X_7186__207 _7186_/RESET_B VDD VSS sg13cmos5l_tiehi
X_6692_ _6692_/Y _6692_/A _6692_/B _6692_/C VDD VSS sg13cmos5l_nor3_1
X_4387_ _4387_/Y _4388_/A _4388_/B _4388_/C VDD VSS sg13cmos5l_a21oi_1
X_4456_ _6989_/A _6981_/A _4453_/X _4455_/Y VDD VSS sg13cmos5l_o21ai_1
X_6126_ _7273_/D _7273_/Q _7135_/Q _6132_/S VDD VSS sg13cmos5l_mux2_1
X_7244_ _7244_/Q _7244_/CLK _7244_/D _7244_/RESET_B VDD VSS sg13cmos5l_dfrbpq_1
X_7175_ _7175_/Q _7220_/CLK _7175_/D _7175_/RESET_B VDD VSS sg13cmos5l_dfrbpq_1
X_5008_ _5009_/B _5008_/A _5008_/B VDD VSS sg13cmos5l_xnor2_1
X_6057_ _6061_/A _7315_/Q _7299_/Q _6054_/Y VDD VSS sg13cmos5l_a21oi_1
X_7318__390 _7318_/RESET_B VDD VSS sg13cmos5l_tiehi
X_7093__301 _7093_/RESET_B VDD VSS sg13cmos5l_tiehi
XFILLER_10_734 VDD VSS sg13cmos5l_fill_2
XFILLER_22_594 VDD VSS sg13cmos5l_fill_1
X_6959_ _7056_/D _4379_/A _6957_/Y _6958_/Y VDD VSS sg13cmos5l_a21oi_1
XFILLER_30_64 VDD VSS sg13cmos5l_fill_1
XFILLER_30_75 VDD VSS sg13cmos5l_fill_1
XFILLER_30_86 VDD VSS sg13cmos5l_fill_1
XFILLER_13_583 VDD VSS sg13cmos5l_fill_1
XFILLER_13_594 VDD VSS sg13cmos5l_fill_1
XFILLER_40_380 VDD VSS sg13cmos5l_fill_1
XFILLER_40_391 VDD VSS sg13cmos5l_fill_2
X_4241_ _4243_/B _4252_/A _6172_/B _4238_/Y VDD VSS sg13cmos5l_o21ai_1
X_4310_ _4403_/A _4311_/A _4449_/B _4311_/C VDD VSS sg13cmos5l_nor3_1
X_5290_ _7103_/D _6563_/A _5290_/B VDD VSS sg13cmos5l_nor2_1
XFILLER_27_119 VDD VSS sg13cmos5l_fill_2
X_4172_ _4174_/C _4171_/A _4171_/C _4171_/B VDD VSS sg13cmos5l_a21o_1
X_3956_ _3957_/B _4885_/B _3956_/B VDD VSS sg13cmos5l_nor2_1
X_6813_ _6813_/Y _6831_/A _6831_/B VDD VSS sg13cmos5l_nor2_1
X_6744_ _6754_/A _7032_/Q _6730_/B _6728_/Y VDD VSS sg13cmos5l_a21oi_1
X_6675_ _6677_/B _6675_/A _6675_/B VDD VSS sg13cmos5l_xnor2_1
X_3887_ _3888_/B _7236_/Q _3886_/C _7237_/Q VDD VSS sg13cmos5l_a21oi_1
X_4508_ _4510_/C _4477_/Y _4490_/Y _4489_/Y VDD VSS sg13cmos5l_o21ai_1
X_5488_ _5513_/B _5489_/A _5489_/B _5489_/C VDD VSS sg13cmos5l_o21ai_1
X_5557_ _5557_/X _5557_/A _5557_/B VDD VSS sg13cmos5l_xor2_1
X_5626_ _5626_/Y _5657_/B _5627_/C _5627_/A VDD VSS sg13cmos5l_o21ai_1
X_4439_ _4445_/A _4439_/A _4439_/B _4439_/C VDD VSS sg13cmos5l_nand3_1
X_6109_ _7216_/D _7216_/Q _6006_/X _6115_/S VDD VSS sg13cmos5l_mux2_1
X_7227_ _7227_/Q _7298_/CLK _7227_/D _7227_/RESET_B VDD VSS sg13cmos5l_dfrbpq_1
X_7158_ _7158_/Q _7220_/CLK _7158_/D _6321_/A VDD VSS sg13cmos5l_dfrbpq_1
X_7089_ _7089_/Q _7243_/CLK _7089_/D _7089_/RESET_B VDD VSS sg13cmos5l_dfrbpq_1
XFILLER_25_42 VDD VSS sg13cmos5l_fill_2
XFILLER_22_391 VDD VSS sg13cmos5l_fill_1
XFILLER_25_64 VDD VSS sg13cmos5l_fill_1
XFILLER_41_144 VDD VSS sg13cmos5l_fill_1
X_7176__217 _7176_/RESET_B VDD VSS sg13cmos5l_tiehi
XFILLER_18_697 VDD VSS sg13cmos5l_fill_1
XFILLER_32_100 VDD VSS sg13cmos5l_fill_1
X_3741_ _5481_/A _3742_/A _3890_/B VDD VSS sg13cmos5l_xor2_1
X_3810_ _5354_/B _3810_/A _3810_/B VDD VSS sg13cmos5l_xnor2_1
X_4790_ _4873_/A _4790_/A _4790_/B VDD VSS sg13cmos5l_xor2_1
X_3672_ _3672_/Y _6436_/A VDD VSS sg13cmos5l_inv_1
X_5342_ _5367_/B _7079_/Q _5343_/B VDD VSS sg13cmos5l_nand2_1
X_5411_ _5413_/B _5411_/A _5411_/B VDD VSS sg13cmos5l_xnor2_1
X_7083__311 _7083_/RESET_B VDD VSS sg13cmos5l_tiehi
X_6460_ _6460_/X _6457_/A _6455_/Y _6452_/A VDD VSS sg13cmos5l_a21o_1
X_6391_ _6409_/B _6392_/A _6392_/B VDD VSS sg13cmos5l_nand2_1
X_4155_ _4155_/Y _4155_/A _4155_/B VDD VSS sg13cmos5l_nor2_1
X_4224_ _4273_/B _7023_/Q _4232_/B _4222_/Y VDD VSS sg13cmos5l_a21oi_1
X_5273_ _5273_/X _5274_/A _5274_/B VDD VSS sg13cmos5l_or2_1
X_7012_ _7012_/Q clkload6/A _7012_/D _7012_/RESET_B VDD VSS sg13cmos5l_dfrbpq_1
XFILLER_24_612 VDD VSS sg13cmos5l_fill_2
XFILLER_24_623 VDD VSS sg13cmos5l_fill_2
X_4086_ _4089_/A _5596_/A _4086_/B VDD VSS sg13cmos5l_xnor2_1
Xclkbuf_leaf_12_sd_clk _7270_/CLK clkload2/A VDD VSS sg13cmos5l_buf_8
X_7090__304 _7090_/RESET_B VDD VSS sg13cmos5l_tiehi
X_3939_ _4801_/B _6565_/A _6565_/B _6247_/A VDD VSS sg13cmos5l_a21oi_1
X_4988_ _5030_/C _4988_/A _4988_/B _4988_/C VDD VSS sg13cmos5l_and3_1
X_7315__393 _7315_/RESET_B VDD VSS sg13cmos5l_tiehi
X_6727_ _6729_/B _6747_/B _6727_/B VDD VSS sg13cmos5l_nand2b_1
X_6658_ _6661_/A _6658_/A _6658_/B VDD VSS sg13cmos5l_xor2_1
X_5609_ _5632_/A _5612_/B _5612_/C _5684_/A VDD VSS sg13cmos5l_a21oi_1
X_7129__263 _7129_/RESET_B VDD VSS sg13cmos5l_tiehi
X_6589_ _6691_/B _6589_/A _6589_/B VDD VSS sg13cmos5l_and2_1
XFILLER_30_637 VDD VSS sg13cmos5l_fill_2
XFILLER_10_383 VDD VSS sg13cmos5l_fill_2
XFILLER_30_659 VDD VSS sg13cmos5l_decap_4
XFILLER_37_203 VDD VSS sg13cmos5l_fill_1
X_4911_ _4914_/B _7060_/Q _4911_/B VDD VSS sg13cmos5l_xnor2_1
X_5891_ _7138_/D _5901_/A _5891_/B VDD VSS sg13cmos5l_nor2_1
X_5960_ _5960_/Y _7224_/Q _5981_/A2 _5980_/A2 _7179_/Q VDD VSS sg13cmos5l_a22oi_1
X_3724_ _3749_/B _3722_/A _3729_/A _3758_/A VDD VSS sg13cmos5l_a21o_1
X_4773_ _4773_/Y _4774_/A _4774_/B VDD VSS sg13cmos5l_nor2_1
X_4842_ _4844_/B _4841_/B _5596_/B VDD VSS sg13cmos5l_nand2b_1
X_6512_ _6536_/B _6995_/Q _6513_/B VDD VSS sg13cmos5l_nand2_1
X_3655_ _6091_/A _7167_/Q VDD VSS sg13cmos5l_inv_1
X_5325_ _5325_/Y _5370_/A _5324_/B _5376_/A VDD VSS sg13cmos5l_o21ai_1
X_6443_ _6444_/A _6443_/A _6443_/B VDD VSS sg13cmos5l_xor2_1
X_6374_ _6375_/B _6374_/A _6374_/B VDD VSS sg13cmos5l_nor2_1
X_4138_ _4138_/Y _4182_/A _4138_/B VDD VSS sg13cmos5l_nand2_1
X_4207_ _4209_/B _4207_/A _4207_/B VDD VSS sg13cmos5l_xor2_1
X_5187_ _5189_/B _7095_/Q _5187_/B VDD VSS sg13cmos5l_xnor2_1
X_5256_ _5257_/B _5256_/A _5256_/B VDD VSS sg13cmos5l_xnor2_1
XFILLER_11_114 VDD VSS sg13cmos5l_fill_2
X_4069_ _4201_/B _4063_/Y _4069_/B VDD VSS sg13cmos5l_nand2b_1
XFILLER_22_87 VDD VSS sg13cmos5l_fill_1
XFILLER_28_781 VDD VSS sg13cmos5l_decap_8
Xfanout160 _6932_/B1 _4596_/A VDD VSS sg13cmos5l_buf_1
Xfanout171 _5845_/A _5159_/A VDD VSS sg13cmos5l_buf_1
X_7073__321 _7073_/RESET_B VDD VSS sg13cmos5l_tiehi
XFILLER_30_467 VDD VSS sg13cmos5l_fill_1
X_7080__314 _7080_/RESET_B VDD VSS sg13cmos5l_tiehi
X_5041_ _5042_/B _5787_/C _4931_/A _5040_/Y VDD VSS sg13cmos5l_a21oi_1
X_5110_ _5113_/A _7065_/Q _5110_/B VDD VSS sg13cmos5l_xnor2_1
X_6090_ _7199_/D _6073_/Y _7199_/Q _6090_/S VDD VSS sg13cmos5l_mux2_1
XFILLER_21_412 VDD VSS sg13cmos5l_fill_2
XFILLER_33_261 VDD VSS sg13cmos5l_fill_1
X_5874_ _5877_/B _7129_/Q _7128_/Q _7130_/Q VDD VSS sg13cmos5l_a21oi_1
X_5943_ _7156_/D _5942_/X _3705_/B _5943_/S VDD VSS sg13cmos5l_mux2_1
X_6992_ _6992_/Q _7266_/CLK _6992_/D _6992_/RESET_B VDD VSS sg13cmos5l_dfrbpq_1
XFILLER_21_489 VDD VSS sg13cmos5l_fill_2
X_3707_ _3824_/B _3796_/A _3796_/B _3706_/Y VDD VSS sg13cmos5l_o21ai_1
X_4687_ _4687_/Y _4688_/A _4688_/B VDD VSS sg13cmos5l_nor2b_1
X_4756_ _4921_/A _4756_/A _4756_/B _4756_/C VDD VSS sg13cmos5l_and3_1
X_4825_ _4825_/Y _4827_/A _4827_/B VDD VSS sg13cmos5l_nand2_1
X_7312__396 _7312_/RESET_B VDD VSS sg13cmos5l_tiehi
X_3638_ _5469_/A _7111_/Q VDD VSS sg13cmos5l_inv_1
X_5308_ _5310_/B _5308_/A _5308_/B VDD VSS sg13cmos5l_xnor2_1
X_6426_ _6427_/B _6905_/A _6434_/B VDD VSS sg13cmos5l_nor2_1
X_6357_ _6358_/B _6355_/A _6355_/B _6355_/C VDD VSS sg13cmos5l_a21oi_1
X_6288_ _6291_/A _6288_/A _6288_/B VDD VSS sg13cmos5l_xnor2_1
XFILLER_17_65 VDD VSS sg13cmos5l_fill_2
X_5239_ _5242_/B _7072_/Q _5239_/B VDD VSS sg13cmos5l_nand2_1
XFILLER_40_743 VDD VSS sg13cmos5l_fill_2
XFILLER_35_559 VDD VSS sg13cmos5l_fill_2
XFILLER_31_787 VDD VSS sg13cmos5l_fill_1
X_4541_ _4543_/B _4541_/A _6172_/B VDD VSS sg13cmos5l_xnor2_1
X_4610_ _4623_/A _4610_/A _4610_/B VDD VSS sg13cmos5l_nand2_1
X_5590_ _7115_/D _5590_/A _5589_/Y VDD VSS sg13cmos5l_nor2b_1
XFILLER_31_0 VDD VSS sg13cmos5l_fill_1
X_4472_ _4474_/B _7066_/Q _4159_/B _4157_/X VDD VSS sg13cmos5l_a21oi_1
X_6142_ _7289_/D _7289_/Q _7135_/Q _6164_/S VDD VSS sg13cmos5l_mux2_1
X_6211_ _6211_/Y _6210_/A _6210_/B _6563_/A VDD VSS sg13cmos5l_a21oi_1
X_7260_ _7261_/D _7266_/CLK _7260_/D _6584_/B1 VDD VSS sg13cmos5l_dfrbpq_1
X_7191_ _7191_/Q _7220_/CLK _7191_/D _7191_/RESET_B VDD VSS sg13cmos5l_dfrbpq_1
X_7045__264 _7045_/RESET_B VDD VSS sg13cmos5l_tiehi
X_5024_ _5027_/B _5024_/A _4988_/B VDD VSS sg13cmos5l_nor2b_1
X_6073_ _6073_/Y _6071_/A _6071_/B _6068_/Y VDD VSS sg13cmos5l_o21ai_1
XFILLER_22_743 VDD VSS sg13cmos5l_fill_1
X_5857_ _5868_/A _7127_/Q _7244_/Q VDD VSS sg13cmos5l_xor2_1
X_5926_ _5926_/Y _5926_/A _7150_/Q VDD VSS sg13cmos5l_nor2b_1
X_6975_ _6977_/B _6981_/A _6981_/C VDD VSS sg13cmos5l_and2_1
X_4739_ _4741_/B _4739_/A _4739_/B VDD VSS sg13cmos5l_xnor2_1
X_4808_ _4809_/B _4808_/A _4808_/B VDD VSS sg13cmos5l_xor2_1
X_5788_ _5790_/C _5788_/A _5788_/B VDD VSS sg13cmos5l_xnor2_1
X_6409_ _6409_/Y _6409_/A _6409_/B _6409_/C VDD VSS sg13cmos5l_nand3_1
XFILLER_28_42 VDD VSS sg13cmos5l_fill_1
XFILLER_32_507 VDD VSS sg13cmos5l_fill_2
XFILLER_13_787 VDD VSS sg13cmos5l_fill_1
XFILLER_4_463 VDD VSS sg13cmos5l_fill_1
X_7226__441 _7226_/RESET_B VDD VSS sg13cmos5l_tiehi
XFILLER_35_356 VDD VSS sg13cmos5l_fill_1
XFILLER_35_378 VDD VSS sg13cmos5l_decap_4
X_3972_ _3974_/B _3972_/A _3972_/B VDD VSS sg13cmos5l_xnor2_1
X_5711_ _5714_/A _5735_/A _5674_/B _5672_/Y VDD VSS sg13cmos5l_a21oi_1
X_6760_ _6765_/C _6739_/A _6760_/B VDD VSS sg13cmos5l_nand2b_1
X_6691_ _6696_/B _6691_/A _6691_/B _6691_/C _6691_/D VDD VSS sg13cmos5l_nand4_1
X_4524_ _4524_/X _4524_/A _4524_/B VDD VSS sg13cmos5l_or2_1
X_5573_ _5575_/B _5573_/A _5573_/B VDD VSS sg13cmos5l_xor2_1
X_5642_ _5680_/A _5642_/A VDD VSS sg13cmos5l_inv_1
X_7312_ _7312_/Q clkload3/A _7312_/D _7312_/RESET_B VDD VSS sg13cmos5l_dfrbpq_1
X_4386_ _4388_/C _7027_/Q _4386_/B VDD VSS sg13cmos5l_xnor2_1
X_4455_ _4455_/Y _4419_/B _6986_/A _4436_/Y _6982_/A _4436_/A VDD VSS sg13cmos5l_a221oi_1
X_6125_ _7272_/D _7272_/Q _7134_/Q _6132_/S VDD VSS sg13cmos5l_mux2_1
X_7243_ _7244_/D _7243_/CLK input2/X _7243_/RESET_B VDD VSS sg13cmos5l_dfrbpq_1
X_7174_ _7174_/Q clkload4/A _7174_/D _7174_/RESET_B VDD VSS sg13cmos5l_dfrbpq_1
XFILLER_38_194 VDD VSS sg13cmos5l_fill_2
X_5007_ _5007_/Y _5008_/A _5008_/B VDD VSS sg13cmos5l_nand2_1
X_6056_ _7180_/D _7180_/Q _6055_/X _6062_/S VDD VSS sg13cmos5l_mux2_1
X_5909_ _7147_/D _6990_/A _5909_/B VDD VSS sg13cmos5l_nor2_1
X_6958_ _6958_/Y _4379_/A _6957_/Y _6956_/A VDD VSS sg13cmos5l_o21ai_1
X_6889_ _6891_/B _7041_/Q _6877_/B _4470_/A VDD VSS sg13cmos5l_a21oi_1
X_7139__243 _7139_/RESET_B VDD VSS sg13cmos5l_tiehi
XFILLER_13_540 VDD VSS sg13cmos5l_decap_4
X_4171_ _4176_/B _4171_/A _4171_/B _4171_/C VDD VSS sg13cmos5l_nand3_1
X_4240_ _6172_/B _6469_/A _6467_/B VDD VSS sg13cmos5l_xnor2_1
XFILLER_27_109 VDD VSS sg13cmos5l_fill_2
XFILLER_36_665 VDD VSS sg13cmos5l_fill_1
XFILLER_36_687 VDD VSS sg13cmos5l_fill_1
X_7192__201 _7192_/RESET_B VDD VSS sg13cmos5l_tiehi
X_6812_ _6812_/Y _6779_/Y _6796_/Y _6797_/Y VDD VSS sg13cmos5l_a21oi_1
XFILLER_23_326 VDD VSS sg13cmos5l_fill_2
XFILLER_35_186 VDD VSS sg13cmos5l_fill_2
X_3886_ _5917_/B _7236_/Q _7237_/Q _3886_/C VDD VSS sg13cmos5l_and3_1
X_3955_ _4724_/B _6565_/A _6565_/B _6226_/A VDD VSS sg13cmos5l_nand3_1
X_5625_ _5662_/B _5627_/A _5625_/B _5625_/C VDD VSS sg13cmos5l_and3_1
X_6743_ _6757_/A _7005_/Q _6733_/B _6731_/Y VDD VSS sg13cmos5l_a21oi_1
X_6674_ _6684_/A _7029_/Q _6664_/B _6662_/X VDD VSS sg13cmos5l_a21o_1
X_4438_ _4439_/C _4427_/B _4427_/C _7061_/Q VDD VSS sg13cmos5l_a21o_1
X_4507_ _4510_/B _6989_/A _4464_/B _4506_/Y VDD VSS sg13cmos5l_a21oi_1
X_5487_ _5489_/C _5487_/A VDD VSS sg13cmos5l_inv_1
X_5556_ _5556_/Y _5557_/A _5557_/B VDD VSS sg13cmos5l_nand2_1
X_7226_ _7226_/Q _7298_/CLK _7226_/D _7226_/RESET_B VDD VSS sg13cmos5l_dfrbpq_1
X_4369_ _4369_/Y _4370_/A _4370_/B VDD VSS sg13cmos5l_nand2_1
X_6039_ _7177_/D _7177_/Q _6038_/Y _6062_/S VDD VSS sg13cmos5l_mux2_1
X_6108_ _7215_/D _7215_/Q _6000_/X _6115_/S VDD VSS sg13cmos5l_mux2_1
X_7157_ _7157_/Q _7220_/CLK _7157_/D fanout144/X VDD VSS sg13cmos5l_dfrbpq_1
X_7088_ _7088_/Q _7243_/CLK _7088_/D _7088_/RESET_B VDD VSS sg13cmos5l_dfrbpq_1
XFILLER_14_348 VDD VSS sg13cmos5l_fill_2
XFILLER_27_676 VDD VSS sg13cmos5l_fill_1
XFILLER_39_492 VDD VSS sg13cmos5l_fill_1
X_7216__451 _7216_/RESET_B VDD VSS sg13cmos5l_tiehi
XFILLER_41_178 VDD VSS sg13cmos5l_fill_1
XFILLER_6_514 VDD VSS sg13cmos5l_fill_2
XFILLER_9_0 VDD VSS sg13cmos5l_fill_1
X_7223__444 _7223_/RESET_B VDD VSS sg13cmos5l_tiehi
XFILLER_33_602 VDD VSS sg13cmos5l_fill_2
XFILLER_37_418 VDD VSS sg13cmos5l_fill_1
X_3740_ _3848_/A _7123_/Q _6720_/A VDD VSS sg13cmos5l_xnor2_1
X_3671_ _5623_/A _7089_/Q VDD VSS sg13cmos5l_inv_1
X_5341_ _5343_/B _5341_/A _5341_/B VDD VSS sg13cmos5l_xnor2_1
X_5410_ _5411_/B _5435_/B _5410_/B VDD VSS sg13cmos5l_xnor2_1
X_6390_ _6392_/B _7011_/Q _6428_/A VDD VSS sg13cmos5l_xnor2_1
X_4085_ _4092_/B _4329_/A _4329_/B _4084_/Y VDD VSS sg13cmos5l_o21ai_1
X_4154_ _4155_/B _4155_/A _4154_/B _4154_/C VDD VSS sg13cmos5l_nor3_1
X_4223_ _4232_/B _4223_/A _4223_/B VDD VSS sg13cmos5l_xor2_1
X_5272_ _5274_/B _5272_/A _5272_/B VDD VSS sg13cmos5l_xnor2_1
X_7011_ _7011_/Q clkload6/A _7011_/D _7011_/RESET_B VDD VSS sg13cmos5l_dfrbpq_1
XFILLER_36_440 VDD VSS sg13cmos5l_fill_2
X_3869_ _3869_/X _3869_/A _3869_/B _3869_/C VDD VSS sg13cmos5l_or3_1
X_3938_ _3970_/A _6226_/A _4806_/A VDD VSS sg13cmos5l_xnor2_1
X_4987_ _5030_/B _4988_/B _4988_/C _4988_/A VDD VSS sg13cmos5l_a21oi_1
X_5608_ _5612_/C _5608_/A _5608_/B _5644_/B VDD VSS sg13cmos5l_nand3_1
X_6726_ _6727_/B _6726_/A _6726_/B _6726_/C VDD VSS sg13cmos5l_nand3_1
X_6657_ _6657_/X _6658_/A _6658_/B VDD VSS sg13cmos5l_or2_1
X_6588_ _6589_/B _6588_/A _6588_/B VDD VSS sg13cmos5l_nand2_1
X_5539_ _5575_/A _5540_/B _5540_/A VDD VSS sg13cmos5l_nor2b_1
X_7209_ _7209_/Q _7220_/CLK _7209_/D _7209_/RESET_B VDD VSS sg13cmos5l_dfrbpq_1
XFILLER_27_473 VDD VSS sg13cmos5l_fill_1
X_7182__211 _7182_/RESET_B VDD VSS sg13cmos5l_tiehi
XFILLER_38_727 VDD VSS sg13cmos5l_fill_2
XFILLER_18_462 VDD VSS sg13cmos5l_fill_2
X_4841_ _4841_/Y _5595_/B _4841_/B VDD VSS sg13cmos5l_nor2_1
X_4910_ _4911_/B _4910_/A _4910_/B VDD VSS sg13cmos5l_xnor2_1
X_5890_ _5891_/B _7138_/Q _5896_/A2 _5896_/B1 _7137_/Q VDD VSS sg13cmos5l_a22oi_1
XFILLER_20_148 VDD VSS sg13cmos5l_fill_1
X_3654_ _3881_/A _7234_/Q VDD VSS sg13cmos5l_inv_1
X_3723_ _3748_/B _3722_/A _3729_/A _3758_/A VDD VSS sg13cmos5l_a21oi_1
X_4772_ _4774_/B _4772_/A _4772_/B VDD VSS sg13cmos5l_xnor2_1
X_6511_ _6513_/B _6511_/A _6511_/B VDD VSS sg13cmos5l_xor2_1
X_6442_ _6452_/A _6443_/A _6443_/B VDD VSS sg13cmos5l_nor2_1
X_5255_ _5255_/Y _5256_/B _5256_/A VDD VSS sg13cmos5l_nor2b_1
X_5324_ _5347_/B _5370_/A _5324_/B VDD VSS sg13cmos5l_nor2_1
X_6373_ _6374_/B _6373_/A VDD VSS sg13cmos5l_inv_1
X_4068_ _4069_/B _4063_/B _4063_/C _4063_/A VDD VSS sg13cmos5l_o21ai_1
X_4137_ _4164_/A _4299_/A _4121_/Y _4123_/Y _4421_/B _4136_/X VDD VSS sg13cmos5l_a221oi_1
X_4206_ _4217_/B _7024_/Q _4218_/B VDD VSS sg13cmos5l_nand2_1
X_5186_ _5187_/B _6772_/A _5186_/B VDD VSS sg13cmos5l_xnor2_1
XFILLER_24_454 VDD VSS sg13cmos5l_fill_1
X_7213__454 _7213_/RESET_B VDD VSS sg13cmos5l_tiehi
X_7055__244 _7055_/RESET_B VDD VSS sg13cmos5l_tiehi
XFILLER_22_66 VDD VSS sg13cmos5l_fill_2
X_6709_ _6709_/Y _6710_/B _6710_/A VDD VSS sg13cmos5l_nand2b_1
Xfanout150 _6253_/A _6672_/B1 VDD VSS sg13cmos5l_buf_1
Xfanout161 _4596_/A _6940_/A VDD VSS sg13cmos5l_buf_1
Xfanout172 _5159_/A _5160_/A VDD VSS sg13cmos5l_buf_1
X_7220__447 _7220_/RESET_B VDD VSS sg13cmos5l_tiehi
XFILLER_28_760 VDD VSS sg13cmos5l_fill_1
XFILLER_30_424 VDD VSS sg13cmos5l_decap_4
XFILLER_8_46 VDD VSS sg13cmos5l_fill_2
X_5040_ _5040_/Y _6745_/B _5787_/C VDD VSS sg13cmos5l_nor2_1
X_6991_ _6991_/Q _7270_/CLK _6991_/D _6991_/RESET_B VDD VSS sg13cmos5l_dfrbpq_1
XFILLER_33_284 VDD VSS sg13cmos5l_fill_1
X_4824_ _4827_/B _7058_/Q _4824_/B VDD VSS sg13cmos5l_xnor2_1
X_5873_ _7129_/D _5873_/A _5873_/B VDD VSS sg13cmos5l_nor2_1
X_5942_ _5942_/X _7174_/Q _7189_/Q _7204_/Q _7219_/Q _7149_/Q _7150_/Q VDD VSS sg13cmos5l_mux4_1
X_3637_ _3808_/A _7112_/Q VDD VSS sg13cmos5l_inv_1
X_3706_ _3706_/Y _3790_/A _3708_/D VDD VSS sg13cmos5l_nor2_1
X_4686_ _4688_/B _4686_/A _4686_/B VDD VSS sg13cmos5l_xor2_1
X_4755_ _4756_/C _4755_/A _4755_/B VDD VSS sg13cmos5l_nand2_1
X_6425_ _6434_/B _6424_/B _6446_/A _6424_/A VDD VSS sg13cmos5l_a21oi_1
X_5238_ _5239_/B _6469_/A _5238_/B VDD VSS sg13cmos5l_xor2_1
X_5307_ _5334_/A _6177_/A _5308_/B VDD VSS sg13cmos5l_nand2_1
X_6356_ _6358_/A _6356_/A VDD VSS sg13cmos5l_inv_1
X_6287_ _6304_/B _6288_/A _6288_/B VDD VSS sg13cmos5l_nor2_1
X_5169_ _5170_/B _5169_/A _5169_/B VDD VSS sg13cmos5l_xor2_1
X_7172__221 _7172_/RESET_B VDD VSS sg13cmos5l_tiehi
XFILLER_33_43 VDD VSS sg13cmos5l_fill_1
XFILLER_28_590 VDD VSS sg13cmos5l_fill_1
XFILLER_31_733 VDD VSS sg13cmos5l_fill_1
X_4471_ _4474_/A _7067_/Q _6804_/B VDD VSS sg13cmos5l_xnor2_1
X_4540_ _7073_/D _6563_/A _4540_/B VDD VSS sg13cmos5l_nor2_1
X_6072_ _7183_/D _7183_/Q _6071_/Y _6074_/S VDD VSS sg13cmos5l_mux2_1
X_6141_ _7288_/D _7288_/Q _7134_/Q _6164_/S VDD VSS sg13cmos5l_mux2_1
X_6210_ _6212_/A _6210_/A _6210_/B VDD VSS sg13cmos5l_nor2_1
X_7190_ _7190_/Q _7220_/CLK _7190_/D _7190_/RESET_B VDD VSS sg13cmos5l_dfrbpq_1
XFILLER_19_590 VDD VSS sg13cmos5l_fill_2
XFILLER_38_310 VDD VSS sg13cmos5l_fill_2
XFILLER_38_398 VDD VSS sg13cmos5l_decap_8
X_5023_ _5027_/A _7063_/Q _5023_/B VDD VSS sg13cmos5l_xnor2_1
X_6974_ _7060_/D _4313_/Y _6972_/Y _6973_/Y VDD VSS sg13cmos5l_a21oi_1
XFILLER_22_722 VDD VSS sg13cmos5l_fill_1
XFILLER_22_777 VDD VSS sg13cmos5l_fill_2
X_4807_ _4807_/Y _4808_/A _4808_/B VDD VSS sg13cmos5l_nor2_1
X_5787_ _5788_/B _5818_/C _5787_/B _5787_/C VDD VSS sg13cmos5l_nand3_1
X_5856_ _5858_/A _5856_/A _5875_/A VDD VSS sg13cmos5l_nor2_1
X_5925_ _5925_/Y _7150_/Q _5926_/A VDD VSS sg13cmos5l_nor2_1
X_4669_ _4671_/A _4754_/A VDD VSS sg13cmos5l_inv_1
X_4738_ _4739_/B _4761_/C _4761_/D VDD VSS sg13cmos5l_nand2_1
X_6408_ _6411_/A _6409_/A _6409_/B _6409_/C VDD VSS sg13cmos5l_and3_1
XFILLER_0_169 VDD VSS sg13cmos5l_fill_1
X_6339_ _6339_/X _6335_/C _6337_/Y _6317_/Y VDD VSS sg13cmos5l_a21o_1
XFILLER_17_505 VDD VSS sg13cmos5l_fill_1
XFILLER_17_527 VDD VSS sg13cmos5l_fill_2
XFILLER_17_538 VDD VSS sg13cmos5l_decap_4
XFILLER_31_574 VDD VSS sg13cmos5l_fill_2
X_3971_ _4087_/A _3972_/A _3972_/B VDD VSS sg13cmos5l_nand2b_1
X_5641_ _5642_/A _5643_/A _5643_/B VDD VSS sg13cmos5l_nand2_1
X_5710_ _5718_/B _5710_/A VDD VSS sg13cmos5l_inv_1
X_6690_ _6691_/D _6692_/A _6692_/C VDD VSS sg13cmos5l_nor2_1
X_4454_ _6982_/A _4447_/B _6978_/A _4446_/A VDD VSS sg13cmos5l_a21o_1
X_4523_ _7070_/D _4520_/Y _4521_/Y _4522_/Y VDD VSS sg13cmos5l_a21oi_1
X_5572_ _5605_/A _5573_/A _5573_/B VDD VSS sg13cmos5l_nor2_1
X_7242_ _7242_/Q clkload3/A _7242_/D _7242_/RESET_B VDD VSS sg13cmos5l_dfrbpq_1
X_7311_ _7311_/Q clkload3/A _7311_/D _7311_/RESET_B VDD VSS sg13cmos5l_dfrbpq_1
XFILLER_39_641 VDD VSS sg13cmos5l_fill_2
X_4385_ _4388_/B _7026_/Q _4385_/B VDD VSS sg13cmos5l_nand2_1
X_5006_ _5008_/B _5154_/A _5006_/B VDD VSS sg13cmos5l_xor2_1
X_6055_ _6055_/X _6055_/A _6055_/B VDD VSS sg13cmos5l_xor2_1
X_6124_ _7271_/D _7271_/Q _7242_/Q _6132_/S VDD VSS sg13cmos5l_mux2_1
X_7173_ _7173_/Q _7308_/CLK _7173_/D _7173_/RESET_B VDD VSS sg13cmos5l_dfrbpq_1
XFILLER_26_379 VDD VSS sg13cmos5l_fill_1
X_6957_ _6957_/Y _4378_/B _6955_/B _4376_/Y VDD VSS sg13cmos5l_a21oi_1
XFILLER_10_714 VDD VSS sg13cmos5l_fill_2
XFILLER_22_552 VDD VSS sg13cmos5l_fill_2
XFILLER_22_563 VDD VSS sg13cmos5l_fill_1
XFILLER_30_22 VDD VSS sg13cmos5l_fill_1
XFILLER_6_729 VDD VSS sg13cmos5l_fill_2
X_5839_ _5852_/A _5840_/A _5840_/B VDD VSS sg13cmos5l_or2_1
X_5908_ _5909_/B _7147_/Q _5881_/C _5910_/B1 _7146_/Q VDD VSS sg13cmos5l_a22oi_1
X_6888_ _6891_/A _7042_/Q _6907_/B VDD VSS sg13cmos5l_xnor2_1
XFILLER_40_393 VDD VSS sg13cmos5l_fill_1
XFILLER_5_751 VDD VSS sg13cmos5l_fill_2
X_4170_ _4171_/C _4151_/B _4151_/C _7065_/Q VDD VSS sg13cmos5l_a21o_1
XFILLER_35_121 VDD VSS sg13cmos5l_fill_2
XFILLER_36_600 VDD VSS sg13cmos5l_fill_1
XFILLER_36_655 VDD VSS sg13cmos5l_fill_2
X_6811_ _6816_/A _6811_/A _6811_/B VDD VSS sg13cmos5l_xnor2_1
X_3885_ _7236_/D _7236_/Q _3886_/C VDD VSS sg13cmos5l_xor2_1
X_3954_ _3956_/B _5330_/A _5330_/B _5597_/B VDD VSS sg13cmos5l_nor3_1
X_5624_ _5625_/C _5657_/A _5621_/C _7089_/Q VDD VSS sg13cmos5l_o21ai_1
X_6742_ _6742_/Y _6742_/A _6742_/B VDD VSS sg13cmos5l_nand2_1
X_6673_ _7029_/D _6653_/Y _6692_/C _6672_/Y VDD VSS sg13cmos5l_a21oi_1
X_4437_ _4439_/B _4437_/A _4437_/B VDD VSS sg13cmos5l_nand2_1
X_4506_ _4506_/Y _4506_/A _4506_/B VDD VSS sg13cmos5l_nand2_1
X_5486_ _5487_/A _5486_/A _5486_/B VDD VSS sg13cmos5l_xnor2_1
X_5555_ _5555_/Y _5557_/A _5557_/B VDD VSS sg13cmos5l_nor2_1
X_7225_ _7225_/Q _7298_/CLK _7225_/D _7225_/RESET_B VDD VSS sg13cmos5l_dfrbpq_1
X_7156_ _7156_/Q _7220_/CLK _7156_/D fanout144/X VDD VSS sg13cmos5l_dfrbpq_1
XFILLER_27_622 VDD VSS sg13cmos5l_fill_2
X_4299_ _4300_/C _4299_/A _4299_/B _4299_/C VDD VSS sg13cmos5l_and3_1
X_4368_ _4370_/B _4368_/A _4368_/B VDD VSS sg13cmos5l_xnor2_1
X_6038_ _6038_/Y _6038_/A _6038_/B VDD VSS sg13cmos5l_xnor2_1
X_6107_ _6107_/Y _6977_/A _6107_/B VDD VSS sg13cmos5l_nor2_1
X_7087_ _7087_/Q _7243_/CLK _7087_/D _7087_/RESET_B VDD VSS sg13cmos5l_dfrbpq_1
XFILLER_10_500 VDD VSS sg13cmos5l_fill_2
XFILLER_10_533 VDD VSS sg13cmos5l_fill_1
X_7065__224 _7065_/RESET_B VDD VSS sg13cmos5l_tiehi
XFILLER_2_732 VDD VSS sg13cmos5l_fill_1
XFILLER_18_655 VDD VSS sg13cmos5l_fill_1
XFILLER_33_636 VDD VSS sg13cmos5l_fill_2
X_3670_ _4908_/A _7087_/Q VDD VSS sg13cmos5l_inv_1
X_4222_ _4222_/Y _4223_/A _4223_/B VDD VSS sg13cmos5l_nor2_1
X_5271_ _5287_/B _5272_/A _5272_/B VDD VSS sg13cmos5l_or2_1
X_5340_ _5367_/A _5341_/B _5341_/A VDD VSS sg13cmos5l_nand2b_1
X_7010_ _7010_/Q clkload6/A _7010_/D _7010_/RESET_B VDD VSS sg13cmos5l_dfrbpq_1
X_4084_ _4084_/Y _4315_/A _4084_/B VDD VSS sg13cmos5l_nor2_1
X_4153_ _4154_/C _5153_/A _6745_/B _5159_/A VDD VSS sg13cmos5l_o21ai_1
XFILLER_24_614 VDD VSS sg13cmos5l_fill_1
X_3937_ _3951_/A _5788_/A _3937_/B VDD VSS sg13cmos5l_xnor2_1
X_4986_ _4988_/C _5024_/A _4985_/C _4985_/A VDD VSS sg13cmos5l_o21ai_1
X_6725_ _6747_/B _6726_/A _6726_/C _6726_/B VDD VSS sg13cmos5l_a21oi_1
X_3799_ _3799_/Y _7113_/Q _5381_/B VDD VSS sg13cmos5l_nand2_1
X_3868_ _3870_/A _3868_/A _3868_/B VDD VSS sg13cmos5l_xnor2_1
X_5538_ _5540_/B _5637_/A _5538_/B VDD VSS sg13cmos5l_xnor2_1
X_5607_ _5612_/B _5608_/A _5608_/B _5644_/B VDD VSS sg13cmos5l_a21o_1
X_6656_ _6658_/B _6720_/B _6656_/B VDD VSS sg13cmos5l_xnor2_1
X_6587_ _6691_/A _6560_/A _6560_/B _6586_/Y VDD VSS sg13cmos5l_o21ai_1
X_5469_ _5471_/B _5469_/A _5469_/B VDD VSS sg13cmos5l_xnor2_1
X_7208_ _7208_/Q _7220_/CLK _7208_/D _7208_/RESET_B VDD VSS sg13cmos5l_dfrbpq_1
X_7139_ _7139_/Q clkload3/A _7139_/D _7139_/RESET_B VDD VSS sg13cmos5l_dfrbpq_1
XFILLER_23_680 VDD VSS sg13cmos5l_fill_2
XFILLER_30_628 VDD VSS sg13cmos5l_decap_4
XFILLER_38_706 VDD VSS sg13cmos5l_fill_1
XFILLER_18_441 VDD VSS sg13cmos5l_fill_2
XFILLER_21_617 VDD VSS sg13cmos5l_fill_2
X_4840_ _4846_/A _4806_/A _4806_/B _4804_/Y VDD VSS sg13cmos5l_a21o_1
X_3653_ _7231_/D _7231_/Q VDD VSS sg13cmos5l_inv_1
X_3722_ _3759_/B _3722_/A _3729_/A VDD VSS sg13cmos5l_nand2_1
X_4771_ _4772_/B _4771_/A _4771_/B VDD VSS sg13cmos5l_xor2_1
X_6510_ _6536_/A _6511_/A _6511_/B VDD VSS sg13cmos5l_or2_1
X_6441_ _6443_/B _6440_/A _6430_/B _6428_/Y VDD VSS sg13cmos5l_a21oi_1
X_6372_ _6373_/A _6360_/A _6356_/A _6358_/B VDD VSS sg13cmos5l_a21oi_1
X_4205_ _4218_/B _4205_/A _4205_/B VDD VSS sg13cmos5l_xor2_1
X_5185_ _5185_/Y _6351_/B _5186_/B VDD VSS sg13cmos5l_nor2_1
X_5254_ _5256_/B _7101_/Q _6483_/B VDD VSS sg13cmos5l_xnor2_1
X_5323_ _5324_/B _5286_/Y _5301_/Y _5372_/B _5372_/A _5302_/Y VDD VSS sg13cmos5l_a221oi_1
X_4067_ _4201_/A _4196_/A _4195_/B VDD VSS sg13cmos5l_nor2_1
X_4136_ _4136_/X _4404_/B _4182_/B VDD VSS sg13cmos5l_or2_1
XFILLER_11_116 VDD VSS sg13cmos5l_fill_1
XFILLER_36_282 VDD VSS sg13cmos5l_fill_2
X_4969_ _4970_/B _5735_/A _5153_/C VDD VSS sg13cmos5l_xnor2_1
X_6708_ _6710_/B _7031_/Q _6708_/B VDD VSS sg13cmos5l_xnor2_1
XFILLER_20_683 VDD VSS sg13cmos5l_fill_1
X_6639_ _6639_/Y _7028_/Q _6640_/B VDD VSS sg13cmos5l_nand2_1
Xfanout140 _5212_/A _5224_/A VDD VSS sg13cmos5l_buf_1
Xfanout151 _6672_/B1 _6967_/A VDD VSS sg13cmos5l_buf_1
Xfanout162 _6940_/A fanout166/X VDD VSS sg13cmos5l_buf_1
Xfanout173 _5160_/A _7166_/Q VDD VSS sg13cmos5l_buf_1
XFILLER_15_444 VDD VSS sg13cmos5l_fill_1
XFILLER_30_436 VDD VSS sg13cmos5l_decap_8
X_5941_ _7155_/D _7155_/Q _5943_/S _5940_/Y VDD VSS sg13cmos5l_a21o_1
X_6990_ _7065_/D _6990_/A _6990_/B _6990_/C VDD VSS sg13cmos5l_nor3_1
X_4754_ _4756_/B _4754_/A _4754_/B _4754_/C VDD VSS sg13cmos5l_nand3_1
X_4823_ _4824_/B _4823_/A _4823_/B VDD VSS sg13cmos5l_xor2_1
X_5872_ _5873_/B _7129_/Q _7128_/Q _6402_/A VDD VSS sg13cmos5l_o21ai_1
X_7119__275 _7119_/RESET_B VDD VSS sg13cmos5l_tiehi
X_3636_ _5613_/A _7116_/Q VDD VSS sg13cmos5l_inv_1
X_3705_ _3708_/D _7157_/Q _3705_/B VDD VSS sg13cmos5l_xnor2_1
X_4685_ _4686_/B _4685_/A _4685_/B VDD VSS sg13cmos5l_xor2_1
X_6424_ _6427_/A _6424_/A _6424_/B _6446_/A VDD VSS sg13cmos5l_nand3_1
X_6355_ _6356_/A _6355_/A _6355_/B _6355_/C VDD VSS sg13cmos5l_nand3_1
X_5168_ _5168_/Y _5169_/A _5169_/B VDD VSS sg13cmos5l_nor2_1
X_5237_ _5242_/A _6469_/A _5238_/B VDD VSS sg13cmos5l_nand2_1
X_5306_ _7104_/D _5321_/B _5304_/Y _5305_/Y VDD VSS sg13cmos5l_a21oi_1
X_7126__268 _7126_/RESET_B VDD VSS sg13cmos5l_tiehi
X_6286_ _6288_/B _7003_/Q _6707_/A VDD VSS sg13cmos5l_xnor2_1
XFILLER_25_786 VDD VSS sg13cmos5l_fill_2
X_4119_ _4421_/B _4117_/B _4119_/B VDD VSS sg13cmos5l_nand2b_1
X_5099_ _5103_/B _4999_/A _4999_/B _5098_/X VDD VSS sg13cmos5l_o21ai_1
XFILLER_24_285 VDD VSS sg13cmos5l_fill_1
XFILLER_33_99 VDD VSS sg13cmos5l_fill_2
XFILLER_16_731 VDD VSS sg13cmos5l_fill_2
X_4470_ _4470_/Y _4470_/A _4470_/B VDD VSS sg13cmos5l_nor2_1
X_7307__401 _7307_/RESET_B VDD VSS sg13cmos5l_tiehi
X_5022_ _5023_/B _5022_/A _5022_/B VDD VSS sg13cmos5l_xor2_1
X_6071_ _6071_/Y _6071_/A _6071_/B VDD VSS sg13cmos5l_xnor2_1
X_6140_ _7287_/D _7287_/Q _7242_/Q _6164_/S VDD VSS sg13cmos5l_mux2_1
X_5924_ _7151_/D _7151_/Q _5924_/B VDD VSS sg13cmos5l_xnor2_1
X_6973_ _6973_/Y _4313_/Y _6972_/Y _6967_/A VDD VSS sg13cmos5l_o21ai_1
XFILLER_21_266 VDD VSS sg13cmos5l_fill_2
XFILLER_21_277 VDD VSS sg13cmos5l_fill_1
XFILLER_22_756 VDD VSS sg13cmos5l_fill_1
X_4737_ _4761_/D _4776_/B _4736_/C _4736_/A VDD VSS sg13cmos5l_o21ai_1
X_4806_ _4808_/B _4806_/A _4806_/B VDD VSS sg13cmos5l_xnor2_1
X_5786_ _5796_/A _7121_/Q _5772_/B _5770_/Y VDD VSS sg13cmos5l_a21oi_1
X_5855_ _5875_/A _7130_/Q _7129_/Q _7128_/Q VDD VSS sg13cmos5l_nand3_1
X_4599_ _4601_/B _7079_/Q _4599_/B VDD VSS sg13cmos5l_xnor2_1
X_4668_ _4754_/A _4668_/A _4668_/B _4668_/C VDD VSS sg13cmos5l_nand3_1
Xclkbuf_leaf_18_sd_clk clkload4/A clkbuf_leaf_2_sd_clk/A VDD VSS sg13cmos5l_buf_8
X_6407_ _6409_/C _6440_/A _6407_/B VDD VSS sg13cmos5l_xnor2_1
X_6338_ _6338_/Y _6323_/A _6329_/Y _6331_/B VDD VSS sg13cmos5l_o21ai_1
X_6269_ _6294_/A _6269_/A _6269_/B VDD VSS sg13cmos5l_xor2_1
XFILLER_40_531 VDD VSS sg13cmos5l_fill_2
X_7109__285 _7109_/RESET_B VDD VSS sg13cmos5l_tiehi
X_3970_ _3972_/B _3970_/A _3970_/B VDD VSS sg13cmos5l_xor2_1
X_5571_ _5573_/B _5637_/A _5571_/B VDD VSS sg13cmos5l_xnor2_1
X_5640_ _5643_/B _5679_/A _5639_/Y VDD VSS sg13cmos5l_nor2b_1
X_7116__278 _7116_/RESET_B VDD VSS sg13cmos5l_tiehi
X_4384_ _4385_/B _4390_/B VDD VSS sg13cmos5l_inv_1
X_4453_ _4453_/X _4453_/A _6983_/B _6981_/B _6981_/C VDD VSS sg13cmos5l_or4_1
X_4522_ _4522_/Y _4520_/Y _4521_/Y _5212_/A VDD VSS sg13cmos5l_o21ai_1
X_7241_ _7242_/D _7270_/CLK input3/X _7241_/RESET_B VDD VSS sg13cmos5l_dfrbpq_1
X_7310_ _7310_/Q _7316_/CLK _7310_/D _7310_/RESET_B VDD VSS sg13cmos5l_dfrbpq_1
X_7172_ _7172_/Q _7308_/CLK _7172_/D _7172_/RESET_B VDD VSS sg13cmos5l_dfrbpq_1
X_5005_ _5006_/B _5004_/B _3931_/B _5004_/Y VDD VSS sg13cmos5l_a21oi_1
X_6054_ _6054_/Y _6055_/A _6055_/B VDD VSS sg13cmos5l_nor2_1
X_6123_ _6123_/Y _7127_/Q _6123_/B _6123_/C VDD VSS sg13cmos5l_nor3_1
X_5907_ _7146_/D _5907_/A _5907_/B VDD VSS sg13cmos5l_nor2_1
Xclkbuf_leaf_5_sd_clk clkload6/A clkload0/A VDD VSS sg13cmos5l_buf_8
X_6956_ _7055_/D _6956_/A _6956_/B _6956_/C VDD VSS sg13cmos5l_and3_1
X_6887_ _7041_/D _6897_/B _6885_/Y _6886_/Y VDD VSS sg13cmos5l_a21oi_1
XFILLER_5_207 VDD VSS sg13cmos5l_fill_1
X_5769_ _5771_/B _5790_/B _5769_/B VDD VSS sg13cmos5l_nand2b_1
X_5838_ _5840_/B _7096_/Q _5825_/B _5823_/Y VDD VSS sg13cmos5l_a21oi_1
XFILLER_29_141 VDD VSS sg13cmos5l_fill_1
X_7304__404 _7304_/RESET_B VDD VSS sg13cmos5l_tiehi
XFILLER_23_328 VDD VSS sg13cmos5l_fill_1
X_3953_ _4724_/A _5330_/A _5330_/B _5597_/B VDD VSS sg13cmos5l_o21ai_1
X_6810_ _6827_/A _6811_/A _6811_/B VDD VSS sg13cmos5l_nor2_1
X_6741_ _7032_/D _6739_/A _6739_/B _6740_/Y VDD VSS sg13cmos5l_a21oi_1
XFILLER_31_372 VDD VSS sg13cmos5l_fill_1
X_3884_ _7235_/D _7235_/Q _3884_/B VDD VSS sg13cmos5l_xor2_1
X_5554_ _5557_/B _7087_/Q _5554_/B VDD VSS sg13cmos5l_xnor2_1
X_5623_ _5625_/B _5623_/A _5623_/B _5623_/C VDD VSS sg13cmos5l_nand3_1
X_6672_ _6672_/Y _6653_/Y _6692_/C _6672_/B1 VDD VSS sg13cmos5l_o21ai_1
X_4367_ _4368_/B _4029_/Y _4367_/B VDD VSS sg13cmos5l_nand2b_1
X_4436_ _4436_/Y _4436_/A _4436_/B _6986_/A _4436_/D VDD VSS sg13cmos5l_nor4_1
X_4505_ _4506_/B _4478_/A _4489_/Y _4490_/Y VDD VSS sg13cmos5l_a21oi_1
X_5485_ _5513_/A _5486_/A _5486_/B VDD VSS sg13cmos5l_nand2_1
X_6106_ _7214_/D _6073_/Y _7214_/Q _6106_/S VDD VSS sg13cmos5l_mux2_1
X_7224_ _7224_/Q _7224_/CLK _7224_/D _7224_/RESET_B VDD VSS sg13cmos5l_dfrbpq_1
X_7155_ _7155_/Q _7220_/CLK _7155_/D fanout144/X VDD VSS sg13cmos5l_dfrbpq_1
XFILLER_26_122 VDD VSS sg13cmos5l_fill_2
X_4298_ _4423_/B _4299_/A _4299_/B _4299_/C VDD VSS sg13cmos5l_a21oi_1
X_6037_ _6038_/B _7312_/Q _7296_/Q VDD VSS sg13cmos5l_xnor2_1
X_7086_ _7086_/Q _7243_/CLK _7086_/D _7086_/RESET_B VDD VSS sg13cmos5l_dfrbpq_1
X_6939_ _6940_/B _6938_/A _6938_/B _6938_/C VDD VSS sg13cmos5l_o21ai_1
X_7106__288 _7106_/RESET_B VDD VSS sg13cmos5l_tiehi
XFILLER_33_604 VDD VSS sg13cmos5l_fill_1
XFILLER_9_387 VDD VSS sg13cmos5l_fill_2
X_4221_ _4223_/B _7050_/Q _4585_/B VDD VSS sg13cmos5l_xnor2_1
X_5270_ _5272_/B _5270_/A _5270_/B VDD VSS sg13cmos5l_xor2_1
XFILLER_36_442 VDD VSS sg13cmos5l_fill_1
X_4083_ _4316_/A _4084_/B _4083_/B VDD VSS sg13cmos5l_nor2_1
X_4152_ _4161_/A _7065_/Q _4151_/C _4148_/Y VDD VSS sg13cmos5l_a21oi_1
XFILLER_23_136 VDD VSS sg13cmos5l_fill_1
XFILLER_24_659 VDD VSS sg13cmos5l_fill_2
X_3936_ _3937_/B _3936_/A _3936_/B VDD VSS sg13cmos5l_xor2_1
X_4985_ _4988_/B _4985_/A _5024_/A _4985_/C VDD VSS sg13cmos5l_or3_1
X_6724_ _6726_/C _6701_/A _6676_/Y _6701_/B VDD VSS sg13cmos5l_o21ai_1
X_3798_ _3798_/X _4046_/A _4046_/B VDD VSS sg13cmos5l_or2_1
X_3867_ _3871_/C _3827_/Y _3831_/Y _3866_/Y VDD VSS sg13cmos5l_a21oi_1
X_5537_ _5538_/B _5537_/A _5537_/B VDD VSS sg13cmos5l_xnor2_1
X_5606_ _5644_/B _5606_/A _5605_/Y VDD VSS sg13cmos5l_nor2b_1
X_6655_ _6666_/A _4288_/A _6638_/B _6639_/Y VDD VSS sg13cmos5l_o21ai_1
X_6586_ _6586_/Y _6583_/A _6589_/A _6581_/Y VDD VSS sg13cmos5l_a21oi_1
X_4419_ _4453_/A _4436_/A _4419_/B VDD VSS sg13cmos5l_nand2b_1
X_5399_ _5400_/B _5397_/A _5397_/B _5397_/C VDD VSS sg13cmos5l_a21o_1
X_5468_ _5469_/B _5492_/A _5468_/B VDD VSS sg13cmos5l_xnor2_1
X_7207_ _7207_/Q _7316_/CLK _7207_/D _7207_/RESET_B VDD VSS sg13cmos5l_dfrbpq_1
X_7138_ _7138_/Q clkload3/A _7138_/D _7138_/RESET_B VDD VSS sg13cmos5l_dfrbpq_1
X_7069_ _7069_/Q clkload7/A _7069_/D _7069_/RESET_B VDD VSS sg13cmos5l_dfrbpq_1
XFILLER_36_77 VDD VSS sg13cmos5l_fill_1
XFILLER_22_191 VDD VSS sg13cmos5l_fill_1
XFILLER_23_692 VDD VSS sg13cmos5l_fill_2
X_7301__407 _7301_/RESET_B VDD VSS sg13cmos5l_tiehi
XFILLER_18_464 VDD VSS sg13cmos5l_fill_1
X_4770_ _4770_/X _4771_/A _4771_/B VDD VSS sg13cmos5l_and2_1
X_3652_ _4252_/A _7046_/Q VDD VSS sg13cmos5l_inv_1
X_3721_ _3729_/A _7162_/Q _7160_/Q _7161_/Q VDD VSS sg13cmos5l_o21ai_1
X_5322_ _5322_/Y _5286_/Y _5301_/Y _5302_/Y VDD VSS sg13cmos5l_a21oi_1
X_6440_ _6443_/A _6440_/A _6440_/B VDD VSS sg13cmos5l_xnor2_1
X_6371_ _6374_/A _6371_/A _6371_/B VDD VSS sg13cmos5l_nor2_1
X_4135_ _4182_/B _4135_/A _4135_/B VDD VSS sg13cmos5l_xnor2_1
X_4204_ _4217_/A _4205_/A _4205_/B VDD VSS sg13cmos5l_nand2_1
X_5184_ _5186_/B _5184_/A _5184_/B _5184_/C VDD VSS sg13cmos5l_nor3_1
X_5253_ _6483_/B _5253_/A _6467_/B VDD VSS sg13cmos5l_xnor2_1
X_4066_ _4195_/B _4219_/A _4219_/B VDD VSS sg13cmos5l_nand2b_1
X_3919_ _4844_/A _5734_/S _6612_/A VDD VSS sg13cmos5l_xnor2_1
X_4899_ _4903_/D _4938_/B _4898_/B _4898_/C VDD VSS sg13cmos5l_a21oi_1
X_4968_ _5012_/A _5735_/B _5001_/B VDD VSS sg13cmos5l_nand2_1
X_6707_ _6708_/B _6707_/A _6707_/B VDD VSS sg13cmos5l_xnor2_1
X_6638_ _6640_/B _6663_/A _6638_/B VDD VSS sg13cmos5l_xnor2_1
X_6569_ _6571_/A _6569_/A _6569_/B VDD VSS sg13cmos5l_xor2_1
Xfanout130 _5907_/A _6990_/A VDD VSS sg13cmos5l_buf_1
Xfanout141 _5224_/A _6784_/A VDD VSS sg13cmos5l_buf_1
Xfanout152 _6967_/A _6956_/A VDD VSS sg13cmos5l_buf_1
Xfanout163 _5376_/A _4917_/A VDD VSS sg13cmos5l_buf_1
Xfanout174 _6745_/A fanout178/X VDD VSS sg13cmos5l_buf_1
XFILLER_7_622 VDD VSS sg13cmos5l_fill_2
XFILLER_7_644 VDD VSS sg13cmos5l_fill_2
XFILLER_26_5 VDD VSS sg13cmos5l_fill_2
XFILLER_38_537 VDD VSS sg13cmos5l_fill_2
X_5940_ _5940_/Y _5938_/Y _5939_/Y _5975_/A2 VDD VSS sg13cmos5l_a21oi_1
X_3704_ _3796_/C _7157_/Q _3705_/B VDD VSS sg13cmos5l_xor2_1
X_4753_ _4757_/A _4753_/A _4753_/B _4753_/C _4753_/D VDD VSS sg13cmos5l_or4_1
X_4822_ _4822_/Y _4823_/A _4823_/B VDD VSS sg13cmos5l_nor2_1
X_5871_ _5873_/A _7129_/Q _5881_/C _5902_/B1 _5854_/Y VDD VSS sg13cmos5l_a22oi_1
X_3635_ _3768_/A _7118_/Q VDD VSS sg13cmos5l_inv_1
X_4684_ _4684_/Y _4685_/A _4685_/B VDD VSS sg13cmos5l_nor2_1
X_5305_ _5305_/Y _5321_/B _5304_/Y _5376_/A VDD VSS sg13cmos5l_o21ai_1
X_6423_ _6446_/A _6393_/Y _6409_/Y _6411_/B VDD VSS sg13cmos5l_a21oi_1
X_6354_ _6355_/C _6381_/A _6354_/B VDD VSS sg13cmos5l_xnor2_1
X_6285_ _6304_/A _6686_/A _6750_/A VDD VSS sg13cmos5l_nor2_1
XFILLER_29_537 VDD VSS sg13cmos5l_decap_4
X_4118_ _4299_/B _3950_/Y _4285_/B _3949_/Y VDD VSS sg13cmos5l_o21ai_1
X_5098_ _5098_/X _5098_/A _5098_/B VDD VSS sg13cmos5l_and2_1
X_5167_ _5169_/B _7094_/Q _5167_/B VDD VSS sg13cmos5l_xnor2_1
X_5236_ _5238_/B _7099_/Q _6467_/B VDD VSS sg13cmos5l_xnor2_1
XFILLER_12_404 VDD VSS sg13cmos5l_fill_2
X_4049_ _4196_/A _4072_/B _4049_/B VDD VSS sg13cmos5l_xnor2_1
XFILLER_35_518 VDD VSS sg13cmos5l_decap_8
XFILLER_35_529 VDD VSS sg13cmos5l_fill_2
XFILLER_30_234 VDD VSS sg13cmos5l_fill_2
XFILLER_30_245 VDD VSS sg13cmos5l_fill_2
XFILLER_30_289 VDD VSS sg13cmos5l_fill_1
XFILLER_31_724 VDD VSS sg13cmos5l_fill_1
X_5021_ _5021_/Y _5022_/A _5022_/B VDD VSS sg13cmos5l_nor2_1
X_6070_ _6071_/B _6066_/A _6066_/B _6063_/X VDD VSS sg13cmos5l_a21o_1
XFILLER_19_592 VDD VSS sg13cmos5l_fill_1
X_5854_ _5854_/Y _7129_/Q _7128_/Q VDD VSS sg13cmos5l_nand2_1
X_5923_ _7150_/D _5921_/A _5921_/B _5922_/Y VDD VSS sg13cmos5l_a21oi_1
X_6972_ _6972_/Y _6972_/A _6972_/B VDD VSS sg13cmos5l_nor2_1
XFILLER_21_223 VDD VSS sg13cmos5l_fill_1
X_4667_ _4668_/C _7054_/Q _4667_/B VDD VSS sg13cmos5l_xnor2_1
X_4736_ _4761_/C _4736_/A _4776_/B _4736_/C VDD VSS sg13cmos5l_or3_1
X_4805_ _4806_/B _5597_/B _4683_/A _4805_/S VDD VSS sg13cmos5l_mux2_1
X_5785_ _5800_/A _7094_/Q _5775_/B _5773_/Y VDD VSS sg13cmos5l_a21o_1
X_4598_ _4629_/A _7079_/Q _4599_/B VDD VSS sg13cmos5l_nor2_1
X_6268_ _6292_/A _6269_/A _6269_/B VDD VSS sg13cmos5l_nand2b_1
X_6406_ _6420_/B _6440_/A _6407_/B VDD VSS sg13cmos5l_nand2_1
X_6337_ _6337_/Y _6337_/A _6337_/B VDD VSS sg13cmos5l_nand2_1
XFILLER_17_529 VDD VSS sg13cmos5l_fill_1
X_5219_ _5221_/B _7070_/Q _5219_/B VDD VSS sg13cmos5l_xnor2_1
X_6199_ _6199_/Y _6199_/A VDD VSS sg13cmos5l_inv_1
XFILLER_13_713 VDD VSS sg13cmos5l_fill_1
X_4521_ _4521_/Y _4524_/A _4521_/B VDD VSS sg13cmos5l_nor2_1
X_5570_ _5571_/B _5570_/A _5570_/B VDD VSS sg13cmos5l_xor2_1
X_4383_ _4390_/B _4383_/A _4383_/B VDD VSS sg13cmos5l_xor2_1
X_4452_ _6981_/C _6978_/A _4452_/B VDD VSS sg13cmos5l_nand2b_1
X_6122_ _7229_/D _7229_/Q _6073_/Y _6122_/S VDD VSS sg13cmos5l_mux2_1
X_7240_ _7240_/Q clkload8/A _7240_/D input4/X VDD VSS sg13cmos5l_dfrbpq_1
X_7171_ _7171_/Q clkload4/A _7171_/D _7171_/RESET_B VDD VSS sg13cmos5l_dfrbpq_1
XFILLER_39_643 VDD VSS sg13cmos5l_fill_1
X_5004_ _5004_/Y _5735_/B _5004_/B VDD VSS sg13cmos5l_nor2_1
X_6053_ _6055_/B _7314_/Q _7298_/Q _6052_/X VDD VSS sg13cmos5l_o21ai_1
XFILLER_22_554 VDD VSS sg13cmos5l_fill_1
X_5837_ _5840_/A _7097_/Q _5837_/B VDD VSS sg13cmos5l_xnor2_1
X_5906_ _5907_/B _7146_/Q _5881_/C _5910_/B1 _7145_/Q VDD VSS sg13cmos5l_a22oi_1
X_6955_ _6956_/C _6954_/B _6955_/B VDD VSS sg13cmos5l_nand2b_1
X_6886_ _6886_/Y _6897_/B _6885_/Y _6436_/A VDD VSS sg13cmos5l_o21ai_1
X_4719_ _4766_/A _6565_/C _4719_/B VDD VSS sg13cmos5l_nand2_1
X_5699_ _5729_/A _5563_/B _5562_/Y _5563_/X _5453_/A _5698_/Y VDD VSS sg13cmos5l_a221oi_1
X_5768_ _5769_/B _5768_/A _5768_/B _5768_/C VDD VSS sg13cmos5l_nand3_1
X_7208__185 _7208_/RESET_B VDD VSS sg13cmos5l_tiehi
XFILLER_17_304 VDD VSS sg13cmos5l_fill_1
XFILLER_9_514 VDD VSS sg13cmos5l_fill_2
X_7122__272 _7122_/RESET_B VDD VSS sg13cmos5l_tiehi
XFILLER_16_370 VDD VSS sg13cmos5l_fill_1
XFILLER_35_123 VDD VSS sg13cmos5l_fill_1
X_3883_ _3886_/C _7235_/Q _3884_/B VDD VSS sg13cmos5l_and2_1
X_3952_ _4885_/B _6565_/A _6565_/B _6226_/A VDD VSS sg13cmos5l_a21oi_1
X_6740_ _6740_/Y _6740_/A _6742_/B VDD VSS sg13cmos5l_nand2_1
X_6671_ _6692_/C _6669_/Y _6671_/B VDD VSS sg13cmos5l_nand2b_1
X_4504_ _4510_/A _4524_/A _4504_/B VDD VSS sg13cmos5l_nand2b_1
X_5484_ _5486_/B _5484_/A _5484_/B VDD VSS sg13cmos5l_xor2_1
X_5553_ _5554_/B _5553_/A _5553_/B VDD VSS sg13cmos5l_xor2_1
X_5622_ _5627_/C _5623_/B _5623_/C _7089_/Q VDD VSS sg13cmos5l_a21oi_1
X_4297_ _4299_/C _4423_/A _4297_/B VDD VSS sg13cmos5l_nand2b_1
X_4366_ _4377_/A _4366_/A _4366_/B VDD VSS sg13cmos5l_xnor2_1
X_4435_ _6983_/B _6986_/A _4436_/D VDD VSS sg13cmos5l_or2_1
X_6105_ _7213_/D _6071_/Y _7213_/Q _6105_/S VDD VSS sg13cmos5l_mux2_1
X_7223_ _7223_/Q _7298_/CLK _7223_/D _7223_/RESET_B VDD VSS sg13cmos5l_dfrbpq_1
X_7154_ _7154_/Q _7238_/CLK _7154_/D _6299_/A VDD VSS sg13cmos5l_dfrbpq_1
X_7085_ _7085_/Q _7243_/CLK _7085_/D _7085_/RESET_B VDD VSS sg13cmos5l_dfrbpq_1
XFILLER_26_134 VDD VSS sg13cmos5l_fill_2
XFILLER_27_624 VDD VSS sg13cmos5l_fill_1
X_6036_ _6038_/A _7311_/Q _7295_/Q _6033_/Y VDD VSS sg13cmos5l_a21o_1
X_6938_ _6941_/A _6938_/A _6938_/B _6938_/C VDD VSS sg13cmos5l_nor3_1
X_6869_ _6869_/Y _6897_/A VDD VSS sg13cmos5l_inv_1
XFILLER_18_613 VDD VSS sg13cmos5l_fill_2
XFILLER_33_627 VDD VSS sg13cmos5l_decap_4
X_4151_ _4171_/A _7065_/Q _4151_/B _4151_/C VDD VSS sg13cmos5l_nand3_1
X_4220_ _4223_/A _7049_/Q _4574_/B VDD VSS sg13cmos5l_nor2_1
X_4082_ _4083_/B _4329_/A _4329_/B VDD VSS sg13cmos5l_nor2_1
XFILLER_24_638 VDD VSS sg13cmos5l_decap_4
XFILLER_32_682 VDD VSS sg13cmos5l_fill_2
X_3866_ _3866_/Y _3827_/Y _3831_/Y _3865_/X VDD VSS sg13cmos5l_o21ai_1
X_3935_ _3935_/Y _3936_/A _3936_/B VDD VSS sg13cmos5l_nor2_1
X_4984_ _4985_/C _4984_/A _4984_/B _4984_/C VDD VSS sg13cmos5l_and3_1
X_5605_ _5605_/Y _5605_/A _5605_/B VDD VSS sg13cmos5l_nand2_1
X_6723_ _6726_/B _6723_/A VDD VSS sg13cmos5l_inv_1
X_6654_ _6654_/Y _6643_/A _6643_/B _6641_/Y VDD VSS sg13cmos5l_o21ai_1
X_3797_ _3797_/Y _4046_/A _4046_/B VDD VSS sg13cmos5l_nor2_1
X_4418_ _4419_/B _4416_/A _4416_/C _4416_/B VDD VSS sg13cmos5l_o21ai_1
X_5467_ _5467_/Y _5492_/A _5468_/B VDD VSS sg13cmos5l_nand2_1
X_5536_ _5536_/Y _5536_/A _5537_/B VDD VSS sg13cmos5l_nor2_1
X_7206_ _7206_/Q clkload4/A _7206_/D _7206_/RESET_B VDD VSS sg13cmos5l_dfrbpq_1
X_6585_ _7025_/D _6582_/Y _6583_/Y _6584_/Y VDD VSS sg13cmos5l_a21oi_1
X_4349_ _4349_/Y _7029_/Q _4362_/B VDD VSS sg13cmos5l_nand2_1
X_5398_ _5398_/Y _5400_/A VDD VSS sg13cmos5l_inv_1
X_6019_ _6019_/X _7309_/Q _7293_/Q VDD VSS sg13cmos5l_and2_1
X_7205__188 _7205_/RESET_B VDD VSS sg13cmos5l_tiehi
X_7137_ _7137_/Q _7308_/CLK _7137_/D _7137_/RESET_B VDD VSS sg13cmos5l_dfrbpq_1
X_7068_ _7068_/Q clkload7/A _7068_/D _7068_/RESET_B VDD VSS sg13cmos5l_dfrbpq_1
X_7136__249 _7136_/RESET_B VDD VSS sg13cmos5l_tiehi
XFILLER_22_170 VDD VSS sg13cmos5l_fill_2
XFILLER_22_181 VDD VSS sg13cmos5l_fill_2
XFILLER_6_358 VDD VSS sg13cmos5l_fill_1
X_7112__282 _7112_/RESET_B VDD VSS sg13cmos5l_tiehi
XFILLER_21_619 VDD VSS sg13cmos5l_fill_1
X_3720_ _3722_/A _3714_/A _3714_/B _3719_/Y VDD VSS sg13cmos5l_o21ai_1
XFILLER_5_380 VDD VSS sg13cmos5l_fill_1
XFILLER_9_163 VDD VSS sg13cmos5l_fill_2
X_3651_ _3651_/Y _7036_/Q VDD VSS sg13cmos5l_inv_1
X_5321_ _5372_/B _5321_/A _5321_/B VDD VSS sg13cmos5l_nor2_1
X_6370_ _6371_/B _6348_/B _6370_/B VDD VSS sg13cmos5l_nand2b_1
XFILLER_29_719 VDD VSS sg13cmos5l_fill_1
X_4134_ _4138_/B _4135_/A _4135_/B VDD VSS sg13cmos5l_nand2_1
X_4203_ _4205_/B _7051_/Q _4599_/B VDD VSS sg13cmos5l_xnor2_1
X_5183_ _5184_/C _5090_/A _5154_/Y _5157_/Y _5159_/Y VDD VSS sg13cmos5l_a22oi_1
X_5252_ _6497_/A _6185_/A _6528_/A VDD VSS sg13cmos5l_nand2_1
X_4065_ _4219_/B _5267_/A _4647_/B VDD VSS sg13cmos5l_xnor2_1
X_6998__382 _6998_/RESET_B VDD VSS sg13cmos5l_tiehi
X_3849_ _3856_/A _3854_/B _3854_/C _3854_/A VDD VSS sg13cmos5l_o21ai_1
X_3918_ _5004_/B _5734_/S _6675_/B VDD VSS sg13cmos5l_nand2_1
X_4898_ _4942_/A _4938_/B _4898_/B _4898_/C VDD VSS sg13cmos5l_and3_1
X_4967_ _4970_/A _4967_/A _4967_/B VDD VSS sg13cmos5l_xor2_1
X_6706_ _6706_/Y _6750_/A _6707_/B VDD VSS sg13cmos5l_nor2_1
X_6637_ _6638_/B _6637_/A _6637_/B VDD VSS sg13cmos5l_xnor2_1
X_6568_ _6568_/Y _6593_/A _6567_/C _6569_/A VDD VSS sg13cmos5l_a21oi_1
X_5519_ _5520_/B _5519_/A _5519_/B VDD VSS sg13cmos5l_xor2_1
Xfanout120 _5980_/B1 _5977_/B1 VDD VSS sg13cmos5l_buf_1
Xfanout131 _6905_/A _6990_/A VDD VSS sg13cmos5l_buf_1
X_6499_ _6501_/B _6994_/Q _6499_/B VDD VSS sg13cmos5l_xnor2_1
Xfanout142 _6784_/A _6985_/A VDD VSS sg13cmos5l_buf_1
Xfanout153 _6610_/A _6956_/A VDD VSS sg13cmos5l_buf_1
Xfanout164 _5528_/A _4917_/A VDD VSS sg13cmos5l_buf_1
Xfanout175 _5812_/A fanout178/X VDD VSS sg13cmos5l_buf_1
XFILLER_2_372 VDD VSS sg13cmos5l_fill_1
XFILLER_19_752 VDD VSS sg13cmos5l_fill_1
XFILLER_33_232 VDD VSS sg13cmos5l_fill_2
X_4821_ _4823_/B _7085_/Q _4821_/B VDD VSS sg13cmos5l_xnor2_1
X_5870_ _7128_/D _7128_/Q _5867_/Y _5869_/Y VDD VSS sg13cmos5l_a21oi_1
X_3634_ _3634_/Y _7120_/Q VDD VSS sg13cmos5l_inv_1
X_3703_ _3790_/B _7157_/Q _3705_/B VDD VSS sg13cmos5l_nand2_1
X_4683_ _4685_/B _4683_/A _4683_/B VDD VSS sg13cmos5l_xnor2_1
X_4752_ _4754_/C _4753_/B _4753_/D VDD VSS sg13cmos5l_nor2_1
X_6422_ _6424_/B _6395_/Y _6422_/B _6422_/C VDD VSS sg13cmos5l_nand3b_1
X_5235_ _5245_/A _7099_/Q _6467_/B VDD VSS sg13cmos5l_nor2_1
X_5304_ _5304_/Y _5372_/A _5288_/B _5286_/Y VDD VSS sg13cmos5l_a21oi_1
X_6353_ _6368_/B _6381_/A _6354_/B VDD VSS sg13cmos5l_nand2_1
X_6284_ _7002_/D _6275_/Y _6282_/Y _6283_/Y VDD VSS sg13cmos5l_a21oi_1
X_4048_ _4058_/A _4072_/B _4049_/B VDD VSS sg13cmos5l_and2_1
X_4117_ _4421_/A _4119_/B _4117_/B VDD VSS sg13cmos5l_nand2b_1
X_5097_ _5103_/A _5149_/A _5097_/B VDD VSS sg13cmos5l_or2_1
X_5166_ _5167_/B _5821_/A _5166_/B VDD VSS sg13cmos5l_xnor2_1
X_7102__292 _7102_/RESET_B VDD VSS sg13cmos5l_tiehi
X_5999_ _6005_/B _6000_/A _6000_/B VDD VSS sg13cmos5l_and2_1
XFILLER_31_703 VDD VSS sg13cmos5l_fill_2
XFILLER_38_324 VDD VSS sg13cmos5l_fill_1
X_5020_ _5022_/B _7090_/Q _5020_/B VDD VSS sg13cmos5l_xnor2_1
X_4804_ _4804_/Y _5597_/B _4805_/S VDD VSS sg13cmos5l_nor2_1
X_5784_ _7121_/D _6977_/A _5784_/B _5803_/B VDD VSS sg13cmos5l_nor3_1
X_5853_ _7125_/D _6905_/A _5853_/B _5853_/C VDD VSS sg13cmos5l_nor3_1
X_5922_ _5922_/Y _5926_/A _5921_/A _7150_/Q VDD VSS sg13cmos5l_a21oi_1
X_6995__385 _6995_/RESET_B VDD VSS sg13cmos5l_tiehi
X_6971_ _7059_/D _6971_/A _6971_/B _6972_/B VDD VSS sg13cmos5l_nor3_1
XFILLER_21_268 VDD VSS sg13cmos5l_fill_1
X_4597_ _4601_/A _4597_/A _4597_/B VDD VSS sg13cmos5l_nand2_1
X_4666_ _4702_/B _7054_/Q _4667_/B VDD VSS sg13cmos5l_nand2_1
X_4735_ _4735_/Y _4736_/A _4776_/B _4736_/C VDD VSS sg13cmos5l_nor3_1
X_6405_ _6407_/B _7012_/Q _6428_/A VDD VSS sg13cmos5l_xnor2_1
X_5218_ _5219_/B _5218_/A _5218_/B VDD VSS sg13cmos5l_xor2_1
X_6198_ _6199_/A _6198_/A _6198_/B VDD VSS sg13cmos5l_xnor2_1
X_6267_ _6269_/B _6612_/A _6256_/B _6254_/Y VDD VSS sg13cmos5l_o21ai_1
X_6336_ _6337_/B _6336_/A _6336_/B VDD VSS sg13cmos5l_nand2_1
XFILLER_25_530 VDD VSS sg13cmos5l_decap_4
X_5149_ _5150_/C _5149_/A _5149_/B VDD VSS sg13cmos5l_and2_1
XFILLER_40_533 VDD VSS sg13cmos5l_fill_1
X_4451_ _4452_/B _4450_/A _4450_/B _4450_/C VDD VSS sg13cmos5l_o21ai_1
X_4520_ _4520_/Y _4524_/B _4520_/B VDD VSS sg13cmos5l_nand2b_1
XFILLER_22_0 VDD VSS sg13cmos5l_fill_1
XFILLER_39_600 VDD VSS sg13cmos5l_fill_2
X_4382_ _4388_/A _4383_/B _4383_/A VDD VSS sg13cmos5l_nand2b_1
X_6052_ _6052_/X _7314_/Q _7298_/Q _6049_/A VDD VSS sg13cmos5l_a21o_1
X_6121_ _7228_/D _7228_/Q _6071_/Y _6122_/S VDD VSS sg13cmos5l_mux2_1
X_7170_ _7170_/Q _7238_/CLK _7170_/D _7170_/RESET_B VDD VSS sg13cmos5l_dfrbpq_1
XFILLER_39_633 VDD VSS sg13cmos5l_fill_2
X_5003_ _5008_/A _6700_/B _4963_/S _4964_/Y VDD VSS sg13cmos5l_o21ai_1
X_6954_ _6956_/B _6955_/B _6954_/B VDD VSS sg13cmos5l_nand2b_1
XFILLER_22_544 VDD VSS sg13cmos5l_fill_2
X_5767_ _5790_/B _5768_/A _5768_/B _5768_/C VDD VSS sg13cmos5l_a21oi_1
X_5836_ _5837_/B _5836_/A _5836_/B VDD VSS sg13cmos5l_xnor2_1
X_5905_ _7145_/D _5907_/A _5905_/B VDD VSS sg13cmos5l_nor2_1
X_6885_ _6885_/Y _6869_/Y _6874_/Y _6867_/Y VDD VSS sg13cmos5l_a21oi_1
X_4649_ _4651_/C _4648_/B _4648_/C _4648_/A VDD VSS sg13cmos5l_a21o_1
X_4718_ _4726_/C _5351_/B _4681_/B _4683_/B _4683_/A VDD VSS sg13cmos5l_a22oi_1
X_5698_ _5698_/Y _5700_/A _5698_/B _5702_/A _5701_/B VDD VSS sg13cmos5l_nand4_1
X_7299_ _7299_/Q _7316_/CLK _7299_/D _7299_/RESET_B VDD VSS sg13cmos5l_dfrbpq_1
X_6319_ _6320_/B _6298_/B _6335_/C _6317_/Y VDD VSS sg13cmos5l_a21oi_1
XFILLER_13_544 VDD VSS sg13cmos5l_fill_1
XFILLER_32_319 VDD VSS sg13cmos5l_fill_1
X_7146__229 _7146_/RESET_B VDD VSS sg13cmos5l_tiehi
XFILLER_36_614 VDD VSS sg13cmos5l_fill_2
XFILLER_36_636 VDD VSS sg13cmos5l_fill_2
XFILLER_31_330 VDD VSS sg13cmos5l_fill_2
X_3882_ _7234_/D _7234_/Q _3882_/B VDD VSS sg13cmos5l_xnor2_1
X_3951_ _4285_/A _3951_/A _3951_/B VDD VSS sg13cmos5l_xnor2_1
X_5621_ _5657_/B _5623_/A _5657_/A _5621_/C VDD VSS sg13cmos5l_nor3_1
X_6992__388 _6992_/RESET_B VDD VSS sg13cmos5l_tiehi
X_6670_ _6671_/B _6654_/Y _6670_/B VDD VSS sg13cmos5l_nand2b_1
X_4434_ _4436_/D _4433_/A _4433_/B _4433_/C VDD VSS sg13cmos5l_a21oi_1
X_4503_ _4504_/B _4503_/A _4503_/B _4503_/C VDD VSS sg13cmos5l_nand3_1
X_5483_ _5511_/A _5484_/A _5484_/B VDD VSS sg13cmos5l_nor2_1
X_5552_ _5552_/Y _5553_/A _5553_/B VDD VSS sg13cmos5l_nor2_1
X_7222_ _7222_/Q _7316_/CLK _7222_/D _7222_/RESET_B VDD VSS sg13cmos5l_dfrbpq_1
X_4296_ _4306_/A _7059_/Q _4289_/C _4286_/Y VDD VSS sg13cmos5l_a21oi_1
X_4365_ _4379_/A _4365_/A _4365_/B VDD VSS sg13cmos5l_xor2_1
X_6035_ _7176_/D _7176_/Q _6034_/Y _6062_/S VDD VSS sg13cmos5l_mux2_1
X_6104_ _7212_/D _6066_/X _7212_/Q _6106_/S VDD VSS sg13cmos5l_mux2_1
X_7153_ _7153_/Q _7238_/CLK _7153_/D fanout144/X VDD VSS sg13cmos5l_dfrbpq_1
X_7084_ _7084_/Q _7244_/CLK _7084_/D _7084_/RESET_B VDD VSS sg13cmos5l_dfrbpq_1
X_6937_ _7049_/D _4266_/A _4266_/B _6936_/Y VDD VSS sg13cmos5l_a21oi_1
XFILLER_10_569 VDD VSS sg13cmos5l_fill_2
X_5819_ _5821_/B _5819_/A _5819_/B _5819_/C VDD VSS sg13cmos5l_nand3_1
X_6868_ _6897_/A _6868_/A _6868_/B VDD VSS sg13cmos5l_xor2_1
X_6799_ _6800_/A _6779_/Y _6799_/B VDD VSS sg13cmos5l_nand2b_1
XFILLER_1_289 VDD VSS sg13cmos5l_fill_1
XFILLER_33_617 VDD VSS sg13cmos5l_fill_2
X_4081_ _4329_/B _4002_/Y _4343_/A _4342_/B VDD VSS sg13cmos5l_o21ai_1
X_4150_ _4151_/C _4149_/B _4149_/C _5821_/A VDD VSS sg13cmos5l_o21ai_1
XFILLER_36_455 VDD VSS sg13cmos5l_fill_2
X_4983_ _5024_/A _4984_/B _4984_/C _4984_/A VDD VSS sg13cmos5l_a21oi_1
X_3796_ _4046_/B _3796_/A _3796_/B _3796_/C VDD VSS sg13cmos5l_nor3_1
X_3865_ _3865_/X _3865_/A _3865_/B _3865_/C _3865_/D VDD VSS sg13cmos5l_and4_1
X_3934_ _3936_/B _3934_/A _3934_/B VDD VSS sg13cmos5l_xor2_1
X_5604_ _5606_/A _5605_/A _5605_/B VDD VSS sg13cmos5l_nor2_1
X_6722_ _6723_/A _6722_/A _6722_/B VDD VSS sg13cmos5l_xnor2_1
X_6653_ _6653_/Y _6653_/A _6653_/B VDD VSS sg13cmos5l_nor2_1
X_6584_ _6584_/Y _6582_/Y _6583_/Y _6584_/B1 VDD VSS sg13cmos5l_o21ai_1
X_4417_ _4436_/B _7036_/Q _4412_/C _4415_/X _4193_/B _4409_/Y VDD VSS sg13cmos5l_a221oi_1
X_5397_ _5400_/A _5397_/A _5397_/B _5397_/C VDD VSS sg13cmos5l_nand3_1
X_5466_ _5468_/B _5489_/B _5465_/Y VDD VSS sg13cmos5l_nor2b_1
X_5535_ _5537_/B _5535_/A _5535_/B VDD VSS sg13cmos5l_xnor2_1
X_7205_ _7205_/Q _7220_/CLK _7205_/D _7205_/RESET_B VDD VSS sg13cmos5l_dfrbpq_1
X_4279_ _4281_/C _4092_/C _4092_/B _4091_/B VDD VSS sg13cmos5l_a21oi_1
X_4348_ _4362_/B _4348_/A _4348_/B VDD VSS sg13cmos5l_xor2_1
X_6018_ _7173_/D _7173_/Q _6017_/Y _6062_/S VDD VSS sg13cmos5l_mux2_1
X_7136_ _7136_/Q _7308_/CLK _7136_/D _7136_/RESET_B VDD VSS sg13cmos5l_dfrbpq_1
X_7067_ _7067_/Q clkload7/A _7067_/D _7067_/RESET_B VDD VSS sg13cmos5l_dfrbpq_1
XFILLER_6_315 VDD VSS sg13cmos5l_fill_1
XFILLER_2_565 VDD VSS sg13cmos5l_fill_1
XFILLER_14_661 VDD VSS sg13cmos5l_fill_2
X_3650_ _6752_/A _7033_/Q VDD VSS sg13cmos5l_inv_1
X_4202_ _4212_/A _7051_/Q _4599_/B VDD VSS sg13cmos5l_nor2_1
X_5251_ _5251_/X _6185_/A _5267_/B VDD VSS sg13cmos5l_and2_1
X_5320_ _5370_/A _5347_/A _5320_/B VDD VSS sg13cmos5l_nand2b_1
X_4064_ _4219_/A _6185_/A _5294_/B VDD VSS sg13cmos5l_nand2_1
X_4133_ _4135_/B _5812_/A _4133_/B VDD VSS sg13cmos5l_xnor2_1
X_5182_ _5189_/A _7094_/Q _5167_/B _5165_/Y VDD VSS sg13cmos5l_a21oi_1
X_4966_ _4966_/Y _4967_/A _4967_/B VDD VSS sg13cmos5l_nand2b_1
X_6705_ _6707_/B _6676_/Y _6701_/B _6704_/Y VDD VSS sg13cmos5l_a21o_1
XFILLER_20_653 VDD VSS sg13cmos5l_fill_1
XFILLER_32_480 VDD VSS sg13cmos5l_fill_1
X_3779_ _3781_/C _3824_/B _3824_/C _3824_/A VDD VSS sg13cmos5l_a21oi_1
X_3848_ _3874_/C _3848_/A _3848_/B _3853_/A VDD VSS sg13cmos5l_or3_1
X_3917_ _4146_/A _4140_/A _4140_/B VDD VSS sg13cmos5l_or2_1
X_4897_ _4898_/C _4855_/A _4855_/C _4852_/Y VDD VSS sg13cmos5l_a21o_1
X_5518_ _5518_/Y _5519_/A _5519_/B VDD VSS sg13cmos5l_nor2_1
X_7211__182 _7211_/RESET_B VDD VSS sg13cmos5l_tiehi
X_6636_ _6637_/B _6616_/A _6616_/B _6613_/Y VDD VSS sg13cmos5l_o21ai_1
X_6567_ _6567_/Y _6569_/A _6593_/A _6567_/C VDD VSS sg13cmos5l_nand3_1
X_5449_ _7110_/D _5427_/Y _5450_/B _5448_/Y VDD VSS sg13cmos5l_a21oi_1
Xfanout110 _5351_/B _5267_/A VDD VSS sg13cmos5l_buf_1
Xfanout121 _5977_/B1 _5926_/Y VDD VSS sg13cmos5l_buf_1
Xfanout132 _6990_/A _6977_/A VDD VSS sg13cmos5l_buf_1
Xfanout143 _6091_/C _5179_/A VDD VSS sg13cmos5l_buf_1
Xfanout154 _6956_/A _5072_/A VDD VSS sg13cmos5l_buf_1
Xfanout165 _4917_/A fanout166/X VDD VSS sg13cmos5l_buf_1
X_7119_ _7119_/Q clkload8/A _7119_/D _7119_/RESET_B VDD VSS sg13cmos5l_dfrbpq_1
X_6498_ _6499_/B _6498_/A _6497_/Y VDD VSS sg13cmos5l_nor2b_1
XFILLER_15_436 VDD VSS sg13cmos5l_fill_2
Xfanout176 _5818_/C fanout178/X VDD VSS sg13cmos5l_buf_1
XFILLER_7_657 VDD VSS sg13cmos5l_fill_1
XFILLER_38_539 VDD VSS sg13cmos5l_fill_1
XFILLER_19_786 VDD VSS sg13cmos5l_fill_2
XFILLER_33_244 VDD VSS sg13cmos5l_fill_2
X_4820_ _4821_/B _4863_/A _4820_/B VDD VSS sg13cmos5l_xnor2_1
XFILLER_33_299 VDD VSS sg13cmos5l_fill_2
X_3633_ _5862_/A _7127_/Q VDD VSS sg13cmos5l_inv_1
X_3702_ _3789_/B _7157_/Q _3705_/B VDD VSS sg13cmos5l_and2_1
X_4682_ _4683_/B _5351_/B _4681_/B _4681_/Y VDD VSS sg13cmos5l_a21oi_1
X_4751_ _7083_/D _4753_/D _4749_/Y _4750_/Y VDD VSS sg13cmos5l_a21oi_1
X_6421_ _6424_/A _6434_/A _6421_/B VDD VSS sg13cmos5l_nand2b_1
X_5165_ _5165_/Y _5820_/A _5166_/B VDD VSS sg13cmos5l_nor2_1
X_5234_ _7098_/D _5227_/Y _5232_/Y _5233_/Y VDD VSS sg13cmos5l_a21oi_1
X_5303_ _5321_/B _5303_/A _5303_/B VDD VSS sg13cmos5l_xor2_1
X_6352_ _6354_/B _7008_/Q _6428_/A VDD VSS sg13cmos5l_xnor2_1
X_6283_ _6283_/Y _6275_/Y _6282_/Y _6672_/B1 VDD VSS sg13cmos5l_o21ai_1
XFILLER_17_37 VDD VSS sg13cmos5l_fill_1
XFILLER_24_200 VDD VSS sg13cmos5l_fill_2
X_4047_ _4049_/B _5280_/A _4072_/A VDD VSS sg13cmos5l_xnor2_1
X_4116_ _4117_/B _6745_/A _4116_/B VDD VSS sg13cmos5l_xor2_1
X_5096_ _5097_/B _5096_/A _5096_/B _5096_/C VDD VSS sg13cmos5l_and3_1
XFILLER_12_406 VDD VSS sg13cmos5l_fill_1
X_4949_ _4949_/Y _4950_/B _4950_/A VDD VSS sg13cmos5l_nor2b_1
X_5998_ _6000_/B _5996_/Y _5997_/Y _5995_/Y VDD VSS sg13cmos5l_o21ai_1
X_6619_ _6621_/B _7027_/Q _6619_/B VDD VSS sg13cmos5l_xnor2_1
XFILLER_28_561 VDD VSS sg13cmos5l_fill_2
XFILLER_30_236 VDD VSS sg13cmos5l_fill_1
XFILLER_30_247 VDD VSS sg13cmos5l_fill_1
XFILLER_7_476 VDD VSS sg13cmos5l_fill_1
XFILLER_19_550 VDD VSS sg13cmos5l_fill_1
X_5921_ _5924_/B _5921_/A _5921_/B VDD VSS sg13cmos5l_nand2_1
X_7201__192 _7201_/RESET_B VDD VSS sg13cmos5l_tiehi
X_6970_ _6972_/B _6970_/A _6969_/A VDD VSS sg13cmos5l_nor2b_1
XFILLER_0_95 VDD VSS sg13cmos5l_fill_2
XFILLER_21_236 VDD VSS sg13cmos5l_fill_2
X_4734_ _4736_/C _6592_/A _4733_/B _4733_/C _4733_/D VDD VSS sg13cmos5l_a22oi_1
X_4803_ _4808_/A _4769_/A _4769_/B _4767_/Y VDD VSS sg13cmos5l_a21oi_1
X_5783_ _5803_/B _5808_/B _5782_/C _5808_/A VDD VSS sg13cmos5l_a21oi_1
X_5852_ _5853_/C _5852_/A _5852_/B _5852_/C VDD VSS sg13cmos5l_and3_1
X_4596_ _7078_/D _4596_/A _4596_/B _4596_/C VDD VSS sg13cmos5l_and3_1
X_4665_ _4667_/B _4665_/A _4665_/B VDD VSS sg13cmos5l_xor2_1
X_6404_ _6420_/A _7012_/Q _6415_/B VDD VSS sg13cmos5l_nand2_1
X_6335_ _6335_/X _6335_/A _6336_/B _6335_/C _6335_/D VDD VSS sg13cmos5l_and4_1
XFILLER_29_325 VDD VSS sg13cmos5l_fill_2
X_5148_ _5148_/Y _5097_/B _5149_/B VDD VSS sg13cmos5l_nand2b_1
X_5217_ _5217_/Y _5218_/A _5218_/B VDD VSS sg13cmos5l_nor2_1
X_6197_ _6197_/X _6198_/A _6198_/B VDD VSS sg13cmos5l_and2_1
X_6266_ _6269_/A _6633_/A _6266_/B VDD VSS sg13cmos5l_xnor2_1
XFILLER_13_704 VDD VSS sg13cmos5l_fill_1
X_5079_ _5080_/B _5081_/B _5081_/C VDD VSS sg13cmos5l_nand2_1
XFILLER_31_501 VDD VSS sg13cmos5l_fill_1
XFILLER_31_523 VDD VSS sg13cmos5l_fill_2
XFILLER_31_545 VDD VSS sg13cmos5l_fill_1
X_4381_ _4383_/B _4381_/A _4381_/B VDD VSS sg13cmos5l_xnor2_1
X_4450_ _6978_/A _4450_/A _4450_/B _4450_/C VDD VSS sg13cmos5l_nor3_1
XFILLER_38_100 VDD VSS sg13cmos5l_fill_1
X_5002_ _5009_/A _5818_/C _5154_/B VDD VSS sg13cmos5l_xnor2_1
X_6051_ _6055_/A _7315_/Q _7299_/Q VDD VSS sg13cmos5l_xnor2_1
X_6120_ _7227_/D _7227_/Q _6066_/X _6122_/S VDD VSS sg13cmos5l_mux2_1
XFILLER_38_177 VDD VSS sg13cmos5l_fill_2
XFILLER_39_667 VDD VSS sg13cmos5l_fill_2
X_5904_ _5905_/B _7145_/Q _5881_/C _5910_/B1 _7144_/Q VDD VSS sg13cmos5l_a22oi_1
X_6953_ _6955_/B _6953_/A _6953_/B VDD VSS sg13cmos5l_or2_1
X_6884_ _6897_/B _6882_/Y _6884_/B VDD VSS sg13cmos5l_nand2b_1
X_4717_ _4728_/A _5380_/A _4841_/B VDD VSS sg13cmos5l_xnor2_1
X_5697_ _7118_/D _5694_/Y _5695_/Y _5696_/Y VDD VSS sg13cmos5l_a21oi_1
X_5766_ _5768_/C _5766_/A _5766_/B VDD VSS sg13cmos5l_xnor2_1
X_5835_ _5835_/Y _5836_/B _5836_/A VDD VSS sg13cmos5l_nor2b_1
X_4579_ _4579_/Y _4579_/A _4579_/B _4579_/C VDD VSS sg13cmos5l_nand3_1
X_4648_ _4651_/B _4648_/A _4648_/B _4648_/C VDD VSS sg13cmos5l_nand3_1
X_7298_ _7298_/Q _7298_/CLK _7298_/D _7298_/RESET_B VDD VSS sg13cmos5l_dfrbpq_1
X_6318_ _6335_/C _6318_/A _6318_/B VDD VSS sg13cmos5l_nor2_1
XFILLER_29_111 VDD VSS sg13cmos5l_fill_2
X_6249_ _6261_/A _6250_/A _6250_/B VDD VSS sg13cmos5l_nand2b_1
XFILLER_40_331 VDD VSS sg13cmos5l_fill_1
XFILLER_4_210 VDD VSS sg13cmos5l_fill_2
X_3950_ _3950_/Y _3951_/A _3951_/B VDD VSS sg13cmos5l_nor2_1
X_3881_ _3884_/B _3881_/A _3882_/B VDD VSS sg13cmos5l_nor2_1
X_5551_ _5553_/B _7114_/Q _5551_/B VDD VSS sg13cmos5l_xnor2_1
X_5620_ _5623_/C _5632_/B _5617_/C _5617_/A VDD VSS sg13cmos5l_o21ai_1
X_4364_ _4364_/Y _4365_/B _4365_/A VDD VSS sg13cmos5l_nor2b_1
X_4433_ _6986_/A _4433_/A _4433_/B _4433_/C VDD VSS sg13cmos5l_and3_1
X_4502_ _4524_/A _4503_/A _4503_/B _4503_/C VDD VSS sg13cmos5l_a21oi_1
X_5482_ _5484_/B _5596_/A _5456_/B _5356_/S VDD VSS sg13cmos5l_a21oi_1
X_7221_ _7221_/Q clkload4/A _7221_/D _7221_/RESET_B VDD VSS sg13cmos5l_dfrbpq_1
X_7152_ _7152_/Q _7238_/CLK _7152_/D _6299_/A VDD VSS sg13cmos5l_dfrbpq_1
XFILLER_39_464 VDD VSS sg13cmos5l_fill_2
X_4295_ _4311_/A _7032_/Q _4294_/C _4291_/Y VDD VSS sg13cmos5l_a21oi_1
X_6034_ _6034_/Y _6034_/A _6034_/B VDD VSS sg13cmos5l_xnor2_1
X_6103_ _7211_/D _6061_/Y _7211_/Q _6106_/S VDD VSS sg13cmos5l_mux2_1
X_7083_ _7083_/Q _7244_/CLK _7083_/D _7083_/RESET_B VDD VSS sg13cmos5l_dfrbpq_1
X_6936_ _6936_/Y _4266_/A _4266_/B _6940_/A VDD VSS sg13cmos5l_o21ai_1
X_6867_ _6867_/Y _6868_/A _6868_/B VDD VSS sg13cmos5l_nor2b_1
X_5749_ _5754_/B _7093_/Q _5776_/A _5750_/C VDD VSS sg13cmos5l_and3_1
X_5818_ _5819_/C _5153_/C _5818_/B _5818_/C VDD VSS sg13cmos5l_nand3b_1
X_6798_ _6831_/B _6798_/A _6798_/B VDD VSS sg13cmos5l_xor2_1
XFILLER_26_670 VDD VSS sg13cmos5l_fill_2
X_4080_ _4343_/A _4017_/X _4354_/B _4016_/X VDD VSS sg13cmos5l_o21ai_1
XFILLER_32_651 VDD VSS sg13cmos5l_fill_2
X_3933_ _4103_/A _3934_/A _3934_/B VDD VSS sg13cmos5l_nand2b_1
X_4982_ _4984_/C _4994_/A _4981_/C _7089_/Q VDD VSS sg13cmos5l_o21ai_1
X_6721_ _6747_/A _6722_/A _6722_/B VDD VSS sg13cmos5l_nor2b_1
X_3795_ _3822_/A _4052_/A _4052_/B _7114_/Q VDD VSS sg13cmos5l_a21oi_1
X_3864_ _3865_/D _3864_/A _3808_/Y VDD VSS sg13cmos5l_nor2b_1
X_5534_ _5570_/A _5534_/A _5534_/B VDD VSS sg13cmos5l_nand2_1
X_5603_ _5605_/B _5603_/A _5603_/B VDD VSS sg13cmos5l_xor2_1
X_6652_ _7028_/D _6692_/A _6650_/B _6651_/Y VDD VSS sg13cmos5l_a21oi_1
X_6583_ _6583_/Y _6583_/A _6583_/B VDD VSS sg13cmos5l_nor2_1
X_4347_ _4348_/B _7056_/Q _4347_/B VDD VSS sg13cmos5l_xnor2_1
X_4416_ _4436_/A _4416_/A _4416_/B _4416_/C VDD VSS sg13cmos5l_nor3_1
X_5396_ _5397_/C _5396_/A _5396_/B VDD VSS sg13cmos5l_xnor2_1
X_5465_ _5465_/Y _5464_/A _5464_/C _5464_/B VDD VSS sg13cmos5l_o21ai_1
X_7204_ _7204_/Q clkload4/A _7204_/D _7204_/RESET_B VDD VSS sg13cmos5l_dfrbpq_1
X_7135_ _7135_/Q _7305_/CLK _7135_/D _7135_/RESET_B VDD VSS sg13cmos5l_dfrbpq_1
X_4278_ _6952_/A _4276_/B _4225_/Y _4272_/Y _4277_/Y _4216_/Y VDD VSS sg13cmos5l_a221oi_1
X_6017_ _6017_/Y _6017_/A _6017_/B VDD VSS sg13cmos5l_xnor2_1
X_7066_ _7066_/Q clkload6/A _7066_/D _7066_/RESET_B VDD VSS sg13cmos5l_dfrbpq_1
XFILLER_22_172 VDD VSS sg13cmos5l_fill_1
XFILLER_22_183 VDD VSS sg13cmos5l_fill_1
X_6919_ _6919_/Y _6915_/A _6912_/Y _6918_/Y _6903_/A _6913_/A VDD VSS sg13cmos5l_a221oi_1
XFILLER_2_500 VDD VSS sg13cmos5l_fill_2
XFILLER_14_651 VDD VSS sg13cmos5l_fill_1
X_4201_ _4599_/B _4201_/A _4201_/B VDD VSS sg13cmos5l_xnor2_1
X_5181_ _5193_/A _7067_/Q _5170_/B _5168_/Y VDD VSS sg13cmos5l_a21oi_1
X_5250_ _5256_/A _3640_/Y _4236_/Y _4234_/Y VDD VSS sg13cmos5l_o21ai_1
X_4063_ _4063_/Y _4063_/A _4063_/B _4063_/C VDD VSS sg13cmos5l_nor3_1
X_4132_ _4135_/A _5812_/A _4128_/B _4126_/Y VDD VSS sg13cmos5l_a21oi_1
XFILLER_24_426 VDD VSS sg13cmos5l_fill_1
XFILLER_24_437 VDD VSS sg13cmos5l_fill_1
X_3916_ _4140_/B _5159_/A _3916_/B VDD VSS sg13cmos5l_xnor2_1
X_4896_ _4898_/B _4938_/A _4895_/C _4895_/A VDD VSS sg13cmos5l_a21o_1
X_4965_ _4967_/B _5812_/B _4965_/B VDD VSS sg13cmos5l_xor2_1
X_7135__251 _7135_/RESET_B VDD VSS sg13cmos5l_tiehi
X_6704_ _6704_/Y _6702_/X _6726_/A _6676_/Y VDD VSS sg13cmos5l_a21oi_1
X_3778_ _3871_/A _3855_/B _3855_/C _3855_/A VDD VSS sg13cmos5l_o21ai_1
X_3847_ _3874_/B _3847_/A _3874_/A _3847_/C VDD VSS sg13cmos5l_nand3_1
X_5517_ _5519_/B _7113_/Q _5517_/B VDD VSS sg13cmos5l_xnor2_1
X_7066__323 _7066_/RESET_B VDD VSS sg13cmos5l_tiehi
X_6635_ _6637_/A _6635_/A _6635_/B VDD VSS sg13cmos5l_xnor2_1
X_6566_ _6569_/B _6593_/A _6567_/C VDD VSS sg13cmos5l_and2_1
X_6497_ _6497_/Y _6497_/A _6497_/B _6497_/C VDD VSS sg13cmos5l_nand3_1
X_5379_ _5537_/A _5671_/B _6565_/C VDD VSS sg13cmos5l_nor2_1
X_5448_ _5448_/Y _5427_/Y _5450_/B _5528_/A VDD VSS sg13cmos5l_o21ai_1
Xfanout100 _5896_/B1 _5902_/B1 VDD VSS sg13cmos5l_buf_1
Xfanout111 _5267_/A _3806_/X VDD VSS sg13cmos5l_buf_1
Xfanout122 _5969_/A2 _5980_/A2 VDD VSS sg13cmos5l_buf_1
Xfanout133 _6977_/A _3672_/Y VDD VSS sg13cmos5l_buf_1
Xfanout144 fanout144/X _6321_/A VDD VSS sg13cmos5l_buf_1
Xfanout155 _5072_/A fanout166/X VDD VSS sg13cmos5l_buf_1
Xfanout166 fanout166/X _7240_/Q VDD VSS sg13cmos5l_buf_1
Xfanout177 _5735_/A fanout178/X VDD VSS sg13cmos5l_buf_1
X_7118_ _7118_/Q _7243_/CLK _7118_/D _7118_/RESET_B VDD VSS sg13cmos5l_dfrbpq_1
X_7049_ _7049_/Q _7103_/CLK _7049_/D _7049_/RESET_B VDD VSS sg13cmos5l_dfrbpq_1
XFILLER_15_404 VDD VSS sg13cmos5l_fill_1
XFILLER_10_153 VDD VSS sg13cmos5l_fill_2
X_7299__409 _7299_/RESET_B VDD VSS sg13cmos5l_tiehi
XFILLER_33_234 VDD VSS sg13cmos5l_fill_1
X_4750_ _4750_/Y _4753_/D _4749_/Y _5376_/A VDD VSS sg13cmos5l_o21ai_1
X_3632_ _5856_/A _7131_/Q VDD VSS sg13cmos5l_inv_1
X_3701_ _3790_/A _7158_/Q _7157_/Q VDD VSS sg13cmos5l_xnor2_1
X_4681_ _4681_/Y _4681_/A _4681_/B VDD VSS sg13cmos5l_nor2_1
X_5302_ _5302_/Y _5301_/A _5301_/B _5303_/B VDD VSS sg13cmos5l_a21oi_1
X_6420_ _6421_/B _6420_/A _6420_/B _6420_/C VDD VSS sg13cmos5l_nand3_1
X_6351_ _6368_/A _7008_/Q _6351_/B VDD VSS sg13cmos5l_nand2_1
X_4115_ _4130_/B _6745_/A _4115_/B VDD VSS sg13cmos5l_nand2_1
X_5164_ _5166_/B _5164_/A _5164_/B VDD VSS sg13cmos5l_xor2_1
X_5233_ _5233_/Y _5227_/Y _5232_/Y _5224_/A VDD VSS sg13cmos5l_o21ai_1
X_6282_ _6282_/Y _6294_/B VDD VSS sg13cmos5l_inv_1
XFILLER_25_768 VDD VSS sg13cmos5l_fill_2
XFILLER_37_562 VDD VSS sg13cmos5l_fill_1
X_4046_ _6505_/A _4046_/A _4046_/B _4235_/A VDD VSS sg13cmos5l_nor3_1
X_5095_ _5149_/A _5096_/A _5096_/B _5096_/C VDD VSS sg13cmos5l_a21oi_1
XFILLER_33_15 VDD VSS sg13cmos5l_fill_1
X_4879_ _4910_/A _4865_/A _4865_/B _4863_/Y VDD VSS sg13cmos5l_o21ai_1
X_4948_ _4950_/B _7088_/Q _4948_/B VDD VSS sg13cmos5l_xnor2_1
X_5997_ _5997_/Y _7303_/Q _7287_/Q VDD VSS sg13cmos5l_nand2_1
X_6618_ _6618_/Y _7027_/Q _6619_/B VDD VSS sg13cmos5l_nand2_1
Xclkbuf_2_2__f_sd_clk clkload1/A clkbuf_0_sd_clk/X VDD VSS sg13cmos5l_buf_8
X_6549_ _6549_/Y _7024_/Q _6550_/B VDD VSS sg13cmos5l_nand2_1
Xclkbuf_leaf_13_sd_clk _7266_/CLK clkload1/A VDD VSS sg13cmos5l_buf_8
XFILLER_28_595 VDD VSS sg13cmos5l_decap_4
XFILLER_31_705 VDD VSS sg13cmos5l_fill_1
XFILLER_7_499 VDD VSS sg13cmos5l_fill_1
XFILLER_34_521 VDD VSS sg13cmos5l_fill_1
XFILLER_34_532 VDD VSS sg13cmos5l_decap_4
X_5920_ _5920_/X _7150_/Q _5926_/A VDD VSS sg13cmos5l_and2_1
XFILLER_9_72 VDD VSS sg13cmos5l_fill_1
X_4733_ _4776_/B _6592_/A _4733_/B _4733_/C _4733_/D VDD VSS sg13cmos5l_and4_1
X_4802_ _4802_/Y _4809_/A VDD VSS sg13cmos5l_inv_1
X_5782_ _5784_/B _5808_/A _5808_/B _5782_/C VDD VSS sg13cmos5l_and3_1
X_5851_ _5853_/B _5852_/A _5852_/B _5852_/C VDD VSS sg13cmos5l_a21oi_1
X_4595_ _4596_/C _4635_/A _4595_/B VDD VSS sg13cmos5l_nand2b_1
X_4664_ _4702_/A _4665_/A _4665_/B VDD VSS sg13cmos5l_or2_1
X_6265_ _6266_/B _7001_/Q _6277_/B VDD VSS sg13cmos5l_xnor2_1
X_6403_ _7011_/D _6395_/Y _6400_/Y _6402_/Y VDD VSS sg13cmos5l_a21oi_1
X_6334_ _6335_/D _6334_/A _6334_/B VDD VSS sg13cmos5l_nor2_1
X_5078_ _5081_/C _5078_/A VDD VSS sg13cmos5l_inv_1
X_5147_ _5169_/A _7093_/Q _5134_/C _5131_/Y VDD VSS sg13cmos5l_a21oi_1
X_5216_ _5218_/B _7097_/Q _6804_/B VDD VSS sg13cmos5l_xnor2_1
X_6196_ _6198_/B _6196_/A _6196_/B VDD VSS sg13cmos5l_xnor2_1
XFILLER_25_543 VDD VSS sg13cmos5l_fill_2
X_4029_ _4029_/Y _4030_/A _4030_/B _4030_/C VDD VSS sg13cmos5l_a21oi_1
X_7289__419 _7289_/RESET_B VDD VSS sg13cmos5l_tiehi
Xclkbuf_leaf_0_sd_clk clkload3/A clkbuf_leaf_2_sd_clk/A VDD VSS sg13cmos5l_buf_8
XFILLER_35_329 VDD VSS sg13cmos5l_fill_2
X_7051__252 _7051_/RESET_B VDD VSS sg13cmos5l_tiehi
XFILLER_7_230 VDD VSS sg13cmos5l_fill_2
XFILLER_7_263 VDD VSS sg13cmos5l_fill_2
X_4380_ _4383_/A _4210_/A _4210_/B _4208_/Y VDD VSS sg13cmos5l_o21ai_1
XFILLER_39_624 VDD VSS sg13cmos5l_fill_1
XFILLER_39_635 VDD VSS sg13cmos5l_fill_1
X_5001_ _5050_/A _5788_/A _5001_/B VDD VSS sg13cmos5l_nand2_1
X_6050_ _7179_/D _7179_/Q _6049_/Y _6074_/S VDD VSS sg13cmos5l_mux2_1
XFILLER_34_395 VDD VSS sg13cmos5l_fill_2
X_5834_ _5836_/B _7123_/Q _5822_/B _5820_/X VDD VSS sg13cmos5l_a21oi_1
X_5903_ _7144_/D _5907_/A _5903_/B VDD VSS sg13cmos5l_nor2_1
X_6952_ _6953_/B _6952_/A _4395_/B VDD VSS sg13cmos5l_nor2b_1
X_6883_ _6884_/B _6883_/A _6883_/B _6883_/C VDD VSS sg13cmos5l_nand3_1
XFILLER_22_546 VDD VSS sg13cmos5l_fill_1
X_4647_ _4677_/A _4647_/A _4647_/B _4648_/B _4648_/C VDD VSS sg13cmos5l_and4_1
X_4716_ _4775_/A _6612_/A _4841_/B VDD VSS sg13cmos5l_nor2_1
X_5696_ _5696_/Y _5694_/Y _5695_/Y _5072_/A VDD VSS sg13cmos5l_o21ai_1
X_5765_ _5790_/A _5766_/A _5766_/B VDD VSS sg13cmos5l_and2_1
XFILLER_30_49 VDD VSS sg13cmos5l_fill_2
X_4578_ _4580_/A _4579_/A _4579_/B _4579_/C VDD VSS sg13cmos5l_a21oi_1
X_6248_ _6250_/B _5354_/A _6236_/B _6234_/Y VDD VSS sg13cmos5l_o21ai_1
X_7297_ _7297_/Q _7316_/CLK _7297_/D _7297_/RESET_B VDD VSS sg13cmos5l_dfrbpq_1
X_6317_ _6317_/Y _6308_/A _6304_/Y _6306_/B VDD VSS sg13cmos5l_o21ai_1
XFILLER_29_167 VDD VSS sg13cmos5l_fill_2
XFILLER_38_690 VDD VSS sg13cmos5l_fill_2
X_6179_ _6179_/X _6179_/A _6179_/B VDD VSS sg13cmos5l_xor2_1
XFILLER_4_266 VDD VSS sg13cmos5l_fill_2
XFILLER_35_104 VDD VSS sg13cmos5l_fill_1
XFILLER_36_638 VDD VSS sg13cmos5l_fill_1
X_3880_ _7233_/D _3882_/B _3880_/B VDD VSS sg13cmos5l_and2_1
X_4501_ _4503_/C _7042_/Q _4501_/B VDD VSS sg13cmos5l_xnor2_1
X_5481_ _5484_/A _5481_/A _5481_/B VDD VSS sg13cmos5l_xnor2_1
X_5550_ _5551_/B _5652_/A _5550_/B VDD VSS sg13cmos5l_xnor2_1
X_4294_ _4325_/A _7032_/Q _4294_/B _4294_/C VDD VSS sg13cmos5l_and3_1
X_4363_ _4363_/Y _4365_/A _4365_/B VDD VSS sg13cmos5l_nand2b_1
X_4432_ _4433_/C _7035_/Q _4443_/B _4430_/Y VDD VSS sg13cmos5l_a21o_1
X_6102_ _7210_/D _6055_/X _7210_/Q _6106_/S VDD VSS sg13cmos5l_mux2_1
X_7279__429 _7279_/RESET_B VDD VSS sg13cmos5l_tiehi
X_7220_ _7220_/Q _7220_/CLK _7220_/D _7220_/RESET_B VDD VSS sg13cmos5l_dfrbpq_1
X_7151_ _7151_/Q _7238_/CLK _7151_/D fanout144/X VDD VSS sg13cmos5l_dfrbpq_1
X_7082_ _7082_/Q _7244_/CLK _7082_/D _7082_/RESET_B VDD VSS sg13cmos5l_dfrbpq_1
XFILLER_26_115 VDD VSS sg13cmos5l_fill_2
XFILLER_39_421 VDD VSS sg13cmos5l_decap_4
XFILLER_39_476 VDD VSS sg13cmos5l_fill_2
X_6033_ _6033_/Y _6034_/A _6034_/B VDD VSS sg13cmos5l_nor2b_1
XFILLER_25_49 VDD VSS sg13cmos5l_fill_1
X_5817_ _5818_/B _5787_/C _5812_/C _5788_/A VDD VSS sg13cmos5l_a21oi_1
X_6935_ _7048_/D _4259_/Y _4260_/X _6934_/Y VDD VSS sg13cmos5l_a21oi_1
X_6866_ _6868_/B _6849_/A _6849_/B _6850_/Y VDD VSS sg13cmos5l_o21ai_1
X_6797_ _6797_/Y _6798_/B _6798_/A VDD VSS sg13cmos5l_nor2b_1
X_5679_ _5706_/B _5679_/A _5679_/B VDD VSS sg13cmos5l_xnor2_1
X_5748_ _5750_/C _5759_/B _5747_/C _5747_/A VDD VSS sg13cmos5l_o21ai_1
X_7145__231 _7145_/RESET_B VDD VSS sg13cmos5l_tiehi
XFILLER_26_682 VDD VSS sg13cmos5l_fill_1
XFILLER_36_457 VDD VSS sg13cmos5l_fill_1
X_3863_ _3865_/C _3863_/A _3863_/B _3863_/C VDD VSS sg13cmos5l_nor3_1
X_3932_ _3934_/B _5596_/B _3920_/Y _5004_/B VDD VSS sg13cmos5l_o21ai_1
X_4981_ _4984_/B _7089_/Q _4994_/A _4981_/C VDD VSS sg13cmos5l_or3_1
X_6720_ _6722_/B _6720_/A _6720_/B VDD VSS sg13cmos5l_xnor2_1
X_6651_ _6651_/Y _6692_/A _6650_/B _6253_/A VDD VSS sg13cmos5l_o21ai_1
X_3794_ _5534_/B _4053_/A _4053_/B VDD VSS sg13cmos5l_nor2_1
X_5464_ _5489_/B _5464_/A _5464_/B _5464_/C VDD VSS sg13cmos5l_nor3_1
X_5533_ _5540_/A _5671_/A _5505_/B _5435_/A VDD VSS sg13cmos5l_o21ai_1
X_5602_ _5643_/A _5603_/A _5603_/B VDD VSS sg13cmos5l_nor2_1
X_6582_ _6582_/Y _6589_/A _6588_/B VDD VSS sg13cmos5l_nand2_1
X_4277_ _4277_/Y _4277_/A _4277_/B VDD VSS sg13cmos5l_nor2_1
X_4346_ _4348_/A _7055_/Q _4358_/B _4344_/X VDD VSS sg13cmos5l_a21oi_1
X_4415_ _4415_/X _4193_/A _4192_/C _7037_/Q VDD VSS sg13cmos5l_a21o_1
X_5395_ _5396_/B _5395_/A _5395_/B VDD VSS sg13cmos5l_xor2_1
X_7203_ _7203_/Q _7308_/CLK _7203_/D _7203_/RESET_B VDD VSS sg13cmos5l_dfrbpq_1
X_7134_ _7134_/Q _7305_/CLK _7134_/D _7134_/RESET_B VDD VSS sg13cmos5l_dfrbpq_1
X_7065_ _7065_/Q clkload5/A _7065_/D _7065_/RESET_B VDD VSS sg13cmos5l_dfrbpq_1
XFILLER_15_619 VDD VSS sg13cmos5l_fill_1
X_6016_ _6017_/B _6016_/A _6015_/Y VDD VSS sg13cmos5l_nor2b_1
X_6918_ _6918_/Y _6918_/A _6918_/B VDD VSS sg13cmos5l_nor2_1
X_6849_ _6851_/B _6849_/A _6849_/B VDD VSS sg13cmos5l_xor2_1
XFILLER_18_435 VDD VSS sg13cmos5l_fill_1
XFILLER_14_641 VDD VSS sg13cmos5l_fill_1
XFILLER_26_490 VDD VSS sg13cmos5l_decap_4
XFILLER_33_427 VDD VSS sg13cmos5l_fill_2
XFILLER_33_438 VDD VSS sg13cmos5l_fill_2
XFILLER_33_449 VDD VSS sg13cmos5l_fill_2
XFILLER_14_685 VDD VSS sg13cmos5l_fill_1
XFILLER_5_394 VDD VSS sg13cmos5l_fill_1
X_4131_ _4404_/B _4182_/A _4131_/B VDD VSS sg13cmos5l_nand2b_1
X_4200_ _4205_/A _4597_/A _4200_/B VDD VSS sg13cmos5l_nand2_1
X_5180_ _7094_/D _5205_/A _5178_/B _5179_/Y VDD VSS sg13cmos5l_a21oi_1
X_4062_ _4063_/C _6205_/A _4072_/A _4610_/A _4061_/D VDD VSS sg13cmos5l_a22oi_1
XFILLER_20_633 VDD VSS sg13cmos5l_fill_2
X_3846_ _3875_/B _3846_/A _3846_/B _3846_/C VDD VSS sg13cmos5l_or3_1
X_3915_ _4144_/B _5845_/A _3916_/B VDD VSS sg13cmos5l_nand2_1
X_4895_ _4938_/B _4895_/A _4938_/A _4895_/C VDD VSS sg13cmos5l_nand3_1
X_4964_ _4964_/Y _5812_/B _4965_/B VDD VSS sg13cmos5l_nand2_1
X_6703_ _6726_/A _6703_/A _6703_/B _6703_/C VDD VSS sg13cmos5l_nand3_1
X_6634_ _6634_/Y _6635_/A _6635_/B VDD VSS sg13cmos5l_nor2b_1
X_3777_ _3855_/C _3836_/C _3850_/A _3755_/Y VDD VSS sg13cmos5l_o21ai_1
X_5447_ _5450_/B _5445_/Y _5447_/B VDD VSS sg13cmos5l_nand2b_1
X_5516_ _5517_/B _5516_/A _5516_/B VDD VSS sg13cmos5l_xnor2_1
X_6565_ _6567_/C _6565_/A _6565_/B _6565_/C VDD VSS sg13cmos5l_nand3_1
X_6496_ _6498_/A _6497_/A _6497_/B _6497_/C VDD VSS sg13cmos5l_a21oi_1
X_4329_ _4331_/B _4329_/A _4329_/B VDD VSS sg13cmos5l_xor2_1
X_5378_ _5395_/A _5360_/A _5360_/B _5358_/Y VDD VSS sg13cmos5l_o21ai_1
Xfanout101 _5902_/B1 _5868_/Y VDD VSS sg13cmos5l_buf_1
Xfanout112 _6196_/A _5266_/A VDD VSS sg13cmos5l_buf_1
Xfanout123 _5980_/A2 _5925_/Y VDD VSS sg13cmos5l_buf_1
Xfanout134 _6563_/A _6480_/A VDD VSS sg13cmos5l_buf_1
Xfanout145 _6299_/A _6321_/A VDD VSS sg13cmos5l_buf_1
Xfanout156 _6584_/B1 _6947_/A VDD VSS sg13cmos5l_buf_1
Xfanout167 _6381_/A _6392_/A VDD VSS sg13cmos5l_buf_1
Xfanout178 fanout178/X _5637_/A VDD VSS sg13cmos5l_buf_1
X_7117_ _7117_/Q _7243_/CLK _7117_/D _7117_/RESET_B VDD VSS sg13cmos5l_dfrbpq_1
X_7048_ _7048_/Q _7103_/CLK _7048_/D _7048_/RESET_B VDD VSS sg13cmos5l_dfrbpq_1
XFILLER_15_438 VDD VSS sg13cmos5l_fill_1
XFILLER_27_232 VDD VSS sg13cmos5l_fill_2
XFILLER_11_622 VDD VSS sg13cmos5l_fill_2
XFILLER_11_644 VDD VSS sg13cmos5l_fill_1
XFILLER_11_688 VDD VSS sg13cmos5l_fill_2
XFILLER_5_0 VDD VSS sg13cmos5l_fill_2
X_3700_ _3789_/A _7158_/Q _7157_/Q VDD VSS sg13cmos5l_xor2_1
X_4680_ _4685_/A _4680_/A _4648_/B VDD VSS sg13cmos5l_nor2b_1
X_5301_ _5301_/Y _5301_/A _5301_/B _5303_/B VDD VSS sg13cmos5l_nand3_1
X_6350_ _7007_/D _6371_/A _6348_/B _6349_/Y VDD VSS sg13cmos5l_a21oi_1
X_6281_ _6294_/B _6281_/A _6281_/B VDD VSS sg13cmos5l_xnor2_1
XFILLER_29_508 VDD VSS sg13cmos5l_fill_2
XFILLER_38_0 VDD VSS sg13cmos5l_fill_1
X_4114_ _4115_/B _4116_/B VDD VSS sg13cmos5l_inv_1
X_5094_ _5096_/C _5094_/A _5094_/B VDD VSS sg13cmos5l_xnor2_1
X_5163_ _5184_/B _5128_/A _5148_/Y _5150_/Y _5103_/B _5164_/B VDD VSS sg13cmos5l_a221oi_1
X_5232_ _5232_/Y _5232_/A _5232_/B VDD VSS sg13cmos5l_xnor2_1
X_7061__232 _7061_/RESET_B VDD VSS sg13cmos5l_tiehi
X_4045_ _4072_/B _5330_/C _4235_/A VDD VSS sg13cmos5l_xnor2_1
X_5996_ _5996_/Y _7304_/Q _7288_/Q VDD VSS sg13cmos5l_nor2_1
X_3829_ _3829_/Y _3869_/A _3869_/B _3869_/C VDD VSS sg13cmos5l_o21ai_1
X_4878_ _4914_/A _7059_/Q _4868_/B _4866_/Y VDD VSS sg13cmos5l_a21oi_1
X_4947_ _4948_/B _5579_/A _4947_/B VDD VSS sg13cmos5l_xnor2_1
X_6617_ _6619_/B _6663_/A _6617_/B VDD VSS sg13cmos5l_xnor2_1
X_7298__410 _7298_/RESET_B VDD VSS sg13cmos5l_tiehi
X_6548_ _6550_/B _6573_/A _6548_/B VDD VSS sg13cmos5l_xnor2_1
X_6479_ _6480_/C _6479_/A _6479_/B VDD VSS sg13cmos5l_nor2_1
XFILLER_11_452 VDD VSS sg13cmos5l_fill_1
XFILLER_7_445 VDD VSS sg13cmos5l_fill_1
XFILLER_19_563 VDD VSS sg13cmos5l_fill_1
XFILLER_34_500 VDD VSS sg13cmos5l_fill_1
XFILLER_34_555 VDD VSS sg13cmos5l_fill_2
X_5850_ _5852_/C _5850_/A _5850_/B VDD VSS sg13cmos5l_xnor2_1
XFILLER_21_238 VDD VSS sg13cmos5l_fill_1
X_4663_ _4665_/B _5396_/A _4663_/B VDD VSS sg13cmos5l_xnor2_1
X_4732_ _4733_/D _4731_/B _4731_/C _4731_/A VDD VSS sg13cmos5l_o21ai_1
X_4801_ _4809_/A _5568_/A _4801_/B VDD VSS sg13cmos5l_xnor2_1
X_5781_ _5782_/C _5781_/A _5806_/B VDD VSS sg13cmos5l_or2_1
X_6402_ _6402_/Y _6402_/A _6412_/B VDD VSS sg13cmos5l_nand2_1
X_4594_ _4596_/B _4595_/B _4635_/A VDD VSS sg13cmos5l_nand2b_1
X_5215_ _5218_/A _7096_/Q _6804_/B _4467_/Y VDD VSS sg13cmos5l_a21oi_1
X_6264_ _6264_/Y _7001_/Q _6277_/B VDD VSS sg13cmos5l_nand2_1
X_6333_ _7006_/D _6323_/X _6334_/B _6332_/Y VDD VSS sg13cmos5l_a21oi_1
X_4028_ _4030_/C _6633_/B _4028_/B VDD VSS sg13cmos5l_xnor2_1
X_5077_ _5078_/A _5070_/A _5074_/D _5066_/X VDD VSS sg13cmos5l_a21o_1
X_5146_ _7093_/D _5179_/A _5146_/B _5146_/C VDD VSS sg13cmos5l_and3_1
X_6195_ _6196_/B _6994_/Q _6195_/B VDD VSS sg13cmos5l_xnor2_1
XFILLER_12_249 VDD VSS sg13cmos5l_fill_1
XFILLER_25_599 VDD VSS sg13cmos5l_decap_4
X_5979_ _7165_/D _7165_/Q _5979_/A2 _5978_/Y VDD VSS sg13cmos5l_a21o_1
XFILLER_11_260 VDD VSS sg13cmos5l_fill_1
XFILLER_31_525 VDD VSS sg13cmos5l_fill_1
XFILLER_3_470 VDD VSS sg13cmos5l_fill_1
XFILLER_38_124 VDD VSS sg13cmos5l_fill_2
XFILLER_39_658 VDD VSS sg13cmos5l_fill_1
X_5000_ _5011_/A _4970_/A _4970_/B _4966_/Y VDD VSS sg13cmos5l_o21ai_1
XFILLER_22_525 VDD VSS sg13cmos5l_decap_4
XFILLER_34_374 VDD VSS sg13cmos5l_fill_1
X_5833_ _5836_/A _7124_/Q _5833_/B VDD VSS sg13cmos5l_xnor2_1
X_5902_ _5903_/B _7144_/Q _5875_/B _5902_/B1 _7143_/Q VDD VSS sg13cmos5l_a22oi_1
X_7288__420 _7288_/RESET_B VDD VSS sg13cmos5l_tiehi
X_6951_ _7054_/D _4394_/A _6949_/Y _6950_/Y VDD VSS sg13cmos5l_a21oi_1
X_6882_ _6882_/Y _6883_/A _6883_/B _6883_/C VDD VSS sg13cmos5l_a21oi_1
X_4577_ _4579_/C _7050_/Q _4577_/B VDD VSS sg13cmos5l_xnor2_1
X_4646_ _4648_/C _4733_/B _4645_/B _4645_/C VDD VSS sg13cmos5l_o21ai_1
X_4715_ _6635_/A _5380_/A _6612_/B VDD VSS sg13cmos5l_nand2_1
X_5695_ _5695_/Y _5701_/A _5695_/B VDD VSS sg13cmos5l_nor2_1
X_5764_ _5766_/B _5787_/C _5001_/B _5763_/Y VDD VSS sg13cmos5l_a21oi_1
X_6178_ _6178_/Y _6179_/A _6179_/B VDD VSS sg13cmos5l_nand2b_1
X_6247_ _6250_/A _6247_/A _6247_/B VDD VSS sg13cmos5l_xnor2_1
X_7295__413 _7295_/RESET_B VDD VSS sg13cmos5l_tiehi
X_7296_ _7296_/Q clkload3/A _7296_/D _7296_/RESET_B VDD VSS sg13cmos5l_dfrbpq_1
X_6316_ _6334_/A _6316_/A _6316_/B VDD VSS sg13cmos5l_xnor2_1
X_5129_ _5133_/B _5149_/A _5130_/B _5130_/C VDD VSS sg13cmos5l_o21ai_1
XFILLER_13_569 VDD VSS sg13cmos5l_fill_2
XFILLER_40_355 VDD VSS sg13cmos5l_fill_1
XFILLER_9_529 VDD VSS sg13cmos5l_fill_2
XFILLER_31_311 VDD VSS sg13cmos5l_fill_1
XANTENNA_1 _7135_/D VDD VSS sg13cmos5l_antennanp
XFILLER_31_399 VDD VSS sg13cmos5l_decap_8
XFILLER_8_573 VDD VSS sg13cmos5l_fill_1
X_4431_ _4443_/B _4431_/A _4431_/B VDD VSS sg13cmos5l_xor2_1
X_4500_ _4519_/B _7042_/Q _4501_/B VDD VSS sg13cmos5l_nand2_1
X_5480_ _5495_/A _5469_/A _5469_/B _5467_/Y VDD VSS sg13cmos5l_o21ai_1
XFILLER_39_400 VDD VSS sg13cmos5l_fill_1
X_4293_ _4294_/C _4292_/B _4292_/C _4292_/A VDD VSS sg13cmos5l_o21ai_1
X_4362_ _4365_/B _7029_/Q _4362_/B VDD VSS sg13cmos5l_xnor2_1
X_6032_ _6034_/B _6026_/Y _6029_/B _6025_/Y VDD VSS sg13cmos5l_o21ai_1
X_6101_ _7209_/D _6049_/Y _7209_/Q _6106_/S VDD VSS sg13cmos5l_mux2_1
X_7150_ _7150_/Q _7238_/CLK _7150_/D fanout144/X VDD VSS sg13cmos5l_dfrbpq_1
X_7081_ _7081_/Q _7244_/CLK _7081_/D _7081_/RESET_B VDD VSS sg13cmos5l_dfrbpq_1
XFILLER_39_444 VDD VSS sg13cmos5l_fill_2
X_7097__297 _7097_/RESET_B VDD VSS sg13cmos5l_tiehi
X_6934_ _6934_/Y _4259_/Y _4260_/X _4596_/A VDD VSS sg13cmos5l_o21ai_1
XFILLER_34_193 VDD VSS sg13cmos5l_fill_2
X_5747_ _5776_/A _5747_/A _5759_/B _5747_/C VDD VSS sg13cmos5l_or3_1
X_5816_ _5819_/B _5816_/A VDD VSS sg13cmos5l_inv_1
X_6865_ _6868_/A _7013_/Q _6865_/B VDD VSS sg13cmos5l_xnor2_1
X_6796_ _6796_/Y _6798_/A _6798_/B VDD VSS sg13cmos5l_nand2b_1
X_4629_ _4631_/B _4629_/A _4629_/B VDD VSS sg13cmos5l_xnor2_1
X_5678_ _5678_/Y _5679_/A _5679_/B VDD VSS sg13cmos5l_nor2_1
X_7279_ _7279_/Q clkload3/A _7279_/D _7279_/RESET_B VDD VSS sg13cmos5l_dfrbpq_1
XFILLER_13_300 VDD VSS sg13cmos5l_fill_1
XFILLER_26_650 VDD VSS sg13cmos5l_fill_1
XFILLER_26_672 VDD VSS sg13cmos5l_fill_1
X_7278__430 _7278_/RESET_B VDD VSS sg13cmos5l_tiehi
XFILLER_1_782 VDD VSS sg13cmos5l_fill_1
XFILLER_36_414 VDD VSS sg13cmos5l_decap_8
XFILLER_32_653 VDD VSS sg13cmos5l_fill_1
X_3862_ _3863_/C _7109_/Q _6469_/A _3861_/Y VDD VSS sg13cmos5l_o21ai_1
X_3931_ _3934_/A _6247_/A _3931_/B VDD VSS sg13cmos5l_xnor2_1
X_4980_ _4994_/B _5623_/A _4994_/A _4981_/C VDD VSS sg13cmos5l_nor3_1
X_5601_ _5603_/B _5637_/A _5601_/B VDD VSS sg13cmos5l_xnor2_1
X_7285__423 _7285_/RESET_B VDD VSS sg13cmos5l_tiehi
X_6650_ _6653_/B _6692_/A _6650_/B VDD VSS sg13cmos5l_nor2_1
X_6581_ _6581_/Y _6588_/B VDD VSS sg13cmos5l_inv_1
X_3793_ _5535_/B _4052_/A _4052_/B VDD VSS sg13cmos5l_nand2_1
X_4414_ _4416_/C _4193_/A _4192_/C _7037_/Q VDD VSS sg13cmos5l_a21oi_1
X_5394_ _5394_/Y _5395_/B _5395_/A VDD VSS sg13cmos5l_nand2b_1
X_5463_ _5464_/C _5411_/A _5411_/B _5462_/Y VDD VSS sg13cmos5l_a21oi_1
X_5532_ _5553_/A _7113_/Q _5517_/B _5515_/Y VDD VSS sg13cmos5l_a21oi_1
X_7202_ _7202_/Q _7308_/CLK _7202_/D _7202_/RESET_B VDD VSS sg13cmos5l_dfrbpq_1
X_4276_ _4277_/B _4276_/A _4276_/B VDD VSS sg13cmos5l_nand2_1
X_4345_ _4358_/B _6216_/B _4345_/B VDD VSS sg13cmos5l_xor2_1
X_6015_ _6015_/Y _7308_/Q _7292_/Q VDD VSS sg13cmos5l_nand2_1
X_7292__416 _7292_/RESET_B VDD VSS sg13cmos5l_tiehi
X_7133_ _7133_/Q _7318_/CLK _7133_/D _7133_/RESET_B VDD VSS sg13cmos5l_dfrbpq_1
X_7064_ _7064_/Q clkload5/A _7064_/D _7064_/RESET_B VDD VSS sg13cmos5l_dfrbpq_1
XFILLER_39_263 VDD VSS sg13cmos5l_fill_2
X_6917_ _7043_/D _6918_/B _6915_/Y _6916_/Y VDD VSS sg13cmos5l_a21oi_1
X_6848_ _6849_/B _7038_/Q _6860_/B _4470_/A VDD VSS sg13cmos5l_a21oi_1
X_6779_ _6779_/Y _6780_/A _6780_/B VDD VSS sg13cmos5l_nor2_1
XFILLER_2_546 VDD VSS sg13cmos5l_fill_1
XFILLER_33_406 VDD VSS sg13cmos5l_fill_1
X_7048__258 _7048_/RESET_B VDD VSS sg13cmos5l_tiehi
X_4061_ _4610_/B _6205_/A _4072_/A _4610_/A _4061_/D VDD VSS sg13cmos5l_nand4_1
X_4130_ _4131_/B _4130_/A _4130_/B _4130_/C VDD VSS sg13cmos5l_nand3_1
X_7241__326 _7241_/RESET_B VDD VSS sg13cmos5l_tiehi
X_4963_ _4965_/B _6700_/B _4844_/A _4963_/S VDD VSS sg13cmos5l_mux2_1
X_3776_ _3855_/B _3836_/B _3836_/C _3836_/D _3776_/D VDD VSS sg13cmos5l_nor4_1
X_3845_ _3875_/A _3846_/B _3846_/C _3846_/A VDD VSS sg13cmos5l_o21ai_1
X_3914_ _3916_/B _3914_/A _3914_/B VDD VSS sg13cmos5l_xnor2_1
X_4894_ _4895_/C _4924_/B _4893_/C _4893_/A VDD VSS sg13cmos5l_a21o_1
X_6702_ _6702_/X _6703_/A _6703_/B _6703_/C VDD VSS sg13cmos5l_a21o_1
X_6633_ _6635_/B _6633_/A _6633_/B VDD VSS sg13cmos5l_xnor2_1
X_6564_ _6576_/A _4331_/A _6548_/B _6549_/Y VDD VSS sg13cmos5l_o21ai_1
X_5377_ _7107_/D _5422_/A _5374_/X _5376_/Y VDD VSS sg13cmos5l_a21oi_1
X_5446_ _5447_/B _5428_/X _5446_/B VDD VSS sg13cmos5l_nand2b_1
X_5515_ _5515_/Y _5652_/A _5516_/B VDD VSS sg13cmos5l_nor2_1
Xfanout102 _5910_/B1 _5868_/Y VDD VSS sg13cmos5l_buf_1
Xfanout113 _5308_/A _4235_/A VDD VSS sg13cmos5l_buf_1
X_6495_ _6497_/C _7021_/Q _6495_/B VDD VSS sg13cmos5l_xor2_1
XFILLER_27_200 VDD VSS sg13cmos5l_fill_2
XFILLER_27_222 VDD VSS sg13cmos5l_fill_2
XFILLER_28_701 VDD VSS sg13cmos5l_fill_1
XFILLER_28_723 VDD VSS sg13cmos5l_fill_1
X_4259_ _4259_/Y _6930_/B _4258_/X _4255_/Y VDD VSS sg13cmos5l_o21ai_1
X_4328_ _4399_/A _4328_/A _4401_/A _4328_/C _4328_/D VDD VSS sg13cmos5l_nand4_1
Xfanout124 _5921_/B _5920_/X VDD VSS sg13cmos5l_buf_1
Xfanout135 _6480_/A _6971_/A VDD VSS sg13cmos5l_buf_1
Xfanout146 _6321_/A _6740_/A VDD VSS sg13cmos5l_buf_1
Xfanout157 _6521_/A _6947_/A VDD VSS sg13cmos5l_buf_1
Xfanout168 _6392_/A _5160_/A VDD VSS sg13cmos5l_buf_1
Xfanout179 _5637_/A _7166_/Q VDD VSS sg13cmos5l_buf_1
X_7116_ _7116_/Q _7243_/CLK _7116_/D _7116_/RESET_B VDD VSS sg13cmos5l_dfrbpq_1
X_7047_ _7047_/Q _7103_/CLK _7047_/D _7047_/RESET_B VDD VSS sg13cmos5l_dfrbpq_1
X_7275__433 _7275_/RESET_B VDD VSS sg13cmos5l_tiehi
X_5231_ _5232_/B _5231_/A _5231_/B VDD VSS sg13cmos5l_xnor2_1
X_5300_ _5303_/B _7077_/Q _5300_/B VDD VSS sg13cmos5l_xnor2_1
X_7282__426 _7282_/RESET_B VDD VSS sg13cmos5l_tiehi
X_6280_ _6292_/B _6281_/A _6281_/B VDD VSS sg13cmos5l_nor2_1
X_4044_ _4195_/A _5266_/A _4647_/B VDD VSS sg13cmos5l_nand2_1
X_4113_ _4116_/B _4113_/A _4113_/B VDD VSS sg13cmos5l_xnor2_1
X_5093_ _5127_/B _5094_/A _5094_/B VDD VSS sg13cmos5l_or2_1
X_5162_ _5164_/B _5162_/A _5162_/B VDD VSS sg13cmos5l_xor2_1
XFILLER_37_575 VDD VSS sg13cmos5l_fill_2
X_4946_ _4946_/X _5018_/A _4947_/B VDD VSS sg13cmos5l_and2_1
X_5995_ _5995_/Y _7304_/Q _7288_/Q VDD VSS sg13cmos5l_nand2_1
X_3759_ _5535_/A _3759_/A _3759_/B VDD VSS sg13cmos5l_xnor2_1
X_3828_ _3869_/C _7115_/Q _6226_/A VDD VSS sg13cmos5l_xnor2_1
X_4877_ _7086_/D _4918_/A _4875_/B _4876_/Y VDD VSS sg13cmos5l_a21oi_1
X_6616_ _6617_/B _6616_/A _6616_/B VDD VSS sg13cmos5l_xnor2_1
X_6547_ _6548_/B _6547_/A _6547_/B VDD VSS sg13cmos5l_xnor2_1
X_5429_ _5433_/C _5568_/A _5429_/B VDD VSS sg13cmos5l_xnor2_1
X_6478_ _6480_/B _6479_/A _6479_/B VDD VSS sg13cmos5l_and2_1
XFILLER_11_420 VDD VSS sg13cmos5l_fill_1
XFILLER_3_641 VDD VSS sg13cmos5l_fill_1
XFILLER_19_531 VDD VSS sg13cmos5l_fill_2
X_4800_ _4855_/A _4800_/A _4929_/B VDD VSS sg13cmos5l_nor2_1
X_5780_ _5806_/B _5753_/Y _5780_/B _5780_/C VDD VSS sg13cmos5l_nand3b_1
X_4593_ _4595_/B _4579_/Y _4581_/Y _4580_/A VDD VSS sg13cmos5l_a21o_1
X_4662_ _4663_/B _4863_/A _4662_/B VDD VSS sg13cmos5l_xnor2_1
X_4731_ _4733_/C _4731_/A _4731_/B _4731_/C VDD VSS sg13cmos5l_or3_1
X_6401_ _6412_/B _6395_/Y _6422_/B VDD VSS sg13cmos5l_nand2b_1
X_5214_ _5221_/A _7069_/Q _5201_/B _5199_/Y VDD VSS sg13cmos5l_a21oi_1
X_6194_ _6194_/Y _6994_/Q _6528_/A VDD VSS sg13cmos5l_nand2_1
X_6263_ _7000_/D _6260_/Y _6261_/Y _6262_/Y VDD VSS sg13cmos5l_a21oi_1
X_6332_ _6332_/Y _6323_/X _6334_/B _6321_/A VDD VSS sg13cmos5l_o21ai_1
XFILLER_25_512 VDD VSS sg13cmos5l_decap_4
XFILLER_25_534 VDD VSS sg13cmos5l_fill_1
X_4027_ _4030_/B _6612_/B _4040_/B VDD VSS sg13cmos5l_nand2_1
X_5076_ _5081_/B _5076_/A _5076_/B _5076_/C VDD VSS sg13cmos5l_nand3_1
X_5145_ _5146_/C _5174_/A _5144_/B _5144_/C VDD VSS sg13cmos5l_o21ai_1
X_4929_ _4929_/Y _6675_/B _4929_/B VDD VSS sg13cmos5l_nor2_1
X_5978_ _5978_/Y _5976_/Y _5977_/Y _5979_/A2 VDD VSS sg13cmos5l_a21oi_1
X_7272__436 _7272_/RESET_B VDD VSS sg13cmos5l_tiehi
XFILLER_31_559 VDD VSS sg13cmos5l_fill_2
XFILLER_39_615 VDD VSS sg13cmos5l_fill_1
X_5901_ _7143_/D _5901_/A _5901_/B VDD VSS sg13cmos5l_nor2_1
X_7199__194 _7199_/RESET_B VDD VSS sg13cmos5l_tiehi
X_6950_ _6950_/Y _4394_/A _6949_/Y _6947_/A VDD VSS sg13cmos5l_o21ai_1
XFILLER_34_397 VDD VSS sg13cmos5l_fill_1
X_4714_ _4731_/A _4686_/A _4686_/B _4684_/Y VDD VSS sg13cmos5l_a21oi_1
X_5763_ _5763_/Y _5818_/C _5787_/C _6675_/A VDD VSS sg13cmos5l_a21oi_1
X_5832_ _5841_/A _5832_/A _5832_/B VDD VSS sg13cmos5l_nor2_1
X_6881_ _6883_/C _7014_/Q _6881_/B VDD VSS sg13cmos5l_xnor2_1
XFILLER_30_570 VDD VSS sg13cmos5l_fill_1
X_4576_ _4577_/B _4576_/A _4576_/B VDD VSS sg13cmos5l_xnor2_1
X_4645_ _4648_/B _4733_/B _4645_/B _4645_/C VDD VSS sg13cmos5l_or3_1
X_5694_ _5694_/Y _5702_/A _5701_/B VDD VSS sg13cmos5l_nand2_1
X_6315_ _6323_/A _6316_/A _6316_/B VDD VSS sg13cmos5l_nand2_1
X_5128_ _5130_/C _5128_/A _5149_/B VDD VSS sg13cmos5l_nand2_1
X_6177_ _6179_/B _6177_/A _6177_/B VDD VSS sg13cmos5l_xnor2_1
X_6246_ _6257_/B _6247_/A _6247_/B VDD VSS sg13cmos5l_or2_1
X_7295_ _7295_/Q clkload3/A _7295_/D _7295_/RESET_B VDD VSS sg13cmos5l_dfrbpq_1
X_5059_ _5060_/C _5579_/A _5059_/B _5059_/C VDD VSS sg13cmos5l_nand3_1
X_7039__341 _7039_/RESET_B VDD VSS sg13cmos5l_tiehi
XFILLER_40_378 VDD VSS sg13cmos5l_fill_2
XFILLER_20_95 VDD VSS sg13cmos5l_fill_2
XFILLER_28_180 VDD VSS sg13cmos5l_fill_2
XANTENNA_2 _7134_/D VDD VSS sg13cmos5l_antennanp
X_4430_ _4430_/Y _4431_/A _4431_/B VDD VSS sg13cmos5l_nor2_1
XFILLER_39_412 VDD VSS sg13cmos5l_fill_2
X_4292_ _4294_/B _4292_/A _4292_/B _4292_/C VDD VSS sg13cmos5l_or3_1
X_4361_ _4365_/A _4366_/A _4366_/B _4359_/Y VDD VSS sg13cmos5l_o21ai_1
X_6031_ _6034_/A _7311_/Q _7295_/Q VDD VSS sg13cmos5l_xnor2_1
X_6100_ _7208_/D _6045_/Y _7208_/Q _6106_/S VDD VSS sg13cmos5l_mux2_1
X_7080_ _7080_/Q _7104_/CLK _7080_/D _7080_/RESET_B VDD VSS sg13cmos5l_dfrbpq_1
XFILLER_13_0 VDD VSS sg13cmos5l_fill_2
XFILLER_22_301 VDD VSS sg13cmos5l_fill_2
X_7058__238 _7058_/RESET_B VDD VSS sg13cmos5l_tiehi
X_6933_ _7047_/D _6930_/B _4258_/X _6932_/Y VDD VSS sg13cmos5l_a21oi_1
X_6864_ _6883_/B _7013_/Q _6865_/B VDD VSS sg13cmos5l_nand2_1
XFILLER_22_345 VDD VSS sg13cmos5l_fill_2
X_5677_ _5677_/Y _5679_/A _5679_/B VDD VSS sg13cmos5l_nand2_1
X_5746_ _5747_/C _5745_/B _5745_/C _7120_/Q VDD VSS sg13cmos5l_a21oi_1
X_5815_ _5816_/A _5090_/A _5154_/Y _5812_/Y _5814_/Y VDD VSS sg13cmos5l_a22oi_1
X_7069__334 _7069_/RESET_B VDD VSS sg13cmos5l_tiehi
X_6795_ _6798_/B _7008_/Q _6795_/B VDD VSS sg13cmos5l_xnor2_1
XFILLER_1_205 VDD VSS sg13cmos5l_fill_2
X_4559_ _4563_/A _5272_/A _4236_/Y _4234_/Y VDD VSS sg13cmos5l_o21ai_1
X_4628_ _4668_/A _4629_/A _4629_/B VDD VSS sg13cmos5l_nand2b_1
X_7278_ _7278_/Q clkload3/A _7278_/D _7278_/RESET_B VDD VSS sg13cmos5l_dfrbpq_1
X_6229_ _6232_/B _6229_/A _6229_/B VDD VSS sg13cmos5l_xor2_1
XFILLER_13_378 VDD VSS sg13cmos5l_fill_1
XFILLER_31_94 VDD VSS sg13cmos5l_fill_1
XFILLER_40_164 VDD VSS sg13cmos5l_fill_2
Xclkbuf_leaf_19_sd_clk _7308_/CLK clkbuf_leaf_2_sd_clk/A VDD VSS sg13cmos5l_buf_8
X_3930_ _3931_/B _5787_/C _4887_/B VDD VSS sg13cmos5l_nand2_1
X_7196__197 _7196_/RESET_B VDD VSS sg13cmos5l_tiehi
XFILLER_31_153 VDD VSS sg13cmos5l_fill_1
X_3792_ _4052_/B _3789_/B _4046_/A _3789_/A VDD VSS sg13cmos5l_o21ai_1
X_3861_ _3861_/Y _7248_/Q _3861_/B _3861_/C _3861_/D VDD VSS sg13cmos5l_nor4_1
X_5531_ _5557_/A _7086_/Q _5520_/B _5518_/Y VDD VSS sg13cmos5l_a21oi_1
X_5600_ _5639_/B _5637_/A _5601_/B VDD VSS sg13cmos5l_nand2_1
X_6580_ _6588_/B _6579_/A _6579_/B _6579_/C VDD VSS sg13cmos5l_a21o_1
X_4344_ _4344_/X _6216_/B _4345_/B VDD VSS sg13cmos5l_and2_1
X_4413_ _4416_/B _7036_/Q _4412_/C _4409_/Y VDD VSS sg13cmos5l_a21oi_1
X_5393_ _5395_/B _7108_/Q _5393_/B VDD VSS sg13cmos5l_xor2_1
X_5462_ _5462_/Y _5462_/A _5462_/B VDD VSS sg13cmos5l_nand2_1
X_7201_ _7201_/Q clkload4/A _7201_/D _7201_/RESET_B VDD VSS sg13cmos5l_dfrbpq_1
X_7132_ _7132_/Q _7318_/CLK _7132_/D _7132_/RESET_B VDD VSS sg13cmos5l_dfrbpq_1
X_7029__351 _7029_/RESET_B VDD VSS sg13cmos5l_tiehi
XFILLER_27_426 VDD VSS sg13cmos5l_fill_2
XFILLER_39_253 VDD VSS sg13cmos5l_fill_1
X_4275_ _4275_/Y _4272_/Y _4274_/Y _4225_/Y VDD VSS sg13cmos5l_a21oi_1
X_6014_ _6016_/A _7308_/Q _7292_/Q VDD VSS sg13cmos5l_nor2_1
X_7063_ _7063_/Q clkload5/A _7063_/D _7063_/RESET_B VDD VSS sg13cmos5l_dfrbpq_1
XFILLER_23_632 VDD VSS sg13cmos5l_fill_2
XFILLER_23_665 VDD VSS sg13cmos5l_fill_2
X_7036__344 _7036_/RESET_B VDD VSS sg13cmos5l_tiehi
X_6916_ _6916_/Y _6918_/B _6915_/Y _6436_/A VDD VSS sg13cmos5l_o21ai_1
X_6847_ _6849_/A _7039_/Q _6860_/B VDD VSS sg13cmos5l_xnor2_1
XFILLER_23_698 VDD VSS sg13cmos5l_decap_4
X_5729_ _5731_/B _5729_/A _5729_/B _5780_/B VDD VSS sg13cmos5l_nor3_1
X_6778_ _6780_/B _7006_/Q _6755_/B _6753_/Y VDD VSS sg13cmos5l_a21oi_1
XFILLER_2_536 VDD VSS sg13cmos5l_fill_2
X_7043__337 _7043_/RESET_B VDD VSS sg13cmos5l_tiehi
XFILLER_33_429 VDD VSS sg13cmos5l_fill_1
Xclkbuf_leaf_6_sd_clk clkload7/A clkload0/A VDD VSS sg13cmos5l_buf_8
XFILLER_3_65 VDD VSS sg13cmos5l_fill_1
XFILLER_3_98 VDD VSS sg13cmos5l_fill_1
X_4060_ _4063_/B _5280_/A _4060_/B _4060_/C VDD VSS sg13cmos5l_nor3_1
XFILLER_17_481 VDD VSS sg13cmos5l_fill_1
X_3913_ _4144_/A _3914_/A _3914_/B VDD VSS sg13cmos5l_nand2b_1
X_4893_ _4938_/A _4893_/A _4924_/B _4893_/C VDD VSS sg13cmos5l_nand3_1
X_4962_ _4967_/A _4097_/Y _4931_/B _4929_/Y VDD VSS sg13cmos5l_a21oi_1
X_6701_ _6703_/C _6701_/A _6701_/B VDD VSS sg13cmos5l_xor2_1
XFILLER_20_635 VDD VSS sg13cmos5l_fill_1
XFILLER_32_473 VDD VSS sg13cmos5l_decap_8
XFILLER_9_691 VDD VSS sg13cmos5l_fill_2
X_3775_ _3854_/B _3868_/A _3834_/B _3767_/Y VDD VSS sg13cmos5l_a21o_1
X_3844_ _3844_/Y _3846_/B _3846_/C VDD VSS sg13cmos5l_nor2_1
X_5514_ _5516_/B _5547_/B _5514_/B VDD VSS sg13cmos5l_nand2_1
X_6632_ _6642_/A _4288_/A _6617_/B _6618_/Y VDD VSS sg13cmos5l_o21ai_1
X_6563_ _7024_/D _6563_/A _6563_/B _6583_/B VDD VSS sg13cmos5l_nor3_1
X_6494_ _6511_/A _7021_/Q _6495_/B VDD VSS sg13cmos5l_nor2_1
X_4327_ _6970_/A _4328_/C _4328_/D VDD VSS sg13cmos5l_nand2_1
X_5376_ _5376_/Y _5376_/A _5401_/B VDD VSS sg13cmos5l_nand2_1
X_5445_ _5445_/Y _5446_/B _5428_/X VDD VSS sg13cmos5l_nor2b_1
Xfanout103 _6565_/C _3798_/X VDD VSS sg13cmos5l_buf_1
Xfanout114 _4235_/A _3814_/Y VDD VSS sg13cmos5l_buf_1
Xfanout125 _5981_/A2 _5920_/X VDD VSS sg13cmos5l_buf_1
Xfanout136 _6971_/A _3672_/Y VDD VSS sg13cmos5l_buf_1
Xfanout147 _6740_/A _5179_/A VDD VSS sg13cmos5l_buf_1
X_7115_ _7115_/Q _7243_/CLK _7115_/D _7115_/RESET_B VDD VSS sg13cmos5l_dfrbpq_1
XFILLER_27_234 VDD VSS sg13cmos5l_fill_1
XFILLER_28_746 VDD VSS sg13cmos5l_fill_2
X_4189_ _4193_/A _4189_/A _4189_/B _4189_/C VDD VSS sg13cmos5l_or3_1
X_4258_ _4258_/X _4258_/A _4258_/B VDD VSS sg13cmos5l_xor2_1
Xfanout158 _6947_/A _6940_/A VDD VSS sg13cmos5l_buf_1
Xfanout169 _6440_/A _4468_/A VDD VSS sg13cmos5l_buf_1
X_7046_ _7046_/Q _7270_/CLK _7046_/D _7046_/RESET_B VDD VSS sg13cmos5l_dfrbpq_1
XFILLER_19_702 VDD VSS sg13cmos5l_fill_2
XFILLER_5_2 VDD VSS sg13cmos5l_fill_1
XFILLER_33_259 VDD VSS sg13cmos5l_fill_2
X_7019__361 _7019_/RESET_B VDD VSS sg13cmos5l_tiehi
XFILLER_14_462 VDD VSS sg13cmos5l_fill_1
X_5161_ _5184_/A _5162_/B _5162_/A VDD VSS sg13cmos5l_nor2b_1
X_5230_ _5231_/B _7097_/Q _4468_/Y _4470_/B VDD VSS sg13cmos5l_a21oi_1
X_7026__354 _7026_/RESET_B VDD VSS sg13cmos5l_tiehi
X_4043_ _4647_/B _4072_/A _4043_/B VDD VSS sg13cmos5l_nor2_1
X_4112_ _4130_/A _4113_/A _4113_/B VDD VSS sg13cmos5l_nand2_1
X_5092_ _5094_/B _5092_/A _5092_/B VDD VSS sg13cmos5l_xor2_1
XFILLER_20_421 VDD VSS sg13cmos5l_fill_2
XFILLER_25_727 VDD VSS sg13cmos5l_fill_1
X_4876_ _4876_/Y _4918_/A _4875_/B _4917_/A VDD VSS sg13cmos5l_o21ai_1
X_4945_ _4947_/B _4977_/B _4944_/Y VDD VSS sg13cmos5l_nor2b_1
X_5994_ _6000_/A _7305_/Q _7289_/Q VDD VSS sg13cmos5l_xor2_1
X_7033__347 _7033_/RESET_B VDD VSS sg13cmos5l_tiehi
XFILLER_20_476 VDD VSS sg13cmos5l_decap_4
X_3689_ _3782_/B _7160_/Q _7159_/Q VDD VSS sg13cmos5l_xor2_1
X_3758_ _3758_/Y _3758_/A _3759_/B VDD VSS sg13cmos5l_xnor2_1
X_3827_ _3827_/Y _7115_/Q _5308_/B VDD VSS sg13cmos5l_nand2_1
X_6615_ _6616_/B _6594_/X _6597_/B _6595_/A VDD VSS sg13cmos5l_a21oi_1
X_6546_ _6547_/B _6546_/A _6545_/Y VDD VSS sg13cmos5l_nor2b_1
X_6477_ _6479_/B _6992_/Q _6477_/B VDD VSS sg13cmos5l_xnor2_1
X_5359_ _5360_/B _5516_/A _5359_/B VDD VSS sg13cmos5l_xnor2_1
X_5428_ _5428_/X _7082_/Q _5415_/Y _5416_/A VDD VSS sg13cmos5l_a21o_1
X_7029_ _7029_/Q clkload9/A _7029_/D _7029_/RESET_B VDD VSS sg13cmos5l_dfrbpq_1
XFILLER_3_675 VDD VSS sg13cmos5l_fill_1
XFILLER_0_55 VDD VSS sg13cmos5l_fill_2
XFILLER_21_229 VDD VSS sg13cmos5l_fill_2
X_4730_ _4776_/A _4731_/A _4731_/B _4731_/C VDD VSS sg13cmos5l_nor3_1
X_7132__257 _7132_/RESET_B VDD VSS sg13cmos5l_tiehi
X_4592_ _4635_/A _4592_/A _4592_/B VDD VSS sg13cmos5l_xnor2_1
X_4661_ _4661_/Y _4863_/A _4662_/B VDD VSS sg13cmos5l_nand2_1
X_6400_ _6400_/Y _6422_/B VDD VSS sg13cmos5l_inv_1
X_6331_ _6334_/B _6329_/Y _6331_/B VDD VSS sg13cmos5l_nand2b_1
X_5144_ _5146_/B _5174_/A _5144_/B _5144_/C VDD VSS sg13cmos5l_or3_1
X_5213_ _7096_/D _5211_/A _5211_/B _5212_/Y VDD VSS sg13cmos5l_a21oi_1
X_6193_ _6198_/A _5253_/A _6185_/B _6183_/Y VDD VSS sg13cmos5l_o21ai_1
X_6262_ _6262_/Y _6260_/Y _6261_/Y _6253_/A VDD VSS sg13cmos5l_o21ai_1
XFILLER_25_557 VDD VSS sg13cmos5l_decap_4
XFILLER_25_568 VDD VSS sg13cmos5l_fill_1
XFILLER_37_373 VDD VSS sg13cmos5l_fill_2
X_4026_ _4040_/B _4026_/A _4026_/B VDD VSS sg13cmos5l_xor2_1
X_5075_ _5080_/A _4921_/B _4920_/Y _4921_/X _4757_/A _5074_/Y VDD VSS sg13cmos5l_a221oi_1
X_4859_ _4903_/B _4858_/A _4858_/B _4858_/C VDD VSS sg13cmos5l_a21oi_1
X_4928_ _4933_/A _5351_/A _4885_/B _4889_/B VDD VSS sg13cmos5l_a21oi_1
X_5977_ _5977_/Y _7183_/Q _5980_/A2 _5977_/B1 _7213_/Q VDD VSS sg13cmos5l_a22oi_1
XFILLER_20_295 VDD VSS sg13cmos5l_fill_1
XFILLER_4_417 VDD VSS sg13cmos5l_fill_2
X_6529_ _6529_/Y _7023_/Q _6530_/B VDD VSS sg13cmos5l_nand2_1
X_7009__371 _7009_/RESET_B VDD VSS sg13cmos5l_tiehi
XFILLER_16_524 VDD VSS sg13cmos5l_fill_2
X_7016__364 _7016_/RESET_B VDD VSS sg13cmos5l_tiehi
XFILLER_12_752 VDD VSS sg13cmos5l_fill_1
X_7023__357 _7023_/RESET_B VDD VSS sg13cmos5l_tiehi
XFILLER_15_4 VDD VSS sg13cmos5l_fill_1
XFILLER_38_126 VDD VSS sg13cmos5l_fill_1
XFILLER_38_159 VDD VSS sg13cmos5l_fill_1
X_5900_ _5901_/B _7143_/Q _5875_/B _5902_/B1 _7142_/Q VDD VSS sg13cmos5l_a22oi_1
X_6880_ _6881_/B _6880_/A _6880_/B VDD VSS sg13cmos5l_xor2_1
XFILLER_34_354 VDD VSS sg13cmos5l_fill_2
X_4713_ _4736_/A _4689_/A _4689_/B _4687_/Y VDD VSS sg13cmos5l_a21oi_1
X_5693_ _5701_/B _5692_/B _5692_/C _5692_/A VDD VSS sg13cmos5l_o21ai_1
X_5762_ _5768_/B _5739_/A _5741_/A _5739_/B VDD VSS sg13cmos5l_o21ai_1
X_5831_ _7123_/D _6977_/A _5831_/B _5832_/B VDD VSS sg13cmos5l_nor3_1
X_4575_ _4575_/Y _4576_/A _4576_/B VDD VSS sg13cmos5l_nor2b_1
X_4644_ _4651_/A _5596_/B _4768_/S VDD VSS sg13cmos5l_xnor2_1
X_6245_ _6247_/B _6999_/Q _6277_/B VDD VSS sg13cmos5l_xnor2_1
X_7294_ _7294_/Q clkload3/A _7294_/D _7294_/RESET_B VDD VSS sg13cmos5l_dfrbpq_1
X_6314_ _6316_/B _6700_/A _6303_/B _6301_/Y VDD VSS sg13cmos5l_o21ai_1
X_5058_ _5060_/B _5059_/B _5059_/C _5579_/A VDD VSS sg13cmos5l_a21o_1
X_5127_ _5149_/B _5127_/A _5127_/B _5127_/C VDD VSS sg13cmos5l_nand3_1
X_6176_ _6177_/B _6992_/Q _6195_/B VDD VSS sg13cmos5l_xnor2_1
X_4009_ _4024_/B _4719_/B _4617_/A VDD VSS sg13cmos5l_nor2_1
XFILLER_20_85 VDD VSS sg13cmos5l_fill_2
XFILLER_16_332 VDD VSS sg13cmos5l_fill_1
XFILLER_29_94 VDD VSS sg13cmos5l_fill_2
XFILLER_35_129 VDD VSS sg13cmos5l_fill_1
XFILLER_16_354 VDD VSS sg13cmos5l_fill_1
XFILLER_16_387 VDD VSS sg13cmos5l_fill_1
XFILLER_31_324 VDD VSS sg13cmos5l_fill_1
XANTENNA_3 _7137_/D VDD VSS sg13cmos5l_antennanp
XFILLER_8_564 VDD VSS sg13cmos5l_fill_1
X_4360_ _4366_/B _4360_/A _4360_/B VDD VSS sg13cmos5l_xor2_1
X_4291_ _4291_/Y _4292_/A _4292_/B _4292_/C VDD VSS sg13cmos5l_nor3_1
X_6030_ _7175_/D _7175_/Q _6029_/Y _6074_/S VDD VSS sg13cmos5l_mux2_1
XFILLER_35_630 VDD VSS sg13cmos5l_fill_1
XFILLER_35_663 VDD VSS sg13cmos5l_fill_2
X_5814_ _5814_/Y _4155_/B _5814_/B VDD VSS sg13cmos5l_nand2b_1
X_6932_ _6932_/Y _6930_/B _4258_/X _6932_/B1 VDD VSS sg13cmos5l_o21ai_1
X_6863_ _6865_/B _6863_/A _6863_/B VDD VSS sg13cmos5l_xor2_1
XFILLER_34_195 VDD VSS sg13cmos5l_fill_1
X_4627_ _4629_/B _7080_/Q _4627_/B VDD VSS sg13cmos5l_xnor2_1
X_5676_ _5679_/B _5715_/A _5715_/B VDD VSS sg13cmos5l_xor2_1
X_5745_ _5759_/B _7120_/Q _5745_/B _5745_/C VDD VSS sg13cmos5l_and3_1
X_6794_ _6795_/B _6794_/A _6794_/B VDD VSS sg13cmos5l_xor2_1
X_4489_ _4489_/Y _4491_/A _4491_/B VDD VSS sg13cmos5l_nand2_1
X_4558_ _7075_/D _4547_/C _4556_/X _4557_/Y VDD VSS sg13cmos5l_a21oi_1
X_6228_ _6240_/A _6229_/A _6229_/B VDD VSS sg13cmos5l_nand2b_1
X_7277_ _7277_/Q clkload3/A _7277_/D _7277_/RESET_B VDD VSS sg13cmos5l_dfrbpq_1
X_6159_ _7306_/D _7306_/Q _7274_/Q _7126_/D VDD VSS sg13cmos5l_mux2_1
X_7006__374 _7006_/RESET_B VDD VSS sg13cmos5l_tiehi
XFILLER_25_173 VDD VSS sg13cmos5l_fill_2
XFILLER_25_195 VDD VSS sg13cmos5l_fill_1
Xoutput5 sd_out _7230_/Q VDD VSS sg13cmos5l_buf_1
X_7013__367 _7013_/RESET_B VDD VSS sg13cmos5l_tiehi
XFILLER_29_490 VDD VSS sg13cmos5l_decap_8
XFILLER_31_110 VDD VSS sg13cmos5l_fill_2
XFILLER_32_600 VDD VSS sg13cmos5l_fill_2
X_3791_ _4053_/B _3790_/B _3790_/C _3790_/A VDD VSS sg13cmos5l_a21oi_1
X_3860_ _3861_/D _7099_/Q _7100_/Q _7102_/Q _7101_/Q VDD VSS sg13cmos5l_nand4_1
X_5461_ _5464_/B _5461_/A _5461_/B VDD VSS sg13cmos5l_xnor2_1
X_5530_ _5530_/Y _5522_/Y _5530_/B VDD VSS sg13cmos5l_nand2b_1
X_4274_ _4274_/Y _4277_/A VDD VSS sg13cmos5l_inv_1
X_4343_ _4345_/B _4343_/A _4343_/B VDD VSS sg13cmos5l_xnor2_1
X_4412_ _4433_/A _7036_/Q _4412_/B _4412_/C VDD VSS sg13cmos5l_nand3_1
X_5392_ _5415_/B _7108_/Q _5392_/B VDD VSS sg13cmos5l_nand2_1
X_7200_ _7200_/Q clkload4/A _7200_/D _7200_/RESET_B VDD VSS sg13cmos5l_dfrbpq_1
X_7131_ _7131_/Q _7318_/CLK _7131_/D _7131_/RESET_B VDD VSS sg13cmos5l_dfrbpq_1
X_7062_ _7062_/Q clkload5/A _7062_/D _7062_/RESET_B VDD VSS sg13cmos5l_dfrbpq_1
XFILLER_39_265 VDD VSS sg13cmos5l_fill_1
X_6013_ _6017_/A _7307_/Q _7291_/Q _6011_/A VDD VSS sg13cmos5l_a21oi_1
XFILLER_22_110 VDD VSS sg13cmos5l_fill_1
XFILLER_35_471 VDD VSS sg13cmos5l_fill_1
X_6915_ _6915_/Y _6915_/A _6915_/B VDD VSS sg13cmos5l_nor2_1
X_6846_ _7038_/D _6857_/B _6845_/Y VDD VSS sg13cmos5l_nor2b_1
X_6777_ _6780_/A _7007_/Q _6777_/B VDD VSS sg13cmos5l_xnor2_1
X_3989_ _4084_/B _3990_/B _3990_/A VDD VSS sg13cmos5l_nor2b_1
X_5659_ _5700_/A _5660_/A _5660_/B VDD VSS sg13cmos5l_xor2_1
X_5728_ _5780_/B _5728_/A _5728_/B VDD VSS sg13cmos5l_xor2_1
XFILLER_41_474 VDD VSS sg13cmos5l_fill_1
XFILLER_5_353 VDD VSS sg13cmos5l_fill_2
X_3843_ _3847_/C _3846_/B _3843_/B VDD VSS sg13cmos5l_or2_1
X_3912_ _3914_/B _5153_/A _3912_/B VDD VSS sg13cmos5l_xnor2_1
X_4892_ _4893_/C _4924_/A _4891_/C _4891_/A VDD VSS sg13cmos5l_a21o_1
X_4961_ _4972_/A _4934_/A _4934_/B _4932_/Y VDD VSS sg13cmos5l_a21oi_1
X_6700_ _6701_/B _6700_/A _6700_/B VDD VSS sg13cmos5l_xnor2_1
X_6631_ _7027_/D _6971_/A _6631_/B _6631_/C VDD VSS sg13cmos5l_nor3_1
XFILLER_32_496 VDD VSS sg13cmos5l_fill_2
X_3774_ _3776_/D _3868_/A _3834_/B _3767_/Y VDD VSS sg13cmos5l_a21oi_1
X_5444_ _5446_/B _7083_/Q _5444_/B VDD VSS sg13cmos5l_xnor2_1
X_5513_ _5514_/B _5513_/A _5513_/B _5513_/C VDD VSS sg13cmos5l_nand3_1
X_6562_ _6583_/B _6562_/A _6562_/B VDD VSS sg13cmos5l_nor2_1
X_6493_ _6501_/A _6993_/Q _6486_/B _6484_/Y VDD VSS sg13cmos5l_a21oi_1
X_4257_ _6930_/B _7018_/Q _7045_/Q _4257_/C VDD VSS sg13cmos5l_nand3_1
X_4326_ _4328_/D _4325_/A _4325_/B _4325_/C VDD VSS sg13cmos5l_o21ai_1
X_5375_ _5401_/B _5422_/A _5451_/A VDD VSS sg13cmos5l_nand2b_1
Xfanout104 _5280_/A _3798_/X VDD VSS sg13cmos5l_buf_1
Xfanout115 _5253_/A _5354_/B VDD VSS sg13cmos5l_buf_1
Xfanout126 _4239_/A _5294_/B VDD VSS sg13cmos5l_buf_1
Xfanout137 _6402_/A _6925_/B1 VDD VSS sg13cmos5l_buf_1
Xfanout148 _5179_/A _6985_/A VDD VSS sg13cmos5l_buf_1
Xfanout159 _6930_/A _6932_/B1 VDD VSS sg13cmos5l_buf_1
X_7142__237 _7142_/RESET_B VDD VSS sg13cmos5l_tiehi
X_7114_ _7114_/Q _7243_/CLK _7114_/D _7114_/RESET_B VDD VSS sg13cmos5l_dfrbpq_1
X_7045_ _7045_/Q _7270_/CLK _7045_/D _7045_/RESET_B VDD VSS sg13cmos5l_dfrbpq_1
XFILLER_27_224 VDD VSS sg13cmos5l_fill_1
X_4188_ _4189_/C _4169_/A _4168_/C _7064_/Q VDD VSS sg13cmos5l_a21oi_1
X_7003__377 _7003_/RESET_B VDD VSS sg13cmos5l_tiehi
XFILLER_11_603 VDD VSS sg13cmos5l_decap_8
XFILLER_23_463 VDD VSS sg13cmos5l_fill_2
X_6829_ _7037_/D _6830_/B _6827_/X _6828_/Y VDD VSS sg13cmos5l_a21oi_1
X_7047__260 _7047_/RESET_B VDD VSS sg13cmos5l_tiehi
XFILLER_26_290 VDD VSS sg13cmos5l_fill_2
X_7089__305 _7089_/RESET_B VDD VSS sg13cmos5l_tiehi
X_4111_ _4113_/B _4111_/A _4111_/B VDD VSS sg13cmos5l_xnor2_1
X_5091_ _5127_/A _5092_/B _5092_/A VDD VSS sg13cmos5l_nand2b_1
X_5160_ _5162_/B _5160_/A _5160_/B VDD VSS sg13cmos5l_xnor2_1
XFILLER_37_533 VDD VSS sg13cmos5l_fill_1
XFILLER_37_577 VDD VSS sg13cmos5l_fill_1
X_4042_ _4043_/B _7154_/Q _5294_/B VDD VSS sg13cmos5l_nor2_1
X_5993_ _6005_/A _7305_/Q _7289_/Q VDD VSS sg13cmos5l_and2_1
XFILLER_40_709 VDD VSS sg13cmos5l_fill_1
X_3826_ _4613_/A _4611_/A _4611_/C VDD VSS sg13cmos5l_nand2_1
X_4875_ _4915_/B _4918_/A _4875_/B VDD VSS sg13cmos5l_nor2_1
X_4944_ _4944_/Y _4944_/A _4997_/A _4944_/C VDD VSS sg13cmos5l_nand3_1
X_6614_ _6616_/A _6614_/A _6614_/B VDD VSS sg13cmos5l_xnor2_1
X_3688_ _3824_/A _7159_/Q _7158_/Q VDD VSS sg13cmos5l_xnor2_1
X_3757_ _3851_/A _3836_/B _3836_/C VDD VSS sg13cmos5l_or2_1
X_5427_ _5427_/Y _5427_/A _5427_/B VDD VSS sg13cmos5l_nor2_1
X_6545_ _6545_/Y _6569_/A _6544_/C _6544_/A VDD VSS sg13cmos5l_o21ai_1
X_6476_ _6477_/B _6476_/A _6476_/B VDD VSS sg13cmos5l_xor2_1
XFILLER_28_533 VDD VSS sg13cmos5l_fill_2
X_4309_ _4311_/C _4308_/B _4308_/C _7033_/Q VDD VSS sg13cmos5l_a21oi_1
X_5289_ _5290_/B _5372_/A _5321_/A VDD VSS sg13cmos5l_xor2_1
X_5358_ _5358_/Y _5516_/A _5359_/B VDD VSS sg13cmos5l_nand2_1
X_7028_ _7028_/Q clkload9/A _7028_/D _7028_/RESET_B VDD VSS sg13cmos5l_dfrbpq_1
XFILLER_28_599 VDD VSS sg13cmos5l_fill_1
XFILLER_31_709 VDD VSS sg13cmos5l_fill_2
XFILLER_23_260 VDD VSS sg13cmos5l_fill_1
XFILLER_23_52 VDD VSS sg13cmos5l_fill_2
XFILLER_3_654 VDD VSS sg13cmos5l_fill_2
XFILLER_9_32 VDD VSS sg13cmos5l_fill_2
X_4660_ _4662_/B _4660_/A _4660_/B VDD VSS sg13cmos5l_xor2_1
X_4591_ _4607_/A _4592_/A _4592_/B VDD VSS sg13cmos5l_nor2_1
X_6261_ _6261_/Y _6261_/A _6261_/B VDD VSS sg13cmos5l_nand2_1
X_6330_ _6331_/B _6327_/Y _6330_/B VDD VSS sg13cmos5l_nand2b_1
X_5074_ _5074_/Y _5076_/A _5074_/B _5074_/C _5074_/D VDD VSS sg13cmos5l_nand4_1
X_5143_ _5144_/C _5176_/B _5176_/C VDD VSS sg13cmos5l_nor2_1
X_5212_ _5212_/Y _5212_/A _5212_/B VDD VSS sg13cmos5l_nand2_1
X_6192_ _6192_/X _6189_/A _6189_/B _6187_/X VDD VSS sg13cmos5l_a21o_1
X_4025_ _4030_/A _4026_/A _4026_/B VDD VSS sg13cmos5l_nand2_1
X_5976_ _5976_/Y _7228_/Q _5981_/A2 _5981_/B1 _7198_/Q VDD VSS sg13cmos5l_a22oi_1
X_3809_ _3809_/X _3810_/A _3810_/B VDD VSS sg13cmos5l_xor2_1
X_4789_ _4828_/A _4790_/A _4790_/B VDD VSS sg13cmos5l_nor2b_1
X_4858_ _4903_/A _4858_/A _4858_/B _4858_/C VDD VSS sg13cmos5l_and3_1
X_4927_ _4934_/A _5671_/A _4927_/B VDD VSS sg13cmos5l_xnor2_1
X_6528_ _6530_/B _6528_/A _6528_/B VDD VSS sg13cmos5l_xnor2_1
X_6459_ _7016_/D _6452_/Y _6457_/X _6458_/Y VDD VSS sg13cmos5l_a21oi_1
X_7079__315 _7079_/RESET_B VDD VSS sg13cmos5l_tiehi
X_7086__308 _7086_/RESET_B VDD VSS sg13cmos5l_tiehi
XFILLER_19_385 VDD VSS sg13cmos5l_fill_2
X_5830_ _5832_/B _5829_/A _5829_/B _5829_/C VDD VSS sg13cmos5l_a21oi_1
X_4643_ _4689_/A _5596_/B _4768_/S VDD VSS sg13cmos5l_nor2_1
X_4712_ _4739_/A _4761_/A _4761_/B _4690_/Y VDD VSS sg13cmos5l_a21oi_1
X_5692_ _5702_/A _5692_/A _5692_/B _5692_/C VDD VSS sg13cmos5l_or3_1
X_5761_ _5768_/A _5718_/A _5718_/B _5760_/X VDD VSS sg13cmos5l_a21o_1
X_4574_ _4576_/B _7077_/Q _4574_/B VDD VSS sg13cmos5l_xnor2_1
X_6244_ _6257_/A _6999_/Q _6277_/B VDD VSS sg13cmos5l_nand2_1
X_7293_ _7293_/Q clkload4/A _7293_/D _7293_/RESET_B VDD VSS sg13cmos5l_dfrbpq_1
Xfanout6 _6877_/B _5833_/B VDD VSS sg13cmos5l_buf_1
X_6313_ _6316_/A _6720_/A _6313_/B VDD VSS sg13cmos5l_xor2_1
X_4008_ _4616_/A _4239_/A _4681_/A VDD VSS sg13cmos5l_nand2_1
X_5057_ _5082_/A _5059_/B _5059_/C _5579_/A VDD VSS sg13cmos5l_a21oi_1
X_5126_ _5128_/A _5127_/A _5127_/B _5127_/C VDD VSS sg13cmos5l_a21o_1
X_6175_ _6175_/Y _6992_/Q _6528_/A VDD VSS sg13cmos5l_nand2_1
XFILLER_13_517 VDD VSS sg13cmos5l_fill_1
XFILLER_25_311 VDD VSS sg13cmos5l_fill_1
XFILLER_25_388 VDD VSS sg13cmos5l_fill_1
X_5959_ _7160_/D _7160_/Q _5967_/A2 _5958_/Y VDD VSS sg13cmos5l_a21o_1
XFILLER_16_344 VDD VSS sg13cmos5l_fill_2
XFILLER_28_182 VDD VSS sg13cmos5l_fill_1
XFILLER_29_694 VDD VSS sg13cmos5l_fill_1
XFILLER_12_561 VDD VSS sg13cmos5l_fill_1
XFILLER_8_554 VDD VSS sg13cmos5l_fill_1
XANTENNA_4 _7145_/D VDD VSS sg13cmos5l_antennanp
XFILLER_6_66 VDD VSS sg13cmos5l_fill_2
X_4290_ _4292_/C _4289_/B _4289_/C _7059_/Q VDD VSS sg13cmos5l_a21oi_1
XFILLER_39_436 VDD VSS sg13cmos5l_decap_4
XFILLER_39_458 VDD VSS sg13cmos5l_fill_1
XFILLER_22_303 VDD VSS sg13cmos5l_fill_1
X_5813_ _5814_/B _4155_/A _4154_/B _4154_/C VDD VSS sg13cmos5l_o21ai_1
X_6931_ _7046_/D _6931_/A _6931_/B VDD VSS sg13cmos5l_nor2_1
X_6862_ _6883_/A _6863_/A _6863_/B VDD VSS sg13cmos5l_or2_1
X_6793_ _6793_/Y _6794_/A _6794_/B VDD VSS sg13cmos5l_nor2_1
X_4626_ _4665_/A _7080_/Q _4627_/B VDD VSS sg13cmos5l_nor2_1
X_5675_ _5716_/A _5715_/A _5715_/B VDD VSS sg13cmos5l_nor2_1
X_5744_ _5745_/C _5770_/A _5744_/B _5744_/C VDD VSS sg13cmos5l_nand3_1
XFILLER_1_207 VDD VSS sg13cmos5l_fill_1
XFILLER_1_218 VDD VSS sg13cmos5l_fill_1
X_4488_ _4491_/B _7041_/Q _4488_/B VDD VSS sg13cmos5l_xnor2_1
X_4557_ _4557_/Y _4547_/C _4556_/X _4596_/A VDD VSS sg13cmos5l_o21ai_1
X_6158_ _7305_/D _7305_/Q _7273_/Q _6164_/S VDD VSS sg13cmos5l_mux2_1
X_6227_ _6229_/B _6592_/B _6217_/B _6215_/Y VDD VSS sg13cmos5l_o21ai_1
X_7276_ _7276_/Q _7308_/CLK _7276_/D _7276_/RESET_B VDD VSS sg13cmos5l_dfrbpq_1
XFILLER_25_141 VDD VSS sg13cmos5l_fill_1
X_5109_ _5110_/B _5109_/A _5109_/B VDD VSS sg13cmos5l_xor2_1
X_6089_ _7198_/D _6071_/Y _7198_/Q _6090_/S VDD VSS sg13cmos5l_mux2_1
X_7076__318 _7076_/RESET_B VDD VSS sg13cmos5l_tiehi
XFILLER_40_166 VDD VSS sg13cmos5l_fill_1
XFILLER_5_502 VDD VSS sg13cmos5l_fill_2
XFILLER_31_133 VDD VSS sg13cmos5l_fill_2
XFILLER_32_623 VDD VSS sg13cmos5l_fill_2
X_7057__240 _7057_/RESET_B VDD VSS sg13cmos5l_tiehi
XFILLER_31_177 VDD VSS sg13cmos5l_fill_1
XFILLER_32_678 VDD VSS sg13cmos5l_decap_4
X_3790_ _4052_/A _3790_/A _3790_/B _3790_/C VDD VSS sg13cmos5l_nand3_1
X_4411_ _4412_/C _4410_/A _4410_/C _4410_/B VDD VSS sg13cmos5l_o21ai_1
X_5460_ _5489_/A _5461_/A _5461_/B VDD VSS sg13cmos5l_and2_1
X_4273_ _4277_/A _4273_/A _4273_/B VDD VSS sg13cmos5l_xnor2_1
X_4342_ _4343_/B _4002_/Y _4342_/B VDD VSS sg13cmos5l_nand2b_1
X_5391_ _5392_/B _5393_/B VDD VSS sg13cmos5l_inv_1
X_6012_ _7172_/D _7172_/Q _6011_/Y _6062_/S VDD VSS sg13cmos5l_mux2_1
X_7130_ _7130_/Q clkload6/A _7130_/D _7130_/RESET_B VDD VSS sg13cmos5l_dfrbpq_1
X_7061_ _7061_/Q clkload5/A _7061_/D _7061_/RESET_B VDD VSS sg13cmos5l_dfrbpq_1
.ends
