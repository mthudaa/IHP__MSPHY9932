** sch_path: /foss/designs/adc8b/sch/adc8b.sch
.subckt adc8b vdd vddr vss vip vin cks data[0] data[1] data[2] cko frame
*.PININFO vddr:I vss:I vip:I vin:I data[0:2]:O cko:O cks:I vdd:I frame:O
x7 vddr vss ph_sw[0] ph_sw[1] ph_sw[2] ph_sw[3] ph_sw[4] ph_sw[5] ph_sw[6] ph_sw[7] ph_sw[8] ph_sw[9] ph_sw[10] pl_sw[0] pl_sw[1]
+ pl_sw[2] pl_sw[3] pl_sw[4] pl_sw[5] pl_sw[6] pl_sw[7] pl_sw[8] pl_sw[9] pl_sw[10] vcp side_cap8b
x8 vddr vss nh_sw[0] nh_sw[1] nh_sw[2] nh_sw[3] nh_sw[4] nh_sw[5] nh_sw[6] nh_sw[7] nh_sw[8] nh_sw[9] nh_sw[10] nl_sw[0] nl_sw[1]
+ nl_sw[2] nl_sw[3] nl_sw[4] nl_sw[5] nl_sw[6] nl_sw[7] nl_sw[8] nl_sw[9] nl_sw[10] vcn side_cap8b
x9 vss vdd ckc cko cks comp_p data[0] data[1] data[2] frame nh_sw[0] nh_sw[10] nh_sw[1] nh_sw[2] nh_sw[3] nh_sw[4] nh_sw[5]
+ nh_sw[6] nh_sw[7] nh_sw[8] nh_sw[9] nl_sw[0] nl_sw[10] nl_sw[1] nl_sw[2] nl_sw[3] nl_sw[4] nl_sw[5] nl_sw[6] nl_sw[7] nl_sw[8] nl_sw[9]
+ ph_sw[0] ph_sw[10] ph_sw[1] ph_sw[2] ph_sw[3] ph_sw[4] ph_sw[5] ph_sw[6] ph_sw[7] ph_sw[8] ph_sw[9] pl_sw[0] pl_sw[10] pl_sw[1] pl_sw[2]
+ pl_sw[3] pl_sw[4] pl_sw[5] pl_sw[6] pl_sw[7] pl_sw[8] pl_sw[9] rdy sar12b
x10 vip vin cks vdd vss vcp vcn diff_bsw
x11 vdd vss vcp vcn ckc rdy comp_p comp_n cmp
**** begin user architecture code

*.include /foss/pdks/ihp-sg13cmos5l/libs.ref/sg13cmos5l_stdcell/spice/sg13cmos5l_stdcell.spice

*xvddr vss vdd iovss iovdd vddr vddr_res sg13cmos5l_IOPadAnalog
*xvip vss vdd iovss iovdd vip vip_res sg13cmos5l_IOPadAnalog
*xvin vss vdd iovss iovdd vin vin_res sg13cmos5l_IOPadAnalog
*xcks vss vdd iovss iovdd cks cks_res sg13cmos5l_IOPadAnalog
*xvdd vss vdd iovss iovdd sg13cmos5l_IOPadVdd
*xvss vss vdd iovss iovdd sg13cmos5l_IOPadVss
*xd1 vss vdd iovss iovdd data[0] dout[0] sg13cmos5l_IOPadAnalog
*xd2 vss vdd iovss iovdd data[1] dout[1] sg13cmos5l_IOPadAnalog
*xd3 vss vdd iovss iovdd data[2] dout[2] sg13cmos5l_IOPadAnalog
*xd4 vss vdd iovss iovdd data[3] dout[3] sg13cmos5l_IOPadAnalog
*xd5 vss vdd iovss iovdd data[4] dout[4] sg13cmos5l_IOPadAnalog
*xd6 vss vdd iovss iovdd data[5] dout[5] sg13cmos5l_IOPadAnalog
*xd7 vss vdd iovss iovdd data[6] dout[6] sg13cmos5l_IOPadAnalog
*xd8 vss vdd iovss iovdd data[7] dout[7] sg13cmos5l_IOPadAnalog
*xd9 vss vdd iovss iovdd data[8] dout[8] sg13cmos5l_IOPadAnalog
*xd10 vss vdd iovss iovdd data[9] dout[9] sg13cmos5l_IOPadAnalog
*xd11 vss vdd iovss iovdd data[10] dout[10] sg13cmos5l_IOPadAnalog
*xd12 vss vdd iovss iovdd data[11] dout[11] sg13cmos5l_IOPadAnalog
*xcko vss vdd iovss iovdd cko eoc sg13cmos5l_IOPadAnalog

**** end user architecture code
.ends

* expanding   symbol:  side_cap8b.sym # of pins=5
** sym_path: /foss/designs/adc8b/sch/side_cap8b.sym
** sch_path: /foss/designs/adc8b/sch/side_cap8b.sch
.subckt side_cap8b vdd vss in_h_sw[0] in_h_sw[1] in_h_sw[2] in_h_sw[3] in_h_sw[4] in_h_sw[5] in_h_sw[6] in_h_sw[7] in_h_sw[8]
+ in_h_sw[9] in_h_sw[10] in_l_sw[0] in_l_sw[1] in_l_sw[2] in_l_sw[3] in_l_sw[4] in_l_sw[5] in_l_sw[6] in_l_sw[7] in_l_sw[8] in_l_sw[9]
+ in_l_sw[10] vc
*.PININFO vdd:I vss:I in_h_sw[0:10]:I in_l_sw[0:10]:I vc:B
x3 vdd vss in_l_sw[10] l_sw[10] buf_1
x7[1] vdd vss in_l_sw[8] l_sw[8] buf_2
x7[2] vdd vss in_l_sw[9] l_sw[9] buf_2
x2[1] vdd vss in_l_sw[6] l_sw[6] buf_4
x2[2] vdd vss in_l_sw[7] l_sw[7] buf_4
x6[1] vdd vss in_l_sw[3] l_sw[3] buf_8
x6[2] vdd vss in_l_sw[4] l_sw[4] buf_8
x6[3] vdd vss in_l_sw[5] l_sw[5] buf_8
x6 vdd vss in_h_sw[10] h_sw[10] buf_1
x8[1] vdd vss in_h_sw[8] h_sw[8] buf_2
x8[2] vdd vss in_h_sw[9] h_sw[9] buf_2
x3[1] vdd vss in_h_sw[6] h_sw[6] buf_4
x3[2] vdd vss in_h_sw[7] h_sw[7] buf_4
x5[1] vdd vss in_h_sw[3] h_sw[3] buf_8
x5[2] vdd vss in_h_sw[4] h_sw[4] buf_8
x5[3] vdd vss in_h_sw[5] h_sw[5] buf_8
x1[1] vdd vss in_l_sw[1] l_sw[1] buf_16
x1[2] vdd vss in_l_sw[2] l_sw[2] buf_16
x4[1] vdd vss in_h_sw[1] h_sw[1] buf_16
x4[2] vdd vss in_h_sw[2] h_sw[2] buf_16
x4 vdd vss in_l_sw[0] l_sw[0] buf_32
x5 vdd vss in_h_sw[0] h_sw[0] buf_32
x1 h_sw[0] h_sw[1] h_sw[2] h_sw[3] h_sw[4] h_sw[5] h_sw[6] h_sw[7] h_sw[8] h_sw[9] h_sw[10] l_sw[0] l_sw[1] l_sw[2] l_sw[3]
+ l_sw[4] l_sw[5] l_sw[6] l_sw[7] l_sw[8] l_sw[9] l_sw[10] vc vdd vss cap8b
.ends

* expanding   symbol:  sar12b.sym # of pins=13
** sym_path: /foss/designs/adc8b/sch/sar12b.sym
.include /foss/designs/adc8b/sch/simulations/sar12b.spice

* expanding   symbol:  diff_bsw.sym # of pins=7
** sym_path: /foss/designs/adc8b/sch/diff_bsw.sym
** sch_path: /foss/designs/adc8b/sch/diff_bsw.sch
.subckt diff_bsw vip vin ck vdd vss vcp vcn
*.PININFO vip:I vin:I ck:I vdd:I vss:I vcp:O vcn:O
x1 vip ck vdd vss vcp single_bsw
x2 vin ck vdd vss vcn single_bsw
.ends

* expanding   symbol:  cmp.sym # of pins=8
** sym_path: /foss/designs/adc8b/sch/cmp.sym
** sch_path: /foss/designs/adc8b/sch/cmp.sch
.subckt cmp vdd vss vip vin clk rdy outp outn
*.PININFO vdd:I vss:I vip:I vin:I clk:I rdy:O outp:O outn:O
MM14 outn clk vdd vdd sg13_lv_pmos w=1.0u l=0.13u ng=2
MM1 outp outn vdd vdd sg13_lv_pmos w=2.5u l=0.13u ng=2
MM2 outp clk vdd vdd sg13_lv_pmos w=1.0u l=0.13u ng=2
MM3 outn outp vdd vdd sg13_lv_pmos w=2.5u l=0.13u ng=2
MM5 net4 vip net1 vss sg13_lv_nmos w=10.0u l=0.13u ng=2
MM6 net1 clk vss vss sg13_lv_nmos w=2.0u l=0.13u ng=4
MM7 net5 vin net1 vss sg13_lv_nmos w=10.0u l=0.13u ng=2
x1 net6 net2 net3 vdd vss sg13cmos5l_or2_1
MM4 outn outp net4 vss sg13_lv_nmos w=10.0u l=0.13u ng=2
MM8 outp outn net5 vss sg13_lv_nmos w=10.0u l=0.13u ng=2
MM9 net4 clk vdd vdd sg13_lv_pmos w=1.0u l=0.13u ng=2
MM10 net5 clk vdd vdd sg13_lv_pmos w=1.0u l=0.13u ng=2
x6 net2 outp vdd vss sg13cmos5l_inv_1
x7 net3 outn vdd vss sg13cmos5l_inv_1
x2 vdd vss sg13cmos5l_decap_4
x3 vdd vss sg13cmos5l_decap_4
x4 rdy net6 vdd vss sg13cmos5l_dlygate4sd3_1
.ends

* expanding   symbol:  buf_1.sym # of pins=4
** sym_path: /foss/designs/adc8b/sch/buf_1.sym
** sch_path: /foss/designs/adc8b/sch/buf_1.sch
.subckt buf_1 vdd vss x z
*.PININFO vdd:I vss:I x:I z:O
MM2 z x vdd vdd sg13_lv_pmos w=1u l=0.13u ng=1
MM4 z x vss vss sg13_lv_nmos w=500n l=0.13u ng=1
.ends

* expanding   symbol:  buf_2.sym # of pins=4
** sym_path: /foss/designs/adc8b/sch/buf_2.sym
** sch_path: /foss/designs/adc8b/sch/buf_2.sch
.subckt buf_2 vdd vss x z
*.PININFO vdd:I vss:I x:I z:O
MM2 z x vdd vdd sg13_lv_pmos w=1u l=0.13u ng=1 m=2
MM4 z x vss vss sg13_lv_nmos w=500n l=0.13u ng=1 m=2
.ends

* expanding   symbol:  buf_4.sym # of pins=4
** sym_path: /foss/designs/adc8b/sch/buf_4.sym
** sch_path: /foss/designs/adc8b/sch/buf_4.sch
.subckt buf_4 vdd vss x z
*.PININFO vdd:I vss:I x:I z:O
MM2 z x vdd vdd rfpmos w=1u l=0.13u ng=1 m=4
MM4 z x vss vss rfnmos w=500n l=0.13u ng=1 m=4
.ends

* expanding   symbol:  buf_8.sym # of pins=4
** sym_path: /foss/designs/adc8b/sch/buf_8.sym
** sch_path: /foss/designs/adc8b/sch/buf_8.sch
.subckt buf_8 vdd vss x z
*.PININFO vdd:I vss:I x:I z:O
MM2 z x vdd vdd sg13_lv_pmos w=1u l=0.13u ng=1 m=8
MM4 z x vss vss sg13_lv_nmos w=500n l=0.13u ng=1 m=8
.ends

* expanding   symbol:  buf_16.sym # of pins=4
** sym_path: /foss/designs/adc8b/sch/buf_16.sym
** sch_path: /foss/designs/adc8b/sch/buf_16.sch
.subckt buf_16 vdd vss x z
*.PININFO vdd:I vss:I x:I z:O
MM2 z x vdd vdd sg13_lv_pmos w=1u l=0.13u ng=1 m=16
MM4 z x vss vss sg13_lv_nmos w=500n l=0.13u ng=1 m=16
.ends

* expanding   symbol:  buf_32.sym # of pins=4
** sym_path: /foss/designs/adc8b/sch/buf_32.sym
** sch_path: /foss/designs/adc8b/sch/buf_32.sch
.subckt buf_32 vdd vss x z
*.PININFO vdd:I vss:I x:I z:O
MM2 z x vdd vdd sg13_lv_pmos w=1u l=0.13u ng=1 m=32
MM4 z x vss vss sg13_lv_nmos w=500n l=0.13u ng=1 m=32
.ends

* expanding   symbol:  cap8b.sym # of pins=5
** sym_path: /foss/designs/adc8b/sch/cap8b.sym
** sch_path: /foss/designs/adc8b/sch/cap8b.sch
.subckt cap8b h_sw[0] h_sw[1] h_sw[2] h_sw[3] h_sw[4] h_sw[5] h_sw[6] h_sw[7] h_sw[8] h_sw[9] h_sw[10] l_sw[0] l_sw[1] l_sw[2]
+ l_sw[3] l_sw[4] l_sw[5] l_sw[6] l_sw[7] l_sw[8] l_sw[9] l_sw[10] vc vdd vss
*.PININFO l_sw[0:10]:I vss:I vc:B h_sw[0:10]:I vdd:I
C3 vc l_sw[4] 'c' m=64
C4 vc h_sw[4] 'c' m=64
C5 vc l_sw[5] 'c' m=32
C6 vc h_sw[5] 'c' m=32
C7 vc l_sw[6] 'c' m=16
C8 vc h_sw[6] 'c' m=16
C9 vc l_sw[7] 'c' m=8
C10 vc h_sw[7] 'c' m=8
C11 vc l_sw[8] 'c' m=4
C12 vc h_sw[8] 'c' m=4
C13 vc l_sw[9] 'c' m=2
C14 vc h_sw[9] 'c' m=2
C15 vc l_sw[10] 'c'
C16 vc h_sw[10] 'c'
C17 vc vdd 'c'
C26 vc vss 'c'
C1 vc l_sw[0] 'c' m=1024
C2 vc h_sw[0] 'c' m=1024
C18 vc l_sw[1] 'c' m=512
C19 vc h_sw[1] 'c' m=512
C20 vc l_sw[2] 'c' m=256
C21 vc h_sw[2] 'c' m=256
C22 vc l_sw[3] 'c' m=128
C23 vc h_sw[3] 'c' m=128
.ends

* expanding   symbol:  single_bsw.sym # of pins=5
** sym_path: /foss/designs/adc8b/sch/single_bsw.sym
** sch_path: /foss/designs/adc8b/sch/single_bsw.sch
.subckt single_bsw in ck vdd vss out
*.PININFO vdd:I vss:I in:I ck:I out:O
MM1 vdd net2 net1 vss sg13_lv_nmos w=1.3u l=0.13u ng=1
MM3 vdd net1 net2 vss sg13_lv_nmos w=1.3u l=0.13u ng=1
MM4 vgs net9 net3 net3 sg13_lv_pmos w=0.5u l=0.13u ng=1
MM2 vdd net2 net3 vss sg13_lv_nmos w=1.3u l=0.13u ng=1
MM6 net5 gp vdd vdd sg13_lv_pmos w=500n l=130n ng=1
MM5 net5 vdd net4 vss sg13_lv_nmos w=3u l=0.13u ng=1
MM7 net4 ckb vss vss sg13_lv_nmos w=3u l=0.13u ng=1
MM8 net6 net5 in vss sg13_lv_nmos w=3u l=0.13u ng=1
MM9 out vgs in vss sg13_lv_nmos w=2.5u l=0.13u ng=1
MM10 net7 vdd vgs vss sg13_lv_nmos w=500n l=0.13u ng=1
MM11 vss ckb net7 vss sg13_lv_nmos w=500n l=0.13u ng=1
MM12 net6 ckb vss vss sg13_lv_nmos w=1.3u l=0.4u ng=1
x1 net8 ckb vdd vss sg13cmos5l_inv_1
x2 net9 gp vdd vss sg13cmos5l_inv_1
x3 ckb ck vdd vss sg13cmos5l_inv_1
CC2 net3 net6 cap_mfringe w=40.0u l=10.0u mmin=1 mmax=4
CC1 net1 net8 cap_mfringe w=8.0u l=8.0u mmin=1 mmax=4
CC3 net2 ckb cap_mfringe w=8.0u l=8.0u mmin=1 mmax=4
x4 vdd vss sg13cmos5l_decap_4
x5 vdd vss sg13cmos5l_decap_4
x6 vdd vss sg13cmos5l_decap_4
.ends
