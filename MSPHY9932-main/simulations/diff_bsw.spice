** sch_path: /foss/designs/adc8b/sch/diff_bsw.sch
.subckt diff_bsw vip vin ck vdd vss vcp vcn
*.PININFO vip:I vin:I ck:I vdd:I vss:I vcp:O vcn:O
x1 vip ck vdd vss vcp single_bsw
x2 vin ck vdd vss vcn single_bsw
.ends

* expanding   symbol:  single_bsw.sym # of pins=5
** sym_path: /foss/designs/adc8b/sch/single_bsw.sym
** sch_path: /foss/designs/adc8b/sch/single_bsw.sch
.subckt single_bsw in ck vdd vss out
*.PININFO vdd:I vss:I in:I ck:I out:O
MM1 vdd net2 net1 vss sg13_lv_nmos w=1.3u l=0.13u ng=1
MM3 vdd net1 net2 vss sg13_lv_nmos w=1.3u l=0.13u ng=1
MM4 vgs net9 net3 net3 sg13_lv_pmos w=0.5u l=0.13u ng=1
MM2 vdd net2 net3 vss sg13_lv_nmos w=1.3u l=0.13u ng=1
MM6 net5 gp vdd vdd sg13_lv_pmos w=500n l=130n ng=1
MM5 net5 vdd net4 vss sg13_lv_nmos w=3u l=0.13u ng=1
MM7 net4 ckb vss vss sg13_lv_nmos w=3u l=0.13u ng=1
MM8 net6 net5 in vss sg13_lv_nmos w=3u l=0.13u ng=1
MM9 out vgs in vss sg13_lv_nmos w=2.5u l=0.13u ng=1
MM10 net7 vdd vgs vss sg13_lv_nmos w=500n l=0.13u ng=1
MM11 vss ckb net7 vss sg13_lv_nmos w=500n l=0.13u ng=1
MM12 net6 ckb vss vss sg13_lv_nmos w=1.3u l=0.4u ng=1
x1 net8 ckb vdd vss sg13cmos5l_inv_1
x2 net9 gp vdd vss sg13cmos5l_inv_1
x3 ckb ck vdd vss sg13cmos5l_inv_1
CC2 net3 net6 cap_mfringe w=4.0u l=4.0u mmin=1 mmax=4
CC1 net1 net8 cap_mfringe w=2.0u l=2.0u mmin=1 mmax=4
CC3 net2 ckb cap_mfringe w=2.0u l=2.0u mmin=1 mmax=4
x4 vdd vss sg13cmos5l_decap_4
x5 vdd vss sg13cmos5l_decap_4
x6 vdd vss sg13cmos5l_decap_4
.ends
