* Simplified IO pad models for Xyce simulation (no ESD structures)
.subckt sg13cmos5l_IOPadIn vss vdd iovss iovdd p2c pad
R_pad pad p2c 0.1
.ends

.subckt sg13cmos5l_IOPadOut4mA vss vdd iovss iovdd c2p pad
R_pad c2p pad 0.1
.ends

.subckt sg13cmos5l_IOPadAnalog vss vdd iovss iovdd pad padres
R_pad pad padres 0.1
C_esd padres vss 0.1p
C_esd2 padres iovdd 0.1p
.ends

.subckt sg13cmos5l_IOPadVdd vss vdd iovss iovdd
R_pwr iovdd vdd 0.1
.ends

.subckt sg13cmos5l_IOPadVss vss vdd iovss iovdd
R_gnd iovss vss 0.1
.ends

.subckt sg13cmos5l_IOPadIOVss vss vdd iovss iovdd
R_gnd iovss vss 0.1
.ends

.subckt sg13cmos5l_IOPadIOVdd vss vdd iovss iovdd
R_pwr iovdd vdd 0.1
.ends

.subckt sg13cmos5l_Corner vss vdd iovss iovdd
.ends

.subckt sg13cmos5l_Filler200 vss vdd iovss iovdd
.ends
.subckt sg13cmos5l_Filler400 vss vdd iovss iovdd
.ends
.subckt sg13cmos5l_Filler1000 vss vdd iovss iovdd
.ends
.subckt sg13cmos5l_Filler2000 vss vdd iovss iovdd
.ends
.subckt sg13cmos5l_Filler4000 vss vdd iovss iovdd
.ends
.subckt sg13cmos5l_Filler10000 vss vdd iovss iovdd
.ends

.subckt sg13cmos5l_IOPadOut16mA vss vdd iovss iovdd c2p pad
R_pad c2p pad 0.1
.ends
.subckt sg13cmos5l_IOPadOut30mA vss vdd iovss iovdd c2p pad
R_pad c2p pad 0.1
.ends
.subckt sg13cmos5l_IOPadTriOut4mA vss vdd iovss iovdd c2p c2p_en pad
R_pad c2p pad 0.1
.ends
.subckt sg13cmos5l_IOPadTriOut16mA vss vdd iovss iovdd c2p c2p_en pad
R_pad c2p pad 0.1
.ends
.subckt sg13cmos5l_IOPadTriOut30mA vss vdd iovss iovdd c2p c2p_en pad
R_pad c2p pad 0.1
.ends
.subckt sg13cmos5l_IOPadInOut4mA vss vdd iovss iovdd p2c c2p c2p_en pad
R_pad pad p2c 0.1
R_pad2 c2p pad 0.1
.ends
.subckt sg13cmos5l_IOPadInOut16mA vss vdd iovss iovdd p2c c2p c2p_en pad
R_pad pad p2c 0.1
R_pad2 c2p pad 0.1
.ends
.subckt sg13cmos5l_IOPadInOut30mA vss vdd iovss iovdd p2c c2p c2p_en pad
R_pad pad p2c 0.1
R_pad2 c2p pad 0.1
.ends
