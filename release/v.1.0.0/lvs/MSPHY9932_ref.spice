* MSPHY9932 ref (per-instance iovss/iovdd)
.model sg13_lv_nmos nmos
.model sg13_lv_pmos pmos
.model sg13_hv_nmos nmos
.model sg13_hv_pmos pmos

.subckt MSPHY9932_ref vdd cks vip vin vddr data[0] data[1] data[2] cko frame
X0 SAR/a_15974_6162# SAR/sg13cmos5l_buf_1_57.X vdd vdd sg13_lv_pmos ad=79.8f pd=0.8u as=0.1428p ps=1.52u w=0.42u l=0.13u
X1 SAR/a_7440_1948# SAR/a_6889_1680# vdd vdd sg13_lv_pmos ad=0.105p pd=1.21u as=1.86162p ps=11.935u w=1u l=0.13u
X2 vdd SAR/sg13cmos5l_inv_1_27.Y SAR/a_14632_9224# vdd sg13_lv_pmos ad=0.2114p pd=1.54u as=0.2856p ps=2.36u w=0.84u l=0.13u
X3 vss SAR/a_7820_9150# SAR/sg13cmos5l_buf_1_73.X vss sg13_lv_nmos ad=0.14875p pd=1.16u as=0.2886p ps=2.26u w=0.74u l=0.13u
X4 vdd SAR/sg13cmos5l_dfrbp_1_6.RESET_B SAR/a_12490_6385# vdd sg13_lv_pmos ad=0.1563p pd=1.22u as=0.147p ps=1.54u w=0.42u l=0.13u
X5 vdd SAR/a_10473_9186# SAR/a_10406_9624# vdd sg13_lv_pmos ad=0.2387p pd=1.84u as=0.1008p ps=0.9u w=0.42u l=0.13u
X6 vss SAR/a_15429_7653# SAR/a_15531_7796# vss sg13_lv_nmos ad=1.49685p pd=9.6u as=0.2516p ps=2.16u w=0.74u l=0.13u
X7 vdd SAR/a_16940_3102# nh_sw[8] vdd sg13_lv_pmos ad=0.2114p pd=1.54u as=0.42p ps=2.99u w=1.12u l=0.13u
X8 vdd SAR/a_12976_2630# SAR/a_12921_2511# vdd sg13_lv_pmos ad=1.86162p pd=11.935u as=93.45f ps=0.865u w=0.42u l=0.13u
X9 SAR/sg13cmos5l_buf_1_44.A SAR/a_5673_3138# vss vss sg13_lv_nmos ad=0.2516p pd=2.16u as=0.1406p ps=1.12u w=0.74u l=0.13u
X10 SAR/a_13072_4142# SAR/a_12815_4261# SAR/a_13234_4338# vss sg13_lv_nmos ad=0.1428p pd=1.52u as=37.8f ps=0.6u w=0.42u l=0.13u
X11 vdd SAR/sg13cmos5l_inv_1_6.A SAR/sg13cmos5l_buf_1_0.A vdd sg13_lv_pmos ad=0.3808p pd=2.92u as=0.3808p ps=2.92u w=1.12u l=0.13u
X12 SAR/a_5104_4870# SAR/a_4847_4727# SAR/a_5266_4650# vss sg13_lv_nmos ad=0.1428p pd=1.52u as=37.8f ps=0.6u w=0.42u l=0.13u
X13 SAR/a_18615_5770# SAR/sg13cmos5l_dfrbp_1_8.D vss vss sg13_lv_nmos ad=0.2516p pd=2.16u as=0.15055p ps=1.17u w=0.74u l=0.13u
X14 SAR/a_11072_5347# SAR/sg13cmos5l_nor2_1_0.A vdd vdd sg13_lv_pmos ad=0.2856p pd=2.36u as=0.1596p ps=1.22u w=0.84u l=0.13u
X15 vdd SAR/sg13cmos5l_dfrbp_1_21.Q_N SAR/a_18793_6216# vdd sg13_lv_pmos ad=1.07253p pd=6.75u as=0.2856p ps=2.36u w=0.84u l=0.13u
X16 vdd SAR/a_14543_3215# SAR/a_15380_3436# vdd sg13_lv_pmos ad=0.2128p pd=1.5u as=0.3864p ps=2.93u w=1.12u l=0.13u
X17 pl_sw[5] SAR/a_7336_9224# vss vss sg13_lv_nmos ad=0.2886p pd=2.26u as=0.14875p ps=1.16u w=0.74u l=0.13u
X18 SAR/a_11973_1605# SAR/sg13cmos5l_dfrbp_1_0.CLK vss vss sg13_lv_nmos ad=0.2516p pd=2.16u as=5.84582p ps=38.34u w=0.74u l=0.13u
X19 vdd SAR/a_11973_3911# SAR/a_12075_3911# vdd sg13_lv_pmos ad=1.43437p pd=9.105u as=0.3864p ps=2.93u w=1.12u l=0.13u
X20 vss SAR/a_3407_8797# SAR/a_4244_8436# vss sg13_lv_nmos ad=0.1406p pd=1.12u as=0.2516p ps=2.16u w=0.74u l=0.13u
X21 vdd SAR/a_19209_5769# SAR/a_19734_5842# vdd sg13_lv_pmos ad=0.1974p pd=1.5u as=0.2856p ps=2.36u w=0.84u l=0.13u
X22 SAR/sg13cmos5l_dlhr_1_16.Q SAR/a_19209_5769# vss vss sg13_lv_nmos ad=0.2516p pd=2.16u as=0.1406p ps=1.12u w=0.74u l=0.13u
X23 vdd SAR/a_19340_8400# pl_sw[9] vdd sg13_lv_pmos ad=0.2114p pd=1.54u as=0.42p ps=2.99u w=1.12u l=0.13u
X24 SAR/sg13cmos5l_dlhr_1_2.D SAR/a_6479_2749# vss vss sg13_lv_nmos ad=0.2849p pd=2.25u as=0.2516p ps=2.16u w=0.74u l=0.13u
X25 SAR/a_13100_8400# SAR/sg13cmos5l_buf_1_90.X vss vss sg13_lv_nmos ad=0.187p pd=1.78u as=0.14875p ps=1.16u w=0.55u l=0.13u
X26 SAR/a_10071_7282# SAR/sg13cmos5l_dfrbp_1_18.Q vss vss sg13_lv_nmos ad=0.2516p pd=2.16u as=0.15055p ps=1.17u w=0.74u l=0.13u
X27 vdd SAR/a_10288_8678# SAR/a_10233_8559# vdd sg13_lv_pmos ad=1.15047p pd=7.175u as=93.45f ps=0.865u w=0.42u l=0.13u
X28 SAR/a_13701_3117# SAR/sg13cmos5l_dfrbp_1_0.CLK vss vss sg13_lv_nmos ad=0.2516p pd=2.16u as=2.43055p ps=15.415u w=0.74u l=0.13u
X29 SAR/a_1484_9150# SAR/sg13cmos5l_inv_1_19.A vss vss sg13_lv_nmos ad=0.187p pd=1.78u as=0.14875p ps=1.16u w=0.55u l=0.13u
X30 SAR/a_934_7349# SAR/sg13cmos5l_dfrbp_1_6.RESET_B vss vss sg13_lv_nmos ad=37.8f pd=0.6u as=0.1701p ps=1.65u w=0.42u l=0.13u
X31 vdd SAR/a_14889_7281# SAR/a_14822_6924# vdd sg13_lv_pmos ad=0.2387p pd=1.84u as=0.1008p ps=0.9u w=0.42u l=0.13u
X32 SAR/sg13cmos5l_buf_1_19.A SAR/a_18856_8436# vdd vdd sg13_lv_pmos ad=0.42p pd=2.99u as=0.2114p ps=1.54u w=1.12u l=0.13u
X33 SAR/a_16068_6928# SAR/a_16042_6892# vdd vdd sg13_lv_pmos ad=0.34p pd=2.68u as=0.36237p ps=2.605u w=1u l=0.13u
X34 vdd SAR/a_16748_9150# pl_sw[7] vdd sg13_lv_pmos ad=0.2114p pd=1.54u as=0.42p ps=2.99u w=1.12u l=0.13u
X35 SAR/sg13cmos5l_buf_1_96.A SAR/a_10665_7281# vss vss sg13_lv_nmos ad=0.2516p pd=2.16u as=0.1406p ps=1.12u w=0.74u l=0.13u
X36 SAR/a_14889_7281# SAR/a_14708_6924# vdd vdd sg13_lv_pmos ad=0.2128p pd=1.5u as=0.2387p ps=1.84u w=1.12u l=0.13u
X37 SAR/a_6898_2826# SAR/sg13cmos5l_dfrbp_1_6.RESET_B vss vss sg13_lv_nmos ad=37.8f pd=0.6u as=79.8f ps=0.8u w=0.42u l=0.13u
X38 SAR/a_11530_1849# SAR/a_11973_1605# SAR/a_11913_2017# vdd sg13_lv_pmos ad=79.8f pd=0.8u as=63f ps=0.72u w=0.42u l=0.13u
X39 vss SAR/sg13cmos5l_buf_1_111.A SAR/a_18376_9224# vss sg13_lv_nmos ad=0.14875p pd=1.16u as=0.187p ps=1.78u w=0.55u l=0.13u
X40 SAR/a_16677_6141# SAR/sg13cmos5l_dfrbp_1_8.D vdd vdd sg13_lv_pmos ad=0.4088p pd=2.97u as=1.04815p ps=6.595u w=1.12u l=0.13u
X41 SAR/a_13284_3456# SAR/a_13258_3361# vdd vdd sg13_lv_pmos ad=0.34p pd=2.68u as=0.36237p ps=2.605u w=1u l=0.13u
X42 SAR/a_16271_7751# SAR/a_15429_7653# SAR/a_16177_7751# vss sg13_lv_nmos ad=0.12665p pd=1.145u as=0.1428p ps=1.52u w=0.42u l=0.13u
X43 vdd SAR/a_7689_1626# SAR/a_7622_2064# vdd sg13_lv_pmos ad=0.2387p pd=1.84u as=0.1008p ps=0.9u w=0.42u l=0.13u
X44 vss SAR/a_9705_4650# SAR/a_9660_4686# vss sg13_lv_nmos ad=0.1428p pd=1.52u as=47.25f ps=0.645u w=0.42u l=0.13u
X45 SAR/sg13cmos5l_dfrbp_1_12.Q_N SAR/a_7055_4261# vss vss sg13_lv_nmos ad=0.2849p pd=2.25u as=0.2516p ps=2.16u w=0.74u l=0.13u
X46 SAR/sg13cmos5l_nor2_1_2.A SAR/sg13cmos5l_inv_1_9.Y vdd vdd sg13_lv_pmos ad=0.3808p pd=2.92u as=0.3808p ps=2.92u w=1.12u l=0.13u
X47 vss SAR/a_2565_8447# SAR/a_2667_8447# vss sg13_lv_nmos ad=2.92392p pd=18.89u as=0.2516p ps=2.16u w=0.74u l=0.13u
X48 SAR/a_1997_6126# SAR/a_2727_6380# SAR/a_2748_6126# vss sg13_lv_nmos ad=0.12665p pd=1.145u as=0.3473p ps=2.71u w=0.74u l=0.13u
X49 vss vdd vss vss sg13_lv_nmos ad=0.1428p pd=1.52u as=0.40368n ps=2.16158m w=0.42u l=1u
X50 SAR/a_15702_4187# SAR/a_15821_3864# vdd vdd sg13_lv_pmos ad=0.3864p pd=2.93u as=0.2128p ps=1.5u w=1.12u l=0.13u
X51 SAR/a_10031_8797# SAR/a_9189_8447# SAR/a_9937_8797# vss sg13_lv_nmos ad=0.12665p pd=1.145u as=0.1428p ps=1.52u w=0.42u l=0.13u
X52 SAR/a_5414_6162# SAR/sg13cmos5l_dfrbp_1_6.D vdd vdd sg13_lv_pmos ad=79.8f pd=0.8u as=0.1428p ps=1.52u w=0.42u l=0.13u
X53 vdd SAR/a_15429_7653# SAR/a_15531_7796# vdd sg13_lv_pmos ad=1.15047p pd=7.175u as=0.3864p ps=2.93u w=1.12u l=0.13u
X54 vdd SAR/a_1967_7285# SAR/a_2804_6924# vdd sg13_lv_pmos ad=0.2128p pd=1.5u as=0.3864p ps=2.93u w=1.12u l=0.13u
X55 nl_sw[3] SAR/a_4456_1664# vss vss sg13_lv_nmos ad=0.2886p pd=2.26u as=0.14875p ps=1.16u w=0.74u l=0.13u
X56 vss SAR/sg13cmos5l_nor2_1_0.A SAR/a_12814_4692# vss sg13_lv_nmos ad=0.17255p pd=1.25u as=0.187p ps=1.78u w=0.55u l=0.13u
X57 SAR/sg13cmos5l_buf_1_78.X SAR/a_6184_9224# vdd vdd sg13_lv_pmos ad=0.42p pd=2.99u as=0.2114p ps=1.54u w=1.12u l=0.13u
X58 SAR/a_12980_6924# SAR/a_12567_7282# SAR/a_12912_6924# vdd sg13_lv_pmos ad=0.191p pd=1.44u as=0.105p ps=1.21u w=1u l=0.13u
X59 vss SAR/a_1402_3864# SAR/a_1121_4166# vss sg13_lv_nmos ad=79.8f pd=0.8u as=0.1428p ps=1.52u w=0.42u l=0.5u
X60 SAR/a_9940_4636# SAR/a_9524_4972# SAR/a_9705_4650# vss sg13_lv_nmos ad=77.7f pd=0.95u as=0.2516p ps=2.16u w=0.74u l=0.13u
X61 SAR/a_2732_1590# SAR/sg13cmos5l_buf_1_37.A vss vss sg13_lv_nmos ad=0.187p pd=1.78u as=0.14875p ps=1.16u w=0.55u l=0.13u
X62 SAR/a_11556_1944# SAR/a_12075_1748# SAR/a_12815_1703# vss sg13_lv_nmos ad=0.3473p pd=2.71u as=0.12665p ps=1.145u w=0.74u l=0.13u
X63 SAR/a_2566_3151# SAR/sg13cmos5l_dfrbp_1_6.RESET_B vss vss sg13_lv_nmos ad=37.8f pd=0.6u as=0.1701p ps=1.65u w=0.42u l=0.13u
X64 vss SAR/sg13cmos5l_buf_1_5.A SAR/sg13cmos5l_inv_1_27.Y vss sg13_lv_nmos ad=0.2516p pd=2.16u as=0.2516p ps=2.16u w=0.74u l=0.13u
X65 SAR/a_11973_1605# SAR/sg13cmos5l_dfrbp_1_0.CLK vdd vdd sg13_lv_pmos ad=0.4088p pd=2.97u as=1.777p ps=11.395u w=1.12u l=0.13u
X66 SAR/a_3575_6553# SAR/a_2879_6432# SAR/a_3669_6320# vss sg13_lv_nmos ad=0.1296p pd=1.52u as=79.8f ps=0.8u w=0.42u l=0.13u
X67 SAR/a_4652_6126# SAR/sg13cmos5l_buf_1_59.A vss vss sg13_lv_nmos ad=0.187p pd=1.78u as=0.14875p ps=1.16u w=0.55u l=0.13u
X68 SAR/a_5673_3138# SAR/a_5492_3460# vdd vdd sg13_lv_pmos ad=0.2128p pd=1.5u as=0.2387p ps=1.84u w=1.12u l=0.13u
X69 SAR/a_10224_9508# SAR/a_9673_9240# vdd vdd sg13_lv_pmos ad=0.105p pd=1.21u as=4.11675p ps=27.17u w=1u l=0.13u
X70 SAR/sg13cmos5l_dlhr_1_1.Q SAR/a_2409_4650# vss vss sg13_lv_nmos ad=0.2516p pd=2.16u as=0.1406p ps=1.12u w=0.74u l=0.13u
X71 vdd SAR/sg13cmos5l_dlhr_1_0.D SAR/a_6889_1680# vdd sg13_lv_pmos ad=1.86162p pd=11.935u as=0.2856p ps=2.36u w=0.84u l=0.13u
X72 SAR/a_19090_1626# SAR/sg13cmos5l_dfrbp_1_0.RESET_B vss vss sg13_lv_nmos ad=37.8f pd=0.6u as=79.8f ps=0.8u w=0.42u l=0.13u
X73 SAR/a_17493_3947# SAR/a_16551_3987# SAR/a_17354_4180# vss sg13_lv_nmos ad=79.8f pd=0.8u as=0.2373p ps=1.97u w=0.42u l=0.13u
X74 SAR/a_5132_3864# SAR/sg13cmos5l_buf_1_44.A vss vss sg13_lv_nmos ad=0.187p pd=1.78u as=0.14875p ps=1.16u w=0.55u l=0.13u
X75 vss vdd vss vss sg13_lv_nmos ad=0.1428p pd=1.52u as=0 ps=0 w=0.42u l=1u
X76 vdd SAR/sg13cmos5l_dfrbp_1_6.RESET_B SAR/a_2314_3361# vdd sg13_lv_pmos ad=0.1563p pd=1.22u as=0.147p ps=1.54u w=0.42u l=0.13u
X77 SAR/sg13cmos5l_dlhr_1_16.Q SAR/a_19209_5769# vdd vdd sg13_lv_pmos ad=0.3808p pd=2.92u as=0.2128p ps=1.5u w=1.12u l=0.13u
X78 SAR/a_13701_3117# SAR/sg13cmos5l_dfrbp_1_0.CLK vdd vdd sg13_lv_pmos ad=0.4088p pd=2.97u as=1.38655p ps=8.8u w=1.12u l=0.13u
X79 SAR/a_1967_5773# SAR/a_1125_5423# SAR/a_1873_5773# vss sg13_lv_nmos ad=0.12665p pd=1.145u as=0.1428p ps=1.52u w=0.42u l=0.13u
X80 SAR/a_14295_7282# SAR/sg13cmos5l_dfrbp_1_23.CLK vdd vdd sg13_lv_pmos ad=0.3234p pd=2.45u as=1.04815p ps=6.595u w=0.84u l=0.13u
X81 SAR/sg13cmos5l_dlhr_1_12.D SAR/a_16271_7751# vdd vdd sg13_lv_pmos ad=0.4312p pd=3.01u as=0.2639p ps=1.81u w=1.12u l=0.13u
X82 vdd SAR/a_17327_7285# SAR/a_18164_6924# vdd sg13_lv_pmos ad=0.2128p pd=1.5u as=0.3864p ps=2.93u w=1.12u l=0.13u
X83 vdd SAR/a_15177_5769# SAR/a_15702_5842# vdd sg13_lv_pmos ad=0.1974p pd=1.5u as=0.2856p ps=2.36u w=0.84u l=0.13u
X84 SAR/a_16748_9150# SAR/sg13cmos5l_buf_1_93.X vdd vdd sg13_lv_pmos ad=0.2856p pd=2.36u as=0.2114p ps=1.54u w=0.84u l=0.13u
X85 vdd SAR/a_7689_1626# SAR/a_8214_1608# vdd sg13_lv_pmos ad=0.1974p pd=1.5u as=0.2856p ps=2.36u w=0.84u l=0.13u
X86 SAR/a_13460_7996# SAR/a_13178_7684# SAR/a_13393_7666# vss sg13_lv_nmos ad=0.141p pd=1.17u as=71.99999f ps=0.865u w=0.64u l=0.13u
X87 SAR/a_1402_3864# SAR/sg13cmos5l_dlygate4sd2_1_0.X vdd vdd sg13_lv_pmos ad=0.1428p pd=1.52u as=0.1523p ps=1.38u w=0.42u l=0.13u
X88 vdd SAR/a_12716_8400# ph_sw[5] vdd sg13_lv_pmos ad=0.2114p pd=1.54u as=0.42p ps=2.99u w=1.12u l=0.13u
X89 SAR/a_12324_6162# SAR/sg13cmos5l_buf_1_57.X SAR/a_12230_6162# vss sg13_lv_nmos ad=60.89999f pd=0.71u as=0.1428p ps=1.52u w=0.42u l=0.13u
X90 SAR/a_6117_6141# SAR/sg13cmos5l_dlhr_1_5.GATE vdd vdd sg13_lv_pmos ad=0.4088p pd=2.97u as=1.04815p ps=6.595u w=1.12u l=0.13u
X91 vdd SAR/sg13cmos5l_dfrbp_1_6.RESET_B SAR/a_8457_7281# vdd sg13_lv_pmos ad=0.2128p pd=1.5u as=0.2128p ps=1.5u w=1.12u l=0.13u
X92 vss SAR/a_12549_9165# SAR/a_12651_9308# vss sg13_lv_nmos ad=2.92392p pd=18.89u as=0.2516p ps=2.16u w=0.74u l=0.13u
X93 vdd SAR/a_18860_9150# ph_sw[8] vdd sg13_lv_pmos ad=0.2114p pd=1.54u as=0.42p ps=2.99u w=1.12u l=0.13u
X94 vdd SAR/sg13cmos5l_buf_1_96.A SAR/a_11464_8436# vdd sg13_lv_pmos ad=0.2114p pd=1.54u as=0.2856p ps=2.36u w=0.84u l=0.13u
X95 SAR/sg13cmos5l_dfrbp_1_1.D SAR/sg13cmos5l_a22oi_1_2.B2 SAR/a_9823_2780# vss sg13_lv_nmos ad=0.2664p pd=1.46u as=0.13875p ps=1.115u w=0.74u l=0.13u
X96 vdd SAR/a_16751_2749# SAR/a_17588_2388# vdd sg13_lv_pmos ad=0.2128p pd=1.5u as=0.3864p ps=2.93u w=1.12u l=0.13u
X97 SAR/sg13cmos5l_dlhr_1_0.D SAR/a_7316_2388# vss vss sg13_lv_nmos ad=0.2516p pd=2.16u as=0.1406p ps=1.12u w=0.74u l=0.13u
X98 SAR/a_2122_8404# SAR/a_2565_8447# SAR/a_1862_8874# vss sg13_lv_nmos ad=79.8f pd=0.8u as=0.1296p ps=1.52u w=0.42u l=0.13u
X99 SAR/a_17367_8794# SAR/sg13cmos5l_dfrbp_1_22.D vdd vdd sg13_lv_pmos ad=0.3234p pd=2.45u as=1.12242p ps=7u w=0.84u l=0.13u
X100 SAR/sg13cmos5l_buf_1_25.A SAR/sg13cmos5l_inv_1_14.A vss vss sg13_lv_nmos ad=0.2516p pd=2.16u as=0.2516p ps=2.16u w=0.74u l=0.13u
X101 SAR/a_20204_5376# SAR/sg13cmos5l_dlhr_1_16.Q vdd vdd sg13_lv_pmos ad=0.2856p pd=2.36u as=0.2114p ps=1.54u w=0.84u l=0.13u
X102 vdd rdy SAR/a_424_8436# vdd sg13_lv_pmos ad=0.2114p pd=1.54u as=0.2856p ps=2.36u w=0.84u l=0.13u
X103 SAR/sg13cmos5l_buf_1_87.A SAR/a_18376_9224# vdd vdd sg13_lv_pmos ad=0.42p pd=2.99u as=0.2114p ps=1.54u w=1.12u l=0.13u
X104 SAR/a_6479_2749# SAR/a_5637_2399# SAR/a_6385_2749# vss sg13_lv_nmos ad=0.12665p pd=1.145u as=0.1428p ps=1.52u w=0.42u l=0.13u
X105 SAR/a_7888_4870# SAR/a_7631_4727# SAR/a_8050_4650# vss sg13_lv_nmos ad=0.1428p pd=1.52u as=37.8f ps=0.6u w=0.42u l=0.13u
X106 vss SAR/a_2831_7630# SAR/a_2786_7666# vss sg13_lv_nmos ad=1.49685p pd=9.6u as=71.99999f ps=0.865u w=0.64u l=0.13u
X107 _frm SAR/a_20008_7712# vss vss sg13_lv_nmos ad=0.2886p pd=2.26u as=0.14875p ps=1.16u w=0.74u l=0.13u
X108 SAR/a_6598_4663# SAR/sg13cmos5l_dfrbp_1_8.RESET_B vss vss sg13_lv_nmos ad=37.8f pd=0.6u as=0.1701p ps=1.65u w=0.42u l=0.13u
X109 SAR/a_1125_6935# SAR/sg13cmos5l_dfrbp_1_15.D vss vss sg13_lv_nmos ad=0.2516p pd=2.16u as=1.49685p ps=9.6u w=0.74u l=0.13u
X110 SAR/a_20012_2352# SAR/sg13cmos5l_buf_1_0.X vdd vdd sg13_lv_pmos ad=0.2856p pd=2.36u as=0.2114p ps=1.54u w=0.84u l=0.13u
X111 SAR/a_8486_8874# SAR/a_9291_8447# SAR/a_8746_8404# vdd sg13_lv_pmos ad=0.1428p pd=1.52u as=79.8f ps=0.8u w=0.42u l=0.13u
X112 vdd SAR/a_15887_8797# SAR/a_16724_8436# vdd sg13_lv_pmos ad=0.2128p pd=1.5u as=0.3864p ps=2.93u w=1.12u l=0.13u
X113 vss comp_p SAR/a_424_1664# vss sg13_lv_nmos ad=0.14875p pd=1.16u as=0.187p ps=1.78u w=0.55u l=0.13u
X114 vdd SAR/a_3664_4142# SAR/a_3609_4023# vdd sg13_lv_pmos ad=1.43437p pd=9.105u as=93.45f ps=0.865u w=0.42u l=0.13u
X115 nh_sw[1] SAR/a_2824_2388# vss vss sg13_lv_nmos ad=0.2886p pd=2.26u as=0.14875p ps=1.16u w=0.74u l=0.13u
X116 vdd SAR/sg13cmos5l_dfrbp_1_0.RESET_B SAR/a_17414_3138# vdd sg13_lv_pmos ad=0.36237p pd=2.605u as=79.8f ps=0.8u w=0.42u l=0.13u
X117 SAR/a_2122_3868# SAR/a_2565_3911# SAR/a_2505_3947# vdd sg13_lv_pmos ad=79.8f pd=0.8u as=63f ps=0.72u w=0.42u l=0.13u
X118 vss SAR/a_4460_9150# SAR/sg13cmos5l_buf_1_60.X vss sg13_lv_nmos ad=0.14875p pd=1.16u as=0.2886p ps=2.26u w=0.74u l=0.13u
X119 SAR/a_11846_9186# SAR/sg13cmos5l_dlhr_1_11.GATE vdd vdd sg13_lv_pmos ad=79.8f pd=0.8u as=0.1428p ps=1.52u w=0.42u l=0.13u
X120 SAR/a_3801_3453# SAR/a_2859_3260# SAR/a_3599_3215# vdd sg13_lv_pmos ad=93.45f pd=0.865u as=0.2048p ps=1.63u w=0.42u l=0.13u
X121 SAR/a_13234_4338# SAR/sg13cmos5l_dfrbp_1_0.RESET_B vss vss sg13_lv_nmos ad=37.8f pd=0.6u as=79.8f ps=0.8u w=0.42u l=0.13u
X122 SAR/a_17751_7690# SAR/sg13cmos5l_dfrbp_1_22.D vss vss sg13_lv_nmos ad=0.2516p pd=2.16u as=0.15055p ps=1.17u w=0.74u l=0.13u
X123 SAR/a_7316_3460# SAR/a_7034_3148# SAR/a_7249_3130# vss sg13_lv_nmos ad=0.141p pd=1.17u as=71.99999f ps=0.865u w=0.64u l=0.13u
X124 SAR/sg13cmos5l_buf_1_116.A SAR/a_15177_5769# vdd vdd sg13_lv_pmos ad=0.3808p pd=2.92u as=0.2128p ps=1.5u w=1.12u l=0.13u
X125 vdd SAR/sg13cmos5l_dfrbp_1_15.D SAR/a_2621_7636# vdd sg13_lv_pmos ad=1.15047p pd=7.175u as=0.3234p ps=2.45u w=0.84u l=0.13u
X126 SAR/a_14928_5412# SAR/a_14377_5770# vdd vdd sg13_lv_pmos ad=0.105p pd=1.21u as=1.28962p ps=8.195u w=1u l=0.13u
X127 SAR/a_7247_8797# SAR/a_6405_8447# SAR/a_5988_8440# vdd sg13_lv_pmos ad=0.2048p pd=1.63u as=0.34p ps=2.68u w=1u l=0.13u
X128 ph_sw[2] SAR/a_3976_9224# vss vss sg13_lv_nmos ad=0.2886p pd=2.26u as=0.14875p ps=1.16u w=0.74u l=0.13u
X129 SAR/a_18196_8824# SAR/a_17780_8436# SAR/a_17961_8793# vss sg13_lv_nmos ad=77.7f pd=0.95u as=0.2516p ps=2.16u w=0.74u l=0.13u
X130 SAR/a_8204_2352# SAR/sg13cmos5l_dlhr_1_2.Q vss vss sg13_lv_nmos ad=0.187p pd=1.78u as=0.14875p ps=1.16u w=0.55u l=0.13u
X131 SAR/a_5104_4870# SAR/sg13cmos5l_dfrbp_1_8.RESET_B vdd vdd sg13_lv_pmos ad=79.8f pd=0.8u as=1.2517p ps=7.955u w=0.42u l=0.13u
X132 SAR/sg13cmos5l_buf_1_59.A SAR/a_4425_7281# vdd vdd sg13_lv_pmos ad=0.3808p pd=2.92u as=0.2128p ps=1.5u w=1.12u l=0.13u
X133 SAR/a_16485_6935# SAR/sg13cmos5l_inv_1_2.A vss vss sg13_lv_nmos ad=0.2516p pd=2.16u as=1.49685p ps=9.6u w=0.74u l=0.13u
X134 SAR/a_17392_4870# SAR/a_17135_4727# SAR/a_17554_4650# vss sg13_lv_nmos ad=0.1428p pd=1.52u as=37.8f ps=0.6u w=0.42u l=0.13u
X135 SAR/a_18860_9150# SAR/sg13cmos5l_buf_1_101.X vdd vdd sg13_lv_pmos ad=0.2856p pd=2.36u as=0.2114p ps=1.54u w=0.84u l=0.13u
X136 SAR/sg13cmos5l_dfrbp_1_7.Q_N SAR/a_14543_3215# vss vss sg13_lv_nmos ad=0.2849p pd=2.25u as=0.2516p ps=2.16u w=0.74u l=0.13u
X137 SAR/a_3575_6553# SAR/sg13cmos5l_dfrbp_1_15.D SAR/a_4322_6162# vss sg13_lv_nmos ad=0.1428p pd=1.52u as=60.89999f ps=0.71u w=0.42u l=0.13u
X138 vdd SAR/sg13cmos5l_buf_1_5.A SAR/sg13cmos5l_inv_1_27.Y vdd sg13_lv_pmos ad=0.3808p pd=2.92u as=0.3808p ps=2.92u w=1.12u l=0.13u
X139 SAR/a_7095_1642# SAR/sg13cmos5l_dlhr_1_0.GATE vss vss sg13_lv_nmos ad=0.2516p pd=2.16u as=0.15055p ps=1.17u w=0.74u l=0.13u
X140 SAR/a_2697_3529# SAR/a_2340_3456# vdd vdd sg13_lv_pmos ad=63f pd=0.72u as=0.1563p ps=1.22u w=0.42u l=0.13u
X141 vss SAR/a_5104_4870# SAR/a_4753_4727# vss sg13_lv_nmos ad=79.8f pd=0.8u as=0.1428p ps=1.52u w=0.42u l=0.13u
X142 SAR/sg13cmos5l_nor2_1_0.A SAR/a_13556_2388# vdd vdd sg13_lv_pmos ad=0.3808p pd=2.92u as=0.2128p ps=1.5u w=1.12u l=0.13u
X143 vss SAR/sg13cmos5l_dfrbp_1_21.Q SAR/a_18409_5770# vss sg13_lv_nmos ad=0.15055p pd=1.17u as=0.187p ps=1.78u w=0.55u l=0.13u
X144 SAR/a_13698_5412# SAR/sg13cmos5l_dfrbp_1_23.Q SAR/a_13486_5412# vdd sg13_lv_pmos ad=0.2128p pd=1.5u as=0.2128p ps=1.5u w=1.12u l=0.13u
X145 SAR/a_19526_6600# SAR/a_19130_6172# SAR/a_19412_6484# vdd sg13_lv_pmos ad=0.1008p pd=0.9u as=0.191p ps=1.44u w=0.42u l=0.13u
X146 vdd SAR/a_17776_6382# SAR/a_17721_6477# vdd sg13_lv_pmos ad=1.07253p pd=6.75u as=93.45f ps=0.865u w=0.42u l=0.13u
X147 vdd SAR/a_16268_3102# nl_sw[8] vdd sg13_lv_pmos ad=0.2114p pd=1.54u as=0.42p ps=2.99u w=1.12u l=0.13u
X148 vdd SAR/a_6213_3911# SAR/a_6315_3911# vdd sg13_lv_pmos ad=1.43437p pd=9.105u as=0.3864p ps=2.93u w=1.12u l=0.13u
X149 vss SAR/sg13cmos5l_dfrbp_1_0.RESET_B SAR/a_11268_2826# vss sg13_lv_nmos ad=0.1626p pd=1.415u as=60.89999f ps=0.71u w=0.42u l=0.13u
X150 vss SAR/a_17493_3947# SAR/a_16572_4261# vss sg13_lv_nmos ad=0.1626p pd=1.415u as=0.2516p ps=2.16u w=0.74u l=0.13u
X151 vss SAR/sg13cmos5l_buf_1_65.X SAR/a_8488_9224# vss sg13_lv_nmos ad=0.14875p pd=1.16u as=0.187p ps=1.78u w=0.55u l=0.13u
X152 SAR/a_708_6928# SAR/a_682_6892# vss vss sg13_lv_nmos ad=0.2516p pd=2.16u as=0.1626p ps=1.415u w=0.74u l=0.13u
X153 SAR/a_1948_7964# SAR/sg13cmos5l_dfrbp_1_6.RESET_B vdd vdd sg13_lv_pmos ad=0.2128p pd=1.5u as=0.2128p ps=1.5u w=1.12u l=0.13u
X154 SAR/a_19161_3453# SAR/a_18219_3260# SAR/a_18959_3215# vdd sg13_lv_pmos ad=93.45f pd=0.865u as=0.2048p ps=1.63u w=0.42u l=0.13u
X155 vdd SAR/a_4041_2745# SAR/a_3974_2388# vdd sg13_lv_pmos ad=0.2387p pd=1.84u as=0.1008p ps=0.9u w=0.42u l=0.13u
X156 SAR/a_16260_6480# SAR/a_16779_6284# SAR/a_17519_6239# vss sg13_lv_nmos ad=0.3473p pd=2.71u as=0.12665p ps=1.145u w=0.74u l=0.13u
X157 vss SAR/a_1484_6126# SAR/sg13cmos5l_buf_1_40.A vss sg13_lv_nmos ad=0.14875p pd=1.16u as=0.2886p ps=2.26u w=0.74u l=0.13u
X158 vss SAR/sg13cmos5l_inv_1_3.A SAR/a_15016_9224# vss sg13_lv_nmos ad=0.14875p pd=1.16u as=0.187p ps=1.78u w=0.55u l=0.13u
X159 vdd SAR/a_18671_1703# SAR/a_18928_1846# vdd sg13_lv_pmos ad=0.2639p pd=1.81u as=79.8f ps=0.8u w=0.42u l=0.13u
X160 vss SAR/sg13cmos5l_dfrbp_1_8.RESET_B SAR/a_11940_9186# vss sg13_lv_nmos ad=0.1626p pd=1.415u as=60.89999f ps=0.71u w=0.42u l=0.13u
X161 vdd SAR/a_9033_6162# SAR/a_8966_6600# vdd sg13_lv_pmos ad=0.2387p pd=1.84u as=0.1008p ps=0.9u w=0.42u l=0.13u
X162 SAR/a_12913_7326# SAR/a_12361_7282# vss vss sg13_lv_nmos ad=71.99999f pd=0.865u as=1.49685p ps=9.6u w=0.64u l=0.13u
X163 SAR/a_5508_2813# SAR/a_5220_2392# SAR/a_5446_2813# vss sg13_lv_nmos ad=0.1428p pd=1.52u as=37.8f ps=0.6u w=0.42u l=0.13u
X164 vss SAR/a_19593_6162# SAR/a_19548_6198# vss sg13_lv_nmos ad=0.1428p pd=1.52u as=47.25f ps=0.645u w=0.42u l=0.13u
X165 SAR/a_18057_3529# SAR/a_17700_3456# vdd vdd sg13_lv_pmos ad=63f pd=0.72u as=0.1563p ps=1.22u w=0.42u l=0.13u
X166 vss SAR/a_7631_4727# SAR/a_8468_4948# vss sg13_lv_nmos ad=0.1406p pd=1.12u as=0.2516p ps=2.16u w=0.74u l=0.13u
X167 vdd vss vdd vdd sg13_lv_pmos ad=0.34p pd=2.68u as=0.43217n ps=2.29179m w=1u l=1u
X168 vdd SAR/a_10473_9186# SAR/a_10998_9168# vdd sg13_lv_pmos ad=0.1974p pd=1.5u as=0.2856p ps=2.36u w=0.84u l=0.13u
X169 SAR/a_17220_1626# SAR/sg13cmos5l_dfrbp_1_0.D SAR/a_17126_1626# vss sg13_lv_nmos ad=60.89999f pd=0.71u as=0.1428p ps=1.52u w=0.42u l=0.13u
X170 vdd SAR/a_620_7638# pl_sw[0] vdd sg13_lv_pmos ad=0.2114p pd=1.54u as=0.42p ps=2.99u w=1.12u l=0.13u
X171 SAR/a_10665_8065# SAR/a_10308_7992# vdd vdd sg13_lv_pmos ad=63f pd=0.72u as=0.1563p ps=1.22u w=0.42u l=0.13u
X172 vdd SAR/a_14800_3358# SAR/a_14745_3453# vdd sg13_lv_pmos ad=1.43437p pd=9.105u as=93.45f ps=0.865u w=0.42u l=0.13u
X173 vss SAR/sg13cmos5l_nor2_1_1.A SAR/a_15439_1630# vss sg13_lv_nmos ad=0.14505p pd=1.15u as=0.1406p ps=1.12u w=0.74u l=0.13u
X174 SAR/a_2148_3138# SAR/sg13cmos5l_dfrbp_1_6.D SAR/a_2054_3138# vss sg13_lv_nmos ad=60.89999f pd=0.71u as=0.1428p ps=1.52u w=0.42u l=0.13u
X175 SAR/a_3860_2388# SAR/a_3578_2752# SAR/a_3793_2790# vss sg13_lv_nmos ad=0.141p pd=1.17u as=71.99999f ps=0.865u w=0.64u l=0.13u
X176 SAR/sg13cmos5l_dlygate4sd2_1_0.A SAR/sg13cmos5l_inv_1_8.Y vdd vdd sg13_lv_pmos ad=0.2128p pd=1.5u as=0.3808p ps=2.92u w=1.12u l=0.13u
X177 SAR/a_1065_5459# SAR/a_708_5416# vdd vdd sg13_lv_pmos ad=63f pd=0.72u as=0.1563p ps=1.22u w=0.42u l=0.13u
X178 vss SAR/a_5132_9150# SAR/sg13cmos5l_buf_1_64.A vss sg13_lv_nmos ad=0.14875p pd=1.16u as=0.2886p ps=2.26u w=0.74u l=0.13u
X179 SAR/a_1862_8874# SAR/a_2667_8447# SAR/a_2122_8404# vdd sg13_lv_pmos ad=0.1428p pd=1.52u as=79.8f ps=0.8u w=0.42u l=0.13u
X180 SAR/a_13392_7996# SAR/a_12841_7728# vdd vdd sg13_lv_pmos ad=0.105p pd=1.21u as=1.15047p ps=7.175u w=1u l=0.13u
X181 vss SAR/sg13cmos5l_dfrbp_1_6.RESET_B SAR/a_8692_7312# vss sg13_lv_nmos ad=0.1406p pd=1.12u as=77.7f ps=0.95u w=0.74u l=0.13u
X182 SAR/a_13284_3456# SAR/a_13803_3260# SAR/a_14543_3215# vss sg13_lv_nmos ad=0.3473p pd=2.71u as=0.12665p ps=1.145u w=0.74u l=0.13u
X183 SAR/sg13cmos5l_nand2_1_2.B SAR/sg13cmos5l_or2_1_0.A SAR/a_650_3900# vdd sg13_lv_pmos ad=0.3808p pd=2.92u as=0.1176p ps=1.33u w=1.12u l=0.13u
X184 vss SAR/a_4425_7281# SAR/a_4950_7354# vss sg13_lv_nmos ad=0.1491p pd=1.18u as=0.187p ps=1.78u w=0.55u l=0.13u
X185 vdd SAR/sg13cmos5l_dfrbp_1_0.RESET_B SAR/a_17386_1849# vdd sg13_lv_pmos ad=0.1563p pd=1.22u as=0.147p ps=1.54u w=0.42u l=0.13u
X186 SAR/a_14628_8440# SAR/a_14602_8404# vdd vdd sg13_lv_pmos ad=0.34p pd=2.68u as=0.36237p ps=2.605u w=1u l=0.13u
X187 SAR/a_20492_8400# SAR/sg13cmos5l_buf_1_104.X vss vss sg13_lv_nmos ad=0.187p pd=1.78u as=0.14875p ps=1.16u w=0.55u l=0.13u
X188 SAR/a_13486_5412# SAR/sg13cmos5l_nor2b_1_0.Y vdd vdd sg13_lv_pmos ad=0.2128p pd=1.5u as=0.3808p ps=2.92u w=1.12u l=0.13u
X189 SAR/sg13cmos5l_dfrbp_1_6.D SAR/a_1672_3176# vss vss sg13_lv_nmos ad=0.2886p pd=2.26u as=0.14875p ps=1.16u w=0.74u l=0.13u
X190 SAR/sg13cmos5l_buf_1_98.A SAR/a_13641_7674# vdd vdd sg13_lv_pmos ad=0.3808p pd=2.92u as=0.2128p ps=1.5u w=1.12u l=0.13u
X191 vdd SAR/a_1997_6126# SAR/sg13cmos5l_dfrbp_1_15.Q_N vdd sg13_lv_pmos ad=0.2639p pd=1.81u as=0.4312p ps=3.01u w=1.12u l=0.13u
X192 _d1 SAR/a_20008_3900# vdd vdd sg13_lv_pmos ad=0.42p pd=2.99u as=0.2114p ps=1.54u w=1.12u l=0.13u
X193 vdd SAR/a_4950_5699# SAR/sg13cmos5l_dlhr_1_5.GATE vdd sg13_lv_pmos ad=0.2128p pd=1.5u as=0.3808p ps=2.92u w=1.12u l=0.13u
X194 SAR/a_6572_1590# SAR/sg13cmos5l_buf_1_24.A vdd vdd sg13_lv_pmos ad=0.2856p pd=2.36u as=0.2114p ps=1.54u w=0.84u l=0.13u
X195 SAR/a_8966_6600# SAR/a_8570_6172# SAR/a_8852_6484# vdd sg13_lv_pmos ad=0.1008p pd=0.9u as=0.191p ps=1.44u w=0.42u l=0.13u
X196 SAR/sg13cmos5l_buf_1_97.A SAR/a_10473_9186# vss vss sg13_lv_nmos ad=0.2516p pd=2.16u as=0.1406p ps=1.12u w=0.74u l=0.13u
X197 SAR/a_10331_1924# SAR/sg13cmos5l_nand2_1_1.B SAR/sg13cmos5l_a22oi_1_2.B1 vdd sg13_lv_pmos ad=0.2128p pd=1.5u as=0.3808p ps=2.92u w=1.12u l=0.13u
X198 vss SAR/sg13cmos5l_dfrbp_1_6.RESET_B SAR/a_516_5850# vss sg13_lv_nmos ad=0.1626p pd=1.415u as=60.89999f ps=0.71u w=0.42u l=0.13u
X199 SAR/sg13cmos5l_a221oi_1_0.A2 SAR/a_7892_3900# vdd vdd sg13_lv_pmos ad=0.3808p pd=2.92u as=0.2128p ps=1.5u w=1.12u l=0.13u
X200 SAR/a_18300_7710# SAR/a_17751_7690# SAR/a_18164_7996# vss sg13_lv_nmos ad=47.25f pd=0.645u as=0.141p ps=1.17u w=0.42u l=0.13u
X201 vdd SAR/sg13cmos5l_dfrbp_1_8.RESET_B SAR/a_14602_8404# vdd sg13_lv_pmos ad=0.1563p pd=1.22u as=0.147p ps=1.54u w=0.42u l=0.13u
X202 SAR/sg13cmos5l_dfrbp_1_1.Q SAR/a_13652_1924# vss vss sg13_lv_nmos ad=0.2516p pd=2.16u as=0.1406p ps=1.12u w=0.74u l=0.13u
X203 SAR/sg13cmos5l_a221oi_1_0.C1 SAR/sg13cmos5l_inv_1_0.A vss vss sg13_lv_nmos ad=0.1406p pd=1.12u as=0.2516p ps=2.16u w=0.74u l=0.13u
X204 vdd SAR/a_8972_9150# SAR/sg13cmos5l_buf_1_77.X vdd sg13_lv_pmos ad=0.2114p pd=1.54u as=0.42p ps=2.99u w=1.12u l=0.13u
X205 vdd SAR/sg13cmos5l_dfrbp_1_6.RESET_B SAR/a_422_7362# vdd sg13_lv_pmos ad=0.36237p pd=2.605u as=79.8f ps=0.8u w=0.42u l=0.13u
X206 vss SAR/a_11372_3102# nh_sw[5] vss sg13_lv_nmos ad=0.14875p pd=1.16u as=0.2886p ps=2.26u w=0.74u l=0.13u
X207 SAR/a_11530_3868# SAR/a_11973_3911# SAR/a_11270_4338# vss sg13_lv_nmos ad=79.8f pd=0.8u as=0.1296p ps=1.52u w=0.42u l=0.13u
X208 SAR/a_2161_4642# SAR/a_1609_4704# vss vss sg13_lv_nmos ad=71.99999f pd=0.865u as=2.41737p ps=15.64u w=0.64u l=0.13u
X209 vdd SAR/sg13cmos5l_a22oi_1_1.A1 SAR/a_14814_3876# vdd sg13_lv_pmos ad=0.3808p pd=2.92u as=0.2716p ps=1.605u w=1.12u l=0.13u
X210 vdd SAR/a_10412_6126# SAR/sg13cmos5l_buf_1_29.A vdd sg13_lv_pmos ad=0.2114p pd=1.54u as=0.42p ps=2.99u w=1.12u l=0.13u
X211 vdd SAR/sg13cmos5l_dfrbp_1_0.RESET_B SAR/a_15466_2356# vdd sg13_lv_pmos ad=0.1563p pd=1.22u as=0.147p ps=1.54u w=0.42u l=0.13u
X212 vdd vss vdd vdd sg13_lv_pmos ad=0.34p pd=2.68u as=0 ps=0 w=1u l=1u
X213 SAR/a_6188_1590# SAR/sg13cmos5l_buf_1_25.A vss vss sg13_lv_nmos ad=0.187p pd=1.78u as=0.14875p ps=1.16u w=0.55u l=0.13u
X214 SAR/sg13cmos5l_dlhr_1_11.Q_N SAR/a_13686_7354# vdd vdd sg13_lv_pmos ad=0.3808p pd=2.92u as=0.1974p ps=1.5u w=1.12u l=0.13u
X215 SAR/a_16425_6971# SAR/a_16068_6928# vdd vdd sg13_lv_pmos ad=63f pd=0.72u as=0.1563p ps=1.22u w=0.42u l=0.13u
X216 SAR/sg13cmos5l_nand2_1_1.A SAR/a_15380_3436# vss vss sg13_lv_nmos ad=0.2516p pd=2.16u as=0.1406p ps=1.12u w=0.74u l=0.13u
X217 SAR/sg13cmos5l_inv_1_2.A SAR/a_8488_9224# vdd vdd sg13_lv_pmos ad=0.42p pd=2.99u as=0.2114p ps=1.54u w=1.12u l=0.13u
X218 SAR/a_9040_7894# SAR/a_8783_7751# SAR/a_9202_7674# vss sg13_lv_nmos ad=0.1428p pd=1.52u as=37.8f ps=0.6u w=0.42u l=0.13u
X219 vdd SAR/a_7631_4727# SAR/a_7888_4870# vdd sg13_lv_pmos ad=0.2639p pd=1.81u as=79.8f ps=0.8u w=0.42u l=0.13u
X220 SAR/a_2374_4325# SAR/sg13cmos5l_dfrbp_1_8.RESET_B vss vss sg13_lv_nmos ad=37.8f pd=0.6u as=0.1701p ps=1.65u w=0.42u l=0.13u
X221 SAR/a_3831_7282# SAR/sg13cmos5l_dfrbp_1_15.D vss vss sg13_lv_nmos ad=0.2516p pd=2.16u as=0.15055p ps=1.17u w=0.74u l=0.13u
X222 SAR/a_10598_6924# SAR/a_10202_7288# SAR/a_10484_6924# vdd sg13_lv_pmos ad=0.1008p pd=0.9u as=0.191p ps=1.44u w=0.42u l=0.13u
X223 SAR/a_7750_7687# SAR/sg13cmos5l_dfrbp_1_6.RESET_B vss vss sg13_lv_nmos ad=37.8f pd=0.6u as=0.1701p ps=1.65u w=0.42u l=0.13u
X224 _d0 SAR/a_20392_2388# vdd vdd sg13_lv_pmos ad=0.42p pd=2.99u as=0.2114p ps=1.54u w=1.12u l=0.13u
X225 vss SAR/sg13cmos5l_dfrbp_1_20.Q_N SAR/a_9673_9240# vss sg13_lv_nmos ad=0.15055p pd=1.17u as=0.187p ps=1.78u w=0.55u l=0.13u
X226 SAR/a_8412_7326# SAR/a_7863_7282# SAR/a_8276_6924# vss sg13_lv_nmos ad=47.25f pd=0.645u as=0.141p ps=1.17u w=0.42u l=0.13u
X227 SAR/sg13cmos5l_buf_1_94.X SAR/a_15016_9224# vdd vdd sg13_lv_pmos ad=0.42p pd=2.99u as=0.2114p ps=1.54u w=1.12u l=0.13u
X228 vdd SAR/a_6380_7638# pl_sw[3] vdd sg13_lv_pmos ad=0.2114p pd=1.54u as=0.42p ps=2.99u w=1.12u l=0.13u
X229 vdd SAR/a_17493_3947# SAR/a_16572_4261# vdd sg13_lv_pmos ad=0.36237p pd=2.605u as=0.34p ps=2.68u w=1u l=0.13u
X230 SAR/a_11364_4338# SAR/sg13cmos5l_dfrbp_1_2.D SAR/a_11270_4338# vss sg13_lv_nmos ad=60.89999f pd=0.71u as=0.1428p ps=1.52u w=0.42u l=0.13u
X231 vdd SAR/a_13484_8400# SAR/sg13cmos5l_buf_1_5.A vdd sg13_lv_pmos ad=0.2114p pd=1.54u as=0.42p ps=2.99u w=1.12u l=0.13u
X232 SAR/a_2638_6162# SAR/a_2380_6162# vss vss sg13_lv_nmos ad=0.1428p pd=1.52u as=79.8f ps=0.8u w=0.42u l=0.13u
X233 SAR/sg13cmos5l_dlhr_1_10.Q_N SAR/a_20118_6144# vdd vdd sg13_lv_pmos ad=0.3808p pd=2.92u as=0.1974p ps=1.5u w=1.12u l=0.13u
X234 SAR/a_11460_2392# SAR/a_11434_2356# vdd vdd sg13_lv_pmos ad=0.34p pd=2.68u as=0.36237p ps=2.605u w=1u l=0.13u
X235 SAR/sg13cmos5l_buf_1_59.A SAR/a_4425_7281# vss vss sg13_lv_nmos ad=0.2516p pd=2.16u as=0.1406p ps=1.12u w=0.74u l=0.13u
X236 vdd SAR/sg13cmos5l_inv_1_29.Y SAR/a_11771_5412# vdd sg13_lv_pmos ad=0.2128p pd=1.5u as=0.2128p ps=1.5u w=1.12u l=0.13u
X237 vdd SAR/a_18959_3215# SAR/a_19796_3436# vdd sg13_lv_pmos ad=0.2128p pd=1.5u as=0.3864p ps=2.93u w=1.12u l=0.13u
X238 vss SAR/sg13cmos5l_buf_1_24.X SAR/a_5704_1664# vss sg13_lv_nmos ad=0.14875p pd=1.16u as=0.187p ps=1.78u w=0.55u l=0.13u
X239 SAR/a_10433_4248# SAR/sg13cmos5l_dfrbp_1_10.Q SAR/sg13cmos5l_a22oi_1_1.B1 vss sg13_lv_nmos ad=0.1406p pd=1.12u as=0.1406p ps=1.12u w=0.74u l=0.13u
X240 SAR/a_2436_4325# SAR/a_2667_3911# SAR/a_2122_3868# vss sg13_lv_nmos ad=0.2373p pd=1.97u as=79.8f ps=0.8u w=0.42u l=0.13u
X241 vss SAR/sg13cmos5l_buf_1_34.X SAR/sg13cmos5l_buf_1_60.A vss sg13_lv_nmos ad=0.2516p pd=2.16u as=0.2516p ps=2.16u w=0.74u l=0.13u
X242 SAR/a_10484_6924# SAR/a_10202_7288# SAR/a_10417_7326# vss sg13_lv_nmos ad=0.141p pd=1.17u as=71.99999f ps=0.865u w=0.64u l=0.13u
X243 vss vdd vss vss sg13_lv_nmos ad=0.1428p pd=1.52u as=0 ps=0 w=0.42u l=1u
X244 SAR/a_4559_7630# SAR/sg13cmos5l_dlhr_1_9.D vdd vdd sg13_lv_pmos ad=0.2856p pd=2.36u as=1.15047p ps=7.175u w=0.84u l=0.13u
X245 vdd SAR/sg13cmos5l_dfrbp_1_6.RESET_B SAR/a_12230_6162# vdd sg13_lv_pmos ad=0.36237p pd=2.605u as=79.8f ps=0.8u w=0.42u l=0.13u
X246 SAR/a_18117_3117# SAR/sg13cmos5l_dfrbp_1_0.CLK vss vss sg13_lv_nmos ad=0.2516p pd=2.16u as=2.43055p ps=15.415u w=0.74u l=0.13u
X247 vss SAR/sg13cmos5l_dfrbp_1_6.RESET_B SAR/a_7732_3124# vss sg13_lv_nmos ad=0.1406p pd=1.12u as=77.7f ps=0.95u w=0.74u l=0.13u
X248 vdd SAR/a_2224_5654# SAR/a_2169_5535# vdd sg13_lv_pmos ad=1.28962p pd=8.195u as=93.45f ps=0.865u w=0.42u l=0.13u
X249 vss SAR/sg13cmos5l_buf_1_61.X SAR/a_1000_9224# vss sg13_lv_nmos ad=0.14875p pd=1.16u as=0.187p ps=1.78u w=0.55u l=0.13u
X250 SAR/a_13017_4023# SAR/a_12075_3911# SAR/a_12815_4261# vdd sg13_lv_pmos ad=93.45f pd=0.865u as=0.2048p ps=1.63u w=0.42u l=0.13u
X251 vdd SAR/a_17135_4727# SAR/a_17392_4870# vdd sg13_lv_pmos ad=0.2639p pd=1.81u as=79.8f ps=0.8u w=0.42u l=0.13u
X252 SAR/sg13cmos5l_buf_1_111.A SAR/a_19240_7712# vss vss sg13_lv_nmos ad=0.2886p pd=2.26u as=0.14875p ps=1.16u w=0.74u l=0.13u
X253 vdd SAR/sg13cmos5l_inv_1_6.A SAR/a_20008_8436# vdd sg13_lv_pmos ad=0.2114p pd=1.54u as=0.2856p ps=2.36u w=0.84u l=0.13u
X254 SAR/a_4172_1590# SAR/sg13cmos5l_buf_1_38.A vss vss sg13_lv_nmos ad=0.187p pd=1.78u as=0.14875p ps=1.16u w=0.55u l=0.13u
X255 vss SAR/a_9879_9202# SAR/a_10010_9196# vss sg13_lv_nmos ad=2.92392p pd=18.89u as=0.2775p ps=2.23u w=0.74u l=0.13u
X256 SAR/a_7474_4338# SAR/sg13cmos5l_dfrbp_1_6.RESET_B vss vss sg13_lv_nmos ad=37.8f pd=0.6u as=79.8f ps=0.8u w=0.42u l=0.13u
X257 SAR/sg13cmos5l_dlhr_1_5.D SAR/a_6959_6239# vss vss sg13_lv_nmos ad=0.2849p pd=2.25u as=0.2516p ps=2.16u w=0.74u l=0.13u
X258 SAR/a_8593_5814# SAR/a_8041_5770# vss vss sg13_lv_nmos ad=71.99999f pd=0.865u as=1.97045p ps=12.335u w=0.64u l=0.13u
X259 SAR/a_11877_2399# SAR/sg13cmos5l_dfrbp_1_0.CLK vss vss sg13_lv_nmos ad=0.2516p pd=2.16u as=2.43055p ps=15.415u w=0.74u l=0.13u
X260 SAR/a_17554_4650# SAR/sg13cmos5l_dfrbp_1_8.RESET_B vss vss sg13_lv_nmos ad=37.8f pd=0.6u as=79.8f ps=0.8u w=0.42u l=0.13u
X261 SAR/a_17132_9150# SAR/sg13cmos5l_buf_1_94.X vss vss sg13_lv_nmos ad=0.187p pd=1.78u as=0.14875p ps=1.16u w=0.55u l=0.13u
X262 vdd SAR/sg13cmos5l_buf_1_19.A SAR/a_18760_2388# vdd sg13_lv_pmos ad=0.2114p pd=1.54u as=0.2856p ps=2.36u w=0.84u l=0.13u
X263 SAR/a_5674_6385# SAR/a_6117_6141# SAR/a_6057_6553# vdd sg13_lv_pmos ad=79.8f pd=0.8u as=63f ps=0.72u w=0.42u l=0.13u
X264 vdd SAR/sg13cmos5l_buf_1_98.A SAR/a_13768_8436# vdd sg13_lv_pmos ad=0.2114p pd=1.54u as=0.2856p ps=2.36u w=0.84u l=0.13u
X265 SAR/sg13cmos5l_dlhr_1_5.Q_N SAR/a_8982_7354# vdd vdd sg13_lv_pmos ad=0.3808p pd=2.92u as=0.1974p ps=1.5u w=1.12u l=0.13u
X266 SAR/a_17700_3456# SAR/a_17674_3361# vdd vdd sg13_lv_pmos ad=0.34p pd=2.68u as=0.36237p ps=2.605u w=1u l=0.13u
X267 SAR/a_10220_3102# SAR/sg13cmos5l_buf_1_28.X vdd vdd sg13_lv_pmos ad=0.2856p pd=2.36u as=0.2114p ps=1.54u w=0.84u l=0.13u
X268 SAR/sg13cmos5l_a22oi_1_1.Y SAR/sg13cmos5l_a22oi_1_1.B2 SAR/a_14814_3876# vdd sg13_lv_pmos ad=0.2128p pd=1.5u as=0.2744p ps=1.61u w=1.12u l=0.13u
X269 SAR/a_8660_5412# SAR/a_8247_5770# SAR/a_8592_5412# vdd sg13_lv_pmos ad=0.191p pd=1.44u as=0.105p ps=1.21u w=1u l=0.13u
X270 SAR/a_8796_5814# SAR/a_8247_5770# SAR/a_8660_5412# vss sg13_lv_nmos ad=47.25f pd=0.645u as=0.141p ps=1.17u w=0.42u l=0.13u
X271 vss SAR/a_17961_8793# SAR/a_18486_8866# vss sg13_lv_nmos ad=0.1491p pd=1.18u as=0.187p ps=1.78u w=0.55u l=0.13u
X272 vdd SAR/sg13cmos5l_inv_1_29.A SAR/a_12841_7728# vdd sg13_lv_pmos ad=1.15047p pd=7.175u as=0.2856p ps=2.36u w=0.84u l=0.13u
X273 vdd SAR/a_13641_7674# SAR/a_13574_8112# vdd sg13_lv_pmos ad=0.2387p pd=1.84u as=0.1008p ps=0.9u w=0.42u l=0.13u
X274 vdd SAR/a_19593_6162# SAR/a_20118_6144# vdd sg13_lv_pmos ad=0.1974p pd=1.5u as=0.2856p ps=2.36u w=0.84u l=0.13u
X275 SAR/a_10028_6126# SAR/sg13cmos5l_buf_1_56.A vss vss sg13_lv_nmos ad=0.187p pd=1.78u as=0.14875p ps=1.16u w=0.55u l=0.13u
X276 vss SAR/sg13cmos5l_buf_1_33.A SAR/a_2248_1664# vss sg13_lv_nmos ad=0.14875p pd=1.16u as=0.187p ps=1.78u w=0.55u l=0.13u
X277 vss SAR/sg13cmos5l_buf_8_1.A SAR/a_18363_4270# vss sg13_lv_nmos ad=0.1406p pd=1.12u as=0.2553p ps=2.17u w=0.74u l=0.13u
X278 vss SAR/a_13076_5376# SAR/sg13cmos5l_or2_1_1.B vss sg13_lv_nmos ad=0.17255p pd=1.25u as=0.1406p ps=1.12u w=0.74u l=0.13u
X279 SAR/sg13cmos5l_dfrbp_1_21.Q SAR/a_18356_6460# vss vss sg13_lv_nmos ad=0.2516p pd=2.16u as=0.1406p ps=1.12u w=0.74u l=0.13u
X280 SAR/a_13161_7281# SAR/a_12980_6924# vdd vdd sg13_lv_pmos ad=0.2128p pd=1.5u as=0.2387p ps=1.84u w=1.12u l=0.13u
X281 SAR/a_7820_2352# SAR/sg13cmos5l_dlhr_1_0.Q vss vss sg13_lv_nmos ad=0.187p pd=1.78u as=0.14875p ps=1.16u w=0.55u l=0.13u
X282 vdd SAR/sg13cmos5l_dlhr_1_6.D SAR/a_8233_6216# vdd sg13_lv_pmos ad=1.07253p pd=6.75u as=0.2856p ps=2.36u w=0.84u l=0.13u
X283 SAR/a_3302_4650# SAR/sg13cmos5l_dfrbp_1_9.Q vdd vdd sg13_lv_pmos ad=79.8f pd=0.8u as=0.1428p ps=1.52u w=0.42u l=0.13u
X284 SAR/sg13cmos5l_o21ai_1_0.A2 SAR/sg13cmos5l_nand2_1_0.B vdd vdd sg13_lv_pmos ad=0.2128p pd=1.5u as=0.3808p ps=2.92u w=1.12u l=0.13u
X285 vdd SAR/a_15884_3102# nh_sw[7] vdd sg13_lv_pmos ad=0.2114p pd=1.54u as=0.42p ps=2.99u w=1.12u l=0.13u
X286 SAR/a_12106_9409# SAR/a_12549_9165# SAR/a_11846_9186# vss sg13_lv_nmos ad=79.8f pd=0.8u as=0.1296p ps=1.52u w=0.42u l=0.13u
X287 SAR/a_8985_7989# SAR/a_8043_7796# SAR/a_8783_7751# vdd sg13_lv_pmos ad=93.45f pd=0.865u as=0.2048p ps=1.63u w=0.42u l=0.13u
X288 SAR/a_4177_7326# SAR/a_3625_7282# vss vss sg13_lv_nmos ad=71.99999f pd=0.865u as=1.49685p ps=9.6u w=0.64u l=0.13u
X289 vdd SAR/a_12815_4261# SAR/a_13072_4142# vdd sg13_lv_pmos ad=0.2639p pd=1.81u as=79.8f ps=0.8u w=0.42u l=0.13u
X290 vss SAR/a_6903_3154# SAR/a_7034_3148# vss sg13_lv_nmos ad=2.59257p pd=16.445u as=0.2775p ps=2.23u w=0.74u l=0.13u
X291 SAR/a_18117_3117# SAR/sg13cmos5l_dfrbp_1_0.CLK vdd vdd sg13_lv_pmos ad=0.4088p pd=2.97u as=1.38655p ps=8.8u w=1.12u l=0.13u
X292 vdd SAR/sg13cmos5l_buf_1_28.A SAR/a_9448_1664# vdd sg13_lv_pmos ad=0.2114p pd=1.54u as=0.2856p ps=2.36u w=0.84u l=0.13u
X293 SAR/a_17584_7166# SAR/sg13cmos5l_dfrbp_1_8.RESET_B vdd vdd sg13_lv_pmos ad=79.8f pd=0.8u as=1.04815p ps=6.595u w=0.42u l=0.13u
X294 vdd SAR/sg13cmos5l_buf_1_86.A SAR/a_20392_6924# vdd sg13_lv_pmos ad=0.2114p pd=1.54u as=0.2856p ps=2.36u w=0.84u l=0.13u
X295 SAR/a_17519_6239# SAR/a_16677_6141# SAR/a_16260_6480# vdd sg13_lv_pmos ad=0.2048p pd=1.63u as=0.34p ps=2.68u w=1u l=0.13u
X296 SAR/a_996_5837# SAR/a_708_5416# SAR/a_934_5837# vss sg13_lv_nmos ad=0.1428p pd=1.52u as=37.8f ps=0.6u w=0.42u l=0.13u
X297 vdd vss vdd vdd sg13_lv_pmos ad=0.19p pd=1.38u as=0 ps=0 w=1u l=1u
X298 vdd SAR/sg13cmos5l_inv_1_8.A SAR/a_2879_6432# vdd sg13_lv_pmos ad=1.07253p pd=6.75u as=0.4088p ps=2.97u w=1.12u l=0.13u
X299 SAR/a_2054_3138# SAR/a_2859_3260# SAR/a_2314_3361# vdd sg13_lv_pmos ad=0.1428p pd=1.52u as=79.8f ps=0.8u w=0.42u l=0.13u
X300 vdd SAR/a_1484_9150# SAR/sg13cmos5l_buf_1_68.X vdd sg13_lv_pmos ad=0.2114p pd=1.54u as=0.42p ps=2.99u w=1.12u l=0.13u
X301 vdd SAR/sg13cmos5l_dfrbp_1_0.RESET_B SAR/a_17126_1626# vdd sg13_lv_pmos ad=0.36237p pd=2.605u as=79.8f ps=0.8u w=0.42u l=0.13u
X302 SAR/sg13cmos5l_dfrbp_1_0.D SAR/sg13cmos5l_nor2_1_1.A vss vss sg13_lv_nmos ad=0.1406p pd=1.12u as=0.2516p ps=2.16u w=0.74u l=0.13u
X303 vdd SAR/sg13cmos5l_buf_1_78.A SAR/a_6184_9224# vdd sg13_lv_pmos ad=0.2114p pd=1.54u as=0.2856p ps=2.36u w=0.84u l=0.13u
X304 SAR/a_5194_2356# SAR/a_5637_2399# SAR/a_5577_2435# vdd sg13_lv_pmos ad=79.8f pd=0.8u as=63f ps=0.72u w=0.42u l=0.13u
X305 SAR/a_14543_3215# SAR/a_13701_3117# SAR/a_14449_3215# vss sg13_lv_nmos ad=0.12665p pd=1.145u as=0.1428p ps=1.52u w=0.42u l=0.13u
X306 vss SAR/a_12719_2749# SAR/a_13556_2388# vss sg13_lv_nmos ad=0.1406p pd=1.12u as=0.2516p ps=2.16u w=0.74u l=0.13u
X307 vdd SAR/sg13cmos5l_dfrbp_1_6.RESET_B SAR/a_2054_3138# vdd sg13_lv_pmos ad=0.36237p pd=2.605u as=79.8f ps=0.8u w=0.42u l=0.13u
X308 SAR/sg13cmos5l_buf_8_0.X SAR/a_19227_4654# vss vss sg13_lv_nmos ad=0.1406p pd=1.12u as=0.1406p ps=1.12u w=0.74u l=0.13u
X309 SAR/a_3945_5041# SAR/a_3588_4968# vdd vdd sg13_lv_pmos ad=63f pd=0.72u as=0.1563p ps=1.22u w=0.42u l=0.13u
X310 pl_sw[1] SAR/a_1000_9224# vdd vdd sg13_lv_pmos ad=0.42p pd=2.99u as=0.2114p ps=1.54u w=1.12u l=0.13u
X311 SAR/a_3407_8797# SAR/a_2565_8447# SAR/a_2148_8440# vdd sg13_lv_pmos ad=0.2048p pd=1.63u as=0.34p ps=2.68u w=1u l=0.13u
X312 SAR/a_12815_1703# SAR/a_11973_1605# SAR/a_11556_1944# vdd sg13_lv_pmos ad=0.2048p pd=1.63u as=0.34p ps=2.68u w=1u l=0.13u
X313 vss SAR/sg13cmos5l_dlygate4sd3_1_0.X SAR/sg13cmos5l_buf_1_43.A vss sg13_lv_nmos ad=0.2516p pd=2.16u as=0.2516p ps=2.16u w=0.74u l=0.13u
X314 SAR/sg13cmos5l_buf_1_6.A SAR/a_12520_3176# vss vss sg13_lv_nmos ad=0.2886p pd=2.26u as=0.14875p ps=1.16u w=0.74u l=0.13u
X315 SAR/a_15876_4968# SAR/a_15850_4873# vss vss sg13_lv_nmos ad=0.2516p pd=2.16u as=0.1626p ps=1.415u w=0.74u l=0.13u
X316 ph_sw[0] SAR/a_616_9224# vss vss sg13_lv_nmos ad=0.2886p pd=2.26u as=0.14875p ps=1.16u w=0.74u l=0.13u
X317 SAR/a_11846_9186# SAR/a_12651_9308# SAR/a_12106_9409# vdd sg13_lv_pmos ad=0.1428p pd=1.52u as=79.8f ps=0.8u w=0.42u l=0.13u
X318 vdd SAR/a_4559_7630# SAR/a_4518_7996# vdd sg13_lv_pmos ad=1.15047p pd=7.175u as=0.105p ps=1.21u w=1u l=0.13u
X319 SAR/a_1948_7964# SAR/a_2348_7624# SAR/a_2306_7660# vss sg13_lv_nmos ad=0.2516p pd=2.16u as=77.7f ps=0.95u w=0.74u l=0.13u
X320 SAR/a_15124_7312# SAR/a_14708_6924# SAR/a_14889_7281# vss sg13_lv_nmos ad=77.7f pd=0.95u as=0.2516p ps=2.16u w=0.74u l=0.13u
X321 vss SAR/a_3308_9150# SAR/sg13cmos5l_inv_1_8.A vss sg13_lv_nmos ad=0.14875p pd=1.16u as=0.2886p ps=2.26u w=0.74u l=0.13u
X322 SAR/a_15821_3864# SAR/a_16551_3987# SAR/a_16572_4261# vss sg13_lv_nmos ad=0.12665p pd=1.145u as=0.3473p ps=2.71u w=0.74u l=0.13u
X323 SAR/a_12804_6175# SAR/a_12516_6480# SAR/a_12742_6175# vss sg13_lv_nmos ad=0.1428p pd=1.52u as=37.8f ps=0.6u w=0.42u l=0.13u
X324 SAR/a_8208_6924# SAR/a_7657_7282# vdd vdd sg13_lv_pmos ad=0.105p pd=1.21u as=1.07253p ps=6.75u w=1u l=0.13u
X325 vss SAR/sg13cmos5l_buf_1_5.A SAR/a_14440_1664# vss sg13_lv_nmos ad=0.14875p pd=1.16u as=0.187p ps=1.78u w=0.55u l=0.13u
X326 SAR/sg13cmos5l_a22oi_1_0.Y SAR/sg13cmos5l_a22oi_1_0.B1 SAR/a_10783_3876# vdd sg13_lv_pmos ad=0.2128p pd=1.5u as=0.2716p ps=1.605u w=1.12u l=0.13u
X327 SAR/a_13648_9406# SAR/a_13391_9263# SAR/a_13810_9186# vss sg13_lv_nmos ad=0.1428p pd=1.52u as=37.8f ps=0.6u w=0.42u l=0.13u
X328 SAR/sg13cmos5l_buf_1_103.A SAR/a_15784_9224# vss vss sg13_lv_nmos ad=0.2886p pd=2.26u as=0.14875p ps=1.16u w=0.74u l=0.13u
X329 SAR/a_17414_3138# SAR/a_18219_3260# SAR/a_17674_3361# vdd sg13_lv_pmos ad=0.1428p pd=1.52u as=79.8f ps=0.8u w=0.42u l=0.13u
X330 SAR/sg13cmos5l_dlhr_1_6.D SAR/a_7796_6460# vss vss sg13_lv_nmos ad=0.2516p pd=2.16u as=0.1406p ps=1.12u w=0.74u l=0.13u
X331 vss vdd vss vss sg13_lv_nmos ad=79.8f pd=0.8u as=0 ps=0 w=0.42u l=1u
X332 SAR/a_6959_6239# SAR/a_6117_6141# SAR/a_6865_6239# vss sg13_lv_nmos ad=0.12665p pd=1.145u as=0.1428p ps=1.52u w=0.42u l=0.13u
X333 vss SAR/a_1580_2352# nh_sw[0] vss sg13_lv_nmos ad=0.14875p pd=1.16u as=0.2886p ps=2.26u w=0.74u l=0.13u
X334 SAR/a_7238_7674# SAR/a_8043_7796# SAR/a_7498_7897# vdd sg13_lv_pmos ad=0.1428p pd=1.52u as=79.8f ps=0.8u w=0.42u l=0.13u
X335 SAR/a_14543_3215# SAR/a_13701_3117# SAR/a_13284_3456# vdd sg13_lv_pmos ad=0.2048p pd=1.63u as=0.34p ps=2.68u w=1u l=0.13u
X336 SAR/a_19412_6484# SAR/a_18999_6178# SAR/a_19344_6484# vdd sg13_lv_pmos ad=0.191p pd=1.44u as=0.105p ps=1.21u w=1u l=0.13u
X337 SAR/sg13cmos5l_dlhr_1_15.Q SAR/a_18345_7674# vss vss sg13_lv_nmos ad=0.2516p pd=2.16u as=0.1406p ps=1.12u w=0.74u l=0.13u
X338 vdd SAR/a_4652_6126# SAR/sg13cmos5l_inv_1_19.A vdd sg13_lv_pmos ad=0.2114p pd=1.54u as=0.42p ps=2.99u w=1.12u l=0.13u
X339 vss SAR/sg13cmos5l_dfrbp_1_6.RESET_B SAR/a_13396_7312# vss sg13_lv_nmos ad=0.1406p pd=1.12u as=77.7f ps=0.95u w=0.74u l=0.13u
X340 vdd SAR/a_8588_2352# nl_sw[4] vdd sg13_lv_pmos ad=0.2114p pd=1.54u as=0.42p ps=2.99u w=1.12u l=0.13u
X341 SAR/a_15466_2356# SAR/a_15909_2399# SAR/a_15206_2826# vss sg13_lv_nmos ad=79.8f pd=0.8u as=0.1296p ps=1.52u w=0.42u l=0.13u
X342 SAR/a_16102_4663# SAR/sg13cmos5l_dfrbp_1_8.RESET_B vss vss sg13_lv_nmos ad=37.8f pd=0.6u as=0.1701p ps=1.65u w=0.42u l=0.13u
X343 vdd vss vdd vdd sg13_lv_pmos ad=0.19p pd=1.38u as=0 ps=0 w=1u l=1u
X344 SAR/a_2409_4650# SAR/a_2228_4972# vdd vdd sg13_lv_pmos ad=0.2128p pd=1.5u as=0.2387p ps=1.84u w=1.12u l=0.13u
X345 SAR/a_13017_1941# SAR/a_12075_1748# SAR/a_12815_1703# vdd sg13_lv_pmos ad=93.45f pd=0.865u as=0.2048p ps=1.63u w=0.42u l=0.13u
X346 SAR/a_9040_7894# SAR/sg13cmos5l_dfrbp_1_6.RESET_B vdd vdd sg13_lv_pmos ad=79.8f pd=0.8u as=1.12242p ps=7u w=0.42u l=0.13u
X347 SAR/a_13047_7690# SAR/sg13cmos5l_dlhr_1_11.GATE vss vss sg13_lv_nmos ad=0.2516p pd=2.16u as=0.15055p ps=1.17u w=0.74u l=0.13u
X348 SAR/sg13cmos5l_buf_1_2.X SAR/a_15784_1664# vdd vdd sg13_lv_pmos ad=0.42p pd=2.99u as=0.2114p ps=1.54u w=1.12u l=0.13u
X349 SAR/a_9524_4972# SAR/a_9242_4660# SAR/a_9457_4642# vss sg13_lv_nmos ad=0.141p pd=1.17u as=71.99999f ps=0.865u w=0.64u l=0.13u
X350 vss vdd vss vss sg13_lv_nmos ad=79.8f pd=0.8u as=0 ps=0 w=0.42u l=1u
X351 vdd SAR/sg13cmos5l_dfrbp_1_0.RESET_B SAR/a_11270_4338# vdd sg13_lv_pmos ad=0.36237p pd=2.605u as=79.8f ps=0.8u w=0.42u l=0.13u
X352 vdd SAR/a_19227_4654# SAR/sg13cmos5l_buf_8_0.X vdd sg13_lv_pmos ad=0.3864p pd=2.93u as=0.2128p ps=1.5u w=1.12u l=0.13u
X353 vdd SAR/sg13cmos5l_buf_1_31.X SAR/a_9448_6924# vdd sg13_lv_pmos ad=0.2114p pd=1.54u as=0.2856p ps=2.36u w=0.84u l=0.13u
X354 SAR/a_18999_6178# SAR/sg13cmos5l_dfrbp_1_8.D vdd vdd sg13_lv_pmos ad=0.3234p pd=2.45u as=1.04815p ps=6.595u w=0.84u l=0.13u
X355 SAR/sg13cmos5l_dlhr_1_15.D SAR/a_17108_7972# vdd vdd sg13_lv_pmos ad=0.3808p pd=2.92u as=0.2128p ps=1.5u w=1.12u l=0.13u
X356 SAR/a_1484_9150# SAR/sg13cmos5l_inv_1_19.A vdd vdd sg13_lv_pmos ad=0.2856p pd=2.36u as=0.2114p ps=1.54u w=0.84u l=0.13u
X357 SAR/a_6959_6239# SAR/a_6117_6141# SAR/a_5700_6480# vdd sg13_lv_pmos ad=0.2048p pd=1.63u as=0.34p ps=2.68u w=1u l=0.13u
X358 SAR/sg13cmos5l_dlhr_1_0.Q SAR/a_7689_1626# vss vss sg13_lv_nmos ad=0.2516p pd=2.16u as=0.1406p ps=1.12u w=0.74u l=0.13u
X359 SAR/a_15782_7362# SAR/sg13cmos5l_dfrbp_1_22.D vdd vdd sg13_lv_pmos ad=79.8f pd=0.8u as=0.1428p ps=1.52u w=0.42u l=0.13u
X360 SAR/a_19593_6162# SAR/a_19412_6484# vdd vdd sg13_lv_pmos ad=0.2128p pd=1.5u as=0.2387p ps=1.84u w=1.12u l=0.13u
X361 SAR/a_1125_6935# SAR/sg13cmos5l_dfrbp_1_15.D vdd vdd sg13_lv_pmos ad=0.4088p pd=2.97u as=1.04815p ps=6.595u w=1.12u l=0.13u
X362 vss SAR/a_620_2352# nl_sw[0] vss sg13_lv_nmos ad=0.14875p pd=1.16u as=0.2886p ps=2.26u w=0.74u l=0.13u
X363 SAR/a_5604_4338# SAR/sg13cmos5l_dfrbp_1_6.D SAR/a_5510_4338# vss sg13_lv_nmos ad=60.89999f pd=0.71u as=0.1428p ps=1.52u w=0.42u l=0.13u
X364 SAR/a_5028_2826# SAR/sg13cmos5l_dfrbp_1_6.D SAR/a_4934_2826# vss sg13_lv_nmos ad=60.89999f pd=0.71u as=0.1428p ps=1.52u w=0.42u l=0.13u
X365 SAR/sg13cmos5l_buf_1_104.A SAR/sg13cmos5l_buf_1_3.A vdd vdd sg13_lv_pmos ad=0.3808p pd=2.92u as=0.3808p ps=2.92u w=1.12u l=0.13u
X366 SAR/a_15684_4650# SAR/sg13cmos5l_dfrbp_1_8.D SAR/a_15590_4650# vss sg13_lv_nmos ad=60.89999f pd=0.71u as=0.1428p ps=1.52u w=0.42u l=0.13u
X367 SAR/sg13cmos5l_o21ai_1_0.A1 SAR/sg13cmos5l_a221oi_1_0.C1 vss vss sg13_lv_nmos ad=0.2516p pd=2.16u as=0.1406p ps=1.12u w=0.74u l=0.13u
X368 SAR/a_2474_6162# SAR/a_1997_6126# SAR/a_2380_6162# vss sg13_lv_nmos ad=37.8f pd=0.6u as=0.1428p ps=1.52u w=0.42u l=0.13u
X369 vdd SAR/sg13cmos5l_buf_1_111.A SAR/a_18376_9224# vdd sg13_lv_pmos ad=0.2114p pd=1.54u as=0.2856p ps=2.36u w=0.84u l=0.13u
X370 SAR/a_18097_7666# SAR/a_17545_7728# vss vss sg13_lv_nmos ad=71.99999f pd=0.865u as=1.49685p ps=9.6u w=0.64u l=0.13u
X371 vss SAR/a_3447_2746# SAR/a_3578_2752# vss sg13_lv_nmos ad=2.59257p pd=16.445u as=0.2775p ps=2.23u w=0.74u l=0.13u
X372 vdd SAR/sg13cmos5l_dfrbp_1_6.RESET_B SAR/a_16234_6385# vdd sg13_lv_pmos ad=0.1563p pd=1.22u as=0.147p ps=1.54u w=0.42u l=0.13u
X373 SAR/a_10665_7281# SAR/a_10484_6924# vdd vdd sg13_lv_pmos ad=0.2128p pd=1.5u as=0.2387p ps=1.84u w=1.12u l=0.13u
X374 vdd SAR/sg13cmos5l_dfrbp_1_8.RESET_B SAR/a_6086_4650# vdd sg13_lv_pmos ad=0.36237p pd=2.605u as=79.8f ps=0.8u w=0.42u l=0.13u
X375 vss SAR/sg13cmos5l_buf_8_1.A SAR/a_16703_3871# vss sg13_lv_nmos ad=2.41737p pd=15.64u as=0.2516p ps=2.16u w=0.74u l=0.13u
X376 vdd SAR/sg13cmos5l_nor2_1_0.A SAR/a_13324_4696# vdd sg13_lv_pmos ad=0.1596p pd=1.22u as=0.2856p ps=2.36u w=0.84u l=0.13u
X377 SAR/a_996_5837# SAR/a_1227_5423# SAR/a_682_5380# vss sg13_lv_nmos ad=0.2373p pd=1.97u as=79.8f ps=0.8u w=0.42u l=0.13u
X378 SAR/a_10282_7897# SAR/a_10725_7653# SAR/a_10665_8065# vdd sg13_lv_pmos ad=79.8f pd=0.8u as=63f ps=0.72u w=0.42u l=0.13u
X379 SAR/a_5424_3460# SAR/a_4873_3192# vdd vdd sg13_lv_pmos ad=0.105p pd=1.21u as=1.43437p ps=9.105u w=1u l=0.13u
X380 SAR/a_1402_3864# SAR/sg13cmos5l_dlygate4sd2_1_0.X vss vss sg13_lv_nmos ad=0.1428p pd=1.52u as=79.8f ps=0.8u w=0.42u l=0.13u
X381 vss SAR/sg13cmos5l_inv_1_29.A SAR/a_12841_7728# vss sg13_lv_nmos ad=0.15055p pd=1.17u as=0.187p ps=1.78u w=0.55u l=0.13u
X382 vdd SAR/sg13cmos5l_dfrbp_1_21.Q SAR/a_18409_5770# vdd sg13_lv_pmos ad=1.28962p pd=8.195u as=0.2856p ps=2.36u w=0.84u l=0.13u
X383 vdd SAR/sg13cmos5l_dfrbp_1_10.Q_N SAR/a_3241_2746# vdd sg13_lv_pmos ad=1.86162p pd=11.935u as=0.2856p ps=2.36u w=0.84u l=0.13u
X384 vss SAR/a_19227_9190# SAR/sg13cmos5l_buf_8_2.X vss sg13_lv_nmos ad=0.2516p pd=2.16u as=0.1406p ps=1.12u w=0.74u l=0.13u
X385 vss SAR/a_10071_7282# SAR/a_10202_7288# vss sg13_lv_nmos ad=1.49685p pd=9.6u as=0.2775p ps=2.23u w=0.74u l=0.13u
X386 vdd SAR/a_7504_8678# SAR/a_7449_8559# vdd sg13_lv_pmos ad=1.15047p pd=7.175u as=93.45f ps=0.865u w=0.42u l=0.13u
X387 SAR/a_4282_8112# SAR/a_3676_7964# vdd vdd sg13_lv_pmos ad=0.1008p pd=0.9u as=0.2387p ps=1.84u w=0.42u l=0.13u
X388 SAR/a_682_5380# SAR/a_1125_5423# SAR/a_1065_5459# vdd sg13_lv_pmos ad=79.8f pd=0.8u as=63f ps=0.72u w=0.42u l=0.13u
X389 vdd SAR/a_11824_7894# SAR/a_11769_7989# vdd sg13_lv_pmos ad=1.15047p pd=7.175u as=93.45f ps=0.865u w=0.42u l=0.13u
X390 vdd SAR/a_4425_7281# SAR/a_4358_6924# vdd sg13_lv_pmos ad=0.2387p pd=1.84u as=0.1008p ps=0.9u w=0.42u l=0.13u
X391 SAR/a_2732_1590# SAR/sg13cmos5l_buf_1_37.A vdd vdd sg13_lv_pmos ad=0.2856p pd=2.36u as=0.2114p ps=1.54u w=0.84u l=0.13u
X392 SAR/a_16485_6935# SAR/sg13cmos5l_inv_1_2.A vdd vdd sg13_lv_pmos ad=0.4088p pd=2.97u as=1.07253p ps=6.75u w=1.12u l=0.13u
X393 SAR/a_13036_4948# SAR/a_12814_4692# vdd vdd sg13_lv_pmos ad=0.1176p pd=1.33u as=0.2618p ps=1.63u w=1.12u l=0.13u
X394 vss SAR/a_18615_5770# SAR/a_18746_5776# vss sg13_lv_nmos ad=1.97045p pd=12.335u as=0.2775p ps=2.23u w=0.74u l=0.13u
X395 vdd SAR/a_3574_7850# SAR/sg13cmos5l_dlhr_1_9.Q_N vdd sg13_lv_pmos ad=0.1974p pd=1.5u as=0.3808p ps=2.92u w=1.12u l=0.13u
X396 vdd SAR/a_16271_7751# SAR/a_16528_7894# vdd sg13_lv_pmos ad=0.2639p pd=1.81u as=79.8f ps=0.8u w=0.42u l=0.13u
X397 SAR/a_6084_4325# SAR/a_5796_3904# SAR/a_6022_4325# vss sg13_lv_nmos ad=0.1428p pd=1.52u as=37.8f ps=0.6u w=0.42u l=0.13u
X398 vdd SAR/a_12815_1703# SAR/a_13072_1846# vdd sg13_lv_pmos ad=0.2639p pd=1.81u as=79.8f ps=0.8u w=0.42u l=0.13u
X399 SAR/sg13cmos5l_a22oi_1_1.B2 SAR/sg13cmos5l_dlhr_1_6.D SAR/a_13486_5760# vss sg13_lv_nmos ad=0.2516p pd=2.16u as=0.1406p ps=1.12u w=0.74u l=0.13u
X400 SAR/a_11072_5347# SAR/sg13cmos5l_nor2_1_0.A SAR/a_11370_5760# vss sg13_lv_nmos ad=0.2176p pd=1.96u as=0.1216p ps=1.02u w=0.64u l=0.13u
X401 vss SAR/sg13cmos5l_buf_1_4.A SAR/a_16552_1664# vss sg13_lv_nmos ad=0.14875p pd=1.16u as=0.187p ps=1.78u w=0.55u l=0.13u
X402 vss SAR/a_16485_6935# SAR/a_16587_6935# vss sg13_lv_nmos ad=1.49685p pd=9.6u as=0.2516p ps=2.16u w=0.74u l=0.13u
X403 vss SAR/sg13cmos5l_inv_1_7.A SAR/a_12232_8436# vss sg13_lv_nmos ad=0.14875p pd=1.16u as=0.187p ps=1.78u w=0.55u l=0.13u
X404 vss SAR/a_8972_3864# SAR/sg13cmos5l_buf_1_45.X vss sg13_lv_nmos ad=0.14875p pd=1.16u as=0.2886p ps=2.26u w=0.74u l=0.13u
X405 SAR/a_10308_7992# SAR/a_10827_7796# SAR/a_11567_7751# vss sg13_lv_nmos ad=0.3473p pd=2.71u as=0.12665p ps=1.145u w=0.74u l=0.13u
X406 SAR/sg13cmos5l_dfrbp_1_22.Q_N SAR/a_17327_7285# vdd vdd sg13_lv_pmos ad=0.4312p pd=3.01u as=0.2639p ps=1.81u w=1.12u l=0.13u
X407 SAR/sg13cmos5l_dfrbp_1_17.Q_N SAR/a_3407_8797# vdd vdd sg13_lv_pmos ad=0.4312p pd=3.01u as=0.2639p ps=1.81u w=1.12u l=0.13u
X408 vdd SAR/a_15909_2399# SAR/a_16011_2399# vdd sg13_lv_pmos ad=1.86162p pd=11.935u as=0.3864p ps=2.93u w=1.12u l=0.13u
X409 SAR/a_16306_8874# SAR/sg13cmos5l_dfrbp_1_8.RESET_B vss vss sg13_lv_nmos ad=37.8f pd=0.6u as=79.8f ps=0.8u w=0.42u l=0.13u
X410 SAR/sg13cmos5l_dlhr_1_11.Q_N SAR/a_13686_7354# vss vss sg13_lv_nmos ad=0.2516p pd=2.16u as=0.1491p ps=1.18u w=0.74u l=0.13u
X411 SAR/sg13cmos5l_buf_1_31.X SAR/a_424_1664# vss vss sg13_lv_nmos ad=0.2886p pd=2.26u as=0.14875p ps=1.16u w=0.74u l=0.13u
X412 SAR/a_5069_5376# SAR/a_5799_5499# SAR/a_5710_5535# vdd sg13_lv_pmos ad=0.2048p pd=1.63u as=93.45f ps=0.865u w=0.42u l=0.13u
X413 SAR/a_3664_8678# SAR/a_3407_8797# SAR/a_3826_8874# vss sg13_lv_nmos ad=0.1428p pd=1.52u as=37.8f ps=0.6u w=0.42u l=0.13u
X414 SAR/a_11434_2356# SAR/a_11877_2399# SAR/a_11174_2826# vss sg13_lv_nmos ad=79.8f pd=0.8u as=0.1296p ps=1.52u w=0.42u l=0.13u
X415 vdd SAR/sg13cmos5l_dfrbp_1_8.RESET_B SAR/a_15590_4650# vdd sg13_lv_pmos ad=0.36237p pd=2.605u as=79.8f ps=0.8u w=0.42u l=0.13u
X416 SAR/sg13cmos5l_buf_1_3.A SAR/a_19528_6924# vss vss sg13_lv_nmos ad=0.2886p pd=2.26u as=0.14875p ps=1.16u w=0.74u l=0.13u
X417 vdd SAR/sg13cmos5l_dfrbp_1_6.D SAR/a_17399_3947# vdd sg13_lv_pmos ad=0.1428p pd=1.52u as=79.8f ps=0.8u w=0.42u l=0.13u
X418 vdd SAR/sg13cmos5l_buf_8_1.A SAR/a_18363_4270# vdd sg13_lv_pmos ad=0.2128p pd=1.5u as=0.3808p ps=2.92u w=1.12u l=0.13u
X419 SAR/a_1065_6971# SAR/a_708_6928# vdd vdd sg13_lv_pmos ad=63f pd=0.72u as=0.1563p ps=1.22u w=0.42u l=0.13u
X420 SAR/a_17700_1639# SAR/a_17412_1944# SAR/a_17638_1639# vss sg13_lv_nmos ad=0.1428p pd=1.52u as=37.8f ps=0.6u w=0.42u l=0.13u
X421 SAR/a_11986_7674# SAR/sg13cmos5l_dfrbp_1_6.RESET_B vss vss sg13_lv_nmos ad=37.8f pd=0.6u as=79.8f ps=0.8u w=0.42u l=0.13u
X422 SAR/a_7689_1626# SAR/a_7508_1948# vdd vdd sg13_lv_pmos ad=0.2128p pd=1.5u as=0.2387p ps=1.84u w=1.12u l=0.13u
X423 vdd SAR/sg13cmos5l_dfrbp_1_0.RESET_B SAR/a_11530_1849# vdd sg13_lv_pmos ad=0.1563p pd=1.22u as=0.147p ps=1.54u w=0.42u l=0.13u
X424 vdd SAR/a_3308_5376# SAR/sg13cmos5l_buf_1_41.A vdd sg13_lv_pmos ad=0.2114p pd=1.54u as=0.42p ps=2.99u w=1.12u l=0.13u
X425 SAR/a_16042_6892# SAR/a_16485_6935# SAR/a_16425_6971# vdd sg13_lv_pmos ad=79.8f pd=0.8u as=63f ps=0.72u w=0.42u l=0.13u
X426 SAR/a_12420_9199# SAR/a_12132_9504# SAR/a_12358_9199# vss sg13_lv_nmos ad=0.1428p pd=1.52u as=37.8f ps=0.6u w=0.42u l=0.13u
X427 vdd SAR/sg13cmos5l_dfrbp_1_6.RESET_B SAR/a_5674_6385# vdd sg13_lv_pmos ad=0.1563p pd=1.22u as=0.147p ps=1.54u w=0.42u l=0.13u
X428 vdd SAR/a_2565_8447# SAR/a_2667_8447# vdd sg13_lv_pmos ad=1.15047p pd=7.175u as=0.3864p ps=2.93u w=1.12u l=0.13u
X429 vdd SAR/a_18671_1703# SAR/a_19508_1924# vdd sg13_lv_pmos ad=0.2128p pd=1.5u as=0.3864p ps=2.93u w=1.12u l=0.13u
X430 SAR/sg13cmos5l_dlygate4sd2_1_0.X SAR/a_1290_3206# vdd vdd sg13_lv_pmos ad=0.3808p pd=2.92u as=0.2245p ps=1.53u w=1.12u l=0.13u
X431 vdd SAR/a_7055_4261# SAR/a_7312_4142# vdd sg13_lv_pmos ad=0.2639p pd=1.81u as=79.8f ps=0.8u w=0.42u l=0.13u
X432 SAR/a_4005_4629# SAR/sg13cmos5l_inv_1_8.A vdd vdd sg13_lv_pmos ad=0.4088p pd=2.97u as=1.2517p ps=7.955u w=1.12u l=0.13u
X433 SAR/a_934_5837# SAR/sg13cmos5l_dfrbp_1_6.RESET_B vss vss sg13_lv_nmos ad=37.8f pd=0.6u as=0.1701p ps=1.65u w=0.42u l=0.13u
X434 SAR/a_7378_6162# SAR/sg13cmos5l_dfrbp_1_6.RESET_B vss vss sg13_lv_nmos ad=37.8f pd=0.6u as=79.8f ps=0.8u w=0.42u l=0.13u
X435 vss SAR/sg13cmos5l_buf_1_35.A SAR/a_1864_1664# vss sg13_lv_nmos ad=0.14875p pd=1.16u as=0.187p ps=1.78u w=0.55u l=0.13u
X436 vss SAR/a_16528_7894# SAR/a_16177_7751# vss sg13_lv_nmos ad=79.8f pd=0.8u as=0.1428p ps=1.52u w=0.42u l=0.13u
X437 SAR/sg13cmos5l_buf_8_0.X SAR/a_19227_4654# vss vss sg13_lv_nmos ad=0.1406p pd=1.12u as=0.1406p ps=1.12u w=0.74u l=0.13u
X438 SAR/a_2596_7996# SAR/a_2621_7636# vdd vdd sg13_lv_pmos ad=0.2856p pd=2.36u as=1.15047p ps=7.175u w=0.84u l=0.13u
X439 SAR/sg13cmos5l_dfrbp_1_1.D SAR/sg13cmos5l_a22oi_1_2.B1 SAR/a_9823_2364# vdd sg13_lv_pmos ad=0.2128p pd=1.5u as=0.2716p ps=1.605u w=1.12u l=0.13u
X440 vdd SAR/a_13391_9263# SAR/a_14228_9484# vdd sg13_lv_pmos ad=0.2128p pd=1.5u as=0.3864p ps=2.93u w=1.12u l=0.13u
X441 vdd SAR/a_3599_3215# SAR/a_4436_3436# vdd sg13_lv_pmos ad=0.2128p pd=1.5u as=0.3864p ps=2.93u w=1.12u l=0.13u
X442 vss SAR/sg13cmos5l_or2_1_1.B SAR/a_11873_5760# vss sg13_lv_nmos ad=0.2516p pd=2.16u as=0.1406p ps=1.12u w=0.74u l=0.13u
X443 SAR/a_17337_4965# SAR/a_16395_4772# SAR/a_17135_4727# vdd sg13_lv_pmos ad=93.45f pd=0.865u as=0.2048p ps=1.63u w=0.42u l=0.13u
X444 vss SAR/sg13cmos5l_dfrbp_1_6.RESET_B SAR/a_9076_5800# vss sg13_lv_nmos ad=0.1406p pd=1.12u as=77.7f ps=0.95u w=0.74u l=0.13u
X445 SAR/sg13cmos5l_dlhr_1_17.Q_N SAR/a_9366_5842# vdd vdd sg13_lv_pmos ad=0.3808p pd=2.92u as=0.1974p ps=1.5u w=1.12u l=0.13u
X446 vss vdd vss vss sg13_lv_nmos ad=0.1428p pd=1.52u as=0 ps=0 w=0.42u l=1u
X447 vss vdd vss vss sg13_lv_nmos ad=79.8f pd=0.8u as=0 ps=0 w=0.42u l=1u
X448 SAR/a_6729_5041# SAR/a_6372_4968# vdd vdd sg13_lv_pmos ad=63f pd=0.72u as=0.1563p ps=1.22u w=0.42u l=0.13u
X449 SAR/a_16617_6553# SAR/a_16260_6480# vdd vdd sg13_lv_pmos ad=63f pd=0.72u as=0.1563p ps=1.22u w=0.42u l=0.13u
X450 vss SAR/a_9033_6162# SAR/a_8988_6198# vss sg13_lv_nmos ad=0.1428p pd=1.52u as=47.25f ps=0.645u w=0.42u l=0.13u
X451 SAR/sg13cmos5l_dlhr_1_1.Q_N SAR/a_2934_4632# vss vss sg13_lv_nmos ad=0.2516p pd=2.16u as=0.1491p ps=1.18u w=0.74u l=0.13u
X452 SAR/sg13cmos5l_dfrbp_1_4.D SAR/sg13cmos5l_nand2_1_1.B SAR/a_10707_2388# vdd sg13_lv_pmos ad=0.2408p pd=1.55u as=0.1428p ps=1.375u w=1.12u l=0.13u
X453 vdd comp_p SAR/a_424_1664# vdd sg13_lv_pmos ad=0.2114p pd=1.54u as=0.2856p ps=2.36u w=0.84u l=0.13u
X454 nh_sw[10] SAR/a_20392_3176# vss vss sg13_lv_nmos ad=0.2886p pd=2.26u as=0.14875p ps=1.16u w=0.74u l=0.13u
X455 SAR/sg13cmos5l_or2_1_0.A SAR/a_18363_4270# vss vss sg13_lv_nmos ad=0.1406p pd=1.12u as=0.1406p ps=1.12u w=0.74u l=0.13u
X456 SAR/a_17126_1626# SAR/a_17931_1748# SAR/a_17386_1849# vdd sg13_lv_pmos ad=0.1428p pd=1.52u as=79.8f ps=0.8u w=0.42u l=0.13u
X457 SAR/sg13cmos5l_dfrbp_1_18.Q SAR/a_8084_8436# vss vss sg13_lv_nmos ad=0.2516p pd=2.16u as=0.1406p ps=1.12u w=0.74u l=0.13u
X458 SAR/a_708_6928# SAR/a_1227_6935# SAR/a_1967_7285# vss sg13_lv_nmos ad=0.3473p pd=2.71u as=0.12665p ps=1.145u w=0.74u l=0.13u
X459 SAR/sg13cmos5l_dlhr_1_5.Q_N SAR/a_8982_7354# vss vss sg13_lv_nmos ad=0.2516p pd=2.16u as=0.1491p ps=1.18u w=0.74u l=0.13u
X460 SAR/a_2757_3117# SAR/sg13cmos5l_dfrbp_1_9.Q vss vss sg13_lv_nmos ad=0.2516p pd=2.16u as=2.59257p ps=16.445u w=0.74u l=0.13u
X461 SAR/a_9456_4972# SAR/a_8905_4704# vdd vdd sg13_lv_pmos ad=0.105p pd=1.21u as=1.28962p ps=8.195u w=1u l=0.13u
X462 vss SAR/sg13cmos5l_dfrbp_1_8.RESET_B SAR/a_1956_8874# vss sg13_lv_nmos ad=0.1626p pd=1.415u as=60.89999f ps=0.71u w=0.42u l=0.13u
X463 SAR/a_19028_5412# SAR/a_18746_5776# SAR/a_18961_5814# vss sg13_lv_nmos ad=0.141p pd=1.17u as=71.99999f ps=0.865u w=0.64u l=0.13u
X464 SAR/a_7524_7992# SAR/a_7498_7897# vss vss sg13_lv_nmos ad=0.2516p pd=2.16u as=0.1626p ps=1.415u w=0.74u l=0.13u
X465 SAR/a_17412_1944# SAR/a_17386_1849# vdd vdd sg13_lv_pmos ad=0.34p pd=2.68u as=0.36237p ps=2.605u w=1u l=0.13u
X466 SAR/a_9268_6148# SAR/a_8852_6484# SAR/a_9033_6162# vss sg13_lv_nmos ad=77.7f pd=0.95u as=0.2516p ps=2.16u w=0.74u l=0.13u
X467 vss SAR/a_18363_4270# SAR/sg13cmos5l_or2_1_0.A vss sg13_lv_nmos ad=0.1406p pd=1.12u as=0.1406p ps=1.12u w=0.74u l=0.13u
X468 SAR/a_11556_1944# SAR/a_11530_1849# vss vss sg13_lv_nmos ad=0.2516p pd=2.16u as=0.1626p ps=1.415u w=0.74u l=0.13u
X469 vdd SAR/a_19227_4654# SAR/sg13cmos5l_buf_8_0.X vdd sg13_lv_pmos ad=0.2128p pd=1.5u as=0.2128p ps=1.5u w=1.12u l=0.13u
X470 vss _cks SAR/sg13cmos5l_dfrbp_1_6.RESET_B vss sg13_lv_nmos ad=0.2516p pd=2.16u as=0.1443p ps=1.13u w=0.74u l=0.13u
X471 SAR/a_14708_6924# SAR/a_14295_7282# SAR/a_14640_6924# vdd sg13_lv_pmos ad=0.191p pd=1.44u as=0.105p ps=1.21u w=1u l=0.13u
X472 SAR/a_15718_2813# SAR/sg13cmos5l_dfrbp_1_0.RESET_B vss vss sg13_lv_nmos ad=37.8f pd=0.6u as=0.1701p ps=1.65u w=0.42u l=0.13u
X473 SAR/a_2340_3456# SAR/a_2314_3361# vdd vdd sg13_lv_pmos ad=0.34p pd=2.68u as=0.36237p ps=2.605u w=1u l=0.13u
X474 SAR/sg13cmos5l_buf_8_2.X SAR/a_19227_9190# vdd vdd sg13_lv_pmos ad=0.2128p pd=1.5u as=0.2128p ps=1.5u w=1.12u l=0.13u
X475 SAR/a_2386_7362# SAR/sg13cmos5l_dfrbp_1_6.RESET_B vss vss sg13_lv_nmos ad=37.8f pd=0.6u as=79.8f ps=0.8u w=0.42u l=0.13u
X476 vdd SAR/sg13cmos5l_buf_8_0.X SAR/a_20392_7712# vdd sg13_lv_pmos ad=0.2114p pd=1.54u as=0.2856p ps=2.36u w=0.84u l=0.13u
X477 SAR/a_2596_7996# SAR/a_2621_7636# vss vss sg13_lv_nmos ad=0.2775p pd=2.23u as=1.49685p ps=9.6u w=0.74u l=0.13u
X478 vss SAR/sg13cmos5l_buf_1_30.A SAR/a_8680_1664# vss sg13_lv_nmos ad=0.14875p pd=1.16u as=0.187p ps=1.78u w=0.55u l=0.13u
X479 SAR/a_17750_4325# SAR/a_16572_4261# SAR/a_17354_4180# vss sg13_lv_nmos ad=37.8f pd=0.6u as=0.1428p ps=1.52u w=0.42u l=0.13u
X480 SAR/a_16268_3102# SAR/sg13cmos5l_buf_1_2.X vss vss sg13_lv_nmos ad=0.187p pd=1.78u as=0.14875p ps=1.16u w=0.55u l=0.13u
X481 SAR/sg13cmos5l_dfrbp_1_23.Q_N SAR/a_13775_6239# vss vss sg13_lv_nmos ad=0.2849p pd=2.25u as=0.2516p ps=2.16u w=0.74u l=0.13u
X482 SAR/a_13284_3456# SAR/a_13258_3361# vss vss sg13_lv_nmos ad=0.2516p pd=2.16u as=0.1626p ps=1.415u w=0.74u l=0.13u
X483 vss SAR/sg13cmos5l_inv_1_29.A SAR/sg13cmos5l_inv_1_29.Y vss sg13_lv_nmos ad=0.2516p pd=2.16u as=0.2516p ps=2.16u w=0.74u l=0.13u
X484 SAR/a_2831_7630# SAR/sg13cmos5l_dfrbp_1_16.Q_N vdd vdd sg13_lv_pmos ad=0.2856p pd=2.36u as=1.15047p ps=7.175u w=0.84u l=0.13u
X485 vss SAR/sg13cmos5l_buf_1_3.A SAR/a_20296_1664# vss sg13_lv_nmos ad=0.14875p pd=1.16u as=0.187p ps=1.78u w=0.55u l=0.13u
X486 vdd SAR/sg13cmos5l_buf_1_41.X SAR/a_2824_2388# vdd sg13_lv_pmos ad=0.2114p pd=1.54u as=0.2856p ps=2.36u w=0.84u l=0.13u
X487 vss SAR/sg13cmos5l_buf_1_8.X SAR/a_11656_3176# vss sg13_lv_nmos ad=0.14875p pd=1.16u as=0.187p ps=1.78u w=0.55u l=0.13u
X488 SAR/a_19412_6484# SAR/a_19130_6172# SAR/a_19345_6154# vss sg13_lv_nmos ad=0.141p pd=1.17u as=71.99999f ps=0.865u w=0.64u l=0.13u
X489 SAR/a_16068_6162# SAR/sg13cmos5l_buf_1_57.X SAR/a_15974_6162# vss sg13_lv_nmos ad=60.89999f pd=0.71u as=0.1428p ps=1.52u w=0.42u l=0.13u
X490 vdd SAR/sg13cmos5l_buf_1_65.X SAR/a_8488_9224# vdd sg13_lv_pmos ad=0.2114p pd=1.54u as=0.2856p ps=2.36u w=0.84u l=0.13u
X491 vss SAR/sg13cmos5l_buf_1_76.X SAR/a_5416_9224# vss sg13_lv_nmos ad=0.14875p pd=1.16u as=0.187p ps=1.78u w=0.55u l=0.13u
X492 vdd SAR/sg13cmos5l_dfrbp_1_6.RESET_B SAR/a_9705_4650# vdd sg13_lv_pmos ad=0.2128p pd=1.5u as=0.2128p ps=1.5u w=1.12u l=0.13u
X493 vss SAR/a_15821_3864# SAR/sg13cmos5l_dfrbp_1_6.Q_N vss sg13_lv_nmos ad=0.2516p pd=2.16u as=0.2849p ps=2.25u w=0.74u l=0.13u
X494 SAR/a_9260_2352# SAR/sg13cmos5l_buf_1_30.X vss vss sg13_lv_nmos ad=0.187p pd=1.78u as=0.14875p ps=1.16u w=0.55u l=0.13u
X495 vdd SAR/sg13cmos5l_inv_1_19.A SAR/sg13cmos5l_buf_1_32.A vdd sg13_lv_pmos ad=0.3808p pd=2.92u as=0.3808p ps=2.92u w=1.12u l=0.13u
X496 vdd SAR/sg13cmos5l_dfrbp_1_6.RESET_B SAR/a_5510_4338# vdd sg13_lv_pmos ad=0.36237p pd=2.605u as=79.8f ps=0.8u w=0.42u l=0.13u
X497 vdd SAR/sg13cmos5l_buf_1_4.A SAR/sg13cmos5l_buf_1_110.A vdd sg13_lv_pmos ad=0.3808p pd=2.92u as=0.3808p ps=2.92u w=1.12u l=0.13u
X498 SAR/a_10292_9508# SAR/a_9879_9202# SAR/a_10224_9508# vdd sg13_lv_pmos ad=0.191p pd=1.44u as=0.105p ps=1.21u w=1u l=0.13u
X499 vss SAR/a_10031_8797# SAR/a_10868_8436# vss sg13_lv_nmos ad=0.1406p pd=1.12u as=0.2516p ps=2.16u w=0.74u l=0.13u
X500 vdd SAR/sg13cmos5l_buf_8_0.A SAR/a_19227_4654# vdd sg13_lv_pmos ad=0.2128p pd=1.5u as=0.3808p ps=2.92u w=1.12u l=0.13u
X501 vdd SAR/a_7631_4727# SAR/a_8468_4948# vdd sg13_lv_pmos ad=0.2128p pd=1.5u as=0.3864p ps=2.93u w=1.12u l=0.13u
X502 vdd SAR/sg13cmos5l_inv_1_3.A SAR/a_15016_9224# vdd sg13_lv_pmos ad=0.2114p pd=1.54u as=0.2856p ps=2.36u w=0.84u l=0.13u
X503 SAR/sg13cmos5l_dfrbp_1_8.RESET_B _cks vss vss sg13_lv_nmos ad=0.2516p pd=2.16u as=0.2516p ps=2.16u w=0.74u l=0.13u
X504 vss SAR/a_3212_1590# SAR/sg13cmos5l_buf_1_41.X vss sg13_lv_nmos ad=0.14875p pd=1.16u as=0.2886p ps=2.26u w=0.74u l=0.13u
X505 vss vdd vss vss sg13_lv_nmos ad=79.8f pd=0.8u as=0 ps=0 w=0.42u l=1u
X506 SAR/a_2148_3904# SAR/a_2122_3868# vdd vdd sg13_lv_pmos ad=0.34p pd=2.68u as=0.36237p ps=2.605u w=1u l=0.13u
X507 SAR/sg13cmos5l_buf_1_4.A SAR/a_15592_6200# vss vss sg13_lv_nmos ad=0.2886p pd=2.26u as=0.14875p ps=1.16u w=0.74u l=0.13u
X508 vss SAR/a_19227_9190# SAR/sg13cmos5l_buf_8_2.X vss sg13_lv_nmos ad=0.1406p pd=1.12u as=0.1406p ps=1.12u w=0.74u l=0.13u
X509 vdd vss vdd vdd sg13_lv_pmos ad=0.19p pd=1.38u as=0 ps=0 w=1u l=1u
X510 SAR/a_11460_2392# SAR/a_11434_2356# vss vss sg13_lv_nmos ad=0.2516p pd=2.16u as=0.1626p ps=1.415u w=0.74u l=0.13u
X511 SAR/a_2757_3117# SAR/sg13cmos5l_dfrbp_1_9.Q vdd vdd sg13_lv_pmos ad=0.4088p pd=2.97u as=1.38655p ps=8.8u w=1.12u l=0.13u
X512 SAR/a_14342_8874# SAR/sg13cmos5l_dfrbp_1_23.CLK vdd vdd sg13_lv_pmos ad=79.8f pd=0.8u as=0.1428p ps=1.52u w=0.42u l=0.13u
X513 SAR/sg13cmos5l_dlhr_1_17.Q_N SAR/a_9366_5842# vss vss sg13_lv_nmos ad=0.2516p pd=2.16u as=0.1491p ps=1.18u w=0.74u l=0.13u
X514 vdd SAR/a_5069_5376# SAR/sg13cmos5l_dfrbp_1_29.Q_N vdd sg13_lv_pmos ad=0.2639p pd=1.81u as=0.4312p ps=3.01u w=1.12u l=0.13u
X515 SAR/a_15238_7687# SAR/sg13cmos5l_dfrbp_1_6.RESET_B vss vss sg13_lv_nmos ad=37.8f pd=0.6u as=0.1701p ps=1.65u w=0.42u l=0.13u
X516 vss vdd vss vss sg13_lv_nmos ad=79.8f pd=0.8u as=0 ps=0 w=0.42u l=1u
X517 SAR/a_5820_5773# SAR/a_5951_5383# SAR/a_5069_5376# vdd sg13_lv_pmos ad=0.34p pd=2.68u as=0.2048p ps=1.63u w=1u l=0.13u
X518 SAR/a_8841_5769# SAR/a_8660_5412# vdd vdd sg13_lv_pmos ad=0.2128p pd=1.5u as=0.2387p ps=1.84u w=1.12u l=0.13u
X519 SAR/a_2732_9150# SAR/sg13cmos5l_inv_1_20.Y vss vss sg13_lv_nmos ad=0.187p pd=1.78u as=0.14875p ps=1.16u w=0.55u l=0.13u
X520 SAR/a_15206_2826# SAR/sg13cmos5l_nor2b_1_1.Y vdd vdd sg13_lv_pmos ad=79.8f pd=0.8u as=0.1428p ps=1.52u w=0.42u l=0.13u
X521 vdd SAR/sg13cmos5l_dfrbp_1_8.RESET_B SAR/a_2122_3868# vdd sg13_lv_pmos ad=0.1563p pd=1.22u as=0.147p ps=1.54u w=0.42u l=0.13u
X522 SAR/a_15012_7992# SAR/a_14986_7897# vss vss sg13_lv_nmos ad=0.2516p pd=2.16u as=0.1626p ps=1.415u w=0.74u l=0.13u
X523 vdd SAR/a_4041_2745# SAR/a_4566_2818# vdd sg13_lv_pmos ad=0.1974p pd=1.5u as=0.2856p ps=2.36u w=0.84u l=0.13u
X524 SAR/a_1125_5423# SAR/sg13cmos5l_dlhr_1_1.GATE vss vss sg13_lv_nmos ad=0.2516p pd=2.16u as=1.97045p ps=12.335u w=0.74u l=0.13u
X525 ph_sw[4] SAR/a_6568_9224# vss vss sg13_lv_nmos ad=0.2886p pd=2.26u as=0.14875p ps=1.16u w=0.74u l=0.13u
X526 vdd SAR/sg13cmos5l_nand2_1_1.B SAR/a_10464_2427# vdd sg13_lv_pmos ad=0.2891p pd=1.695u as=0.1596p ps=1.22u w=0.84u l=0.13u
X527 SAR/a_11913_3947# SAR/a_11556_3904# vdd vdd sg13_lv_pmos ad=63f pd=0.72u as=0.1563p ps=1.22u w=0.42u l=0.13u
X528 vdd SAR/a_3831_7282# SAR/a_3962_7288# vdd sg13_lv_pmos ad=1.07253p pd=6.75u as=0.2856p ps=2.36u w=0.84u l=0.13u
X529 SAR/a_13574_8112# SAR/a_13178_7684# SAR/a_13460_7996# vdd sg13_lv_pmos ad=0.1008p pd=0.9u as=0.191p ps=1.44u w=0.42u l=0.13u
X530 SAR/a_1878_6337# SAR/a_1997_6126# vdd vdd sg13_lv_pmos ad=0.3864p pd=2.93u as=0.2128p ps=1.5u w=1.12u l=0.13u
X531 SAR/a_13418_4696# SAR/sg13cmos5l_nor2_1_0.A SAR/a_13324_4696# vss sg13_lv_nmos ad=0.1216p pd=1.02u as=0.2176p ps=1.96u w=0.64u l=0.13u
X532 SAR/a_6372_4968# SAR/a_6346_4873# vdd vdd sg13_lv_pmos ad=0.34p pd=2.68u as=0.36237p ps=2.605u w=1u l=0.13u
X533 vss _cks SAR/sg13cmos5l_dfrbp_1_6.RESET_B vss sg13_lv_nmos ad=0.1406p pd=1.12u as=0.1406p ps=1.12u w=0.74u l=0.13u
X534 vss _cks SAR/a_19227_9190# vss sg13_lv_nmos ad=0.1406p pd=1.12u as=0.2553p ps=2.17u w=0.74u l=0.13u
X535 vdd SAR/sg13cmos5l_dfrbp_1_12.Q_N SAR/a_8905_4704# vdd sg13_lv_pmos ad=1.28962p pd=8.195u as=0.2856p ps=2.36u w=0.84u l=0.13u
X536 SAR/a_1484_6126# SAR/sg13cmos5l_buf_1_58.A vdd vdd sg13_lv_pmos ad=0.2856p pd=2.36u as=0.2114p ps=1.54u w=0.84u l=0.13u
X537 SAR/sg13cmos5l_dlhr_1_2.Q SAR/a_7497_3138# vdd vdd sg13_lv_pmos ad=0.3808p pd=2.92u as=0.2128p ps=1.5u w=1.12u l=0.13u
X538 SAR/sg13cmos5l_buf_8_2.X SAR/a_19227_9190# vdd vdd sg13_lv_pmos ad=0.2128p pd=1.5u as=0.2128p ps=1.5u w=1.12u l=0.13u
X539 vss SAR/a_2409_4650# SAR/a_2934_4632# vss sg13_lv_nmos ad=0.1491p pd=1.18u as=0.187p ps=1.78u w=0.55u l=0.13u
X540 SAR/a_18860_6888# SAR/sg13cmos5l_buf_1_87.A vss vss sg13_lv_nmos ad=0.187p pd=1.78u as=0.14875p ps=1.16u w=0.55u l=0.13u
X541 vss SAR/a_19244_2352# nl_sw[9] vss sg13_lv_nmos ad=0.14875p pd=1.16u as=0.2886p ps=2.26u w=0.74u l=0.13u
X542 vss vdd vss vss sg13_lv_nmos ad=0.1428p pd=1.52u as=0 ps=0 w=0.42u l=1u
X543 SAR/a_5508_6162# SAR/sg13cmos5l_dfrbp_1_6.D SAR/a_5414_6162# vss sg13_lv_nmos ad=60.89999f pd=0.71u as=0.1428p ps=1.52u w=0.42u l=0.13u
X544 SAR/sg13cmos5l_dfrbp_1_6.RESET_B _cks vdd vdd sg13_lv_pmos ad=0.2128p pd=1.5u as=0.2128p ps=1.5u w=1.12u l=0.13u
X545 vdd SAR/a_3407_4261# SAR/a_4244_3900# vdd sg13_lv_pmos ad=0.2128p pd=1.5u as=0.3864p ps=2.93u w=1.12u l=0.13u
X546 vss SAR/sg13cmos5l_or2_1_0.A SAR/a_18480_5028# vss sg13_lv_nmos ad=0.1469p pd=1.155u as=0.1045p ps=0.93u w=0.55u l=0.13u
X547 vss SAR/a_5637_2399# SAR/a_5739_2399# vss sg13_lv_nmos ad=2.59257p pd=16.445u as=0.2516p ps=2.16u w=0.74u l=0.13u
X548 SAR/a_7508_1948# SAR/a_7226_1636# SAR/a_7441_1618# vss sg13_lv_nmos ad=0.141p pd=1.17u as=71.99999f ps=0.865u w=0.64u l=0.13u
X549 vss SAR/a_3664_8678# SAR/a_3313_8797# vss sg13_lv_nmos ad=79.8f pd=0.8u as=0.1428p ps=1.52u w=0.42u l=0.13u
X550 vdd SAR/a_13076_5376# SAR/a_13034_5412# vdd sg13_lv_pmos ad=0.2618p pd=1.63u as=0.1176p ps=1.33u w=1.12u l=0.13u
X551 vdd SAR/a_16268_1590# nl_sw[7] vdd sg13_lv_pmos ad=0.2114p pd=1.54u as=0.42p ps=2.99u w=1.12u l=0.13u
X552 vdd SAR/sg13cmos5l_dfrbp_1_0.RESET_B SAR/a_11270_1626# vdd sg13_lv_pmos ad=0.36237p pd=2.605u as=79.8f ps=0.8u w=0.42u l=0.13u
X553 SAR/sg13cmos5l_dfrbp_1_10.Q_N SAR/a_3599_3215# vss vss sg13_lv_nmos ad=0.2849p pd=2.25u as=0.2516p ps=2.16u w=0.74u l=0.13u
X554 SAR/a_3588_4968# SAR/a_4107_4772# SAR/a_4847_4727# vss sg13_lv_nmos ad=0.3473p pd=2.71u as=0.12665p ps=1.145u w=0.74u l=0.13u
X555 SAR/a_14929_5814# SAR/a_14377_5770# vss vss sg13_lv_nmos ad=71.99999f pd=0.865u as=1.97045p ps=12.335u w=0.64u l=0.13u
X556 vdd SAR/a_10665_7281# SAR/a_11190_7354# vdd sg13_lv_pmos ad=0.1974p pd=1.5u as=0.2856p ps=2.36u w=0.84u l=0.13u
X557 SAR/a_3792_2388# SAR/a_3241_2746# vdd vdd sg13_lv_pmos ad=0.105p pd=1.21u as=1.86162p ps=11.935u w=1u l=0.13u
X558 vdd SAR/a_17132_9150# ph_sw[7] vdd sg13_lv_pmos ad=0.2114p pd=1.54u as=0.42p ps=2.99u w=1.12u l=0.13u
X559 vdd SAR/sg13cmos5l_inv_1_17.A SAR/sg13cmos5l_buf_1_37.A vdd sg13_lv_pmos ad=0.3808p pd=2.92u as=0.3808p ps=2.92u w=1.12u l=0.13u
X560 SAR/a_18959_3215# SAR/a_18117_3117# SAR/a_18865_3215# vss sg13_lv_nmos ad=0.12665p pd=1.145u as=0.1428p ps=1.52u w=0.42u l=0.13u
X561 SAR/a_6188_1590# SAR/sg13cmos5l_buf_1_25.A vdd vdd sg13_lv_pmos ad=0.2856p pd=2.36u as=0.2114p ps=1.54u w=0.84u l=0.13u
X562 nh_sw[2] SAR/a_3688_1664# vss vss sg13_lv_nmos ad=0.2886p pd=2.26u as=0.14875p ps=1.16u w=0.74u l=0.13u
X563 SAR/sg13cmos5l_dfrbp_1_2.Q_N SAR/a_12815_4261# vss vss sg13_lv_nmos ad=0.2849p pd=2.25u as=0.2516p ps=2.16u w=0.74u l=0.13u
X564 SAR/a_6789_4629# SAR/sg13cmos5l_inv_1_8.A vdd vdd sg13_lv_pmos ad=0.4088p pd=2.97u as=1.2517p ps=7.955u w=1.12u l=0.13u
X565 SAR/a_708_5416# SAR/a_682_5380# vss vss sg13_lv_nmos ad=0.2516p pd=2.16u as=0.1626p ps=1.415u w=0.74u l=0.13u
X566 vdd SAR/sg13cmos5l_buf_1_105.A SAR/a_18856_8436# vdd sg13_lv_pmos ad=0.2114p pd=1.54u as=0.2856p ps=2.36u w=0.84u l=0.13u
X567 SAR/a_15876_4968# SAR/a_15850_4873# vdd vdd sg13_lv_pmos ad=0.34p pd=2.68u as=0.36237p ps=2.605u w=1u l=0.13u
X568 ph_sw[3] SAR/a_5416_9224# vdd vdd sg13_lv_pmos ad=0.42p pd=2.99u as=0.2114p ps=1.54u w=1.12u l=0.13u
X569 SAR/a_19227_9190# _cks vdd vdd sg13_lv_pmos ad=0.2128p pd=1.5u as=0.2128p ps=1.5u w=1.12u l=0.13u
X570 vdd SAR/sg13cmos5l_dfrbp_1_0.RESET_B SAR/a_11174_2826# vdd sg13_lv_pmos ad=0.36237p pd=2.605u as=79.8f ps=0.8u w=0.42u l=0.13u
X571 SAR/a_16298_4338# SAR/a_15821_3864# SAR/a_16204_4338# vss sg13_lv_nmos ad=37.8f pd=0.6u as=0.1428p ps=1.52u w=0.42u l=0.13u
X572 SAR/sg13cmos5l_dfrbp_1_23.Q SAR/a_14612_6460# vss vss sg13_lv_nmos ad=0.2516p pd=2.16u as=0.1406p ps=1.12u w=0.74u l=0.13u
X573 SAR/a_14800_3358# SAR/a_14543_3215# SAR/a_14962_3138# vss sg13_lv_nmos ad=0.1428p pd=1.52u as=37.8f ps=0.6u w=0.42u l=0.13u
X574 SAR/sg13cmos5l_buf_1_8.A SAR/sg13cmos5l_inv_1_7.A vss vss sg13_lv_nmos ad=0.2516p pd=2.16u as=0.2516p ps=2.16u w=0.74u l=0.13u
X575 SAR/sg13cmos5l_dfrbp_1_0.Q_N SAR/a_18671_1703# vss vss sg13_lv_nmos ad=0.2849p pd=2.25u as=0.2516p ps=2.16u w=0.74u l=0.13u
X576 vss SAR/sg13cmos5l_inv_1_28.Y SAR/a_11464_9224# vss sg13_lv_nmos ad=0.14875p pd=1.16u as=0.187p ps=1.78u w=0.55u l=0.13u
X577 SAR/a_19142_5412# SAR/a_18746_5776# SAR/a_19028_5412# vdd sg13_lv_pmos ad=0.1008p pd=0.9u as=0.191p ps=1.44u w=0.42u l=0.13u
X578 vdd SAR/a_4076_5376# SAR/sg13cmos5l_inv_1_17.A vdd sg13_lv_pmos ad=0.2114p pd=1.54u as=0.42p ps=2.99u w=1.12u l=0.13u
X579 SAR/sg13cmos5l_dfrbp_1_24.Q_N SAR/a_13391_9263# vss vss sg13_lv_nmos ad=0.2849p pd=2.25u as=0.2516p ps=2.16u w=0.74u l=0.13u
X580 SAR/a_8580_8874# SAR/sg13cmos5l_dfrbp_1_18.Q SAR/a_8486_8874# vss sg13_lv_nmos ad=60.89999f pd=0.71u as=0.1428p ps=1.52u w=0.42u l=0.13u
X581 vss SAR/a_11567_7751# SAR/a_12404_7972# vss sg13_lv_nmos ad=0.1406p pd=1.12u as=0.2516p ps=2.16u w=0.74u l=0.13u
X582 vdd SAR/a_10028_6126# SAR/sg13cmos5l_inv_1_18.A vdd sg13_lv_pmos ad=0.2114p pd=1.54u as=0.42p ps=2.99u w=1.12u l=0.13u
X583 SAR/a_5770_3868# SAR/a_6213_3911# SAR/a_5510_4338# vss sg13_lv_nmos ad=79.8f pd=0.8u as=0.1296p ps=1.52u w=0.42u l=0.13u
X584 vdd SAR/sg13cmos5l_dfrbp_1_6.RESET_B SAR/a_16204_4338# vdd sg13_lv_pmos ad=1.38655p pd=8.8u as=79.8f ps=0.8u w=0.42u l=0.13u
X585 SAR/a_18959_3215# SAR/a_18117_3117# SAR/a_17700_3456# vdd sg13_lv_pmos ad=0.2048p pd=1.63u as=0.34p ps=2.68u w=1u l=0.13u
X586 SAR/a_2306_7660# SAR/sg13cmos5l_dfrbp_1_6.RESET_B vss vss sg13_lv_nmos ad=77.7f pd=0.95u as=0.1406p ps=1.12u w=0.74u l=0.13u
X587 SAR/sg13cmos5l_buf_1_98.A SAR/a_13641_7674# vss vss sg13_lv_nmos ad=0.2516p pd=2.16u as=0.1406p ps=1.12u w=0.74u l=0.13u
X588 SAR/a_16473_7989# SAR/a_15531_7796# SAR/a_16271_7751# vdd sg13_lv_pmos ad=93.45f pd=0.865u as=0.2048p ps=1.63u w=0.42u l=0.13u
X589 vdd SAR/sg13cmos5l_buf_1_24.X SAR/a_5704_1664# vdd sg13_lv_pmos ad=0.2114p pd=1.54u as=0.2856p ps=2.36u w=0.84u l=0.13u
X590 SAR/a_2348_7624# SAR/a_2621_7636# SAR/a_2583_7710# vss sg13_lv_nmos ad=0.141p pd=1.17u as=47.25f ps=0.645u w=0.42u l=0.13u
X591 SAR/sg13cmos5l_dlhr_1_6.Q_N SAR/a_9558_6144# vdd vdd sg13_lv_pmos ad=0.3808p pd=2.92u as=0.1974p ps=1.5u w=1.12u l=0.13u
X592 SAR/a_17493_3947# SAR/a_16551_3987# SAR/a_17399_3947# vdd sg13_lv_pmos ad=79.8f pd=0.8u as=0.1428p ps=1.52u w=0.42u l=0.13u
X593 vdd SAR/a_1967_5773# SAR/a_2804_5412# vdd sg13_lv_pmos ad=0.2128p pd=1.5u as=0.3864p ps=2.93u w=1.12u l=0.13u
X594 SAR/sg13cmos5l_or2_1_0.A SAR/a_18363_4270# vdd vdd sg13_lv_pmos ad=0.2128p pd=1.5u as=0.2128p ps=1.5u w=1.12u l=0.13u
X595 vss SAR/a_524_4614# ckc vss sg13_lv_nmos ad=0.14875p pd=1.16u as=0.2886p ps=2.26u w=0.74u l=0.13u
X596 vss SAR/a_13641_7674# SAR/a_13596_7710# vss sg13_lv_nmos ad=0.1428p pd=1.52u as=47.25f ps=0.645u w=0.42u l=0.13u
X597 vss SAR/sg13cmos5l_dfrbp_1_8.RESET_B SAR/a_15876_7362# vss sg13_lv_nmos ad=0.1626p pd=1.415u as=60.89999f ps=0.71u w=0.42u l=0.13u
X598 SAR/a_13396_7312# SAR/a_12980_6924# SAR/a_13161_7281# vss sg13_lv_nmos ad=77.7f pd=0.95u as=0.2516p ps=2.16u w=0.74u l=0.13u
X599 vdd SAR/a_17008_2630# SAR/a_16953_2511# vdd sg13_lv_pmos ad=1.86162p pd=11.935u as=93.45f ps=0.865u w=0.42u l=0.13u
X600 vdd vss vdd vdd sg13_lv_pmos ad=0.34p pd=2.68u as=0 ps=0 w=1u l=1u
X601 vdd SAR/sg13cmos5l_buf_1_61.X SAR/a_1000_9224# vdd sg13_lv_pmos ad=0.2114p pd=1.54u as=0.2856p ps=2.36u w=0.84u l=0.13u
X602 SAR/a_15887_8797# SAR/a_15045_8447# SAR/a_14628_8440# vdd sg13_lv_pmos ad=0.2048p pd=1.63u as=0.34p ps=2.68u w=1u l=0.13u
X603 SAR/a_6741_5459# SAR/sg13cmos5l_dfrbp_1_8.RESET_B vdd vdd sg13_lv_pmos ad=0.147p pd=1.54u as=0.1563p ps=1.22u w=0.42u l=0.13u
X604 vss SAR/a_7941_7653# SAR/a_8043_7796# vss sg13_lv_nmos ad=1.49685p pd=9.6u as=0.2516p ps=2.16u w=0.74u l=0.13u
X605 SAR/a_4172_1590# SAR/sg13cmos5l_buf_1_38.A vdd vdd sg13_lv_pmos ad=0.2856p pd=2.36u as=0.2114p ps=1.54u w=0.84u l=0.13u
X606 SAR/a_13076_5376# SAR/sg13cmos5l_inv_1_0.A vss vss sg13_lv_nmos ad=0.187p pd=1.78u as=0.17255p ps=1.25u w=0.55u l=0.13u
X607 SAR/a_9060_8861# SAR/a_8772_8440# SAR/a_8998_8861# vss sg13_lv_nmos ad=0.1428p pd=1.52u as=37.8f ps=0.6u w=0.42u l=0.13u
X608 vdd SAR/sg13cmos5l_dfrbp_1_6.RESET_B SAR/a_17961_8793# vdd sg13_lv_pmos ad=0.2128p pd=1.5u as=0.2128p ps=1.5u w=1.12u l=0.13u
X609 vdd SAR/a_18363_4270# SAR/sg13cmos5l_or2_1_0.A vdd sg13_lv_pmos ad=0.2128p pd=1.5u as=0.2128p ps=1.5u w=1.12u l=0.13u
X610 SAR/a_17132_9150# SAR/sg13cmos5l_buf_1_94.X vdd vdd sg13_lv_pmos ad=0.2856p pd=2.36u as=0.2114p ps=1.54u w=0.84u l=0.13u
X611 vdd SAR/a_18928_1846# SAR/a_18873_1941# vdd sg13_lv_pmos ad=1.86162p pd=11.935u as=93.45f ps=0.865u w=0.42u l=0.13u
X612 SAR/sg13cmos5l_dfrbp_1_16.Q_N SAR/a_1967_7285# vdd vdd sg13_lv_pmos ad=0.4312p pd=3.01u as=0.2639p ps=1.81u w=1.12u l=0.13u
X613 SAR/a_2565_3911# SAR/sg13cmos5l_inv_1_8.A vss vss sg13_lv_nmos ad=0.2516p pd=2.16u as=2.27517p ps=14.72u w=0.74u l=0.13u
X614 SAR/sg13cmos5l_buf_1_107.X SAR/a_17896_9224# vss vss sg13_lv_nmos ad=0.2886p pd=2.26u as=0.14875p ps=1.16u w=0.74u l=0.13u
X615 vdd SAR/a_17961_8793# SAR/a_17894_8436# vdd sg13_lv_pmos ad=0.2387p pd=1.84u as=0.1008p ps=0.9u w=0.42u l=0.13u
X616 vdd SAR/a_13100_8400# pl_sw[6] vdd sg13_lv_pmos ad=0.2114p pd=1.54u as=0.42p ps=2.99u w=1.12u l=0.13u
X617 vss SAR/sg13cmos5l_dfrbp_1_6.RESET_B SAR/a_19828_6148# vss sg13_lv_nmos ad=0.1406p pd=1.12u as=77.7f ps=0.95u w=0.74u l=0.13u
X618 SAR/a_12216_5728# SAR/sg13cmos5l_or2_1_1.B SAR/a_12358_5388# vdd sg13_lv_pmos ad=0.2856p pd=2.36u as=0.1596p ps=1.22u w=0.84u l=0.13u
X619 vdd SAR/sg13cmos5l_dfrbp_1_6.RESET_B SAR/a_422_5850# vdd sg13_lv_pmos ad=0.36237p pd=2.605u as=79.8f ps=0.8u w=0.42u l=0.13u
X620 SAR/a_13460_7996# SAR/a_13047_7690# SAR/a_13392_7996# vdd sg13_lv_pmos ad=0.191p pd=1.44u as=0.105p ps=1.21u w=1u l=0.13u
X621 vdd SAR/a_2409_4650# SAR/a_2342_5088# vdd sg13_lv_pmos ad=0.2387p pd=1.84u as=0.1008p ps=0.9u w=0.42u l=0.13u
X622 SAR/a_15974_6162# SAR/a_16779_6284# SAR/a_16234_6385# vdd sg13_lv_pmos ad=0.1428p pd=1.52u as=79.8f ps=0.8u w=0.42u l=0.13u
X623 SAR/a_7257_4023# SAR/a_6315_3911# SAR/a_7055_4261# vdd sg13_lv_pmos ad=93.45f pd=0.865u as=0.2048p ps=1.63u w=0.42u l=0.13u
X624 SAR/a_13648_9406# SAR/sg13cmos5l_dfrbp_1_8.RESET_B vdd vdd sg13_lv_pmos ad=79.8f pd=0.8u as=4.11675p ps=27.17u w=0.42u l=0.13u
X625 vdd SAR/a_11567_7751# SAR/a_11824_7894# vdd sg13_lv_pmos ad=0.2639p pd=1.81u as=79.8f ps=0.8u w=0.42u l=0.13u
X626 SAR/a_10071_7282# SAR/sg13cmos5l_dfrbp_1_18.Q vdd vdd sg13_lv_pmos ad=0.3234p pd=2.45u as=1.07253p ps=6.75u w=0.84u l=0.13u
X627 vdd SAR/sg13cmos5l_buf_1_33.A SAR/a_2248_1664# vdd sg13_lv_pmos ad=0.2114p pd=1.54u as=0.2856p ps=2.36u w=0.84u l=0.13u
X628 vss vdd vss vss sg13_lv_nmos ad=79.8f pd=0.8u as=0 ps=0 w=0.42u l=1u
X629 vdd SAR/a_14032_6382# SAR/a_13977_6477# vdd sg13_lv_pmos ad=1.07253p pd=6.75u as=93.45f ps=0.865u w=0.42u l=0.13u
X630 SAR/sg13cmos5l_buf_1_8.X SAR/a_10888_1664# vss vss sg13_lv_nmos ad=0.2886p pd=2.26u as=0.14875p ps=1.16u w=0.74u l=0.13u
X631 vdd SAR/a_9033_6162# SAR/a_9558_6144# vdd sg13_lv_pmos ad=0.1974p pd=1.5u as=0.2856p ps=2.36u w=0.84u l=0.13u
X632 SAR/a_682_6892# SAR/a_1125_6935# SAR/a_1065_6971# vdd sg13_lv_pmos ad=79.8f pd=0.8u as=63f ps=0.72u w=0.42u l=0.13u
X633 SAR/a_15884_3102# SAR/sg13cmos5l_buf_1_5.X vss vss sg13_lv_nmos ad=0.187p pd=1.78u as=0.14875p ps=1.16u w=0.55u l=0.13u
X634 SAR/a_15110_5412# SAR/a_14714_5776# SAR/a_14996_5412# vdd sg13_lv_pmos ad=0.1008p pd=0.9u as=0.191p ps=1.44u w=0.42u l=0.13u
X635 vdd SAR/sg13cmos5l_dfrbp_1_6.RESET_B SAR/a_15974_6162# vdd sg13_lv_pmos ad=0.36237p pd=2.605u as=79.8f ps=0.8u w=0.42u l=0.13u
X636 vss SAR/a_3692_9150# SAR/sg13cmos5l_buf_1_62.X vss sg13_lv_nmos ad=0.14875p pd=1.16u as=0.2886p ps=2.26u w=0.74u l=0.13u
X637 SAR/a_8772_8440# SAR/a_9291_8447# SAR/a_10031_8797# vss sg13_lv_nmos ad=0.3473p pd=2.71u as=0.12665p ps=1.145u w=0.74u l=0.13u
X638 SAR/a_7238_7674# SAR/sg13cmos5l_dfrbp_1_6.D vdd vdd sg13_lv_pmos ad=79.8f pd=0.8u as=0.1428p ps=1.52u w=0.42u l=0.13u
X639 SAR/a_6346_4873# SAR/a_6789_4629# SAR/a_6729_5041# vdd sg13_lv_pmos ad=79.8f pd=0.8u as=63f ps=0.72u w=0.42u l=0.13u
X640 vdd SAR/sg13cmos5l_buf_8_1.A SAR/a_16703_3871# vdd sg13_lv_pmos ad=1.43437p pd=9.105u as=0.4088p ps=2.97u w=1.12u l=0.13u
X641 vss SAR/a_5673_3138# SAR/a_5628_3174# vss sg13_lv_nmos ad=0.1428p pd=1.52u as=47.25f ps=0.645u w=0.42u l=0.13u
X642 SAR/sg13cmos5l_buf_1_90.X SAR/a_11464_9224# vdd vdd sg13_lv_pmos ad=0.42p pd=2.99u as=0.2114p ps=1.54u w=1.12u l=0.13u
X643 SAR/a_13641_7674# SAR/a_13460_7996# vdd vdd sg13_lv_pmos ad=0.2128p pd=1.5u as=0.2387p ps=1.84u w=1.12u l=0.13u
X644 SAR/sg13cmos5l_nor2b_1_1.Y SAR/a_14254_2444# vss vss sg13_lv_nmos ad=0.1406p pd=1.12u as=0.17255p ps=1.25u w=0.74u l=0.13u
X645 _d2 SAR/a_20392_3900# vss vss sg13_lv_nmos ad=0.2886p pd=2.26u as=0.14875p ps=1.16u w=0.74u l=0.13u
X646 SAR/a_12719_2749# SAR/a_11877_2399# SAR/a_11460_2392# vdd sg13_lv_pmos ad=0.2048p pd=1.63u as=0.34p ps=2.68u w=1u l=0.13u
X647 SAR/a_12976_2630# SAR/sg13cmos5l_dfrbp_1_0.RESET_B vdd vdd sg13_lv_pmos ad=79.8f pd=0.8u as=1.777p ps=11.395u w=0.42u l=0.13u
X648 SAR/a_10726_5760# SAR/sg13cmos5l_dfrbp_1_20.Q SAR/sg13cmos5l_a22oi_1_2.B2 vss sg13_lv_nmos ad=0.1406p pd=1.12u as=0.2516p ps=2.16u w=0.74u l=0.13u
X649 SAR/sg13cmos5l_buf_1_65.X SAR/a_424_8436# vdd vdd sg13_lv_pmos ad=0.42p pd=2.99u as=0.2114p ps=1.54u w=1.12u l=0.13u
X650 SAR/a_8439_6178# SAR/sg13cmos5l_dlhr_1_5.GATE vdd vdd sg13_lv_pmos ad=0.3234p pd=2.45u as=1.04815p ps=6.595u w=0.84u l=0.13u
X651 vss vdd vss vss sg13_lv_nmos ad=0.1428p pd=1.52u as=0 ps=0 w=0.42u l=1u
X652 vdd SAR/a_7941_7653# SAR/a_8043_7796# vdd sg13_lv_pmos ad=1.15047p pd=7.175u as=0.3864p ps=2.93u w=1.12u l=0.13u
X653 SAR/a_16293_4629# SAR/sg13cmos5l_inv_1_2.A vss vss sg13_lv_nmos ad=0.2516p pd=2.16u as=2.41737p ps=15.64u w=0.74u l=0.13u
X654 SAR/a_9638_5088# SAR/a_9242_4660# SAR/a_9524_4972# vdd sg13_lv_pmos ad=0.1008p pd=0.9u as=0.191p ps=1.44u w=0.42u l=0.13u
X655 vss SAR/sg13cmos5l_inv_1_1.A SAR/a_16264_9224# vss sg13_lv_nmos ad=0.14875p pd=1.16u as=0.187p ps=1.78u w=0.55u l=0.13u
X656 SAR/a_5908_3124# SAR/a_5492_3460# SAR/a_5673_3138# vss sg13_lv_nmos ad=77.7f pd=0.95u as=0.2516p ps=2.16u w=0.74u l=0.13u
X657 SAR/a_9033_6162# SAR/a_8852_6484# vdd vdd sg13_lv_pmos ad=0.2128p pd=1.5u as=0.2387p ps=1.84u w=1.12u l=0.13u
X658 SAR/sg13cmos5l_dfrbp_1_17.D SAR/a_1662_8374# vdd vdd sg13_lv_pmos ad=0.3927p pd=2.99u as=1.15047p ps=7.175u w=1.155u l=0.13u
X659 SAR/sg13cmos5l_dfrbp_1_15.D SAR/a_4244_8436# vss vss sg13_lv_nmos ad=0.2516p pd=2.16u as=0.1406p ps=1.12u w=0.74u l=0.13u
X660 vdd vss vdd vdd sg13_lv_pmos ad=0.34p pd=2.68u as=0 ps=0 w=1u l=1u
X661 SAR/a_6405_8447# SAR/sg13cmos5l_inv_1_8.A vss vss sg13_lv_nmos ad=0.2516p pd=2.16u as=2.71505p ps=17.54u w=0.74u l=0.13u
X662 vdd SAR/a_16485_6935# SAR/a_16587_6935# vdd sg13_lv_pmos ad=1.07253p pd=6.75u as=0.3864p ps=2.93u w=1.12u l=0.13u
X663 SAR/sg13cmos5l_dlhr_1_0.Q SAR/a_7689_1626# vdd vdd sg13_lv_pmos ad=0.3808p pd=2.92u as=0.2128p ps=1.5u w=1.12u l=0.13u
X664 SAR/a_8204_9150# SAR/sg13cmos5l_buf_1_45.X vss vss sg13_lv_nmos ad=0.187p pd=1.78u as=0.14875p ps=1.16u w=0.55u l=0.13u
X665 vdd SAR/a_20012_1590# SAR/sg13cmos5l_buf_1_0.X vdd sg13_lv_pmos ad=0.2114p pd=1.54u as=0.42p ps=2.99u w=1.12u l=0.13u
X666 SAR/a_10288_8678# SAR/sg13cmos5l_dfrbp_1_8.RESET_B vdd vdd sg13_lv_pmos ad=79.8f pd=0.8u as=1.12242p ps=7u w=0.42u l=0.13u
X667 vss SAR/sg13cmos5l_dlhr_1_12.D SAR/a_17161_8794# vss sg13_lv_nmos ad=0.15055p pd=1.17u as=0.187p ps=1.78u w=0.55u l=0.13u
X668 SAR/a_7316_3460# SAR/a_6903_3154# SAR/a_7248_3460# vdd sg13_lv_pmos ad=0.191p pd=1.44u as=0.105p ps=1.21u w=1u l=0.13u
X669 vdd SAR/a_7888_4870# SAR/a_7833_4965# vdd sg13_lv_pmos ad=1.28962p pd=8.195u as=93.45f ps=0.865u w=0.42u l=0.13u
X670 vss SAR/sg13cmos5l_a221oi_1_1.C1 SAR/sg13cmos5l_a22oi_1_2.B2 vss sg13_lv_nmos ad=0.1406p pd=1.12u as=0.2516p ps=2.16u w=0.74u l=0.13u
X671 SAR/a_9060_8861# SAR/a_9291_8447# SAR/a_8746_8404# vss sg13_lv_nmos ad=0.2373p pd=1.97u as=79.8f ps=0.8u w=0.42u l=0.13u
X672 vss SAR/sg13cmos5l_buf_1_34.A SAR/a_4840_1664# vss sg13_lv_nmos ad=0.14875p pd=1.16u as=0.187p ps=1.78u w=0.55u l=0.13u
X673 vdd SAR/a_12815_1703# SAR/a_13652_1924# vdd sg13_lv_pmos ad=0.2128p pd=1.5u as=0.3864p ps=2.93u w=1.12u l=0.13u
X674 vss SAR/a_1158_3142# SAR/a_1290_3206# vss sg13_lv_nmos ad=0.1405p pd=1.15u as=0.2163p ps=1.87u w=0.42u l=0.18u
X675 SAR/sg13cmos5l_dfrbp_1_20.Q_N SAR/a_8783_7751# vdd vdd sg13_lv_pmos ad=0.4312p pd=3.01u as=0.2639p ps=1.81u w=1.12u l=0.13u
X676 SAR/a_6903_3154# SAR/sg13cmos5l_dlhr_1_0.GATE vss vss sg13_lv_nmos ad=0.2516p pd=2.16u as=0.15055p ps=1.17u w=0.74u l=0.13u
X677 SAR/sg13cmos5l_dfrbp_1_25.Q_N SAR/a_15887_8797# vdd vdd sg13_lv_pmos ad=0.4312p pd=3.01u as=0.2639p ps=1.81u w=1.12u l=0.13u
X678 SAR/a_2638_6162# SAR/a_2879_6432# SAR/a_1997_6126# vss sg13_lv_nmos ad=0.1428p pd=1.52u as=0.12665p ps=1.145u w=0.42u l=0.13u
X679 vss SAR/a_4425_7281# SAR/a_4380_7326# vss sg13_lv_nmos ad=0.1428p pd=1.52u as=47.25f ps=0.645u w=0.42u l=0.13u
X680 SAR/a_6372_4968# SAR/a_6891_4772# SAR/a_7631_4727# vss sg13_lv_nmos ad=0.3473p pd=2.71u as=0.12665p ps=1.145u w=0.74u l=0.13u
X681 vss vdd vss vss sg13_lv_nmos ad=0.1428p pd=1.52u as=0 ps=0 w=0.42u l=1u
X682 vdd SAR/sg13cmos5l_buf_1_5.A SAR/a_14440_1664# vdd sg13_lv_pmos ad=0.2114p pd=1.54u as=0.2856p ps=2.36u w=0.84u l=0.13u
X683 vdd SAR/a_5132_3864# SAR/sg13cmos5l_buf_1_44.X vdd sg13_lv_pmos ad=0.2114p pd=1.54u as=0.42p ps=2.99u w=1.12u l=0.13u
X684 vdd vss vdd vdd sg13_lv_pmos ad=0.34p pd=2.68u as=0 ps=0 w=1u l=1u
X685 SAR/a_10900_7312# SAR/a_10484_6924# SAR/a_10665_7281# vss sg13_lv_nmos ad=77.7f pd=0.95u as=0.2516p ps=2.16u w=0.74u l=0.13u
X686 SAR/a_10331_3900# SAR/sg13cmos5l_nand2_1_1.B SAR/sg13cmos5l_a22oi_1_1.B1 vdd sg13_lv_pmos ad=0.2128p pd=1.5u as=0.3808p ps=2.92u w=1.12u l=0.13u
X687 vdd SAR/sg13cmos5l_dfrbp_1_6.RESET_B SAR/a_5414_6162# vdd sg13_lv_pmos ad=0.36237p pd=2.605u as=79.8f ps=0.8u w=0.42u l=0.13u
X688 SAR/sg13cmos5l_dfrbp_1_16.Q SAR/a_2804_6924# vdd vdd sg13_lv_pmos ad=0.3808p pd=2.92u as=0.2128p ps=1.5u w=1.12u l=0.13u
X689 SAR/a_9076_5800# SAR/a_8660_5412# SAR/a_8841_5769# vss sg13_lv_nmos ad=77.7f pd=0.95u as=0.2516p ps=2.16u w=0.74u l=0.13u
X690 SAR/a_14726_7674# SAR/sg13cmos5l_buf_1_57.X vdd vdd sg13_lv_pmos ad=79.8f pd=0.8u as=0.1428p ps=1.52u w=0.42u l=0.13u
X691 SAR/a_16233_5041# SAR/a_15876_4968# vdd vdd sg13_lv_pmos ad=63f pd=0.72u as=0.1563p ps=1.22u w=0.42u l=0.13u
X692 SAR/a_5220_2392# SAR/a_5739_2399# SAR/a_6479_2749# vss sg13_lv_nmos ad=0.3473p pd=2.71u as=0.12665p ps=1.145u w=0.74u l=0.13u
X693 SAR/a_14602_8404# SAR/a_15045_8447# SAR/a_14985_8483# vdd sg13_lv_pmos ad=79.8f pd=0.8u as=63f ps=0.72u w=0.42u l=0.13u
X694 SAR/a_11556_1944# SAR/a_11530_1849# vdd vdd sg13_lv_pmos ad=0.34p pd=2.68u as=0.36237p ps=2.605u w=1u l=0.13u
X695 vdd SAR/sg13cmos5l_dfrbp_1_6.RESET_B SAR/a_5673_3138# vdd sg13_lv_pmos ad=0.2128p pd=1.5u as=0.2128p ps=1.5u w=1.12u l=0.13u
X696 SAR/a_19628_2352# SAR/sg13cmos5l_buf_1_19.X vss vss sg13_lv_nmos ad=0.187p pd=1.78u as=0.14875p ps=1.16u w=0.55u l=0.13u
X697 vdd SAR/sg13cmos5l_inv_1_29.A SAR/sg13cmos5l_inv_1_29.Y vdd sg13_lv_pmos ad=0.3808p pd=2.92u as=0.3808p ps=2.92u w=1.12u l=0.13u
X698 SAR/sg13cmos5l_buf_1_40.X SAR/a_1192_1664# vdd vdd sg13_lv_pmos ad=0.42p pd=2.99u as=0.2114p ps=1.54u w=1.12u l=0.13u
X699 vdd SAR/sg13cmos5l_buf_1_104.A SAR/a_19624_8436# vdd sg13_lv_pmos ad=0.2114p pd=1.54u as=0.2856p ps=2.36u w=0.84u l=0.13u
X700 SAR/sg13cmos5l_buf_1_18.X SAR/a_18376_2388# vss vss sg13_lv_nmos ad=0.2886p pd=2.26u as=0.14875p ps=1.16u w=0.74u l=0.13u
X701 SAR/a_17399_3947# SAR/a_16703_3871# SAR/a_17493_3947# vss sg13_lv_nmos ad=0.1296p pd=1.52u as=79.8f ps=0.8u w=0.42u l=0.13u
X702 SAR/sg13cmos5l_nand2_1_0.A SAR/sg13cmos5l_dfrbp_1_0.Q vss vss sg13_lv_nmos ad=0.1406p pd=1.12u as=0.2516p ps=2.16u w=0.74u l=0.13u
X703 vss SAR/sg13cmos5l_o21ai_1_0.A1 SAR/a_12022_3134# vss sg13_lv_nmos ad=0.1406p pd=1.12u as=0.2516p ps=2.16u w=0.74u l=0.15u
X704 SAR/sg13cmos5l_dfrbp_1_8.D SAR/a_18164_6924# vdd vdd sg13_lv_pmos ad=0.3808p pd=2.92u as=0.2128p ps=1.5u w=1.12u l=0.13u
X705 vdd SAR/sg13cmos5l_dfrbp_1_6.RESET_B SAR/a_5194_2356# vdd sg13_lv_pmos ad=0.1563p pd=1.22u as=0.147p ps=1.54u w=0.42u l=0.13u
X706 SAR/a_17700_3456# SAR/a_17674_3361# vss vss sg13_lv_nmos ad=0.2516p pd=2.16u as=0.1626p ps=1.415u w=0.74u l=0.13u
X707 SAR/sg13cmos5l_dlhr_1_19.Q_N SAR/a_15702_5842# vdd vdd sg13_lv_pmos ad=0.3808p pd=2.92u as=0.1974p ps=1.5u w=1.12u l=0.13u
X708 SAR/sg13cmos5l_dfrbp_1_4.Q_N SAR/a_12719_2749# vdd vdd sg13_lv_pmos ad=0.4312p pd=3.01u as=0.2639p ps=1.81u w=1.12u l=0.13u
X709 SAR/a_1580_2352# SAR/sg13cmos5l_buf_1_40.X vdd vdd sg13_lv_pmos ad=0.2856p pd=2.36u as=0.2114p ps=1.54u w=0.84u l=0.13u
X710 vss SAR/sg13cmos5l_dfrbp_1_6.RESET_B SAR/a_7332_7674# vss sg13_lv_nmos ad=0.1626p pd=1.415u as=60.89999f ps=0.71u w=0.42u l=0.13u
X711 SAR/sg13cmos5l_buf_1_101.X SAR/a_16264_9224# vdd vdd sg13_lv_pmos ad=0.42p pd=2.99u as=0.2114p ps=1.54u w=1.12u l=0.13u
X712 vss vdd vss vss sg13_lv_nmos ad=0.1428p pd=1.52u as=0 ps=0 w=0.42u l=1u
X713 SAR/a_19209_5769# SAR/a_19028_5412# vdd vdd sg13_lv_pmos ad=0.2128p pd=1.5u as=0.2387p ps=1.84u w=1.12u l=0.13u
X714 SAR/a_7452_3174# SAR/a_6903_3154# SAR/a_7316_3460# vss sg13_lv_nmos ad=47.25f pd=0.645u as=0.141p ps=1.17u w=0.42u l=0.13u
X715 vss SAR/a_4847_4727# SAR/a_5684_4948# vss sg13_lv_nmos ad=0.1406p pd=1.12u as=0.2516p ps=2.16u w=0.74u l=0.13u
X716 vss SAR/a_14800_3358# SAR/a_14449_3215# vss sg13_lv_nmos ad=79.8f pd=0.8u as=0.1428p ps=1.52u w=0.42u l=0.13u
X717 vdd SAR/a_12216_5728# SAR/sg13cmos5l_a221oi_1_0.B1 vdd sg13_lv_pmos ad=0.2226p pd=1.535u as=0.3976p ps=2.95u w=1.12u l=0.13u
X718 SAR/a_11844_1639# SAR/a_12075_1748# SAR/a_11530_1849# vss sg13_lv_nmos ad=0.2373p pd=1.97u as=79.8f ps=0.8u w=0.42u l=0.13u
X719 SAR/a_2148_3904# SAR/a_2667_3911# SAR/a_3407_4261# vss sg13_lv_nmos ad=0.3473p pd=2.71u as=0.12665p ps=1.145u w=0.74u l=0.13u
X720 SAR/a_18960_5412# SAR/a_18409_5770# vdd vdd sg13_lv_pmos ad=0.105p pd=1.21u as=1.28962p ps=8.195u w=1u l=0.13u
X721 SAR/a_19345_6154# SAR/a_18793_6216# vss vss sg13_lv_nmos ad=71.99999f pd=0.865u as=1.97045p ps=12.335u w=0.64u l=0.13u
X722 vss vdd vss vss sg13_lv_nmos ad=0.1428p pd=1.52u as=0 ps=0 w=0.42u l=1u
X723 SAR/a_11530_3868# SAR/a_11973_3911# SAR/a_11913_3947# vdd sg13_lv_pmos ad=79.8f pd=0.8u as=63f ps=0.72u w=0.42u l=0.13u
X724 vdd SAR/a_8204_2352# SAR/sg13cmos5l_buf_1_24.A vdd sg13_lv_pmos ad=0.2114p pd=1.54u as=0.42p ps=2.99u w=1.12u l=0.13u
X725 SAR/a_6057_6553# SAR/a_5700_6480# vdd vdd sg13_lv_pmos ad=63f pd=0.72u as=0.1563p ps=1.22u w=0.42u l=0.13u
X726 vss SAR/a_13161_7281# SAR/a_13686_7354# vss sg13_lv_nmos ad=0.1491p pd=1.18u as=0.187p ps=1.78u w=0.55u l=0.13u
X727 SAR/sg13cmos5l_nor2_1_1.A SAR/a_17588_2388# vdd vdd sg13_lv_pmos ad=0.3808p pd=2.92u as=0.2128p ps=1.5u w=1.12u l=0.13u
X728 vdd SAR/a_9705_4650# SAR/a_10230_4632# vdd sg13_lv_pmos ad=0.1974p pd=1.5u as=0.2856p ps=2.36u w=0.84u l=0.13u
X729 SAR/a_16548_6175# SAR/a_16260_6480# SAR/a_16486_6175# vss sg13_lv_nmos ad=0.1428p pd=1.52u as=37.8f ps=0.6u w=0.42u l=0.13u
X730 vss SAR/sg13cmos5l_dfrbp_1_0.RESET_B SAR/a_15300_2826# vss sg13_lv_nmos ad=0.1626p pd=1.415u as=60.89999f ps=0.71u w=0.42u l=0.13u
X731 SAR/a_3447_2746# SAR/sg13cmos5l_dfrbp_1_9.Q vdd vdd sg13_lv_pmos ad=0.3234p pd=2.45u as=1.86162p ps=11.935u w=0.84u l=0.13u
X732 SAR/a_2436_8861# SAR/a_2667_8447# SAR/a_2122_8404# vss sg13_lv_nmos ad=0.2373p pd=1.97u as=79.8f ps=0.8u w=0.42u l=0.13u
X733 vdd SAR/sg13cmos5l_buf_1_4.A SAR/a_16552_1664# vdd sg13_lv_pmos ad=0.2114p pd=1.54u as=0.2856p ps=2.36u w=0.84u l=0.13u
X734 vdd SAR/a_17367_8794# SAR/a_17498_8800# vdd sg13_lv_pmos ad=1.15047p pd=7.175u as=0.2856p ps=2.36u w=0.84u l=0.13u
X735 SAR/a_620_2352# SAR/sg13cmos5l_buf_1_32.X vdd vdd sg13_lv_pmos ad=0.2856p pd=2.36u as=0.2114p ps=1.54u w=0.84u l=0.13u
X736 SAR/a_18146_4338# SAR/sg13cmos5l_dfrbp_1_6.RESET_B vss vss sg13_lv_nmos ad=60.89999f pd=0.71u as=0.1626p ps=1.415u w=0.42u l=0.13u
X737 SAR/a_3669_6320# SAR/a_2727_6380# SAR/a_3575_6553# vdd sg13_lv_pmos ad=79.8f pd=0.8u as=0.1428p ps=1.52u w=0.42u l=0.13u
X738 SAR/a_12815_4261# SAR/a_11973_3911# SAR/a_12721_4261# vss sg13_lv_nmos ad=0.12665p pd=1.145u as=0.1428p ps=1.52u w=0.42u l=0.13u
X739 vss SAR/sg13cmos5l_buf_1_60.X SAR/a_2248_9224# vss sg13_lv_nmos ad=0.14875p pd=1.16u as=0.187p ps=1.78u w=0.55u l=0.13u
X740 vdd vss vdd vdd sg13_lv_pmos ad=0.19p pd=1.38u as=0 ps=0 w=1u l=1u
X741 SAR/a_10308_7992# SAR/a_10282_7897# vss vss sg13_lv_nmos ad=0.2516p pd=2.16u as=0.1626p ps=1.415u w=0.74u l=0.13u
X742 ph_sw[1] SAR/a_1864_9224# vss vss sg13_lv_nmos ad=0.2886p pd=2.26u as=0.14875p ps=1.16u w=0.74u l=0.13u
X743 SAR/a_18671_1703# SAR/a_17829_1605# SAR/a_18577_1703# vss sg13_lv_nmos ad=0.12665p pd=1.145u as=0.1428p ps=1.52u w=0.42u l=0.13u
X744 SAR/a_6741_5459# SAR/a_5799_5499# SAR/a_6602_5692# vss sg13_lv_nmos ad=79.8f pd=0.8u as=0.2373p ps=1.97u w=0.42u l=0.13u
X745 vdd SAR/a_17519_6239# SAR/a_18356_6460# vdd sg13_lv_pmos ad=0.2128p pd=1.5u as=0.3864p ps=2.93u w=1.12u l=0.13u
X746 vdd SAR/a_1196_8400# SAR/sg13cmos5l_buf_1_63.X vdd sg13_lv_pmos ad=0.2114p pd=1.54u as=0.42p ps=2.99u w=1.12u l=0.13u
X747 SAR/a_17780_8436# SAR/a_17498_8800# SAR/a_17713_8838# vss sg13_lv_nmos ad=0.141p pd=1.17u as=71.99999f ps=0.865u w=0.64u l=0.13u
X748 vss SAR/a_3676_7964# SAR/sg13cmos5l_dlhr_1_9.Q vss sg13_lv_nmos ad=0.1406p pd=1.12u as=0.2516p ps=2.16u w=0.74u l=0.13u
X749 SAR/sg13cmos5l_dfrbp_1_20.Q SAR/a_9620_7972# vdd vdd sg13_lv_pmos ad=0.3808p pd=2.92u as=0.2128p ps=1.5u w=1.12u l=0.13u
X750 SAR/sg13cmos5l_dfrbp_1_22.D SAR/a_16724_8436# vdd vdd sg13_lv_pmos ad=0.3808p pd=2.92u as=0.2128p ps=1.5u w=1.12u l=0.13u
X751 SAR/a_3676_7964# SAR/a_4076_7624# SAR/a_4034_7660# vss sg13_lv_nmos ad=0.2516p pd=2.16u as=77.7f ps=0.95u w=0.74u l=0.13u
X752 SAR/a_13391_9263# SAR/a_12549_9165# SAR/a_13297_9263# vss sg13_lv_nmos ad=0.12665p pd=1.145u as=0.1428p ps=1.52u w=0.42u l=0.13u
X753 vss SAR/sg13cmos5l_inv_1_26.Y SAR/a_17896_9224# vss sg13_lv_nmos ad=0.14875p pd=1.16u as=0.187p ps=1.78u w=0.55u l=0.13u
X754 SAR/a_18615_5770# SAR/sg13cmos5l_dfrbp_1_8.D vdd vdd sg13_lv_pmos ad=0.3234p pd=2.45u as=1.28962p ps=8.195u w=0.84u l=0.13u
X755 SAR/a_1862_4338# SAR/a_2667_3911# SAR/a_2122_3868# vdd sg13_lv_pmos ad=0.1428p pd=1.52u as=79.8f ps=0.8u w=0.42u l=0.13u
X756 vss SAR/a_8588_3864# SAR/sg13cmos5l_buf_1_30.A vss sg13_lv_nmos ad=0.14875p pd=1.16u as=0.2886p ps=2.26u w=0.74u l=0.13u
X757 SAR/a_16677_6141# SAR/sg13cmos5l_dfrbp_1_8.D vss vss sg13_lv_nmos ad=0.2516p pd=2.16u as=1.97045p ps=12.335u w=0.74u l=0.13u
X758 vdd SAR/a_12549_9165# SAR/a_12651_9308# vdd sg13_lv_pmos ad=4.11675p pd=27.17u as=0.3864p ps=2.93u w=1.12u l=0.13u
X759 vss SAR/a_17961_8793# SAR/a_17916_8838# vss sg13_lv_nmos ad=0.1428p pd=1.52u as=47.25f ps=0.645u w=0.42u l=0.13u
X760 nl_sw[1] SAR/a_1864_1664# vdd vdd sg13_lv_pmos ad=0.42p pd=2.99u as=0.2114p ps=1.54u w=1.12u l=0.13u
X761 vss SAR/sg13cmos5l_dfrbp_1_6.RESET_B SAR/a_15124_7312# vss sg13_lv_nmos ad=0.1406p pd=1.12u as=77.7f ps=0.95u w=0.74u l=0.13u
X762 SAR/a_18671_1703# SAR/a_17829_1605# SAR/a_17412_1944# vdd sg13_lv_pmos ad=0.2048p pd=1.63u as=0.34p ps=2.68u w=1u l=0.13u
X763 SAR/a_10783_4292# SAR/sg13cmos5l_a22oi_1_0.B1 vss vss sg13_lv_nmos ad=0.13875p pd=1.115u as=0.2553p ps=2.17u w=0.74u l=0.13u
X764 SAR/a_8276_6924# SAR/a_7863_7282# SAR/a_8208_6924# vdd sg13_lv_pmos ad=0.191p pd=1.44u as=0.105p ps=1.21u w=1u l=0.13u
X765 SAR/a_13572_3151# SAR/a_13284_3456# SAR/a_13510_3151# vss sg13_lv_nmos ad=0.1428p pd=1.52u as=37.8f ps=0.6u w=0.42u l=0.13u
X766 SAR/a_20204_5376# SAR/sg13cmos5l_dlhr_1_16.Q vss vss sg13_lv_nmos ad=0.187p pd=1.78u as=0.14875p ps=1.16u w=0.55u l=0.13u
X767 SAR/a_3609_8559# SAR/a_2667_8447# SAR/a_3407_8797# vdd sg13_lv_pmos ad=93.45f pd=0.865u as=0.2048p ps=1.63u w=0.42u l=0.13u
X768 vdd SAR/a_4847_4727# SAR/a_5104_4870# vdd sg13_lv_pmos ad=0.2639p pd=1.81u as=79.8f ps=0.8u w=0.42u l=0.13u
X769 SAR/sg13cmos5l_dfrbp_1_6.RESET_B _cks vdd vdd sg13_lv_pmos ad=0.2128p pd=1.5u as=0.2128p ps=1.5u w=1.12u l=0.13u
X770 vdd SAR/sg13cmos5l_buf_1_35.A SAR/a_1864_1664# vdd sg13_lv_pmos ad=0.2114p pd=1.54u as=0.2856p ps=2.36u w=0.84u l=0.13u
X771 SAR/a_3664_4142# SAR/sg13cmos5l_dfrbp_1_8.RESET_B vdd vdd sg13_lv_pmos ad=79.8f pd=0.8u as=1.43437p ps=9.105u w=0.42u l=0.13u
X772 SAR/sg13cmos5l_dlhr_1_19.Q_N SAR/a_15702_5842# vss vss sg13_lv_nmos ad=0.2516p pd=2.16u as=0.1491p ps=1.18u w=0.74u l=0.13u
X773 SAR/a_15132_5814# SAR/a_14583_5770# SAR/a_14996_5412# vss sg13_lv_nmos ad=47.25f pd=0.645u as=0.141p ps=1.17u w=0.42u l=0.13u
X774 SAR/sg13cmos5l_buf_1_95.X SAR/a_12232_8436# vdd vdd sg13_lv_pmos ad=0.42p pd=2.99u as=0.2114p ps=1.54u w=1.12u l=0.13u
X775 SAR/a_16260_6480# SAR/a_16234_6385# vdd vdd sg13_lv_pmos ad=0.34p pd=2.68u as=0.36237p ps=2.605u w=1u l=0.13u
X776 SAR/a_9189_8447# SAR/sg13cmos5l_inv_1_2.A vss vss sg13_lv_nmos ad=0.2516p pd=2.16u as=2.71505p ps=17.54u w=0.74u l=0.13u
X777 SAR/a_3599_3215# SAR/a_2757_3117# SAR/a_2340_3456# vdd sg13_lv_pmos ad=0.2048p pd=1.63u as=0.34p ps=2.68u w=1u l=0.13u
X778 SAR/a_8785_6154# SAR/a_8233_6216# vss vss sg13_lv_nmos ad=71.99999f pd=0.865u as=1.97045p ps=12.335u w=0.64u l=0.13u
X779 vss SAR/sg13cmos5l_buf_8_0.X SAR/a_20392_7712# vss sg13_lv_nmos ad=0.14875p pd=1.16u as=0.187p ps=1.78u w=0.55u l=0.13u
X780 SAR/sg13cmos5l_dfrbp_1_1.Q_N SAR/a_12815_1703# vss vss sg13_lv_nmos ad=0.2849p pd=2.25u as=0.2516p ps=2.16u w=0.74u l=0.13u
X781 SAR/a_15177_5769# SAR/a_14996_5412# vdd vdd sg13_lv_pmos ad=0.2128p pd=1.5u as=0.2387p ps=1.84u w=1.12u l=0.13u
X782 SAR/a_17776_6382# SAR/sg13cmos5l_dfrbp_1_6.RESET_B vdd vdd sg13_lv_pmos ad=79.8f pd=0.8u as=1.04815p ps=6.595u w=0.42u l=0.13u
X783 vdd SAR/a_12933_6141# SAR/a_13035_6284# vdd sg13_lv_pmos ad=1.07253p pd=6.75u as=0.3864p ps=2.93u w=1.12u l=0.13u
X784 SAR/a_5577_2435# SAR/a_5220_2392# vdd vdd sg13_lv_pmos ad=63f pd=0.72u as=0.1563p ps=1.22u w=0.42u l=0.13u
X785 vdd SAR/a_3669_6320# SAR/a_2748_6126# vdd sg13_lv_pmos ad=0.36237p pd=2.605u as=0.34p ps=2.68u w=1u l=0.13u
X786 SAR/a_3692_9150# SAR/sg13cmos5l_inv_1_17.A vss vss sg13_lv_nmos ad=0.187p pd=1.78u as=0.14875p ps=1.16u w=0.55u l=0.13u
X787 vss SAR/sg13cmos5l_dfrbp_1_21.Q_N SAR/a_18793_6216# vss sg13_lv_nmos ad=0.15055p pd=1.17u as=0.187p ps=1.78u w=0.55u l=0.13u
X788 vdd SAR/a_2348_7624# SAR/a_1948_7964# vdd sg13_lv_pmos ad=0.2387p pd=1.84u as=0.2128p ps=1.5u w=1.12u l=0.13u
X789 SAR/a_1210_4654# SAR/sg13cmos5l_inv_1_8.Y SAR/sg13cmos5l_dlygate4sd2_1_0.A vss sg13_lv_nmos ad=0.1406p pd=1.12u as=0.2516p ps=2.16u w=0.74u l=0.13u
X790 SAR/a_5988_6175# SAR/a_5700_6480# SAR/a_5926_6175# vss sg13_lv_nmos ad=0.1428p pd=1.52u as=37.8f ps=0.6u w=0.42u l=0.13u
X791 vdd SAR/a_9164_1590# SAR/sg13cmos5l_buf_1_26.X vdd sg13_lv_pmos ad=0.2114p pd=1.54u as=0.42p ps=2.99u w=1.12u l=0.13u
X792 SAR/sg13cmos5l_dfrbp_1_3.Q_N SAR/a_18959_3215# vdd vdd sg13_lv_pmos ad=0.4312p pd=3.01u as=0.2639p ps=1.81u w=1.12u l=0.13u
X793 SAR/a_8972_9150# SAR/sg13cmos5l_buf_1_77.A vss vss sg13_lv_nmos ad=0.187p pd=1.78u as=0.14875p ps=1.16u w=0.55u l=0.13u
X794 SAR/a_5799_5499# SAR/a_5951_5383# vss vss sg13_lv_nmos ad=0.2516p pd=2.16u as=1.97045p ps=12.335u w=0.74u l=0.13u
X795 vdd SAR/a_6959_6239# SAR/a_7796_6460# vdd sg13_lv_pmos ad=0.2128p pd=1.5u as=0.3864p ps=2.93u w=1.12u l=0.13u
X796 vdd SAR/a_2732_9150# SAR/sg13cmos5l_buf_1_61.X vdd sg13_lv_pmos ad=0.2114p pd=1.54u as=0.42p ps=2.99u w=1.12u l=0.13u
X797 SAR/sg13cmos5l_nor2b_1_0.Y SAR/sg13cmos5l_inv_1_0.A SAR/a_13036_4948# vdd sg13_lv_pmos ad=0.3808p pd=2.92u as=0.1176p ps=1.33u w=1.12u l=0.13u
X798 SAR/a_7820_9150# SAR/sg13cmos5l_buf_1_73.A vss vss sg13_lv_nmos ad=0.187p pd=1.78u as=0.14875p ps=1.16u w=0.55u l=0.13u
X799 vdd vss vdd vdd sg13_lv_pmos ad=0.19p pd=1.38u as=0 ps=0 w=1u l=1u
X800 SAR/a_10707_2388# SAR/sg13cmos5l_nor2_1_0.A vdd vdd sg13_lv_pmos ad=0.1428p pd=1.375u as=0.2891p ps=1.695u w=1.12u l=0.13u
X801 SAR/sg13cmos5l_dfrbp_1_11.Q SAR/a_8468_4948# vss vss sg13_lv_nmos ad=0.2516p pd=2.16u as=0.1406p ps=1.12u w=0.74u l=0.13u
X802 SAR/a_7631_4727# SAR/a_6789_4629# SAR/a_7537_4727# vss sg13_lv_nmos ad=0.12665p pd=1.145u as=0.1428p ps=1.52u w=0.42u l=0.13u
X803 SAR/a_3407_4261# SAR/a_2565_3911# SAR/a_3313_4261# vss sg13_lv_nmos ad=0.12665p pd=1.145u as=0.1428p ps=1.52u w=0.42u l=0.13u
X804 vdd SAR/sg13cmos5l_buf_1_30.A SAR/a_8680_1664# vdd sg13_lv_pmos ad=0.2114p pd=1.54u as=0.2856p ps=2.36u w=0.84u l=0.13u
X805 SAR/a_5492_3460# SAR/a_5079_3154# SAR/a_5424_3460# vdd sg13_lv_pmos ad=0.191p pd=1.44u as=0.105p ps=1.21u w=1u l=0.13u
X806 SAR/a_7863_7282# SAR/sg13cmos5l_dlhr_1_5.GATE vss vss sg13_lv_nmos ad=0.2516p pd=2.16u as=0.15055p ps=1.17u w=0.74u l=0.13u
X807 SAR/a_14800_3358# SAR/sg13cmos5l_dfrbp_1_0.RESET_B vdd vdd sg13_lv_pmos ad=79.8f pd=0.8u as=1.38655p ps=8.8u w=0.42u l=0.13u
X808 pl_sw[2] SAR/a_2248_9224# vdd vdd sg13_lv_pmos ad=0.42p pd=2.99u as=0.2114p ps=1.54u w=1.12u l=0.13u
X809 SAR/a_2148_8440# SAR/a_2122_8404# vss vss sg13_lv_nmos ad=0.2516p pd=2.16u as=0.1626p ps=1.415u w=0.74u l=0.13u
X810 SAR/a_6117_6141# SAR/sg13cmos5l_dlhr_1_5.GATE vss vss sg13_lv_nmos ad=0.2516p pd=2.16u as=1.97045p ps=12.335u w=0.74u l=0.13u
X811 SAR/a_16268_3102# SAR/sg13cmos5l_buf_1_2.X vdd vdd sg13_lv_pmos ad=0.2856p pd=2.36u as=0.2114p ps=1.54u w=0.84u l=0.13u
X812 SAR/sg13cmos5l_buf_1_1.A SAR/a_14056_1664# vdd vdd sg13_lv_pmos ad=0.42p pd=2.99u as=0.2114p ps=1.54u w=1.12u l=0.13u
X813 vdd SAR/sg13cmos5l_dfrbp_1_8.RESET_B SAR/a_16042_6892# vdd sg13_lv_pmos ad=0.1563p pd=1.22u as=0.147p ps=1.54u w=0.42u l=0.13u
X814 SAR/a_14583_5770# SAR/sg13cmos5l_dfrbp_1_23.CLK vdd vdd sg13_lv_pmos ad=0.3234p pd=2.45u as=1.28962p ps=8.195u w=0.84u l=0.13u
X815 vdd SAR/a_3599_3215# SAR/a_3856_3358# vdd sg13_lv_pmos ad=0.2639p pd=1.81u as=79.8f ps=0.8u w=0.42u l=0.13u
X816 vdd SAR/sg13cmos5l_buf_1_3.A SAR/a_20296_1664# vdd sg13_lv_pmos ad=0.2114p pd=1.54u as=0.2856p ps=2.36u w=0.84u l=0.13u
X817 vdd SAR/sg13cmos5l_buf_1_8.X SAR/a_11656_3176# vdd sg13_lv_pmos ad=0.2114p pd=1.54u as=0.2856p ps=2.36u w=0.84u l=0.13u
X818 vdd SAR/a_1815_4666# SAR/a_1946_4660# vdd sg13_lv_pmos ad=1.28962p pd=8.195u as=0.2856p ps=2.36u w=0.84u l=0.13u
X819 vdd SAR/sg13cmos5l_nand2_1_2.B SAR/sg13cmos5l_dlygate4sd2_1_0.A vdd sg13_lv_pmos ad=0.3808p pd=2.92u as=0.2128p ps=1.5u w=1.12u l=0.13u
X820 vdd SAR/a_908_1590# SAR/sg13cmos5l_buf_1_32.X vdd sg13_lv_pmos ad=0.2114p pd=1.54u as=0.42p ps=2.99u w=1.12u l=0.13u
X821 SAR/a_15492_2392# SAR/a_15466_2356# vdd vdd sg13_lv_pmos ad=0.34p pd=2.68u as=0.36237p ps=2.605u w=1u l=0.13u
X822 vdd SAR/sg13cmos5l_buf_1_76.X SAR/a_5416_9224# vdd sg13_lv_pmos ad=0.2114p pd=1.54u as=0.2856p ps=2.36u w=0.84u l=0.13u
X823 SAR/sg13cmos5l_dlhr_1_5.Q SAR/a_8457_7281# vss vss sg13_lv_nmos ad=0.2516p pd=2.16u as=0.1406p ps=1.12u w=0.74u l=0.13u
X824 SAR/a_3831_7282# SAR/sg13cmos5l_dfrbp_1_15.D vdd vdd sg13_lv_pmos ad=0.3234p pd=2.45u as=1.04815p ps=6.595u w=0.84u l=0.13u
X825 vss SAR/a_8841_5769# SAR/a_9366_5842# vss sg13_lv_nmos ad=0.1491p pd=1.18u as=0.187p ps=1.78u w=0.55u l=0.13u
X826 SAR/sg13cmos5l_dlhr_1_13.Q_N SAR/a_15414_7354# vss vss sg13_lv_nmos ad=0.2516p pd=2.16u as=0.1491p ps=1.18u w=0.74u l=0.13u
X827 SAR/a_11782_4325# SAR/sg13cmos5l_dfrbp_1_0.RESET_B vss vss sg13_lv_nmos ad=37.8f pd=0.6u as=0.1701p ps=1.65u w=0.42u l=0.13u
X828 vdd SAR/sg13cmos5l_dlhr_1_6.D SAR/a_13486_5412# vdd sg13_lv_pmos ad=0.3808p pd=2.92u as=0.2128p ps=1.5u w=1.12u l=0.13u
X829 SAR/a_5700_6480# SAR/a_5674_6385# vdd vdd sg13_lv_pmos ad=0.34p pd=2.68u as=0.36237p ps=2.605u w=1u l=0.13u
X830 vdd SAR/sg13cmos5l_buf_8_2.X SAR/a_20008_7712# vdd sg13_lv_pmos ad=0.2114p pd=1.54u as=0.2856p ps=2.36u w=0.84u l=0.13u
X831 vdd SAR/a_14295_7282# SAR/a_14426_7288# vdd sg13_lv_pmos ad=1.07253p pd=6.75u as=0.2856p ps=2.36u w=0.84u l=0.13u
X832 SAR/a_7631_4727# SAR/a_6789_4629# SAR/a_6372_4968# vdd sg13_lv_pmos ad=0.2048p pd=1.63u as=0.34p ps=2.68u w=1u l=0.13u
X833 SAR/a_12815_4261# SAR/a_11973_3911# SAR/a_11556_3904# vdd sg13_lv_pmos ad=0.2048p pd=1.63u as=0.34p ps=2.68u w=1u l=0.13u
X834 SAR/a_1862_4338# SAR/sg13cmos5l_dlhr_1_1.GATE vdd vdd sg13_lv_pmos ad=79.8f pd=0.8u as=0.1428p ps=1.52u w=0.42u l=0.13u
X835 vss SAR/a_19340_8400# pl_sw[9] vss sg13_lv_nmos ad=0.14875p pd=1.16u as=0.2886p ps=2.26u w=0.74u l=0.13u
X836 vdd SAR/sg13cmos5l_dlhr_1_0.D SAR/a_10331_1924# vdd sg13_lv_pmos ad=0.2128p pd=1.5u as=0.2128p ps=1.5u w=1.12u l=0.13u
X837 vdd SAR/a_7497_3138# SAR/a_8022_3120# vdd sg13_lv_pmos ad=0.1974p pd=1.5u as=0.2856p ps=2.36u w=0.84u l=0.13u
X838 SAR/a_15702_4187# SAR/a_15821_3864# vss vss sg13_lv_nmos ad=0.2516p pd=2.16u as=0.1406p ps=1.12u w=0.74u l=0.13u
X839 vss SAR/sg13cmos5l_dfrbp_1_0.RESET_B SAR/a_17508_3138# vss sg13_lv_nmos ad=0.1626p pd=1.415u as=60.89999f ps=0.71u w=0.42u l=0.13u
X840 vss SAR/a_1967_7285# SAR/a_2804_6924# vss sg13_lv_nmos ad=0.1406p pd=1.12u as=0.2516p ps=2.16u w=0.74u l=0.13u
X841 SAR/sg13cmos5l_buf_1_19.A SAR/a_18856_8436# vss vss sg13_lv_nmos ad=0.2886p pd=2.26u as=0.14875p ps=1.16u w=0.74u l=0.13u
X842 _cko SAR/a_20392_7712# vdd vdd sg13_lv_pmos ad=0.42p pd=2.99u as=0.2114p ps=1.54u w=1.12u l=0.13u
X843 SAR/a_17493_3947# SAR/sg13cmos5l_dfrbp_1_6.RESET_B vdd vdd sg13_lv_pmos ad=0.147p pd=1.54u as=0.1563p ps=1.22u w=0.42u l=0.13u
X844 SAR/a_2732_9150# SAR/sg13cmos5l_inv_1_20.Y vdd vdd sg13_lv_pmos ad=0.2856p pd=2.36u as=0.2114p ps=1.54u w=0.84u l=0.13u
X845 SAR/a_15909_2399# SAR/sg13cmos5l_dfrbp_1_0.CLK vss vss sg13_lv_nmos ad=0.2516p pd=2.16u as=2.43055p ps=15.415u w=0.74u l=0.13u
X846 SAR/a_17894_8436# SAR/a_17498_8800# SAR/a_17780_8436# vdd sg13_lv_pmos ad=0.1008p pd=0.9u as=0.191p ps=1.44u w=0.42u l=0.13u
X847 SAR/a_4324_7996# SAR/a_4349_7636# vdd vdd sg13_lv_pmos ad=0.2856p pd=2.36u as=1.15047p ps=7.175u w=0.84u l=0.13u
X848 SAR/sg13cmos5l_inv_1_1.A SAR/a_15208_6200# vss vss sg13_lv_nmos ad=0.2886p pd=2.26u as=0.14875p ps=1.16u w=0.74u l=0.13u
X849 vdd SAR/a_6736_2630# SAR/a_6681_2511# vdd sg13_lv_pmos ad=1.86162p pd=11.935u as=93.45f ps=0.865u w=0.42u l=0.13u
X850 SAR/sg13cmos5l_dfrbp_1_21.Q_N SAR/a_17519_6239# vss vss sg13_lv_nmos ad=0.2849p pd=2.25u as=0.2516p ps=2.16u w=0.74u l=0.13u
X851 SAR/a_2565_3911# SAR/sg13cmos5l_inv_1_8.A vdd vdd sg13_lv_pmos ad=0.4088p pd=2.97u as=1.43437p ps=9.105u w=1.12u l=0.13u
X852 vss vdd vss vss sg13_lv_nmos ad=0.1428p pd=1.52u as=0 ps=0 w=0.42u l=1u
X853 SAR/a_708_5416# SAR/a_1227_5423# SAR/a_1967_5773# vss sg13_lv_nmos ad=0.3473p pd=2.71u as=0.12665p ps=1.145u w=0.74u l=0.13u
X854 vss SAR/a_4950_5699# SAR/sg13cmos5l_dlhr_1_5.GATE vss sg13_lv_nmos ad=0.1406p pd=1.12u as=0.2516p ps=2.16u w=0.74u l=0.13u
X855 vdd vss vdd vdd sg13_lv_pmos ad=0.34p pd=2.68u as=0 ps=0 w=1u l=1u
X856 SAR/a_9524_4972# SAR/a_9111_4666# SAR/a_9456_4972# vdd sg13_lv_pmos ad=0.191p pd=1.44u as=0.105p ps=1.21u w=1u l=0.13u
X857 vss SAR/a_17327_7285# SAR/a_18164_6924# vss sg13_lv_nmos ad=0.1406p pd=1.12u as=0.2516p ps=2.16u w=0.74u l=0.13u
X858 vdd SAR/sg13cmos5l_dfrbp_1_8.RESET_B SAR/a_1862_8874# vdd sg13_lv_pmos ad=0.36237p pd=2.605u as=79.8f ps=0.8u w=0.42u l=0.13u
X859 SAR/sg13cmos5l_dlhr_1_4.Q_N SAR/a_6198_3120# vdd vdd sg13_lv_pmos ad=0.3808p pd=2.92u as=0.1974p ps=1.5u w=1.12u l=0.13u
X860 SAR/a_11771_5412# SAR/sg13cmos5l_or2_1_1.B vdd vdd sg13_lv_pmos ad=0.3808p pd=2.92u as=0.2128p ps=1.5u w=1.12u l=0.13u
X861 vdd SAR/sg13cmos5l_dfrbp_1_8.RESET_B SAR/a_2380_6162# vdd sg13_lv_pmos ad=1.04815p pd=6.595u as=79.8f ps=0.8u w=0.42u l=0.13u
X862 vdd SAR/a_7820_2352# SAR/sg13cmos5l_inv_1_14.A vdd sg13_lv_pmos ad=0.2114p pd=1.54u as=0.42p ps=2.99u w=1.12u l=0.13u
X863 SAR/sg13cmos5l_inv_1_5.A SAR/a_19796_3436# vdd vdd sg13_lv_pmos ad=0.3808p pd=2.92u as=0.2128p ps=1.5u w=1.12u l=0.13u
X864 vss SAR/sg13cmos5l_a221oi_1_0.C1 SAR/a_10433_4248# vss sg13_lv_nmos ad=0.2516p pd=2.16u as=0.1406p ps=1.12u w=0.74u l=0.13u
X865 SAR/a_2386_5850# SAR/sg13cmos5l_dfrbp_1_6.RESET_B vss vss sg13_lv_nmos ad=37.8f pd=0.6u as=79.8f ps=0.8u w=0.42u l=0.13u
X866 SAR/a_12490_6385# SAR/a_12933_6141# SAR/a_12230_6162# vss sg13_lv_nmos ad=79.8f pd=0.8u as=0.1296p ps=1.52u w=0.42u l=0.13u
X867 SAR/a_6153_3947# SAR/a_5796_3904# vdd vdd sg13_lv_pmos ad=63f pd=0.72u as=0.1563p ps=1.22u w=0.42u l=0.13u
X868 SAR/a_16268_1590# SAR/sg13cmos5l_buf_1_1.A vss vss sg13_lv_nmos ad=0.187p pd=1.78u as=0.14875p ps=1.16u w=0.55u l=0.13u
X869 SAR/a_8209_7326# SAR/a_7657_7282# vss vss sg13_lv_nmos ad=71.99999f pd=0.865u as=1.49685p ps=9.6u w=0.64u l=0.13u
X870 SAR/a_19444_5800# SAR/a_19028_5412# SAR/a_19209_5769# vss sg13_lv_nmos ad=77.7f pd=0.95u as=0.2516p ps=2.16u w=0.74u l=0.13u
X871 vdd SAR/sg13cmos5l_inv_1_3.A SAR/sg13cmos5l_buf_1_7.A vdd sg13_lv_pmos ad=0.3808p pd=2.92u as=0.3808p ps=2.92u w=1.12u l=0.13u
X872 SAR/a_4324_7996# SAR/a_4349_7636# vss vss sg13_lv_nmos ad=0.2775p pd=2.23u as=1.49685p ps=9.6u w=0.74u l=0.13u
X873 SAR/a_15300_7687# SAR/a_15531_7796# SAR/a_14986_7897# vss sg13_lv_nmos ad=0.2373p pd=1.97u as=79.8f ps=0.8u w=0.42u l=0.13u
X874 SAR/sg13cmos5l_dlhr_1_2.Q SAR/a_7497_3138# vss vss sg13_lv_nmos ad=0.2516p pd=2.16u as=0.1406p ps=1.12u w=0.74u l=0.13u
X875 vss SAR/sg13cmos5l_buf_1_62.X SAR/a_1864_9224# vss sg13_lv_nmos ad=0.14875p pd=1.16u as=0.187p ps=1.78u w=0.55u l=0.13u
X876 vss SAR/sg13cmos5l_dfrbp_1_6.RESET_B SAR/a_9268_6148# vss sg13_lv_nmos ad=0.1406p pd=1.12u as=77.7f ps=0.95u w=0.74u l=0.13u
X877 SAR/a_8772_8440# SAR/a_8746_8404# vdd vdd sg13_lv_pmos ad=0.34p pd=2.68u as=0.36237p ps=2.605u w=1u l=0.13u
X878 SAR/a_11002_3142# SAR/sg13cmos5l_nand2_1_0.B vss vss sg13_lv_nmos ad=0.1406p pd=1.12u as=0.2516p ps=2.16u w=0.74u l=0.13u
X879 vss SAR/sg13cmos5l_dlygate4sd2_1_0.A SAR/a_902_3142# vss sg13_lv_nmos ad=0.1323p pd=1.05u as=0.1428p ps=1.52u w=0.42u l=0.13u
X880 SAR/a_5414_6162# SAR/a_6219_6284# SAR/a_5674_6385# vdd sg13_lv_pmos ad=0.1428p pd=1.52u as=79.8f ps=0.8u w=0.42u l=0.13u
X881 SAR/a_3407_4261# SAR/a_2565_3911# SAR/a_2148_3904# vdd sg13_lv_pmos ad=0.2048p pd=1.63u as=0.34p ps=2.68u w=1u l=0.13u
X882 SAR/a_8050_4650# SAR/sg13cmos5l_dfrbp_1_8.RESET_B vss vss sg13_lv_nmos ad=37.8f pd=0.6u as=79.8f ps=0.8u w=0.42u l=0.13u
X883 SAR/a_1125_5423# SAR/sg13cmos5l_dlhr_1_1.GATE vdd vdd sg13_lv_pmos ad=0.4088p pd=2.97u as=1.2517p ps=7.955u w=1.12u l=0.13u
X884 vdd SAR/sg13cmos5l_inv_1_28.Y SAR/a_11464_9224# vdd sg13_lv_pmos ad=0.2114p pd=1.54u as=0.2856p ps=2.36u w=0.84u l=0.13u
X885 vss SAR/a_12716_8400# ph_sw[5] vss sg13_lv_nmos ad=0.14875p pd=1.16u as=0.2886p ps=2.26u w=0.74u l=0.13u
X886 vss SAR/a_17584_7166# SAR/a_17233_7285# vss sg13_lv_nmos ad=79.8f pd=0.8u as=0.1428p ps=1.52u w=0.42u l=0.13u
X887 SAR/a_17412_1944# SAR/a_17386_1849# vss vss sg13_lv_nmos ad=0.2516p pd=2.16u as=0.1626p ps=1.415u w=0.74u l=0.13u
X888 vdd SAR/a_17392_4870# SAR/a_17337_4965# vdd sg13_lv_pmos ad=1.28962p pd=8.195u as=93.45f ps=0.865u w=0.42u l=0.13u
X889 vss SAR/sg13cmos5l_buf_1_2.A SAR/a_15784_1664# vss sg13_lv_nmos ad=0.14875p pd=1.16u as=0.187p ps=1.78u w=0.55u l=0.13u
X890 vss SAR/a_18363_4270# SAR/sg13cmos5l_or2_1_0.A vss sg13_lv_nmos ad=0.1406p pd=1.12u as=0.1406p ps=1.12u w=0.74u l=0.13u
X891 vss SAR/sg13cmos5l_buf_1_96.A SAR/a_11464_8436# vss sg13_lv_nmos ad=0.14875p pd=1.16u as=0.187p ps=1.78u w=0.55u l=0.13u
X892 vss SAR/a_16751_2749# SAR/a_17588_2388# vss sg13_lv_nmos ad=0.1406p pd=1.12u as=0.2516p ps=2.16u w=0.74u l=0.13u
X893 SAR/sg13cmos5l_buf_1_28.X SAR/a_9448_1664# vss vss sg13_lv_nmos ad=0.2886p pd=2.26u as=0.14875p ps=1.16u w=0.74u l=0.13u
X894 vdd SAR/sg13cmos5l_dfrbp_1_8.RESET_B SAR/a_8746_8404# vdd sg13_lv_pmos ad=0.1563p pd=1.22u as=0.147p ps=1.54u w=0.42u l=0.13u
X895 SAR/a_19244_2352# SAR/sg13cmos5l_buf_1_18.X vdd vdd sg13_lv_pmos ad=0.2856p pd=2.36u as=0.2114p ps=1.54u w=0.84u l=0.13u
X896 vss SAR/a_4041_2745# SAR/a_4566_2818# vss sg13_lv_nmos ad=0.1491p pd=1.18u as=0.187p ps=1.78u w=0.55u l=0.13u
X897 vdd SAR/a_524_4614# ckc vdd sg13_lv_pmos ad=0.2114p pd=1.54u as=0.42p ps=2.99u w=1.12u l=0.13u
X898 SAR/a_10022_7674# SAR/sg13cmos5l_buf_1_57.X vdd vdd sg13_lv_pmos ad=79.8f pd=0.8u as=0.1428p ps=1.52u w=0.42u l=0.13u
X899 SAR/a_17008_2630# SAR/a_16751_2749# SAR/a_17170_2826# vss sg13_lv_nmos ad=0.1428p pd=1.52u as=37.8f ps=0.6u w=0.42u l=0.13u
X900 SAR/a_17386_1849# SAR/a_17829_1605# SAR/a_17126_1626# vss sg13_lv_nmos ad=79.8f pd=0.8u as=0.1296p ps=1.52u w=0.42u l=0.13u
X901 SAR/a_2340_3456# SAR/a_2314_3361# vss vss sg13_lv_nmos ad=0.2516p pd=2.16u as=0.1626p ps=1.415u w=0.74u l=0.13u
X902 SAR/a_15876_4968# SAR/a_16395_4772# SAR/a_17135_4727# vss sg13_lv_nmos ad=0.3473p pd=2.71u as=0.12665p ps=1.145u w=0.74u l=0.13u
X903 SAR/a_11182_4948# SAR/sg13cmos5l_a221oi_1_0.B1 SAR/a_11394_4948# vdd sg13_lv_pmos ad=0.2128p pd=1.5u as=0.3808p ps=2.92u w=1.12u l=0.13u
X904 vss SAR/a_1815_4666# SAR/a_1946_4660# vss sg13_lv_nmos ad=2.41737p pd=15.64u as=0.2775p ps=2.23u w=0.74u l=0.13u
X905 vss rdy SAR/a_424_8436# vss sg13_lv_nmos ad=0.14875p pd=1.16u as=0.187p ps=1.78u w=0.55u l=0.13u
X906 SAR/a_16462_4338# SAR/a_16703_3871# SAR/a_15821_3864# vss sg13_lv_nmos ad=0.1428p pd=1.52u as=0.12665p ps=1.145u w=0.42u l=0.13u
X907 SAR/a_18363_4270# SAR/sg13cmos5l_buf_8_1.A vss vss sg13_lv_nmos ad=0.1406p pd=1.12u as=0.1406p ps=1.12u w=0.74u l=0.13u
X908 vdd SAR/sg13cmos5l_dfrbp_1_6.RESET_B SAR/a_13161_7281# vdd sg13_lv_pmos ad=0.2128p pd=1.5u as=0.2128p ps=1.5u w=1.12u l=0.13u
X909 SAR/sg13cmos5l_buf_1_104.A SAR/sg13cmos5l_buf_1_3.A vss vss sg13_lv_nmos ad=0.2516p pd=2.16u as=0.2516p ps=2.16u w=0.74u l=0.13u
X910 vss SAR/a_2409_4650# SAR/a_2364_4686# vss sg13_lv_nmos ad=0.1428p pd=1.52u as=47.25f ps=0.645u w=0.42u l=0.13u
X911 SAR/a_20012_2352# SAR/sg13cmos5l_buf_1_0.X vss vss sg13_lv_nmos ad=0.187p pd=1.78u as=0.14875p ps=1.16u w=0.55u l=0.13u
X912 vdd SAR/sg13cmos5l_dfrbp_1_8.RESET_B SAR/a_3302_4650# vdd sg13_lv_pmos ad=0.36237p pd=2.605u as=79.8f ps=0.8u w=0.42u l=0.13u
X913 vdd SAR/sg13cmos5l_dlhr_1_15.D SAR/a_17545_7728# vdd sg13_lv_pmos ad=1.15047p pd=7.175u as=0.2856p ps=2.36u w=0.84u l=0.13u
X914 SAR/a_4460_9150# SAR/sg13cmos5l_buf_1_60.A vss vss sg13_lv_nmos ad=0.187p pd=1.78u as=0.14875p ps=1.16u w=0.55u l=0.13u
X915 vdd SAR/a_18345_7674# SAR/a_18278_8112# vdd sg13_lv_pmos ad=0.2387p pd=1.84u as=0.1008p ps=0.9u w=0.42u l=0.13u
X916 SAR/a_11182_4948# SAR/sg13cmos5l_a221oi_1_0.A2 vdd vdd sg13_lv_pmos ad=0.2128p pd=1.5u as=0.3808p ps=2.92u w=1.12u l=0.13u
X917 vss SAR/a_15887_8797# SAR/a_16724_8436# vss sg13_lv_nmos ad=0.1406p pd=1.12u as=0.2516p ps=2.16u w=0.74u l=0.13u
X918 SAR/a_3575_6553# SAR/sg13cmos5l_dfrbp_1_8.RESET_B vdd vdd sg13_lv_pmos ad=79.8f pd=0.8u as=0.36237p ps=2.605u w=0.42u l=0.13u
X919 SAR/a_5079_3154# SAR/sg13cmos5l_dfrbp_1_9.Q vdd vdd sg13_lv_pmos ad=0.3234p pd=2.45u as=1.38655p ps=8.8u w=0.84u l=0.13u
X920 vss SAR/a_8783_7751# SAR/a_9620_7972# vss sg13_lv_nmos ad=0.1406p pd=1.12u as=0.2516p ps=2.16u w=0.74u l=0.13u
X921 SAR/a_2644_4636# SAR/a_2228_4972# SAR/a_2409_4650# vss sg13_lv_nmos ad=77.7f pd=0.95u as=0.2516p ps=2.16u w=0.74u l=0.13u
X922 SAR/a_17519_6239# SAR/a_16677_6141# SAR/a_17425_6239# vss sg13_lv_nmos ad=0.12665p pd=1.145u as=0.1428p ps=1.52u w=0.42u l=0.13u
X923 vdd vss vdd vdd sg13_lv_pmos ad=0.34p pd=2.68u as=0 ps=0 w=1u l=1u
X924 vss vdd vss vss sg13_lv_nmos ad=0.1428p pd=1.52u as=0 ps=0 w=0.42u l=1u
X925 SAR/a_1967_5773# SAR/a_1125_5423# SAR/a_708_5416# vdd sg13_lv_pmos ad=0.2048p pd=1.63u as=0.34p ps=2.68u w=1u l=0.13u
X926 vdd SAR/a_17327_7285# SAR/a_17584_7166# vdd sg13_lv_pmos ad=0.2639p pd=1.81u as=79.8f ps=0.8u w=0.42u l=0.13u
X927 SAR/sg13cmos5l_buf_1_9.A SAR/a_9832_1664# vss vss sg13_lv_nmos ad=0.2886p pd=2.26u as=0.14875p ps=1.16u w=0.74u l=0.13u
X928 vdd SAR/a_8204_9150# SAR/sg13cmos5l_buf_1_74.X vdd sg13_lv_pmos ad=0.2114p pd=1.54u as=0.42p ps=2.99u w=1.12u l=0.13u
X929 SAR/a_8783_7751# SAR/a_7941_7653# SAR/a_7524_7992# vdd sg13_lv_pmos ad=0.2048p pd=1.63u as=0.34p ps=2.68u w=1u l=0.13u
X930 vdd SAR/a_13072_4142# SAR/a_13017_4023# vdd sg13_lv_pmos ad=1.43437p pd=9.105u as=93.45f ps=0.865u w=0.42u l=0.13u
X931 vss SAR/sg13cmos5l_dfrbp_1_0.Q SAR/sg13cmos5l_dfrbp_1_0.D vss sg13_lv_nmos ad=0.2516p pd=2.16u as=0.1406p ps=1.12u w=0.74u l=0.13u
X932 SAR/a_708_6928# SAR/a_682_6892# vdd vdd sg13_lv_pmos ad=0.34p pd=2.68u as=0.36237p ps=2.605u w=1u l=0.13u
X933 vss SAR/sg13cmos5l_dlhr_1_5.D SAR/a_7657_7282# vss sg13_lv_nmos ad=0.15055p pd=1.17u as=0.187p ps=1.78u w=0.55u l=0.13u
X934 SAR/a_15412_5800# SAR/a_14996_5412# SAR/a_15177_5769# vss sg13_lv_nmos ad=77.7f pd=0.95u as=0.2516p ps=2.16u w=0.74u l=0.13u
X935 SAR/a_5492_3460# SAR/a_5210_3148# SAR/a_5425_3130# vss sg13_lv_nmos ad=0.141p pd=1.17u as=71.99999f ps=0.865u w=0.64u l=0.13u
X936 SAR/a_4934_2826# SAR/a_5739_2399# SAR/a_5194_2356# vdd sg13_lv_pmos ad=0.1428p pd=1.52u as=79.8f ps=0.8u w=0.42u l=0.13u
X937 vss SAR/sg13cmos5l_inv_1_3.A SAR/sg13cmos5l_buf_1_7.A vss sg13_lv_nmos ad=0.2516p pd=2.16u as=0.2516p ps=2.16u w=0.74u l=0.13u
X938 SAR/a_5049_4965# SAR/a_4107_4772# SAR/a_4847_4727# vdd sg13_lv_pmos ad=93.45f pd=0.865u as=0.2048p ps=1.63u w=0.42u l=0.13u
X939 SAR/sg13cmos5l_nor2_1_0.A SAR/a_13556_2388# vss vss sg13_lv_nmos ad=0.2516p pd=2.16u as=0.1406p ps=1.12u w=0.74u l=0.13u
X940 SAR/a_12815_1703# SAR/a_11973_1605# SAR/a_12721_1703# vss sg13_lv_nmos ad=0.12665p pd=1.145u as=0.1428p ps=1.52u w=0.42u l=0.13u
X941 vss SAR/a_14889_7281# SAR/a_14844_7326# vss sg13_lv_nmos ad=0.1428p pd=1.52u as=47.25f ps=0.645u w=0.42u l=0.13u
X942 vss SAR/a_19227_4654# SAR/sg13cmos5l_buf_8_0.X vss sg13_lv_nmos ad=0.2516p pd=2.16u as=0.1406p ps=1.12u w=0.74u l=0.13u
X943 SAR/a_6022_4325# SAR/sg13cmos5l_dfrbp_1_6.RESET_B vss vss sg13_lv_nmos ad=37.8f pd=0.6u as=0.1701p ps=1.65u w=0.42u l=0.13u
X944 SAR/a_1484_6126# SAR/sg13cmos5l_buf_1_58.A vss vss sg13_lv_nmos ad=0.187p pd=1.78u as=0.14875p ps=1.16u w=0.55u l=0.13u
X945 SAR/a_5446_2813# SAR/sg13cmos5l_dfrbp_1_6.RESET_B vss vss sg13_lv_nmos ad=37.8f pd=0.6u as=0.1701p ps=1.65u w=0.42u l=0.13u
X946 SAR/a_15884_3102# SAR/sg13cmos5l_buf_1_5.X vdd vdd sg13_lv_pmos ad=0.2856p pd=2.36u as=0.2114p ps=1.54u w=0.84u l=0.13u
X947 SAR/a_4559_7630# SAR/sg13cmos5l_dlhr_1_9.D vss vss sg13_lv_nmos ad=0.187p pd=1.78u as=0.15055p ps=1.17u w=0.55u l=0.13u
X948 SAR/a_6372_4968# SAR/a_6346_4873# vss vss sg13_lv_nmos ad=0.2516p pd=2.16u as=0.1626p ps=1.415u w=0.74u l=0.13u
X949 SAR/sg13cmos5l_a22oi_1_2.B1 SAR/sg13cmos5l_nand2_1_1.B vss vss sg13_lv_nmos ad=0.1406p pd=1.12u as=0.2516p ps=2.16u w=0.74u l=0.13u
X950 SAR/a_10783_3876# SAR/sg13cmos5l_inv_1_0.A SAR/sg13cmos5l_a22oi_1_0.Y vdd sg13_lv_pmos ad=0.2744p pd=1.61u as=0.2128p ps=1.5u w=1.12u l=0.13u
X951 SAR/a_12976_2630# SAR/a_12719_2749# SAR/a_13138_2826# vss sg13_lv_nmos ad=0.1428p pd=1.52u as=37.8f ps=0.6u w=0.42u l=0.13u
X952 SAR/sg13cmos5l_dfrbp_1_6.RESET_B _cks vss vss sg13_lv_nmos ad=0.1406p pd=1.12u as=0.2516p ps=2.16u w=0.74u l=0.13u
X953 vdd SAR/sg13cmos5l_dlhr_1_15.Q SAR/a_19240_7712# vdd sg13_lv_pmos ad=0.2114p pd=1.54u as=0.2856p ps=2.36u w=0.84u l=0.13u
X954 vdd SAR/a_8457_7281# SAR/a_8390_6924# vdd sg13_lv_pmos ad=0.2387p pd=1.84u as=0.1008p ps=0.9u w=0.42u l=0.13u
X955 vss SAR/sg13cmos5l_dfrbp_1_6.RESET_B SAR/a_13876_7660# vss sg13_lv_nmos ad=0.1406p pd=1.12u as=77.7f ps=0.95u w=0.74u l=0.13u
X956 vdd SAR/a_5324_1590# SAR/sg13cmos5l_buf_1_39.A vdd sg13_lv_pmos ad=0.2114p pd=1.54u as=0.42p ps=2.99u w=1.12u l=0.13u
X957 vdd SAR/sg13cmos5l_inv_1_1.A SAR/a_16264_9224# vdd sg13_lv_pmos ad=0.2114p pd=1.54u as=0.2856p ps=2.36u w=0.84u l=0.13u
X958 SAR/a_3669_6320# SAR/sg13cmos5l_dfrbp_1_8.RESET_B vdd vdd sg13_lv_pmos ad=0.147p pd=1.54u as=0.1563p ps=1.22u w=0.42u l=0.13u
X959 SAR/a_3860_2388# SAR/a_3447_2746# SAR/a_3792_2388# vdd sg13_lv_pmos ad=0.191p pd=1.44u as=0.105p ps=1.21u w=1u l=0.13u
X960 vdd SAR/a_10464_2427# SAR/sg13cmos5l_dfrbp_1_4.D vdd sg13_lv_pmos ad=0.3808p pd=2.92u as=0.2408p ps=1.55u w=1.12u l=0.13u
X961 SAR/a_14924_1590# SAR/sg13cmos5l_buf_1_6.A vss vss sg13_lv_nmos ad=0.187p pd=1.78u as=0.14875p ps=1.16u w=0.55u l=0.13u
X962 SAR/a_20012_1590# SAR/sg13cmos5l_buf_1_0.A vss vss sg13_lv_nmos ad=0.187p pd=1.78u as=0.14875p ps=1.16u w=0.55u l=0.13u
X963 vdd SAR/a_8783_7751# SAR/a_9040_7894# vdd sg13_lv_pmos ad=0.2639p pd=1.81u as=79.8f ps=0.8u w=0.42u l=0.13u
X964 SAR/a_5132_9150# SAR/sg13cmos5l_buf_1_44.X vss vss sg13_lv_nmos ad=0.187p pd=1.78u as=0.14875p ps=1.16u w=0.55u l=0.13u
X965 SAR/a_8204_9150# SAR/sg13cmos5l_buf_1_45.X vdd vdd sg13_lv_pmos ad=0.2856p pd=2.36u as=0.2114p ps=1.54u w=0.84u l=0.13u
X966 _d1 SAR/a_20008_3900# vss vss sg13_lv_nmos ad=0.2886p pd=2.26u as=0.14875p ps=1.16u w=0.74u l=0.13u
X967 SAR/sg13cmos5l_buf_1_34.X SAR/a_4840_1664# vdd vdd sg13_lv_pmos ad=0.42p pd=2.99u as=0.2114p ps=1.54u w=1.12u l=0.13u
X968 SAR/sg13cmos5l_dlhr_1_20.Q_N SAR/a_10230_4632# vss vss sg13_lv_nmos ad=0.2516p pd=2.16u as=0.1491p ps=1.18u w=0.74u l=0.13u
X969 SAR/a_5988_8440# SAR/a_6507_8447# SAR/a_7247_8797# vss sg13_lv_nmos ad=0.3473p pd=2.71u as=0.12665p ps=1.145u w=0.74u l=0.13u
X970 SAR/sg13cmos5l_nor2b_1_0.Y SAR/a_12814_4692# vss vss sg13_lv_nmos ad=0.1406p pd=1.12u as=0.17255p ps=1.25u w=0.74u l=0.13u
X971 SAR/a_4076_7624# SAR/a_4349_7636# SAR/a_4311_7710# vss sg13_lv_nmos ad=0.141p pd=1.17u as=47.25f ps=0.645u w=0.42u l=0.13u
X972 vss SAR/a_7689_1626# SAR/a_7644_1662# vss sg13_lv_nmos ad=0.1428p pd=1.52u as=47.25f ps=0.645u w=0.42u l=0.13u
X973 SAR/sg13cmos5l_a221oi_1_0.A2 SAR/a_7892_3900# vss vss sg13_lv_nmos ad=0.2516p pd=2.16u as=0.1406p ps=1.12u w=0.74u l=0.13u
X974 SAR/a_17988_3151# SAR/a_17700_3456# SAR/a_17926_3151# vss sg13_lv_nmos ad=0.1428p pd=1.52u as=37.8f ps=0.6u w=0.42u l=0.13u
X975 vdd SAR/sg13cmos5l_dfrbp_1_8.RESET_B SAR/a_15782_7362# vdd sg13_lv_pmos ad=0.36237p pd=2.605u as=79.8f ps=0.8u w=0.42u l=0.13u
X976 vdd SAR/sg13cmos5l_dfrbp_1_6.RESET_B SAR/a_19593_6162# vdd sg13_lv_pmos ad=0.2128p pd=1.5u as=0.2128p ps=1.5u w=1.12u l=0.13u
X977 vdd SAR/sg13cmos5l_buf_1_34.A SAR/a_4840_1664# vdd sg13_lv_pmos ad=0.2114p pd=1.54u as=0.2856p ps=2.36u w=0.84u l=0.13u
X978 SAR/a_6346_4873# SAR/a_6789_4629# SAR/a_6086_4650# vss sg13_lv_nmos ad=79.8f pd=0.8u as=0.1296p ps=1.52u w=0.42u l=0.13u
X979 SAR/a_4934_2826# SAR/sg13cmos5l_dfrbp_1_6.D vdd vdd sg13_lv_pmos ad=79.8f pd=0.8u as=0.1428p ps=1.52u w=0.42u l=0.13u
X980 SAR/a_6180_4650# SAR/sg13cmos5l_dlhr_1_0.GATE SAR/a_6086_4650# vss sg13_lv_nmos ad=60.89999f pd=0.71u as=0.1428p ps=1.52u w=0.42u l=0.13u
X981 SAR/a_10725_7653# SAR/sg13cmos5l_dlhr_1_11.GATE vss vss sg13_lv_nmos ad=0.2516p pd=2.16u as=1.49685p ps=9.6u w=0.74u l=0.13u
X982 SAR/a_7924_1612# SAR/a_7508_1948# SAR/a_7689_1626# vss sg13_lv_nmos ad=77.7f pd=0.95u as=0.2516p ps=2.16u w=0.74u l=0.13u
X983 SAR/a_7666_8874# SAR/sg13cmos5l_dfrbp_1_8.RESET_B vss vss sg13_lv_nmos ad=37.8f pd=0.6u as=79.8f ps=0.8u w=0.42u l=0.13u
X984 vdd SAR/sg13cmos5l_dfrbp_1_6.RESET_B SAR/a_10665_7281# vdd sg13_lv_pmos ad=0.2128p pd=1.5u as=0.2128p ps=1.5u w=1.12u l=0.13u
X985 vss SAR/sg13cmos5l_dfrbp_1_16.Q SAR/a_3625_7282# vss sg13_lv_nmos ad=0.15055p pd=1.17u as=0.187p ps=1.78u w=0.55u l=0.13u
X986 SAR/a_13324_4696# SAR/sg13cmos5l_inv_1_0.A vdd vdd sg13_lv_pmos ad=0.1596p pd=1.22u as=0.1596p ps=1.22u w=0.84u l=0.13u
X987 SAR/a_10022_7674# SAR/a_10827_7796# SAR/a_10282_7897# vdd sg13_lv_pmos ad=0.1428p pd=1.52u as=79.8f ps=0.8u w=0.42u l=0.13u
X988 SAR/sg13cmos5l_dlhr_1_6.Q_N SAR/a_9558_6144# vss vss sg13_lv_nmos ad=0.2516p pd=2.16u as=0.1491p ps=1.18u w=0.74u l=0.13u
X989 SAR/a_10484_6924# SAR/a_10071_7282# SAR/a_10416_6924# vdd sg13_lv_pmos ad=0.191p pd=1.44u as=0.105p ps=1.21u w=1u l=0.13u
X990 SAR/a_19216_3358# SAR/a_18959_3215# SAR/a_19378_3138# vss sg13_lv_nmos ad=0.1428p pd=1.52u as=37.8f ps=0.6u w=0.42u l=0.13u
X991 SAR/sg13cmos5l_a22oi_1_1.B2 SAR/sg13cmos5l_and3_1_0.X vss vss sg13_lv_nmos ad=0.2516p pd=2.16u as=0.1406p ps=1.12u w=0.74u l=0.13u
X992 vss SAR/a_17516_9150# pl_sw[8] vss sg13_lv_nmos ad=0.14875p pd=1.16u as=0.2886p ps=2.26u w=0.74u l=0.13u
X993 vdd SAR/a_13775_6239# SAR/a_14612_6460# vdd sg13_lv_pmos ad=0.2128p pd=1.5u as=0.3864p ps=2.93u w=1.12u l=0.13u
X994 vss SAR/a_6572_1590# SAR/sg13cmos5l_buf_1_24.X vss sg13_lv_nmos ad=0.14875p pd=1.16u as=0.2886p ps=2.26u w=0.74u l=0.13u
X995 vdd SAR/sg13cmos5l_dfrbp_1_8.RESET_B SAR/a_6346_4873# vdd sg13_lv_pmos ad=0.1563p pd=1.22u as=0.147p ps=1.54u w=0.42u l=0.13u
X996 pl_sw[4] SAR/a_5800_9224# vss vss sg13_lv_nmos ad=0.2886p pd=2.26u as=0.14875p ps=1.16u w=0.74u l=0.13u
X997 SAR/a_422_5850# SAR/a_1227_5423# SAR/a_682_5380# vdd sg13_lv_pmos ad=0.1428p pd=1.52u as=79.8f ps=0.8u w=0.42u l=0.13u
X998 SAR/a_18999_6178# SAR/sg13cmos5l_dfrbp_1_8.D vss vss sg13_lv_nmos ad=0.2516p pd=2.16u as=0.15055p ps=1.17u w=0.74u l=0.13u
X999 SAR/a_11748_2813# SAR/a_11460_2392# SAR/a_11686_2813# vss sg13_lv_nmos ad=0.1428p pd=1.52u as=37.8f ps=0.6u w=0.42u l=0.13u
X1000 SAR/a_15062_4292# SAR/sg13cmos5l_a22oi_1_1.B2 SAR/sg13cmos5l_a22oi_1_1.Y vss sg13_lv_nmos ad=0.13875p pd=1.115u as=0.2664p ps=1.46u w=0.74u l=0.13u
X1001 vdd SAR/sg13cmos5l_or2_1_0.A SAR/a_18574_5028# vdd sg13_lv_pmos ad=0.2226p pd=1.535u as=0.1596p ps=1.22u w=0.84u l=0.13u
X1002 vss SAR/a_9040_7894# SAR/a_8689_7751# vss sg13_lv_nmos ad=79.8f pd=0.8u as=0.1428p ps=1.52u w=0.42u l=0.13u
X1003 SAR/a_14986_7897# SAR/a_15429_7653# SAR/a_15369_8065# vdd sg13_lv_pmos ad=79.8f pd=0.8u as=63f ps=0.72u w=0.42u l=0.13u
X1004 vss SAR/sg13cmos5l_dfrbp_1_0.RESET_B SAR/a_17220_1626# vss sg13_lv_nmos ad=0.1626p pd=1.415u as=60.89999f ps=0.71u w=0.42u l=0.13u
X1005 vss SAR/sg13cmos5l_buf_1_77.X SAR/a_7336_9224# vss sg13_lv_nmos ad=0.14875p pd=1.16u as=0.187p ps=1.78u w=0.55u l=0.13u
X1006 SAR/a_6405_8447# SAR/sg13cmos5l_inv_1_8.A vdd vdd sg13_lv_pmos ad=0.4088p pd=2.97u as=1.12242p ps=7u w=1.12u l=0.13u
X1007 SAR/a_7249_3130# SAR/a_6697_3192# vss vss sg13_lv_nmos ad=71.99999f pd=0.865u as=2.59257p ps=16.445u w=0.64u l=0.13u
X1008 SAR/sg13cmos5l_dlygate4sd2_1_0.X SAR/a_1290_3206# vss vss sg13_lv_nmos ad=0.2516p pd=2.16u as=0.1405p ps=1.15u w=0.74u l=0.13u
X1009 vss SAR/sg13cmos5l_inv_1_8.A SAR/a_2879_6432# vss sg13_lv_nmos ad=1.88087p pd=11.775u as=0.2516p ps=2.16u w=0.74u l=0.13u
X1010 _d0 SAR/a_20392_2388# vss vss sg13_lv_nmos ad=0.2886p pd=2.26u as=0.14875p ps=1.16u w=0.74u l=0.13u
X1011 vdd SAR/a_18363_4270# SAR/sg13cmos5l_or2_1_0.A vdd sg13_lv_pmos ad=0.2128p pd=1.5u as=0.2128p ps=1.5u w=1.12u l=0.13u
X1012 vss SAR/sg13cmos5l_dfrbp_1_6.RESET_B SAR/a_2148_3138# vss sg13_lv_nmos ad=0.1626p pd=1.415u as=60.89999f ps=0.71u w=0.42u l=0.13u
X1013 SAR/sg13cmos5l_buf_8_0.X SAR/a_19227_4654# vdd vdd sg13_lv_pmos ad=0.2128p pd=1.5u as=0.2128p ps=1.5u w=1.12u l=0.13u
X1014 vdd SAR/a_13072_1846# SAR/a_13017_1941# vdd sg13_lv_pmos ad=1.86162p pd=11.935u as=93.45f ps=0.865u w=0.42u l=0.13u
X1015 vdd vss vdd vdd sg13_lv_pmos ad=0.34p pd=2.68u as=0 ps=0 w=1u l=1u
X1016 vdd SAR/a_4847_4727# SAR/a_5684_4948# vdd sg13_lv_pmos ad=0.2128p pd=1.5u as=0.3864p ps=2.93u w=1.12u l=0.13u
X1017 SAR/a_10613_2758# SAR/sg13cmos5l_nand2_1_1.B vss vss sg13_lv_nmos ad=0.1406p pd=1.12u as=0.1898p ps=1.36u w=0.74u l=0.13u
X1018 SAR/a_11748_2813# SAR/a_11979_2399# SAR/a_11434_2356# vss sg13_lv_nmos ad=0.2373p pd=1.97u as=79.8f ps=0.8u w=0.42u l=0.13u
X1019 vss SAR/a_13484_8400# SAR/sg13cmos5l_buf_1_5.A vss sg13_lv_nmos ad=0.14875p pd=1.16u as=0.2886p ps=2.26u w=0.74u l=0.13u
X1020 SAR/a_17135_4727# SAR/a_16293_4629# SAR/a_17041_4727# vss sg13_lv_nmos ad=0.12665p pd=1.145u as=0.1428p ps=1.52u w=0.42u l=0.13u
X1021 vss vdd vss vss sg13_lv_nmos ad=0.1428p pd=1.52u as=0 ps=0 w=0.42u l=1u
X1022 SAR/a_12516_6480# SAR/a_12490_6385# vdd vdd sg13_lv_pmos ad=0.34p pd=2.68u as=0.36237p ps=2.605u w=1u l=0.13u
X1023 vss SAR/sg13cmos5l_buf_1_4.A SAR/sg13cmos5l_buf_1_110.A vss sg13_lv_nmos ad=0.2516p pd=2.16u as=0.2516p ps=2.16u w=0.74u l=0.13u
X1024 vss SAR/sg13cmos5l_dlhr_1_2.D SAR/a_6697_3192# vss sg13_lv_nmos ad=0.15055p pd=1.17u as=0.187p ps=1.78u w=0.55u l=0.13u
X1025 SAR/a_18363_4270# SAR/sg13cmos5l_buf_8_1.A vdd vdd sg13_lv_pmos ad=0.2128p pd=1.5u as=0.2128p ps=1.5u w=1.12u l=0.13u
X1026 SAR/a_10725_7653# SAR/sg13cmos5l_dlhr_1_11.GATE vdd vdd sg13_lv_pmos ad=0.4088p pd=2.97u as=1.12242p ps=7u w=1.12u l=0.13u
X1027 vdd SAR/a_16293_4629# SAR/a_16395_4772# vdd sg13_lv_pmos ad=1.28962p pd=8.195u as=0.3864p ps=2.93u w=1.12u l=0.13u
X1028 SAR/a_13116_7326# SAR/a_12567_7282# SAR/a_12980_6924# vss sg13_lv_nmos ad=47.25f pd=0.645u as=0.141p ps=1.17u w=0.42u l=0.13u
X1029 vss SAR/a_15500_9150# ph_sw[6] vss sg13_lv_nmos ad=0.14875p pd=1.16u as=0.2886p ps=2.26u w=0.74u l=0.13u
X1030 vdd SAR/a_12567_7282# SAR/a_12698_7288# vdd sg13_lv_pmos ad=1.07253p pd=6.75u as=0.2856p ps=2.36u w=0.84u l=0.13u
X1031 SAR/a_15782_7362# SAR/a_16587_6935# SAR/a_16042_6892# vdd sg13_lv_pmos ad=0.1428p pd=1.52u as=79.8f ps=0.8u w=0.42u l=0.13u
X1032 vdd SAR/sg13cmos5l_dlhr_1_5.D SAR/a_7657_7282# vdd sg13_lv_pmos ad=1.07253p pd=6.75u as=0.2856p ps=2.36u w=0.84u l=0.13u
X1033 SAR/a_10464_2427# SAR/sg13cmos5l_nand2_1_1.B SAR/a_10427_2736# vss sg13_lv_nmos ad=0.2176p pd=1.96u as=78.39999f ps=0.885u w=0.64u l=0.13u
X1034 vss SAR/sg13cmos5l_dlhr_1_6.D SAR/a_8233_6216# vss sg13_lv_nmos ad=0.15055p pd=1.17u as=0.187p ps=1.78u w=0.55u l=0.13u
X1035 SAR/sg13cmos5l_dfrbp_1_0.Q SAR/a_19508_1924# vdd vdd sg13_lv_pmos ad=0.3808p pd=2.92u as=0.2128p ps=1.5u w=1.12u l=0.13u
X1036 SAR/a_17135_4727# SAR/a_16293_4629# SAR/a_15876_4968# vdd sg13_lv_pmos ad=0.2048p pd=1.63u as=0.34p ps=2.68u w=1u l=0.13u
X1037 SAR/a_10420_5412# SAR/sg13cmos5l_dfrbp_1_20.Q vdd vdd sg13_lv_pmos ad=0.2128p pd=1.5u as=0.3808p ps=2.92u w=1.12u l=0.13u
X1038 vss SAR/a_19227_4654# SAR/sg13cmos5l_buf_8_0.X vss sg13_lv_nmos ad=0.1406p pd=1.12u as=0.1406p ps=1.12u w=0.74u l=0.13u
X1039 SAR/a_16690_7674# SAR/sg13cmos5l_dfrbp_1_6.RESET_B vss vss sg13_lv_nmos ad=37.8f pd=0.6u as=79.8f ps=0.8u w=0.42u l=0.13u
X1040 SAR/a_1158_3142# SAR/a_902_3142# vdd vdd sg13_lv_pmos ad=0.34p pd=2.68u as=0.2481p ps=1.56u w=1u l=0.25u
X1041 SAR/a_3588_4968# SAR/a_3562_4873# vdd vdd sg13_lv_pmos ad=0.34p pd=2.68u as=0.36237p ps=2.605u w=1u l=0.13u
X1042 SAR/sg13cmos5l_buf_8_2.X SAR/a_19227_9190# vss vss sg13_lv_nmos ad=0.1406p pd=1.12u as=0.1406p ps=1.12u w=0.74u l=0.13u
X1043 vss SAR/sg13cmos5l_inv_1_6.A SAR/a_20008_8436# vss sg13_lv_nmos ad=0.14875p pd=1.16u as=0.187p ps=1.78u w=0.55u l=0.13u
X1044 SAR/sg13cmos5l_dfrbp_1_23.CLK SAR/a_14228_9484# vdd vdd sg13_lv_pmos ad=0.3808p pd=2.92u as=0.2128p ps=1.5u w=1.12u l=0.13u
X1045 vss SAR/sg13cmos5l_buf_1_24.A SAR/sg13cmos5l_buf_1_78.A vss sg13_lv_nmos ad=0.2516p pd=2.16u as=0.2516p ps=2.16u w=0.74u l=0.13u
X1046 SAR/a_7508_1948# SAR/a_7095_1642# SAR/a_7440_1948# vdd sg13_lv_pmos ad=0.191p pd=1.44u as=0.105p ps=1.21u w=1u l=0.13u
X1047 vdd SAR/a_7216_6382# SAR/a_7161_6477# vdd sg13_lv_pmos ad=1.07253p pd=6.75u as=93.45f ps=0.865u w=0.42u l=0.13u
X1048 vss SAR/sg13cmos5l_nor2b_1_0.Y SAR/a_11054_4292# vss sg13_lv_nmos ad=0.2516p pd=2.16u as=96.2f ps=1u w=0.74u l=0.13u
X1049 SAR/a_19548_6198# SAR/a_18999_6178# SAR/a_19412_6484# vss sg13_lv_nmos ad=47.25f pd=0.645u as=0.141p ps=1.17u w=0.42u l=0.13u
X1050 vss SAR/a_4041_2745# SAR/a_3996_2790# vss sg13_lv_nmos ad=0.1428p pd=1.52u as=47.25f ps=0.645u w=0.42u l=0.13u
X1051 SAR/sg13cmos5l_dfrbp_1_10.Q SAR/a_4436_3436# vdd vdd sg13_lv_pmos ad=0.3808p pd=2.92u as=0.2128p ps=1.5u w=1.12u l=0.13u
X1052 vss SAR/a_1006_4167# SAR/sg13cmos5l_dlygate4sd3_1_0.X vss sg13_lv_nmos ad=0.1426p pd=1.16u as=0.2516p ps=2.16u w=0.74u l=0.13u
X1053 vss SAR/sg13cmos5l_buf_1_19.A SAR/a_18760_2388# vss sg13_lv_nmos ad=0.14875p pd=1.16u as=0.187p ps=1.78u w=0.55u l=0.13u
X1054 vss SAR/sg13cmos5l_dfrbp_1_6.RESET_B SAR/a_5908_3124# vss sg13_lv_nmos ad=0.1406p pd=1.12u as=77.7f ps=0.95u w=0.74u l=0.13u
X1055 vdd SAR/sg13cmos5l_buf_1_60.X SAR/a_2248_9224# vdd sg13_lv_pmos ad=0.2114p pd=1.54u as=0.2856p ps=2.36u w=0.84u l=0.13u
X1056 vss SAR/sg13cmos5l_buf_1_98.A SAR/a_13768_8436# vss sg13_lv_nmos ad=0.14875p pd=1.16u as=0.187p ps=1.78u w=0.55u l=0.13u
X1057 vss SAR/a_11072_5347# SAR/sg13cmos5l_a221oi_1_1.C1 vss sg13_lv_nmos ad=0.1371p pd=1.12u as=0.2516p ps=2.16u w=0.74u l=0.13u
X1058 SAR/a_14628_8440# SAR/a_14602_8404# vss vss sg13_lv_nmos ad=0.2516p pd=2.16u as=0.1626p ps=1.415u w=0.74u l=0.13u
X1059 vdd SAR/a_9260_2352# nh_sw[4] vdd sg13_lv_pmos ad=0.2114p pd=1.54u as=0.42p ps=2.99u w=1.12u l=0.13u
X1060 vdd SAR/a_7312_4142# SAR/a_7257_4023# vdd sg13_lv_pmos ad=1.43437p pd=9.105u as=93.45f ps=0.865u w=0.42u l=0.13u
X1061 vss SAR/a_17135_4727# SAR/a_17972_4948# vss sg13_lv_nmos ad=0.1406p pd=1.12u as=0.2516p ps=2.16u w=0.74u l=0.13u
X1062 SAR/a_908_1590# SAR/sg13cmos5l_buf_1_32.A vss vss sg13_lv_nmos ad=0.187p pd=1.78u as=0.14875p ps=1.16u w=0.55u l=0.13u
X1063 SAR/a_7247_8797# SAR/a_6405_8447# SAR/a_7153_8797# vss sg13_lv_nmos ad=0.12665p pd=1.145u as=0.1428p ps=1.52u w=0.42u l=0.13u
X1064 SAR/a_5700_6480# SAR/a_6219_6284# SAR/a_6959_6239# vss sg13_lv_nmos ad=0.3473p pd=2.71u as=0.12665p ps=1.145u w=0.74u l=0.13u
X1065 vdd SAR/sg13cmos5l_dfrbp_1_1.Q SAR/sg13cmos5l_inv_1_11.Y vdd sg13_lv_pmos ad=0.3808p pd=2.92u as=0.3808p ps=2.92u w=1.12u l=0.13u
X1066 SAR/a_5770_3868# SAR/a_6213_3911# SAR/a_6153_3947# vdd sg13_lv_pmos ad=79.8f pd=0.8u as=63f ps=0.72u w=0.42u l=0.13u
X1067 vss SAR/a_10473_9186# SAR/a_10428_9222# vss sg13_lv_nmos ad=0.1428p pd=1.52u as=47.25f ps=0.645u w=0.42u l=0.13u
X1068 SAR/a_524_4614# SAR/sg13cmos5l_buf_1_43.A vdd vdd sg13_lv_pmos ad=0.2856p pd=2.36u as=0.2114p ps=1.54u w=0.84u l=0.13u
X1069 vdd SAR/sg13cmos5l_buf_1_116.A SAR/a_15592_6200# vdd sg13_lv_pmos ad=0.2114p pd=1.54u as=0.2856p ps=2.36u w=0.84u l=0.13u
X1070 SAR/a_15492_2392# SAR/a_15466_2356# vss vss sg13_lv_nmos ad=0.2516p pd=2.16u as=0.1626p ps=1.415u w=0.74u l=0.13u
X1071 vss SAR/a_18363_4270# SAR/sg13cmos5l_or2_1_0.A vss sg13_lv_nmos ad=0.2516p pd=2.16u as=0.1406p ps=1.12u w=0.74u l=0.13u
X1072 vss SAR/a_3308_5376# SAR/sg13cmos5l_buf_1_41.A vss sg13_lv_nmos ad=0.14875p pd=1.16u as=0.2886p ps=2.26u w=0.74u l=0.13u
X1073 vdd SAR/sg13cmos5l_inv_1_26.Y SAR/a_17896_9224# vdd sg13_lv_pmos ad=0.2114p pd=1.54u as=0.2856p ps=2.36u w=0.84u l=0.13u
X1074 SAR/a_6345_8483# SAR/a_5988_8440# vdd vdd sg13_lv_pmos ad=63f pd=0.72u as=0.1563p ps=1.22u w=0.42u l=0.13u
X1075 vss SAR/a_10220_3102# nl_sw[5] vss sg13_lv_nmos ad=0.14875p pd=1.16u as=0.2886p ps=2.26u w=0.74u l=0.13u
X1076 vdd SAR/a_7820_9150# SAR/sg13cmos5l_buf_1_73.X vdd sg13_lv_pmos ad=0.2114p pd=1.54u as=0.42p ps=2.99u w=1.12u l=0.13u
X1077 SAR/a_16144_8678# SAR/sg13cmos5l_dfrbp_1_8.RESET_B vdd vdd sg13_lv_pmos ad=79.8f pd=0.8u as=1.12242p ps=7u w=0.42u l=0.13u
X1078 vss SAR/sg13cmos5l_inv_1_0.A SAR/sg13cmos5l_inv_1_0.Y vss sg13_lv_nmos ad=0.2516p pd=2.16u as=0.2516p ps=2.16u w=0.74u l=0.13u
X1079 SAR/a_10318_5412# SAR/sg13cmos5l_a221oi_1_1.C1 SAR/sg13cmos5l_a22oi_1_2.B2 vdd sg13_lv_pmos ad=0.2128p pd=1.5u as=0.3808p ps=2.92u w=1.12u l=0.13u
X1080 vss SAR/a_9033_6162# SAR/a_9558_6144# vss sg13_lv_nmos ad=0.1491p pd=1.18u as=0.187p ps=1.78u w=0.55u l=0.13u
X1081 vss SAR/sg13cmos5l_buf_8_0.A SAR/a_19227_4654# vss sg13_lv_nmos ad=0.1406p pd=1.12u as=0.2553p ps=2.17u w=0.74u l=0.13u
X1082 SAR/a_11556_3904# SAR/a_11530_3868# vdd vdd sg13_lv_pmos ad=0.34p pd=2.68u as=0.36237p ps=2.605u w=1u l=0.13u
X1083 vss SAR/sg13cmos5l_buf_1_86.A SAR/a_20392_6924# vss sg13_lv_nmos ad=0.14875p pd=1.16u as=0.187p ps=1.78u w=0.55u l=0.13u
X1084 SAR/sg13cmos5l_or2_1_0.A SAR/a_18363_4270# vss vss sg13_lv_nmos ad=0.1406p pd=1.12u as=0.1406p ps=1.12u w=0.74u l=0.13u
X1085 SAR/a_7055_4261# SAR/a_6213_3911# SAR/a_6961_4261# vss sg13_lv_nmos ad=0.12665p pd=1.145u as=0.1428p ps=1.52u w=0.42u l=0.13u
X1086 SAR/sg13cmos5l_buf_8_0.X SAR/a_19227_4654# vdd vdd sg13_lv_pmos ad=0.2128p pd=1.5u as=0.2128p ps=1.5u w=1.12u l=0.13u
X1087 vdd SAR/a_19227_9190# SAR/sg13cmos5l_buf_8_2.X vdd sg13_lv_pmos ad=0.2128p pd=1.5u as=0.2128p ps=1.5u w=1.12u l=0.13u
X1088 pl_sw[5] SAR/a_7336_9224# vdd vdd sg13_lv_pmos ad=0.42p pd=2.99u as=0.2114p ps=1.54u w=1.12u l=0.13u
X1089 SAR/a_16042_6892# SAR/a_16485_6935# SAR/a_15782_7362# vss sg13_lv_nmos ad=79.8f pd=0.8u as=0.1296p ps=1.52u w=0.42u l=0.13u
X1090 vss SAR/sg13cmos5l_dfrbp_1_6.RESET_B SAR/a_10900_7312# vss sg13_lv_nmos ad=0.1406p pd=1.12u as=77.7f ps=0.95u w=0.74u l=0.13u
X1091 SAR/a_6647_5459# SAR/sg13cmos5l_dfrbp_1_11.Q SAR/a_7394_5850# vss sg13_lv_nmos ad=0.1428p pd=1.52u as=60.89999f ps=0.71u w=0.42u l=0.13u
X1092 SAR/a_6647_5459# SAR/sg13cmos5l_dfrbp_1_8.RESET_B vdd vdd sg13_lv_pmos ad=79.8f pd=0.8u as=0.36237p ps=2.605u w=0.42u l=0.13u
X1093 SAR/a_5606_3576# SAR/a_5210_3148# SAR/a_5492_3460# vdd sg13_lv_pmos ad=0.1008p pd=0.9u as=0.191p ps=1.44u w=0.42u l=0.13u
X1094 SAR/a_3664_4142# SAR/a_3407_4261# SAR/a_3826_4338# vss sg13_lv_nmos ad=0.1428p pd=1.52u as=37.8f ps=0.6u w=0.42u l=0.13u
X1095 vss SAR/sg13cmos5l_dlhr_1_11.D SAR/a_12361_7282# vss sg13_lv_nmos ad=0.15055p pd=1.17u as=0.187p ps=1.78u w=0.55u l=0.13u
X1096 SAR/a_2727_6380# SAR/a_2879_6432# vdd vdd sg13_lv_pmos ad=0.3864p pd=2.93u as=1.07253p ps=6.75u w=1.12u l=0.13u
X1097 vdd SAR/sg13cmos5l_dfrbp_1_0.RESET_B SAR/a_11530_3868# vdd sg13_lv_pmos ad=0.1563p pd=1.22u as=0.147p ps=1.54u w=0.42u l=0.13u
X1098 vdd SAR/sg13cmos5l_nor2_1_0.A SAR/a_11980_4948# vdd sg13_lv_pmos ad=0.4032p pd=2.96u as=0.1176p ps=1.33u w=1.12u l=0.13u
X1099 SAR/a_5796_8874# SAR/sg13cmos5l_dlhr_1_5.GATE SAR/a_5702_8874# vss sg13_lv_nmos ad=60.89999f pd=0.71u as=0.1428p ps=1.52u w=0.42u l=0.13u
X1100 SAR/a_9164_1590# SAR/sg13cmos5l_buf_1_26.A vss vss sg13_lv_nmos ad=0.187p pd=1.78u as=0.14875p ps=1.16u w=0.55u l=0.13u
X1101 SAR/a_12230_6162# SAR/a_13035_6284# SAR/a_12490_6385# vdd sg13_lv_pmos ad=0.1428p pd=1.52u as=79.8f ps=0.8u w=0.42u l=0.13u
X1102 SAR/a_3692_9150# SAR/sg13cmos5l_inv_1_17.A vdd vdd sg13_lv_pmos ad=0.2856p pd=2.36u as=0.2114p ps=1.54u w=0.84u l=0.13u
X1103 SAR/a_7332_7674# SAR/sg13cmos5l_dfrbp_1_6.D SAR/a_7238_7674# vss sg13_lv_nmos ad=60.89999f pd=0.71u as=0.1428p ps=1.52u w=0.42u l=0.13u
X1104 SAR/sg13cmos5l_buf_1_46.A SAR/a_9705_4650# vdd vdd sg13_lv_pmos ad=0.3808p pd=2.92u as=0.2128p ps=1.5u w=1.12u l=0.13u
X1105 vdd SAR/sg13cmos5l_dfrbp_1_16.Q SAR/a_3625_7282# vdd sg13_lv_pmos ad=1.07253p pd=6.75u as=0.2856p ps=2.36u w=0.84u l=0.13u
X1106 SAR/sg13cmos5l_dlhr_1_11.D SAR/a_11567_7751# vss vss sg13_lv_nmos ad=0.2849p pd=2.25u as=0.2516p ps=2.16u w=0.74u l=0.13u
X1107 SAR/a_17529_7047# SAR/a_16587_6935# SAR/a_17327_7285# vdd sg13_lv_pmos ad=93.45f pd=0.865u as=0.2048p ps=1.63u w=0.42u l=0.13u
X1108 SAR/a_8988_6198# SAR/a_8439_6178# SAR/a_8852_6484# vss sg13_lv_nmos ad=47.25f pd=0.645u as=0.141p ps=1.17u w=0.42u l=0.13u
X1109 SAR/sg13cmos5l_buf_1_10.A SAR/a_11848_8436# vdd vdd sg13_lv_pmos ad=0.42p pd=2.99u as=0.2114p ps=1.54u w=1.12u l=0.13u
X1110 SAR/a_19227_4654# SAR/sg13cmos5l_buf_8_0.A vdd vdd sg13_lv_pmos ad=0.2128p pd=1.5u as=0.2128p ps=1.5u w=1.12u l=0.13u
X1111 SAR/sg13cmos5l_dfrbp_1_11.Q SAR/a_8468_4948# vdd vdd sg13_lv_pmos ad=0.3808p pd=2.92u as=0.2128p ps=1.5u w=1.12u l=0.13u
X1112 vss SAR/sg13cmos5l_dfrbp_1_6.RESET_B SAR/a_9940_4636# vss sg13_lv_nmos ad=0.1406p pd=1.12u as=77.7f ps=0.95u w=0.74u l=0.13u
X1113 SAR/a_12742_6175# SAR/sg13cmos5l_dfrbp_1_6.RESET_B vss vss sg13_lv_nmos ad=37.8f pd=0.6u as=0.1701p ps=1.65u w=0.42u l=0.13u
X1114 vss SAR/sg13cmos5l_buf_8_2.X SAR/a_20008_7712# vss sg13_lv_nmos ad=0.14875p pd=1.16u as=0.187p ps=1.78u w=0.55u l=0.13u
X1115 SAR/a_8972_9150# SAR/sg13cmos5l_buf_1_77.A vdd vdd sg13_lv_pmos ad=0.2856p pd=2.36u as=0.2114p ps=1.54u w=0.84u l=0.13u
X1116 SAR/sg13cmos5l_buf_8_2.X SAR/a_19227_9190# vss vss sg13_lv_nmos ad=0.1406p pd=1.12u as=0.1406p ps=1.12u w=0.74u l=0.13u
X1117 vss SAR/a_12976_2630# SAR/a_12625_2749# vss sg13_lv_nmos ad=79.8f pd=0.8u as=0.1428p ps=1.52u w=0.42u l=0.13u
X1118 SAR/a_10473_9186# SAR/a_10292_9508# vdd vdd sg13_lv_pmos ad=0.2128p pd=1.5u as=0.2387p ps=1.84u w=1.12u l=0.13u
X1119 SAR/sg13cmos5l_dlhr_1_1.D SAR/a_1967_5773# vdd vdd sg13_lv_pmos ad=0.4312p pd=3.01u as=0.2639p ps=1.81u w=1.12u l=0.13u
X1120 vdd SAR/sg13cmos5l_dfrbp_1_8.RESET_B SAR/a_14342_8874# vdd sg13_lv_pmos ad=0.36237p pd=2.605u as=79.8f ps=0.8u w=0.42u l=0.13u
X1121 SAR/a_18961_5814# SAR/a_18409_5770# vss vss sg13_lv_nmos ad=71.99999f pd=0.865u as=1.97045p ps=12.335u w=0.64u l=0.13u
X1122 vdd SAR/sg13cmos5l_dfrbp_1_6.RESET_B SAR/a_7498_7897# vdd sg13_lv_pmos ad=0.1563p pd=1.22u as=0.147p ps=1.54u w=0.42u l=0.13u
X1123 SAR/a_7820_9150# SAR/sg13cmos5l_buf_1_73.A vdd vdd sg13_lv_pmos ad=0.2856p pd=2.36u as=0.2114p ps=1.54u w=0.84u l=0.13u
X1124 SAR/a_3308_9150# SAR/sg13cmos5l_buf_1_65.X vss vss sg13_lv_nmos ad=0.187p pd=1.78u as=0.14875p ps=1.16u w=0.55u l=0.13u
X1125 vdd SAR/a_18860_6888# ph_sw[9] vdd sg13_lv_pmos ad=0.2114p pd=1.54u as=0.42p ps=2.99u w=1.12u l=0.13u
X1126 vss SAR/a_18928_1846# SAR/a_18577_1703# vss sg13_lv_nmos ad=79.8f pd=0.8u as=0.1428p ps=1.52u w=0.42u l=0.13u
X1127 SAR/a_12120_3456# SAR/sg13cmos5l_o21ai_1_0.A1 vdd vdd sg13_lv_pmos ad=0.2128p pd=1.5u as=0.3808p ps=2.92u w=1.12u l=0.15u
X1128 nl_sw[3] SAR/a_4456_1664# vdd vdd sg13_lv_pmos ad=0.42p pd=2.99u as=0.2114p ps=1.54u w=1.12u l=0.13u
X1129 vdd SAR/a_12815_4261# SAR/a_13652_3900# vdd sg13_lv_pmos ad=0.2128p pd=1.5u as=0.3864p ps=2.93u w=1.12u l=0.13u
X1130 SAR/a_6276_8861# SAR/a_5988_8440# SAR/a_6214_8861# vss sg13_lv_nmos ad=0.1428p pd=1.52u as=37.8f ps=0.6u w=0.42u l=0.13u
X1131 vss SAR/sg13cmos5l_inv_1_18.A SAR/sg13cmos5l_buf_1_28.A vss sg13_lv_nmos ad=0.2516p pd=2.16u as=0.2516p ps=2.16u w=0.74u l=0.13u
X1132 vdd SAR/sg13cmos5l_dfrbp_1_6.RESET_B SAR/a_8841_5769# vdd sg13_lv_pmos ad=0.2128p pd=1.5u as=0.2128p ps=1.5u w=1.12u l=0.13u
X1133 vss SAR/a_14889_7281# SAR/a_15414_7354# vss sg13_lv_nmos ad=0.1491p pd=1.18u as=0.187p ps=1.78u w=0.55u l=0.13u
X1134 vdd SAR/sg13cmos5l_dfrbp_1_0.RESET_B SAR/a_15206_2826# vdd sg13_lv_pmos ad=0.36237p pd=2.605u as=79.8f ps=0.8u w=0.42u l=0.13u
X1135 vss SAR/a_13648_9406# SAR/a_13297_9263# vss sg13_lv_nmos ad=79.8f pd=0.8u as=0.1428p ps=1.52u w=0.42u l=0.13u
X1136 SAR/a_10620_7326# SAR/a_10071_7282# SAR/a_10484_6924# vss sg13_lv_nmos ad=47.25f pd=0.645u as=0.141p ps=1.17u w=0.42u l=0.13u
X1137 SAR/a_8588_3864# SAR/sg13cmos5l_buf_1_46.A vdd vdd sg13_lv_pmos ad=0.2856p pd=2.36u as=0.2114p ps=1.54u w=0.84u l=0.13u
X1138 vss SAR/a_11973_1605# SAR/a_12075_1748# vss sg13_lv_nmos ad=7.01497p pd=46.005u as=0.2516p ps=2.16u w=0.74u l=0.13u
X1139 vss SAR/sg13cmos5l_dfrbp_1_6.RESET_B SAR/a_4276_2776# vss sg13_lv_nmos ad=0.1406p pd=1.12u as=77.7f ps=0.95u w=0.74u l=0.13u
X1140 SAR/sg13cmos5l_dlhr_1_3.Q_N SAR/a_4566_2818# vdd vdd sg13_lv_pmos ad=0.3808p pd=2.92u as=0.1974p ps=1.5u w=1.12u l=0.13u
X1141 vss SAR/sg13cmos5l_buf_1_31.X SAR/a_9448_6924# vss sg13_lv_nmos ad=0.14875p pd=1.16u as=0.187p ps=1.78u w=0.55u l=0.13u
X1142 SAR/a_2224_7166# SAR/sg13cmos5l_dfrbp_1_6.RESET_B vdd vdd sg13_lv_pmos ad=79.8f pd=0.8u as=1.04815p ps=6.595u w=0.42u l=0.13u
X1143 vdd SAR/a_8841_5769# SAR/a_8774_5412# vdd sg13_lv_pmos ad=0.2387p pd=1.84u as=0.1008p ps=0.9u w=0.42u l=0.13u
X1144 SAR/a_9189_8447# SAR/sg13cmos5l_inv_1_2.A vdd vdd sg13_lv_pmos ad=0.4088p pd=2.97u as=1.12242p ps=7u w=1.12u l=0.13u
X1145 SAR/a_13520_4696# SAR/sg13cmos5l_inv_1_0.A SAR/a_13418_4696# vss sg13_lv_nmos ad=0.1216p pd=1.02u as=0.1216p ps=1.02u w=0.64u l=0.13u
X1146 SAR/a_4005_4629# SAR/sg13cmos5l_inv_1_8.A vss vss sg13_lv_nmos ad=0.2516p pd=2.16u as=2.27517p ps=14.72u w=0.74u l=0.13u
X1147 SAR/sg13cmos5l_dfrbp_1_6.RESET_B _cks vss vss sg13_lv_nmos ad=0.1443p pd=1.13u as=0.1406p ps=1.12u w=0.74u l=0.13u
X1148 vss SAR/sg13cmos5l_buf_1_64.A SAR/a_3976_9224# vss sg13_lv_nmos ad=0.14875p pd=1.16u as=0.187p ps=1.78u w=0.55u l=0.13u
X1149 vss SAR/sg13cmos5l_dfrbp_1_8.RESET_B SAR/a_1956_4338# vss sg13_lv_nmos ad=0.1626p pd=1.415u as=60.89999f ps=0.71u w=0.42u l=0.13u
X1150 SAR/a_19227_9190# _cks vss vss sg13_lv_nmos ad=0.1406p pd=1.12u as=0.1406p ps=1.12u w=0.74u l=0.13u
X1151 SAR/a_13258_3361# SAR/a_13701_3117# SAR/a_12998_3138# vss sg13_lv_nmos ad=79.8f pd=0.8u as=0.1296p ps=1.52u w=0.42u l=0.13u
X1152 vss SAR/a_8588_2352# nl_sw[4] vss sg13_lv_nmos ad=0.14875p pd=1.16u as=0.2886p ps=2.26u w=0.74u l=0.13u
X1153 vss SAR/a_13701_3117# SAR/a_13803_3260# vss sg13_lv_nmos ad=2.59257p pd=16.445u as=0.2516p ps=2.16u w=0.74u l=0.13u
X1154 SAR/a_8998_8861# SAR/sg13cmos5l_dfrbp_1_8.RESET_B vss vss sg13_lv_nmos ad=37.8f pd=0.6u as=0.1701p ps=1.65u w=0.42u l=0.13u
X1155 vdd SAR/sg13cmos5l_dlygate4sd3_1_0.X SAR/sg13cmos5l_buf_1_43.A vdd sg13_lv_pmos ad=0.3808p pd=2.92u as=0.3808p ps=2.92u w=1.12u l=0.13u
X1156 vdd SAR/a_19227_9190# SAR/sg13cmos5l_buf_8_2.X vdd sg13_lv_pmos ad=0.2128p pd=1.5u as=0.2128p ps=1.5u w=1.12u l=0.13u
X1157 SAR/a_16953_2511# SAR/a_16011_2399# SAR/a_16751_2749# vdd sg13_lv_pmos ad=93.45f pd=0.865u as=0.2048p ps=1.63u w=0.42u l=0.13u
X1158 vss SAR/a_5069_5376# SAR/sg13cmos5l_dfrbp_1_29.Q_N vss sg13_lv_nmos ad=0.2516p pd=2.16u as=0.2849p ps=2.25u w=0.74u l=0.13u
X1159 vss _cks SAR/sg13cmos5l_dfrbp_1_6.RESET_B vss sg13_lv_nmos ad=0.1406p pd=1.12u as=0.1406p ps=1.12u w=0.74u l=0.13u
X1160 vdd SAR/a_16677_6141# SAR/a_16779_6284# vdd sg13_lv_pmos ad=1.07253p pd=6.75u as=0.3864p ps=2.93u w=1.12u l=0.13u
X1161 SAR/a_1967_7285# SAR/a_1125_6935# SAR/a_708_6928# vdd sg13_lv_pmos ad=0.2048p pd=1.63u as=0.34p ps=2.68u w=1u l=0.13u
X1162 SAR/sg13cmos5l_dfrbp_1_9.Q SAR/a_4244_3900# vdd vdd sg13_lv_pmos ad=0.3808p pd=2.92u as=0.2128p ps=1.5u w=1.12u l=0.13u
X1163 SAR/a_14820_7674# SAR/sg13cmos5l_buf_1_57.X SAR/a_14726_7674# vss sg13_lv_nmos ad=60.89999f pd=0.71u as=0.1428p ps=1.52u w=0.42u l=0.13u
X1164 SAR/a_6736_2630# SAR/a_6479_2749# SAR/a_6898_2826# vss sg13_lv_nmos ad=0.1428p pd=1.52u as=37.8f ps=0.6u w=0.42u l=0.13u
X1165 SAR/a_5799_5499# SAR/a_5951_5383# vdd vdd sg13_lv_pmos ad=0.3864p pd=2.93u as=1.28962p ps=8.195u w=1.12u l=0.13u
X1166 SAR/sg13cmos5l_inv_1_20.Y SAR/sg13cmos5l_buf_1_41.A vss vss sg13_lv_nmos ad=0.2516p pd=2.16u as=0.2516p ps=2.16u w=0.74u l=0.13u
X1167 vdd vss vdd vdd sg13_lv_pmos ad=0.19p pd=1.38u as=0 ps=0 w=1u l=1u
X1168 nh_sw[3] SAR/a_5704_1664# vss vss sg13_lv_nmos ad=0.2886p pd=2.26u as=0.14875p ps=1.16u w=0.74u l=0.13u
X1169 SAR/sg13cmos5l_dlhr_1_18.Q_N SAR/a_11190_7354# vdd vdd sg13_lv_pmos ad=0.3808p pd=2.92u as=0.1974p ps=1.5u w=1.12u l=0.13u
X1170 vss SAR/a_15045_8447# SAR/a_15147_8447# vss sg13_lv_nmos ad=2.92392p pd=18.89u as=0.2516p ps=2.16u w=0.74u l=0.13u
X1171 SAR/a_17367_8794# SAR/sg13cmos5l_dfrbp_1_22.D vss vss sg13_lv_nmos ad=0.2516p pd=2.16u as=0.15055p ps=1.17u w=0.74u l=0.13u
X1172 SAR/sg13cmos5l_nand2_1_0.B SAR/sg13cmos5l_a221oi_1_0.C1 vdd vdd sg13_lv_pmos ad=0.2128p pd=1.5u as=0.2198p ps=1.53u w=1.12u l=0.13u
X1173 SAR/sg13cmos5l_dlhr_1_11.GATE SAR/a_10868_8436# vdd vdd sg13_lv_pmos ad=0.3808p pd=2.92u as=0.2128p ps=1.5u w=1.12u l=0.13u
X1174 vdd SAR/a_11973_1605# SAR/a_12075_1748# vdd sg13_lv_pmos ad=1.86162p pd=11.935u as=0.3864p ps=2.93u w=1.12u l=0.13u
X1175 SAR/sg13cmos5l_dfrbp_1_22.Q_N SAR/a_17327_7285# vss vss sg13_lv_nmos ad=0.2849p pd=2.25u as=0.2516p ps=2.16u w=0.74u l=0.13u
X1176 vdd SAR/a_1463_8741# SAR/a_1463_8511# vdd sg13_lv_pmos ad=1.15047p pd=7.175u as=0.2442p ps=2.06u w=0.66u l=0.13u
X1177 SAR/a_2831_7630# SAR/sg13cmos5l_dfrbp_1_16.Q_N vss vss sg13_lv_nmos ad=0.187p pd=1.78u as=0.15055p ps=1.17u w=0.55u l=0.13u
X1178 SAR/a_12980_6924# SAR/a_12698_7288# SAR/a_12913_7326# vss sg13_lv_nmos ad=0.141p pd=1.17u as=71.99999f ps=0.865u w=0.64u l=0.13u
X1179 SAR/a_18122_2388# SAR/sg13cmos5l_nor2_1_1.A vdd vdd sg13_lv_pmos ad=0.1176p pd=1.33u as=0.4032p ps=2.96u w=1.12u l=0.13u
X1180 SAR/a_2628_3151# SAR/a_2340_3456# SAR/a_2566_3151# vss sg13_lv_nmos ad=0.1428p pd=1.52u as=37.8f ps=0.6u w=0.42u l=0.13u
X1181 SAR/a_4322_6162# SAR/sg13cmos5l_dfrbp_1_8.RESET_B vss vss sg13_lv_nmos ad=60.89999f pd=0.71u as=0.1626p ps=1.415u w=0.42u l=0.13u
X1182 SAR/sg13cmos5l_buf_1_105.A SAR/a_17961_8793# vss vss sg13_lv_nmos ad=0.2516p pd=2.16u as=0.1406p ps=1.12u w=0.74u l=0.13u
X1183 SAR/a_17327_7285# SAR/a_16485_6935# SAR/a_16068_6928# vdd sg13_lv_pmos ad=0.2048p pd=1.63u as=0.34p ps=2.68u w=1u l=0.13u
X1184 SAR/a_3826_8874# SAR/sg13cmos5l_dfrbp_1_8.RESET_B vss vss sg13_lv_nmos ad=37.8f pd=0.6u as=79.8f ps=0.8u w=0.42u l=0.13u
X1185 SAR/a_19340_8400# SAR/sg13cmos5l_buf_1_107.X vdd vdd sg13_lv_pmos ad=0.2856p pd=2.36u as=0.2114p ps=1.54u w=0.84u l=0.13u
X1186 vdd SAR/a_4076_7624# SAR/a_3676_7964# vdd sg13_lv_pmos ad=0.2387p pd=1.84u as=0.2128p ps=1.5u w=1.12u l=0.13u
X1187 _frm SAR/a_20008_7712# vdd vdd sg13_lv_pmos ad=0.42p pd=2.99u as=0.2114p ps=1.54u w=1.12u l=0.13u
X1188 SAR/sg13cmos5l_inv_1_29.A SAR/a_12404_7972# vss vss sg13_lv_nmos ad=0.2516p pd=2.16u as=0.1406p ps=1.12u w=0.74u l=0.13u
X1189 vss SAR/sg13cmos5l_nand2_1_1.B SAR/a_10094_2780# vss sg13_lv_nmos ad=0.2516p pd=2.16u as=96.2f ps=1u w=0.74u l=0.13u
X1190 vss SAR/sg13cmos5l_a221oi_1_0.A2 SAR/a_8041_5770# vss sg13_lv_nmos ad=0.15055p pd=1.17u as=0.187p ps=1.78u w=0.55u l=0.13u
X1191 SAR/a_8486_8874# SAR/sg13cmos5l_dfrbp_1_18.Q vdd vdd sg13_lv_pmos ad=79.8f pd=0.8u as=0.1428p ps=1.52u w=0.42u l=0.13u
X1192 SAR/a_16462_4023# SAR/a_16204_4338# vdd vdd sg13_lv_pmos ad=93.45f pd=0.865u as=1.43437p ps=9.105u w=0.42u l=0.13u
X1193 SAR/a_6084_4325# SAR/a_6315_3911# SAR/a_5770_3868# vss sg13_lv_nmos ad=0.2373p pd=1.97u as=79.8f ps=0.8u w=0.42u l=0.13u
X1194 SAR/a_11973_3911# SAR/sg13cmos5l_dfrbp_1_0.CLK vss vss sg13_lv_nmos ad=0.2516p pd=2.16u as=2.41737p ps=15.64u w=0.74u l=0.13u
X1195 SAR/sg13cmos5l_buf_1_79.X SAR/a_9256_9224# vss vss sg13_lv_nmos ad=0.2886p pd=2.26u as=0.14875p ps=1.16u w=0.74u l=0.13u
X1196 vdd vss vdd vdd sg13_lv_pmos ad=0.19p pd=1.38u as=0 ps=0 w=1u l=1u
X1197 vdd SAR/a_13701_3117# SAR/a_13803_3260# vdd sg13_lv_pmos ad=1.43437p pd=9.105u as=0.3864p ps=2.93u w=1.12u l=0.13u
X1198 SAR/a_18928_1846# SAR/a_18671_1703# SAR/a_19090_1626# vss sg13_lv_nmos ad=0.1428p pd=1.52u as=37.8f ps=0.6u w=0.42u l=0.13u
X1199 SAR/a_16940_3102# SAR/sg13cmos5l_buf_1_4.X vss vss sg13_lv_nmos ad=0.187p pd=1.78u as=0.14875p ps=1.16u w=0.55u l=0.13u
X1200 SAR/a_9129_8483# SAR/a_8772_8440# vdd vdd sg13_lv_pmos ad=63f pd=0.72u as=0.1563p ps=1.22u w=0.42u l=0.13u
X1201 SAR/a_7881_8065# SAR/a_7524_7992# vdd vdd sg13_lv_pmos ad=63f pd=0.72u as=0.1563p ps=1.22u w=0.42u l=0.13u
X1202 vdd _cks SAR/a_19227_9190# vdd sg13_lv_pmos ad=0.2128p pd=1.5u as=0.2128p ps=1.5u w=1.12u l=0.13u
X1203 SAR/a_17638_1639# SAR/sg13cmos5l_dfrbp_1_0.RESET_B vss vss sg13_lv_nmos ad=37.8f pd=0.6u as=0.1701p ps=1.65u w=0.42u l=0.13u
X1204 SAR/a_14996_5412# SAR/a_14583_5770# SAR/a_14928_5412# vdd sg13_lv_pmos ad=0.191p pd=1.44u as=0.105p ps=1.21u w=1u l=0.13u
X1205 vss SAR/sg13cmos5l_dfrbp_1_8.RESET_B SAR/a_5546_5850# vss sg13_lv_nmos ad=79.8f pd=0.8u as=37.8f ps=0.6u w=0.42u l=0.13u
X1206 vss SAR/a_2732_1590# SAR/sg13cmos5l_buf_1_35.A vss sg13_lv_nmos ad=0.14875p pd=1.16u as=0.2886p ps=2.26u w=0.74u l=0.13u
X1207 SAR/a_17595_3947# SAR/a_16703_3871# SAR/a_17493_3947# vdd sg13_lv_pmos ad=63f pd=0.72u as=79.8f ps=0.8u w=0.42u l=0.13u
X1208 SAR/sg13cmos5l_dlhr_1_9.D SAR/a_2804_5412# vdd vdd sg13_lv_pmos ad=0.3808p pd=2.92u as=0.2128p ps=1.5u w=1.12u l=0.13u
X1209 vdd SAR/a_4460_9150# SAR/sg13cmos5l_buf_1_60.X vdd sg13_lv_pmos ad=0.2114p pd=1.54u as=0.42p ps=2.99u w=1.12u l=0.13u
X1210 SAR/sg13cmos5l_dfrbp_1_17.Q_N SAR/a_3407_8797# vss vss sg13_lv_nmos ad=0.2849p pd=2.25u as=0.2516p ps=2.16u w=0.74u l=0.13u
X1211 SAR/a_16268_1590# SAR/sg13cmos5l_buf_1_1.A vdd vdd sg13_lv_pmos ad=0.2856p pd=2.36u as=0.2114p ps=1.54u w=0.84u l=0.13u
X1212 vss SAR/a_16271_7751# SAR/a_17108_7972# vss sg13_lv_nmos ad=0.1406p pd=1.12u as=0.2516p ps=2.16u w=0.74u l=0.13u
X1213 SAR/a_4041_2745# SAR/a_3860_2388# vdd vdd sg13_lv_pmos ad=0.2128p pd=1.5u as=0.2387p ps=1.84u w=1.12u l=0.13u
X1214 SAR/a_12358_9199# SAR/sg13cmos5l_dfrbp_1_8.RESET_B vss vss sg13_lv_nmos ad=37.8f pd=0.6u as=0.1701p ps=1.65u w=0.42u l=0.13u
X1215 SAR/a_13876_7660# SAR/a_13460_7996# SAR/a_13641_7674# vss sg13_lv_nmos ad=77.7f pd=0.95u as=0.2516p ps=2.16u w=0.74u l=0.13u
X1216 vdd SAR/a_18363_4270# SAR/sg13cmos5l_or2_1_0.A vdd sg13_lv_pmos ad=0.3864p pd=2.93u as=0.2128p ps=1.5u w=1.12u l=0.13u
X1217 SAR/sg13cmos5l_buf_1_93.X SAR/a_14632_9224# vss vss sg13_lv_nmos ad=0.2886p pd=2.26u as=0.14875p ps=1.16u w=0.74u l=0.13u
X1218 SAR/a_16751_2749# SAR/a_15909_2399# SAR/a_15492_2392# vdd sg13_lv_pmos ad=0.2048p pd=1.63u as=0.34p ps=2.68u w=1u l=0.13u
X1219 SAR/a_17008_2630# SAR/sg13cmos5l_dfrbp_1_0.RESET_B vdd vdd sg13_lv_pmos ad=79.8f pd=0.8u as=1.777p ps=11.395u w=0.42u l=0.13u
X1220 nl_sw[2] SAR/a_2248_1664# vss vss sg13_lv_nmos ad=0.2886p pd=2.26u as=0.14875p ps=1.16u w=0.74u l=0.13u
X1221 SAR/a_14458_4270# SAR/sg13cmos5l_nand2_1_1.B vss vss sg13_lv_nmos ad=0.1406p pd=1.12u as=0.2516p ps=2.16u w=0.74u l=0.13u
X1222 SAR/a_11567_7751# SAR/a_10725_7653# SAR/a_10308_7992# vdd sg13_lv_pmos ad=0.2048p pd=1.63u as=0.34p ps=2.68u w=1u l=0.13u
X1223 vdd SAR/a_6117_6141# SAR/a_6219_6284# vdd sg13_lv_pmos ad=1.07253p pd=6.75u as=0.3864p ps=2.93u w=1.12u l=0.13u
X1224 vdd SAR/sg13cmos5l_buf_1_62.X SAR/a_1864_9224# vdd sg13_lv_pmos ad=0.2114p pd=1.54u as=0.2856p ps=2.36u w=0.84u l=0.13u
X1225 SAR/a_12921_2511# SAR/a_11979_2399# SAR/a_12719_2749# vdd sg13_lv_pmos ad=93.45f pd=0.865u as=0.2048p ps=1.63u w=0.42u l=0.13u
X1226 ph_sw[2] SAR/a_3976_9224# vdd vdd sg13_lv_pmos ad=0.42p pd=2.99u as=0.2114p ps=1.54u w=1.12u l=0.13u
X1227 vdd SAR/a_3664_8678# SAR/a_3609_8559# vdd sg13_lv_pmos ad=1.15047p pd=7.175u as=93.45f ps=0.865u w=0.42u l=0.13u
X1228 SAR/sg13cmos5l_buf_1_105.A SAR/a_17961_8793# vdd vdd sg13_lv_pmos ad=0.3808p pd=2.92u as=0.2128p ps=1.5u w=1.12u l=0.13u
X1229 vss SAR/a_4076_5376# SAR/sg13cmos5l_inv_1_17.A vss sg13_lv_nmos ad=0.14875p pd=1.16u as=0.2886p ps=2.26u w=0.74u l=0.13u
X1230 SAR/sg13cmos5l_or2_1_0.A SAR/a_18363_4270# vdd vdd sg13_lv_pmos ad=0.2128p pd=1.5u as=0.2128p ps=1.5u w=1.12u l=0.13u
X1231 SAR/a_5796_3904# SAR/a_5770_3868# vdd vdd sg13_lv_pmos ad=0.34p pd=2.68u as=0.36237p ps=2.605u w=1u l=0.13u
X1232 vss SAR/sg13cmos5l_dfrbp_1_8.RESET_B SAR/a_6998_5837# vss sg13_lv_nmos ad=0.1701p pd=1.65u as=37.8f ps=0.6u w=0.42u l=0.13u
X1233 SAR/sg13cmos5l_buf_1_104.X SAR/a_19624_8436# vdd vdd sg13_lv_pmos ad=0.42p pd=2.99u as=0.2114p ps=1.54u w=1.12u l=0.13u
X1234 SAR/sg13cmos5l_dfrbp_1_7.Q_N SAR/a_14543_3215# vdd vdd sg13_lv_pmos ad=0.4312p pd=3.01u as=0.2639p ps=1.81u w=1.12u l=0.13u
X1235 vss SAR/a_18345_7674# SAR/a_18300_7710# vss sg13_lv_nmos ad=0.1428p pd=1.52u as=47.25f ps=0.645u w=0.42u l=0.13u
X1236 vdd vss vdd vdd sg13_lv_pmos ad=0.19p pd=1.38u as=0 ps=0 w=1u l=1u
X1237 vdd SAR/a_6479_2749# SAR/a_7316_2388# vdd sg13_lv_pmos ad=0.2128p pd=1.5u as=0.3864p ps=2.93u w=1.12u l=0.13u
X1238 SAR/a_11940_9186# SAR/sg13cmos5l_dlhr_1_11.GATE SAR/a_11846_9186# vss sg13_lv_nmos ad=60.89999f pd=0.71u as=0.1428p ps=1.52u w=0.42u l=0.13u
X1239 SAR/a_2228_4972# SAR/a_1946_4660# SAR/a_2161_4642# vss sg13_lv_nmos ad=0.141p pd=1.17u as=71.99999f ps=0.865u w=0.64u l=0.13u
X1240 vdd SAR/sg13cmos5l_buf_1_2.A SAR/a_15784_1664# vdd sg13_lv_pmos ad=0.2114p pd=1.54u as=0.2856p ps=2.36u w=0.84u l=0.13u
X1241 SAR/a_10783_3876# SAR/sg13cmos5l_nand2_1_0.A vdd vdd sg13_lv_pmos ad=0.2716p pd=1.605u as=0.3808p ps=2.92u w=1.12u l=0.13u
X1242 SAR/a_524_4614# SAR/sg13cmos5l_buf_1_43.A vss vss sg13_lv_nmos ad=0.187p pd=1.78u as=0.14875p ps=1.16u w=0.55u l=0.13u
X1243 vdd SAR/sg13cmos5l_inv_1_5.A SAR/a_20392_3900# vdd sg13_lv_pmos ad=0.2114p pd=1.54u as=0.2856p ps=2.36u w=0.84u l=0.13u
X1244 SAR/a_14602_8404# SAR/a_15045_8447# SAR/a_14342_8874# vss sg13_lv_nmos ad=79.8f pd=0.8u as=0.1296p ps=1.52u w=0.42u l=0.13u
X1245 SAR/sg13cmos5l_dlhr_1_10.Q SAR/a_19593_6162# vss vss sg13_lv_nmos ad=0.2516p pd=2.16u as=0.1406p ps=1.12u w=0.74u l=0.13u
X1246 vss SAR/a_1967_5773# SAR/a_2804_5412# vss sg13_lv_nmos ad=0.1406p pd=1.12u as=0.2516p ps=2.16u w=0.74u l=0.13u
X1247 vss SAR/a_3664_4142# SAR/a_3313_4261# vss sg13_lv_nmos ad=79.8f pd=0.8u as=0.1428p ps=1.52u w=0.42u l=0.13u
X1248 vss SAR/sg13cmos5l_buf_1_40.A SAR/a_1192_1664# vss sg13_lv_nmos ad=0.14875p pd=1.16u as=0.187p ps=1.78u w=0.55u l=0.13u
X1249 vdd SAR/sg13cmos5l_dfrbp_1_6.RESET_B SAR/a_5770_3868# vdd sg13_lv_pmos ad=0.1563p pd=1.22u as=0.147p ps=1.54u w=0.42u l=0.13u
X1250 vss SAR/a_1125_6935# SAR/a_1227_6935# vss sg13_lv_nmos ad=1.49685p pd=9.6u as=0.2516p ps=2.16u w=0.74u l=0.13u
X1251 vdd SAR/a_1484_6126# SAR/sg13cmos5l_buf_1_40.A vdd sg13_lv_pmos ad=0.2114p pd=1.54u as=0.42p ps=2.99u w=1.12u l=0.13u
X1252 SAR/a_6660_4663# SAR/a_6372_4968# SAR/a_6598_4663# vss sg13_lv_nmos ad=0.1428p pd=1.52u as=37.8f ps=0.6u w=0.42u l=0.13u
X1253 SAR/a_16234_6385# SAR/a_16677_6141# SAR/a_15974_6162# vss sg13_lv_nmos ad=79.8f pd=0.8u as=0.1296p ps=1.52u w=0.42u l=0.13u
X1254 vdd SAR/a_13391_9263# SAR/a_13648_9406# vdd sg13_lv_pmos ad=0.2639p pd=1.81u as=79.8f ps=0.8u w=0.42u l=0.13u
X1255 SAR/sg13cmos5l_dlhr_1_0.Q_N SAR/a_8214_1608# vdd vdd sg13_lv_pmos ad=0.3808p pd=2.92u as=0.1974p ps=1.5u w=1.12u l=0.13u
X1256 SAR/a_10292_9508# SAR/a_10010_9196# SAR/a_10225_9178# vss sg13_lv_nmos ad=0.141p pd=1.17u as=71.99999f ps=0.865u w=0.64u l=0.13u
X1257 SAR/sg13cmos5l_dlhr_1_2.Q_N SAR/a_8022_3120# vss vss sg13_lv_nmos ad=0.2516p pd=2.16u as=0.1491p ps=1.18u w=0.74u l=0.13u
X1258 SAR/a_10416_6924# SAR/a_9865_7282# vdd vdd sg13_lv_pmos ad=0.105p pd=1.21u as=1.07253p ps=6.75u w=1u l=0.13u
X1259 SAR/a_14032_6382# SAR/sg13cmos5l_dfrbp_1_6.RESET_B vdd vdd sg13_lv_pmos ad=79.8f pd=0.8u as=1.04815p ps=6.595u w=0.42u l=0.13u
X1260 vss SAR/sg13cmos5l_dfrbp_1_8.RESET_B SAR/a_3926_6175# vss sg13_lv_nmos ad=0.1701p pd=1.65u as=37.8f ps=0.6u w=0.42u l=0.13u
X1261 vdd SAR/a_3856_3358# SAR/a_3801_3453# vdd sg13_lv_pmos ad=1.43437p pd=9.105u as=93.45f ps=0.865u w=0.42u l=0.13u
X1262 vss SAR/a_8457_7281# SAR/a_8412_7326# vss sg13_lv_nmos ad=0.1428p pd=1.52u as=47.25f ps=0.645u w=0.42u l=0.13u
X1263 SAR/a_422_7362# SAR/a_1227_6935# SAR/a_682_6892# vdd sg13_lv_pmos ad=0.1428p pd=1.52u as=79.8f ps=0.8u w=0.42u l=0.13u
X1264 vdd SAR/sg13cmos5l_dfrbp_1_6.RESET_B SAR/a_7238_7674# vdd sg13_lv_pmos ad=0.36237p pd=2.605u as=79.8f ps=0.8u w=0.42u l=0.13u
X1265 SAR/a_18164_7996# SAR/a_17751_7690# SAR/a_18096_7996# vdd sg13_lv_pmos ad=0.191p pd=1.44u as=0.105p ps=1.21u w=1u l=0.13u
X1266 vdd SAR/sg13cmos5l_buf_1_29.A SAR/sg13cmos5l_buf_1_77.A vdd sg13_lv_pmos ad=0.3808p pd=2.92u as=0.3808p ps=2.92u w=1.12u l=0.13u
X1267 vdd vss vdd vdd sg13_lv_pmos ad=0.34p pd=2.68u as=0 ps=0 w=1u l=1u
X1268 SAR/a_5452_5850# SAR/a_5069_5376# vdd vdd sg13_lv_pmos ad=79.8f pd=0.8u as=0.2639p ps=1.81u w=0.42u l=0.13u
X1269 SAR/a_4460_9150# SAR/sg13cmos5l_buf_1_60.A vdd vdd sg13_lv_pmos ad=0.2856p pd=2.36u as=0.2114p ps=1.54u w=0.84u l=0.13u
X1270 SAR/sg13cmos5l_inv_1_20.Y SAR/sg13cmos5l_buf_1_41.A vdd vdd sg13_lv_pmos ad=0.3808p pd=2.92u as=0.3808p ps=2.92u w=1.12u l=0.13u
X1271 vdd SAR/sg13cmos5l_dfrbp_1_20.Q_N SAR/a_9673_9240# vdd sg13_lv_pmos ad=4.11675p pd=27.17u as=0.2856p ps=2.36u w=0.84u l=0.13u
X1272 SAR/a_11877_2399# SAR/sg13cmos5l_dfrbp_1_0.CLK vdd vdd sg13_lv_pmos ad=0.4088p pd=2.97u as=1.777p ps=11.395u w=1.12u l=0.13u
X1273 vss SAR/sg13cmos5l_dfrbp_1_0.RESET_B SAR/a_11364_1626# vss sg13_lv_nmos ad=0.1626p pd=1.415u as=60.89999f ps=0.71u w=0.42u l=0.13u
X1274 vdd SAR/sg13cmos5l_dfrbp_1_6.RESET_B SAR/a_13641_7674# vdd sg13_lv_pmos ad=0.2128p pd=1.5u as=0.2128p ps=1.5u w=1.12u l=0.13u
X1275 vss SAR/a_14924_1590# nh_sw[6] vss sg13_lv_nmos ad=0.14875p pd=1.16u as=0.2886p ps=2.26u w=0.74u l=0.13u
X1276 SAR/a_2340_3456# SAR/a_2859_3260# SAR/a_3599_3215# vss sg13_lv_nmos ad=0.3473p pd=2.71u as=0.12665p ps=1.145u w=0.74u l=0.13u
X1277 vdd SAR/sg13cmos5l_dlhr_1_9.D SAR/a_10587_4692# vdd sg13_lv_pmos ad=0.2198p pd=1.53u as=0.2856p ps=2.36u w=0.84u l=0.13u
X1278 vdd vss vdd vdd sg13_lv_pmos ad=0.19p pd=1.38u as=0 ps=0 w=1u l=1u
X1279 vss SAR/sg13cmos5l_nor2_1_1.A SAR/sg13cmos5l_nor2b_1_1.Y vss sg13_lv_nmos ad=0.2516p pd=2.16u as=0.1406p ps=1.12u w=0.74u l=0.13u
X1280 vdd SAR/a_12719_2749# SAR/a_12976_2630# vdd sg13_lv_pmos ad=0.2639p pd=1.81u as=79.8f ps=0.8u w=0.42u l=0.13u
X1281 SAR/sg13cmos5l_dfrbp_1_18.Q_N SAR/a_7247_8797# vdd vdd sg13_lv_pmos ad=0.4312p pd=3.01u as=0.2639p ps=1.81u w=1.12u l=0.13u
X1282 vss SAR/sg13cmos5l_or2_1_1.B SAR/a_10726_5760# vss sg13_lv_nmos ad=0.2516p pd=2.16u as=0.1406p ps=1.12u w=0.74u l=0.13u
X1283 SAR/sg13cmos5l_dfrbp_1_14.Q_N SAR/a_4847_4727# vss vss sg13_lv_nmos ad=0.2849p pd=2.25u as=0.2516p ps=2.16u w=0.74u l=0.13u
X1284 SAR/a_12716_8400# SAR/sg13cmos5l_buf_1_79.X vdd vdd sg13_lv_pmos ad=0.2856p pd=2.36u as=0.2114p ps=1.54u w=0.84u l=0.13u
X1285 SAR/a_17751_7690# SAR/sg13cmos5l_dfrbp_1_22.D vdd vdd sg13_lv_pmos ad=0.3234p pd=2.45u as=1.12242p ps=7u w=0.84u l=0.13u
X1286 SAR/sg13cmos5l_nor2b_1_1.Y SAR/sg13cmos5l_nor2_1_1.A SAR/a_14476_2388# vdd sg13_lv_pmos ad=0.3808p pd=2.92u as=0.1176p ps=1.33u w=1.12u l=0.13u
X1287 vdd SAR/a_7055_4261# SAR/a_7892_3900# vdd sg13_lv_pmos ad=0.2128p pd=1.5u as=0.3864p ps=2.93u w=1.12u l=0.13u
X1288 vdd SAR/a_5132_9150# SAR/sg13cmos5l_buf_1_64.A vdd sg13_lv_pmos ad=0.2114p pd=1.54u as=0.42p ps=2.99u w=1.12u l=0.13u
X1289 SAR/sg13cmos5l_inv_1_7.A SAR/a_11464_8436# vdd vdd sg13_lv_pmos ad=0.42p pd=2.99u as=0.2114p ps=1.54u w=1.12u l=0.13u
X1290 SAR/a_6789_4629# SAR/sg13cmos5l_inv_1_8.A vss vss sg13_lv_nmos ad=0.2516p pd=2.16u as=2.27517p ps=14.72u w=0.74u l=0.13u
X1291 vss SAR/sg13cmos5l_dlhr_1_15.Q SAR/a_19240_7712# vss sg13_lv_nmos ad=0.14875p pd=1.16u as=0.187p ps=1.78u w=0.55u l=0.13u
X1292 SAR/sg13cmos5l_buf_1_5.X SAR/a_14440_1664# vss vss sg13_lv_nmos ad=0.2886p pd=2.26u as=0.14875p ps=1.16u w=0.74u l=0.13u
X1293 vss SAR/sg13cmos5l_dfrbp_1_0.RESET_B SAR/a_13092_3138# vss sg13_lv_nmos ad=0.1626p pd=1.415u as=60.89999f ps=0.71u w=0.42u l=0.13u
X1294 SAR/a_1196_8400# SAR/sg13cmos5l_buf_1_63.A vdd vdd sg13_lv_pmos ad=0.2856p pd=2.36u as=0.2114p ps=1.54u w=0.84u l=0.13u
X1295 vdd SAR/sg13cmos5l_dfrbp_1_6.RESET_B SAR/a_9033_6162# vdd sg13_lv_pmos ad=0.2128p pd=1.5u as=0.2128p ps=1.5u w=1.12u l=0.13u
X1296 SAR/a_12022_3134# SAR/sg13cmos5l_o21ai_1_0.A2 vss vss sg13_lv_nmos ad=0.1406p pd=1.12u as=0.1406p ps=1.12u w=0.74u l=0.15u
X1297 SAR/a_18345_7674# SAR/a_18164_7996# vdd vdd sg13_lv_pmos ad=0.2128p pd=1.5u as=0.2387p ps=1.84u w=1.12u l=0.13u
X1298 vdd SAR/a_8247_5770# SAR/a_8378_5776# vdd sg13_lv_pmos ad=1.28962p pd=8.195u as=0.2856p ps=2.36u w=0.84u l=0.13u
X1299 vdd SAR/a_19628_2352# nh_sw[9] vdd sg13_lv_pmos ad=0.2114p pd=1.54u as=0.42p ps=2.99u w=1.12u l=0.13u
X1300 vdd SAR/a_19216_3358# SAR/a_19161_3453# vdd sg13_lv_pmos ad=1.43437p pd=9.105u as=93.45f ps=0.865u w=0.42u l=0.13u
X1301 SAR/sg13cmos5l_dfrbp_1_6.D SAR/a_1672_3176# vdd vdd sg13_lv_pmos ad=0.42p pd=2.99u as=0.2114p ps=1.54u w=1.12u l=0.13u
X1302 vdd SAR/sg13cmos5l_buf_1_24.A SAR/sg13cmos5l_buf_1_78.A vdd sg13_lv_pmos ad=0.3808p pd=2.92u as=0.3808p ps=2.92u w=1.12u l=0.13u
X1303 vdd SAR/sg13cmos5l_buf_1_18.A SAR/a_18376_2388# vdd sg13_lv_pmos ad=0.2114p pd=1.54u as=0.2856p ps=2.36u w=0.84u l=0.13u
X1304 vss SAR/sg13cmos5l_dfrbp_1_10.Q_N SAR/a_3241_2746# vss sg13_lv_nmos ad=0.15055p pd=1.17u as=0.187p ps=1.78u w=0.55u l=0.13u
X1305 vdd SAR/a_10031_8797# SAR/a_10288_8678# vdd sg13_lv_pmos ad=0.2639p pd=1.81u as=79.8f ps=0.8u w=0.42u l=0.13u
X1306 SAR/a_8660_5412# SAR/a_8378_5776# SAR/a_8593_5814# vss sg13_lv_nmos ad=0.141p pd=1.17u as=71.99999f ps=0.865u w=0.64u l=0.13u
X1307 SAR/a_5962_8404# SAR/a_6405_8447# SAR/a_6345_8483# vdd sg13_lv_pmos ad=79.8f pd=0.8u as=63f ps=0.72u w=0.42u l=0.13u
X1308 SAR/a_17700_3456# SAR/a_18219_3260# SAR/a_18959_3215# vss sg13_lv_nmos ad=0.3473p pd=2.71u as=0.12665p ps=1.145u w=0.74u l=0.13u
X1309 SAR/a_17776_6382# SAR/a_17519_6239# SAR/a_17938_6162# vss sg13_lv_nmos ad=0.1428p pd=1.52u as=37.8f ps=0.6u w=0.42u l=0.13u
X1310 vss SAR/sg13cmos5l_buf_1_41.X SAR/a_2824_2388# vss sg13_lv_nmos ad=0.14875p pd=1.16u as=0.187p ps=1.78u w=0.55u l=0.13u
X1311 SAR/a_10420_5760# SAR/sg13cmos5l_dfrbp_1_16.Q vss vss sg13_lv_nmos ad=0.1406p pd=1.12u as=0.1406p ps=1.12u w=0.74u l=0.13u
X1312 SAR/sg13cmos5l_dfrbp_1_1.Q SAR/a_13652_1924# vdd vdd sg13_lv_pmos ad=0.3808p pd=2.92u as=0.2128p ps=1.5u w=1.12u l=0.13u
X1313 vdd SAR/a_11372_3102# nh_sw[5] vdd sg13_lv_pmos ad=0.2114p pd=1.54u as=0.42p ps=2.99u w=1.12u l=0.13u
X1314 SAR/a_4358_6924# SAR/a_3962_7288# SAR/a_4244_6924# vdd sg13_lv_pmos ad=0.1008p pd=0.9u as=0.191p ps=1.44u w=0.42u l=0.13u
X1315 vss vdd vss vss sg13_lv_nmos ad=0.1428p pd=1.52u as=0 ps=0 w=0.42u l=1u
X1316 vss SAR/sg13cmos5l_dfrbp_1_12.Q_N SAR/a_8905_4704# vss sg13_lv_nmos ad=0.15055p pd=1.17u as=0.187p ps=1.78u w=0.55u l=0.13u
X1317 SAR/a_8439_6178# SAR/sg13cmos5l_dlhr_1_5.GATE vss vss sg13_lv_nmos ad=0.2516p pd=2.16u as=0.15055p ps=1.17u w=0.74u l=0.13u
X1318 SAR/a_682_6892# SAR/a_1125_6935# SAR/a_422_7362# vss sg13_lv_nmos ad=79.8f pd=0.8u as=0.1296p ps=1.52u w=0.42u l=0.13u
X1319 vss SAR/a_8841_5769# SAR/a_8796_5814# vss sg13_lv_nmos ad=0.1428p pd=1.52u as=47.25f ps=0.645u w=0.42u l=0.13u
X1320 SAR/a_1956_8874# SAR/sg13cmos5l_dfrbp_1_17.D SAR/a_1862_8874# vss sg13_lv_nmos ad=60.89999f pd=0.71u as=0.1428p ps=1.52u w=0.42u l=0.13u
X1321 SAR/a_5324_1590# SAR/sg13cmos5l_buf_1_34.X vss vss sg13_lv_nmos ad=0.187p pd=1.78u as=0.14875p ps=1.16u w=0.55u l=0.13u
X1322 vdd SAR/a_7497_3138# SAR/a_7430_3576# vdd sg13_lv_pmos ad=0.2387p pd=1.84u as=0.1008p ps=0.9u w=0.42u l=0.13u
X1323 vdd SAR/sg13cmos5l_dfrbp_1_10.Q SAR/a_10331_3900# vdd sg13_lv_pmos ad=0.2128p pd=1.5u as=0.2128p ps=1.5u w=1.12u l=0.13u
X1324 vss vdd vss vss sg13_lv_nmos ad=79.8f pd=0.8u as=0 ps=0 w=0.42u l=1u
X1325 vdd SAR/sg13cmos5l_inv_1_0.A SAR/sg13cmos5l_inv_1_0.Y vdd sg13_lv_pmos ad=0.3808p pd=2.92u as=0.3808p ps=2.92u w=1.12u l=0.13u
X1326 SAR/sg13cmos5l_nand2_1_1.A SAR/a_15380_3436# vdd vdd sg13_lv_pmos ad=0.3808p pd=2.92u as=0.2128p ps=1.5u w=1.12u l=0.13u
X1327 vdd SAR/sg13cmos5l_dfrbp_1_6.RESET_B SAR/a_14726_7674# vdd sg13_lv_pmos ad=0.36237p pd=2.605u as=79.8f ps=0.8u w=0.42u l=0.13u
X1328 SAR/sg13cmos5l_a22oi_1_0.B1 SAR/sg13cmos5l_nand2_1_0.A vdd vdd sg13_lv_pmos ad=0.2128p pd=1.5u as=0.3808p ps=2.92u w=1.12u l=0.13u
X1329 SAR/sg13cmos5l_dlhr_1_16.Q_N SAR/a_19734_5842# vdd vdd sg13_lv_pmos ad=0.3808p pd=2.92u as=0.1974p ps=1.5u w=1.12u l=0.13u
X1330 SAR/sg13cmos5l_dlhr_1_10.Q_N SAR/a_20118_6144# vss vss sg13_lv_nmos ad=0.2516p pd=2.16u as=0.1491p ps=1.18u w=0.74u l=0.13u
X1331 SAR/a_2748_6126# SAR/a_2879_6432# SAR/a_1997_6126# vdd sg13_lv_pmos ad=0.34p pd=2.68u as=0.2048p ps=1.63u w=1u l=0.13u
X1332 SAR/sg13cmos5l_dfrbp_1_5.Q_N SAR/a_16751_2749# vdd vdd sg13_lv_pmos ad=0.4312p pd=3.01u as=0.2639p ps=1.81u w=1.12u l=0.13u
X1333 SAR/a_20012_1590# SAR/sg13cmos5l_buf_1_0.A vdd vdd sg13_lv_pmos ad=0.2856p pd=2.36u as=0.2114p ps=1.54u w=0.84u l=0.13u
X1334 SAR/a_14924_1590# SAR/sg13cmos5l_buf_1_6.A vdd vdd sg13_lv_pmos ad=0.2856p pd=2.36u as=0.2114p ps=1.54u w=0.84u l=0.13u
X1335 SAR/a_11556_3904# SAR/a_12075_3911# SAR/a_12815_4261# vss sg13_lv_nmos ad=0.3473p pd=2.71u as=0.12665p ps=1.145u w=0.74u l=0.13u
X1336 SAR/a_11072_5347# SAR/sg13cmos5l_dlhr_1_15.D vdd vdd sg13_lv_pmos ad=0.1596p pd=1.22u as=0.36195p ps=1.84u w=0.84u l=0.13u
X1337 vdd SAR/a_15702_4187# SAR/sg13cmos5l_and3_1_0.C vdd sg13_lv_pmos ad=0.2128p pd=1.5u as=0.3808p ps=2.92u w=1.12u l=0.13u
X1338 SAR/a_5132_9150# SAR/sg13cmos5l_buf_1_44.X vdd vdd sg13_lv_pmos ad=0.2856p pd=2.36u as=0.2114p ps=1.54u w=0.84u l=0.13u
X1339 SAR/a_14342_8874# SAR/a_15147_8447# SAR/a_14602_8404# vdd sg13_lv_pmos ad=0.1428p pd=1.52u as=79.8f ps=0.8u w=0.42u l=0.13u
X1340 SAR/a_4244_6924# SAR/a_3962_7288# SAR/a_4177_7326# vss sg13_lv_nmos ad=0.141p pd=1.17u as=71.99999f ps=0.865u w=0.64u l=0.13u
X1341 vdd SAR/a_18999_6178# SAR/a_19130_6172# vdd sg13_lv_pmos ad=1.07253p pd=6.75u as=0.2856p ps=2.36u w=0.84u l=0.13u
X1342 SAR/sg13cmos5l_dfrbp_1_8.RESET_B _cks vdd vdd sg13_lv_pmos ad=0.3808p pd=2.92u as=0.3808p ps=2.92u w=1.12u l=0.13u
X1343 vss SAR/a_3407_4261# SAR/a_4244_3900# vss sg13_lv_nmos ad=0.1406p pd=1.12u as=0.2516p ps=2.16u w=0.74u l=0.13u
X1344 SAR/a_2436_8861# SAR/a_2148_8440# SAR/a_2374_8861# vss sg13_lv_nmos ad=0.1428p pd=1.52u as=37.8f ps=0.6u w=0.42u l=0.13u
X1345 vdd SAR/sg13cmos5l_dfrbp_1_6.RESET_B SAR/a_14889_7281# vdd sg13_lv_pmos ad=0.2128p pd=1.5u as=0.2128p ps=1.5u w=1.12u l=0.13u
X1346 SAR/sg13cmos5l_buf_1_4.X SAR/a_16552_1664# vss vss sg13_lv_nmos ad=0.2886p pd=2.26u as=0.14875p ps=1.16u w=0.74u l=0.13u
X1347 SAR/a_6213_3911# SAR/sg13cmos5l_dfrbp_1_11.Q vss vss sg13_lv_nmos ad=0.2516p pd=2.16u as=2.41737p ps=15.64u w=0.74u l=0.13u
X1348 SAR/a_2160_4972# SAR/a_1609_4704# vdd vdd sg13_lv_pmos ad=0.105p pd=1.21u as=1.28962p ps=8.195u w=1u l=0.13u
X1349 SAR/a_5637_2399# SAR/sg13cmos5l_dlhr_1_0.GATE vss vss sg13_lv_nmos ad=0.2516p pd=2.16u as=2.59257p ps=16.445u w=0.74u l=0.13u
X1350 vss SAR/sg13cmos5l_dfrbp_1_6.RESET_B SAR/a_16068_6162# vss sg13_lv_nmos ad=0.1626p pd=1.415u as=60.89999f ps=0.71u w=0.42u l=0.13u
X1351 SAR/sg13cmos5l_buf_1_111.A SAR/a_19240_7712# vdd vdd sg13_lv_pmos ad=0.42p pd=2.99u as=0.2114p ps=1.54u w=1.12u l=0.13u
X1352 vdd _cks SAR/sg13cmos5l_dfrbp_1_6.RESET_B vdd sg13_lv_pmos ad=0.3808p pd=2.92u as=0.2184p ps=1.51u w=1.12u l=0.13u
X1353 SAR/sg13cmos5l_dlhr_1_0.GATE SAR/a_5684_4948# vss vss sg13_lv_nmos ad=0.2516p pd=2.16u as=0.1406p ps=1.12u w=0.74u l=0.13u
X1354 vss SAR/sg13cmos5l_buf_1_68.X SAR/a_616_9224# vss sg13_lv_nmos ad=0.14875p pd=1.16u as=0.187p ps=1.78u w=0.55u l=0.13u
X1355 SAR/a_14962_3138# SAR/sg13cmos5l_dfrbp_1_0.RESET_B vss vss sg13_lv_nmos ad=37.8f pd=0.6u as=79.8f ps=0.8u w=0.42u l=0.13u
X1356 SAR/sg13cmos5l_dlhr_1_5.D SAR/a_6959_6239# vdd vdd sg13_lv_pmos ad=0.4312p pd=3.01u as=0.2639p ps=1.81u w=1.12u l=0.13u
X1357 SAR/a_4847_4727# SAR/a_4005_4629# SAR/a_4753_4727# vss sg13_lv_nmos ad=0.12665p pd=1.145u as=0.1428p ps=1.52u w=0.42u l=0.13u
X1358 SAR/a_15206_2826# SAR/a_16011_2399# SAR/a_15466_2356# vdd sg13_lv_pmos ad=0.1428p pd=1.52u as=79.8f ps=0.8u w=0.42u l=0.13u
X1359 SAR/sg13cmos5l_o21ai_1_0.B1 SAR/sg13cmos5l_nand2_1_1.B vdd vdd sg13_lv_pmos ad=0.2128p pd=1.5u as=0.3808p ps=2.92u w=1.12u l=0.13u
X1360 SAR/a_19164_5814# SAR/a_18615_5770# SAR/a_19028_5412# vss sg13_lv_nmos ad=47.25f pd=0.645u as=0.141p ps=1.17u w=0.42u l=0.13u
X1361 SAR/sg13cmos5l_or2_1_1.B SAR/sg13cmos5l_nor2_1_0.A vss vss sg13_lv_nmos ad=0.1406p pd=1.12u as=0.2516p ps=2.16u w=0.74u l=0.13u
X1362 vss SAR/sg13cmos5l_buf_1_110.A SAR/a_15784_9224# vss sg13_lv_nmos ad=0.14875p pd=1.16u as=0.187p ps=1.78u w=0.55u l=0.13u
X1363 vss SAR/a_14900_2352# SAR/sg13cmos5l_nand2_1_0.A vss sg13_lv_nmos ad=0.17255p pd=1.25u as=0.1406p ps=1.12u w=0.74u l=0.13u
X1364 vss SAR/sg13cmos5l_buf_1_7.A SAR/a_14056_1664# vss sg13_lv_nmos ad=0.14875p pd=1.16u as=0.187p ps=1.78u w=0.55u l=0.13u
X1365 vss SAR/sg13cmos5l_buf_1_105.A SAR/a_18856_8436# vss sg13_lv_nmos ad=0.14875p pd=1.16u as=0.187p ps=1.78u w=0.55u l=0.13u
X1366 vdd SAR/sg13cmos5l_buf_1_77.X SAR/a_7336_9224# vdd sg13_lv_pmos ad=0.2114p pd=1.54u as=0.2856p ps=2.36u w=0.84u l=0.13u
X1367 SAR/a_1846_7850# SAR/a_1948_7964# vss vss sg13_lv_nmos ad=0.187p pd=1.78u as=0.1491p ps=1.18u w=0.55u l=0.13u
X1368 SAR/a_3771_6553# SAR/a_2879_6432# SAR/a_3669_6320# vdd sg13_lv_pmos ad=63f pd=0.72u as=79.8f ps=0.8u w=0.42u l=0.13u
X1369 vss SAR/sg13cmos5l_dfrbp_1_8.RESET_B SAR/a_14436_8874# vss sg13_lv_nmos ad=0.1626p pd=1.415u as=60.89999f ps=0.71u w=0.42u l=0.13u
X1370 SAR/sg13cmos5l_dlhr_1_18.Q_N SAR/a_11190_7354# vss vss sg13_lv_nmos ad=0.2516p pd=2.16u as=0.1491p ps=1.18u w=0.74u l=0.13u
X1371 SAR/a_4847_4727# SAR/a_4005_4629# SAR/a_3588_4968# vdd sg13_lv_pmos ad=0.2048p pd=1.63u as=0.34p ps=2.68u w=1u l=0.13u
X1372 vss SAR/a_6188_1590# SAR/sg13cmos5l_buf_1_25.X vss sg13_lv_nmos ad=0.14875p pd=1.16u as=0.2886p ps=2.26u w=0.74u l=0.13u
X1373 vss SAR/sg13cmos5l_dlhr_1_1.GATE SAR/a_4349_7636# vss sg13_lv_nmos ad=0.15055p pd=1.17u as=0.2516p ps=2.16u w=0.74u l=0.13u
X1374 SAR/sg13cmos5l_dlhr_1_16.Q_N SAR/a_19734_5842# vss vss sg13_lv_nmos ad=0.2516p pd=2.16u as=0.1491p ps=1.18u w=0.74u l=0.13u
X1375 SAR/sg13cmos5l_dfrbp_1_21.Q SAR/a_18356_6460# vdd vdd sg13_lv_pmos ad=0.3808p pd=2.92u as=0.2128p ps=1.5u w=1.12u l=0.13u
X1376 vss SAR/sg13cmos5l_dfrbp_1_6.RESET_B SAR/a_15412_5800# vss sg13_lv_nmos ad=0.1406p pd=1.12u as=77.7f ps=0.95u w=0.74u l=0.13u
X1377 SAR/a_6647_5459# SAR/a_5951_5383# SAR/a_6741_5459# vss sg13_lv_nmos ad=0.1296p pd=1.52u as=79.8f ps=0.8u w=0.42u l=0.13u
X1378 vss SAR/a_7052_9150# SAR/sg13cmos5l_buf_1_76.X vss sg13_lv_nmos ad=0.14875p pd=1.16u as=0.2886p ps=2.26u w=0.74u l=0.13u
X1379 vss SAR/a_1878_6337# SAR/sg13cmos5l_dlhr_1_1.GATE vss sg13_lv_nmos ad=0.1406p pd=1.12u as=0.2516p ps=2.16u w=0.74u l=0.13u
X1380 vdd SAR/a_8439_6178# SAR/a_8570_6172# vdd sg13_lv_pmos ad=1.07253p pd=6.75u as=0.2856p ps=2.36u w=0.84u l=0.13u
X1381 SAR/a_9823_2780# SAR/sg13cmos5l_a22oi_1_2.B1 vss vss sg13_lv_nmos ad=0.13875p pd=1.115u as=0.2553p ps=2.17u w=0.74u l=0.13u
X1382 SAR/a_14295_7282# SAR/sg13cmos5l_dfrbp_1_23.CLK vss vss sg13_lv_nmos ad=0.2516p pd=2.16u as=0.15055p ps=1.17u w=0.74u l=0.13u
X1383 SAR/a_6741_5459# SAR/a_5799_5499# SAR/a_6647_5459# vdd sg13_lv_pmos ad=79.8f pd=0.8u as=0.1428p ps=1.52u w=0.42u l=0.13u
X1384 SAR/a_4276_2776# SAR/a_3860_2388# SAR/a_4041_2745# vss sg13_lv_nmos ad=77.7f pd=0.95u as=0.2516p ps=2.16u w=0.74u l=0.13u
X1385 vdd SAR/a_18345_7674# SAR/a_18870_7656# vdd sg13_lv_pmos ad=0.1974p pd=1.5u as=0.2856p ps=2.36u w=0.84u l=0.13u
X1386 vss SAR/a_18117_3117# SAR/a_18219_3260# vss sg13_lv_nmos ad=2.59257p pd=16.445u as=0.2516p ps=2.16u w=0.74u l=0.13u
X1387 vss SAR/sg13cmos5l_buf_1_8.A SAR/a_10888_1664# vss sg13_lv_nmos ad=0.14875p pd=1.16u as=0.187p ps=1.78u w=0.55u l=0.13u
X1388 SAR/sg13cmos5l_buf_8_0.A SAR/a_18480_5028# vdd vdd sg13_lv_pmos ad=0.3976p pd=2.95u as=0.2226p ps=1.535u w=1.12u l=0.13u
X1389 SAR/a_7941_7653# SAR/sg13cmos5l_dfrbp_1_18.Q vss vss sg13_lv_nmos ad=0.2516p pd=2.16u as=1.49685p ps=9.6u w=0.74u l=0.13u
X1390 SAR/a_8746_8404# SAR/a_9189_8447# SAR/a_9129_8483# vdd sg13_lv_pmos ad=79.8f pd=0.8u as=63f ps=0.72u w=0.42u l=0.13u
X1391 SAR/sg13cmos5l_dfrbp_1_16.Q_N SAR/a_1967_7285# vss vss sg13_lv_nmos ad=0.2849p pd=2.25u as=0.2516p ps=2.16u w=0.74u l=0.13u
X1392 SAR/sg13cmos5l_dlhr_1_5.Q SAR/a_8457_7281# vdd vdd sg13_lv_pmos ad=0.3808p pd=2.92u as=0.2128p ps=1.5u w=1.12u l=0.13u
X1393 SAR/sg13cmos5l_buf_1_8.A SAR/sg13cmos5l_inv_1_7.A vdd vdd sg13_lv_pmos ad=0.3808p pd=2.92u as=0.3808p ps=2.92u w=1.12u l=0.13u
X1394 SAR/a_8774_5412# SAR/a_8378_5776# SAR/a_8660_5412# vdd sg13_lv_pmos ad=0.1008p pd=0.9u as=0.191p ps=1.44u w=0.42u l=0.13u
X1395 SAR/sg13cmos5l_buf_1_89.A SAR/a_14889_7281# vss vss sg13_lv_nmos ad=0.2516p pd=2.16u as=0.1406p ps=1.12u w=0.74u l=0.13u
X1396 vss SAR/a_19593_6162# SAR/a_20118_6144# vss sg13_lv_nmos ad=0.1491p pd=1.18u as=0.187p ps=1.78u w=0.55u l=0.13u
X1397 vss SAR/sg13cmos5l_dfrbp_1_6.RESET_B SAR/a_5508_6162# vss sg13_lv_nmos ad=0.1626p pd=1.415u as=60.89999f ps=0.71u w=0.42u l=0.13u
X1398 vss SAR/a_11877_2399# SAR/a_11979_2399# vss sg13_lv_nmos ad=2.59257p pd=16.445u as=0.2516p ps=2.16u w=0.74u l=0.13u
X1399 SAR/a_3599_3215# SAR/a_2757_3117# SAR/a_3505_3215# vss sg13_lv_nmos ad=0.12665p pd=1.145u as=0.1428p ps=1.52u w=0.42u l=0.13u
X1400 SAR/a_18164_7996# SAR/a_17882_7684# SAR/a_18097_7666# vss sg13_lv_nmos ad=0.141p pd=1.17u as=71.99999f ps=0.865u w=0.64u l=0.13u
X1401 vdd vss vdd vdd sg13_lv_pmos ad=0.34p pd=2.68u as=0 ps=0 w=1u l=1u
X1402 SAR/a_10116_7674# SAR/sg13cmos5l_buf_1_57.X SAR/a_10022_7674# vss sg13_lv_nmos ad=60.89999f pd=0.71u as=0.1428p ps=1.52u w=0.42u l=0.13u
X1403 vdd SAR/a_17135_4727# SAR/a_17972_4948# vdd sg13_lv_pmos ad=0.2128p pd=1.5u as=0.3864p ps=2.93u w=1.12u l=0.13u
X1404 vdd _cks SAR/sg13cmos5l_dfrbp_1_6.RESET_B vdd sg13_lv_pmos ad=0.2128p pd=1.5u as=0.2128p ps=1.5u w=1.12u l=0.13u
X1405 vdd SAR/a_3407_4261# SAR/a_3664_4142# vdd sg13_lv_pmos ad=0.2639p pd=1.81u as=79.8f ps=0.8u w=0.42u l=0.13u
X1406 SAR/a_3562_4873# SAR/a_4005_4629# SAR/a_3945_5041# vdd sg13_lv_pmos ad=79.8f pd=0.8u as=63f ps=0.72u w=0.42u l=0.13u
X1407 SAR/a_4514_7666# SAR/a_4324_7996# SAR/a_4076_7624# vss sg13_lv_nmos ad=71.99999f pd=0.865u as=0.141p ps=1.17u w=0.64u l=0.13u
X1408 SAR/sg13cmos5l_dfrbp_1_8.Q_N SAR/a_17135_4727# vss vss sg13_lv_nmos ad=0.2849p pd=2.25u as=0.2516p ps=2.16u w=0.74u l=0.13u
X1409 vss SAR/sg13cmos5l_inv_1_1.A SAR/sg13cmos5l_buf_1_2.A vss sg13_lv_nmos ad=0.2516p pd=2.16u as=0.2516p ps=2.16u w=0.74u l=0.13u
X1410 vdd SAR/sg13cmos5l_dlhr_1_1.D SAR/a_1609_4704# vdd sg13_lv_pmos ad=1.28962p pd=8.195u as=0.2856p ps=2.36u w=0.84u l=0.13u
X1411 vdd SAR/sg13cmos5l_dfrbp_1_6.RESET_B SAR/a_15177_5769# vdd sg13_lv_pmos ad=0.2128p pd=1.5u as=0.2128p ps=1.5u w=1.12u l=0.13u
X1412 SAR/a_17584_7166# SAR/a_17327_7285# SAR/a_17746_7362# vss sg13_lv_nmos ad=0.1428p pd=1.52u as=37.8f ps=0.6u w=0.42u l=0.13u
X1413 vss SAR/a_1463_8741# SAR/a_1463_8741# vss sg13_lv_nmos ad=2.92392p pd=18.89u as=0.111p ps=1.34u w=0.3u l=0.13u
X1414 SAR/sg13cmos5l_buf_1_30.X SAR/a_8680_1664# vss vss sg13_lv_nmos ad=0.2886p pd=2.26u as=0.14875p ps=1.16u w=0.74u l=0.13u
X1415 SAR/a_13484_8400# SAR/sg13cmos5l_dlhr_1_11.Q vdd vdd sg13_lv_pmos ad=0.2856p pd=2.36u as=0.2114p ps=1.54u w=0.84u l=0.13u
X1416 vdd SAR/a_5104_4870# SAR/a_5049_4965# vdd sg13_lv_pmos ad=1.28962p pd=8.195u as=93.45f ps=0.865u w=0.42u l=0.13u
X1417 SAR/a_7498_7897# SAR/a_7941_7653# SAR/a_7881_8065# vdd sg13_lv_pmos ad=79.8f pd=0.8u as=63f ps=0.72u w=0.42u l=0.13u
X1418 SAR/a_908_1590# SAR/sg13cmos5l_buf_1_32.A vdd vdd sg13_lv_pmos ad=0.2856p pd=2.36u as=0.2114p ps=1.54u w=0.84u l=0.13u
X1419 SAR/a_11054_4292# SAR/sg13cmos5l_nand2_1_0.A SAR/sg13cmos5l_a22oi_1_0.Y vss sg13_lv_nmos ad=96.2f pd=1u as=0.2664p ps=1.46u w=0.74u l=0.13u
X1420 vss SAR/a_4172_1590# SAR/sg13cmos5l_buf_1_33.A vss sg13_lv_nmos ad=0.14875p pd=1.16u as=0.2886p ps=2.26u w=0.74u l=0.13u
X1421 SAR/a_1846_7850# SAR/a_1948_7964# vdd vdd sg13_lv_pmos ad=0.2856p pd=2.36u as=0.1974p ps=1.5u w=0.84u l=0.13u
X1422 vdd SAR/sg13cmos5l_dfrbp_1_6.RESET_B SAR/a_10282_7897# vdd sg13_lv_pmos ad=0.1563p pd=1.22u as=0.147p ps=1.54u w=0.42u l=0.13u
X1423 vdd SAR/a_16572_4261# SAR/a_17595_3947# vdd sg13_lv_pmos ad=0.1563p pd=1.22u as=63f ps=0.72u w=0.42u l=0.13u
X1424 vss SAR/sg13cmos5l_nand2_1_2.B SAR/a_1210_4654# vss sg13_lv_nmos ad=0.2516p pd=2.16u as=0.1406p ps=1.12u w=0.74u l=0.13u
X1425 vss SAR/a_13100_8400# pl_sw[6] vss sg13_lv_nmos ad=0.14875p pd=1.16u as=0.2886p ps=2.26u w=0.74u l=0.13u
X1426 SAR/sg13cmos5l_buf_1_6.A SAR/a_12520_3176# vdd vdd sg13_lv_pmos ad=0.42p pd=2.99u as=0.2114p ps=1.54u w=1.12u l=0.13u
X1427 ph_sw[0] SAR/a_616_9224# vdd vdd sg13_lv_pmos ad=0.42p pd=2.99u as=0.2114p ps=1.54u w=1.12u l=0.13u
X1428 SAR/sg13cmos5l_buf_1_3.X SAR/a_20296_1664# vss vss sg13_lv_nmos ad=0.2886p pd=2.26u as=0.14875p ps=1.16u w=0.74u l=0.13u
X1429 nl_sw[6] SAR/a_11656_3176# vss vss sg13_lv_nmos ad=0.2886p pd=2.26u as=0.14875p ps=1.16u w=0.74u l=0.13u
X1430 SAR/a_11782_1639# SAR/sg13cmos5l_dfrbp_1_0.RESET_B vss vss sg13_lv_nmos ad=37.8f pd=0.6u as=0.1701p ps=1.65u w=0.42u l=0.13u
X1431 SAR/sg13cmos5l_and3_1_0.X SAR/a_13324_4696# vss vss sg13_lv_nmos ad=0.2516p pd=2.16u as=0.1371p ps=1.12u w=0.74u l=0.13u
X1432 vss SAR/a_18999_6178# SAR/a_19130_6172# vss sg13_lv_nmos ad=1.97045p pd=12.335u as=0.2775p ps=2.23u w=0.74u l=0.13u
X1433 vss SAR/sg13cmos5l_dfrbp_1_8.RESET_B SAR/a_8580_8874# vss sg13_lv_nmos ad=0.1626p pd=1.415u as=60.89999f ps=0.71u w=0.42u l=0.13u
X1434 vdd SAR/sg13cmos5l_buf_1_44.X SAR/sg13cmos5l_buf_1_38.A vdd sg13_lv_pmos ad=0.3808p pd=2.92u as=0.3808p ps=2.92u w=1.12u l=0.13u
X1435 vdd SAR/a_3308_9150# SAR/sg13cmos5l_inv_1_8.A vdd sg13_lv_pmos ad=0.2114p pd=1.54u as=0.42p ps=2.99u w=1.12u l=0.13u
X1436 vdd SAR/a_20492_8400# pl_sw[10] vdd sg13_lv_pmos ad=0.2114p pd=1.54u as=0.42p ps=2.99u w=1.12u l=0.13u
X1437 SAR/sg13cmos5l_buf_1_103.A SAR/a_15784_9224# vdd vdd sg13_lv_pmos ad=0.42p pd=2.99u as=0.2114p ps=1.54u w=1.12u l=0.13u
X1438 SAR/sg13cmos5l_dlhr_1_6.D SAR/a_7796_6460# vdd vdd sg13_lv_pmos ad=0.3808p pd=2.92u as=0.2128p ps=1.5u w=1.12u l=0.13u
X1439 vdd SAR/a_18117_3117# SAR/a_18219_3260# vdd sg13_lv_pmos ad=1.43437p pd=9.105u as=0.3864p ps=2.93u w=1.12u l=0.13u
X1440 SAR/a_13593_9501# SAR/a_12651_9308# SAR/a_13391_9263# vdd sg13_lv_pmos ad=93.45f pd=0.865u as=0.2048p ps=1.63u w=0.42u l=0.13u
X1441 SAR/a_7524_7992# SAR/a_8043_7796# SAR/a_8783_7751# vss sg13_lv_nmos ad=0.3473p pd=2.71u as=0.12665p ps=1.145u w=0.74u l=0.13u
X1442 vss SAR/sg13cmos5l_dfrbp_1_6.RESET_B SAR/a_7924_1612# vss sg13_lv_nmos ad=0.1406p pd=1.12u as=77.7f ps=0.95u w=0.74u l=0.13u
X1443 SAR/a_5988_8440# SAR/a_5962_8404# vdd vdd sg13_lv_pmos ad=0.34p pd=2.68u as=0.36237p ps=2.605u w=1u l=0.13u
X1444 SAR/sg13cmos5l_buf_1_86.A SAR/a_20008_8436# vdd vdd sg13_lv_pmos ad=0.42p pd=2.99u as=0.2114p ps=1.54u w=1.12u l=0.13u
X1445 SAR/a_7941_7653# SAR/sg13cmos5l_dfrbp_1_18.Q vdd vdd sg13_lv_pmos ad=0.4088p pd=2.97u as=1.15047p ps=7.175u w=1.12u l=0.13u
X1446 vdd SAR/sg13cmos5l_buf_1_89.A SAR/a_15208_6200# vdd sg13_lv_pmos ad=0.2114p pd=1.54u as=0.2856p ps=2.36u w=0.84u l=0.13u
X1447 SAR/sg13cmos5l_dlhr_1_14.Q_N SAR/a_14166_7656# vdd vdd sg13_lv_pmos ad=0.3808p pd=2.92u as=0.1974p ps=1.5u w=1.12u l=0.13u
X1448 vss vdd vss vss sg13_lv_nmos ad=0.1428p pd=1.52u as=0 ps=0 w=0.42u l=1u
X1449 SAR/a_11556_3904# SAR/a_11530_3868# vss vss sg13_lv_nmos ad=0.2516p pd=2.16u as=0.1626p ps=1.415u w=0.74u l=0.13u
X1450 vss SAR/a_8457_7281# SAR/a_8982_7354# vss sg13_lv_nmos ad=0.1491p pd=1.18u as=0.187p ps=1.78u w=0.55u l=0.13u
X1451 SAR/a_5266_4650# SAR/sg13cmos5l_dfrbp_1_8.RESET_B vss vss sg13_lv_nmos ad=37.8f pd=0.6u as=79.8f ps=0.8u w=0.42u l=0.13u
X1452 SAR/sg13cmos5l_inv_1_3.A SAR/a_13768_8436# vdd vdd sg13_lv_pmos ad=0.42p pd=2.99u as=0.2114p ps=1.54u w=1.12u l=0.13u
X1453 SAR/sg13cmos5l_buf_1_19.X SAR/a_18760_2388# vdd vdd sg13_lv_pmos ad=0.42p pd=2.99u as=0.2114p ps=1.54u w=1.12u l=0.13u
X1454 SAR/sg13cmos5l_a22oi_1_1.B2 SAR/sg13cmos5l_and3_1_0.X SAR/a_13698_5412# vdd sg13_lv_pmos ad=0.3808p pd=2.92u as=0.2128p ps=1.5u w=1.12u l=0.13u
X1455 SAR/a_7441_1618# SAR/a_6889_1680# vss vss sg13_lv_nmos ad=71.99999f pd=0.865u as=7.01497p ps=46.005u w=0.64u l=0.13u
X1456 SAR/sg13cmos5l_buf_1_65.X SAR/a_424_8436# vss vss sg13_lv_nmos ad=0.2886p pd=2.26u as=0.14875p ps=1.16u w=0.74u l=0.13u
X1457 vss SAR/a_1846_7850# SAR/sg13cmos5l_dlhr_1_8.Q_N vss sg13_lv_nmos ad=0.1491p pd=1.18u as=0.2516p ps=2.16u w=0.74u l=0.13u
X1458 vss vdd vss vss sg13_lv_nmos ad=0.1428p pd=1.52u as=0 ps=0 w=0.42u l=1u
X1459 vss SAR/a_17776_6382# SAR/a_17425_6239# vss sg13_lv_nmos ad=79.8f pd=0.8u as=0.1428p ps=1.52u w=0.42u l=0.13u
X1460 SAR/a_4425_7281# SAR/a_4244_6924# vdd vdd sg13_lv_pmos ad=0.2128p pd=1.5u as=0.2387p ps=1.84u w=1.12u l=0.13u
X1461 SAR/a_9164_1590# SAR/sg13cmos5l_buf_1_26.A vdd vdd sg13_lv_pmos ad=0.2856p pd=2.36u as=0.2114p ps=1.54u w=0.84u l=0.13u
X1462 SAR/a_9823_2364# SAR/sg13cmos5l_a22oi_1_2.B2 SAR/sg13cmos5l_dfrbp_1_1.D vdd sg13_lv_pmos ad=0.2744p pd=1.61u as=0.2128p ps=1.5u w=1.12u l=0.13u
X1463 SAR/a_11973_3911# SAR/sg13cmos5l_dfrbp_1_0.CLK vdd vdd sg13_lv_pmos ad=0.4088p pd=2.97u as=1.38655p ps=8.8u w=1.12u l=0.13u
X1464 SAR/a_15012_7992# SAR/a_14986_7897# vdd vdd sg13_lv_pmos ad=0.34p pd=2.68u as=0.36237p ps=2.605u w=1u l=0.13u
X1465 vss SAR/a_3831_7282# SAR/a_3962_7288# vss sg13_lv_nmos ad=1.49685p pd=9.6u as=0.2775p ps=2.23u w=0.74u l=0.13u
X1466 vdd SAR/sg13cmos5l_dlhr_1_2.D SAR/a_6697_3192# vdd sg13_lv_pmos ad=1.43437p pd=9.105u as=0.2856p ps=2.36u w=0.84u l=0.13u
X1467 SAR/a_10331_1924# SAR/sg13cmos5l_nor2b_1_0.Y vdd vdd sg13_lv_pmos ad=0.3808p pd=2.92u as=0.2128p ps=1.5u w=1.12u l=0.13u
X1468 vss SAR/a_5132_3864# SAR/sg13cmos5l_buf_1_44.X vss sg13_lv_nmos ad=0.14875p pd=1.16u as=0.2886p ps=2.26u w=0.74u l=0.13u
X1469 SAR/a_3308_9150# SAR/sg13cmos5l_buf_1_65.X vdd vdd sg13_lv_pmos ad=0.2856p pd=2.36u as=0.2114p ps=1.54u w=0.84u l=0.13u
X1470 SAR/a_10233_8559# SAR/a_9291_8447# SAR/a_10031_8797# vdd sg13_lv_pmos ad=93.45f pd=0.865u as=0.2048p ps=1.63u w=0.42u l=0.13u
X1471 SAR/sg13cmos5l_dfrbp_1_16.Q SAR/a_2804_6924# vss vss sg13_lv_nmos ad=0.2516p pd=2.16u as=0.1406p ps=1.12u w=0.74u l=0.13u
X1472 vss SAR/a_8439_6178# SAR/a_8570_6172# vss sg13_lv_nmos ad=1.97045p pd=12.335u as=0.2775p ps=2.23u w=0.74u l=0.13u
X1473 SAR/sg13cmos5l_dfrbp_1_25.Q_N SAR/a_15887_8797# vss vss sg13_lv_nmos ad=0.2849p pd=2.25u as=0.2516p ps=2.16u w=0.74u l=0.13u
X1474 SAR/a_708_5416# SAR/a_682_5380# vdd vdd sg13_lv_pmos ad=0.34p pd=2.68u as=0.36237p ps=2.605u w=1u l=0.13u
X1475 SAR/a_7812_7687# SAR/a_8043_7796# SAR/a_7498_7897# vss sg13_lv_nmos ad=0.2373p pd=1.97u as=79.8f ps=0.8u w=0.42u l=0.13u
X1476 SAR/a_6736_2630# SAR/sg13cmos5l_dfrbp_1_6.RESET_B vdd vdd sg13_lv_pmos ad=79.8f pd=0.8u as=1.86162p ps=11.935u w=0.42u l=0.13u
X1477 ph_sw[10] SAR/a_20392_6924# vdd vdd sg13_lv_pmos ad=0.42p pd=2.99u as=0.2114p ps=1.54u w=1.12u l=0.13u
X1478 SAR/a_5194_2356# SAR/a_5637_2399# SAR/a_4934_2826# vss sg13_lv_nmos ad=79.8f pd=0.8u as=0.1296p ps=1.52u w=0.42u l=0.13u
X1479 vss SAR/sg13cmos5l_buf_1_44.X SAR/sg13cmos5l_buf_1_38.A vss sg13_lv_nmos ad=0.2516p pd=2.16u as=0.2516p ps=2.16u w=0.74u l=0.13u
X1480 SAR/a_16164_4663# SAR/a_15876_4968# SAR/a_16102_4663# vss sg13_lv_nmos ad=0.1428p pd=1.52u as=37.8f ps=0.6u w=0.42u l=0.13u
X1481 vss SAR/a_16940_3102# nh_sw[8] vss sg13_lv_nmos ad=0.14875p pd=1.16u as=0.2886p ps=2.26u w=0.74u l=0.13u
X1482 vdd SAR/sg13cmos5l_buf_1_64.A SAR/a_3976_9224# vdd sg13_lv_pmos ad=0.2114p pd=1.54u as=0.2856p ps=2.36u w=0.84u l=0.13u
X1483 SAR/a_15369_8065# SAR/a_15012_7992# vdd vdd sg13_lv_pmos ad=63f pd=0.72u as=0.1563p ps=1.22u w=0.42u l=0.13u
X1484 vdd SAR/sg13cmos5l_dfrbp_1_6.RESET_B SAR/a_682_5380# vdd sg13_lv_pmos ad=0.1563p pd=1.22u as=0.147p ps=1.54u w=0.42u l=0.13u
X1485 vss SAR/a_12933_6141# SAR/a_13035_6284# vss sg13_lv_nmos ad=1.97045p pd=12.335u as=0.2516p ps=2.16u w=0.74u l=0.13u
X1486 vss SAR/a_14543_3215# SAR/a_15380_3436# vss sg13_lv_nmos ad=0.1406p pd=1.12u as=0.2516p ps=2.16u w=0.74u l=0.13u
X1487 vdd SAR/a_1125_6935# SAR/a_1227_6935# vdd sg13_lv_pmos ad=1.07253p pd=6.75u as=0.3864p ps=2.93u w=1.12u l=0.13u
X1488 SAR/sg13cmos5l_buf_1_31.X SAR/a_424_1664# vdd vdd sg13_lv_pmos ad=0.42p pd=2.99u as=0.2114p ps=1.54u w=1.12u l=0.13u
X1489 SAR/a_13047_7690# SAR/sg13cmos5l_dlhr_1_11.GATE vdd vdd sg13_lv_pmos ad=0.3234p pd=2.45u as=1.12242p ps=7u w=0.84u l=0.13u
X1490 SAR/a_18096_7996# SAR/a_17545_7728# vdd vdd sg13_lv_pmos ad=0.105p pd=1.21u as=1.15047p ps=7.175u w=1u l=0.13u
X1491 SAR/sg13cmos5l_dfrbp_1_8.D SAR/a_18164_6924# vss vss sg13_lv_nmos ad=0.2516p pd=2.16u as=0.1406p ps=1.12u w=0.74u l=0.13u
X1492 vdd SAR/a_20204_5376# SAR/sg13cmos5l_inv_1_6.A vdd sg13_lv_pmos ad=0.2114p pd=1.54u as=0.42p ps=2.99u w=1.12u l=0.13u
X1493 SAR/a_2638_6477# SAR/a_2380_6162# vdd vdd sg13_lv_pmos ad=93.45f pd=0.865u as=1.07253p ps=6.75u w=0.42u l=0.13u
X1494 vss SAR/sg13cmos5l_buf_1_104.A SAR/a_19624_8436# vss sg13_lv_nmos ad=0.14875p pd=1.16u as=0.187p ps=1.78u w=0.55u l=0.13u
X1495 vdd SAR/a_20012_2352# nl_sw[10] vdd sg13_lv_pmos ad=0.2114p pd=1.54u as=0.42p ps=2.99u w=1.12u l=0.13u
X1496 SAR/a_2148_3904# SAR/a_2122_3868# vss vss sg13_lv_nmos ad=0.2516p pd=2.16u as=0.1626p ps=1.415u w=0.74u l=0.13u
X1497 SAR/a_3588_4968# SAR/a_3562_4873# vss vss sg13_lv_nmos ad=0.2516p pd=2.16u as=0.1626p ps=1.415u w=0.74u l=0.13u
X1498 vss SAR/a_2565_3911# SAR/a_2667_3911# vss sg13_lv_nmos ad=2.41737p pd=15.64u as=0.2516p ps=2.16u w=0.74u l=0.13u
X1499 SAR/a_14476_2388# SAR/a_14254_2444# vdd vdd sg13_lv_pmos ad=0.1176p pd=1.33u as=0.2618p ps=1.63u w=1.12u l=0.13u
X1500 vss SAR/sg13cmos5l_buf_1_116.A SAR/a_15592_6200# vss sg13_lv_nmos ad=0.14875p pd=1.16u as=0.187p ps=1.78u w=0.55u l=0.13u
X1501 SAR/a_10282_7897# SAR/a_10725_7653# SAR/a_10022_7674# vss sg13_lv_nmos ad=79.8f pd=0.8u as=0.1296p ps=1.52u w=0.42u l=0.13u
X1502 vss SAR/a_16748_9150# pl_sw[7] vss sg13_lv_nmos ad=0.14875p pd=1.16u as=0.2886p ps=2.26u w=0.74u l=0.13u
X1503 SAR/a_516_7362# SAR/sg13cmos5l_dfrbp_1_6.D SAR/a_422_7362# vss sg13_lv_nmos ad=60.89999f pd=0.71u as=0.1428p ps=1.52u w=0.42u l=0.13u
X1504 SAR/sg13cmos5l_dfrbp_1_4.Q_N SAR/a_12719_2749# vss vss sg13_lv_nmos ad=0.2849p pd=2.25u as=0.2516p ps=2.16u w=0.74u l=0.13u
X1505 SAR/a_1580_2352# SAR/sg13cmos5l_buf_1_40.X vss vss sg13_lv_nmos ad=0.187p pd=1.78u as=0.14875p ps=1.16u w=0.55u l=0.13u
X1506 SAR/sg13cmos5l_buf_1_56.A SAR/a_9033_6162# vss vss sg13_lv_nmos ad=0.2516p pd=2.16u as=0.1406p ps=1.12u w=0.74u l=0.13u
X1507 vss SAR/sg13cmos5l_dfrbp_1_23.Q SAR/a_14089_7282# vss sg13_lv_nmos ad=0.15055p pd=1.17u as=0.187p ps=1.78u w=0.55u l=0.13u
X1508 SAR/a_2342_5088# SAR/a_1946_4660# SAR/a_2228_4972# vdd sg13_lv_pmos ad=0.1008p pd=0.9u as=0.191p ps=1.44u w=0.42u l=0.13u
X1509 vdd SAR/a_11072_5347# SAR/sg13cmos5l_a221oi_1_1.C1 vdd sg13_lv_pmos ad=0.36195p pd=1.84u as=0.3808p ps=2.92u w=1.12u l=0.13u
X1510 SAR/a_8588_2352# SAR/sg13cmos5l_buf_1_26.X vdd vdd sg13_lv_pmos ad=0.2856p pd=2.36u as=0.2114p ps=1.54u w=0.84u l=0.13u
X1511 SAR/sg13cmos5l_nand2_1_1.B SAR/a_15357_1816# vdd vdd sg13_lv_pmos ad=0.2128p pd=1.5u as=0.3808p ps=2.92u w=1.12u l=0.13u
X1512 SAR/a_5674_6385# SAR/a_6117_6141# SAR/a_5414_6162# vss sg13_lv_nmos ad=79.8f pd=0.8u as=0.1296p ps=1.52u w=0.42u l=0.13u
X1513 vdd vss vdd vdd sg13_lv_pmos ad=0.19p pd=1.38u as=0 ps=0 w=1u l=1u
X1514 SAR/a_17392_4870# SAR/sg13cmos5l_dfrbp_1_8.RESET_B vdd vdd sg13_lv_pmos ad=79.8f pd=0.8u as=1.2517p ps=7.955u w=0.42u l=0.13u
X1515 vss SAR/a_8204_2352# SAR/sg13cmos5l_buf_1_24.A vss sg13_lv_nmos ad=0.14875p pd=1.16u as=0.2886p ps=2.26u w=0.74u l=0.13u
X1516 vss SAR/sg13cmos5l_buf_1_74.X SAR/a_6568_9224# vss sg13_lv_nmos ad=0.14875p pd=1.16u as=0.187p ps=1.78u w=0.55u l=0.13u
X1517 SAR/a_5628_3174# SAR/a_5079_3154# SAR/a_5492_3460# vss sg13_lv_nmos ad=47.25f pd=0.645u as=0.141p ps=1.17u w=0.42u l=0.13u
X1518 vdd SAR/sg13cmos5l_a22oi_1_0.Y SAR/sg13cmos5l_dfrbp_1_2.D vdd sg13_lv_pmos ad=0.3808p pd=2.92u as=0.3808p ps=2.92u w=1.12u l=0.13u
X1519 SAR/sg13cmos5l_or2_1_0.A SAR/a_18363_4270# vss vss sg13_lv_nmos ad=0.1406p pd=1.12u as=0.1406p ps=1.12u w=0.74u l=0.13u
X1520 SAR/a_15850_4873# SAR/a_16293_4629# SAR/a_16233_5041# vdd sg13_lv_pmos ad=79.8f pd=0.8u as=63f ps=0.72u w=0.42u l=0.13u
X1521 SAR/sg13cmos5l_buf_1_57.X SAR/a_9448_6924# vdd vdd sg13_lv_pmos ad=0.42p pd=2.99u as=0.2114p ps=1.54u w=1.12u l=0.13u
X1522 SAR/sg13cmos5l_buf_1_78.X SAR/a_6184_9224# vss vss sg13_lv_nmos ad=0.2886p pd=2.26u as=0.14875p ps=1.16u w=0.74u l=0.13u
X1523 SAR/sg13cmos5l_nor2_1_1.A SAR/a_17588_2388# vss vss sg13_lv_nmos ad=0.2516p pd=2.16u as=0.1406p ps=1.12u w=0.74u l=0.13u
X1524 SAR/a_11270_1626# SAR/a_12075_1748# SAR/a_11530_1849# vdd sg13_lv_pmos ad=0.1428p pd=1.52u as=79.8f ps=0.8u w=0.42u l=0.13u
X1525 vdd SAR/sg13cmos5l_dfrbp_1_6.RESET_B SAR/a_10022_7674# vdd sg13_lv_pmos ad=0.36237p pd=2.605u as=79.8f ps=0.8u w=0.42u l=0.13u
X1526 vdd SAR/a_5637_2399# SAR/a_5739_2399# vdd sg13_lv_pmos ad=1.86162p pd=11.935u as=0.3864p ps=2.93u w=1.12u l=0.13u
X1527 SAR/a_11460_2392# SAR/a_11979_2399# SAR/a_12719_2749# vss sg13_lv_nmos ad=0.3473p pd=2.71u as=0.12665p ps=1.145u w=0.74u l=0.13u
X1528 nh_sw[10] SAR/a_20392_3176# vdd vdd sg13_lv_pmos ad=0.42p pd=2.99u as=0.2114p ps=1.54u w=1.12u l=0.13u
X1529 SAR/a_16940_3102# SAR/sg13cmos5l_buf_1_4.X vdd vdd sg13_lv_pmos ad=0.2856p pd=2.36u as=0.2114p ps=1.54u w=0.84u l=0.13u
X1530 SAR/a_10094_2780# SAR/sg13cmos5l_inv_1_11.Y SAR/sg13cmos5l_dfrbp_1_1.D vss sg13_lv_nmos ad=96.2f pd=1u as=0.2664p ps=1.46u w=0.74u l=0.13u
X1531 vdd SAR/sg13cmos5l_nor2b_1_0.Y SAR/a_10783_3876# vdd sg13_lv_pmos ad=0.3808p pd=2.92u as=0.2744p ps=1.61u w=1.12u l=0.13u
X1532 SAR/a_11394_4948# SAR/sg13cmos5l_a221oi_1_0.B2 SAR/a_11182_4948# vdd sg13_lv_pmos ad=0.2128p pd=1.5u as=0.2128p ps=1.5u w=1.12u l=0.13u
X1533 SAR/a_16751_2749# SAR/a_15909_2399# SAR/a_16657_2749# vss sg13_lv_nmos ad=0.12665p pd=1.145u as=0.1428p ps=1.52u w=0.42u l=0.13u
X1534 SAR/a_620_2352# SAR/sg13cmos5l_buf_1_32.X vss vss sg13_lv_nmos ad=0.187p pd=1.78u as=0.14875p ps=1.16u w=0.55u l=0.13u
X1535 SAR/a_16144_8678# SAR/a_15887_8797# SAR/a_16306_8874# vss sg13_lv_nmos ad=0.1428p pd=1.52u as=37.8f ps=0.6u w=0.42u l=0.13u
X1536 vss SAR/sg13cmos5l_buf_8_1.A SAR/a_18363_4270# vss sg13_lv_nmos ad=0.1406p pd=1.12u as=0.1406p ps=1.12u w=0.74u l=0.13u
X1537 SAR/sg13cmos5l_dfrbp_1_27.Q_N SAR/a_10031_8797# vdd vdd sg13_lv_pmos ad=0.4312p pd=3.01u as=0.2639p ps=1.81u w=1.12u l=0.13u
X1538 SAR/a_3396_4650# SAR/sg13cmos5l_dfrbp_1_9.Q SAR/a_3302_4650# vss sg13_lv_nmos ad=60.89999f pd=0.71u as=0.1428p ps=1.52u w=0.42u l=0.13u
X1539 vss SAR/sg13cmos5l_buf_1_10.A SAR/sg13cmos5l_inv_1_28.Y vss sg13_lv_nmos ad=0.2516p pd=2.16u as=0.2516p ps=2.16u w=0.74u l=0.13u
X1540 SAR/sg13cmos5l_dlhr_1_11.Q SAR/a_13161_7281# vdd vdd sg13_lv_pmos ad=0.3808p pd=2.92u as=0.2128p ps=1.5u w=1.12u l=0.13u
X1541 vss SAR/a_1196_8400# SAR/sg13cmos5l_buf_1_63.X vss sg13_lv_nmos ad=0.14875p pd=1.16u as=0.2886p ps=2.26u w=0.74u l=0.13u
X1542 SAR/a_2224_5654# SAR/sg13cmos5l_dfrbp_1_6.RESET_B vdd vdd sg13_lv_pmos ad=79.8f pd=0.8u as=1.28962p ps=8.195u w=0.42u l=0.13u
X1543 SAR/sg13cmos5l_nand2_1_2.B SAR/sg13cmos5l_nor2_1_2.A vss vss sg13_lv_nmos ad=0.1406p pd=1.12u as=0.2516p ps=2.16u w=0.74u l=0.13u
X1544 vdd SAR/sg13cmos5l_inv_1_0.Y SAR/a_11182_4948# vdd sg13_lv_pmos ad=0.3808p pd=2.92u as=0.2128p ps=1.5u w=1.12u l=0.13u
X1545 SAR/a_10406_9624# SAR/a_10010_9196# SAR/a_10292_9508# vdd sg13_lv_pmos ad=0.1008p pd=0.9u as=0.191p ps=1.44u w=0.42u l=0.13u
X1546 SAR/sg13cmos5l_dfrbp_1_22.D SAR/a_16724_8436# vss vss sg13_lv_nmos ad=0.2516p pd=2.16u as=0.1406p ps=1.12u w=0.74u l=0.13u
X1547 SAR/sg13cmos5l_dlhr_1_12.D SAR/a_16271_7751# vss vss sg13_lv_nmos ad=0.2849p pd=2.25u as=0.2516p ps=2.16u w=0.74u l=0.13u
X1548 SAR/a_2314_3361# SAR/a_2757_3117# SAR/a_2054_3138# vss sg13_lv_nmos ad=79.8f pd=0.8u as=0.1296p ps=1.52u w=0.42u l=0.13u
X1549 vdd SAR/sg13cmos5l_dfrbp_1_8.RESET_B SAR/a_3562_4873# vdd sg13_lv_pmos ad=0.1563p pd=1.22u as=0.147p ps=1.54u w=0.42u l=0.13u
X1550 vdd SAR/a_15045_8447# SAR/a_15147_8447# vdd sg13_lv_pmos ad=1.15047p pd=7.175u as=0.3864p ps=2.93u w=1.12u l=0.13u
X1551 vdd SAR/a_4005_4629# SAR/a_4107_4772# vdd sg13_lv_pmos ad=1.28962p pd=8.195u as=0.3864p ps=2.93u w=1.12u l=0.13u
X1552 SAR/a_16356_7349# SAR/a_16068_6928# SAR/a_16294_7349# vss sg13_lv_nmos ad=0.1428p pd=1.52u as=37.8f ps=0.6u w=0.42u l=0.13u
X1553 SAR/sg13cmos5l_dfrbp_1_23.Q_N SAR/a_13775_6239# vdd vdd sg13_lv_pmos ad=0.4312p pd=3.01u as=0.2639p ps=1.81u w=1.12u l=0.13u
X1554 SAR/a_12933_6141# SAR/sg13cmos5l_dfrbp_1_23.CLK vdd vdd sg13_lv_pmos ad=0.4088p pd=2.97u as=1.04815p ps=6.595u w=1.12u l=0.13u
X1555 SAR/a_7216_6382# SAR/a_6959_6239# SAR/a_7378_6162# vss sg13_lv_nmos ad=0.1428p pd=1.52u as=37.8f ps=0.6u w=0.42u l=0.13u
X1556 vdd SAR/a_2748_6126# SAR/a_3771_6553# vdd sg13_lv_pmos ad=0.1563p pd=1.22u as=63f ps=0.72u w=0.42u l=0.13u
X1557 SAR/a_5796_3904# SAR/a_5770_3868# vss vss sg13_lv_nmos ad=0.2516p pd=2.16u as=0.1626p ps=1.415u w=0.74u l=0.13u
X1558 SAR/a_5926_6175# SAR/sg13cmos5l_dfrbp_1_6.RESET_B vss vss sg13_lv_nmos ad=37.8f pd=0.6u as=0.1701p ps=1.65u w=0.42u l=0.13u
X1559 SAR/a_5220_2392# SAR/a_5194_2356# vss vss sg13_lv_nmos ad=0.2516p pd=2.16u as=0.1626p ps=1.415u w=0.74u l=0.13u
X1560 SAR/a_13072_4142# SAR/sg13cmos5l_dfrbp_1_0.RESET_B vdd vdd sg13_lv_pmos ad=79.8f pd=0.8u as=1.38655p ps=8.8u w=0.42u l=0.13u
X1561 SAR/a_12216_5728# SAR/sg13cmos5l_dfrbp_1_21.Q vss vss sg13_lv_nmos ad=0.1045p pd=0.93u as=0.1469p ps=1.155u w=0.55u l=0.13u
X1562 vss SAR/a_17829_1605# SAR/a_17931_1748# vss sg13_lv_nmos ad=7.01497p pd=46.005u as=0.2516p ps=2.16u w=0.74u l=0.13u
X1563 vss SAR/a_13072_1846# SAR/a_12721_1703# vss sg13_lv_nmos ad=79.8f pd=0.8u as=0.1428p ps=1.52u w=0.42u l=0.13u
X1564 vss SAR/a_18860_9150# ph_sw[8] vss sg13_lv_nmos ad=0.14875p pd=1.16u as=0.2886p ps=2.26u w=0.74u l=0.13u
X1565 SAR/sg13cmos5l_buf_1_95.X SAR/a_12232_8436# vss vss sg13_lv_nmos ad=0.2886p pd=2.26u as=0.14875p ps=1.16u w=0.74u l=0.13u
X1566 vdd SAR/sg13cmos5l_buf_1_40.A SAR/a_1192_1664# vdd sg13_lv_pmos ad=0.2114p pd=1.54u as=0.2856p ps=2.36u w=0.84u l=0.13u
X1567 vdd SAR/a_17584_7166# SAR/a_17529_7047# vdd sg13_lv_pmos ad=1.07253p pd=6.75u as=93.45f ps=0.865u w=0.42u l=0.13u
X1568 vdd SAR/a_3212_1590# SAR/sg13cmos5l_buf_1_41.X vdd sg13_lv_pmos ad=0.2114p pd=1.54u as=0.42p ps=2.99u w=1.12u l=0.13u
X1569 SAR/a_14822_6924# SAR/a_14426_7288# SAR/a_14708_6924# vdd sg13_lv_pmos ad=0.1008p pd=0.9u as=0.191p ps=1.44u w=0.42u l=0.13u
X1570 SAR/sg13cmos5l_buf_1_4.A SAR/a_15592_6200# vdd vdd sg13_lv_pmos ad=0.42p pd=2.99u as=0.2114p ps=1.54u w=1.12u l=0.13u
X1571 vdd SAR/a_7247_8797# SAR/a_8084_8436# vdd sg13_lv_pmos ad=0.2128p pd=1.5u as=0.3864p ps=2.93u w=1.12u l=0.13u
X1572 SAR/a_9660_4686# SAR/a_9111_4666# SAR/a_9524_4972# vss sg13_lv_nmos ad=47.25f pd=0.645u as=0.141p ps=1.17u w=0.42u l=0.13u
X1573 SAR/a_6213_3911# SAR/sg13cmos5l_dfrbp_1_11.Q vdd vdd sg13_lv_pmos ad=0.4088p pd=2.97u as=1.43437p ps=9.105u w=1.12u l=0.13u
X1574 vdd vss vdd vdd sg13_lv_pmos ad=0.34p pd=2.68u as=0 ps=0 w=1u l=1u
X1575 SAR/a_17399_3947# SAR/sg13cmos5l_dfrbp_1_6.D SAR/a_18146_4338# vss sg13_lv_nmos ad=0.1428p pd=1.52u as=60.89999f ps=0.71u w=0.42u l=0.13u
X1576 SAR/a_17674_3361# SAR/a_18117_3117# SAR/a_17414_3138# vss sg13_lv_nmos ad=79.8f pd=0.8u as=0.1296p ps=1.52u w=0.42u l=0.13u
X1577 SAR/sg13cmos5l_dfrbp_1_14.Q_N SAR/a_4847_4727# vdd vdd sg13_lv_pmos ad=0.4312p pd=3.01u as=0.2639p ps=1.81u w=1.12u l=0.13u
X1578 SAR/sg13cmos5l_buf_1_87.A SAR/a_18376_9224# vss vss sg13_lv_nmos ad=0.2886p pd=2.26u as=0.14875p ps=1.16u w=0.74u l=0.13u
X1579 vdd SAR/sg13cmos5l_nand2_1_1.A SAR/a_20008_3900# vdd sg13_lv_pmos ad=0.2114p pd=1.54u as=0.2856p ps=2.36u w=0.84u l=0.13u
X1580 SAR/a_7622_2064# SAR/a_7226_1636# SAR/a_7508_1948# vdd sg13_lv_pmos ad=0.1008p pd=0.9u as=0.191p ps=1.44u w=0.42u l=0.13u
X1581 SAR/a_12420_9199# SAR/a_12651_9308# SAR/a_12106_9409# vss sg13_lv_nmos ad=0.2373p pd=1.97u as=79.8f ps=0.8u w=0.42u l=0.13u
X1582 vdd SAR/sg13cmos5l_inv_1_5.A SAR/sg13cmos5l_a22oi_1_1.A1 vdd sg13_lv_pmos ad=0.3808p pd=2.92u as=0.3808p ps=2.92u w=1.12u l=0.13u
X1583 vss SAR/sg13cmos5l_a22oi_1_0.Y SAR/sg13cmos5l_dfrbp_1_2.D vss sg13_lv_nmos ad=0.2516p pd=2.16u as=0.2516p ps=2.16u w=0.74u l=0.13u
X1584 SAR/a_10433_1652# SAR/sg13cmos5l_dlhr_1_0.D SAR/sg13cmos5l_a22oi_1_2.B1 vss sg13_lv_nmos ad=0.1406p pd=1.12u as=0.1406p ps=1.12u w=0.74u l=0.13u
X1585 SAR/a_3308_5376# SAR/sg13cmos5l_dlhr_1_1.Q vdd vdd sg13_lv_pmos ad=0.2856p pd=2.36u as=0.2114p ps=1.54u w=0.84u l=0.13u
X1586 ph_sw[4] SAR/a_6568_9224# vdd vdd sg13_lv_pmos ad=0.42p pd=2.99u as=0.2114p ps=1.54u w=1.12u l=0.13u
X1587 vss _cks SAR/sg13cmos5l_dfrbp_1_6.RESET_B vss sg13_lv_nmos ad=0.1406p pd=1.12u as=0.1406p ps=1.12u w=0.74u l=0.13u
X1588 SAR/a_12106_9409# SAR/a_12549_9165# SAR/a_12489_9577# vdd sg13_lv_pmos ad=79.8f pd=0.8u as=63f ps=0.72u w=0.42u l=0.13u
X1589 SAR/a_12719_2749# SAR/a_11877_2399# SAR/a_12625_2749# vss sg13_lv_nmos ad=0.12665p pd=1.145u as=0.1428p ps=1.52u w=0.42u l=0.13u
X1590 SAR/a_15780_2813# SAR/a_15492_2392# SAR/a_15718_2813# vss sg13_lv_nmos ad=0.1428p pd=1.52u as=37.8f ps=0.6u w=0.42u l=0.13u
X1591 SAR/a_2224_7166# SAR/a_1967_7285# SAR/a_2386_7362# vss sg13_lv_nmos ad=0.1428p pd=1.52u as=37.8f ps=0.6u w=0.42u l=0.13u
X1592 SAR/a_14708_6924# SAR/a_14426_7288# SAR/a_14641_7326# vss sg13_lv_nmos ad=0.141p pd=1.17u as=71.99999f ps=0.865u w=0.64u l=0.13u
X1593 SAR/a_9879_9202# SAR/sg13cmos5l_dfrbp_1_18.Q vdd vdd sg13_lv_pmos ad=0.3234p pd=2.45u as=4.11675p ps=27.17u w=0.84u l=0.13u
X1594 vss SAR/sg13cmos5l_dfrbp_1_6.RESET_B SAR/a_12324_6162# vss sg13_lv_nmos ad=0.1626p pd=1.415u as=60.89999f ps=0.71u w=0.42u l=0.13u
X1595 vdd SAR/a_13641_7674# SAR/a_14166_7656# vdd sg13_lv_pmos ad=0.1974p pd=1.5u as=0.2856p ps=2.36u w=0.84u l=0.13u
X1596 vdd SAR/sg13cmos5l_inv_1_1.A SAR/sg13cmos5l_buf_1_2.A vdd sg13_lv_pmos ad=0.3808p pd=2.92u as=0.3808p ps=2.92u w=1.12u l=0.13u
X1597 vdd SAR/sg13cmos5l_dfrbp_1_1.Q SAR/a_20392_2388# vdd sg13_lv_pmos ad=0.2114p pd=1.54u as=0.2856p ps=2.36u w=0.84u l=0.13u
X1598 SAR/sg13cmos5l_dfrbp_1_0.D SAR/sg13cmos5l_dfrbp_1_0.Q SAR/a_18122_2388# vdd sg13_lv_pmos ad=0.3808p pd=2.92u as=0.1176p ps=1.33u w=1.12u l=0.13u
X1599 vss SAR/sg13cmos5l_inv_1_0.A SAR/sg13cmos5l_nor2b_1_0.Y vss sg13_lv_nmos ad=0.2516p pd=2.16u as=0.1406p ps=1.12u w=0.74u l=0.13u
X1600 vdd SAR/a_17829_1605# SAR/a_17931_1748# vdd sg13_lv_pmos ad=1.86162p pd=11.935u as=0.3864p ps=2.93u w=1.12u l=0.13u
X1601 vdd SAR/a_4425_7281# SAR/a_4950_7354# vdd sg13_lv_pmos ad=0.1974p pd=1.5u as=0.2856p ps=2.36u w=0.84u l=0.13u
X1602 SAR/a_14745_3453# SAR/a_13803_3260# SAR/a_14543_3215# vdd sg13_lv_pmos ad=93.45f pd=0.865u as=0.2048p ps=1.63u w=0.42u l=0.13u
X1603 SAR/sg13cmos5l_inv_1_26.Y SAR/sg13cmos5l_buf_1_19.A vss vss sg13_lv_nmos ad=0.2516p pd=2.16u as=0.2516p ps=2.16u w=0.74u l=0.13u
X1604 vss vdd vss vss sg13_lv_nmos ad=0.1428p pd=1.52u as=0 ps=0 w=0.42u l=1u
X1605 SAR/sg13cmos5l_dlhr_1_10.Q SAR/a_19593_6162# vdd vdd sg13_lv_pmos ad=0.3808p pd=2.92u as=0.2128p ps=1.5u w=1.12u l=0.13u
X1606 SAR/a_11372_3102# SAR/sg13cmos5l_buf_1_9.A vss vss sg13_lv_nmos ad=0.187p pd=1.78u as=0.14875p ps=1.16u w=0.55u l=0.13u
X1607 vdd SAR/sg13cmos5l_dfrbp_1_8.RESET_B SAR/a_11846_9186# vdd sg13_lv_pmos ad=0.36237p pd=2.605u as=79.8f ps=0.8u w=0.42u l=0.13u
X1608 SAR/a_16572_4261# SAR/a_16703_3871# SAR/a_15821_3864# vdd sg13_lv_pmos ad=0.34p pd=2.68u as=0.2048p ps=1.63u w=1u l=0.13u
X1609 vdd SAR/sg13cmos5l_dfrbp_1_23.Q SAR/a_14089_7282# vdd sg13_lv_pmos ad=1.07253p pd=6.75u as=0.2856p ps=2.36u w=0.84u l=0.13u
X1610 vss SAR/a_16268_3102# nl_sw[8] vss sg13_lv_nmos ad=0.14875p pd=1.16u as=0.2886p ps=2.26u w=0.74u l=0.13u
X1611 vdd SAR/sg13cmos5l_dfrbp_1_6.RESET_B SAR/a_4934_2826# vdd sg13_lv_pmos ad=0.36237p pd=2.605u as=79.8f ps=0.8u w=0.42u l=0.13u
X1612 SAR/a_11270_4338# SAR/sg13cmos5l_dfrbp_1_2.D vdd vdd sg13_lv_pmos ad=79.8f pd=0.8u as=0.1428p ps=1.52u w=0.42u l=0.13u
X1613 SAR/a_13393_7666# SAR/a_12841_7728# vss vss sg13_lv_nmos ad=71.99999f pd=0.865u as=1.49685p ps=9.6u w=0.64u l=0.13u
X1614 vdd SAR/sg13cmos5l_buf_1_10.A SAR/sg13cmos5l_inv_1_28.Y vdd sg13_lv_pmos ad=0.3808p pd=2.92u as=0.3808p ps=2.92u w=1.12u l=0.13u
X1615 vss SAR/sg13cmos5l_dfrbp_1_1.Q SAR/sg13cmos5l_inv_1_11.Y vss sg13_lv_nmos ad=0.2516p pd=2.16u as=0.2516p ps=2.16u w=0.74u l=0.13u
X1616 SAR/a_12567_7282# SAR/sg13cmos5l_dlhr_1_11.GATE vss vss sg13_lv_nmos ad=0.2516p pd=2.16u as=0.15055p ps=1.17u w=0.74u l=0.13u
X1617 SAR/sg13cmos5l_buf_8_0.X SAR/a_19227_4654# vss vss sg13_lv_nmos ad=0.1406p pd=1.12u as=0.1406p ps=1.12u w=0.74u l=0.13u
X1618 vdd SAR/a_3676_7964# SAR/sg13cmos5l_dlhr_1_9.Q vdd sg13_lv_pmos ad=0.2128p pd=1.5u as=0.3808p ps=2.92u w=1.12u l=0.13u
X1619 SAR/sg13cmos5l_dfrbp_1_10.Q_N SAR/a_3599_3215# vdd vdd sg13_lv_pmos ad=0.4312p pd=3.01u as=0.2639p ps=1.81u w=1.12u l=0.13u
X1620 vdd SAR/a_6903_3154# SAR/a_7034_3148# vdd sg13_lv_pmos ad=1.43437p pd=9.105u as=0.2856p ps=2.36u w=0.84u l=0.13u
X1621 vdd SAR/sg13cmos5l_and3_1_0.C SAR/a_13324_4696# vdd sg13_lv_pmos ad=0.36195p pd=1.84u as=0.1596p ps=1.22u w=0.84u l=0.13u
X1622 nh_sw[2] SAR/a_3688_1664# vdd vdd sg13_lv_pmos ad=0.42p pd=2.99u as=0.2114p ps=1.54u w=1.12u l=0.13u
X1623 SAR/a_5324_1590# SAR/sg13cmos5l_buf_1_34.X vdd vdd sg13_lv_pmos ad=0.2856p pd=2.36u as=0.2114p ps=1.54u w=0.84u l=0.13u
X1624 SAR/a_13641_3529# SAR/a_13284_3456# vdd vdd sg13_lv_pmos ad=63f pd=0.72u as=0.1563p ps=1.22u w=0.42u l=0.13u
X1625 vdd SAR/a_15177_5769# SAR/a_15110_5412# vdd sg13_lv_pmos ad=0.2387p pd=1.84u as=0.1008p ps=0.9u w=0.42u l=0.13u
X1626 SAR/a_10596_7687# SAR/a_10308_7992# SAR/a_10534_7687# vss sg13_lv_nmos ad=0.1428p pd=1.52u as=37.8f ps=0.6u w=0.42u l=0.13u
X1627 SAR/sg13cmos5l_dlhr_1_11.Q SAR/a_13161_7281# vss vss sg13_lv_nmos ad=0.2516p pd=2.16u as=0.1406p ps=1.12u w=0.74u l=0.13u
X1628 vss SAR/a_1125_5423# SAR/a_1227_5423# vss sg13_lv_nmos ad=1.97045p pd=12.335u as=0.2516p ps=2.16u w=0.74u l=0.13u
X1629 vdd SAR/sg13cmos5l_buf_1_97.A SAR/a_11848_8436# vdd sg13_lv_pmos ad=0.2114p pd=1.54u as=0.2856p ps=2.36u w=0.84u l=0.13u
X1630 SAR/sg13cmos5l_dfrbp_1_23.Q SAR/a_14612_6460# vdd vdd sg13_lv_pmos ad=0.3808p pd=2.92u as=0.2128p ps=1.5u w=1.12u l=0.13u
X1631 vdd SAR/sg13cmos5l_dfrbp_1_6.RESET_B SAR/a_2409_4650# vdd sg13_lv_pmos ad=0.2128p pd=1.5u as=0.2128p ps=1.5u w=1.12u l=0.13u
X1632 SAR/sg13cmos5l_dfrbp_1_0.Q_N SAR/a_18671_1703# vdd vdd sg13_lv_pmos ad=0.4312p pd=3.01u as=0.2639p ps=1.81u w=1.12u l=0.13u
X1633 SAR/a_2786_7666# SAR/a_2596_7996# SAR/a_2348_7624# vss sg13_lv_nmos ad=71.99999f pd=0.865u as=0.141p ps=1.17u w=0.64u l=0.13u
X1634 SAR/sg13cmos5l_dfrbp_1_24.Q_N SAR/a_13391_9263# vdd vdd sg13_lv_pmos ad=0.4312p pd=3.01u as=0.2639p ps=1.81u w=1.12u l=0.13u
X1635 SAR/a_5069_5376# SAR/a_5799_5499# SAR/a_5820_5773# vss sg13_lv_nmos ad=0.12665p pd=1.145u as=0.3473p ps=2.71u w=0.74u l=0.13u
X1636 SAR/a_9202_7674# SAR/sg13cmos5l_dfrbp_1_6.RESET_B vss vss sg13_lv_nmos ad=37.8f pd=0.6u as=79.8f ps=0.8u w=0.42u l=0.13u
X1637 vdd SAR/a_11567_7751# SAR/a_12404_7972# vdd sg13_lv_pmos ad=0.2128p pd=1.5u as=0.3864p ps=2.93u w=1.12u l=0.13u
X1638 SAR/a_13792_5760# SAR/sg13cmos5l_or2_1_1.B SAR/sg13cmos5l_a22oi_1_1.B2 vss sg13_lv_nmos ad=0.1406p pd=1.12u as=0.2516p ps=2.16u w=0.74u l=0.13u
X1639 vss SAR/a_620_7638# pl_sw[0] vss sg13_lv_nmos ad=0.14875p pd=1.16u as=0.2886p ps=2.26u w=0.74u l=0.13u
X1640 SAR/a_8972_3864# SAR/sg13cmos5l_buf_1_45.A vdd vdd sg13_lv_pmos ad=0.2856p pd=2.36u as=0.2114p ps=1.54u w=0.84u l=0.13u
X1641 vss SAR/sg13cmos5l_inv_1_5.A SAR/sg13cmos5l_a22oi_1_1.A1 vss sg13_lv_nmos ad=0.2516p pd=2.16u as=0.2516p ps=2.16u w=0.74u l=0.13u
X1642 vdd SAR/sg13cmos5l_dlhr_1_10.Q SAR/a_19528_6924# vdd sg13_lv_pmos ad=0.2114p pd=1.54u as=0.2856p ps=2.36u w=0.84u l=0.13u
X1643 SAR/sg13cmos5l_a22oi_1_1.Y SAR/sg13cmos5l_a22oi_1_1.A1 SAR/a_14814_4292# vss sg13_lv_nmos ad=0.2664p pd=1.46u as=96.2f ps=1u w=0.74u l=0.13u
X1644 SAR/sg13cmos5l_or2_1_0.A SAR/a_18363_4270# vdd vdd sg13_lv_pmos ad=0.2128p pd=1.5u as=0.2128p ps=1.5u w=1.12u l=0.13u
X1645 vdd SAR/a_19227_4654# SAR/sg13cmos5l_buf_8_0.X vdd sg13_lv_pmos ad=0.2128p pd=1.5u as=0.2128p ps=1.5u w=1.12u l=0.13u
X1646 SAR/a_13072_1846# SAR/sg13cmos5l_dfrbp_1_0.RESET_B vdd vdd sg13_lv_pmos ad=79.8f pd=0.8u as=1.777p ps=11.395u w=0.42u l=0.13u
X1647 SAR/sg13cmos5l_dlhr_1_0.GATE SAR/a_5684_4948# vdd vdd sg13_lv_pmos ad=0.3808p pd=2.92u as=0.2128p ps=1.5u w=1.12u l=0.13u
X1648 SAR/a_15429_7653# SAR/sg13cmos5l_dfrbp_1_22.D vss vss sg13_lv_nmos ad=0.2516p pd=2.16u as=1.49685p ps=9.6u w=0.74u l=0.13u
X1649 SAR/sg13cmos5l_dfrbp_1_4.D SAR/a_10464_2427# SAR/a_10613_2758# vss sg13_lv_nmos ad=0.2516p pd=2.16u as=0.1406p ps=1.12u w=0.74u l=0.13u
X1650 SAR/a_10031_8797# SAR/a_9189_8447# SAR/a_8772_8440# vdd sg13_lv_pmos ad=0.2048p pd=1.63u as=0.34p ps=2.68u w=1u l=0.13u
X1651 vdd SAR/sg13cmos5l_buf_8_1.A SAR/a_18363_4270# vdd sg13_lv_pmos ad=0.2128p pd=1.5u as=0.2128p ps=1.5u w=1.12u l=0.13u
X1652 SAR/a_5796_3904# SAR/a_6315_3911# SAR/a_7055_4261# vss sg13_lv_nmos ad=0.3473p pd=2.71u as=0.12665p ps=1.145u w=0.74u l=0.13u
X1653 SAR/a_11488_4676# SAR/sg13cmos5l_a221oi_1_0.B1 SAR/sg13cmos5l_o21ai_1_0.A1 vss sg13_lv_nmos ad=0.1406p pd=1.12u as=0.2516p ps=2.16u w=0.74u l=0.13u
X1654 vss SAR/a_1997_6126# SAR/sg13cmos5l_dfrbp_1_15.Q_N vss sg13_lv_nmos ad=0.2516p pd=2.16u as=0.2849p ps=2.25u w=0.74u l=0.13u
X1655 vss SAR/a_7820_2352# SAR/sg13cmos5l_inv_1_14.A vss sg13_lv_nmos ad=0.14875p pd=1.16u as=0.2886p ps=2.26u w=0.74u l=0.13u
X1656 vdd SAR/a_6741_5459# SAR/a_5820_5773# vdd sg13_lv_pmos ad=0.36237p pd=2.605u as=0.34p ps=2.68u w=1u l=0.13u
X1657 vdd SAR/sg13cmos5l_buf_1_68.X SAR/a_616_9224# vdd sg13_lv_pmos ad=0.2114p pd=1.54u as=0.2856p ps=2.36u w=0.84u l=0.13u
X1658 vss SAR/a_16144_8678# SAR/a_15793_8797# vss sg13_lv_nmos ad=79.8f pd=0.8u as=0.1428p ps=1.52u w=0.42u l=0.13u
X1659 SAR/a_10308_7992# SAR/a_10282_7897# vdd vdd sg13_lv_pmos ad=0.34p pd=2.68u as=0.36237p ps=2.605u w=1u l=0.13u
X1660 vss SAR/sg13cmos5l_buf_1_25.X SAR/a_4456_1664# vss sg13_lv_nmos ad=0.14875p pd=1.16u as=0.187p ps=1.78u w=0.55u l=0.13u
X1661 SAR/a_15590_4650# SAR/sg13cmos5l_dfrbp_1_8.D vdd vdd sg13_lv_pmos ad=79.8f pd=0.8u as=0.1428p ps=1.52u w=0.42u l=0.13u
X1662 vdd SAR/a_6789_4629# SAR/a_6891_4772# vdd sg13_lv_pmos ad=1.28962p pd=8.195u as=0.3864p ps=2.93u w=1.12u l=0.13u
X1663 SAR/a_7504_8678# SAR/sg13cmos5l_dfrbp_1_8.RESET_B vdd vdd sg13_lv_pmos ad=79.8f pd=0.8u as=1.12242p ps=7u w=0.42u l=0.13u
X1664 SAR/a_650_3900# SAR/sg13cmos5l_nor2_1_2.A vdd vdd sg13_lv_pmos ad=0.1176p pd=1.33u as=0.4032p ps=2.96u w=1.12u l=0.13u
X1665 vss SAR/a_10665_7281# SAR/a_11190_7354# vss sg13_lv_nmos ad=0.1491p pd=1.18u as=0.187p ps=1.78u w=0.55u l=0.13u
X1666 SAR/a_11824_7894# SAR/sg13cmos5l_dfrbp_1_6.RESET_B vdd vdd sg13_lv_pmos ad=79.8f pd=0.8u as=1.12242p ps=7u w=0.42u l=0.13u
X1667 vdd SAR/sg13cmos5l_buf_1_110.A SAR/a_15784_9224# vdd sg13_lv_pmos ad=0.2114p pd=1.54u as=0.2856p ps=2.36u w=0.84u l=0.13u
X1668 SAR/a_11182_4676# SAR/sg13cmos5l_a221oi_1_0.A2 vss vss sg13_lv_nmos ad=0.1406p pd=1.12u as=0.2516p ps=2.16u w=0.74u l=0.13u
X1669 vss SAR/a_19209_5769# SAR/a_19734_5842# vss sg13_lv_nmos ad=0.1491p pd=1.18u as=0.187p ps=1.78u w=0.55u l=0.13u
X1670 SAR/sg13cmos5l_buf_1_107.X SAR/a_17896_9224# vdd vdd sg13_lv_pmos ad=0.42p pd=2.99u as=0.2114p ps=1.54u w=1.12u l=0.13u
X1671 vss SAR/a_8972_9150# SAR/sg13cmos5l_buf_1_77.X vss sg13_lv_nmos ad=0.14875p pd=1.16u as=0.2886p ps=2.26u w=0.74u l=0.13u
X1672 vdd SAR/sg13cmos5l_buf_1_7.A SAR/a_14056_1664# vdd sg13_lv_pmos ad=0.2114p pd=1.54u as=0.2856p ps=2.36u w=0.84u l=0.13u
X1673 vss SAR/a_11824_7894# SAR/a_11473_7751# vss sg13_lv_nmos ad=79.8f pd=0.8u as=0.1428p ps=1.52u w=0.42u l=0.13u
X1674 vss SAR/sg13cmos5l_dlhr_1_15.D SAR/a_17545_7728# vss sg13_lv_nmos ad=0.15055p pd=1.17u as=0.187p ps=1.78u w=0.55u l=0.13u
X1675 vss SAR/sg13cmos5l_dfrbp_1_6.RESET_B SAR/a_16298_4338# vss sg13_lv_nmos ad=79.8f pd=0.8u as=37.8f ps=0.6u w=0.42u l=0.13u
X1676 vdd SAR/sg13cmos5l_or2_1_1.B SAR/a_10420_5412# vdd sg13_lv_pmos ad=0.3808p pd=2.92u as=0.2128p ps=1.5u w=1.12u l=0.13u
X1677 SAR/sg13cmos5l_buf_8_0.X SAR/a_19227_4654# vss vss sg13_lv_nmos ad=0.1406p pd=1.12u as=0.1406p ps=1.12u w=0.74u l=0.13u
X1678 vss SAR/a_19227_9190# SAR/sg13cmos5l_buf_8_2.X vss sg13_lv_nmos ad=0.1406p pd=1.12u as=0.1406p ps=1.12u w=0.74u l=0.13u
X1679 vss SAR/a_17367_8794# SAR/a_17498_8800# vss sg13_lv_nmos ad=2.92392p pd=18.89u as=0.2775p ps=2.23u w=0.74u l=0.13u
X1680 vss SAR/a_10412_6126# SAR/sg13cmos5l_buf_1_29.A vss sg13_lv_nmos ad=0.14875p pd=1.16u as=0.2886p ps=2.26u w=0.74u l=0.13u
X1681 SAR/a_4950_5699# SAR/a_5069_5376# vdd vdd sg13_lv_pmos ad=0.3864p pd=2.93u as=0.2128p ps=1.5u w=1.12u l=0.13u
X1682 SAR/a_7216_6382# SAR/sg13cmos5l_dfrbp_1_6.RESET_B vdd vdd sg13_lv_pmos ad=79.8f pd=0.8u as=1.04815p ps=6.595u w=0.42u l=0.13u
X1683 vdd SAR/a_16528_7894# SAR/a_16473_7989# vdd sg13_lv_pmos ad=1.15047p pd=7.175u as=93.45f ps=0.865u w=0.42u l=0.13u
X1684 vdd vss vdd vdd sg13_lv_pmos ad=0.19p pd=1.38u as=0 ps=0 w=1u l=1u
X1685 SAR/a_11268_5760# SAR/sg13cmos5l_dlhr_1_15.D vss vss sg13_lv_nmos ad=0.1216p pd=1.02u as=0.1371p ps=1.12u w=0.64u l=0.13u
X1686 SAR/sg13cmos5l_inv_1_2.A SAR/a_8488_9224# vss vss sg13_lv_nmos ad=0.2886p pd=2.26u as=0.14875p ps=1.16u w=0.74u l=0.13u
X1687 SAR/a_7312_4142# SAR/sg13cmos5l_dfrbp_1_6.RESET_B vdd vdd sg13_lv_pmos ad=79.8f pd=0.8u as=1.38655p ps=8.8u w=0.42u l=0.13u
X1688 SAR/sg13cmos5l_o21ai_1_0.Y SAR/sg13cmos5l_o21ai_1_0.A2 SAR/a_12120_3456# vdd sg13_lv_pmos ad=0.2128p pd=1.5u as=0.2128p ps=1.5u w=1.12u l=0.15u
X1689 SAR/sg13cmos5l_buf_8_1.A SAR/a_17972_4948# vss vss sg13_lv_nmos ad=0.2516p pd=2.16u as=0.1406p ps=1.12u w=0.74u l=0.13u
X1690 SAR/sg13cmos5l_inv_1_26.Y SAR/sg13cmos5l_buf_1_19.A vdd vdd sg13_lv_pmos ad=0.3808p pd=2.92u as=0.3808p ps=2.92u w=1.12u l=0.13u
X1691 SAR/a_6479_2749# SAR/a_5637_2399# SAR/a_5220_2392# vdd sg13_lv_pmos ad=0.2048p pd=1.63u as=0.34p ps=2.68u w=1u l=0.13u
X1692 SAR/sg13cmos5l_buf_8_0.A SAR/a_18480_5028# vss vss sg13_lv_nmos ad=0.2516p pd=2.16u as=0.1469p ps=1.155u w=0.74u l=0.13u
X1693 vss SAR/sg13cmos5l_nor2_1_0.A SAR/sg13cmos5l_a221oi_1_0.C1 vss sg13_lv_nmos ad=0.2516p pd=2.16u as=0.1406p ps=1.12u w=0.74u l=0.13u
X1694 vss SAR/a_17008_2630# SAR/a_16657_2749# vss sg13_lv_nmos ad=79.8f pd=0.8u as=0.1428p ps=1.52u w=0.42u l=0.13u
X1695 SAR/sg13cmos5l_buf_1_8.X SAR/a_10888_1664# vdd vdd sg13_lv_pmos ad=0.42p pd=2.99u as=0.2114p ps=1.54u w=1.12u l=0.13u
X1696 SAR/a_11844_4325# SAR/a_12075_3911# SAR/a_11530_3868# vss sg13_lv_nmos ad=0.2373p pd=1.97u as=79.8f ps=0.8u w=0.42u l=0.13u
X1697 SAR/a_5510_4338# SAR/a_6315_3911# SAR/a_5770_3868# vdd sg13_lv_pmos ad=0.1428p pd=1.52u as=79.8f ps=0.8u w=0.42u l=0.13u
X1698 SAR/a_10708_9172# SAR/a_10292_9508# SAR/a_10473_9186# vss sg13_lv_nmos ad=77.7f pd=0.95u as=0.2516p ps=2.16u w=0.74u l=0.13u
X1699 SAR/a_2565_8447# SAR/sg13cmos5l_inv_1_8.A vss vss sg13_lv_nmos ad=0.2516p pd=2.16u as=2.71505p ps=17.54u w=0.74u l=0.13u
X1700 SAR/a_15012_7992# SAR/a_15531_7796# SAR/a_16271_7751# vss sg13_lv_nmos ad=0.3473p pd=2.71u as=0.12665p ps=1.145u w=0.74u l=0.13u
X1701 vdd SAR/sg13cmos5l_inv_1_8.A SAR/sg13cmos5l_inv_1_8.Y vdd sg13_lv_pmos ad=0.3808p pd=2.92u as=0.3808p ps=2.92u w=1.12u l=0.13u
X1702 vss SAR/a_9705_4650# SAR/a_10230_4632# vss sg13_lv_nmos ad=0.1491p pd=1.18u as=0.187p ps=1.78u w=0.55u l=0.13u
X1703 SAR/sg13cmos5l_buf_1_94.X SAR/a_15016_9224# vss vss sg13_lv_nmos ad=0.2886p pd=2.26u as=0.14875p ps=1.16u w=0.74u l=0.13u
X1704 vdd SAR/a_3692_9150# SAR/sg13cmos5l_buf_1_62.X vdd sg13_lv_pmos ad=0.2114p pd=1.54u as=0.42p ps=2.99u w=1.12u l=0.13u
X1705 vss SAR/a_6380_7638# pl_sw[3] vss sg13_lv_nmos ad=0.14875p pd=1.16u as=0.2886p ps=2.26u w=0.74u l=0.13u
X1706 SAR/a_19244_2352# SAR/sg13cmos5l_buf_1_18.X vss vss sg13_lv_nmos ad=0.187p pd=1.78u as=0.14875p ps=1.16u w=0.55u l=0.13u
X1707 SAR/a_15429_7653# SAR/sg13cmos5l_dfrbp_1_22.D vdd vdd sg13_lv_pmos ad=0.4088p pd=2.97u as=1.12242p ps=7u w=1.12u l=0.13u
X1708 vdd SAR/a_15887_8797# SAR/a_16144_8678# vdd sg13_lv_pmos ad=0.2639p pd=1.81u as=79.8f ps=0.8u w=0.42u l=0.13u
X1709 vdd SAR/sg13cmos5l_dfrbp_1_6.RESET_B SAR/a_7689_1626# vdd sg13_lv_pmos ad=0.2128p pd=1.5u as=0.2128p ps=1.5u w=1.12u l=0.13u
X1710 vdd SAR/sg13cmos5l_buf_1_8.A SAR/a_10888_1664# vdd sg13_lv_pmos ad=0.2114p pd=1.54u as=0.2856p ps=2.36u w=0.84u l=0.13u
X1711 SAR/a_10420_5412# SAR/sg13cmos5l_dfrbp_1_16.Q SAR/a_10318_5412# vdd sg13_lv_pmos ad=0.2128p pd=1.5u as=0.2128p ps=1.5u w=1.12u l=0.13u
X1712 SAR/a_1006_4167# SAR/a_1121_4166# vdd vdd sg13_lv_pmos ad=0.34p pd=2.68u as=0.2254p ps=1.53u w=1u l=0.5u
X1713 SAR/a_19227_4654# SAR/sg13cmos5l_buf_8_0.A vss vss sg13_lv_nmos ad=0.1406p pd=1.12u as=0.1406p ps=1.12u w=0.74u l=0.13u
X1714 vss SAR/a_18345_7674# SAR/a_18870_7656# vss sg13_lv_nmos ad=0.1491p pd=1.18u as=0.187p ps=1.78u w=0.55u l=0.13u
X1715 vss SAR/a_18959_3215# SAR/a_19796_3436# vss sg13_lv_nmos ad=0.1406p pd=1.12u as=0.2516p ps=2.16u w=0.74u l=0.13u
X1716 SAR/sg13cmos5l_dfrbp_1_8.Q_N SAR/a_17135_4727# vdd vdd sg13_lv_pmos ad=0.4312p pd=3.01u as=0.2639p ps=1.81u w=1.12u l=0.13u
X1717 vss SAR/a_18363_4270# SAR/sg13cmos5l_or2_1_0.A vss sg13_lv_nmos ad=0.1406p pd=1.12u as=0.1406p ps=1.12u w=0.74u l=0.13u
X1718 SAR/a_17386_1849# SAR/a_17829_1605# SAR/a_17769_2017# vdd sg13_lv_pmos ad=79.8f pd=0.8u as=63f ps=0.72u w=0.42u l=0.13u
X1719 vdd SAR/a_19227_4654# SAR/sg13cmos5l_buf_8_0.X vdd sg13_lv_pmos ad=0.2128p pd=1.5u as=0.2128p ps=1.5u w=1.12u l=0.13u
X1720 SAR/a_8247_5770# SAR/sg13cmos5l_dfrbp_1_11.Q vss vss sg13_lv_nmos ad=0.2516p pd=2.16u as=0.15055p ps=1.17u w=0.74u l=0.13u
X1721 SAR/sg13cmos5l_buf_8_2.X SAR/a_19227_9190# vdd vdd sg13_lv_pmos ad=0.2128p pd=1.5u as=0.2128p ps=1.5u w=1.12u l=0.13u
X1722 vdd SAR/sg13cmos5l_dfrbp_1_6.RESET_B SAR/a_682_6892# vdd sg13_lv_pmos ad=0.1563p pd=1.22u as=0.147p ps=1.54u w=0.42u l=0.13u
X1723 SAR/a_3793_2790# SAR/a_3241_2746# vss vss sg13_lv_nmos ad=71.99999f pd=0.865u as=2.59257p ps=16.445u w=0.64u l=0.13u
X1724 SAR/a_16356_7349# SAR/a_16587_6935# SAR/a_16042_6892# vss sg13_lv_nmos ad=0.2373p pd=1.97u as=79.8f ps=0.8u w=0.42u l=0.13u
X1725 vdd SAR/sg13cmos5l_dfrbp_1_11.Q SAR/a_6647_5459# vdd sg13_lv_pmos ad=0.1428p pd=1.52u as=79.8f ps=0.8u w=0.42u l=0.13u
X1726 SAR/sg13cmos5l_dfrbp_1_9.Q_N SAR/a_3407_4261# vdd vdd sg13_lv_pmos ad=0.4312p pd=3.01u as=0.2639p ps=1.81u w=1.12u l=0.13u
X1727 SAR/sg13cmos5l_buf_1_45.A SAR/a_8841_5769# vss vss sg13_lv_nmos ad=0.2516p pd=2.16u as=0.1406p ps=1.12u w=0.74u l=0.13u
X1728 SAR/a_4076_5376# SAR/sg13cmos5l_dlhr_1_9.Q vdd vdd sg13_lv_pmos ad=0.2856p pd=2.36u as=0.2114p ps=1.54u w=0.84u l=0.13u
X1729 vss SAR/a_2224_7166# SAR/a_1873_7285# vss sg13_lv_nmos ad=79.8f pd=0.8u as=0.1428p ps=1.52u w=0.42u l=0.13u
X1730 vdd vss vdd vdd sg13_lv_pmos ad=0.34p pd=2.68u as=0 ps=0 w=1u l=1u
X1731 SAR/a_5702_8874# SAR/sg13cmos5l_dlhr_1_5.GATE vdd vdd sg13_lv_pmos ad=79.8f pd=0.8u as=0.1428p ps=1.52u w=0.42u l=0.13u
X1732 SAR/a_3996_2790# SAR/a_3447_2746# SAR/a_3860_2388# vss sg13_lv_nmos ad=47.25f pd=0.645u as=0.141p ps=1.17u w=0.42u l=0.13u
X1733 SAR/a_9111_4666# SAR/sg13cmos5l_dfrbp_1_11.Q vdd vdd sg13_lv_pmos ad=0.3234p pd=2.45u as=1.2517p ps=7.955u w=0.84u l=0.13u
X1734 SAR/a_4660_7312# SAR/a_4244_6924# SAR/a_4425_7281# vss sg13_lv_nmos ad=77.7f pd=0.95u as=0.2516p ps=2.16u w=0.74u l=0.13u
X1735 SAR/sg13cmos5l_a221oi_1_0.B2 SAR/sg13cmos5l_nor2b_1_0.Y vss vss sg13_lv_nmos ad=0.1406p pd=1.12u as=0.2516p ps=2.16u w=0.74u l=0.13u
X1736 vss SAR/sg13cmos5l_dfrbp_1_0.RESET_B SAR/a_11364_4338# vss sg13_lv_nmos ad=0.1626p pd=1.415u as=60.89999f ps=0.71u w=0.42u l=0.13u
X1737 SAR/a_15466_2356# SAR/a_15909_2399# SAR/a_15849_2435# vdd sg13_lv_pmos ad=79.8f pd=0.8u as=63f ps=0.72u w=0.42u l=0.13u
X1738 SAR/a_7732_3124# SAR/a_7316_3460# SAR/a_7497_3138# vss sg13_lv_nmos ad=77.7f pd=0.95u as=0.2516p ps=2.16u w=0.74u l=0.13u
X1739 vss SAR/a_15177_5769# SAR/a_15702_5842# vss sg13_lv_nmos ad=0.1491p pd=1.18u as=0.187p ps=1.78u w=0.55u l=0.13u
X1740 SAR/a_10288_8678# SAR/a_10031_8797# SAR/a_10450_8874# vss sg13_lv_nmos ad=0.1428p pd=1.52u as=37.8f ps=0.6u w=0.42u l=0.13u
X1741 vss SAR/a_19227_9190# SAR/sg13cmos5l_buf_8_2.X vss sg13_lv_nmos ad=0.1406p pd=1.12u as=0.1406p ps=1.12u w=0.74u l=0.13u
X1742 SAR/a_13138_2826# SAR/sg13cmos5l_dfrbp_1_0.RESET_B vss vss sg13_lv_nmos ad=37.8f pd=0.6u as=79.8f ps=0.8u w=0.42u l=0.13u
X1743 vdd SAR/a_2565_3911# SAR/a_2667_3911# vdd sg13_lv_pmos ad=1.43437p pd=9.105u as=0.3864p ps=2.93u w=1.12u l=0.13u
X1744 SAR/a_12549_9165# SAR/sg13cmos5l_inv_1_2.A vss vss sg13_lv_nmos ad=0.2516p pd=2.16u as=2.71505p ps=17.54u w=0.74u l=0.13u
X1745 vdd SAR/sg13cmos5l_dfrbp_1_6.RESET_B SAR/a_10473_9186# vdd sg13_lv_pmos ad=0.2128p pd=1.5u as=0.2128p ps=1.5u w=1.12u l=0.13u
X1746 vss SAR/a_5079_3154# SAR/a_5210_3148# vss sg13_lv_nmos ad=2.59257p pd=16.445u as=0.2775p ps=2.23u w=0.74u l=0.13u
X1747 SAR/a_2228_4972# SAR/a_1815_4666# SAR/a_2160_4972# vdd sg13_lv_pmos ad=0.191p pd=1.44u as=0.105p ps=1.21u w=1u l=0.13u
X1748 SAR/a_5510_4338# SAR/sg13cmos5l_dfrbp_1_6.D vdd vdd sg13_lv_pmos ad=79.8f pd=0.8u as=0.1428p ps=1.52u w=0.42u l=0.13u
X1749 SAR/a_10534_7687# SAR/sg13cmos5l_dfrbp_1_6.RESET_B vss vss sg13_lv_nmos ad=37.8f pd=0.6u as=0.1701p ps=1.65u w=0.42u l=0.13u
X1750 vss SAR/a_14295_7282# SAR/a_14426_7288# vss sg13_lv_nmos ad=1.49685p pd=9.6u as=0.2775p ps=2.23u w=0.74u l=0.13u
X1751 vdd SAR/a_7863_7282# SAR/a_7994_7288# vdd sg13_lv_pmos ad=1.07253p pd=6.75u as=0.2856p ps=2.36u w=0.84u l=0.13u
X1752 SAR/sg13cmos5l_inv_1_0.A SAR/a_13652_3900# vdd vdd sg13_lv_pmos ad=0.3808p pd=2.92u as=0.2128p ps=1.5u w=1.12u l=0.13u
X1753 SAR/a_3562_4873# SAR/a_4005_4629# SAR/a_3302_4650# vss sg13_lv_nmos ad=79.8f pd=0.8u as=0.1296p ps=1.52u w=0.42u l=0.13u
X1754 SAR/sg13cmos5l_buf_1_45.A SAR/a_8841_5769# vdd vdd sg13_lv_pmos ad=0.3808p pd=2.92u as=0.2128p ps=1.5u w=1.12u l=0.13u
X1755 vss SAR/a_16293_4629# SAR/a_16395_4772# vss sg13_lv_nmos ad=2.41737p pd=15.64u as=0.2516p ps=2.16u w=0.74u l=0.13u
X1756 SAR/a_8772_8440# SAR/a_8746_8404# vss vss sg13_lv_nmos ad=0.2516p pd=2.16u as=0.1626p ps=1.415u w=0.74u l=0.13u
X1757 SAR/a_12132_9504# SAR/a_12106_9409# vdd vdd sg13_lv_pmos ad=0.34p pd=2.68u as=0.36237p ps=2.605u w=1u l=0.13u
X1758 SAR/a_13810_9186# SAR/sg13cmos5l_dfrbp_1_8.RESET_B vss vss sg13_lv_nmos ad=37.8f pd=0.6u as=79.8f ps=0.8u w=0.42u l=0.13u
X1759 vdd SAR/sg13cmos5l_buf_8_0.A SAR/a_19227_4654# vdd sg13_lv_pmos ad=0.2128p pd=1.5u as=0.2128p ps=1.5u w=1.12u l=0.13u
X1760 SAR/a_1815_4666# SAR/sg13cmos5l_dlhr_1_1.GATE vdd vdd sg13_lv_pmos ad=0.3234p pd=2.45u as=1.2517p ps=7.955u w=0.84u l=0.13u
X1761 vdd SAR/a_3407_8797# SAR/a_4244_8436# vdd sg13_lv_pmos ad=0.2128p pd=1.5u as=0.3864p ps=2.93u w=1.12u l=0.13u
X1762 SAR/a_14814_3876# SAR/sg13cmos5l_a22oi_1_1.B1 SAR/sg13cmos5l_a22oi_1_1.Y vdd sg13_lv_pmos ad=0.2716p pd=1.605u as=0.2128p ps=1.5u w=1.12u l=0.13u
X1763 vss SAR/a_15884_3102# nh_sw[7] vss sg13_lv_nmos ad=0.14875p pd=1.16u as=0.2886p ps=2.26u w=0.74u l=0.13u
X1764 vss SAR/a_6405_8447# SAR/a_6507_8447# vss sg13_lv_nmos ad=2.92392p pd=18.89u as=0.2516p ps=2.16u w=0.74u l=0.13u
X1765 SAR/a_3574_7850# SAR/a_3676_7964# vss vss sg13_lv_nmos ad=0.187p pd=1.78u as=0.1491p ps=1.18u w=0.55u l=0.13u
X1766 vdd SAR/a_1967_7285# SAR/a_2224_7166# vdd sg13_lv_pmos ad=0.2639p pd=1.81u as=79.8f ps=0.8u w=0.42u l=0.13u
X1767 vdd SAR/sg13cmos5l_nor2_1_0.A SAR/a_12814_4692# vdd sg13_lv_pmos ad=0.2618p pd=1.63u as=0.2856p ps=2.36u w=0.84u l=0.13u
X1768 SAR/a_17926_3151# SAR/sg13cmos5l_dfrbp_1_0.RESET_B vss vss sg13_lv_nmos ad=37.8f pd=0.6u as=0.1701p ps=1.65u w=0.42u l=0.13u
X1769 vss SAR/sg13cmos5l_and3_1_0.C SAR/a_13520_4696# vss sg13_lv_nmos ad=0.1371p pd=1.12u as=0.1216p ps=1.02u w=0.64u l=0.13u
X1770 SAR/a_10789_4654# SAR/sg13cmos5l_a221oi_1_0.C1 vss vss sg13_lv_nmos ad=0.1406p pd=1.12u as=0.14505p ps=1.15u w=0.74u l=0.13u
X1771 SAR/sg13cmos5l_dlhr_1_2.D SAR/a_6479_2749# vdd vdd sg13_lv_pmos ad=0.4312p pd=3.01u as=0.2639p ps=1.81u w=1.12u l=0.13u
X1772 SAR/a_13100_8400# SAR/sg13cmos5l_buf_1_90.X vdd vdd sg13_lv_pmos ad=0.2856p pd=2.36u as=0.2114p ps=1.54u w=0.84u l=0.13u
X1773 SAR/sg13cmos5l_nor2_1_2.A SAR/sg13cmos5l_inv_1_9.Y vss vss sg13_lv_nmos ad=0.2516p pd=2.16u as=0.2516p ps=2.16u w=0.74u l=0.13u
X1774 SAR/a_13572_3151# SAR/a_13803_3260# SAR/a_13258_3361# vss sg13_lv_nmos ad=0.2373p pd=1.97u as=79.8f ps=0.8u w=0.42u l=0.13u
X1775 SAR/a_11530_1849# SAR/a_11973_1605# SAR/a_11270_1626# vss sg13_lv_nmos ad=79.8f pd=0.8u as=0.1296p ps=1.52u w=0.42u l=0.13u
X1776 SAR/a_14032_6382# SAR/a_13775_6239# SAR/a_14194_6162# vss sg13_lv_nmos ad=0.1428p pd=1.52u as=37.8f ps=0.6u w=0.42u l=0.13u
X1777 SAR/a_10464_2427# SAR/sg13cmos5l_nor2_1_0.A vdd vdd sg13_lv_pmos ad=0.1596p pd=1.22u as=0.4536p ps=2.76u w=0.84u l=0.13u
X1778 vss SAR/a_3856_3358# SAR/a_3505_3215# vss sg13_lv_nmos ad=79.8f pd=0.8u as=0.1428p ps=1.52u w=0.42u l=0.13u
X1779 SAR/a_3876_4663# SAR/a_3588_4968# SAR/a_3814_4663# vss sg13_lv_nmos ad=0.1428p pd=1.52u as=37.8f ps=0.6u w=0.42u l=0.13u
X1780 SAR/a_6998_5837# SAR/a_5820_5773# SAR/a_6602_5692# vss sg13_lv_nmos ad=37.8f pd=0.6u as=0.1428p ps=1.52u w=0.42u l=0.13u
X1781 SAR/sg13cmos5l_dlhr_1_1.D SAR/a_1967_5773# vss vss sg13_lv_nmos ad=0.2849p pd=2.25u as=0.2516p ps=2.16u w=0.74u l=0.13u
X1782 vss vdd vss vss sg13_lv_nmos ad=0.1428p pd=1.52u as=0 ps=0 w=0.42u l=1u
X1783 SAR/a_10417_7326# SAR/a_9865_7282# vss vss sg13_lv_nmos ad=71.99999f pd=0.865u as=1.49685p ps=9.6u w=0.64u l=0.13u
X1784 vdd SAR/sg13cmos5l_nand2_1_0.A SAR/sg13cmos5l_o21ai_1_0.A2 vdd sg13_lv_pmos ad=0.3808p pd=2.92u as=0.2128p ps=1.5u w=1.12u l=0.13u
X1785 vss SAR/a_1484_9150# SAR/sg13cmos5l_buf_1_68.X vss sg13_lv_nmos ad=0.14875p pd=1.16u as=0.2886p ps=2.26u w=0.74u l=0.13u
X1786 vss SAR/sg13cmos5l_buf_1_40.A SAR/sg13cmos5l_buf_1_63.A vss sg13_lv_nmos ad=0.2516p pd=2.16u as=0.2516p ps=2.16u w=0.74u l=0.13u
X1787 vdd SAR/a_13161_7281# SAR/a_13094_6924# vdd sg13_lv_pmos ad=0.2387p pd=1.84u as=0.1008p ps=0.9u w=0.42u l=0.13u
X1788 vdd SAR/sg13cmos5l_nand2_1_1.B SAR/a_9823_2364# vdd sg13_lv_pmos ad=0.3808p pd=2.92u as=0.2744p ps=1.61u w=1.12u l=0.13u
X1789 SAR/a_14858_2388# SAR/sg13cmos5l_dfrbp_1_0.Q SAR/sg13cmos5l_nand2_1_0.A vdd sg13_lv_pmos ad=0.1176p pd=1.33u as=0.3808p ps=2.92u w=1.12u l=0.13u
X1790 vss _cks SAR/a_19227_9190# vss sg13_lv_nmos ad=0.1406p pd=1.12u as=0.1406p ps=1.12u w=0.74u l=0.13u
X1791 SAR/a_16068_6928# SAR/a_16042_6892# vss vss sg13_lv_nmos ad=0.2516p pd=2.16u as=0.1626p ps=1.415u w=0.74u l=0.13u
X1792 vdd SAR/a_19593_6162# SAR/a_19526_6600# vdd sg13_lv_pmos ad=0.2387p pd=1.84u as=0.1008p ps=0.9u w=0.42u l=0.13u
X1793 pl_sw[1] SAR/a_1000_9224# vss vss sg13_lv_nmos ad=0.2886p pd=2.26u as=0.14875p ps=1.16u w=0.74u l=0.13u
X1794 vss SAR/sg13cmos5l_buf_1_29.A SAR/sg13cmos5l_buf_1_77.A vss sg13_lv_nmos ad=0.2516p pd=2.16u as=0.2516p ps=2.16u w=0.74u l=0.13u
X1795 SAR/a_3447_2746# SAR/sg13cmos5l_dfrbp_1_9.Q vss vss sg13_lv_nmos ad=0.2516p pd=2.16u as=0.15055p ps=1.17u w=0.74u l=0.13u
X1796 SAR/a_18480_5028# SAR/sg13cmos5l_dfrbp_1_0.D vss vss sg13_lv_nmos ad=0.1045p pd=0.93u as=0.187p ps=1.78u w=0.55u l=0.13u
X1797 SAR/a_17516_9150# SAR/sg13cmos5l_buf_1_103.A vss vss sg13_lv_nmos ad=0.187p pd=1.78u as=0.14875p ps=1.16u w=0.55u l=0.13u
X1798 SAR/a_11434_2356# SAR/a_11877_2399# SAR/a_11817_2435# vdd sg13_lv_pmos ad=79.8f pd=0.8u as=63f ps=0.72u w=0.42u l=0.13u
X1799 vdd SAR/a_10587_4692# SAR/sg13cmos5l_nand2_1_0.B vdd sg13_lv_pmos ad=0.3808p pd=2.92u as=0.2128p ps=1.5u w=1.12u l=0.13u
X1800 vss SAR/a_19216_3358# SAR/a_18865_3215# vss sg13_lv_nmos ad=79.8f pd=0.8u as=0.1428p ps=1.52u w=0.42u l=0.13u
X1801 SAR/a_7497_3138# SAR/a_7316_3460# vdd vdd sg13_lv_pmos ad=0.2128p pd=1.5u as=0.2387p ps=1.84u w=1.12u l=0.13u
X1802 SAR/a_11270_1626# SAR/sg13cmos5l_dfrbp_1_1.D vdd vdd sg13_lv_pmos ad=79.8f pd=0.8u as=0.1428p ps=1.52u w=0.42u l=0.13u
X1803 SAR/sg13cmos5l_dlhr_1_1.Q_N SAR/a_2934_4632# vdd vdd sg13_lv_pmos ad=0.3808p pd=2.92u as=0.1974p ps=1.5u w=1.12u l=0.13u
X1804 SAR/sg13cmos5l_dfrbp_1_12.Q_N SAR/a_7055_4261# vdd vdd sg13_lv_pmos ad=0.4312p pd=3.01u as=0.2639p ps=1.81u w=1.12u l=0.13u
X1805 SAR/a_2727_6380# SAR/a_2879_6432# vss vss sg13_lv_nmos ad=0.2516p pd=2.16u as=1.97045p ps=12.335u w=0.74u l=0.13u
X1806 SAR/a_5425_3130# SAR/a_4873_3192# vss vss sg13_lv_nmos ad=71.99999f pd=0.865u as=2.59257p ps=16.445u w=0.64u l=0.13u
X1807 SAR/a_2148_8440# SAR/a_2667_8447# SAR/a_3407_8797# vss sg13_lv_nmos ad=0.3473p pd=2.71u as=0.12665p ps=1.145u w=0.74u l=0.13u
X1808 SAR/a_3574_7850# SAR/a_3676_7964# vdd vdd sg13_lv_pmos ad=0.2856p pd=2.36u as=0.1974p ps=1.5u w=0.84u l=0.13u
X1809 vss SAR/sg13cmos5l_buf_1_31.X SAR/a_1672_3176# vss sg13_lv_nmos ad=0.14875p pd=1.16u as=0.187p ps=1.78u w=0.55u l=0.13u
X1810 ph_sw[1] SAR/a_1864_9224# vdd vdd sg13_lv_pmos ad=0.42p pd=2.99u as=0.2114p ps=1.54u w=1.12u l=0.13u
X1811 vdd SAR/sg13cmos5l_dfrbp_1_8.RESET_B SAR/a_8486_8874# vdd sg13_lv_pmos ad=0.36237p pd=2.605u as=79.8f ps=0.8u w=0.42u l=0.13u
X1812 vss SAR/a_4652_6126# SAR/sg13cmos5l_inv_1_19.A vss sg13_lv_nmos ad=0.14875p pd=1.16u as=0.2886p ps=2.26u w=0.74u l=0.13u
X1813 SAR/a_18278_8112# SAR/a_17882_7684# SAR/a_18164_7996# vdd sg13_lv_pmos ad=0.1008p pd=0.9u as=0.191p ps=1.44u w=0.42u l=0.13u
X1814 SAR/a_7055_4261# SAR/a_6213_3911# SAR/a_5796_3904# vdd sg13_lv_pmos ad=0.2048p pd=1.63u as=0.34p ps=2.68u w=1u l=0.13u
X1815 SAR/a_12998_3138# SAR/sg13cmos5l_o21ai_1_0.Y vdd vdd sg13_lv_pmos ad=79.8f pd=0.8u as=0.1428p ps=1.52u w=0.42u l=0.13u
X1816 SAR/a_5962_8404# SAR/a_6405_8447# SAR/a_5702_8874# vss sg13_lv_nmos ad=79.8f pd=0.8u as=0.1296p ps=1.52u w=0.42u l=0.13u
X1817 SAR/sg13cmos5l_buf_1_2.X SAR/a_15784_1664# vss vss sg13_lv_nmos ad=0.2886p pd=2.26u as=0.14875p ps=1.16u w=0.74u l=0.13u
X1818 SAR/sg13cmos5l_buf_8_2.X SAR/a_19227_9190# vdd vdd sg13_lv_pmos ad=0.2128p pd=1.5u as=0.2128p ps=1.5u w=1.12u l=0.13u
X1819 vdd SAR/a_17961_8793# SAR/a_18486_8866# vdd sg13_lv_pmos ad=0.1974p pd=1.5u as=0.2856p ps=2.36u w=0.84u l=0.13u
X1820 SAR/a_5710_5850# SAR/a_5452_5850# vss vss sg13_lv_nmos ad=0.1428p pd=1.52u as=79.8f ps=0.8u w=0.42u l=0.13u
X1821 vdd SAR/a_9111_4666# SAR/a_9242_4660# vdd sg13_lv_pmos ad=1.28962p pd=8.195u as=0.2856p ps=2.36u w=0.84u l=0.13u
X1822 SAR/sg13cmos5l_dlhr_1_15.D SAR/a_17108_7972# vss vss sg13_lv_nmos ad=0.2516p pd=2.16u as=0.1406p ps=1.12u w=0.74u l=0.13u
X1823 vdd SAR/sg13cmos5l_dfrbp_1_6.RESET_B SAR/a_4041_2745# vdd sg13_lv_pmos ad=0.2128p pd=1.5u as=0.2128p ps=1.5u w=1.12u l=0.13u
X1824 SAR/a_19344_6484# SAR/a_18793_6216# vdd vdd sg13_lv_pmos ad=0.105p pd=1.21u as=1.07253p ps=6.75u w=1u l=0.13u
X1825 SAR/a_15909_2399# SAR/sg13cmos5l_dfrbp_1_0.CLK vdd vdd sg13_lv_pmos ad=0.4088p pd=2.97u as=1.777p ps=11.395u w=1.12u l=0.13u
X1826 vss SAR/a_1948_7964# SAR/sg13cmos5l_buf_1_58.A vss sg13_lv_nmos ad=0.1406p pd=1.12u as=0.2516p ps=2.16u w=0.74u l=0.13u
X1827 SAR/a_13258_3361# SAR/a_13701_3117# SAR/a_13641_3529# vdd sg13_lv_pmos ad=79.8f pd=0.8u as=63f ps=0.72u w=0.42u l=0.13u
X1828 vdd vss vdd vdd sg13_lv_pmos ad=0.34p pd=2.68u as=0 ps=0 w=1u l=1u
X1829 vdd SAR/a_16751_2749# SAR/a_17008_2630# vdd sg13_lv_pmos ad=0.2639p pd=1.81u as=79.8f ps=0.8u w=0.42u l=0.13u
X1830 SAR/sg13cmos5l_dfrbp_1_6.RESET_B _cks vdd vdd sg13_lv_pmos ad=0.2128p pd=1.5u as=0.3808p ps=2.92u w=1.12u l=0.13u
X1831 SAR/sg13cmos5l_o21ai_1_0.B1 SAR/sg13cmos5l_nand2_1_1.A SAR/a_14458_4270# vss sg13_lv_nmos ad=0.2516p pd=2.16u as=0.1406p ps=1.12u w=0.74u l=0.13u
X1832 SAR/a_5132_3864# SAR/sg13cmos5l_buf_1_44.A vdd vdd sg13_lv_pmos ad=0.2856p pd=2.36u as=0.2114p ps=1.54u w=0.84u l=0.13u
X1833 vss SAR/sg13cmos5l_dfrbp_1_8.RESET_B SAR/a_6180_4650# vss sg13_lv_nmos ad=0.1626p pd=1.415u as=60.89999f ps=0.71u w=0.42u l=0.13u
X1834 SAR/a_15500_9150# SAR/sg13cmos5l_buf_1_95.X vss vss sg13_lv_nmos ad=0.187p pd=1.78u as=0.14875p ps=1.16u w=0.55u l=0.13u
X1835 SAR/a_14844_7326# SAR/a_14295_7282# SAR/a_14708_6924# vss sg13_lv_nmos ad=47.25f pd=0.645u as=0.141p ps=1.17u w=0.42u l=0.13u
X1836 SAR/a_3856_3358# SAR/a_3599_3215# SAR/a_4018_3138# vss sg13_lv_nmos ad=0.1428p pd=1.52u as=37.8f ps=0.6u w=0.42u l=0.13u
X1837 vdd SAR/a_18363_4270# SAR/sg13cmos5l_or2_1_0.A vdd sg13_lv_pmos ad=0.2128p pd=1.5u as=0.2128p ps=1.5u w=1.12u l=0.13u
X1838 vss SAR/a_3574_7850# SAR/sg13cmos5l_dlhr_1_9.Q_N vss sg13_lv_nmos ad=0.1491p pd=1.18u as=0.2516p ps=2.16u w=0.74u l=0.13u
X1839 SAR/a_18580_7660# SAR/a_18164_7996# SAR/a_18345_7674# vss sg13_lv_nmos ad=77.7f pd=0.95u as=0.2516p ps=2.16u w=0.74u l=0.13u
X1840 SAR/sg13cmos5l_dfrbp_1_1.Q_N SAR/a_12815_1703# vdd vdd sg13_lv_pmos ad=0.4312p pd=3.01u as=0.2639p ps=1.81u w=1.12u l=0.13u
X1841 vss SAR/sg13cmos5l_dfrbp_1_10.Q SAR/a_4873_3192# vss sg13_lv_nmos ad=0.15055p pd=1.17u as=0.187p ps=1.78u w=0.55u l=0.13u
X1842 SAR/a_13977_6477# SAR/a_13035_6284# SAR/a_13775_6239# vdd sg13_lv_pmos ad=93.45f pd=0.865u as=0.2048p ps=1.63u w=0.42u l=0.13u
X1843 SAR/sg13cmos5l_dlhr_1_0.D SAR/a_7316_2388# vdd vdd sg13_lv_pmos ad=0.3808p pd=2.92u as=0.2128p ps=1.5u w=1.12u l=0.13u
X1844 vdd _cks SAR/sg13cmos5l_dfrbp_1_0.RESET_B vdd sg13_lv_pmos ad=0.3808p pd=2.92u as=0.3808p ps=2.92u w=1.12u l=0.13u
X1845 SAR/a_11268_2826# SAR/sg13cmos5l_dfrbp_1_4.D SAR/a_11174_2826# vss sg13_lv_nmos ad=60.89999f pd=0.71u as=0.1428p ps=1.52u w=0.42u l=0.13u
X1846 SAR/a_16271_7751# SAR/a_15429_7653# SAR/a_15012_7992# vdd sg13_lv_pmos ad=0.2048p pd=1.63u as=0.34p ps=2.68u w=1u l=0.13u
X1847 vss SAR/sg13cmos5l_dfrbp_1_6.RESET_B SAR/a_5028_2826# vss sg13_lv_nmos ad=0.1626p pd=1.415u as=60.89999f ps=0.71u w=0.42u l=0.13u
X1848 vss SAR/sg13cmos5l_buf_1_89.A SAR/a_15208_6200# vss sg13_lv_nmos ad=0.14875p pd=1.16u as=0.187p ps=1.78u w=0.55u l=0.13u
X1849 vdd SAR/sg13cmos5l_buf_1_74.X SAR/a_6568_9224# vdd sg13_lv_pmos ad=0.2114p pd=1.54u as=0.2856p ps=2.36u w=0.84u l=0.13u
X1850 SAR/sg13cmos5l_o21ai_1_0.Y SAR/sg13cmos5l_o21ai_1_0.B1 SAR/a_12022_3134# vss sg13_lv_nmos ad=0.2516p pd=2.16u as=0.1406p ps=1.12u w=0.74u l=0.15u
X1851 SAR/a_14916_8861# SAR/a_15147_8447# SAR/a_14602_8404# vss sg13_lv_nmos ad=0.2373p pd=1.97u as=79.8f ps=0.8u w=0.42u l=0.13u
X1852 vss vdd vss vss sg13_lv_nmos ad=0.1428p pd=1.52u as=0 ps=0 w=0.42u l=1u
X1853 SAR/sg13cmos5l_dlhr_1_9.D SAR/a_2804_5412# vss vss sg13_lv_nmos ad=0.2516p pd=2.16u as=0.1406p ps=1.12u w=0.74u l=0.13u
X1854 SAR/sg13cmos5l_dlhr_1_14.Q_N SAR/a_14166_7656# vss vss sg13_lv_nmos ad=0.2516p pd=2.16u as=0.1491p ps=1.18u w=0.74u l=0.13u
X1855 SAR/a_17712_8436# SAR/a_17161_8794# vdd vdd sg13_lv_pmos ad=0.105p pd=1.21u as=1.15047p ps=7.175u w=1u l=0.13u
X1856 SAR/a_3664_8678# SAR/sg13cmos5l_dfrbp_1_8.RESET_B vdd vdd sg13_lv_pmos ad=79.8f pd=0.8u as=1.12242p ps=7u w=0.42u l=0.13u
X1857 SAR/a_16548_6175# SAR/a_16779_6284# SAR/a_16234_6385# vss sg13_lv_nmos ad=0.2373p pd=1.97u as=79.8f ps=0.8u w=0.42u l=0.13u
X1858 SAR/a_8390_6924# SAR/a_7994_7288# SAR/a_8276_6924# vdd sg13_lv_pmos ad=0.1008p pd=0.9u as=0.191p ps=1.44u w=0.42u l=0.13u
X1859 vdd SAR/sg13cmos5l_dlhr_1_11.D SAR/a_12361_7282# vdd sg13_lv_pmos ad=1.07253p pd=6.75u as=0.2856p ps=2.36u w=0.84u l=0.13u
X1860 SAR/a_3856_3358# SAR/sg13cmos5l_dfrbp_1_6.RESET_B vdd vdd sg13_lv_pmos ad=79.8f pd=0.8u as=1.38655p ps=8.8u w=0.42u l=0.13u
X1861 vss SAR/a_9260_2352# nh_sw[4] vss sg13_lv_nmos ad=0.14875p pd=1.16u as=0.2886p ps=2.26u w=0.74u l=0.13u
X1862 nh_sw[1] SAR/a_2824_2388# vdd vdd sg13_lv_pmos ad=0.42p pd=2.99u as=0.2114p ps=1.54u w=1.12u l=0.13u
X1863 vss SAR/sg13cmos5l_dfrbp_1_6.RESET_B SAR/a_5604_4338# vss sg13_lv_nmos ad=0.1626p pd=1.415u as=60.89999f ps=0.71u w=0.42u l=0.13u
X1864 vss SAR/a_16677_6141# SAR/a_16779_6284# vss sg13_lv_nmos ad=1.97045p pd=12.335u as=0.2516p ps=2.16u w=0.74u l=0.13u
X1865 vdd SAR/a_10665_7281# SAR/a_10598_6924# vdd sg13_lv_pmos ad=0.2387p pd=1.84u as=0.1008p ps=0.9u w=0.42u l=0.13u
X1866 vss SAR/sg13cmos5l_dfrbp_1_8.RESET_B SAR/a_15684_4650# vss sg13_lv_nmos ad=0.1626p pd=1.415u as=60.89999f ps=0.71u w=0.42u l=0.13u
X1867 vdd SAR/sg13cmos5l_dfrbp_1_8.RESET_B SAR/a_5452_5850# vdd sg13_lv_pmos ad=1.2517p pd=7.955u as=79.8f ps=0.8u w=0.42u l=0.13u
X1868 SAR/a_7644_1662# SAR/a_7095_1642# SAR/a_7508_1948# vss sg13_lv_nmos ad=47.25f pd=0.645u as=0.141p ps=1.17u w=0.42u l=0.13u
X1869 SAR/a_3826_4338# SAR/sg13cmos5l_dfrbp_1_8.RESET_B vss vss sg13_lv_nmos ad=37.8f pd=0.6u as=79.8f ps=0.8u w=0.42u l=0.13u
X1870 SAR/a_8784_6484# SAR/a_8233_6216# vdd vdd sg13_lv_pmos ad=0.105p pd=1.21u as=1.07253p ps=6.75u w=1u l=0.13u
X1871 SAR/sg13cmos5l_inv_1_9.Y _cks vss vss sg13_lv_nmos ad=0.2516p pd=2.16u as=0.2516p ps=2.16u w=0.74u l=0.13u
X1872 SAR/a_8204_2352# SAR/sg13cmos5l_dlhr_1_2.Q vdd vdd sg13_lv_pmos ad=0.2856p pd=2.36u as=0.2114p ps=1.54u w=0.84u l=0.13u
X1873 vss SAR/a_9189_8447# SAR/a_9291_8447# vss sg13_lv_nmos ad=2.92392p pd=18.89u as=0.2516p ps=2.16u w=0.74u l=0.13u
X1874 SAR/a_9457_4642# SAR/a_8905_4704# vss vss sg13_lv_nmos ad=71.99999f pd=0.865u as=2.41737p ps=15.64u w=0.64u l=0.13u
X1875 SAR/a_16089_8559# SAR/a_15147_8447# SAR/a_15887_8797# vdd sg13_lv_pmos ad=93.45f pd=0.865u as=0.2048p ps=1.63u w=0.42u l=0.13u
X1876 SAR/a_15850_4873# SAR/a_16293_4629# SAR/a_15590_4650# vss sg13_lv_nmos ad=79.8f pd=0.8u as=0.1296p ps=1.52u w=0.42u l=0.13u
X1877 SAR/a_8276_6924# SAR/a_7994_7288# SAR/a_8209_7326# vss sg13_lv_nmos ad=0.141p pd=1.17u as=71.99999f ps=0.865u w=0.64u l=0.13u
X1878 SAR/sg13cmos5l_buf_1_56.A SAR/a_9033_6162# vdd vdd sg13_lv_pmos ad=0.3808p pd=2.92u as=0.2128p ps=1.5u w=1.12u l=0.13u
X1879 SAR/a_6214_8861# SAR/sg13cmos5l_dfrbp_1_8.RESET_B vss vss sg13_lv_nmos ad=37.8f pd=0.6u as=0.1701p ps=1.65u w=0.42u l=0.13u
X1880 vdd SAR/sg13cmos5l_dfrbp_1_6.RESET_B SAR/a_18345_7674# vdd sg13_lv_pmos ad=0.2128p pd=1.5u as=0.2128p ps=1.5u w=1.12u l=0.13u
X1881 vdd SAR/a_14889_7281# SAR/a_15414_7354# vdd sg13_lv_pmos ad=0.1974p pd=1.5u as=0.2856p ps=2.36u w=0.84u l=0.13u
X1882 SAR/a_19216_3358# SAR/sg13cmos5l_dfrbp_1_0.RESET_B vdd vdd sg13_lv_pmos ad=79.8f pd=0.8u as=1.38655p ps=8.8u w=0.42u l=0.13u
X1883 SAR/a_3212_1590# SAR/sg13cmos5l_buf_1_41.A vss vss sg13_lv_nmos ad=0.187p pd=1.78u as=0.14875p ps=1.16u w=0.55u l=0.13u
X1884 SAR/a_10618_3142# SAR/sg13cmos5l_nand2_1_0.A vss vss sg13_lv_nmos ad=0.1406p pd=1.12u as=0.2516p ps=2.16u w=0.74u l=0.13u
X1885 SAR/sg13cmos5l_buf_1_26.A SAR/sg13cmos5l_buf_1_45.X vdd vdd sg13_lv_pmos ad=0.3808p pd=2.92u as=0.3808p ps=2.92u w=1.12u l=0.13u
X1886 SAR/a_3407_8797# SAR/a_2565_8447# SAR/a_3313_8797# vss sg13_lv_nmos ad=0.12665p pd=1.145u as=0.1428p ps=1.52u w=0.42u l=0.13u
X1887 vss SAR/a_18671_1703# SAR/a_19508_1924# vss sg13_lv_nmos ad=0.1406p pd=1.12u as=0.2516p ps=2.16u w=0.74u l=0.13u
X1888 vss SAR/a_10288_8678# SAR/a_9937_8797# vss sg13_lv_nmos ad=79.8f pd=0.8u as=0.1428p ps=1.52u w=0.42u l=0.13u
X1889 SAR/a_5702_8874# SAR/a_6507_8447# SAR/a_5962_8404# vdd sg13_lv_pmos ad=0.1428p pd=1.52u as=79.8f ps=0.8u w=0.42u l=0.13u
X1890 SAR/a_516_5850# SAR/sg13cmos5l_dfrbp_1_6.D SAR/a_422_5850# vss sg13_lv_nmos ad=60.89999f pd=0.71u as=0.1428p ps=1.52u w=0.42u l=0.13u
X1891 vss SAR/a_13391_9263# SAR/a_14228_9484# vss sg13_lv_nmos ad=0.1406p pd=1.12u as=0.2516p ps=2.16u w=0.74u l=0.13u
X1892 SAR/a_2505_8483# SAR/a_2148_8440# vdd vdd sg13_lv_pmos ad=63f pd=0.72u as=0.1563p ps=1.22u w=0.42u l=0.13u
X1893 vss SAR/a_3599_3215# SAR/a_4436_3436# vss sg13_lv_nmos ad=0.1406p pd=1.12u as=0.2516p ps=2.16u w=0.74u l=0.13u
X1894 vdd SAR/sg13cmos5l_dfrbp_1_8.RESET_B SAR/a_15850_4873# vdd sg13_lv_pmos ad=0.1563p pd=1.22u as=0.147p ps=1.54u w=0.42u l=0.13u
X1895 SAR/sg13cmos5l_a22oi_1_2.B2 SAR/sg13cmos5l_a221oi_1_0.C1 SAR/a_10420_5760# vss sg13_lv_nmos ad=0.2516p pd=2.16u as=0.1406p ps=1.12u w=0.74u l=0.13u
X1896 vss SAR/sg13cmos5l_inv_1_8.A SAR/a_5951_5383# vss sg13_lv_nmos ad=1.88087p pd=11.775u as=0.2516p ps=2.16u w=0.74u l=0.13u
X1897 vss SAR/a_18860_6888# ph_sw[9] vss sg13_lv_nmos ad=0.14875p pd=1.16u as=0.2886p ps=2.26u w=0.74u l=0.13u
X1898 vss SAR/a_14032_6382# SAR/a_13681_6239# vss sg13_lv_nmos ad=79.8f pd=0.8u as=0.1428p ps=1.52u w=0.42u l=0.13u
X1899 SAR/a_6086_4650# SAR/a_6891_4772# SAR/a_6346_4873# vdd sg13_lv_pmos ad=0.1428p pd=1.52u as=79.8f ps=0.8u w=0.42u l=0.13u
X1900 vss SAR/a_12815_4261# SAR/a_13652_3900# vss sg13_lv_nmos ad=0.1406p pd=1.12u as=0.2516p ps=2.16u w=0.74u l=0.13u
X1901 SAR/a_996_7349# SAR/a_1227_6935# SAR/a_682_6892# vss sg13_lv_nmos ad=0.2373p pd=1.97u as=79.8f ps=0.8u w=0.42u l=0.13u
X1902 SAR/a_8588_3864# SAR/sg13cmos5l_buf_1_46.A vss vss sg13_lv_nmos ad=0.187p pd=1.78u as=0.14875p ps=1.16u w=0.55u l=0.13u
X1903 SAR/sg13cmos5l_buf_1_10.A SAR/a_11848_8436# vss vss sg13_lv_nmos ad=0.2886p pd=2.26u as=0.14875p ps=1.16u w=0.74u l=0.13u
X1904 SAR/sg13cmos5l_dlhr_1_21.Q_N SAR/a_10998_9168# vdd vdd sg13_lv_pmos ad=0.3808p pd=2.92u as=0.1974p ps=1.5u w=1.12u l=0.13u
X1905 SAR/sg13cmos5l_buf_1_18.A SAR/sg13cmos5l_buf_1_111.A vss vss sg13_lv_nmos ad=0.2516p pd=2.16u as=0.2516p ps=2.16u w=0.74u l=0.13u
X1906 vss SAR/a_9111_4666# SAR/a_9242_4660# vss sg13_lv_nmos ad=2.41737p pd=15.64u as=0.2775p ps=2.23u w=0.74u l=0.13u
X1907 SAR/a_1862_8874# SAR/sg13cmos5l_dfrbp_1_17.D vdd vdd sg13_lv_pmos ad=79.8f pd=0.8u as=0.1428p ps=1.52u w=0.42u l=0.13u
X1908 SAR/a_8746_8404# SAR/a_9189_8447# SAR/a_8486_8874# vss sg13_lv_nmos ad=79.8f pd=0.8u as=0.1296p ps=1.52u w=0.42u l=0.13u
X1909 SAR/a_10331_3900# SAR/sg13cmos5l_a221oi_1_0.C1 vdd vdd sg13_lv_pmos ad=0.3808p pd=2.92u as=0.2128p ps=1.5u w=1.12u l=0.13u
X1910 SAR/sg13cmos5l_inv_1_1.A SAR/a_15208_6200# vdd vdd sg13_lv_pmos ad=0.42p pd=2.99u as=0.2114p ps=1.54u w=1.12u l=0.13u
X1911 SAR/sg13cmos5l_dfrbp_1_21.Q_N SAR/a_17519_6239# vdd vdd sg13_lv_pmos ad=0.4312p pd=3.01u as=0.2639p ps=1.81u w=1.12u l=0.13u
X1912 vss SAR/a_6117_6141# SAR/a_6219_6284# vss sg13_lv_nmos ad=1.97045p pd=12.335u as=0.2516p ps=2.16u w=0.74u l=0.13u
X1913 vdd SAR/sg13cmos5l_nor2_1_0.A SAR/sg13cmos5l_a22oi_1_0.B1 vdd sg13_lv_pmos ad=0.3808p pd=2.92u as=0.2128p ps=1.5u w=1.12u l=0.13u
X1914 vdd SAR/sg13cmos5l_inv_1_0.A SAR/a_11072_5347# vdd sg13_lv_pmos ad=0.1596p pd=1.22u as=0.1596p ps=1.22u w=0.84u l=0.13u
X1915 vss SAR/a_13641_7674# SAR/a_14166_7656# vss sg13_lv_nmos ad=0.1491p pd=1.18u as=0.187p ps=1.78u w=0.55u l=0.13u
X1916 SAR/a_5220_2392# SAR/a_5194_2356# vdd vdd sg13_lv_pmos ad=0.34p pd=2.68u as=0.36237p ps=2.605u w=1u l=0.13u
X1917 SAR/a_7095_1642# SAR/sg13cmos5l_dlhr_1_0.GATE vdd vdd sg13_lv_pmos ad=0.3234p pd=2.45u as=1.777p ps=11.395u w=0.84u l=0.13u
X1918 SAR/a_20492_8400# SAR/sg13cmos5l_buf_1_104.X vdd vdd sg13_lv_pmos ad=0.2856p pd=2.36u as=0.2114p ps=1.54u w=0.84u l=0.13u
X1919 vss SAR/sg13cmos5l_dfrbp_1_6.RESET_B SAR/a_19444_5800# vss sg13_lv_nmos ad=0.1406p pd=1.12u as=77.7f ps=0.95u w=0.74u l=0.13u
X1920 SAR/a_1997_6126# SAR/a_2727_6380# SAR/a_2638_6477# vdd sg13_lv_pmos ad=0.2048p pd=1.63u as=93.45f ps=0.865u w=0.42u l=0.13u
X1921 SAR/a_11844_4325# SAR/a_11556_3904# SAR/a_11782_4325# vss sg13_lv_nmos ad=0.1428p pd=1.52u as=37.8f ps=0.6u w=0.42u l=0.13u
X1922 SAR/sg13cmos5l_dfrbp_1_9.Q SAR/a_4244_3900# vss vss sg13_lv_nmos ad=0.2516p pd=2.16u as=0.1406p ps=1.12u w=0.74u l=0.13u
X1923 SAR/sg13cmos5l_buf_1_89.A SAR/a_14889_7281# vdd vdd sg13_lv_pmos ad=0.3808p pd=2.92u as=0.2128p ps=1.5u w=1.12u l=0.13u
X1924 SAR/a_11372_3102# SAR/sg13cmos5l_buf_1_9.A vdd vdd sg13_lv_pmos ad=0.2856p pd=2.36u as=0.2114p ps=1.54u w=0.84u l=0.13u
X1925 vss SAR/sg13cmos5l_buf_1_10.A SAR/a_12520_3176# vss sg13_lv_nmos ad=0.14875p pd=1.16u as=0.187p ps=1.78u w=0.55u l=0.13u
X1926 vss SAR/a_7888_4870# SAR/a_7537_4727# vss sg13_lv_nmos ad=79.8f pd=0.8u as=0.1428p ps=1.52u w=0.42u l=0.13u
X1927 SAR/a_2169_7047# SAR/a_1227_6935# SAR/a_1967_7285# vdd sg13_lv_pmos ad=93.45f pd=0.865u as=0.2048p ps=1.63u w=0.42u l=0.13u
X1928 SAR/a_14640_6924# SAR/a_14089_7282# vdd vdd sg13_lv_pmos ad=0.105p pd=1.21u as=1.07253p ps=6.75u w=1u l=0.13u
X1929 vss SAR/sg13cmos5l_dfrbp_1_8.RESET_B SAR/a_5796_8874# vss sg13_lv_nmos ad=0.1626p pd=1.415u as=60.89999f ps=0.71u w=0.42u l=0.13u
X1930 SAR/a_11567_7751# SAR/a_10725_7653# SAR/a_11473_7751# vss sg13_lv_nmos ad=0.12665p pd=1.145u as=0.1428p ps=1.52u w=0.42u l=0.13u
X1931 vdd SAR/sg13cmos5l_inv_1_18.A SAR/sg13cmos5l_buf_1_28.A vdd sg13_lv_pmos ad=0.3808p pd=2.92u as=0.3808p ps=2.92u w=1.12u l=0.13u
X1932 SAR/sg13cmos5l_dlhr_1_3.Q_N SAR/a_4566_2818# vss vss sg13_lv_nmos ad=0.2516p pd=2.16u as=0.1491p ps=1.18u w=0.74u l=0.13u
X1933 vss SAR/a_6736_2630# SAR/a_6385_2749# vss sg13_lv_nmos ad=79.8f pd=0.8u as=0.1428p ps=1.52u w=0.42u l=0.13u
X1934 SAR/sg13cmos5l_dlhr_1_2.Q_N SAR/a_8022_3120# vdd vdd sg13_lv_pmos ad=0.3808p pd=2.92u as=0.1974p ps=1.5u w=1.12u l=0.13u
X1935 SAR/a_15045_8447# SAR/sg13cmos5l_inv_1_2.A vss vss sg13_lv_nmos ad=0.2516p pd=2.16u as=2.71505p ps=17.54u w=0.74u l=0.13u
X1936 vss SAR/a_15909_2399# SAR/a_16011_2399# vss sg13_lv_nmos ad=2.59257p pd=16.445u as=0.2516p ps=2.16u w=0.74u l=0.13u
X1937 SAR/a_12873_6553# SAR/a_12516_6480# vdd vdd sg13_lv_pmos ad=63f pd=0.72u as=0.1563p ps=1.22u w=0.42u l=0.13u
X1938 vdd vss vdd vdd sg13_lv_pmos ad=0.34p pd=2.68u as=0 ps=0 w=1u l=1u
X1939 SAR/a_9823_2364# SAR/sg13cmos5l_inv_1_11.Y vdd vdd sg13_lv_pmos ad=0.2716p pd=1.605u as=0.3808p ps=2.92u w=1.12u l=0.13u
X1940 SAR/a_10428_9222# SAR/a_9879_9202# SAR/a_10292_9508# vss sg13_lv_nmos ad=47.25f pd=0.645u as=0.141p ps=1.17u w=0.42u l=0.13u
X1941 vdd SAR/sg13cmos5l_nand2_1_1.A SAR/sg13cmos5l_o21ai_1_0.B1 vdd sg13_lv_pmos ad=0.3808p pd=2.92u as=0.2128p ps=1.5u w=1.12u l=0.13u
X1942 vss SAR/a_3669_6320# SAR/a_2748_6126# vss sg13_lv_nmos ad=0.1626p pd=1.415u as=0.2516p ps=2.16u w=0.74u l=0.13u
X1943 vdd vss vdd vdd sg13_lv_pmos ad=0.19p pd=1.38u as=0 ps=0 w=1u l=1u
X1944 vdd vss vdd vdd sg13_lv_pmos ad=0.19p pd=1.38u as=0 ps=0 w=1u l=1u
X1945 SAR/sg13cmos5l_buf_1_28.X SAR/a_9448_1664# vdd vdd sg13_lv_pmos ad=0.42p pd=2.99u as=0.2114p ps=1.54u w=1.12u l=0.13u
X1946 vdd SAR/sg13cmos5l_dfrbp_1_8.RESET_B SAR/a_12106_9409# vdd sg13_lv_pmos ad=0.1563p pd=1.22u as=0.147p ps=1.54u w=0.42u l=0.13u
X1947 SAR/a_14583_5770# SAR/sg13cmos5l_dfrbp_1_23.CLK vss vss sg13_lv_nmos ad=0.2516p pd=2.16u as=0.15055p ps=1.17u w=0.74u l=0.13u
X1948 SAR/sg13cmos5l_dlhr_1_11.GATE SAR/a_10868_8436# vss vss sg13_lv_nmos ad=0.2516p pd=2.16u as=0.1406p ps=1.12u w=0.74u l=0.13u
X1949 vss SAR/a_7497_3138# SAR/a_8022_3120# vss sg13_lv_nmos ad=0.1491p pd=1.18u as=0.187p ps=1.78u w=0.55u l=0.13u
X1950 SAR/a_5546_5850# SAR/a_5069_5376# SAR/a_5452_5850# vss sg13_lv_nmos ad=37.8f pd=0.6u as=0.1428p ps=1.52u w=0.42u l=0.13u
X1951 vss SAR/a_12567_7282# SAR/a_12698_7288# vss sg13_lv_nmos ad=1.49685p pd=9.6u as=0.2775p ps=2.23u w=0.74u l=0.13u
X1952 SAR/a_3669_6320# SAR/a_2727_6380# SAR/a_3530_6320# vss sg13_lv_nmos ad=79.8f pd=0.8u as=0.2373p ps=1.97u w=0.42u l=0.13u
X1953 vdd SAR/sg13cmos5l_dfrbp_1_0.Q SAR/a_14254_2444# vdd sg13_lv_pmos ad=0.2618p pd=1.63u as=0.2856p ps=2.36u w=0.84u l=0.13u
X1954 SAR/a_1956_4338# SAR/sg13cmos5l_dlhr_1_1.GATE SAR/a_1862_4338# vss sg13_lv_nmos ad=60.89999f pd=0.71u as=0.1428p ps=1.52u w=0.42u l=0.13u
X1955 SAR/a_1878_6337# SAR/a_1997_6126# vss vss sg13_lv_nmos ad=0.2516p pd=2.16u as=0.1406p ps=1.12u w=0.74u l=0.13u
X1956 SAR/a_14814_4292# SAR/sg13cmos5l_nand2_1_1.B vss vss sg13_lv_nmos ad=96.2f pd=1u as=0.2516p ps=2.16u w=0.74u l=0.13u
X1957 SAR/sg13cmos5l_buf_1_116.A SAR/a_15177_5769# vss vss sg13_lv_nmos ad=0.2516p pd=2.16u as=0.1406p ps=1.12u w=0.74u l=0.13u
X1958 SAR/a_12516_6480# SAR/a_12490_6385# vss vss sg13_lv_nmos ad=0.2516p pd=2.16u as=0.1626p ps=1.415u w=0.74u l=0.13u
X1959 SAR/a_19340_8400# SAR/sg13cmos5l_buf_1_107.X vss vss sg13_lv_nmos ad=0.187p pd=1.78u as=0.14875p ps=1.16u w=0.55u l=0.13u
X1960 vss SAR/sg13cmos5l_dfrbp_1_6.RESET_B SAR/a_2644_4636# vss sg13_lv_nmos ad=0.1406p pd=1.12u as=77.7f ps=0.95u w=0.74u l=0.13u
X1961 SAR/a_7812_7687# SAR/a_7524_7992# SAR/a_7750_7687# vss sg13_lv_nmos ad=0.1428p pd=1.52u as=37.8f ps=0.6u w=0.42u l=0.13u
X1962 SAR/a_2224_5654# SAR/a_1967_5773# SAR/a_2386_5850# vss sg13_lv_nmos ad=0.1428p pd=1.52u as=37.8f ps=0.6u w=0.42u l=0.13u
X1963 vdd SAR/a_17751_7690# SAR/a_17882_7684# vdd sg13_lv_pmos ad=1.15047p pd=7.175u as=0.2856p ps=2.36u w=0.84u l=0.13u
X1964 vdd SAR/sg13cmos5l_dfrbp_1_6.RESET_B SAR/a_19209_5769# vdd sg13_lv_pmos ad=0.2128p pd=1.5u as=0.2128p ps=1.5u w=1.12u l=0.13u
X1965 SAR/a_6843_5459# SAR/a_5951_5383# SAR/a_6741_5459# vdd sg13_lv_pmos ad=63f pd=0.72u as=79.8f ps=0.8u w=0.42u l=0.13u
X1966 vdd SAR/sg13cmos5l_buf_1_40.A SAR/sg13cmos5l_buf_1_63.A vdd sg13_lv_pmos ad=0.3808p pd=2.92u as=0.3808p ps=2.92u w=1.12u l=0.13u
X1967 vdd SAR/sg13cmos5l_inv_1_2.A SAR/sg13cmos5l_dfrbp_1_0.CLK vdd sg13_lv_pmos ad=0.3808p pd=2.92u as=0.3808p ps=2.92u w=1.12u l=0.13u
X1968 SAR/sg13cmos5l_and3_1_0.X SAR/a_13324_4696# vdd vdd sg13_lv_pmos ad=0.3808p pd=2.92u as=0.36195p ps=1.84u w=1.12u l=0.13u
X1969 vdd SAR/a_10071_7282# SAR/a_10202_7288# vdd sg13_lv_pmos ad=1.07253p pd=6.75u as=0.2856p ps=2.36u w=0.84u l=0.13u
X1970 SAR/a_19028_5412# SAR/a_18615_5770# SAR/a_18960_5412# vdd sg13_lv_pmos ad=0.191p pd=1.44u as=0.105p ps=1.21u w=1u l=0.13u
X1971 SAR/a_10427_2736# SAR/sg13cmos5l_nor2_1_0.A vss vss sg13_lv_nmos ad=78.39999f pd=0.885u as=0.2272p ps=1.99u w=0.64u l=0.13u
X1972 vdd SAR/sg13cmos5l_buf_1_25.X SAR/a_4456_1664# vdd sg13_lv_pmos ad=0.2114p pd=1.54u as=0.2856p ps=2.36u w=0.84u l=0.13u
X1973 vdd SAR/a_8783_7751# SAR/a_9620_7972# vdd sg13_lv_pmos ad=0.2128p pd=1.5u as=0.3864p ps=2.93u w=1.12u l=0.13u
X1974 SAR/sg13cmos5l_buf_1_9.A SAR/a_9832_1664# vdd vdd sg13_lv_pmos ad=0.42p pd=2.99u as=0.2114p ps=1.54u w=1.12u l=0.13u
X1975 vss SAR/sg13cmos5l_dfrbp_1_6.RESET_B SAR/a_14820_7674# vss sg13_lv_nmos ad=0.1626p pd=1.415u as=60.89999f ps=0.71u w=0.42u l=0.13u
X1976 vss SAR/sg13cmos5l_inv_1_5.A SAR/a_20392_3900# vss sg13_lv_nmos ad=0.14875p pd=1.16u as=0.187p ps=1.78u w=0.55u l=0.13u
X1977 vdd SAR/a_1125_5423# SAR/a_1227_5423# vdd sg13_lv_pmos ad=1.28962p pd=8.195u as=0.3864p ps=2.93u w=1.12u l=0.13u
X1978 SAR/a_2436_4325# SAR/a_2148_3904# SAR/a_2374_4325# vss sg13_lv_nmos ad=0.1428p pd=1.52u as=37.8f ps=0.6u w=0.42u l=0.13u
X1979 SAR/sg13cmos5l_buf_8_1.A SAR/a_17972_4948# vdd vdd sg13_lv_pmos ad=0.3808p pd=2.92u as=0.2128p ps=1.5u w=1.12u l=0.13u
X1980 SAR/sg13cmos5l_dfrbp_1_6.RESET_B _cks vdd vdd sg13_lv_pmos ad=0.2184p pd=1.51u as=0.2128p ps=1.5u w=1.12u l=0.13u
X1981 SAR/a_3302_4650# SAR/a_4107_4772# SAR/a_3562_4873# vdd sg13_lv_pmos ad=0.1428p pd=1.52u as=79.8f ps=0.8u w=0.42u l=0.13u
X1982 vss SAR/a_16268_1590# nl_sw[7] vss sg13_lv_nmos ad=0.14875p pd=1.16u as=0.2886p ps=2.26u w=0.74u l=0.13u
X1983 SAR/a_8457_7281# SAR/a_8276_6924# vdd vdd sg13_lv_pmos ad=0.2128p pd=1.5u as=0.2387p ps=1.84u w=1.12u l=0.13u
X1984 SAR/sg13cmos5l_dfrbp_1_11.Q_N SAR/a_7631_4727# vss vss sg13_lv_nmos ad=0.2849p pd=2.25u as=0.2516p ps=2.16u w=0.74u l=0.13u
X1985 vss SAR/a_17132_9150# ph_sw[7] vss sg13_lv_nmos ad=0.14875p pd=1.16u as=0.2886p ps=2.26u w=0.74u l=0.13u
X1986 vss SAR/sg13cmos5l_buf_1_73.X SAR/a_5800_9224# vss sg13_lv_nmos ad=0.14875p pd=1.16u as=0.187p ps=1.78u w=0.55u l=0.13u
X1987 SAR/sg13cmos5l_buf_1_104.X SAR/a_19624_8436# vss vss sg13_lv_nmos ad=0.2886p pd=2.26u as=0.14875p ps=1.16u w=0.74u l=0.13u
X1988 ph_sw[3] SAR/a_5416_9224# vss vss sg13_lv_nmos ad=0.2886p pd=2.26u as=0.14875p ps=1.16u w=0.74u l=0.13u
X1989 SAR/a_3926_6175# SAR/a_2748_6126# SAR/a_3530_6320# vss sg13_lv_nmos ad=37.8f pd=0.6u as=0.1428p ps=1.52u w=0.42u l=0.13u
X1990 SAR/a_13094_6924# SAR/a_12698_7288# SAR/a_12980_6924# vdd sg13_lv_pmos ad=0.1008p pd=0.9u as=0.191p ps=1.44u w=0.42u l=0.13u
X1991 vss SAR/a_6479_2749# SAR/a_7316_2388# vss sg13_lv_nmos ad=0.1406p pd=1.12u as=0.2516p ps=2.16u w=0.74u l=0.13u
X1992 SAR/a_9705_4650# SAR/a_9524_4972# vdd vdd sg13_lv_pmos ad=0.2128p pd=1.5u as=0.2387p ps=1.84u w=1.12u l=0.13u
X1993 vdd _cks SAR/sg13cmos5l_dfrbp_1_6.RESET_B vdd sg13_lv_pmos ad=0.2128p pd=1.5u as=0.2128p ps=1.5u w=1.12u l=0.13u
X1994 SAR/a_18873_1941# SAR/a_17931_1748# SAR/a_18671_1703# vdd sg13_lv_pmos ad=93.45f pd=0.865u as=0.2048p ps=1.63u w=0.42u l=0.13u
X1995 vdd SAR/a_1402_3864# SAR/a_1121_4166# vdd sg13_lv_pmos ad=0.1523p pd=1.38u as=0.34p ps=2.68u w=1u l=0.5u
X1996 SAR/a_13034_5412# SAR/sg13cmos5l_nor2_1_0.A SAR/sg13cmos5l_or2_1_1.B vdd sg13_lv_pmos ad=0.1176p pd=1.33u as=0.3808p ps=2.92u w=1.12u l=0.13u
X1997 vss SAR/a_7863_7282# SAR/a_7994_7288# vss sg13_lv_nmos ad=1.49685p pd=9.6u as=0.2775p ps=2.23u w=0.74u l=0.13u
X1998 SAR/a_16551_3987# SAR/a_16703_3871# vss vss sg13_lv_nmos ad=0.2516p pd=2.16u as=2.41737p ps=15.64u w=0.74u l=0.13u
X1999 SAR/a_7524_7992# SAR/a_7498_7897# vdd vdd sg13_lv_pmos ad=0.34p pd=2.68u as=0.36237p ps=2.605u w=1u l=0.13u
X2000 vdd SAR/a_7095_1642# SAR/a_7226_1636# vdd sg13_lv_pmos ad=1.86162p pd=11.935u as=0.2856p ps=2.36u w=0.84u l=0.13u
X2001 SAR/a_7820_2352# SAR/sg13cmos5l_dlhr_1_0.Q vdd vdd sg13_lv_pmos ad=0.2856p pd=2.36u as=0.2114p ps=1.54u w=0.84u l=0.13u
X2002 vss SAR/a_10028_6126# SAR/sg13cmos5l_inv_1_18.A vss sg13_lv_nmos ad=0.14875p pd=1.16u as=0.2886p ps=2.26u w=0.74u l=0.13u
X2003 SAR/a_4076_7624# SAR/a_4324_7996# SAR/a_4282_8112# vdd sg13_lv_pmos ad=0.191p pd=1.44u as=0.1008p ps=0.9u w=0.42u l=0.13u
X2004 SAR/sg13cmos5l_a22oi_1_0.Y SAR/sg13cmos5l_inv_1_0.A SAR/a_10783_4292# vss sg13_lv_nmos ad=0.2664p pd=1.46u as=0.13875p ps=1.115u w=0.74u l=0.13u
X2005 vss vdd vss vss sg13_lv_nmos ad=0.1428p pd=1.52u as=0 ps=0 w=0.42u l=1u
X2006 vdd SAR/sg13cmos5l_dfrbp_1_6.RESET_B SAR/a_14986_7897# vdd sg13_lv_pmos ad=0.1563p pd=1.22u as=0.147p ps=1.54u w=0.42u l=0.13u
X2007 SAR/a_2790_7996# SAR/a_2621_7636# SAR/a_2348_7624# vdd sg13_lv_pmos ad=0.105p pd=1.21u as=0.191p ps=1.44u w=1u l=0.13u
X2008 vss SAR/a_7055_4261# SAR/a_7892_3900# vss sg13_lv_nmos ad=0.1406p pd=1.12u as=0.2516p ps=2.16u w=0.74u l=0.13u
X2009 SAR/a_7312_4142# SAR/a_7055_4261# SAR/a_7474_4338# vss sg13_lv_nmos ad=0.1428p pd=1.52u as=37.8f ps=0.6u w=0.42u l=0.13u
X2010 SAR/a_17414_3138# SAR/sg13cmos5l_a22oi_1_1.Y vdd vdd sg13_lv_pmos ad=79.8f pd=0.8u as=0.1428p ps=1.52u w=0.42u l=0.13u
X2011 SAR/a_12489_9577# SAR/a_12132_9504# vdd vdd sg13_lv_pmos ad=63f pd=0.72u as=0.1563p ps=1.22u w=0.42u l=0.13u
X2012 vss SAR/a_13072_4142# SAR/a_12721_4261# vss sg13_lv_nmos ad=79.8f pd=0.8u as=0.1428p ps=1.52u w=0.42u l=0.13u
X2013 SAR/a_10412_6126# SAR/sg13cmos5l_dlhr_1_5.Q vdd vdd sg13_lv_pmos ad=0.2856p pd=2.36u as=0.2114p ps=1.54u w=0.84u l=0.13u
X2014 SAR/sg13cmos5l_dlhr_1_4.Q_N SAR/a_6198_3120# vss vss sg13_lv_nmos ad=0.2516p pd=2.16u as=0.1491p ps=1.18u w=0.74u l=0.13u
X2015 vss SAR/a_12216_5728# SAR/sg13cmos5l_a221oi_1_0.B1 vss sg13_lv_nmos ad=0.1469p pd=1.155u as=0.2516p ps=2.16u w=0.74u l=0.13u
X2016 SAR/a_7863_7282# SAR/sg13cmos5l_dlhr_1_5.GATE vdd vdd sg13_lv_pmos ad=0.3234p pd=2.45u as=1.04815p ps=6.595u w=0.84u l=0.13u
X2017 SAR/sg13cmos5l_dfrbp_1_18.Q_N SAR/a_7247_8797# vss vss sg13_lv_nmos ad=0.2849p pd=2.25u as=0.2516p ps=2.16u w=0.74u l=0.13u
X2018 SAR/a_13391_9263# SAR/a_12549_9165# SAR/a_12132_9504# vdd sg13_lv_pmos ad=0.2048p pd=1.63u as=0.34p ps=2.68u w=1u l=0.13u
X2019 SAR/a_12716_8400# SAR/sg13cmos5l_buf_1_79.X vss vss sg13_lv_nmos ad=0.187p pd=1.78u as=0.14875p ps=1.16u w=0.55u l=0.13u
X2020 SAR/a_15357_1816# SAR/sg13cmos5l_dfrbp_1_0.Q vdd vdd sg13_lv_pmos ad=0.2856p pd=2.36u as=0.2198p ps=1.53u w=0.84u l=0.13u
X2021 vss SAR/sg13cmos5l_inv_1_2.A SAR/sg13cmos5l_dfrbp_1_0.CLK vss sg13_lv_nmos ad=0.2516p pd=2.16u as=0.2516p ps=2.16u w=0.74u l=0.13u
X2022 SAR/a_17938_6162# SAR/sg13cmos5l_dfrbp_1_6.RESET_B vss vss sg13_lv_nmos ad=37.8f pd=0.6u as=79.8f ps=0.8u w=0.42u l=0.13u
X2023 vss SAR/a_13161_7281# SAR/a_13116_7326# vss sg13_lv_nmos ad=0.1428p pd=1.52u as=47.25f ps=0.645u w=0.42u l=0.13u
X2024 vdd SAR/sg13cmos5l_dfrbp_1_6.RESET_B SAR/a_4425_7281# vdd sg13_lv_pmos ad=0.2128p pd=1.5u as=0.2128p ps=1.5u w=1.12u l=0.13u
X2025 SAR/sg13cmos5l_inv_1_7.A SAR/a_11464_8436# vss vss sg13_lv_nmos ad=0.2886p pd=2.26u as=0.14875p ps=1.16u w=0.74u l=0.13u
X2026 SAR/sg13cmos5l_dlhr_1_15.Q_N SAR/a_18870_7656# vdd vdd sg13_lv_pmos ad=0.3808p pd=2.92u as=0.1974p ps=1.5u w=1.12u l=0.13u
X2027 SAR/a_1196_8400# SAR/sg13cmos5l_buf_1_63.A vss vss sg13_lv_nmos ad=0.187p pd=1.78u as=0.14875p ps=1.16u w=0.55u l=0.13u
X2028 SAR/a_13072_1846# SAR/a_12815_1703# SAR/a_13234_1626# vss sg13_lv_nmos ad=0.1428p pd=1.52u as=37.8f ps=0.6u w=0.42u l=0.13u
X2029 SAR/a_13486_5412# SAR/sg13cmos5l_or2_1_1.B SAR/a_13698_5412# vdd sg13_lv_pmos ad=0.2128p pd=1.5u as=0.3808p ps=2.92u w=1.12u l=0.13u
X2030 vdd SAR/a_12719_2749# SAR/a_13556_2388# vdd sg13_lv_pmos ad=0.2128p pd=1.5u as=0.3864p ps=2.93u w=1.12u l=0.13u
X2031 SAR/a_4244_6924# SAR/a_3831_7282# SAR/a_4176_6924# vdd sg13_lv_pmos ad=0.191p pd=1.44u as=0.105p ps=1.21u w=1u l=0.13u
X2032 vss SAR/sg13cmos5l_buf_1_3.X SAR/a_20392_3176# vss sg13_lv_nmos ad=0.14875p pd=1.16u as=0.187p ps=1.78u w=0.55u l=0.13u
X2033 vss SAR/a_19628_2352# nh_sw[9] vss sg13_lv_nmos ad=0.14875p pd=1.16u as=0.2886p ps=2.26u w=0.74u l=0.13u
X2034 vdd SAR/a_1158_3142# SAR/a_1290_3206# vdd sg13_lv_pmos ad=0.2245p pd=1.53u as=0.445p ps=2.89u w=1u l=0.25u
X2035 SAR/a_2565_8447# SAR/sg13cmos5l_inv_1_8.A vdd vdd sg13_lv_pmos ad=0.4088p pd=2.97u as=1.12242p ps=7u w=1.12u l=0.13u
X2036 SAR/a_14628_8440# SAR/a_15147_8447# SAR/a_15887_8797# vss sg13_lv_nmos ad=0.3473p pd=2.71u as=0.12665p ps=1.145u w=0.74u l=0.13u
X2037 vdd SAR/a_1948_7964# SAR/sg13cmos5l_buf_1_58.A vdd sg13_lv_pmos ad=0.2128p pd=1.5u as=0.3808p ps=2.92u w=1.12u l=0.13u
X2038 vss SAR/sg13cmos5l_buf_1_18.A SAR/a_18376_2388# vss sg13_lv_nmos ad=0.14875p pd=1.16u as=0.187p ps=1.78u w=0.55u l=0.13u
X2039 vss SAR/a_8247_5770# SAR/a_8378_5776# vss sg13_lv_nmos ad=1.97045p pd=12.335u as=0.2775p ps=2.23u w=0.74u l=0.13u
X2040 SAR/a_3974_2388# SAR/a_3578_2752# SAR/a_3860_2388# vdd sg13_lv_pmos ad=0.1008p pd=0.9u as=0.191p ps=1.44u w=0.42u l=0.13u
X2041 vdd SAR/a_2409_4650# SAR/a_2934_4632# vdd sg13_lv_pmos ad=0.1974p pd=1.5u as=0.2856p ps=2.36u w=0.84u l=0.13u
X2042 SAR/a_2374_8861# SAR/sg13cmos5l_dfrbp_1_8.RESET_B vss vss sg13_lv_nmos ad=37.8f pd=0.6u as=0.1701p ps=1.65u w=0.42u l=0.13u
X2043 SAR/a_18928_1846# SAR/sg13cmos5l_dfrbp_1_0.RESET_B vdd vdd sg13_lv_pmos ad=79.8f pd=0.8u as=1.777p ps=11.395u w=0.42u l=0.13u
X2044 vdd SAR/a_17516_9150# pl_sw[8] vdd sg13_lv_pmos ad=0.2114p pd=1.54u as=0.42p ps=2.99u w=1.12u l=0.13u
X2045 vss SAR/sg13cmos5l_dlhr_1_9.D SAR/a_10587_4692# vss sg13_lv_nmos ad=0.14505p pd=1.15u as=0.187p ps=1.78u w=0.55u l=0.13u
X2046 SAR/a_1158_3142# SAR/a_902_3142# vss vss sg13_lv_nmos ad=0.1428p pd=1.52u as=0.1323p ps=1.05u w=0.42u l=0.18u
X2047 vdd SAR/a_6572_1590# SAR/sg13cmos5l_buf_1_24.X vdd sg13_lv_pmos ad=0.2114p pd=1.54u as=0.42p ps=2.99u w=1.12u l=0.13u
X2048 vdd SAR/a_1580_2352# nh_sw[0] vdd sg13_lv_pmos ad=0.2114p pd=1.54u as=0.42p ps=2.99u w=1.12u l=0.13u
X2049 vdd SAR/sg13cmos5l_a221oi_1_0.A2 SAR/a_8041_5770# vdd sg13_lv_pmos ad=1.28962p pd=8.195u as=0.2856p ps=2.36u w=0.84u l=0.13u
X2050 SAR/a_7833_4965# SAR/a_6891_4772# SAR/a_7631_4727# vdd sg13_lv_pmos ad=93.45f pd=0.865u as=0.2048p ps=1.63u w=0.42u l=0.13u
X2051 pl_sw[4] SAR/a_5800_9224# vdd vdd sg13_lv_pmos ad=0.42p pd=2.99u as=0.2114p ps=1.54u w=1.12u l=0.13u
X2052 vss SAR/a_17751_7690# SAR/a_17882_7684# vss sg13_lv_nmos ad=1.49685p pd=9.6u as=0.2775p ps=2.23u w=0.74u l=0.13u
X2053 SAR/a_19828_6148# SAR/a_19412_6484# SAR/a_19593_6162# vss sg13_lv_nmos ad=77.7f pd=0.95u as=0.2516p ps=2.16u w=0.74u l=0.13u
X2054 vss SAR/a_15702_4187# SAR/sg13cmos5l_and3_1_0.C vss sg13_lv_nmos ad=0.1406p pd=1.12u as=0.2516p ps=2.16u w=0.74u l=0.13u
X2055 vdd SAR/a_6479_2749# SAR/a_6736_2630# vdd sg13_lv_pmos ad=0.2639p pd=1.81u as=79.8f ps=0.8u w=0.42u l=0.13u
X2056 SAR/sg13cmos5l_inv_1_9.Y _cks vdd vdd sg13_lv_pmos ad=0.3808p pd=2.92u as=0.3808p ps=2.92u w=1.12u l=0.13u
X2057 SAR/a_5508_2813# SAR/a_5739_2399# SAR/a_5194_2356# vss sg13_lv_nmos ad=0.2373p pd=1.97u as=79.8f ps=0.8u w=0.42u l=0.13u
X2058 vdd SAR/a_9879_9202# SAR/a_10010_9196# vdd sg13_lv_pmos ad=4.11675p pd=27.17u as=0.2856p ps=2.36u w=0.84u l=0.13u
X2059 SAR/sg13cmos5l_buf_1_90.X SAR/a_11464_9224# vss vss sg13_lv_nmos ad=0.2886p pd=2.26u as=0.14875p ps=1.16u w=0.74u l=0.13u
X2060 vdd vss vdd vdd sg13_lv_pmos ad=0.34p pd=2.68u as=0 ps=0 w=1u l=1u
X2061 SAR/a_15492_2392# SAR/a_16011_2399# SAR/a_16751_2749# vss sg13_lv_nmos ad=0.3473p pd=2.71u as=0.12665p ps=1.145u w=0.74u l=0.13u
X2062 SAR/a_2583_7710# SAR/a_1948_7964# vss vss sg13_lv_nmos ad=47.25f pd=0.645u as=0.1428p ps=1.52u w=0.42u l=0.13u
X2063 vdd SAR/a_5673_3138# SAR/a_5606_3576# vdd sg13_lv_pmos ad=0.2387p pd=1.84u as=0.1008p ps=0.9u w=0.42u l=0.13u
X2064 SAR/sg13cmos5l_dfrbp_1_5.Q_N SAR/a_16751_2749# vss vss sg13_lv_nmos ad=0.2849p pd=2.25u as=0.2516p ps=2.16u w=0.74u l=0.13u
X2065 SAR/a_15439_1630# SAR/a_15357_1816# SAR/sg13cmos5l_nand2_1_1.B vss sg13_lv_nmos ad=0.1406p pd=1.12u as=0.333p ps=2.38u w=0.74u l=0.13u
X2066 SAR/sg13cmos5l_buf_1_25.A SAR/sg13cmos5l_inv_1_14.A vdd vdd sg13_lv_pmos ad=0.3808p pd=2.92u as=0.3808p ps=2.92u w=1.12u l=0.13u
X2067 vdd vss vdd vdd sg13_lv_pmos ad=0.34p pd=2.68u as=0 ps=0 w=1u l=1u
X2068 SAR/a_2122_8404# SAR/a_2565_8447# SAR/a_2505_8483# vdd sg13_lv_pmos ad=79.8f pd=0.8u as=63f ps=0.72u w=0.42u l=0.13u
X2069 SAR/a_10225_9178# SAR/a_9673_9240# vss vss sg13_lv_nmos ad=71.99999f pd=0.865u as=2.92392p ps=18.89u w=0.64u l=0.13u
X2070 vdd SAR/a_3447_2746# SAR/a_3578_2752# vdd sg13_lv_pmos ad=1.86162p pd=11.935u as=0.2856p ps=2.36u w=0.84u l=0.13u
X2071 vdd SAR/a_620_2352# nl_sw[0] vdd sg13_lv_pmos ad=0.2114p pd=1.54u as=0.42p ps=2.99u w=1.12u l=0.13u
X2072 SAR/a_13596_7710# SAR/a_13047_7690# SAR/a_13460_7996# vss sg13_lv_nmos ad=47.25f pd=0.645u as=0.141p ps=1.17u w=0.42u l=0.13u
X2073 vss SAR/sg13cmos5l_dfrbp_1_23.Q_N SAR/a_14377_5770# vss sg13_lv_nmos ad=0.15055p pd=1.17u as=0.187p ps=1.78u w=0.55u l=0.13u
X2074 vss SAR/a_10725_7653# SAR/a_10827_7796# vss sg13_lv_nmos ad=1.49685p pd=9.6u as=0.2516p ps=2.16u w=0.74u l=0.13u
X2075 vss SAR/a_20012_1590# SAR/sg13cmos5l_buf_1_0.X vss sg13_lv_nmos ad=0.14875p pd=1.16u as=0.2886p ps=2.26u w=0.74u l=0.13u
X2076 vss SAR/sg13cmos5l_dfrbp_1_6.RESET_B SAR/a_10708_9172# vss sg13_lv_nmos ad=0.1406p pd=1.12u as=77.7f ps=0.95u w=0.74u l=0.13u
X2077 SAR/sg13cmos5l_buf_1_46.A SAR/a_9705_4650# vss vss sg13_lv_nmos ad=0.2516p pd=2.16u as=0.1406p ps=1.12u w=0.74u l=0.13u
X2078 SAR/a_7504_8678# SAR/a_7247_8797# SAR/a_7666_8874# vss sg13_lv_nmos ad=0.1428p pd=1.52u as=37.8f ps=0.6u w=0.42u l=0.13u
X2079 vdd SAR/a_15500_9150# ph_sw[6] vdd sg13_lv_pmos ad=0.2114p pd=1.54u as=0.42p ps=2.99u w=1.12u l=0.13u
X2080 SAR/a_2380_6162# SAR/a_1997_6126# vdd vdd sg13_lv_pmos ad=79.8f pd=0.8u as=0.2639p ps=1.81u w=0.42u l=0.13u
X2081 vss SAR/a_7095_1642# SAR/a_7226_1636# vss sg13_lv_nmos ad=7.01497p pd=46.005u as=0.2775p ps=2.23u w=0.74u l=0.13u
X2082 SAR/a_10596_7687# SAR/a_10827_7796# SAR/a_10282_7897# vss sg13_lv_nmos ad=0.2373p pd=1.97u as=79.8f ps=0.8u w=0.42u l=0.13u
X2083 vdd vss vdd vdd sg13_lv_pmos ad=0.34p pd=2.68u as=0 ps=0 w=1u l=1u
X2084 vss SAR/a_5673_3138# SAR/a_6198_3120# vss sg13_lv_nmos ad=0.1491p pd=1.18u as=0.187p ps=1.78u w=0.55u l=0.13u
X2085 vss SAR/a_2224_5654# SAR/a_1873_5773# vss sg13_lv_nmos ad=79.8f pd=0.8u as=0.1428p ps=1.52u w=0.42u l=0.13u
X2086 vss SAR/a_12815_1703# SAR/a_13652_1924# vss sg13_lv_nmos ad=0.1406p pd=1.12u as=0.2516p ps=2.16u w=0.74u l=0.13u
X2087 SAR/a_13076_5376# SAR/sg13cmos5l_inv_1_0.A vdd vdd sg13_lv_pmos ad=0.2856p pd=2.36u as=0.2618p ps=1.63u w=0.84u l=0.13u
X2088 SAR/a_17516_9150# SAR/sg13cmos5l_buf_1_103.A vdd vdd sg13_lv_pmos ad=0.2856p pd=2.36u as=0.2114p ps=1.54u w=0.84u l=0.13u
X2089 SAR/sg13cmos5l_buf_1_18.A SAR/sg13cmos5l_buf_1_111.A vdd vdd sg13_lv_pmos ad=0.3808p pd=2.92u as=0.3808p ps=2.92u w=1.12u l=0.13u
X2090 vdd SAR/a_18615_5770# SAR/a_18746_5776# vdd sg13_lv_pmos ad=1.28962p pd=8.195u as=0.2856p ps=2.36u w=0.84u l=0.13u
X2091 vss SAR/sg13cmos5l_buf_1_30.A SAR/sg13cmos5l_buf_1_73.A vss sg13_lv_nmos ad=0.2516p pd=2.16u as=0.2516p ps=2.16u w=0.74u l=0.13u
X2092 SAR/sg13cmos5l_dfrbp_1_20.Q_N SAR/a_8783_7751# vss vss sg13_lv_nmos ad=0.2849p pd=2.25u as=0.2516p ps=2.16u w=0.74u l=0.13u
X2093 SAR/a_422_7362# SAR/sg13cmos5l_dfrbp_1_6.D vdd vdd sg13_lv_pmos ad=79.8f pd=0.8u as=0.1428p ps=1.52u w=0.42u l=0.13u
X2094 SAR/a_15357_1816# SAR/sg13cmos5l_dfrbp_1_0.Q vss vss sg13_lv_nmos ad=0.187p pd=1.78u as=0.14505p ps=1.15u w=0.55u l=0.13u
X2095 SAR/a_7394_5850# SAR/sg13cmos5l_dfrbp_1_8.RESET_B vss vss sg13_lv_nmos ad=60.89999f pd=0.71u as=0.1626p ps=1.415u w=0.42u l=0.13u
X2096 vdd SAR/sg13cmos5l_nor2_1_1.A SAR/sg13cmos5l_nand2_1_1.B vdd sg13_lv_pmos ad=0.2198p pd=1.53u as=0.2128p ps=1.5u w=1.12u l=0.13u
X2097 SAR/a_7248_3460# SAR/a_6697_3192# vdd vdd sg13_lv_pmos ad=0.105p pd=1.21u as=1.43437p ps=9.105u w=1u l=0.13u
X2098 SAR/a_620_7638# SAR/sg13cmos5l_buf_1_63.X vdd vdd sg13_lv_pmos ad=0.2856p pd=2.36u as=0.2114p ps=1.54u w=0.84u l=0.13u
X2099 SAR/a_5988_6175# SAR/a_6219_6284# SAR/a_5674_6385# vss sg13_lv_nmos ad=0.2373p pd=1.97u as=79.8f ps=0.8u w=0.42u l=0.13u
X2100 vss SAR/a_20204_5376# SAR/sg13cmos5l_inv_1_6.A vss sg13_lv_nmos ad=0.14875p pd=1.16u as=0.2886p ps=2.26u w=0.74u l=0.13u
X2101 vdd SAR/a_6405_8447# SAR/a_6507_8447# vdd sg13_lv_pmos ad=1.15047p pd=7.175u as=0.3864p ps=2.93u w=1.12u l=0.13u
X2102 SAR/a_14986_7897# SAR/a_15429_7653# SAR/a_14726_7674# vss sg13_lv_nmos ad=79.8f pd=0.8u as=0.1296p ps=1.52u w=0.42u l=0.13u
X2103 vdd SAR/a_13161_7281# SAR/a_13686_7354# vdd sg13_lv_pmos ad=0.1974p pd=1.5u as=0.2856p ps=2.36u w=0.84u l=0.13u
X2104 vss vdd vss vss sg13_lv_nmos ad=0.1428p pd=1.52u as=0 ps=0 w=0.42u l=1u
X2105 vdd SAR/sg13cmos5l_inv_1_7.A SAR/a_12232_8436# vdd sg13_lv_pmos ad=0.2114p pd=1.54u as=0.2856p ps=2.36u w=0.84u l=0.13u
X2106 vdd SAR/sg13cmos5l_buf_1_31.X SAR/a_1672_3176# vdd sg13_lv_pmos ad=0.2114p pd=1.54u as=0.2856p ps=2.36u w=0.84u l=0.13u
X2107 SAR/a_7888_4870# SAR/sg13cmos5l_dfrbp_1_8.RESET_B vdd vdd sg13_lv_pmos ad=79.8f pd=0.8u as=1.2517p ps=7.955u w=0.42u l=0.13u
X2108 SAR/a_16486_6175# SAR/sg13cmos5l_dfrbp_1_6.RESET_B vss vss sg13_lv_nmos ad=37.8f pd=0.6u as=0.1701p ps=1.65u w=0.42u l=0.13u
X2109 SAR/a_15590_4650# SAR/a_16395_4772# SAR/a_15850_4873# vdd sg13_lv_pmos ad=0.1428p pd=1.52u as=79.8f ps=0.8u w=0.42u l=0.13u
X2110 vss SAR/a_10665_7281# SAR/a_10620_7326# vss sg13_lv_nmos ad=0.1428p pd=1.52u as=47.25f ps=0.645u w=0.42u l=0.13u
X2111 SAR/a_12230_6162# SAR/sg13cmos5l_buf_1_57.X vdd vdd sg13_lv_pmos ad=79.8f pd=0.8u as=0.1428p ps=1.52u w=0.42u l=0.13u
X2112 vss SAR/sg13cmos5l_dfrbp_1_8.RESET_B SAR/a_2474_6162# vss sg13_lv_nmos ad=79.8f pd=0.8u as=37.8f ps=0.6u w=0.42u l=0.13u
X2113 SAR/sg13cmos5l_o21ai_1_0.A1 SAR/sg13cmos5l_a221oi_1_0.C1 SAR/a_11394_4948# vdd sg13_lv_pmos ad=0.3808p pd=2.92u as=0.2128p ps=1.5u w=1.12u l=0.13u
X2114 SAR/a_7052_9150# SAR/sg13cmos5l_inv_1_14.A vss vss sg13_lv_nmos ad=0.187p pd=1.78u as=0.14875p ps=1.16u w=0.55u l=0.13u
X2115 vdd SAR/a_10220_3102# nl_sw[5] vdd sg13_lv_pmos ad=0.2114p pd=1.54u as=0.42p ps=2.99u w=1.12u l=0.13u
X2116 vss SAR/sg13cmos5l_dfrbp_1_6.RESET_B SAR/a_4660_7312# vss sg13_lv_nmos ad=0.1406p pd=1.12u as=77.7f ps=0.95u w=0.74u l=0.13u
X2117 SAR/sg13cmos5l_or2_1_0.A SAR/a_18363_4270# vss vss sg13_lv_nmos ad=0.1406p pd=1.12u as=0.1406p ps=1.12u w=0.74u l=0.13u
X2118 SAR/a_11771_5412# SAR/sg13cmos5l_nor2b_1_0.Y SAR/sg13cmos5l_a221oi_1_0.B2 vdd sg13_lv_pmos ad=0.2128p pd=1.5u as=0.3808p ps=2.92u w=1.12u l=0.13u
X2119 vss SAR/sg13cmos5l_dlhr_1_1.D SAR/a_1609_4704# vss sg13_lv_nmos ad=0.15055p pd=1.17u as=0.187p ps=1.78u w=0.55u l=0.13u
X2120 SAR/a_15887_8797# SAR/a_15045_8447# SAR/a_15793_8797# vss sg13_lv_nmos ad=0.12665p pd=1.145u as=0.1428p ps=1.52u w=0.42u l=0.13u
X2121 SAR/sg13cmos5l_buf_1_40.X SAR/a_1192_1664# vss vss sg13_lv_nmos ad=0.2886p pd=2.26u as=0.14875p ps=1.16u w=0.74u l=0.13u
X2122 vdd SAR/a_10725_7653# SAR/a_10827_7796# vdd sg13_lv_pmos ad=1.15047p pd=7.175u as=0.3864p ps=2.93u w=1.12u l=0.13u
X2123 SAR/a_16068_6928# SAR/a_16587_6935# SAR/a_17327_7285# vss sg13_lv_nmos ad=0.3473p pd=2.71u as=0.12665p ps=1.145u w=0.74u l=0.13u
X2124 SAR/sg13cmos5l_a22oi_1_1.B1 SAR/sg13cmos5l_nand2_1_1.B vss vss sg13_lv_nmos ad=0.1406p pd=1.12u as=0.2516p ps=2.16u w=0.74u l=0.13u
X2125 vdd SAR/a_8972_3864# SAR/sg13cmos5l_buf_1_45.X vdd sg13_lv_pmos ad=0.2114p pd=1.54u as=0.42p ps=2.99u w=1.12u l=0.13u
X2126 SAR/a_2122_3868# SAR/a_2565_3911# SAR/a_1862_4338# vss sg13_lv_nmos ad=79.8f pd=0.8u as=0.1296p ps=1.52u w=0.42u l=0.13u
X2127 SAR/a_12490_6385# SAR/a_12933_6141# SAR/a_12873_6553# vdd sg13_lv_pmos ad=79.8f pd=0.8u as=63f ps=0.72u w=0.42u l=0.13u
X2128 vdd SAR/a_1967_5773# SAR/a_2224_5654# vdd sg13_lv_pmos ad=0.2639p pd=1.81u as=79.8f ps=0.8u w=0.42u l=0.13u
X2129 SAR/a_14985_8483# SAR/a_14628_8440# vdd vdd sg13_lv_pmos ad=63f pd=0.72u as=0.1563p ps=1.22u w=0.42u l=0.13u
X2130 vss SAR/sg13cmos5l_buf_1_29.A SAR/a_9832_1664# vss sg13_lv_nmos ad=0.14875p pd=1.16u as=0.187p ps=1.78u w=0.55u l=0.13u
X2131 vss SAR/sg13cmos5l_or2_1_0.A SAR/sg13cmos5l_nand2_1_2.B vss sg13_lv_nmos ad=0.2516p pd=2.16u as=0.1406p ps=1.12u w=0.74u l=0.13u
X2132 vss SAR/sg13cmos5l_buf_1_39.A SAR/a_3688_1664# vss sg13_lv_nmos ad=0.14875p pd=1.16u as=0.187p ps=1.78u w=0.55u l=0.13u
X2133 SAR/a_17769_2017# SAR/a_17412_1944# vdd vdd sg13_lv_pmos ad=63f pd=0.72u as=0.1563p ps=1.22u w=0.42u l=0.13u
X2134 SAR/a_15500_9150# SAR/sg13cmos5l_buf_1_95.X vdd vdd sg13_lv_pmos ad=0.2856p pd=2.36u as=0.2114p ps=1.54u w=0.84u l=0.13u
X2135 SAR/a_2628_3151# SAR/a_2859_3260# SAR/a_2314_3361# vss sg13_lv_nmos ad=0.2373p pd=1.97u as=79.8f ps=0.8u w=0.42u l=0.13u
X2136 SAR/a_12912_6924# SAR/a_12361_7282# vdd vdd sg13_lv_pmos ad=0.105p pd=1.21u as=1.07253p ps=6.75u w=1u l=0.13u
X2137 SAR/a_17746_7362# SAR/sg13cmos5l_dfrbp_1_8.RESET_B vss vss sg13_lv_nmos ad=37.8f pd=0.6u as=79.8f ps=0.8u w=0.42u l=0.13u
X2138 SAR/sg13cmos5l_buf_1_3.A SAR/a_19528_6924# vdd vdd sg13_lv_pmos ad=0.42p pd=2.99u as=0.2114p ps=1.54u w=1.12u l=0.13u
X2139 SAR/sg13cmos5l_buf_1_44.A SAR/a_5673_3138# vdd vdd sg13_lv_pmos ad=0.3808p pd=2.92u as=0.2128p ps=1.5u w=1.12u l=0.13u
X2140 SAR/sg13cmos5l_buf_1_101.X SAR/a_16264_9224# vss vss sg13_lv_nmos ad=0.2886p pd=2.26u as=0.14875p ps=1.16u w=0.74u l=0.13u
X2141 SAR/a_13510_3151# SAR/sg13cmos5l_dfrbp_1_0.RESET_B vss vss sg13_lv_nmos ad=37.8f pd=0.6u as=0.1701p ps=1.65u w=0.42u l=0.13u
X2142 SAR/a_4652_6126# SAR/sg13cmos5l_buf_1_59.A vdd vdd sg13_lv_pmos ad=0.2856p pd=2.36u as=0.2114p ps=1.54u w=0.84u l=0.13u
X2143 vss SAR/a_7312_4142# SAR/a_6961_4261# vss sg13_lv_nmos ad=79.8f pd=0.8u as=0.1428p ps=1.52u w=0.42u l=0.13u
X2144 SAR/a_16528_7894# SAR/a_16271_7751# SAR/a_16690_7674# vss sg13_lv_nmos ad=0.1428p pd=1.52u as=37.8f ps=0.6u w=0.42u l=0.13u
X2145 vss SAR/a_17392_4870# SAR/a_17041_4727# vss sg13_lv_nmos ad=79.8f pd=0.8u as=0.1428p ps=1.52u w=0.42u l=0.13u
X2146 vdd SAR/sg13cmos5l_dfrbp_1_0.RESET_B SAR/a_11434_2356# vdd sg13_lv_pmos ad=0.1563p pd=1.22u as=0.147p ps=1.54u w=0.42u l=0.13u
X2147 vss SAR/sg13cmos5l_or2_1_1.B SAR/a_12216_5728# vss sg13_lv_nmos ad=0.187p pd=1.78u as=0.1045p ps=0.93u w=0.55u l=0.13u
X2148 SAR/a_17700_1639# SAR/a_17931_1748# SAR/a_17386_1849# vss sg13_lv_nmos ad=0.2373p pd=1.97u as=79.8f ps=0.8u w=0.42u l=0.13u
X2149 SAR/a_13234_1626# SAR/sg13cmos5l_dfrbp_1_0.RESET_B vss vss sg13_lv_nmos ad=37.8f pd=0.6u as=79.8f ps=0.8u w=0.42u l=0.13u
X2150 SAR/sg13cmos5l_dlhr_1_11.D SAR/a_11567_7751# vdd vdd sg13_lv_pmos ad=0.4312p pd=3.01u as=0.2639p ps=1.81u w=1.12u l=0.13u
X2151 vdd vss vdd vdd sg13_lv_pmos ad=0.34p pd=2.68u as=0 ps=0 w=1u l=1u
X2152 vdd SAR/a_8457_7281# SAR/a_8982_7354# vdd sg13_lv_pmos ad=0.1974p pd=1.5u as=0.2856p ps=2.36u w=0.84u l=0.13u
X2153 vdd SAR/a_14583_5770# SAR/a_14714_5776# vdd sg13_lv_pmos ad=1.28962p pd=8.195u as=0.2856p ps=2.36u w=0.84u l=0.13u
X2154 vdd SAR/sg13cmos5l_dfrbp_1_0.RESET_B SAR/a_13258_3361# vdd sg13_lv_pmos ad=0.1563p pd=1.22u as=0.147p ps=1.54u w=0.42u l=0.13u
X2155 SAR/a_12132_9504# SAR/a_12106_9409# vss vss sg13_lv_nmos ad=0.2516p pd=2.16u as=0.1626p ps=1.415u w=0.74u l=0.13u
X2156 SAR/a_6380_7638# SAR/sg13cmos5l_buf_1_78.X vdd vdd sg13_lv_pmos ad=0.2856p pd=2.36u as=0.2114p ps=1.54u w=0.84u l=0.13u
X2157 SAR/a_7430_3576# SAR/a_7034_3148# SAR/a_7316_3460# vdd sg13_lv_pmos ad=0.1008p pd=0.9u as=0.191p ps=1.44u w=0.42u l=0.13u
X2158 SAR/a_15849_2435# SAR/a_15492_2392# vdd vdd sg13_lv_pmos ad=63f pd=0.72u as=0.1563p ps=1.22u w=0.42u l=0.13u
X2159 SAR/sg13cmos5l_dfrbp_1_18.Q SAR/a_8084_8436# vdd vdd sg13_lv_pmos ad=0.3808p pd=2.92u as=0.2128p ps=1.5u w=1.12u l=0.13u
X2160 SAR/a_4380_7326# SAR/a_3831_7282# SAR/a_4244_6924# vss sg13_lv_nmos ad=47.25f pd=0.645u as=0.141p ps=1.17u w=0.42u l=0.13u
X2161 SAR/a_13484_8400# SAR/sg13cmos5l_dlhr_1_11.Q vss vss sg13_lv_nmos ad=0.187p pd=1.78u as=0.14875p ps=1.16u w=0.55u l=0.13u
X2162 vdd SAR/a_5820_5773# SAR/a_6843_5459# vdd sg13_lv_pmos ad=0.1563p pd=1.22u as=63f ps=0.72u w=0.42u l=0.13u
X2163 vss SAR/sg13cmos5l_inv_1_18.A SAR/a_9256_9224# vss sg13_lv_nmos ad=0.14875p pd=1.16u as=0.187p ps=1.78u w=0.55u l=0.13u
X2164 SAR/a_17988_3151# SAR/a_18219_3260# SAR/a_17674_3361# vss sg13_lv_nmos ad=0.2373p pd=1.97u as=79.8f ps=0.8u w=0.42u l=0.13u
X2165 SAR/a_14996_5412# SAR/a_14714_5776# SAR/a_14929_5814# vss sg13_lv_nmos ad=0.141p pd=1.17u as=71.99999f ps=0.865u w=0.64u l=0.13u
X2166 vdd SAR/sg13cmos5l_dfrbp_1_15.D SAR/a_3575_6553# vdd sg13_lv_pmos ad=0.1428p pd=1.52u as=79.8f ps=0.8u w=0.42u l=0.13u
X2167 vss SAR/sg13cmos5l_dlhr_1_0.D SAR/a_6889_1680# vss sg13_lv_nmos ad=0.15055p pd=1.17u as=0.187p ps=1.78u w=0.55u l=0.13u
X2168 SAR/a_11270_4338# SAR/a_12075_3911# SAR/a_11530_3868# vdd sg13_lv_pmos ad=0.1428p pd=1.52u as=79.8f ps=0.8u w=0.42u l=0.13u
X2169 vdd SAR/a_19209_5769# SAR/a_19142_5412# vdd sg13_lv_pmos ad=0.2387p pd=1.84u as=0.1008p ps=0.9u w=0.42u l=0.13u
X2170 vss SAR/a_17519_6239# SAR/a_18356_6460# vss sg13_lv_nmos ad=0.1406p pd=1.12u as=0.2516p ps=2.16u w=0.74u l=0.13u
X2171 SAR/a_3609_4023# SAR/a_2667_3911# SAR/a_3407_4261# vdd sg13_lv_pmos ad=93.45f pd=0.865u as=0.2048p ps=1.63u w=0.42u l=0.13u
X2172 SAR/sg13cmos5l_dfrbp_1_20.Q SAR/a_9620_7972# vss vss sg13_lv_nmos ad=0.2516p pd=2.16u as=0.1406p ps=1.12u w=0.74u l=0.13u
X2173 SAR/a_12567_7282# SAR/sg13cmos5l_dlhr_1_11.GATE vdd vdd sg13_lv_pmos ad=0.3234p pd=2.45u as=1.07253p ps=6.75u w=0.84u l=0.13u
X2174 vss SAR/sg13cmos5l_nor2b_1_0.Y SAR/a_10433_1652# vss sg13_lv_nmos ad=0.2516p pd=2.16u as=0.1406p ps=1.12u w=0.74u l=0.13u
X2175 vss SAR/a_2757_3117# SAR/a_2859_3260# vss sg13_lv_nmos ad=2.59257p pd=16.445u as=0.2516p ps=2.16u w=0.74u l=0.13u
X2176 vss SAR/sg13cmos5l_inv_1_19.A SAR/sg13cmos5l_buf_1_32.A vss sg13_lv_nmos ad=0.2516p pd=2.16u as=0.2516p ps=2.16u w=0.74u l=0.13u
X2177 vss SAR/a_20492_8400# pl_sw[10] vss sg13_lv_nmos ad=0.14875p pd=1.16u as=0.2886p ps=2.26u w=0.74u l=0.13u
X2178 SAR/sg13cmos5l_dfrbp_1_6.RESET_B _cks vss vss sg13_lv_nmos ad=0.1406p pd=1.12u as=0.1406p ps=1.12u w=0.74u l=0.13u
X2179 vdd SAR/a_14900_2352# SAR/a_14858_2388# vdd sg13_lv_pmos ad=0.2618p pd=1.63u as=0.1176p ps=1.33u w=1.12u l=0.13u
X2180 vss SAR/sg13cmos5l_inv_1_27.Y SAR/a_14632_9224# vss sg13_lv_nmos ad=0.14875p pd=1.16u as=0.187p ps=1.78u w=0.55u l=0.13u
X2181 SAR/a_17721_6477# SAR/a_16779_6284# SAR/a_17519_6239# vdd sg13_lv_pmos ad=93.45f pd=0.865u as=0.2048p ps=1.63u w=0.42u l=0.13u
X2182 vss SAR/a_6741_5459# SAR/a_5820_5773# vss sg13_lv_nmos ad=0.1626p pd=1.415u as=0.2516p ps=2.16u w=0.74u l=0.13u
X2183 vdd SAR/a_13047_7690# SAR/a_13178_7684# vdd sg13_lv_pmos ad=1.15047p pd=7.175u as=0.2856p ps=2.36u w=0.84u l=0.13u
X2184 SAR/a_14916_8861# SAR/a_14628_8440# SAR/a_14854_8861# vss sg13_lv_nmos ad=0.1428p pd=1.52u as=37.8f ps=0.6u w=0.42u l=0.13u
X2185 SAR/a_1967_7285# SAR/a_1125_6935# SAR/a_1873_7285# vss sg13_lv_nmos ad=0.12665p pd=1.145u as=0.1428p ps=1.52u w=0.42u l=0.13u
X2186 nl_sw[1] SAR/a_1864_1664# vss vss sg13_lv_nmos ad=0.2886p pd=2.26u as=0.14875p ps=1.16u w=0.74u l=0.13u
X2187 vss vdd vss vss sg13_lv_nmos ad=79.8f pd=0.8u as=0 ps=0 w=0.42u l=1u
X2188 SAR/sg13cmos5l_buf_1_86.A SAR/a_20008_8436# vss vss sg13_lv_nmos ad=0.2886p pd=2.26u as=0.14875p ps=1.16u w=0.74u l=0.13u
X2189 SAR/a_4034_7660# SAR/sg13cmos5l_dfrbp_1_6.RESET_B vss vss sg13_lv_nmos ad=77.7f pd=0.95u as=0.1406p ps=1.12u w=0.74u l=0.13u
X2190 vdd SAR/sg13cmos5l_dlhr_1_1.GATE SAR/a_4349_7636# vdd sg13_lv_pmos ad=1.15047p pd=7.175u as=0.3234p ps=2.45u w=0.84u l=0.13u
X2191 SAR/a_3212_1590# SAR/sg13cmos5l_buf_1_41.A vdd vdd sg13_lv_pmos ad=0.2856p pd=2.36u as=0.2114p ps=1.54u w=0.84u l=0.13u
X2192 SAR/a_1006_4167# SAR/a_1121_4166# vss vss sg13_lv_nmos ad=0.1428p pd=1.52u as=0.1426p ps=1.16u w=0.42u l=0.5u
X2193 SAR/sg13cmos5l_inv_1_3.A SAR/a_13768_8436# vss vss sg13_lv_nmos ad=0.2886p pd=2.26u as=0.14875p ps=1.16u w=0.74u l=0.13u
X2194 vss SAR/sg13cmos5l_dfrbp_1_0.Q SAR/a_14254_2444# vss sg13_lv_nmos ad=0.17255p pd=1.25u as=0.187p ps=1.78u w=0.55u l=0.13u
X2195 SAR/sg13cmos5l_buf_1_19.X SAR/a_18760_2388# vss vss sg13_lv_nmos ad=0.2886p pd=2.26u as=0.14875p ps=1.16u w=0.74u l=0.13u
X2196 vss SAR/sg13cmos5l_dfrbp_1_6.RESET_B SAR/a_10116_7674# vss sg13_lv_nmos ad=0.1626p pd=1.415u as=60.89999f ps=0.71u w=0.42u l=0.13u
X2197 SAR/a_9260_2352# SAR/sg13cmos5l_buf_1_30.X vdd vdd sg13_lv_pmos ad=0.2856p pd=2.36u as=0.2114p ps=1.54u w=0.84u l=0.13u
X2198 SAR/a_2314_3361# SAR/a_2757_3117# SAR/a_2697_3529# vdd sg13_lv_pmos ad=79.8f pd=0.8u as=63f ps=0.72u w=0.42u l=0.13u
X2199 vss SAR/sg13cmos5l_dfrbp_1_6.RESET_B SAR/a_17750_4325# vss sg13_lv_nmos ad=0.1701p pd=1.65u as=37.8f ps=0.6u w=0.42u l=0.13u
X2200 vdd SAR/a_10031_8797# SAR/a_10868_8436# vdd sg13_lv_pmos ad=0.2128p pd=1.5u as=0.3864p ps=2.93u w=1.12u l=0.13u
X2201 SAR/sg13cmos5l_dlhr_1_7.Q_N SAR/a_4950_7354# vdd vdd sg13_lv_pmos ad=0.3808p pd=2.92u as=0.1974p ps=1.5u w=1.12u l=0.13u
X2202 SAR/a_17126_1626# SAR/sg13cmos5l_dfrbp_1_0.D vdd vdd sg13_lv_pmos ad=79.8f pd=0.8u as=0.1428p ps=1.52u w=0.42u l=0.13u
X2203 SAR/a_3308_5376# SAR/sg13cmos5l_dlhr_1_1.Q vss vss sg13_lv_nmos ad=0.187p pd=1.78u as=0.14875p ps=1.16u w=0.55u l=0.13u
X2204 SAR/a_14900_2352# SAR/sg13cmos5l_nor2_1_1.A vdd vdd sg13_lv_pmos ad=0.2856p pd=2.36u as=0.2618p ps=1.63u w=0.84u l=0.13u
X2205 vdd SAR/sg13cmos5l_buf_1_34.X SAR/sg13cmos5l_buf_1_60.A vdd sg13_lv_pmos ad=0.3808p pd=2.92u as=0.3808p ps=2.92u w=1.12u l=0.13u
X2206 vss SAR/sg13cmos5l_inv_1_8.A SAR/sg13cmos5l_inv_1_8.Y vss sg13_lv_nmos ad=0.2516p pd=2.16u as=0.2516p ps=2.16u w=0.74u l=0.13u
X2207 SAR/a_2054_3138# SAR/sg13cmos5l_dfrbp_1_6.D vdd vdd sg13_lv_pmos ad=79.8f pd=0.8u as=0.1428p ps=1.52u w=0.42u l=0.13u
X2208 vss SAR/a_19227_4654# SAR/sg13cmos5l_buf_8_0.X vss sg13_lv_nmos ad=0.1406p pd=1.12u as=0.1406p ps=1.12u w=0.74u l=0.13u
X2209 SAR/a_3676_7964# SAR/sg13cmos5l_dfrbp_1_6.RESET_B vdd vdd sg13_lv_pmos ad=0.2128p pd=1.5u as=0.2128p ps=1.5u w=1.12u l=0.13u
X2210 nh_sw[3] SAR/a_5704_1664# vdd vdd sg13_lv_pmos ad=0.42p pd=2.99u as=0.2114p ps=1.54u w=1.12u l=0.13u
X2211 vss SAR/a_9164_1590# SAR/sg13cmos5l_buf_1_26.X vss sg13_lv_nmos ad=0.14875p pd=1.16u as=0.2886p ps=2.26u w=0.74u l=0.13u
X2212 SAR/a_17327_7285# SAR/a_16485_6935# SAR/a_17233_7285# vss sg13_lv_nmos ad=0.12665p pd=1.145u as=0.1428p ps=1.52u w=0.42u l=0.13u
X2213 vdd SAR/a_15821_3864# SAR/sg13cmos5l_dfrbp_1_6.Q_N vdd sg13_lv_pmos ad=0.2639p pd=1.81u as=0.4312p ps=3.01u w=1.12u l=0.13u
X2214 ph_sw[10] SAR/a_20392_6924# vss vss sg13_lv_nmos ad=0.2886p pd=2.26u as=0.14875p ps=1.16u w=0.74u l=0.13u
X2215 SAR/sg13cmos5l_dfrbp_1_3.Q_N SAR/a_18959_3215# vss vss sg13_lv_nmos ad=0.2849p pd=2.25u as=0.2516p ps=2.16u w=0.74u l=0.13u
X2216 vdd SAR/a_2757_3117# SAR/a_2859_3260# vdd sg13_lv_pmos ad=1.43437p pd=9.105u as=0.3864p ps=2.93u w=1.12u l=0.13u
X2217 SAR/a_11817_2435# SAR/a_11460_2392# vdd vdd sg13_lv_pmos ad=63f pd=0.72u as=0.1563p ps=1.22u w=0.42u l=0.13u
X2218 vdd SAR/a_17519_6239# SAR/a_17776_6382# vdd sg13_lv_pmos ad=0.2639p pd=1.81u as=79.8f ps=0.8u w=0.42u l=0.13u
X2219 vdd SAR/sg13cmos5l_dfrbp_1_10.Q SAR/a_4873_3192# vdd sg13_lv_pmos ad=1.43437p pd=9.105u as=0.2856p ps=2.36u w=0.84u l=0.13u
X2220 SAR/sg13cmos5l_dlhr_1_1.Q SAR/a_2409_4650# vdd vdd sg13_lv_pmos ad=0.3808p pd=2.92u as=0.2128p ps=1.5u w=1.12u l=0.13u
X2221 vss SAR/a_6959_6239# SAR/a_7796_6460# vss sg13_lv_nmos ad=0.1406p pd=1.12u as=0.2516p ps=2.16u w=0.74u l=0.13u
X2222 vss SAR/a_7504_8678# SAR/a_7153_8797# vss sg13_lv_nmos ad=79.8f pd=0.8u as=0.1428p ps=1.52u w=0.42u l=0.13u
X2223 SAR/a_17674_3361# SAR/a_18117_3117# SAR/a_18057_3529# vdd sg13_lv_pmos ad=79.8f pd=0.8u as=63f ps=0.72u w=0.42u l=0.13u
X2224 vss SAR/a_2732_9150# SAR/sg13cmos5l_buf_1_61.X vss sg13_lv_nmos ad=0.14875p pd=1.16u as=0.2886p ps=2.26u w=0.74u l=0.13u
X2225 vdd SAR/a_9189_8447# SAR/a_9291_8447# vdd sg13_lv_pmos ad=1.15047p pd=7.175u as=0.3864p ps=2.93u w=1.12u l=0.13u
X2226 vss SAR/a_4005_4629# SAR/a_4107_4772# vss sg13_lv_nmos ad=2.41737p pd=15.64u as=0.2516p ps=2.16u w=0.74u l=0.13u
X2227 vdd vss vdd vdd sg13_lv_pmos ad=0.34p pd=2.68u as=0 ps=0 w=1u l=1u
X2228 SAR/sg13cmos5l_inv_1_29.A SAR/a_12404_7972# vdd vdd sg13_lv_pmos ad=0.3808p pd=2.92u as=0.2128p ps=1.5u w=1.12u l=0.13u
X2229 vss SAR/sg13cmos5l_dfrbp_1_23.Q SAR/a_13792_5760# vss sg13_lv_nmos ad=0.1406p pd=1.12u as=0.1406p ps=1.12u w=0.74u l=0.13u
X2230 vss SAR/sg13cmos5l_dfrbp_1_6.RESET_B SAR/a_18580_7660# vss sg13_lv_nmos ad=0.1406p pd=1.12u as=77.7f ps=0.95u w=0.74u l=0.13u
X2231 SAR/a_17713_8838# SAR/a_17161_8794# vss vss sg13_lv_nmos ad=71.99999f pd=0.865u as=2.92392p ps=18.89u w=0.64u l=0.13u
X2232 SAR/a_15300_7687# SAR/a_15012_7992# SAR/a_15238_7687# vss sg13_lv_nmos ad=0.1428p pd=1.52u as=37.8f ps=0.6u w=0.42u l=0.13u
X2233 SAR/a_12933_6141# SAR/sg13cmos5l_dfrbp_1_23.CLK vss vss sg13_lv_nmos ad=0.2516p pd=2.16u as=1.97045p ps=12.335u w=0.74u l=0.13u
X2234 SAR/sg13cmos5l_buf_1_79.X SAR/a_9256_9224# vdd vdd sg13_lv_pmos ad=0.42p pd=2.99u as=0.2114p ps=1.54u w=1.12u l=0.13u
X2235 vss SAR/sg13cmos5l_inv_1_17.A SAR/sg13cmos5l_buf_1_37.A vss sg13_lv_nmos ad=0.2516p pd=2.16u as=0.2516p ps=2.16u w=0.74u l=0.13u
X2236 pl_sw[2] SAR/a_2248_9224# vss vss sg13_lv_nmos ad=0.2886p pd=2.26u as=0.14875p ps=1.16u w=0.74u l=0.13u
X2237 vdd SAR/a_9040_7894# SAR/a_8985_7989# vdd sg13_lv_pmos ad=1.15047p pd=7.175u as=93.45f ps=0.865u w=0.42u l=0.13u
X2238 SAR/sg13cmos5l_buf_1_1.A SAR/a_14056_1664# vss vss sg13_lv_nmos ad=0.2886p pd=2.26u as=0.14875p ps=1.16u w=0.74u l=0.13u
X2239 vdd SAR/a_5673_3138# SAR/a_6198_3120# vdd sg13_lv_pmos ad=0.1974p pd=1.5u as=0.2856p ps=2.36u w=0.84u l=0.13u
X2240 SAR/a_6660_4663# SAR/a_6891_4772# SAR/a_6346_4873# vss sg13_lv_nmos ad=0.2373p pd=1.97u as=79.8f ps=0.8u w=0.42u l=0.13u
X2241 SAR/a_6681_2511# SAR/a_5739_2399# SAR/a_6479_2749# vdd sg13_lv_pmos ad=93.45f pd=0.865u as=0.2048p ps=1.63u w=0.42u l=0.13u
X2242 vdd SAR/a_2732_1590# SAR/sg13cmos5l_buf_1_35.A vdd sg13_lv_pmos ad=0.2114p pd=1.54u as=0.42p ps=2.99u w=1.12u l=0.13u
X2243 SAR/sg13cmos5l_buf_8_0.X SAR/a_19227_4654# vdd vdd sg13_lv_pmos ad=0.2128p pd=1.5u as=0.2128p ps=1.5u w=1.12u l=0.13u
X2244 SAR/a_18574_5028# SAR/sg13cmos5l_dfrbp_1_0.D SAR/a_18480_5028# vdd sg13_lv_pmos ad=0.1596p pd=1.22u as=0.2856p ps=2.36u w=0.84u l=0.13u
X2245 SAR/a_16551_3987# SAR/a_16703_3871# vdd vdd sg13_lv_pmos ad=0.3864p pd=2.93u as=1.43437p ps=9.105u w=1.12u l=0.13u
X2246 vdd SAR/sg13cmos5l_buf_1_10.A SAR/a_12520_3176# vdd sg13_lv_pmos ad=0.2114p pd=1.54u as=0.2856p ps=2.36u w=0.84u l=0.13u
X2247 vdd SAR/sg13cmos5l_o21ai_1_0.B1 SAR/sg13cmos5l_o21ai_1_0.Y vdd sg13_lv_pmos ad=0.3808p pd=2.92u as=0.2128p ps=1.5u w=1.12u l=0.15u
X2248 vdd SAR/a_16271_7751# SAR/a_17108_7972# vdd sg13_lv_pmos ad=0.2128p pd=1.5u as=0.3864p ps=2.93u w=1.12u l=0.13u
X2249 vdd SAR/a_19244_2352# nl_sw[9] vdd sg13_lv_pmos ad=0.2114p pd=1.54u as=0.42p ps=2.99u w=1.12u l=0.13u
X2250 vss SAR/a_908_1590# SAR/sg13cmos5l_buf_1_32.X vss sg13_lv_nmos ad=0.14875p pd=1.16u as=0.2886p ps=2.26u w=0.74u l=0.13u
X2251 vss vdd vss vss sg13_lv_nmos ad=79.8f pd=0.8u as=0 ps=0 w=0.42u l=1u
X2252 SAR/a_17780_8436# SAR/a_17367_8794# SAR/a_17712_8436# vdd sg13_lv_pmos ad=0.191p pd=1.44u as=0.105p ps=1.21u w=1u l=0.13u
X2253 SAR/a_15876_7362# SAR/sg13cmos5l_dfrbp_1_22.D SAR/a_15782_7362# vss sg13_lv_nmos ad=60.89999f pd=0.71u as=0.1428p ps=1.52u w=0.42u l=0.13u
X2254 SAR/a_17916_8838# SAR/a_17367_8794# SAR/a_17780_8436# vss sg13_lv_nmos ad=47.25f pd=0.645u as=0.141p ps=1.17u w=0.42u l=0.13u
X2255 SAR/sg13cmos5l_buf_1_93.X SAR/a_14632_9224# vdd vdd sg13_lv_pmos ad=0.42p pd=2.99u as=0.2114p ps=1.54u w=1.12u l=0.13u
X2256 SAR/a_2348_7624# SAR/a_2596_7996# SAR/a_2554_8112# vdd sg13_lv_pmos ad=0.191p pd=1.44u as=0.1008p ps=0.9u w=0.42u l=0.13u
X2257 vdd SAR/a_9705_4650# SAR/a_9638_5088# vdd sg13_lv_pmos ad=0.2387p pd=1.84u as=0.1008p ps=0.9u w=0.42u l=0.13u
X2258 vdd SAR/sg13cmos5l_inv_1_8.A SAR/a_5951_5383# vdd sg13_lv_pmos ad=1.2517p pd=7.955u as=0.4088p ps=2.97u w=1.12u l=0.13u
X2259 nl_sw[2] SAR/a_2248_1664# vdd vdd sg13_lv_pmos ad=0.42p pd=2.99u as=0.2114p ps=1.54u w=1.12u l=0.13u
X2260 SAR/sg13cmos5l_or2_1_0.A SAR/a_18363_4270# vdd vdd sg13_lv_pmos ad=0.2128p pd=1.5u as=0.2128p ps=1.5u w=1.12u l=0.13u
X2261 vss SAR/sg13cmos5l_a221oi_1_0.B2 SAR/a_11488_4676# vss sg13_lv_nmos ad=0.1406p pd=1.12u as=0.1406p ps=1.12u w=0.74u l=0.13u
X2262 vss SAR/sg13cmos5l_a22oi_1_1.B1 SAR/a_15062_4292# vss sg13_lv_nmos ad=0.2553p pd=2.17u as=0.13875p ps=1.115u w=0.74u l=0.13u
X2263 vdd SAR/a_14543_3215# SAR/a_14800_3358# vdd sg13_lv_pmos ad=0.2639p pd=1.81u as=79.8f ps=0.8u w=0.42u l=0.13u
X2264 SAR/a_18860_6888# SAR/sg13cmos5l_buf_1_87.A vdd vdd sg13_lv_pmos ad=0.2856p pd=2.36u as=0.2114p ps=1.54u w=0.84u l=0.13u
X2265 SAR/a_11364_1626# SAR/sg13cmos5l_dfrbp_1_1.D SAR/a_11270_1626# vss sg13_lv_nmos ad=60.89999f pd=0.71u as=0.1428p ps=1.52u w=0.42u l=0.13u
X2266 vss SAR/a_20012_2352# nl_sw[10] vss sg13_lv_nmos ad=0.14875p pd=1.16u as=0.2886p ps=2.26u w=0.74u l=0.13u
X2267 SAR/a_6086_4650# SAR/sg13cmos5l_dlhr_1_0.GATE vdd vdd sg13_lv_pmos ad=79.8f pd=0.8u as=0.1428p ps=1.52u w=0.42u l=0.13u
X2268 SAR/a_16748_9150# SAR/sg13cmos5l_buf_1_93.X vss vss sg13_lv_nmos ad=0.187p pd=1.78u as=0.14875p ps=1.16u w=0.55u l=0.13u
X2269 SAR/a_5988_8440# SAR/a_5962_8404# vss vss sg13_lv_nmos ad=0.2516p pd=2.16u as=0.1626p ps=1.415u w=0.74u l=0.13u
X2270 vdd SAR/a_7247_8797# SAR/a_7504_8678# vdd sg13_lv_pmos ad=0.2639p pd=1.81u as=79.8f ps=0.8u w=0.42u l=0.13u
X2271 SAR/a_682_5380# SAR/a_1125_5423# SAR/a_422_5850# vss sg13_lv_nmos ad=79.8f pd=0.8u as=0.1296p ps=1.52u w=0.42u l=0.13u
X2272 SAR/sg13cmos5l_o21ai_1_0.A1 SAR/sg13cmos5l_inv_1_0.Y SAR/a_11182_4676# vss sg13_lv_nmos ad=0.2516p pd=2.16u as=0.1406p ps=1.12u w=0.74u l=0.13u
X2273 vdd SAR/sg13cmos5l_dfrbp_1_8.RESET_B SAR/a_5962_8404# vdd sg13_lv_pmos ad=0.1563p pd=1.22u as=0.147p ps=1.54u w=0.42u l=0.13u
X2274 SAR/a_14726_7674# SAR/a_15531_7796# SAR/a_14986_7897# vdd sg13_lv_pmos ad=0.1428p pd=1.52u as=79.8f ps=0.8u w=0.42u l=0.13u
X2275 SAR/sg13cmos5l_buf_1_57.X SAR/a_9448_6924# vss vss sg13_lv_nmos ad=0.2886p pd=2.26u as=0.14875p ps=1.16u w=0.74u l=0.13u
X2276 SAR/a_8852_6484# SAR/a_8439_6178# SAR/a_8784_6484# vdd sg13_lv_pmos ad=0.191p pd=1.44u as=0.105p ps=1.21u w=1u l=0.13u
X2277 SAR/a_4176_6924# SAR/a_3625_7282# vdd vdd sg13_lv_pmos ad=0.105p pd=1.21u as=1.07253p ps=6.75u w=1u l=0.13u
X2278 SAR/a_13092_3138# SAR/sg13cmos5l_o21ai_1_0.Y SAR/a_12998_3138# vss sg13_lv_nmos ad=60.89999f pd=0.71u as=0.1428p ps=1.52u w=0.42u l=0.13u
X2279 SAR/a_16462_4338# SAR/a_16204_4338# vss vss sg13_lv_nmos ad=0.1428p pd=1.52u as=79.8f ps=0.8u w=0.42u l=0.13u
X2280 vdd SAR/sg13cmos5l_dlhr_1_12.D SAR/a_17161_8794# vdd sg13_lv_pmos ad=1.15047p pd=7.175u as=0.2856p ps=2.36u w=0.84u l=0.13u
X2281 _cko SAR/a_20392_7712# vss vss sg13_lv_nmos ad=0.2886p pd=2.26u as=0.14875p ps=1.16u w=0.74u l=0.13u
X2282 SAR/a_15821_3864# SAR/a_16551_3987# SAR/a_16462_4023# vdd sg13_lv_pmos ad=0.2048p pd=1.63u as=93.45f ps=0.865u w=0.42u l=0.13u
X2283 vss SAR/a_19227_4654# SAR/sg13cmos5l_buf_8_0.X vss sg13_lv_nmos ad=0.1406p pd=1.12u as=0.1406p ps=1.12u w=0.74u l=0.13u
X2284 SAR/sg13cmos5l_buf_8_2.X SAR/a_19227_9190# vss vss sg13_lv_nmos ad=0.1406p pd=1.12u as=0.1406p ps=1.12u w=0.74u l=0.13u
X2285 SAR/sg13cmos5l_dlhr_1_0.Q_N SAR/a_8214_1608# vss vss sg13_lv_nmos ad=0.2516p pd=2.16u as=0.1491p ps=1.18u w=0.74u l=0.13u
X2286 SAR/a_8783_7751# SAR/a_7941_7653# SAR/a_8689_7751# vss sg13_lv_nmos ad=0.12665p pd=1.145u as=0.1428p ps=1.52u w=0.42u l=0.13u
X2287 vdd SAR/sg13cmos5l_dfrbp_1_8.RESET_B SAR/a_1862_4338# vdd sg13_lv_pmos ad=0.36237p pd=2.605u as=79.8f ps=0.8u w=0.42u l=0.13u
X2288 vdd SAR/a_6959_6239# SAR/a_7216_6382# vdd sg13_lv_pmos ad=0.2639p pd=1.81u as=79.8f ps=0.8u w=0.42u l=0.13u
X2289 SAR/a_16294_7349# SAR/sg13cmos5l_dfrbp_1_8.RESET_B vss vss sg13_lv_nmos ad=37.8f pd=0.6u as=0.1701p ps=1.65u w=0.42u l=0.13u
X2290 SAR/a_12516_6480# SAR/a_13035_6284# SAR/a_13775_6239# vss sg13_lv_nmos ad=0.3473p pd=2.71u as=0.12665p ps=1.145u w=0.74u l=0.13u
X2291 SAR/a_16528_7894# SAR/sg13cmos5l_dfrbp_1_6.RESET_B vdd vdd sg13_lv_pmos ad=79.8f pd=0.8u as=1.12242p ps=7u w=0.42u l=0.13u
X2292 SAR/a_8692_7312# SAR/a_8276_6924# SAR/a_8457_7281# vss sg13_lv_nmos ad=77.7f pd=0.95u as=0.2516p ps=2.16u w=0.74u l=0.13u
X2293 SAR/a_8588_2352# SAR/sg13cmos5l_buf_1_26.X vss vss sg13_lv_nmos ad=0.187p pd=1.78u as=0.14875p ps=1.16u w=0.55u l=0.13u
X2294 vss SAR/a_11973_3911# SAR/a_12075_3911# vss sg13_lv_nmos ad=2.41737p pd=15.64u as=0.2516p ps=2.16u w=0.74u l=0.13u
X2295 vss SAR/a_13047_7690# SAR/a_13178_7684# vss sg13_lv_nmos ad=1.49685p pd=9.6u as=0.2775p ps=2.23u w=0.74u l=0.13u
X2296 SAR/a_11370_5760# SAR/sg13cmos5l_inv_1_0.A SAR/a_11268_5760# vss sg13_lv_nmos ad=0.1216p pd=1.02u as=0.1216p ps=1.02u w=0.64u l=0.13u
X2297 SAR/a_5637_2399# SAR/sg13cmos5l_dlhr_1_0.GATE vdd vdd sg13_lv_pmos ad=0.4088p pd=2.97u as=1.777p ps=11.395u w=1.12u l=0.13u
X2298 SAR/sg13cmos5l_dfrbp_1_2.Q_N SAR/a_12815_4261# vdd vdd sg13_lv_pmos ad=0.4312p pd=3.01u as=0.2639p ps=1.81u w=1.12u l=0.13u
X2299 SAR/a_13486_5760# SAR/sg13cmos5l_nor2b_1_0.Y vss vss sg13_lv_nmos ad=0.1406p pd=1.12u as=0.2516p ps=2.16u w=0.74u l=0.13u
X2300 SAR/a_17170_2826# SAR/sg13cmos5l_dfrbp_1_0.RESET_B vss vss sg13_lv_nmos ad=37.8f pd=0.6u as=79.8f ps=0.8u w=0.42u l=0.13u
X2301 vss SAR/sg13cmos5l_dfrbp_1_20.Q SAR/a_9865_7282# vss sg13_lv_nmos ad=0.15055p pd=1.17u as=0.187p ps=1.78u w=0.55u l=0.13u
X2302 vdd SAR/a_14924_1590# nh_sw[6] vdd sg13_lv_pmos ad=0.2114p pd=1.54u as=0.42p ps=2.99u w=1.12u l=0.13u
X2303 SAR/a_10318_5412# SAR/sg13cmos5l_a221oi_1_0.C1 SAR/a_10420_5412# vdd sg13_lv_pmos ad=0.3808p pd=2.92u as=0.2128p ps=1.5u w=1.12u l=0.13u
X2304 SAR/sg13cmos5l_inv_1_5.A SAR/a_19796_3436# vss vss sg13_lv_nmos ad=0.2516p pd=2.16u as=0.1406p ps=1.12u w=0.74u l=0.13u
X2305 SAR/sg13cmos5l_dfrbp_1_27.Q_N SAR/a_10031_8797# vss vss sg13_lv_nmos ad=0.2849p pd=2.25u as=0.2516p ps=2.16u w=0.74u l=0.13u
X2306 SAR/a_5079_3154# SAR/sg13cmos5l_dfrbp_1_9.Q vss vss sg13_lv_nmos ad=0.2516p pd=2.16u as=0.15055p ps=1.17u w=0.74u l=0.13u
X2307 SAR/a_17399_3947# SAR/sg13cmos5l_dfrbp_1_6.RESET_B vdd vdd sg13_lv_pmos ad=79.8f pd=0.8u as=0.36237p ps=2.605u w=0.42u l=0.13u
X2308 SAR/sg13cmos5l_dfrbp_1_11.Q_N SAR/a_7631_4727# vdd vdd sg13_lv_pmos ad=0.4312p pd=3.01u as=0.2639p ps=1.81u w=1.12u l=0.13u
X2309 SAR/a_15045_8447# SAR/sg13cmos5l_inv_1_2.A vdd vdd sg13_lv_pmos ad=0.4088p pd=2.97u as=1.12242p ps=7u w=1.12u l=0.13u
X2310 vss SAR/a_14583_5770# SAR/a_14714_5776# vss sg13_lv_nmos ad=1.97045p pd=12.335u as=0.2775p ps=2.23u w=0.74u l=0.13u
X2311 SAR/a_4950_5699# SAR/a_5069_5376# vss vss sg13_lv_nmos ad=0.2516p pd=2.16u as=0.1406p ps=1.12u w=0.74u l=0.13u
X2312 vdd SAR/a_19227_9190# SAR/sg13cmos5l_buf_8_2.X vdd sg13_lv_pmos ad=0.3864p pd=2.93u as=0.2128p ps=1.5u w=1.12u l=0.13u
X2313 SAR/sg13cmos5l_dlhr_1_20.Q_N SAR/a_10230_4632# vdd vdd sg13_lv_pmos ad=0.3808p pd=2.92u as=0.1974p ps=1.5u w=1.12u l=0.13u
X2314 vss SAR/sg13cmos5l_inv_1_6.A SAR/sg13cmos5l_buf_1_0.A vss sg13_lv_nmos ad=0.2516p pd=2.16u as=0.2516p ps=2.16u w=0.74u l=0.13u
X2315 vdd SAR/a_16144_8678# SAR/a_16089_8559# vdd sg13_lv_pmos ad=1.15047p pd=7.175u as=93.45f ps=0.865u w=0.42u l=0.13u
X2316 SAR/sg13cmos5l_buf_1_5.X SAR/a_14440_1664# vdd vdd sg13_lv_pmos ad=0.42p pd=2.99u as=0.2114p ps=1.54u w=1.12u l=0.13u
X2317 SAR/a_14854_8861# SAR/sg13cmos5l_dfrbp_1_8.RESET_B vss vss sg13_lv_nmos ad=37.8f pd=0.6u as=0.1701p ps=1.65u w=0.42u l=0.13u
X2318 vdd SAR/sg13cmos5l_buf_1_30.A SAR/sg13cmos5l_buf_1_73.A vdd sg13_lv_pmos ad=0.3808p pd=2.92u as=0.3808p ps=2.92u w=1.12u l=0.13u
X2319 SAR/a_2169_5535# SAR/a_1227_5423# SAR/a_1967_5773# vdd sg13_lv_pmos ad=93.45f pd=0.865u as=0.2048p ps=1.63u w=0.42u l=0.13u
X2320 SAR/sg13cmos5l_dlhr_1_21.Q_N SAR/a_10998_9168# vss vss sg13_lv_nmos ad=0.2516p pd=2.16u as=0.1491p ps=1.18u w=0.74u l=0.13u
X2321 vdd SAR/sg13cmos5l_buf_1_73.X SAR/a_5800_9224# vdd sg13_lv_pmos ad=0.2114p pd=1.54u as=0.2856p ps=2.36u w=0.84u l=0.13u
X2322 vdd SAR/sg13cmos5l_dfrbp_1_23.Q_N SAR/a_14377_5770# vdd sg13_lv_pmos ad=1.28962p pd=8.195u as=0.2856p ps=2.36u w=0.84u l=0.13u
X2323 vss SAR/sg13cmos5l_dfrbp_1_6.RESET_B SAR/a_516_7362# vss sg13_lv_nmos ad=0.1626p pd=1.415u as=60.89999f ps=0.71u w=0.42u l=0.13u
X2324 SAR/a_17829_1605# SAR/sg13cmos5l_dfrbp_1_0.CLK vss vss sg13_lv_nmos ad=0.2516p pd=2.16u as=5.84582p ps=38.34u w=0.74u l=0.13u
X2325 vss SAR/a_7216_6382# SAR/a_6865_6239# vss sg13_lv_nmos ad=79.8f pd=0.8u as=0.1428p ps=1.52u w=0.42u l=0.13u
X2326 vss SAR/sg13cmos5l_buf_8_0.A SAR/a_19227_4654# vss sg13_lv_nmos ad=0.1406p pd=1.12u as=0.1406p ps=1.12u w=0.74u l=0.13u
X2327 vdd SAR/sg13cmos5l_dfrbp_1_8.RESET_B SAR/a_5702_8874# vdd sg13_lv_pmos ad=0.36237p pd=2.605u as=79.8f ps=0.8u w=0.42u l=0.13u
X2328 SAR/a_12804_6175# SAR/a_13035_6284# SAR/a_12490_6385# vss sg13_lv_nmos ad=0.2373p pd=1.97u as=79.8f ps=0.8u w=0.42u l=0.13u
X2329 SAR/a_18860_9150# SAR/sg13cmos5l_buf_1_101.X vss vss sg13_lv_nmos ad=0.187p pd=1.78u as=0.14875p ps=1.16u w=0.55u l=0.13u
X2330 vss SAR/a_19209_5769# SAR/a_19164_5814# vss sg13_lv_nmos ad=0.1428p pd=1.52u as=47.25f ps=0.645u w=0.42u l=0.13u
X2331 SAR/a_11873_5760# SAR/sg13cmos5l_inv_1_29.Y SAR/sg13cmos5l_a221oi_1_0.B2 vss sg13_lv_nmos ad=0.1406p pd=1.12u as=0.1406p ps=1.12u w=0.74u l=0.13u
X2332 vss SAR/sg13cmos5l_nand2_1_1.A SAR/a_20008_3900# vss sg13_lv_nmos ad=0.14875p pd=1.16u as=0.187p ps=1.78u w=0.55u l=0.13u
X2333 SAR/a_11980_4948# SAR/sg13cmos5l_inv_1_0.A SAR/sg13cmos5l_a221oi_1_0.C1 vdd sg13_lv_pmos ad=0.1176p pd=1.33u as=0.3808p ps=2.92u w=1.12u l=0.13u
X2334 vdd SAR/a_8841_5769# SAR/a_9366_5842# vdd sg13_lv_pmos ad=0.1974p pd=1.5u as=0.2856p ps=2.36u w=0.84u l=0.13u
X2335 vss SAR/a_7497_3138# SAR/a_7452_3174# vss sg13_lv_nmos ad=0.1428p pd=1.52u as=47.25f ps=0.645u w=0.42u l=0.13u
X2336 vss vdd vss vss sg13_lv_nmos ad=79.8f pd=0.8u as=0 ps=0 w=0.42u l=1u
X2337 SAR/sg13cmos5l_buf_1_97.A SAR/a_10473_9186# vdd vdd sg13_lv_pmos ad=0.3808p pd=2.92u as=0.2128p ps=1.5u w=1.12u l=0.13u
X2338 vdd SAR/a_11877_2399# SAR/a_11979_2399# vdd sg13_lv_pmos ad=1.86162p pd=11.935u as=0.3864p ps=2.93u w=1.12u l=0.13u
X2339 vdd SAR/sg13cmos5l_dlygate4sd2_1_0.A SAR/a_902_3142# vdd sg13_lv_pmos ad=0.2481p pd=1.56u as=0.1428p ps=1.52u w=0.42u l=0.13u
X2340 vss SAR/a_7247_8797# SAR/a_8084_8436# vss sg13_lv_nmos ad=0.1406p pd=1.12u as=0.2516p ps=2.16u w=0.74u l=0.13u
X2341 SAR/sg13cmos5l_o21ai_1_0.A2 SAR/sg13cmos5l_nand2_1_0.A SAR/a_11002_3142# vss sg13_lv_nmos ad=0.2516p pd=2.16u as=0.1406p ps=1.12u w=0.74u l=0.13u
X2342 SAR/a_16260_6480# SAR/a_16234_6385# vss vss sg13_lv_nmos ad=0.2516p pd=2.16u as=0.1626p ps=1.415u w=0.74u l=0.13u
X2343 SAR/a_3876_4663# SAR/a_4107_4772# SAR/a_3562_4873# vss sg13_lv_nmos ad=0.2373p pd=1.97u as=79.8f ps=0.8u w=0.42u l=0.13u
X2344 vss SAR/sg13cmos5l_dfrbp_1_8.RESET_B SAR/a_3396_4650# vss sg13_lv_nmos ad=0.1626p pd=1.415u as=60.89999f ps=0.71u w=0.42u l=0.13u
X2345 SAR/a_11913_2017# SAR/a_11556_1944# vdd vdd sg13_lv_pmos ad=63f pd=0.72u as=0.1563p ps=1.22u w=0.42u l=0.13u
X2346 SAR/a_4076_5376# SAR/sg13cmos5l_dlhr_1_9.Q vss vss sg13_lv_nmos ad=0.187p pd=1.78u as=0.14875p ps=1.16u w=0.55u l=0.13u
X2347 vss SAR/a_6789_4629# SAR/a_6891_4772# vss sg13_lv_nmos ad=2.41737p pd=15.64u as=0.2516p ps=2.16u w=0.74u l=0.13u
X2348 vss SAR/a_7689_1626# SAR/a_8214_1608# vss sg13_lv_nmos ad=0.1491p pd=1.18u as=0.187p ps=1.78u w=0.55u l=0.13u
X2349 SAR/sg13cmos5l_buf_8_0.X SAR/a_19227_4654# vdd vdd sg13_lv_pmos ad=0.2128p pd=1.5u as=0.2128p ps=1.5u w=1.12u l=0.13u
X2350 SAR/a_9111_4666# SAR/sg13cmos5l_dfrbp_1_11.Q vss vss sg13_lv_nmos ad=0.2516p pd=2.16u as=0.15055p ps=1.17u w=0.74u l=0.13u
X2351 SAR/sg13cmos5l_dfrbp_1_15.D SAR/a_4244_8436# vdd vdd sg13_lv_pmos ad=0.3808p pd=2.92u as=0.2128p ps=1.5u w=1.12u l=0.13u
X2352 SAR/a_17412_1944# SAR/a_17931_1748# SAR/a_18671_1703# vss sg13_lv_nmos ad=0.3473p pd=2.71u as=0.12665p ps=1.145u w=0.74u l=0.13u
X2353 _d2 SAR/a_20392_3900# vdd vdd sg13_lv_pmos ad=0.42p pd=2.99u as=0.2114p ps=1.54u w=1.12u l=0.13u
X2354 SAR/sg13cmos5l_nand2_1_0.B SAR/a_10587_4692# SAR/a_10789_4654# vss sg13_lv_nmos ad=0.333p pd=2.38u as=0.1406p ps=1.12u w=0.74u l=0.13u
X2355 vss _cks SAR/sg13cmos5l_dfrbp_1_0.RESET_B vss sg13_lv_nmos ad=0.2516p pd=2.16u as=0.2516p ps=2.16u w=0.74u l=0.13u
X2356 SAR/a_1815_4666# SAR/sg13cmos5l_dlhr_1_1.GATE vss vss sg13_lv_nmos ad=0.2516p pd=2.16u as=0.15055p ps=1.17u w=0.74u l=0.13u
X2357 SAR/a_17829_1605# SAR/sg13cmos5l_dfrbp_1_0.CLK vdd vdd sg13_lv_pmos ad=0.4088p pd=2.97u as=1.777p ps=11.395u w=1.12u l=0.13u
X2358 SAR/a_8592_5412# SAR/a_8041_5770# vdd vdd sg13_lv_pmos ad=0.105p pd=1.21u as=1.28962p ps=8.195u w=1u l=0.13u
X2359 SAR/a_9879_9202# SAR/sg13cmos5l_dfrbp_1_18.Q vss vss sg13_lv_nmos ad=0.2516p pd=2.16u as=0.15055p ps=1.17u w=0.74u l=0.13u
X2360 SAR/a_12132_9504# SAR/a_12651_9308# SAR/a_13391_9263# vss sg13_lv_nmos ad=0.3473p pd=2.71u as=0.12665p ps=1.145u w=0.74u l=0.13u
X2361 vdd SAR/sg13cmos5l_buf_1_3.X SAR/a_20392_3176# vdd sg13_lv_pmos ad=0.2114p pd=1.54u as=0.2856p ps=2.36u w=0.84u l=0.13u
X2362 SAR/a_10028_6126# SAR/sg13cmos5l_buf_1_56.A vdd vdd sg13_lv_pmos ad=0.2856p pd=2.36u as=0.2114p ps=1.54u w=0.84u l=0.13u
X2363 vss vdd vss vss sg13_lv_nmos ad=0.1428p pd=1.52u as=0 ps=0 w=0.42u l=1u
X2364 SAR/a_4018_3138# SAR/sg13cmos5l_dfrbp_1_6.RESET_B vss vss sg13_lv_nmos ad=37.8f pd=0.6u as=79.8f ps=0.8u w=0.42u l=0.13u
X2365 vss SAR/a_8204_9150# SAR/sg13cmos5l_buf_1_74.X vss sg13_lv_nmos ad=0.14875p pd=1.16u as=0.2886p ps=2.26u w=0.74u l=0.13u
X2366 SAR/a_1662_8374# SAR/a_1463_8511# vss vss sg13_lv_nmos ad=0.27427p pd=2.28u as=2.92392p ps=18.89u w=0.795u l=0.13u
X2367 SAR/sg13cmos5l_buf_1_4.X SAR/a_16552_1664# vdd vdd sg13_lv_pmos ad=0.42p pd=2.99u as=0.2114p ps=1.54u w=1.12u l=0.13u
X2368 vss vdd vss vss sg13_lv_nmos ad=79.8f pd=0.8u as=0 ps=0 w=0.42u l=1u
X2369 SAR/a_12549_9165# SAR/sg13cmos5l_inv_1_2.A vdd vdd sg13_lv_pmos ad=0.4088p pd=2.97u as=4.11675p ps=27.17u w=1.12u l=0.13u
X2370 vdd SAR/a_2224_7166# SAR/a_2169_7047# vdd sg13_lv_pmos ad=1.07253p pd=6.75u as=93.45f ps=0.865u w=0.42u l=0.13u
X2371 vss SAR/a_4559_7630# SAR/a_4514_7666# vss sg13_lv_nmos ad=1.49685p pd=9.6u as=71.99999f ps=0.865u w=0.64u l=0.13u
X2372 vss SAR/sg13cmos5l_dfrbp_1_1.Q SAR/a_20392_2388# vss sg13_lv_nmos ad=0.14875p pd=1.16u as=0.187p ps=1.78u w=0.55u l=0.13u
X2373 SAR/a_11824_7894# SAR/a_11567_7751# SAR/a_11986_7674# vss sg13_lv_nmos ad=0.1428p pd=1.52u as=37.8f ps=0.6u w=0.42u l=0.13u
X2374 vdd SAR/a_5079_3154# SAR/a_5210_3148# vdd sg13_lv_pmos ad=1.43437p pd=9.105u as=0.2856p ps=2.36u w=0.84u l=0.13u
X2375 SAR/a_6572_1590# SAR/sg13cmos5l_buf_1_24.A vss vss sg13_lv_nmos ad=0.187p pd=1.78u as=0.14875p ps=1.16u w=0.55u l=0.13u
X2376 SAR/sg13cmos5l_buf_8_2.X SAR/a_19227_9190# vss vss sg13_lv_nmos ad=0.1406p pd=1.12u as=0.1406p ps=1.12u w=0.74u l=0.13u
X2377 vss SAR/a_15177_5769# SAR/a_15132_5814# vss sg13_lv_nmos ad=0.1428p pd=1.52u as=47.25f ps=0.645u w=0.42u l=0.13u
X2378 SAR/a_14436_8874# SAR/sg13cmos5l_dfrbp_1_23.CLK SAR/a_14342_8874# vss sg13_lv_nmos ad=60.89999f pd=0.71u as=0.1428p ps=1.52u w=0.42u l=0.13u
X2379 vdd vss vdd vdd sg13_lv_pmos ad=0.34p pd=2.68u as=0 ps=0 w=1u l=1u
X2380 SAR/sg13cmos5l_dlhr_1_7.Q_N SAR/a_4950_7354# vss vss sg13_lv_nmos ad=0.2516p pd=2.16u as=0.1491p ps=1.18u w=0.74u l=0.13u
X2381 SAR/sg13cmos5l_buf_1_34.A SAR/a_4041_2745# vss vss sg13_lv_nmos ad=0.2516p pd=2.16u as=0.1406p ps=1.12u w=0.74u l=0.13u
X2382 vdd SAR/sg13cmos5l_dfrbp_1_0.RESET_B SAR/a_17674_3361# vdd sg13_lv_pmos ad=0.1563p pd=1.22u as=0.147p ps=1.54u w=0.42u l=0.13u
X2383 SAR/a_11174_2826# SAR/a_11979_2399# SAR/a_11434_2356# vdd sg13_lv_pmos ad=0.1428p pd=1.52u as=79.8f ps=0.8u w=0.42u l=0.13u
X2384 vdd SAR/sg13cmos5l_dfrbp_1_6.RESET_B SAR/a_7497_3138# vdd sg13_lv_pmos ad=0.2128p pd=1.5u as=0.2128p ps=1.5u w=1.12u l=0.13u
X2385 vss SAR/a_10473_9186# SAR/a_10998_9168# vss sg13_lv_nmos ad=0.1491p pd=1.18u as=0.187p ps=1.78u w=0.55u l=0.13u
X2386 SAR/a_15300_2826# SAR/sg13cmos5l_nor2b_1_1.Y SAR/a_15206_2826# vss sg13_lv_nmos ad=60.89999f pd=0.71u as=0.1428p ps=1.52u w=0.42u l=0.13u
X2387 SAR/a_19378_3138# SAR/sg13cmos5l_dfrbp_1_0.RESET_B vss vss sg13_lv_nmos ad=37.8f pd=0.6u as=79.8f ps=0.8u w=0.42u l=0.13u
X2388 SAR/a_8972_3864# SAR/sg13cmos5l_buf_1_45.A vss vss sg13_lv_nmos ad=0.187p pd=1.78u as=0.14875p ps=1.16u w=0.55u l=0.13u
X2389 SAR/a_8247_5770# SAR/sg13cmos5l_dfrbp_1_11.Q vdd vdd sg13_lv_pmos ad=0.3234p pd=2.45u as=1.2517p ps=7.955u w=0.84u l=0.13u
X2390 SAR/a_5700_6480# SAR/a_5674_6385# vss vss sg13_lv_nmos ad=0.2516p pd=2.16u as=0.1626p ps=1.415u w=0.74u l=0.13u
X2391 vss SAR/sg13cmos5l_dlhr_1_10.Q SAR/a_19528_6924# vss sg13_lv_nmos ad=0.14875p pd=1.16u as=0.187p ps=1.78u w=0.55u l=0.13u
X2392 vss SAR/sg13cmos5l_buf_1_97.A SAR/a_11848_8436# vss sg13_lv_nmos ad=0.14875p pd=1.16u as=0.187p ps=1.78u w=0.55u l=0.13u
X2393 SAR/a_11686_2813# SAR/sg13cmos5l_dfrbp_1_0.RESET_B vss vss sg13_lv_nmos ad=37.8f pd=0.6u as=0.1701p ps=1.65u w=0.42u l=0.13u
X2394 vdd SAR/sg13cmos5l_dfrbp_1_20.Q SAR/a_9865_7282# vdd sg13_lv_pmos ad=1.07253p pd=6.75u as=0.2856p ps=2.36u w=0.84u l=0.13u
X2395 SAR/a_19628_2352# SAR/sg13cmos5l_buf_1_19.X vdd vdd sg13_lv_pmos ad=0.2856p pd=2.36u as=0.2114p ps=1.54u w=0.84u l=0.13u
X2396 vdd SAR/a_6188_1590# SAR/sg13cmos5l_buf_1_25.X vdd sg13_lv_pmos ad=0.2114p pd=1.54u as=0.42p ps=2.99u w=1.12u l=0.13u
X2397 vdd SAR/a_1006_4167# SAR/sg13cmos5l_dlygate4sd3_1_0.X vdd sg13_lv_pmos ad=0.2254p pd=1.53u as=0.4256p ps=3u w=1.12u l=0.13u
X2398 SAR/a_620_7638# SAR/sg13cmos5l_buf_1_63.X vss vss sg13_lv_nmos ad=0.187p pd=1.78u as=0.14875p ps=1.16u w=0.55u l=0.13u
X2399 vss SAR/a_5324_1590# SAR/sg13cmos5l_buf_1_39.A vss sg13_lv_nmos ad=0.14875p pd=1.16u as=0.2886p ps=2.26u w=0.74u l=0.13u
X2400 SAR/a_5710_5850# SAR/a_5951_5383# SAR/a_5069_5376# vss sg13_lv_nmos ad=0.1428p pd=1.52u as=0.12665p ps=1.145u w=0.42u l=0.13u
X2401 SAR/sg13cmos5l_dfrbp_1_6.RESET_B _cks vss vss sg13_lv_nmos ad=0.1406p pd=1.12u as=0.1406p ps=1.12u w=0.74u l=0.13u
X2402 vdd SAR/a_1878_6337# SAR/sg13cmos5l_dlhr_1_1.GATE vdd sg13_lv_pmos ad=0.2128p pd=1.5u as=0.3808p ps=2.92u w=1.12u l=0.13u
X2403 SAR/sg13cmos5l_buf_1_18.X SAR/a_18376_2388# vdd vdd sg13_lv_pmos ad=0.42p pd=2.99u as=0.2114p ps=1.54u w=1.12u l=0.13u
X2404 vdd SAR/a_7052_9150# SAR/sg13cmos5l_buf_1_76.X vdd sg13_lv_pmos ad=0.2114p pd=1.54u as=0.42p ps=2.99u w=1.12u l=0.13u
X2405 SAR/a_8852_6484# SAR/a_8570_6172# SAR/a_8785_6154# vss sg13_lv_nmos ad=0.141p pd=1.17u as=71.99999f ps=0.865u w=0.64u l=0.13u
X2406 SAR/sg13cmos5l_buf_1_26.A SAR/sg13cmos5l_buf_1_45.X vss vss sg13_lv_nmos ad=0.2516p pd=2.16u as=0.2516p ps=2.16u w=0.74u l=0.13u
X2407 SAR/a_13775_6239# SAR/a_12933_6141# SAR/a_13681_6239# vss sg13_lv_nmos ad=0.12665p pd=1.145u as=0.1428p ps=1.52u w=0.42u l=0.13u
X2408 vdd SAR/sg13cmos5l_dfrbp_1_0.RESET_B SAR/a_12998_3138# vdd sg13_lv_pmos ad=0.36237p pd=2.605u as=79.8f ps=0.8u w=0.42u l=0.13u
X2409 vss SAR/a_6213_3911# SAR/a_6315_3911# vss sg13_lv_nmos ad=2.41737p pd=15.64u as=0.2516p ps=2.16u w=0.74u l=0.13u
X2410 SAR/a_2364_4686# SAR/a_1815_4666# SAR/a_2228_4972# vss sg13_lv_nmos ad=47.25f pd=0.645u as=0.141p ps=1.17u w=0.42u l=0.13u
X2411 SAR/a_6276_8861# SAR/a_6507_8447# SAR/a_5962_8404# vss sg13_lv_nmos ad=0.2373p pd=1.97u as=79.8f ps=0.8u w=0.42u l=0.13u
X2412 vss SAR/sg13cmos5l_dfrbp_1_6.RESET_B SAR/a_18196_8824# vss sg13_lv_nmos ad=0.1406p pd=1.12u as=77.7f ps=0.95u w=0.74u l=0.13u
X2413 vdd SAR/a_19227_9190# SAR/sg13cmos5l_buf_8_2.X vdd sg13_lv_pmos ad=0.2128p pd=1.5u as=0.2128p ps=1.5u w=1.12u l=0.13u
X2414 SAR/sg13cmos5l_dlhr_1_12.Q_N SAR/a_18486_8866# vdd vdd sg13_lv_pmos ad=0.3808p pd=2.92u as=0.1974p ps=1.5u w=1.12u l=0.13u
X2415 SAR/sg13cmos5l_buf_1_34.X SAR/a_4840_1664# vss vss sg13_lv_nmos ad=0.2886p pd=2.26u as=0.14875p ps=1.16u w=0.74u l=0.13u
X2416 SAR/sg13cmos5l_buf_1_34.A SAR/a_4041_2745# vdd vdd sg13_lv_pmos ad=0.3808p pd=2.92u as=0.2128p ps=1.5u w=1.12u l=0.13u
X2417 vdd vss vdd vdd sg13_lv_pmos ad=0.34p pd=2.68u as=0 ps=0 w=1u l=1u
X2418 SAR/a_4518_7996# SAR/a_4349_7636# SAR/a_4076_7624# vdd sg13_lv_pmos ad=0.105p pd=1.21u as=0.191p ps=1.44u w=1u l=0.13u
X2419 vss SAR/sg13cmos5l_dfrbp_1_15.D SAR/a_2621_7636# vss sg13_lv_nmos ad=0.15055p pd=1.17u as=0.2516p ps=2.16u w=0.74u l=0.13u
X2420 SAR/a_12998_3138# SAR/a_13803_3260# SAR/a_13258_3361# vdd sg13_lv_pmos ad=0.1428p pd=1.52u as=79.8f ps=0.8u w=0.42u l=0.13u
X2421 SAR/a_6903_3154# SAR/sg13cmos5l_dlhr_1_0.GATE vdd vdd sg13_lv_pmos ad=0.3234p pd=2.45u as=1.43437p ps=9.105u w=0.84u l=0.13u
X2422 SAR/a_14814_3876# SAR/sg13cmos5l_nand2_1_1.B vdd vdd sg13_lv_pmos ad=0.2744p pd=1.61u as=0.3808p ps=2.92u w=1.12u l=0.13u
X2423 SAR/a_996_7349# SAR/a_708_6928# SAR/a_934_7349# vss sg13_lv_nmos ad=0.1428p pd=1.52u as=37.8f ps=0.6u w=0.42u l=0.13u
X2424 vdd _cks SAR/sg13cmos5l_dfrbp_1_6.RESET_B vdd sg13_lv_pmos ad=0.2128p pd=1.5u as=0.2128p ps=1.5u w=1.12u l=0.13u
X2425 vss vdd vss vss sg13_lv_nmos ad=79.8f pd=0.8u as=0 ps=0 w=0.42u l=1u
X2426 SAR/a_13775_6239# SAR/a_12933_6141# SAR/a_12516_6480# vdd sg13_lv_pmos ad=0.2048p pd=1.63u as=0.34p ps=2.68u w=1u l=0.13u
X2427 vdd SAR/a_2831_7630# SAR/a_2790_7996# vdd sg13_lv_pmos ad=1.15047p pd=7.175u as=0.105p ps=1.21u w=1u l=0.13u
X2428 SAR/a_2505_3947# SAR/a_2148_3904# vdd vdd sg13_lv_pmos ad=63f pd=0.72u as=0.1563p ps=1.22u w=0.42u l=0.13u
X2429 SAR/a_16293_4629# SAR/sg13cmos5l_inv_1_2.A vdd vdd sg13_lv_pmos ad=0.4088p pd=2.97u as=1.28962p ps=8.195u w=1.12u l=0.13u
X2430 vss SAR/sg13cmos5l_nor2_1_0.A SAR/a_10613_2758# vss sg13_lv_nmos ad=0.1898p pd=1.36u as=0.2516p ps=2.16u w=0.74u l=0.13u
X2431 SAR/sg13cmos5l_buf_1_30.X SAR/a_8680_1664# vdd vdd sg13_lv_pmos ad=0.42p pd=2.99u as=0.2114p ps=1.54u w=1.12u l=0.13u
X2432 vdd _cks SAR/a_19227_9190# vdd sg13_lv_pmos ad=0.2128p pd=1.5u as=0.3808p ps=2.92u w=1.12u l=0.13u
X2433 SAR/a_10412_6126# SAR/sg13cmos5l_dlhr_1_5.Q vss vss sg13_lv_nmos ad=0.187p pd=1.78u as=0.14875p ps=1.16u w=0.55u l=0.13u
X2434 SAR/a_11174_2826# SAR/sg13cmos5l_dfrbp_1_4.D vdd vdd sg13_lv_pmos ad=79.8f pd=0.8u as=0.1428p ps=1.52u w=0.42u l=0.13u
X2435 vss SAR/a_13775_6239# SAR/a_14612_6460# vss sg13_lv_nmos ad=0.1406p pd=1.12u as=0.2516p ps=2.16u w=0.74u l=0.13u
X2436 SAR/a_2148_8440# SAR/a_2122_8404# vdd vdd sg13_lv_pmos ad=0.34p pd=2.68u as=0.36237p ps=2.605u w=1u l=0.13u
X2437 vdd SAR/a_4172_1590# SAR/sg13cmos5l_buf_1_33.A vdd sg13_lv_pmos ad=0.2114p pd=1.54u as=0.42p ps=2.99u w=1.12u l=0.13u
X2438 SAR/a_7449_8559# SAR/a_6507_8447# SAR/a_7247_8797# vdd sg13_lv_pmos ad=93.45f pd=0.865u as=0.2048p ps=1.63u w=0.42u l=0.13u
X2439 SAR/a_11769_7989# SAR/a_10827_7796# SAR/a_11567_7751# vdd sg13_lv_pmos ad=93.45f pd=0.865u as=0.2048p ps=1.63u w=0.42u l=0.13u
X2440 SAR/sg13cmos5l_buf_1_3.X SAR/a_20296_1664# vdd vdd sg13_lv_pmos ad=0.42p pd=2.99u as=0.2114p ps=1.54u w=1.12u l=0.13u
X2441 SAR/a_10220_3102# SAR/sg13cmos5l_buf_1_28.X vss vss sg13_lv_nmos ad=0.187p pd=1.78u as=0.14875p ps=1.16u w=0.55u l=0.13u
X2442 nl_sw[6] SAR/a_11656_3176# vdd vdd sg13_lv_pmos ad=0.42p pd=2.99u as=0.2114p ps=1.54u w=1.12u l=0.13u
X2443 SAR/sg13cmos5l_buf_1_96.A SAR/a_10665_7281# vdd vdd sg13_lv_pmos ad=0.3808p pd=2.92u as=0.2128p ps=1.5u w=1.12u l=0.13u
X2444 SAR/a_14641_7326# SAR/a_14089_7282# vss vss sg13_lv_nmos ad=71.99999f pd=0.865u as=1.49685p ps=9.6u w=0.64u l=0.13u
X2445 SAR/a_7052_9150# SAR/sg13cmos5l_inv_1_14.A vdd vdd sg13_lv_pmos ad=0.2856p pd=2.36u as=0.2114p ps=1.54u w=0.84u l=0.13u
X2446 vdd SAR/a_3407_8797# SAR/a_3664_8678# vdd sg13_lv_pmos ad=0.2639p pd=1.81u as=79.8f ps=0.8u w=0.42u l=0.13u
X2447 SAR/a_16204_4338# SAR/a_15821_3864# vdd vdd sg13_lv_pmos ad=79.8f pd=0.8u as=0.2639p ps=1.81u w=0.42u l=0.13u
X2448 vdd SAR/sg13cmos5l_dfrbp_1_8.RESET_B SAR/a_2122_8404# vdd sg13_lv_pmos ad=0.1563p pd=1.22u as=0.147p ps=1.54u w=0.42u l=0.13u
X2449 SAR/a_6380_7638# SAR/sg13cmos5l_buf_1_78.X vss vss sg13_lv_nmos ad=0.187p pd=1.78u as=0.14875p ps=1.16u w=0.55u l=0.13u
X2450 SAR/a_14900_2352# SAR/sg13cmos5l_nor2_1_1.A vss vss sg13_lv_nmos ad=0.187p pd=1.78u as=0.17255p ps=1.25u w=0.55u l=0.13u
X2451 SAR/a_7161_6477# SAR/a_6219_6284# SAR/a_6959_6239# vdd sg13_lv_pmos ad=93.45f pd=0.865u as=0.2048p ps=1.63u w=0.42u l=0.13u
X2452 SAR/sg13cmos5l_dlhr_1_15.Q_N SAR/a_18870_7656# vss vss sg13_lv_nmos ad=0.2516p pd=2.16u as=0.1491p ps=1.18u w=0.74u l=0.13u
X2453 SAR/a_15780_2813# SAR/a_16011_2399# SAR/a_15466_2356# vss sg13_lv_nmos ad=0.2373p pd=1.97u as=79.8f ps=0.8u w=0.42u l=0.13u
X2454 SAR/a_5710_5535# SAR/a_5452_5850# vdd vdd sg13_lv_pmos ad=93.45f pd=0.865u as=1.28962p ps=8.195u w=0.42u l=0.13u
X2455 vdd SAR/sg13cmos5l_buf_1_29.A SAR/a_9832_1664# vdd sg13_lv_pmos ad=0.2114p pd=1.54u as=0.2856p ps=2.36u w=0.84u l=0.13u
X2456 vdd SAR/sg13cmos5l_buf_1_39.A SAR/a_3688_1664# vdd sg13_lv_pmos ad=0.2114p pd=1.54u as=0.2856p ps=2.36u w=0.84u l=0.13u
X2457 SAR/sg13cmos5l_dfrbp_1_9.Q_N SAR/a_3407_4261# vss vss sg13_lv_nmos ad=0.2849p pd=2.25u as=0.2516p ps=2.16u w=0.74u l=0.13u
X2458 SAR/sg13cmos5l_dlhr_1_12.Q_N SAR/a_18486_8866# vss vss sg13_lv_nmos ad=0.2516p pd=2.16u as=0.1491p ps=1.18u w=0.74u l=0.13u
X2459 SAR/a_16164_4663# SAR/a_16395_4772# SAR/a_15850_4873# vss sg13_lv_nmos ad=0.2373p pd=1.97u as=79.8f ps=0.8u w=0.42u l=0.13u
X2460 SAR/a_17961_8793# SAR/a_17780_8436# vdd vdd sg13_lv_pmos ad=0.2128p pd=1.5u as=0.2387p ps=1.84u w=1.12u l=0.13u
X2461 vdd SAR/a_8588_3864# SAR/sg13cmos5l_buf_1_30.A vdd sg13_lv_pmos ad=0.2114p pd=1.54u as=0.42p ps=2.99u w=1.12u l=0.13u
X2462 SAR/a_4311_7710# SAR/a_3676_7964# vss vss sg13_lv_nmos ad=47.25f pd=0.645u as=0.1428p ps=1.52u w=0.42u l=0.13u
X2463 SAR/sg13cmos5l_dlhr_1_15.Q SAR/a_18345_7674# vdd vdd sg13_lv_pmos ad=0.3808p pd=2.92u as=0.2128p ps=1.5u w=1.12u l=0.13u
X2464 vss SAR/sg13cmos5l_buf_1_28.A SAR/a_9448_1664# vss sg13_lv_nmos ad=0.14875p pd=1.16u as=0.187p ps=1.78u w=0.55u l=0.13u
X2465 vdd SAR/a_18959_3215# SAR/a_19216_3358# vdd sg13_lv_pmos ad=0.2639p pd=1.81u as=79.8f ps=0.8u w=0.42u l=0.13u
X2466 SAR/sg13cmos5l_a22oi_1_0.B1 SAR/sg13cmos5l_nor2_1_0.A SAR/a_10618_3142# vss sg13_lv_nmos ad=0.2516p pd=2.16u as=0.1406p ps=1.12u w=0.74u l=0.13u
X2467 SAR/sg13cmos5l_dfrbp_1_0.Q SAR/a_19508_1924# vss vss sg13_lv_nmos ad=0.2516p pd=2.16u as=0.1406p ps=1.12u w=0.74u l=0.13u
X2468 SAR/a_10450_8874# SAR/sg13cmos5l_dfrbp_1_8.RESET_B vss vss sg13_lv_nmos ad=37.8f pd=0.6u as=79.8f ps=0.8u w=0.42u l=0.13u
X2469 SAR/a_2554_8112# SAR/a_1948_7964# vdd vdd sg13_lv_pmos ad=0.1008p pd=0.9u as=0.2387p ps=1.84u w=0.42u l=0.13u
X2470 SAR/a_7498_7897# SAR/a_7941_7653# SAR/a_7238_7674# vss sg13_lv_nmos ad=79.8f pd=0.8u as=0.1296p ps=1.52u w=0.42u l=0.13u
X2471 vss vdd vss vss sg13_lv_nmos ad=79.8f pd=0.8u as=0 ps=0 w=0.42u l=1u
X2472 vdd SAR/a_1846_7850# SAR/sg13cmos5l_dlhr_1_8.Q_N vdd sg13_lv_pmos ad=0.1974p pd=1.5u as=0.3808p ps=2.92u w=1.12u l=0.13u
X2473 vdd SAR/a_13775_6239# SAR/a_14032_6382# vdd sg13_lv_pmos ad=0.2639p pd=1.81u as=79.8f ps=0.8u w=0.42u l=0.13u
X2474 SAR/sg13cmos5l_dfrbp_1_23.CLK SAR/a_14228_9484# vss vss sg13_lv_nmos ad=0.2516p pd=2.16u as=0.1406p ps=1.12u w=0.74u l=0.13u
X2475 SAR/a_12358_5388# SAR/sg13cmos5l_dfrbp_1_21.Q vdd vdd sg13_lv_pmos ad=0.1596p pd=1.22u as=0.2226p ps=1.535u w=0.84u l=0.13u
X2476 SAR/a_422_5850# SAR/sg13cmos5l_dfrbp_1_6.D vdd vdd sg13_lv_pmos ad=79.8f pd=0.8u as=0.1428p ps=1.52u w=0.42u l=0.13u
X2477 vdd SAR/sg13cmos5l_inv_1_18.A SAR/a_9256_9224# vdd sg13_lv_pmos ad=0.2114p pd=1.54u as=0.2856p ps=2.36u w=0.84u l=0.13u
X2478 vss SAR/sg13cmos5l_buf_1_78.A SAR/a_6184_9224# vss sg13_lv_nmos ad=0.14875p pd=1.16u as=0.187p ps=1.78u w=0.55u l=0.13u
X2479 SAR/sg13cmos5l_dfrbp_1_10.Q SAR/a_4436_3436# vss vss sg13_lv_nmos ad=0.2516p pd=2.16u as=0.1406p ps=1.12u w=0.74u l=0.13u
X2480 SAR/a_17508_3138# SAR/sg13cmos5l_a22oi_1_1.Y SAR/a_17414_3138# vss sg13_lv_nmos ad=60.89999f pd=0.71u as=0.1428p ps=1.52u w=0.42u l=0.13u
X2481 SAR/a_16234_6385# SAR/a_16677_6141# SAR/a_16617_6553# vdd sg13_lv_pmos ad=79.8f pd=0.8u as=63f ps=0.72u w=0.42u l=0.13u
X2482 SAR/a_14194_6162# SAR/sg13cmos5l_dfrbp_1_6.RESET_B vss vss sg13_lv_nmos ad=37.8f pd=0.6u as=79.8f ps=0.8u w=0.42u l=0.13u
X2483 SAR/a_11844_1639# SAR/a_11556_1944# SAR/a_11782_1639# vss sg13_lv_nmos ad=0.1428p pd=1.52u as=37.8f ps=0.6u w=0.42u l=0.13u
X2484 vdd SAR/a_13648_9406# SAR/a_13593_9501# vdd sg13_lv_pmos ad=4.11675p pd=27.17u as=93.45f ps=0.865u w=0.42u l=0.13u
X2485 SAR/sg13cmos5l_inv_1_0.A SAR/a_13652_3900# vss vss sg13_lv_nmos ad=0.2516p pd=2.16u as=0.1406p ps=1.12u w=0.74u l=0.13u
X2486 SAR/a_3814_4663# SAR/sg13cmos5l_dfrbp_1_8.RESET_B vss vss sg13_lv_nmos ad=37.8f pd=0.6u as=0.1701p ps=1.65u w=0.42u l=0.13u
X2487 SAR/sg13cmos5l_dlhr_1_13.Q_N SAR/a_15414_7354# vdd vdd sg13_lv_pmos ad=0.3808p pd=2.92u as=0.1974p ps=1.5u w=1.12u l=0.13u
X0 vddr ph_sw[1] SC0/buf_16_3.z vddr sg13_lv_pmos ad=0.19p pd=1.38u as=0.19p ps=1.38u w=1u l=0.13u
X1 SC0/vss ph_sw[0] SC0/buf_32_1.z SC0/vss sg13_lv_nmos ad=95f pd=0.88u as=95f ps=0.88u w=0.5u l=0.13u
X2 vddr pl_sw[4] SC0/buf_8_0.z vddr sg13_lv_pmos ad=0.19p pd=1.38u as=0.19p ps=1.38u w=1u l=0.13u
X3 vddr pl_sw[0] SC0/buf_32_0.z vddr sg13_lv_pmos ad=0.19p pd=1.38u as=0.19p ps=1.38u w=1u l=0.13u
X4 SC0/buf_16_1.z pl_sw[2] SC0/vss SC0/vss sg13_lv_nmos ad=95f pd=0.88u as=95f ps=0.88u w=0.5u l=0.13u
X5 SC0/vss ph_sw[2] SC0/buf_16_0.z SC0/vss sg13_lv_nmos ad=95f pd=0.88u as=95f ps=0.88u w=0.5u l=0.13u
X6 SC0/buf_32_0.z pl_sw[0] SC0/vss SC0/vss sg13_lv_nmos ad=95f pd=0.88u as=95f ps=0.88u w=0.5u l=0.13u
X7 SC0/vss ph_sw[2] SC0/buf_16_0.z SC0/vss sg13_lv_nmos ad=95f pd=0.88u as=95f ps=0.88u w=0.5u l=0.13u
X8 vddr ph_sw[5] SC0/buf_8_5.z vddr sg13_lv_pmos ad=0.19p pd=1.38u as=0.34p ps=2.68u w=1u l=0.13u
X9 SC0/buf_16_1.z pl_sw[2] SC0/vss SC0/vss sg13_lv_nmos ad=95f pd=0.88u as=95f ps=0.88u w=0.5u l=0.13u
X10 SC0/buf_32_1.z ph_sw[0] SC0/vss SC0/vss sg13_lv_nmos ad=95f pd=0.88u as=95f ps=0.88u w=0.5u l=0.13u
X11 vddr pl_sw[0] SC0/buf_32_0.z vddr sg13_lv_pmos ad=0.19p pd=1.38u as=0.19p ps=1.38u w=1u l=0.13u
X12 SC0/buf_32_0.z pl_sw[0] vddr vddr sg13_lv_pmos ad=0.19p pd=1.38u as=0.19p ps=1.38u w=1u l=0.13u
X13 SC0/buf_2_2.z pl_sw[9] SC0/vss SC0/vss sg13_lv_nmos ad=0.17p pd=1.68u as=95f ps=0.88u w=0.5u l=0.13u
X14 vddr ph_sw[0] SC0/buf_32_1.z vddr sg13_lv_pmos ad=0.19p pd=1.38u as=0.19p ps=1.38u w=1u l=0.13u
X15 SC0/vss pl_sw[0] SC0/buf_32_0.z SC0/vss sg13_lv_nmos ad=95f pd=0.88u as=95f ps=0.88u w=0.5u l=0.13u
X16 SC0/buf_8_2.z ph_sw[4] SC0/vss SC0/vss sg13_lv_nmos ad=0.17p pd=1.68u as=95f ps=0.88u w=0.5u l=0.13u
X17 SC0/buf_16_0.z ph_sw[2] vddr vddr sg13_lv_pmos ad=0.34p pd=2.68u as=0.19p ps=1.38u w=1u l=0.13u
X18 SC0/vss ph_sw[0] SC0/buf_32_1.z SC0/vss sg13_lv_nmos ad=95f pd=0.88u as=95f ps=0.88u w=0.5u l=0.13u
X19 SC0/buf_16_3.z ph_sw[1] vddr vddr sg13_lv_pmos ad=0.19p pd=1.38u as=0.19p ps=1.38u w=1u l=0.13u
X20 SC0/buf_32_1.z ph_sw[0] vddr vddr sg13_lv_pmos ad=0.19p pd=1.38u as=0.19p ps=1.38u w=1u l=0.13u
X21 SC0/vss ph_sw[1] SC0/buf_16_3.z SC0/vss sg13_lv_nmos ad=95f pd=0.88u as=0.17p ps=1.68u w=0.5u l=0.13u
X22 SC0/buf_32_0.z pl_sw[0] SC0/vss SC0/vss sg13_lv_nmos ad=95f pd=0.88u as=95f ps=0.88u w=0.5u l=0.13u
X23 vddr ph_sw[3] SC0/buf_8_3.z vddr sg13_lv_pmos ad=0.19p pd=1.38u as=0.19p ps=1.38u w=1u l=0.13u
X24 SC0/buf_2_1.z pl_sw[8] vddr vddr sg13_lv_pmos ad=0.34p pd=2.68u as=0.19p ps=1.38u w=1u l=0.13u
X25 SC0/buf_32_1.z ph_sw[0] SC0/vss SC0/vss sg13_lv_nmos ad=95f pd=0.88u as=95f ps=0.88u w=0.5u l=0.13u
X26 vddr ph_sw[2] SC0/buf_16_0.z vddr sg13_lv_pmos ad=0.19p pd=1.38u as=0.34p ps=2.68u w=1u l=0.13u
X27 SC0/buf_8_1.z pl_sw[3] SC0/vss SC0/vss sg13_lv_nmos ad=95f pd=0.88u as=95f ps=0.88u w=0.5u l=0.13u
X28 vddr pl_sw[3] SC0/buf_8_1.z vddr sg13_lv_pmos ad=0.19p pd=1.38u as=0.19p ps=1.38u w=1u l=0.13u
X29 vddr ph_sw[0] SC0/buf_32_1.z vddr sg13_lv_pmos ad=0.19p pd=1.38u as=0.19p ps=1.38u w=1u l=0.13u
X30 SC0/buf_16_3.z ph_sw[1] SC0/vss SC0/vss sg13_lv_nmos ad=95f pd=0.88u as=95f ps=0.88u w=0.5u l=0.13u
X31 SC0/buf_8_2.z ph_sw[4] SC0/vss SC0/vss sg13_lv_nmos ad=95f pd=0.88u as=95f ps=0.88u w=0.5u l=0.13u
X32 SC0/vss ph_sw[0] SC0/buf_32_1.z SC0/vss sg13_lv_nmos ad=95f pd=0.88u as=95f ps=0.88u w=0.5u l=0.13u
X33 vddr ph_sw[0] SC0/buf_32_1.z vddr sg13_lv_pmos ad=0.19p pd=1.38u as=0.19p ps=1.38u w=1u l=0.13u
X34 SC0/buf_16_0.z ph_sw[2] vddr vddr sg13_lv_pmos ad=0.19p pd=1.38u as=0.19p ps=1.38u w=1u l=0.13u
X35 vddr ph_sw[6] SC0/buf_4_1.z vddr sg13_lv_pmos ad=0.19p pd=1.38u as=0.34p ps=2.68u w=1u l=0.13u
X36 SC0/buf_16_2.z pl_sw[1] SC0/vss SC0/vss sg13_lv_nmos ad=95f pd=0.88u as=95f ps=0.88u w=0.5u l=0.13u
X37 SC0/vss pl_sw[1] SC0/buf_16_2.z SC0/vss sg13_lv_nmos ad=95f pd=0.88u as=95f ps=0.88u w=0.5u l=0.13u
X38 SC0/buf_8_3.z ph_sw[3] SC0/vss SC0/vss sg13_lv_nmos ad=95f pd=0.88u as=95f ps=0.88u w=0.5u l=0.13u
X39 vddr pl_sw[2] SC0/buf_16_1.z vddr sg13_lv_pmos ad=0.19p pd=1.38u as=0.19p ps=1.38u w=1u l=0.13u
X40 SC0/buf_8_4.z pl_sw[5] SC0/vss SC0/vss sg13_lv_nmos ad=95f pd=0.88u as=95f ps=0.88u w=0.5u l=0.13u
X41 SC0/buf_32_0.z pl_sw[0] SC0/vss SC0/vss sg13_lv_nmos ad=95f pd=0.88u as=95f ps=0.88u w=0.5u l=0.13u
X42 vddr ph_sw[3] SC0/buf_8_3.z vddr sg13_lv_pmos ad=0.19p pd=1.38u as=0.19p ps=1.38u w=1u l=0.13u
X43 SC0/buf_16_1.z pl_sw[2] vddr vddr sg13_lv_pmos ad=0.19p pd=1.38u as=0.19p ps=1.38u w=1u l=0.13u
X44 SC0/buf_16_2.z pl_sw[1] vddr vddr sg13_lv_pmos ad=0.19p pd=1.38u as=0.19p ps=1.38u w=1u l=0.13u
X45 vddr pl_sw[0] SC0/buf_32_0.z vddr sg13_lv_pmos ad=0.19p pd=1.38u as=0.19p ps=1.38u w=1u l=0.13u
X46 SC0/vss ph_sw[7] SC0/buf_4_2.z SC0/vss sg13_lv_nmos ad=95f pd=0.88u as=95f ps=0.88u w=0.5u l=0.13u
X47 SC0/buf_2_2.z pl_sw[9] vddr vddr sg13_lv_pmos ad=0.34p pd=2.68u as=0.19p ps=1.38u w=1u l=0.13u
X48 SC0/buf_16_3.z ph_sw[1] vddr vddr sg13_lv_pmos ad=0.19p pd=1.38u as=0.19p ps=1.38u w=1u l=0.13u
X49 SC0/buf_4_0.z pl_sw[7] vddr vddr sg13_lv_pmos ad=0.19p pd=1.38u as=0.19p ps=1.38u w=1u l=0.13u
X50 SC0/vss pl_sw[0] SC0/buf_32_0.z SC0/vss sg13_lv_nmos ad=95f pd=0.88u as=95f ps=0.88u w=0.5u l=0.13u
X51 SC0/buf_8_5.z ph_sw[5] SC0/vss SC0/vss sg13_lv_nmos ad=0.17p pd=1.68u as=95f ps=0.88u w=0.5u l=0.13u
X52 vddr ph_sw[8] SC0/buf_2_0.z vddr sg13_lv_pmos ad=0.19p pd=1.38u as=0.34p ps=2.68u w=1u l=0.13u
X53 SC0/buf_8_0.z pl_sw[4] vddr vddr sg13_lv_pmos ad=0.19p pd=1.38u as=0.19p ps=1.38u w=1u l=0.13u
X54 SC0/buf_32_0.z pl_sw[0] vddr vddr sg13_lv_pmos ad=0.19p pd=1.38u as=0.19p ps=1.38u w=1u l=0.13u
X55 SC0/vss pl_sw[2] SC0/buf_16_1.z SC0/vss sg13_lv_nmos ad=95f pd=0.88u as=95f ps=0.88u w=0.5u l=0.13u
X56 SC0/vss pl_sw[0] SC0/buf_32_0.z SC0/vss sg13_lv_nmos ad=95f pd=0.88u as=95f ps=0.88u w=0.5u l=0.13u
X57 vddr pl_sw[2] SC0/buf_16_1.z vddr sg13_lv_pmos ad=0.19p pd=1.38u as=0.19p ps=1.38u w=1u l=0.13u
X58 vddr pl_sw[1] SC0/buf_16_2.z vddr sg13_lv_pmos ad=0.19p pd=1.38u as=0.19p ps=1.38u w=1u l=0.13u
X59 SC0/vss pl_sw[3] SC0/buf_8_1.z SC0/vss sg13_lv_nmos ad=95f pd=0.88u as=95f ps=0.88u w=0.5u l=0.13u
X60 vddr pl_sw[0] SC0/buf_32_0.z vddr sg13_lv_pmos ad=0.19p pd=1.38u as=0.19p ps=1.38u w=1u l=0.13u
X61 SC0/buf_32_1.z ph_sw[0] vddr vddr sg13_lv_pmos ad=0.19p pd=1.38u as=0.19p ps=1.38u w=1u l=0.13u
X62 vddr pl_sw[5] SC0/buf_8_4.z vddr sg13_lv_pmos ad=0.19p pd=1.38u as=0.19p ps=1.38u w=1u l=0.13u
X63 vddr ph_sw[2] SC0/buf_16_0.z vddr sg13_lv_pmos ad=0.19p pd=1.38u as=0.19p ps=1.38u w=1u l=0.13u
X64 SC0/buf_8_5.z ph_sw[5] SC0/vss SC0/vss sg13_lv_nmos ad=95f pd=0.88u as=95f ps=0.88u w=0.5u l=0.13u
X65 SC0/buf_32_0.z pl_sw[0] vddr vddr sg13_lv_pmos ad=0.19p pd=1.38u as=0.19p ps=1.38u w=1u l=0.13u
X66 SC0/vss pl_sw[4] SC0/buf_8_0.z SC0/vss sg13_lv_nmos ad=95f pd=0.88u as=0.17p ps=1.68u w=0.5u l=0.13u
X67 SC0/buf_16_3.z ph_sw[1] SC0/vss SC0/vss sg13_lv_nmos ad=95f pd=0.88u as=95f ps=0.88u w=0.5u l=0.13u
X68 vddr ph_sw[0] SC0/buf_32_1.z vddr sg13_lv_pmos ad=0.19p pd=1.38u as=0.19p ps=1.38u w=1u l=0.13u
X69 SC0/vss pl_sw[0] SC0/buf_32_0.z SC0/vss sg13_lv_nmos ad=95f pd=0.88u as=0.17p ps=1.68u w=0.5u l=0.13u
X70 SC0/buf_16_0.z ph_sw[2] SC0/vss SC0/vss sg13_lv_nmos ad=95f pd=0.88u as=95f ps=0.88u w=0.5u l=0.13u
X71 SC0/vss ph_sw[0] SC0/buf_32_1.z SC0/vss sg13_lv_nmos ad=95f pd=0.88u as=95f ps=0.88u w=0.5u l=0.13u
X72 SC0/buf_2_1.z pl_sw[8] SC0/vss SC0/vss sg13_lv_nmos ad=0.17p pd=1.68u as=95f ps=0.88u w=0.5u l=0.13u
X73 vddr pl_sw[0] SC0/buf_32_0.z vddr sg13_lv_pmos ad=0.19p pd=1.38u as=0.19p ps=1.38u w=1u l=0.13u
X74 SC0/buf_4_3.z pl_sw[6] SC0/vss SC0/vss sg13_lv_nmos ad=95f pd=0.88u as=95f ps=0.88u w=0.5u l=0.13u
X75 SC0/buf_8_1.z pl_sw[3] vddr vddr sg13_lv_pmos ad=0.34p pd=2.68u as=0.19p ps=1.38u w=1u l=0.13u
X76 SC0/buf_32_1.z ph_sw[0] vddr vddr sg13_lv_pmos ad=0.19p pd=1.38u as=0.19p ps=1.38u w=1u l=0.13u
X77 SC0/buf_4_2.z ph_sw[7] vddr vddr sg13_lv_pmos ad=0.19p pd=1.38u as=0.19p ps=1.38u w=1u l=0.13u
X78 SC0/vss ph_sw[1] SC0/buf_16_3.z SC0/vss sg13_lv_nmos ad=95f pd=0.88u as=95f ps=0.88u w=0.5u l=0.13u
X79 SC0/buf_32_0.z pl_sw[0] SC0/vss SC0/vss sg13_lv_nmos ad=95f pd=0.88u as=95f ps=0.88u w=0.5u l=0.13u
X80 SC0/vss ph_sw[4] SC0/buf_8_2.z SC0/vss sg13_lv_nmos ad=95f pd=0.88u as=95f ps=0.88u w=0.5u l=0.13u
X81 SC0/buf_32_1.z ph_sw[0] SC0/vss SC0/vss sg13_lv_nmos ad=95f pd=0.88u as=95f ps=0.88u w=0.5u l=0.13u
X82 SC0/buf_32_1.z ph_sw[0] vddr vddr sg13_lv_pmos ad=0.19p pd=1.38u as=0.19p ps=1.38u w=1u l=0.13u
X83 vddr ph_sw[2] SC0/buf_16_0.z vddr sg13_lv_pmos ad=0.19p pd=1.38u as=0.19p ps=1.38u w=1u l=0.13u
X84 SC0/vss ph_sw[0] SC0/buf_32_1.z SC0/vss sg13_lv_nmos ad=95f pd=0.88u as=95f ps=0.88u w=0.5u l=0.13u
X85 vddr ph_sw[5] SC0/buf_8_5.z vddr sg13_lv_pmos ad=0.19p pd=1.38u as=0.19p ps=1.38u w=1u l=0.13u
X86 SC0/buf_16_2.z pl_sw[1] SC0/vss SC0/vss sg13_lv_nmos ad=95f pd=0.88u as=95f ps=0.88u w=0.5u l=0.13u
X87 vddr ph_sw[0] SC0/buf_32_1.z vddr sg13_lv_pmos ad=0.19p pd=1.38u as=0.19p ps=1.38u w=1u l=0.13u
X88 vddr pl_sw[1] SC0/buf_16_2.z vddr sg13_lv_pmos ad=0.19p pd=1.38u as=0.19p ps=1.38u w=1u l=0.13u
X89 SC0/vss pl_sw[0] SC0/buf_32_0.z SC0/vss sg13_lv_nmos ad=95f pd=0.88u as=95f ps=0.88u w=0.5u l=0.13u
X90 SC0/buf_8_3.z ph_sw[3] vddr vddr sg13_lv_pmos ad=0.19p pd=1.38u as=0.19p ps=1.38u w=1u l=0.13u
X91 SC0/buf_4_0.z pl_sw[7] SC0/vss SC0/vss sg13_lv_nmos ad=0.17p pd=1.68u as=95f ps=0.88u w=0.5u l=0.13u
X92 vddr pl_sw[5] SC0/buf_8_4.z vddr sg13_lv_pmos ad=0.19p pd=1.38u as=0.19p ps=1.38u w=1u l=0.13u
X93 vddr ph_sw[1] SC0/buf_16_3.z vddr sg13_lv_pmos ad=0.19p pd=1.38u as=0.19p ps=1.38u w=1u l=0.13u
X94 SC0/buf_32_1.z ph_sw[0] vddr vddr sg13_lv_pmos ad=0.19p pd=1.38u as=0.19p ps=1.38u w=1u l=0.13u
X95 SC0/vss ph_sw[1] SC0/buf_16_3.z SC0/vss sg13_lv_nmos ad=95f pd=0.88u as=95f ps=0.88u w=0.5u l=0.13u
X96 SC0/vss ph_sw[4] SC0/buf_8_2.z SC0/vss sg13_lv_nmos ad=95f pd=0.88u as=0.17p ps=1.68u w=0.5u l=0.13u
X97 SC0/buf_8_0.z pl_sw[4] vddr vddr sg13_lv_pmos ad=0.19p pd=1.38u as=0.19p ps=1.38u w=1u l=0.13u
X98 SC0/buf_32_0.z pl_sw[0] SC0/vss SC0/vss sg13_lv_nmos ad=95f pd=0.88u as=95f ps=0.88u w=0.5u l=0.13u
X99 vddr ph_sw[2] SC0/buf_16_0.z vddr sg13_lv_pmos ad=0.19p pd=1.38u as=0.19p ps=1.38u w=1u l=0.13u
X100 SC0/buf_16_1.z pl_sw[2] SC0/vss SC0/vss sg13_lv_nmos ad=95f pd=0.88u as=95f ps=0.88u w=0.5u l=0.13u
X101 SC0/buf_16_2.z pl_sw[1] SC0/vss SC0/vss sg13_lv_nmos ad=95f pd=0.88u as=95f ps=0.88u w=0.5u l=0.13u
X102 vddr ph_sw[5] SC0/buf_8_5.z vddr sg13_lv_pmos ad=0.19p pd=1.38u as=0.19p ps=1.38u w=1u l=0.13u
X103 SC0/buf_16_1.z pl_sw[2] vddr vddr sg13_lv_pmos ad=0.19p pd=1.38u as=0.19p ps=1.38u w=1u l=0.13u
X104 SC0/buf_16_2.z pl_sw[1] vddr vddr sg13_lv_pmos ad=0.19p pd=1.38u as=0.19p ps=1.38u w=1u l=0.13u
X105 SC0/buf_8_0.z pl_sw[4] SC0/vss SC0/vss sg13_lv_nmos ad=95f pd=0.88u as=95f ps=0.88u w=0.5u l=0.13u
X106 SC0/vss pl_sw[5] SC0/buf_8_4.z SC0/vss sg13_lv_nmos ad=95f pd=0.88u as=0.17p ps=1.68u w=0.5u l=0.13u
X107 SC0/buf_8_1.z pl_sw[3] SC0/vss SC0/vss sg13_lv_nmos ad=95f pd=0.88u as=95f ps=0.88u w=0.5u l=0.13u
X108 SC0/buf_8_2.z ph_sw[4] vddr vddr sg13_lv_pmos ad=0.19p pd=1.38u as=0.19p ps=1.38u w=1u l=0.13u
X109 vddr ph_sw[9] SC0/buf_2_3.z vddr sg13_lv_pmos ad=0.19p pd=1.38u as=0.34p ps=2.68u w=1u l=0.13u
X110 SC0/buf_8_4.z pl_sw[5] vddr vddr sg13_lv_pmos ad=0.19p pd=1.38u as=0.19p ps=1.38u w=1u l=0.13u
X111 SC0/vss ph_sw[0] SC0/buf_32_1.z SC0/vss sg13_lv_nmos ad=95f pd=0.88u as=95f ps=0.88u w=0.5u l=0.13u
X112 SC0/vss ph_sw[5] SC0/buf_8_5.z SC0/vss sg13_lv_nmos ad=95f pd=0.88u as=95f ps=0.88u w=0.5u l=0.13u
X113 vddr pl_sw[0] SC0/buf_32_0.z vddr sg13_lv_pmos ad=0.19p pd=1.38u as=0.19p ps=1.38u w=1u l=0.13u
X114 SC0/buf_16_1.z pl_sw[2] SC0/vss SC0/vss sg13_lv_nmos ad=95f pd=0.88u as=95f ps=0.88u w=0.5u l=0.13u
X115 SC0/vss ph_sw[2] SC0/buf_16_0.z SC0/vss sg13_lv_nmos ad=95f pd=0.88u as=95f ps=0.88u w=0.5u l=0.13u
X116 SC0/vss ph_sw[2] SC0/buf_16_0.z SC0/vss sg13_lv_nmos ad=95f pd=0.88u as=95f ps=0.88u w=0.5u l=0.13u
X117 SC0/buf_32_1.z ph_sw[0] SC0/vss SC0/vss sg13_lv_nmos ad=95f pd=0.88u as=95f ps=0.88u w=0.5u l=0.13u
X118 SC0/buf_4_1.z ph_sw[6] SC0/vss SC0/vss sg13_lv_nmos ad=95f pd=0.88u as=95f ps=0.88u w=0.5u l=0.13u
X119 SC0/buf_16_1.z pl_sw[2] SC0/vss SC0/vss sg13_lv_nmos ad=0.17p pd=1.68u as=95f ps=0.88u w=0.5u l=0.13u
X120 vddr pl_sw[0] SC0/buf_32_0.z vddr sg13_lv_pmos ad=0.19p pd=1.38u as=0.19p ps=1.38u w=1u l=0.13u
X121 vddr pl_sw[3] SC0/buf_8_1.z vddr sg13_lv_pmos ad=0.19p pd=1.38u as=0.19p ps=1.38u w=1u l=0.13u
X122 SC0/buf_32_0.z pl_sw[0] vddr vddr sg13_lv_pmos ad=0.19p pd=1.38u as=0.19p ps=1.38u w=1u l=0.13u
X123 SC0/vss pl_sw[0] SC0/buf_32_0.z SC0/vss sg13_lv_nmos ad=95f pd=0.88u as=95f ps=0.88u w=0.5u l=0.13u
X124 SC0/vss ph_sw[0] SC0/buf_32_1.z SC0/vss sg13_lv_nmos ad=95f pd=0.88u as=95f ps=0.88u w=0.5u l=0.13u
X125 SC0/buf_16_3.z ph_sw[1] vddr vddr sg13_lv_pmos ad=0.34p pd=2.68u as=0.19p ps=1.38u w=1u l=0.13u
X126 SC0/vss ph_sw[5] SC0/buf_8_5.z SC0/vss sg13_lv_nmos ad=95f pd=0.88u as=0.17p ps=1.68u w=0.5u l=0.13u
X127 SC0/buf_32_1.z ph_sw[0] SC0/vss SC0/vss sg13_lv_nmos ad=95f pd=0.88u as=95f ps=0.88u w=0.5u l=0.13u
X128 SC0/buf_8_3.z ph_sw[3] SC0/vss SC0/vss sg13_lv_nmos ad=0.17p pd=1.68u as=95f ps=0.88u w=0.5u l=0.13u
X129 SC0/buf_32_0.z pl_sw[0] SC0/vss SC0/vss sg13_lv_nmos ad=95f pd=0.88u as=95f ps=0.88u w=0.5u l=0.13u
X130 SC0/buf_4_3.z pl_sw[6] vddr vddr sg13_lv_pmos ad=0.19p pd=1.38u as=0.19p ps=1.38u w=1u l=0.13u
X131 SC0/buf_32_1.z ph_sw[0] vddr vddr sg13_lv_pmos ad=0.19p pd=1.38u as=0.19p ps=1.38u w=1u l=0.13u
X132 SC0/vss pl_sw[7] SC0/buf_4_0.z SC0/vss sg13_lv_nmos ad=95f pd=0.88u as=0.17p ps=1.68u w=0.5u l=0.13u
X133 vddr ph_sw[0] SC0/buf_32_1.z vddr sg13_lv_pmos ad=0.19p pd=1.38u as=0.19p ps=1.38u w=1u l=0.13u
X134 SC0/buf_16_3.z ph_sw[1] SC0/vss SC0/vss sg13_lv_nmos ad=95f pd=0.88u as=95f ps=0.88u w=0.5u l=0.13u
X135 vddr ph_sw[6] SC0/buf_4_1.z vddr sg13_lv_pmos ad=0.19p pd=1.38u as=0.19p ps=1.38u w=1u l=0.13u
X136 SC0/buf_16_0.z ph_sw[2] vddr vddr sg13_lv_pmos ad=0.19p pd=1.38u as=0.19p ps=1.38u w=1u l=0.13u
X137 SC0/vss ph_sw[8] SC0/buf_2_0.z SC0/vss sg13_lv_nmos ad=95f pd=0.88u as=0.17p ps=1.68u w=0.5u l=0.13u
X138 SC0/buf_16_2.z pl_sw[1] SC0/vss SC0/vss sg13_lv_nmos ad=0.17p pd=1.68u as=95f ps=0.88u w=0.5u l=0.13u
X139 SC0/buf_8_3.z ph_sw[3] SC0/vss SC0/vss sg13_lv_nmos ad=95f pd=0.88u as=95f ps=0.88u w=0.5u l=0.13u
X140 vddr pl_sw[2] SC0/buf_16_1.z vddr sg13_lv_pmos ad=0.19p pd=1.38u as=0.19p ps=1.38u w=1u l=0.13u
X141 SC0/buf_8_5.z ph_sw[5] vddr vddr sg13_lv_pmos ad=0.19p pd=1.38u as=0.19p ps=1.38u w=1u l=0.13u
X142 SC0/buf_8_4.z pl_sw[5] SC0/vss SC0/vss sg13_lv_nmos ad=95f pd=0.88u as=95f ps=0.88u w=0.5u l=0.13u
X143 SC0/vss pl_sw[1] SC0/buf_16_2.z SC0/vss sg13_lv_nmos ad=95f pd=0.88u as=95f ps=0.88u w=0.5u l=0.13u
X144 SC0/buf_16_2.z pl_sw[1] vddr vddr sg13_lv_pmos ad=0.19p pd=1.38u as=0.19p ps=1.38u w=1u l=0.13u
X145 SC0/buf_16_1.z pl_sw[2] vddr vddr sg13_lv_pmos ad=0.34p pd=2.68u as=0.19p ps=1.38u w=1u l=0.13u
X146 vddr pl_sw[0] SC0/buf_32_0.z vddr sg13_lv_pmos ad=0.19p pd=1.38u as=0.19p ps=1.38u w=1u l=0.13u
X147 SC0/buf_16_3.z ph_sw[1] vddr vddr sg13_lv_pmos ad=0.19p pd=1.38u as=0.19p ps=1.38u w=1u l=0.13u
X148 SC0/buf_32_1.z ph_sw[0] SC0/vss SC0/vss sg13_lv_nmos ad=95f pd=0.88u as=95f ps=0.88u w=0.5u l=0.13u
X149 SC0/buf_4_0.z pl_sw[7] vddr vddr sg13_lv_pmos ad=0.34p pd=2.68u as=0.19p ps=1.38u w=1u l=0.13u
X150 SC0/buf_8_0.z pl_sw[4] vddr vddr sg13_lv_pmos ad=0.19p pd=1.38u as=0.19p ps=1.38u w=1u l=0.13u
X151 SC0/buf_32_0.z pl_sw[0] vddr vddr sg13_lv_pmos ad=0.19p pd=1.38u as=0.19p ps=1.38u w=1u l=0.13u
X152 SC0/vss pl_sw[2] SC0/buf_16_1.z SC0/vss sg13_lv_nmos ad=95f pd=0.88u as=95f ps=0.88u w=0.5u l=0.13u
X153 SC0/vss pl_sw[0] SC0/buf_32_0.z SC0/vss sg13_lv_nmos ad=95f pd=0.88u as=95f ps=0.88u w=0.5u l=0.13u
X154 SC0/buf_4_2.z ph_sw[7] vddr vddr sg13_lv_pmos ad=0.34p pd=2.68u as=0.19p ps=1.38u w=1u l=0.13u
X155 SC0/buf_16_0.z ph_sw[2] SC0/vss SC0/vss sg13_lv_nmos ad=95f pd=0.88u as=95f ps=0.88u w=0.5u l=0.13u
X156 SC0/buf_16_0.z ph_sw[2] SC0/vss SC0/vss sg13_lv_nmos ad=95f pd=0.88u as=95f ps=0.88u w=0.5u l=0.13u
X157 SC0/vss ph_sw[0] SC0/buf_32_1.z SC0/vss sg13_lv_nmos ad=95f pd=0.88u as=95f ps=0.88u w=0.5u l=0.13u
X158 SC0/vss pl_sw[2] SC0/buf_16_1.z SC0/vss sg13_lv_nmos ad=95f pd=0.88u as=95f ps=0.88u w=0.5u l=0.13u
X159 SC0/buf_2_3.z ph_sw[9] SC0/vss SC0/vss sg13_lv_nmos ad=0.17p pd=1.68u as=95f ps=0.88u w=0.5u l=0.13u
X160 SC0/buf_32_0.z pl_sw[0] vddr vddr sg13_lv_pmos ad=0.19p pd=1.38u as=0.19p ps=1.38u w=1u l=0.13u
X161 vddr pl_sw[0] SC0/buf_32_0.z vddr sg13_lv_pmos ad=0.19p pd=1.38u as=0.19p ps=1.38u w=1u l=0.13u
X162 SC0/vss pl_sw[9] SC0/buf_2_2.z SC0/vss sg13_lv_nmos ad=95f pd=0.88u as=0.17p ps=1.68u w=0.5u l=0.13u
X163 SC0/buf_32_1.z ph_sw[0] vddr vddr sg13_lv_pmos ad=0.19p pd=1.38u as=0.19p ps=1.38u w=1u l=0.13u
X164 SC0/buf_32_0.z pl_sw[0] SC0/vss SC0/vss sg13_lv_nmos ad=95f pd=0.88u as=95f ps=0.88u w=0.5u l=0.13u
X165 SC0/vss ph_sw[4] SC0/buf_8_2.z SC0/vss sg13_lv_nmos ad=95f pd=0.88u as=95f ps=0.88u w=0.5u l=0.13u
X166 SC0/buf_32_1.z ph_sw[0] SC0/vss SC0/vss sg13_lv_nmos ad=95f pd=0.88u as=95f ps=0.88u w=0.5u l=0.13u
X167 vddr ph_sw[2] SC0/buf_16_0.z vddr sg13_lv_pmos ad=0.19p pd=1.38u as=0.19p ps=1.38u w=1u l=0.13u
X168 vddr ph_sw[1] SC0/buf_16_3.z vddr sg13_lv_pmos ad=0.19p pd=1.38u as=0.19p ps=1.38u w=1u l=0.13u
X169 SC0/buf_16_3.z ph_sw[1] SC0/vss SC0/vss sg13_lv_nmos ad=0.17p pd=1.68u as=95f ps=0.88u w=0.5u l=0.13u
X170 SC0/vss pl_sw[4] SC0/buf_8_0.z SC0/vss sg13_lv_nmos ad=95f pd=0.88u as=95f ps=0.88u w=0.5u l=0.13u
X171 vddr ph_sw[0] SC0/buf_32_1.z vddr sg13_lv_pmos ad=0.19p pd=1.38u as=0.19p ps=1.38u w=1u l=0.13u
X172 SC0/vss pl_sw[0] SC0/buf_32_0.z SC0/vss sg13_lv_nmos ad=95f pd=0.88u as=95f ps=0.88u w=0.5u l=0.13u
X173 vddr pl_sw[8] SC0/buf_2_1.z vddr sg13_lv_pmos ad=0.19p pd=1.38u as=0.34p ps=2.68u w=1u l=0.13u
X174 SC0/buf_16_0.z ph_sw[2] SC0/vss SC0/vss sg13_lv_nmos ad=95f pd=0.88u as=95f ps=0.88u w=0.5u l=0.13u
X175 SC0/vss ph_sw[0] SC0/buf_32_1.z SC0/vss sg13_lv_nmos ad=95f pd=0.88u as=95f ps=0.88u w=0.5u l=0.13u
X176 SC0/vss pl_sw[3] SC0/buf_8_1.z SC0/vss sg13_lv_nmos ad=95f pd=0.88u as=0.17p ps=1.68u w=0.5u l=0.13u
X177 SC0/buf_4_3.z pl_sw[6] SC0/vss SC0/vss sg13_lv_nmos ad=0.17p pd=1.68u as=95f ps=0.88u w=0.5u l=0.13u
X178 SC0/buf_8_1.z pl_sw[3] vddr vddr sg13_lv_pmos ad=0.19p pd=1.38u as=0.19p ps=1.38u w=1u l=0.13u
X179 SC0/vss pl_sw[1] SC0/buf_16_2.z SC0/vss sg13_lv_nmos ad=95f pd=0.88u as=0.17p ps=1.68u w=0.5u l=0.13u
X180 SC0/buf_32_1.z ph_sw[0] vddr vddr sg13_lv_pmos ad=0.19p pd=1.38u as=0.19p ps=1.38u w=1u l=0.13u
X181 SC0/vss ph_sw[1] SC0/buf_16_3.z SC0/vss sg13_lv_nmos ad=95f pd=0.88u as=95f ps=0.88u w=0.5u l=0.13u
X182 SC0/buf_32_0.z pl_sw[0] SC0/vss SC0/vss sg13_lv_nmos ad=95f pd=0.88u as=95f ps=0.88u w=0.5u l=0.13u
X183 SC0/vss ph_sw[4] SC0/buf_8_2.z SC0/vss sg13_lv_nmos ad=95f pd=0.88u as=95f ps=0.88u w=0.5u l=0.13u
X184 SC0/buf_32_1.z ph_sw[0] SC0/vss SC0/vss sg13_lv_nmos ad=95f pd=0.88u as=95f ps=0.88u w=0.5u l=0.13u
X185 SC0/buf_32_1.z ph_sw[0] vddr vddr sg13_lv_pmos ad=0.19p pd=1.38u as=0.19p ps=1.38u w=1u l=0.13u
X186 vddr ph_sw[2] SC0/buf_16_0.z vddr sg13_lv_pmos ad=0.19p pd=1.38u as=0.19p ps=1.38u w=1u l=0.13u
X187 SC0/vss pl_sw[1] SC0/buf_16_2.z SC0/vss sg13_lv_nmos ad=95f pd=0.88u as=95f ps=0.88u w=0.5u l=0.13u
X188 SC0/buf_16_2.z pl_sw[1] SC0/vss SC0/vss sg13_lv_nmos ad=95f pd=0.88u as=95f ps=0.88u w=0.5u l=0.13u
X189 SC0/vss ph_sw[3] SC0/buf_8_3.z SC0/vss sg13_lv_nmos ad=95f pd=0.88u as=95f ps=0.88u w=0.5u l=0.13u
X190 SC0/vss pl_sw[0] SC0/buf_32_0.z SC0/vss sg13_lv_nmos ad=95f pd=0.88u as=95f ps=0.88u w=0.5u l=0.13u
X191 vddr pl_sw[1] SC0/buf_16_2.z vddr sg13_lv_pmos ad=0.19p pd=1.38u as=0.19p ps=1.38u w=1u l=0.13u
X192 SC0/buf_8_3.z ph_sw[3] vddr vddr sg13_lv_pmos ad=0.19p pd=1.38u as=0.19p ps=1.38u w=1u l=0.13u
X193 vddr pl_sw[2] SC0/buf_16_1.z vddr sg13_lv_pmos ad=0.19p pd=1.38u as=0.19p ps=1.38u w=1u l=0.13u
X194 SC0/buf_32_0.z pl_sw[0] vddr vddr sg13_lv_pmos ad=0.19p pd=1.38u as=0.19p ps=1.38u w=1u l=0.13u
X195 SC0/buf_8_2.z ph_sw[4] vddr vddr sg13_lv_pmos ad=0.34p pd=2.68u as=0.19p ps=1.38u w=1u l=0.13u
X196 SC0/buf_4_2.z ph_sw[7] SC0/vss SC0/vss sg13_lv_nmos ad=95f pd=0.88u as=95f ps=0.88u w=0.5u l=0.13u
X197 SC0/vss pl_sw[2] SC0/buf_16_1.z SC0/vss sg13_lv_nmos ad=95f pd=0.88u as=0.17p ps=1.68u w=0.5u l=0.13u
X198 vddr ph_sw[1] SC0/buf_16_3.z vddr sg13_lv_pmos ad=0.19p pd=1.38u as=0.19p ps=1.38u w=1u l=0.13u
X199 vddr pl_sw[9] SC0/buf_2_2.z vddr sg13_lv_pmos ad=0.19p pd=1.38u as=0.34p ps=2.68u w=1u l=0.13u
X200 SC0/buf_4_1.z ph_sw[6] SC0/vss SC0/vss sg13_lv_nmos ad=0.17p pd=1.68u as=95f ps=0.88u w=0.5u l=0.13u
X201 SC0/buf_32_1.z ph_sw[0] vddr vddr sg13_lv_pmos ad=0.19p pd=1.38u as=0.19p ps=1.38u w=1u l=0.13u
X202 vddr pl_sw[7] SC0/buf_4_0.z vddr sg13_lv_pmos ad=0.19p pd=1.38u as=0.34p ps=2.68u w=1u l=0.13u
X203 SC0/buf_32_0.z pl_sw[0] SC0/vss SC0/vss sg13_lv_nmos ad=95f pd=0.88u as=95f ps=0.88u w=0.5u l=0.13u
X204 SC0/vss ph_sw[5] SC0/buf_8_5.z SC0/vss sg13_lv_nmos ad=95f pd=0.88u as=95f ps=0.88u w=0.5u l=0.13u
X205 vddr pl_sw[0] SC0/buf_32_0.z vddr sg13_lv_pmos ad=0.19p pd=1.38u as=0.19p ps=1.38u w=1u l=0.13u
X206 SC0/buf_16_1.z pl_sw[2] SC0/vss SC0/vss sg13_lv_nmos ad=95f pd=0.88u as=95f ps=0.88u w=0.5u l=0.13u
X207 SC0/vss ph_sw[3] SC0/buf_8_3.z SC0/vss sg13_lv_nmos ad=95f pd=0.88u as=0.17p ps=1.68u w=0.5u l=0.13u
X208 SC0/buf_16_1.z pl_sw[2] vddr vddr sg13_lv_pmos ad=0.19p pd=1.38u as=0.19p ps=1.38u w=1u l=0.13u
X209 SC0/buf_16_2.z pl_sw[1] vddr vddr sg13_lv_pmos ad=0.19p pd=1.38u as=0.19p ps=1.38u w=1u l=0.13u
X210 SC0/vss pl_sw[5] SC0/buf_8_4.z SC0/vss sg13_lv_nmos ad=95f pd=0.88u as=95f ps=0.88u w=0.5u l=0.13u
X211 SC0/buf_8_0.z pl_sw[4] SC0/vss SC0/vss sg13_lv_nmos ad=0.17p pd=1.68u as=95f ps=0.88u w=0.5u l=0.13u
X212 SC0/buf_8_1.z pl_sw[3] SC0/vss SC0/vss sg13_lv_nmos ad=95f pd=0.88u as=95f ps=0.88u w=0.5u l=0.13u
X213 SC0/buf_32_0.z pl_sw[0] vddr vddr sg13_lv_pmos ad=0.19p pd=1.38u as=0.19p ps=1.38u w=1u l=0.13u
X214 SC0/buf_8_2.z ph_sw[4] vddr vddr sg13_lv_pmos ad=0.19p pd=1.38u as=0.19p ps=1.38u w=1u l=0.13u
X215 vddr ph_sw[0] SC0/buf_32_1.z vddr sg13_lv_pmos ad=0.19p pd=1.38u as=0.19p ps=1.38u w=1u l=0.13u
X216 SC0/buf_8_4.z pl_sw[5] vddr vddr sg13_lv_pmos ad=0.19p pd=1.38u as=0.19p ps=1.38u w=1u l=0.13u
X217 vddr ph_sw[10] SC0/buf_1_1.z vddr sg13_lv_pmos ad=0.34p pd=2.68u as=0.34p ps=2.68u w=1u l=0.13u
X218 SC0/buf_16_0.z ph_sw[2] vddr vddr sg13_lv_pmos ad=0.19p pd=1.38u as=0.19p ps=1.38u w=1u l=0.13u
X219 SC0/vss ph_sw[5] SC0/buf_8_5.z SC0/vss sg13_lv_nmos ad=95f pd=0.88u as=95f ps=0.88u w=0.5u l=0.13u
X220 vddr pl_sw[0] SC0/buf_32_0.z vddr sg13_lv_pmos ad=0.19p pd=1.38u as=0.19p ps=1.38u w=1u l=0.13u
X221 SC0/vss ph_sw[1] SC0/buf_16_3.z SC0/vss sg13_lv_nmos ad=95f pd=0.88u as=95f ps=0.88u w=0.5u l=0.13u
X222 SC0/vss ph_sw[2] SC0/buf_16_0.z SC0/vss sg13_lv_nmos ad=95f pd=0.88u as=95f ps=0.88u w=0.5u l=0.13u
X223 SC0/buf_32_1.z ph_sw[0] SC0/vss SC0/vss sg13_lv_nmos ad=95f pd=0.88u as=95f ps=0.88u w=0.5u l=0.13u
X224 SC0/vss pl_sw[8] SC0/buf_2_1.z SC0/vss sg13_lv_nmos ad=95f pd=0.88u as=0.17p ps=1.68u w=0.5u l=0.13u
X225 SC0/buf_32_0.z pl_sw[0] vddr vddr sg13_lv_pmos ad=0.19p pd=1.38u as=0.19p ps=1.38u w=1u l=0.13u
X226 SC0/vss pl_sw[6] SC0/buf_4_3.z SC0/vss sg13_lv_nmos ad=95f pd=0.88u as=0.17p ps=1.68u w=0.5u l=0.13u
X227 vddr pl_sw[3] SC0/buf_8_1.z vddr sg13_lv_pmos ad=0.19p pd=1.38u as=0.19p ps=1.38u w=1u l=0.13u
X228 vddr ph_sw[0] SC0/buf_32_1.z vddr sg13_lv_pmos ad=0.19p pd=1.38u as=0.34p ps=2.68u w=1u l=0.13u
X229 vddr ph_sw[7] SC0/buf_4_2.z vddr sg13_lv_pmos ad=0.19p pd=1.38u as=0.34p ps=2.68u w=1u l=0.13u
X230 SC0/vss pl_sw[0] SC0/buf_32_0.z SC0/vss sg13_lv_nmos ad=95f pd=0.88u as=95f ps=0.88u w=0.5u l=0.13u
X231 SC0/vss ph_sw[0] SC0/buf_32_1.z SC0/vss sg13_lv_nmos ad=95f pd=0.88u as=95f ps=0.88u w=0.5u l=0.13u
X232 SC0/buf_8_2.z ph_sw[4] SC0/vss SC0/vss sg13_lv_nmos ad=95f pd=0.88u as=95f ps=0.88u w=0.5u l=0.13u
X233 SC0/buf_32_1.z ph_sw[0] SC0/vss SC0/vss sg13_lv_nmos ad=95f pd=0.88u as=95f ps=0.88u w=0.5u l=0.13u
X234 SC0/buf_4_3.z pl_sw[6] vddr vddr sg13_lv_pmos ad=0.34p pd=2.68u as=0.19p ps=1.38u w=1u l=0.13u
X235 SC0/vss pl_sw[1] SC0/buf_16_2.z SC0/vss sg13_lv_nmos ad=95f pd=0.88u as=95f ps=0.88u w=0.5u l=0.13u
X236 SC0/buf_32_1.z ph_sw[0] vddr vddr sg13_lv_pmos ad=0.19p pd=1.38u as=0.19p ps=1.38u w=1u l=0.13u
X237 SC0/buf_16_2.z pl_sw[1] vddr vddr sg13_lv_pmos ad=0.19p pd=1.38u as=0.19p ps=1.38u w=1u l=0.13u
X238 SC0/buf_32_0.z pl_sw[0] SC0/vss SC0/vss sg13_lv_nmos ad=95f pd=0.88u as=95f ps=0.88u w=0.5u l=0.13u
X239 SC0/vss pl_sw[7] SC0/buf_4_0.z SC0/vss sg13_lv_nmos ad=95f pd=0.88u as=95f ps=0.88u w=0.5u l=0.13u
X240 SC0/buf_8_4.z pl_sw[5] vddr vddr sg13_lv_pmos ad=0.19p pd=1.38u as=0.19p ps=1.38u w=1u l=0.13u
X241 SC0/buf_16_3.z ph_sw[1] vddr vddr sg13_lv_pmos ad=0.19p pd=1.38u as=0.19p ps=1.38u w=1u l=0.13u
X242 vddr ph_sw[0] SC0/buf_32_1.z vddr sg13_lv_pmos ad=0.19p pd=1.38u as=0.19p ps=1.38u w=1u l=0.13u
X243 SC0/buf_16_3.z ph_sw[1] SC0/vss SC0/vss sg13_lv_nmos ad=95f pd=0.88u as=95f ps=0.88u w=0.5u l=0.13u
X244 vddr pl_sw[4] SC0/buf_8_0.z vddr sg13_lv_pmos ad=0.19p pd=1.38u as=0.34p ps=2.68u w=1u l=0.13u
X245 SC0/buf_16_0.z ph_sw[2] vddr vddr sg13_lv_pmos ad=0.19p pd=1.38u as=0.19p ps=1.38u w=1u l=0.13u
X246 SC0/vss pl_sw[2] SC0/buf_16_1.z SC0/vss sg13_lv_nmos ad=95f pd=0.88u as=95f ps=0.88u w=0.5u l=0.13u
X247 SC0/buf_8_5.z ph_sw[5] vddr vddr sg13_lv_pmos ad=0.19p pd=1.38u as=0.19p ps=1.38u w=1u l=0.13u
X248 SC0/buf_8_4.z pl_sw[5] SC0/vss SC0/vss sg13_lv_nmos ad=0.17p pd=1.68u as=95f ps=0.88u w=0.5u l=0.13u
X249 vddr pl_sw[2] SC0/buf_16_1.z vddr sg13_lv_pmos ad=0.19p pd=1.38u as=0.19p ps=1.38u w=1u l=0.13u
X250 SC0/vss pl_sw[1] SC0/buf_16_2.z SC0/vss sg13_lv_nmos ad=95f pd=0.88u as=95f ps=0.88u w=0.5u l=0.13u
X251 SC0/vss pl_sw[4] SC0/buf_8_0.z SC0/vss sg13_lv_nmos ad=95f pd=0.88u as=95f ps=0.88u w=0.5u l=0.13u
X252 SC0/buf_16_2.z pl_sw[1] vddr vddr sg13_lv_pmos ad=0.19p pd=1.38u as=0.19p ps=1.38u w=1u l=0.13u
X253 vddr ph_sw[4] SC0/buf_8_2.z vddr sg13_lv_pmos ad=0.19p pd=1.38u as=0.19p ps=1.38u w=1u l=0.13u
X254 SC0/buf_16_3.z ph_sw[1] vddr vddr sg13_lv_pmos ad=0.19p pd=1.38u as=0.19p ps=1.38u w=1u l=0.13u
X255 SC0/vss ph_sw[2] SC0/buf_16_0.z SC0/vss sg13_lv_nmos ad=95f pd=0.88u as=0.17p ps=1.68u w=0.5u l=0.13u
X256 SC0/buf_32_1.z ph_sw[0] SC0/vss SC0/vss sg13_lv_nmos ad=95f pd=0.88u as=95f ps=0.88u w=0.5u l=0.13u
X257 SC0/buf_8_0.z pl_sw[4] vddr vddr sg13_lv_pmos ad=0.34p pd=2.68u as=0.19p ps=1.38u w=1u l=0.13u
X258 SC0/buf_8_5.z ph_sw[5] SC0/vss SC0/vss sg13_lv_nmos ad=95f pd=0.88u as=95f ps=0.88u w=0.5u l=0.13u
X259 SC0/buf_32_0.z pl_sw[0] vddr vddr sg13_lv_pmos ad=0.19p pd=1.38u as=0.19p ps=1.38u w=1u l=0.13u
X260 SC0/vss pl_sw[2] SC0/buf_16_1.z SC0/vss sg13_lv_nmos ad=95f pd=0.88u as=95f ps=0.88u w=0.5u l=0.13u
X261 SC0/vss pl_sw[0] SC0/buf_32_0.z SC0/vss sg13_lv_nmos ad=95f pd=0.88u as=95f ps=0.88u w=0.5u l=0.13u
X262 SC0/buf_16_0.z ph_sw[2] SC0/vss SC0/vss sg13_lv_nmos ad=95f pd=0.88u as=95f ps=0.88u w=0.5u l=0.13u
X263 SC0/buf_16_0.z ph_sw[2] SC0/vss SC0/vss sg13_lv_nmos ad=95f pd=0.88u as=95f ps=0.88u w=0.5u l=0.13u
X264 SC0/vss ph_sw[0] SC0/buf_32_1.z SC0/vss sg13_lv_nmos ad=95f pd=0.88u as=95f ps=0.88u w=0.5u l=0.13u
X265 vddr pl_sw[10] SC0/buf_1_0.z vddr sg13_lv_pmos ad=0.34p pd=2.68u as=0.34p ps=2.68u w=1u l=0.13u
X266 SC0/vss ph_sw[6] SC0/buf_4_1.z SC0/vss sg13_lv_nmos ad=95f pd=0.88u as=0.17p ps=1.68u w=0.5u l=0.13u
X267 SC0/vss pl_sw[2] SC0/buf_16_1.z SC0/vss sg13_lv_nmos ad=95f pd=0.88u as=95f ps=0.88u w=0.5u l=0.13u
X268 SC0/buf_32_0.z pl_sw[0] vddr vddr sg13_lv_pmos ad=0.19p pd=1.38u as=0.19p ps=1.38u w=1u l=0.13u
X269 vddr pl_sw[0] SC0/buf_32_0.z vddr sg13_lv_pmos ad=0.19p pd=1.38u as=0.19p ps=1.38u w=1u l=0.13u
X270 vddr ph_sw[4] SC0/buf_8_2.z vddr sg13_lv_pmos ad=0.19p pd=1.38u as=0.34p ps=2.68u w=1u l=0.13u
X271 SC0/buf_8_1.z pl_sw[3] vddr vddr sg13_lv_pmos ad=0.19p pd=1.38u as=0.19p ps=1.38u w=1u l=0.13u
X272 SC0/buf_32_0.z pl_sw[0] SC0/vss SC0/vss sg13_lv_nmos ad=95f pd=0.88u as=95f ps=0.88u w=0.5u l=0.13u
X273 SC0/buf_32_1.z ph_sw[0] SC0/vss SC0/vss sg13_lv_nmos ad=95f pd=0.88u as=95f ps=0.88u w=0.5u l=0.13u
X274 SC0/buf_4_2.z ph_sw[7] SC0/vss SC0/vss sg13_lv_nmos ad=0.17p pd=1.68u as=95f ps=0.88u w=0.5u l=0.13u
X275 vddr ph_sw[1] SC0/buf_16_3.z vddr sg13_lv_pmos ad=0.19p pd=1.38u as=0.19p ps=1.38u w=1u l=0.13u
X276 vddr ph_sw[0] SC0/buf_32_1.z vddr sg13_lv_pmos ad=0.19p pd=1.38u as=0.19p ps=1.38u w=1u l=0.13u
X277 SC0/vss ph_sw[3] SC0/buf_8_3.z SC0/vss sg13_lv_nmos ad=95f pd=0.88u as=95f ps=0.88u w=0.5u l=0.13u
X278 vddr pl_sw[6] SC0/buf_4_3.z vddr sg13_lv_pmos ad=0.19p pd=1.38u as=0.34p ps=2.68u w=1u l=0.13u
X279 SC0/vss pl_sw[0] SC0/buf_32_0.z SC0/vss sg13_lv_nmos ad=95f pd=0.88u as=95f ps=0.88u w=0.5u l=0.13u
X280 SC0/buf_8_3.z ph_sw[3] vddr vddr sg13_lv_pmos ad=0.34p pd=2.68u as=0.19p ps=1.38u w=1u l=0.13u
X281 SC0/vss pl_sw[3] SC0/buf_8_1.z SC0/vss sg13_lv_nmos ad=95f pd=0.88u as=95f ps=0.88u w=0.5u l=0.13u
X282 SC0/buf_32_1.z ph_sw[0] vddr vddr sg13_lv_pmos ad=0.19p pd=1.38u as=0.19p ps=1.38u w=1u l=0.13u
X283 SC0/vss ph_sw[1] SC0/buf_16_3.z SC0/vss sg13_lv_nmos ad=95f pd=0.88u as=95f ps=0.88u w=0.5u l=0.13u
X284 SC0/buf_32_1.z ph_sw[0] SC0/vss SC0/vss sg13_lv_nmos ad=95f pd=0.88u as=95f ps=0.88u w=0.5u l=0.13u
X285 SC0/buf_32_1.z ph_sw[0] vddr vddr sg13_lv_pmos ad=0.34p pd=2.68u as=0.19p ps=1.38u w=1u l=0.13u
X286 vddr ph_sw[2] SC0/buf_16_0.z vddr sg13_lv_pmos ad=0.19p pd=1.38u as=0.19p ps=1.38u w=1u l=0.13u
X287 SC0/buf_4_1.z ph_sw[6] vddr vddr sg13_lv_pmos ad=0.19p pd=1.38u as=0.19p ps=1.38u w=1u l=0.13u
X288 SC0/vss pl_sw[1] SC0/buf_16_2.z SC0/vss sg13_lv_nmos ad=95f pd=0.88u as=95f ps=0.88u w=0.5u l=0.13u
X289 SC0/vss ph_sw[3] SC0/buf_8_3.z SC0/vss sg13_lv_nmos ad=95f pd=0.88u as=95f ps=0.88u w=0.5u l=0.13u
X290 SC0/buf_16_1.z pl_sw[2] vddr vddr sg13_lv_pmos ad=0.19p pd=1.38u as=0.19p ps=1.38u w=1u l=0.13u
X291 SC0/buf_16_2.z pl_sw[1] SC0/vss SC0/vss sg13_lv_nmos ad=95f pd=0.88u as=95f ps=0.88u w=0.5u l=0.13u
X292 SC0/buf_8_3.z ph_sw[3] vddr vddr sg13_lv_pmos ad=0.19p pd=1.38u as=0.19p ps=1.38u w=1u l=0.13u
X293 SC0/vss pl_sw[5] SC0/buf_8_4.z SC0/vss sg13_lv_nmos ad=95f pd=0.88u as=95f ps=0.88u w=0.5u l=0.13u
X294 vddr pl_sw[1] SC0/buf_16_2.z vddr sg13_lv_pmos ad=0.19p pd=1.38u as=0.19p ps=1.38u w=1u l=0.13u
X295 vddr pl_sw[2] SC0/buf_16_1.z vddr sg13_lv_pmos ad=0.19p pd=1.38u as=0.19p ps=1.38u w=1u l=0.13u
X296 SC0/buf_32_0.z pl_sw[0] vddr vddr sg13_lv_pmos ad=0.19p pd=1.38u as=0.19p ps=1.38u w=1u l=0.13u
X297 vddr ph_sw[1] SC0/buf_16_3.z vddr sg13_lv_pmos ad=0.19p pd=1.38u as=0.19p ps=1.38u w=1u l=0.13u
X298 SC0/vss ph_sw[0] SC0/buf_32_1.z SC0/vss sg13_lv_nmos ad=95f pd=0.88u as=95f ps=0.88u w=0.5u l=0.13u
X299 vddr pl_sw[7] SC0/buf_4_0.z vddr sg13_lv_pmos ad=0.19p pd=1.38u as=0.19p ps=1.38u w=1u l=0.13u
X300 SC0/buf_32_0.z pl_sw[0] SC0/vss SC0/vss sg13_lv_nmos ad=0.17p pd=1.68u as=95f ps=0.88u w=0.5u l=0.13u
X301 SC0/buf_2_0.z ph_sw[8] vddr vddr sg13_lv_pmos ad=0.34p pd=2.68u as=0.19p ps=1.38u w=1u l=0.13u
X302 vddr pl_sw[4] SC0/buf_8_0.z vddr sg13_lv_pmos ad=0.19p pd=1.38u as=0.19p ps=1.38u w=1u l=0.13u
X303 vddr pl_sw[0] SC0/buf_32_0.z vddr sg13_lv_pmos ad=0.19p pd=1.38u as=0.19p ps=1.38u w=1u l=0.13u
X304 SC0/vss ph_sw[10] SC0/buf_1_1.z SC0/vss sg13_lv_nmos ad=0.17p pd=1.68u as=0.17p ps=1.68u w=0.5u l=0.13u
X305 SC0/buf_16_1.z pl_sw[2] SC0/vss SC0/vss sg13_lv_nmos ad=95f pd=0.88u as=95f ps=0.88u w=0.5u l=0.13u
X306 SC0/buf_32_0.z pl_sw[0] SC0/vss SC0/vss sg13_lv_nmos ad=95f pd=0.88u as=95f ps=0.88u w=0.5u l=0.13u
X307 SC0/vss ph_sw[2] SC0/buf_16_0.z SC0/vss sg13_lv_nmos ad=95f pd=0.88u as=95f ps=0.88u w=0.5u l=0.13u
X308 SC0/buf_16_1.z pl_sw[2] vddr vddr sg13_lv_pmos ad=0.19p pd=1.38u as=0.19p ps=1.38u w=1u l=0.13u
X309 SC0/buf_16_2.z pl_sw[1] vddr vddr sg13_lv_pmos ad=0.34p pd=2.68u as=0.19p ps=1.38u w=1u l=0.13u
X310 SC0/buf_16_1.z pl_sw[2] SC0/vss SC0/vss sg13_lv_nmos ad=95f pd=0.88u as=95f ps=0.88u w=0.5u l=0.13u
X311 SC0/vss ph_sw[9] SC0/buf_2_3.z SC0/vss sg13_lv_nmos ad=95f pd=0.88u as=0.17p ps=1.68u w=0.5u l=0.13u
X312 SC0/buf_8_1.z pl_sw[3] SC0/vss SC0/vss sg13_lv_nmos ad=0.17p pd=1.68u as=95f ps=0.88u w=0.5u l=0.13u
X313 SC0/vss pl_sw[10] SC0/buf_1_0.z SC0/vss sg13_lv_nmos ad=0.17p pd=1.68u as=0.17p ps=1.68u w=0.5u l=0.13u
X314 SC0/buf_32_0.z pl_sw[0] vddr vddr sg13_lv_pmos ad=0.19p pd=1.38u as=0.19p ps=1.38u w=1u l=0.13u
X315 vddr ph_sw[0] SC0/buf_32_1.z vddr sg13_lv_pmos ad=0.19p pd=1.38u as=0.19p ps=1.38u w=1u l=0.13u
X316 SC0/buf_8_4.z pl_sw[5] vddr vddr sg13_lv_pmos ad=0.34p pd=2.68u as=0.19p ps=1.38u w=1u l=0.13u
X317 SC0/vss pl_sw[0] SC0/buf_32_0.z SC0/vss sg13_lv_nmos ad=95f pd=0.88u as=95f ps=0.88u w=0.5u l=0.13u
X318 SC0/vss ph_sw[0] SC0/buf_32_1.z SC0/vss sg13_lv_nmos ad=95f pd=0.88u as=0.17p ps=1.68u w=0.5u l=0.13u
X319 SC0/buf_16_0.z ph_sw[2] vddr vddr sg13_lv_pmos ad=0.19p pd=1.38u as=0.19p ps=1.38u w=1u l=0.13u
X320 SC0/buf_16_3.z ph_sw[1] vddr vddr sg13_lv_pmos ad=0.19p pd=1.38u as=0.19p ps=1.38u w=1u l=0.13u
X321 SC0/vss ph_sw[1] SC0/buf_16_3.z SC0/vss sg13_lv_nmos ad=95f pd=0.88u as=95f ps=0.88u w=0.5u l=0.13u
X322 SC0/buf_32_1.z ph_sw[0] vddr vddr sg13_lv_pmos ad=0.19p pd=1.38u as=0.19p ps=1.38u w=1u l=0.13u
X323 SC0/buf_8_0.z pl_sw[4] SC0/vss SC0/vss sg13_lv_nmos ad=95f pd=0.88u as=95f ps=0.88u w=0.5u l=0.13u
X324 SC0/buf_32_0.z pl_sw[0] SC0/vss SC0/vss sg13_lv_nmos ad=95f pd=0.88u as=95f ps=0.88u w=0.5u l=0.13u
X325 SC0/vss ph_sw[2] SC0/buf_16_0.z SC0/vss sg13_lv_nmos ad=95f pd=0.88u as=95f ps=0.88u w=0.5u l=0.13u
X326 SC0/buf_32_1.z ph_sw[0] SC0/vss SC0/vss sg13_lv_nmos ad=95f pd=0.88u as=95f ps=0.88u w=0.5u l=0.13u
X327 SC0/vss pl_sw[6] SC0/buf_4_3.z SC0/vss sg13_lv_nmos ad=95f pd=0.88u as=95f ps=0.88u w=0.5u l=0.13u
X328 SC0/buf_32_0.z pl_sw[0] vddr vddr sg13_lv_pmos ad=0.19p pd=1.38u as=0.19p ps=1.38u w=1u l=0.13u
X329 vddr pl_sw[3] SC0/buf_8_1.z vddr sg13_lv_pmos ad=0.19p pd=1.38u as=0.34p ps=2.68u w=1u l=0.13u
X330 vddr ph_sw[0] SC0/buf_32_1.z vddr sg13_lv_pmos ad=0.19p pd=1.38u as=0.19p ps=1.38u w=1u l=0.13u
X331 vddr pl_sw[1] SC0/buf_16_2.z vddr sg13_lv_pmos ad=0.19p pd=1.38u as=0.34p ps=2.68u w=1u l=0.13u
X332 vddr ph_sw[7] SC0/buf_4_2.z vddr sg13_lv_pmos ad=0.19p pd=1.38u as=0.19p ps=1.38u w=1u l=0.13u
X333 SC0/buf_16_3.z ph_sw[1] SC0/vss SC0/vss sg13_lv_nmos ad=95f pd=0.88u as=95f ps=0.88u w=0.5u l=0.13u
X334 SC0/vss pl_sw[0] SC0/buf_32_0.z SC0/vss sg13_lv_nmos ad=95f pd=0.88u as=95f ps=0.88u w=0.5u l=0.13u
X335 SC0/buf_8_2.z ph_sw[4] SC0/vss SC0/vss sg13_lv_nmos ad=95f pd=0.88u as=95f ps=0.88u w=0.5u l=0.13u
X336 SC0/vss ph_sw[0] SC0/buf_32_1.z SC0/vss sg13_lv_nmos ad=95f pd=0.88u as=95f ps=0.88u w=0.5u l=0.13u
X337 vddr ph_sw[0] SC0/buf_32_1.z vddr sg13_lv_pmos ad=0.19p pd=1.38u as=0.19p ps=1.38u w=1u l=0.13u
X338 SC0/buf_16_0.z ph_sw[2] vddr vddr sg13_lv_pmos ad=0.19p pd=1.38u as=0.19p ps=1.38u w=1u l=0.13u
X339 SC0/buf_32_1.z ph_sw[0] SC0/vss SC0/vss sg13_lv_nmos ad=0.17p pd=1.68u as=95f ps=0.88u w=0.5u l=0.13u
X340 vddr ph_sw[1] SC0/buf_16_3.z vddr sg13_lv_pmos ad=0.19p pd=1.38u as=0.34p ps=2.68u w=1u l=0.13u
X341 SC0/buf_16_2.z pl_sw[1] SC0/vss SC0/vss sg13_lv_nmos ad=95f pd=0.88u as=95f ps=0.88u w=0.5u l=0.13u
X342 SC0/buf_8_5.z ph_sw[5] vddr vddr sg13_lv_pmos ad=0.34p pd=2.68u as=0.19p ps=1.38u w=1u l=0.13u
X343 SC0/vss pl_sw[1] SC0/buf_16_2.z SC0/vss sg13_lv_nmos ad=95f pd=0.88u as=95f ps=0.88u w=0.5u l=0.13u
X344 SC0/buf_32_1.z ph_sw[0] vddr vddr sg13_lv_pmos ad=0.19p pd=1.38u as=0.19p ps=1.38u w=1u l=0.13u
X345 SC0/buf_8_3.z ph_sw[3] SC0/vss SC0/vss sg13_lv_nmos ad=95f pd=0.88u as=95f ps=0.88u w=0.5u l=0.13u
X346 SC0/buf_32_0.z pl_sw[0] SC0/vss SC0/vss sg13_lv_nmos ad=95f pd=0.88u as=95f ps=0.88u w=0.5u l=0.13u
X347 vddr ph_sw[3] SC0/buf_8_3.z vddr sg13_lv_pmos ad=0.19p pd=1.38u as=0.19p ps=1.38u w=1u l=0.13u
X348 SC0/buf_16_2.z pl_sw[1] vddr vddr sg13_lv_pmos ad=0.19p pd=1.38u as=0.19p ps=1.38u w=1u l=0.13u
X349 SC0/buf_16_1.z pl_sw[2] vddr vddr sg13_lv_pmos ad=0.19p pd=1.38u as=0.19p ps=1.38u w=1u l=0.13u
X350 vddr pl_sw[0] SC0/buf_32_0.z vddr sg13_lv_pmos ad=0.19p pd=1.38u as=0.19p ps=1.38u w=1u l=0.13u
X351 vddr ph_sw[4] SC0/buf_8_2.z vddr sg13_lv_pmos ad=0.19p pd=1.38u as=0.19p ps=1.38u w=1u l=0.13u
X352 SC0/vss ph_sw[7] SC0/buf_4_2.z SC0/vss sg13_lv_nmos ad=95f pd=0.88u as=0.17p ps=1.68u w=0.5u l=0.13u
X353 SC0/buf_16_3.z ph_sw[1] vddr vddr sg13_lv_pmos ad=0.19p pd=1.38u as=0.19p ps=1.38u w=1u l=0.13u
X354 vddr ph_sw[0] SC0/buf_32_1.z vddr sg13_lv_pmos ad=0.19p pd=1.38u as=0.19p ps=1.38u w=1u l=0.13u
X355 SC0/buf_16_3.z ph_sw[1] SC0/vss SC0/vss sg13_lv_nmos ad=95f pd=0.88u as=95f ps=0.88u w=0.5u l=0.13u
X356 vddr pl_sw[4] SC0/buf_8_0.z vddr sg13_lv_pmos ad=0.19p pd=1.38u as=0.19p ps=1.38u w=1u l=0.13u
X357 SC0/vss pl_sw[0] SC0/buf_32_0.z SC0/vss sg13_lv_nmos ad=95f pd=0.88u as=95f ps=0.88u w=0.5u l=0.13u
X358 SC0/buf_16_0.z ph_sw[2] vddr vddr sg13_lv_pmos ad=0.19p pd=1.38u as=0.19p ps=1.38u w=1u l=0.13u
X359 SC0/vss pl_sw[2] SC0/buf_16_1.z SC0/vss sg13_lv_nmos ad=95f pd=0.88u as=95f ps=0.88u w=0.5u l=0.13u
X360 SC0/buf_8_5.z ph_sw[5] vddr vddr sg13_lv_pmos ad=0.19p pd=1.38u as=0.19p ps=1.38u w=1u l=0.13u
X361 SC0/vss pl_sw[4] SC0/buf_8_0.z SC0/vss sg13_lv_nmos ad=95f pd=0.88u as=95f ps=0.88u w=0.5u l=0.13u
X362 vddr pl_sw[2] SC0/buf_16_1.z vddr sg13_lv_pmos ad=0.19p pd=1.38u as=0.19p ps=1.38u w=1u l=0.13u
X363 vddr pl_sw[1] SC0/buf_16_2.z vddr sg13_lv_pmos ad=0.19p pd=1.38u as=0.19p ps=1.38u w=1u l=0.13u
X364 vddr ph_sw[3] SC0/buf_8_3.z vddr sg13_lv_pmos ad=0.19p pd=1.38u as=0.34p ps=2.68u w=1u l=0.13u
X365 SC0/buf_8_4.z pl_sw[5] SC0/vss SC0/vss sg13_lv_nmos ad=95f pd=0.88u as=95f ps=0.88u w=0.5u l=0.13u
X366 SC0/vss pl_sw[3] SC0/buf_8_1.z SC0/vss sg13_lv_nmos ad=95f pd=0.88u as=95f ps=0.88u w=0.5u l=0.13u
X367 vddr pl_sw[0] SC0/buf_32_0.z vddr sg13_lv_pmos ad=0.19p pd=1.38u as=0.34p ps=2.68u w=1u l=0.13u
X368 vddr ph_sw[4] SC0/buf_8_2.z vddr sg13_lv_pmos ad=0.19p pd=1.38u as=0.19p ps=1.38u w=1u l=0.13u
X369 SC0/buf_2_3.z ph_sw[9] vddr vddr sg13_lv_pmos ad=0.34p pd=2.68u as=0.19p ps=1.38u w=1u l=0.13u
X370 vddr pl_sw[5] SC0/buf_8_4.z vddr sg13_lv_pmos ad=0.19p pd=1.38u as=0.19p ps=1.38u w=1u l=0.13u
X371 SC0/buf_8_5.z ph_sw[5] SC0/vss SC0/vss sg13_lv_nmos ad=95f pd=0.88u as=95f ps=0.88u w=0.5u l=0.13u
X372 SC0/buf_32_0.z pl_sw[0] vddr vddr sg13_lv_pmos ad=0.19p pd=1.38u as=0.19p ps=1.38u w=1u l=0.13u
X373 SC0/buf_16_3.z ph_sw[1] SC0/vss SC0/vss sg13_lv_nmos ad=95f pd=0.88u as=95f ps=0.88u w=0.5u l=0.13u
X374 SC0/buf_16_0.z ph_sw[2] SC0/vss SC0/vss sg13_lv_nmos ad=0.17p pd=1.68u as=95f ps=0.88u w=0.5u l=0.13u
X375 SC0/buf_16_0.z ph_sw[2] SC0/vss SC0/vss sg13_lv_nmos ad=95f pd=0.88u as=95f ps=0.88u w=0.5u l=0.13u
X376 SC0/vss ph_sw[6] SC0/buf_4_1.z SC0/vss sg13_lv_nmos ad=95f pd=0.88u as=95f ps=0.88u w=0.5u l=0.13u
X377 SC0/vss ph_sw[0] SC0/buf_32_1.z SC0/vss sg13_lv_nmos ad=95f pd=0.88u as=95f ps=0.88u w=0.5u l=0.13u
X378 SC0/buf_32_0.z pl_sw[0] vddr vddr sg13_lv_pmos ad=0.34p pd=2.68u as=0.19p ps=1.38u w=1u l=0.13u
X379 SC0/buf_4_1.z ph_sw[6] vddr vddr sg13_lv_pmos ad=0.34p pd=2.68u as=0.19p ps=1.38u w=1u l=0.13u
X380 SC0/buf_8_1.z pl_sw[3] vddr vddr sg13_lv_pmos ad=0.19p pd=1.38u as=0.19p ps=1.38u w=1u l=0.13u
X381 vddr pl_sw[0] SC0/buf_32_0.z vddr sg13_lv_pmos ad=0.19p pd=1.38u as=0.19p ps=1.38u w=1u l=0.13u
X382 SC0/buf_32_0.z pl_sw[0] SC0/vss SC0/vss sg13_lv_nmos ad=95f pd=0.88u as=95f ps=0.88u w=0.5u l=0.13u
X383 SC0/buf_32_1.z ph_sw[0] SC0/vss SC0/vss sg13_lv_nmos ad=95f pd=0.88u as=95f ps=0.88u w=0.5u l=0.13u
X384 SC0/vss ph_sw[0] SC0/buf_32_1.z SC0/vss sg13_lv_nmos ad=95f pd=0.88u as=95f ps=0.88u w=0.5u l=0.13u
X385 vddr pl_sw[6] SC0/buf_4_3.z vddr sg13_lv_pmos ad=0.19p pd=1.38u as=0.19p ps=1.38u w=1u l=0.13u
X386 vddr ph_sw[0] SC0/buf_32_1.z vddr sg13_lv_pmos ad=0.19p pd=1.38u as=0.19p ps=1.38u w=1u l=0.13u
X387 SC0/vss pl_sw[0] SC0/buf_32_0.z SC0/vss sg13_lv_nmos ad=95f pd=0.88u as=95f ps=0.88u w=0.5u l=0.13u
X388 vddr pl_sw[1] SC0/buf_16_2.z vddr sg13_lv_pmos ad=0.19p pd=1.38u as=0.19p ps=1.38u w=1u l=0.13u
X389 SC0/buf_4_0.z pl_sw[7] SC0/vss SC0/vss sg13_lv_nmos ad=95f pd=0.88u as=95f ps=0.88u w=0.5u l=0.13u
X390 vddr pl_sw[5] SC0/buf_8_4.z vddr sg13_lv_pmos ad=0.19p pd=1.38u as=0.34p ps=2.68u w=1u l=0.13u
X391 vddr ph_sw[1] SC0/buf_16_3.z vddr sg13_lv_pmos ad=0.19p pd=1.38u as=0.19p ps=1.38u w=1u l=0.13u
X392 vddr pl_sw[2] SC0/buf_16_1.z vddr sg13_lv_pmos ad=0.19p pd=1.38u as=0.34p ps=2.68u w=1u l=0.13u
X393 SC0/buf_32_1.z ph_sw[0] vddr vddr sg13_lv_pmos ad=0.19p pd=1.38u as=0.19p ps=1.38u w=1u l=0.13u
X394 SC0/vss ph_sw[1] SC0/buf_16_3.z SC0/vss sg13_lv_nmos ad=95f pd=0.88u as=95f ps=0.88u w=0.5u l=0.13u
X395 vddr ph_sw[2] SC0/buf_16_0.z vddr sg13_lv_pmos ad=0.19p pd=1.38u as=0.19p ps=1.38u w=1u l=0.13u
X396 SC0/buf_2_0.z ph_sw[8] SC0/vss SC0/vss sg13_lv_nmos ad=0.17p pd=1.68u as=95f ps=0.88u w=0.5u l=0.13u
X397 SC0/buf_16_1.z pl_sw[2] vddr vddr sg13_lv_pmos ad=0.19p pd=1.38u as=0.19p ps=1.38u w=1u l=0.13u
X398 vddr ph_sw[5] SC0/buf_8_5.z vddr sg13_lv_pmos ad=0.19p pd=1.38u as=0.19p ps=1.38u w=1u l=0.13u
X399 SC0/vss pl_sw[5] SC0/buf_8_4.z SC0/vss sg13_lv_nmos ad=95f pd=0.88u as=95f ps=0.88u w=0.5u l=0.13u
X400 SC0/buf_16_2.z pl_sw[1] SC0/vss SC0/vss sg13_lv_nmos ad=95f pd=0.88u as=95f ps=0.88u w=0.5u l=0.13u
X401 SC0/buf_8_0.z pl_sw[4] SC0/vss SC0/vss sg13_lv_nmos ad=95f pd=0.88u as=95f ps=0.88u w=0.5u l=0.13u
X402 vddr pl_sw[1] SC0/buf_16_2.z vddr sg13_lv_pmos ad=0.19p pd=1.38u as=0.19p ps=1.38u w=1u l=0.13u
X403 SC0/buf_8_2.z ph_sw[4] vddr vddr sg13_lv_pmos ad=0.19p pd=1.38u as=0.19p ps=1.38u w=1u l=0.13u
X0 vdd nh_sw[1] SC1/buf_16_3.z vdd sg13_lv_pmos ad=0.19p pd=1.38u as=0.19p ps=1.38u w=1u l=0.13u
X1 SC1/vss nh_sw[0] SC1/buf_32_1.z SC1/vss sg13_lv_nmos ad=95f pd=0.88u as=95f ps=0.88u w=0.5u l=0.13u
X2 vdd nl_sw[4] SC1/buf_8_0.z vdd sg13_lv_pmos ad=0.19p pd=1.38u as=0.19p ps=1.38u w=1u l=0.13u
X3 vdd nl_sw[0] SC1/buf_32_0.z vdd sg13_lv_pmos ad=0.19p pd=1.38u as=0.19p ps=1.38u w=1u l=0.13u
X4 SC1/buf_16_1.z nl_sw[2] SC1/vss SC1/vss sg13_lv_nmos ad=95f pd=0.88u as=95f ps=0.88u w=0.5u l=0.13u
X5 SC1/vss nh_sw[2] SC1/buf_16_0.z SC1/vss sg13_lv_nmos ad=95f pd=0.88u as=95f ps=0.88u w=0.5u l=0.13u
X6 SC1/buf_32_0.z nl_sw[0] SC1/vss SC1/vss sg13_lv_nmos ad=95f pd=0.88u as=95f ps=0.88u w=0.5u l=0.13u
X7 SC1/vss nh_sw[2] SC1/buf_16_0.z SC1/vss sg13_lv_nmos ad=95f pd=0.88u as=95f ps=0.88u w=0.5u l=0.13u
X8 vdd nh_sw[5] SC1/buf_8_5.z vdd sg13_lv_pmos ad=0.19p pd=1.38u as=0.34p ps=2.68u w=1u l=0.13u
X9 SC1/buf_16_1.z nl_sw[2] SC1/vss SC1/vss sg13_lv_nmos ad=95f pd=0.88u as=95f ps=0.88u w=0.5u l=0.13u
X10 SC1/buf_32_1.z nh_sw[0] SC1/vss SC1/vss sg13_lv_nmos ad=95f pd=0.88u as=95f ps=0.88u w=0.5u l=0.13u
X11 vdd nl_sw[0] SC1/buf_32_0.z vdd sg13_lv_pmos ad=0.19p pd=1.38u as=0.19p ps=1.38u w=1u l=0.13u
X12 SC1/buf_32_0.z nl_sw[0] vdd vdd sg13_lv_pmos ad=0.19p pd=1.38u as=0.19p ps=1.38u w=1u l=0.13u
X13 SC1/buf_2_2.z nl_sw[9] SC1/vss SC1/vss sg13_lv_nmos ad=0.17p pd=1.68u as=95f ps=0.88u w=0.5u l=0.13u
X14 vdd nh_sw[0] SC1/buf_32_1.z vdd sg13_lv_pmos ad=0.19p pd=1.38u as=0.19p ps=1.38u w=1u l=0.13u
X15 SC1/vss nl_sw[0] SC1/buf_32_0.z SC1/vss sg13_lv_nmos ad=95f pd=0.88u as=95f ps=0.88u w=0.5u l=0.13u
X16 SC1/buf_8_2.z nh_sw[4] SC1/vss SC1/vss sg13_lv_nmos ad=0.17p pd=1.68u as=95f ps=0.88u w=0.5u l=0.13u
X17 SC1/buf_16_0.z nh_sw[2] vdd vdd sg13_lv_pmos ad=0.34p pd=2.68u as=0.19p ps=1.38u w=1u l=0.13u
X18 SC1/vss nh_sw[0] SC1/buf_32_1.z SC1/vss sg13_lv_nmos ad=95f pd=0.88u as=95f ps=0.88u w=0.5u l=0.13u
X19 SC1/buf_16_3.z nh_sw[1] vdd vdd sg13_lv_pmos ad=0.19p pd=1.38u as=0.19p ps=1.38u w=1u l=0.13u
X20 SC1/buf_32_1.z nh_sw[0] vdd vdd sg13_lv_pmos ad=0.19p pd=1.38u as=0.19p ps=1.38u w=1u l=0.13u
X21 SC1/vss nh_sw[1] SC1/buf_16_3.z SC1/vss sg13_lv_nmos ad=95f pd=0.88u as=0.17p ps=1.68u w=0.5u l=0.13u
X22 SC1/buf_32_0.z nl_sw[0] SC1/vss SC1/vss sg13_lv_nmos ad=95f pd=0.88u as=95f ps=0.88u w=0.5u l=0.13u
X23 vdd nh_sw[3] SC1/buf_8_3.z vdd sg13_lv_pmos ad=0.19p pd=1.38u as=0.19p ps=1.38u w=1u l=0.13u
X24 SC1/buf_2_1.z nl_sw[8] vdd vdd sg13_lv_pmos ad=0.34p pd=2.68u as=0.19p ps=1.38u w=1u l=0.13u
X25 SC1/buf_32_1.z nh_sw[0] SC1/vss SC1/vss sg13_lv_nmos ad=95f pd=0.88u as=95f ps=0.88u w=0.5u l=0.13u
X26 vdd nh_sw[2] SC1/buf_16_0.z vdd sg13_lv_pmos ad=0.19p pd=1.38u as=0.34p ps=2.68u w=1u l=0.13u
X27 SC1/buf_8_1.z nl_sw[3] SC1/vss SC1/vss sg13_lv_nmos ad=95f pd=0.88u as=95f ps=0.88u w=0.5u l=0.13u
X28 vdd nl_sw[3] SC1/buf_8_1.z vdd sg13_lv_pmos ad=0.19p pd=1.38u as=0.19p ps=1.38u w=1u l=0.13u
X29 vdd nh_sw[0] SC1/buf_32_1.z vdd sg13_lv_pmos ad=0.19p pd=1.38u as=0.19p ps=1.38u w=1u l=0.13u
X30 SC1/buf_16_3.z nh_sw[1] SC1/vss SC1/vss sg13_lv_nmos ad=95f pd=0.88u as=95f ps=0.88u w=0.5u l=0.13u
X31 SC1/buf_8_2.z nh_sw[4] SC1/vss SC1/vss sg13_lv_nmos ad=95f pd=0.88u as=95f ps=0.88u w=0.5u l=0.13u
X32 SC1/vss nh_sw[0] SC1/buf_32_1.z SC1/vss sg13_lv_nmos ad=95f pd=0.88u as=95f ps=0.88u w=0.5u l=0.13u
X33 vdd nh_sw[0] SC1/buf_32_1.z vdd sg13_lv_pmos ad=0.19p pd=1.38u as=0.19p ps=1.38u w=1u l=0.13u
X34 SC1/buf_16_0.z nh_sw[2] vdd vdd sg13_lv_pmos ad=0.19p pd=1.38u as=0.19p ps=1.38u w=1u l=0.13u
X35 vdd nh_sw[6] SC1/buf_4_1.z vdd sg13_lv_pmos ad=0.19p pd=1.38u as=0.34p ps=2.68u w=1u l=0.13u
X36 SC1/buf_16_2.z nl_sw[1] SC1/vss SC1/vss sg13_lv_nmos ad=95f pd=0.88u as=95f ps=0.88u w=0.5u l=0.13u
X37 SC1/vss nl_sw[1] SC1/buf_16_2.z SC1/vss sg13_lv_nmos ad=95f pd=0.88u as=95f ps=0.88u w=0.5u l=0.13u
X38 SC1/buf_8_3.z nh_sw[3] SC1/vss SC1/vss sg13_lv_nmos ad=95f pd=0.88u as=95f ps=0.88u w=0.5u l=0.13u
X39 vdd nl_sw[2] SC1/buf_16_1.z vdd sg13_lv_pmos ad=0.19p pd=1.38u as=0.19p ps=1.38u w=1u l=0.13u
X40 SC1/buf_8_4.z nl_sw[5] SC1/vss SC1/vss sg13_lv_nmos ad=95f pd=0.88u as=95f ps=0.88u w=0.5u l=0.13u
X41 SC1/buf_32_0.z nl_sw[0] SC1/vss SC1/vss sg13_lv_nmos ad=95f pd=0.88u as=95f ps=0.88u w=0.5u l=0.13u
X42 vdd nh_sw[3] SC1/buf_8_3.z vdd sg13_lv_pmos ad=0.19p pd=1.38u as=0.19p ps=1.38u w=1u l=0.13u
X43 SC1/buf_16_1.z nl_sw[2] vdd vdd sg13_lv_pmos ad=0.19p pd=1.38u as=0.19p ps=1.38u w=1u l=0.13u
X44 SC1/buf_16_2.z nl_sw[1] vdd vdd sg13_lv_pmos ad=0.19p pd=1.38u as=0.19p ps=1.38u w=1u l=0.13u
X45 vdd nl_sw[0] SC1/buf_32_0.z vdd sg13_lv_pmos ad=0.19p pd=1.38u as=0.19p ps=1.38u w=1u l=0.13u
X46 SC1/vss nh_sw[7] SC1/buf_4_2.z SC1/vss sg13_lv_nmos ad=95f pd=0.88u as=95f ps=0.88u w=0.5u l=0.13u
X47 SC1/buf_2_2.z nl_sw[9] vdd vdd sg13_lv_pmos ad=0.34p pd=2.68u as=0.19p ps=1.38u w=1u l=0.13u
X48 SC1/buf_16_3.z nh_sw[1] vdd vdd sg13_lv_pmos ad=0.19p pd=1.38u as=0.19p ps=1.38u w=1u l=0.13u
X49 SC1/buf_4_0.z nl_sw[7] vdd vdd sg13_lv_pmos ad=0.19p pd=1.38u as=0.19p ps=1.38u w=1u l=0.13u
X50 SC1/vss nl_sw[0] SC1/buf_32_0.z SC1/vss sg13_lv_nmos ad=95f pd=0.88u as=95f ps=0.88u w=0.5u l=0.13u
X51 SC1/buf_8_5.z nh_sw[5] SC1/vss SC1/vss sg13_lv_nmos ad=0.17p pd=1.68u as=95f ps=0.88u w=0.5u l=0.13u
X52 vdd nh_sw[8] SC1/buf_2_0.z vdd sg13_lv_pmos ad=0.19p pd=1.38u as=0.34p ps=2.68u w=1u l=0.13u
X53 SC1/buf_8_0.z nl_sw[4] vdd vdd sg13_lv_pmos ad=0.19p pd=1.38u as=0.19p ps=1.38u w=1u l=0.13u
X54 SC1/buf_32_0.z nl_sw[0] vdd vdd sg13_lv_pmos ad=0.19p pd=1.38u as=0.19p ps=1.38u w=1u l=0.13u
X55 SC1/vss nl_sw[2] SC1/buf_16_1.z SC1/vss sg13_lv_nmos ad=95f pd=0.88u as=95f ps=0.88u w=0.5u l=0.13u
X56 SC1/vss nl_sw[0] SC1/buf_32_0.z SC1/vss sg13_lv_nmos ad=95f pd=0.88u as=95f ps=0.88u w=0.5u l=0.13u
X57 vdd nl_sw[2] SC1/buf_16_1.z vdd sg13_lv_pmos ad=0.19p pd=1.38u as=0.19p ps=1.38u w=1u l=0.13u
X58 vdd nl_sw[1] SC1/buf_16_2.z vdd sg13_lv_pmos ad=0.19p pd=1.38u as=0.19p ps=1.38u w=1u l=0.13u
X59 SC1/vss nl_sw[3] SC1/buf_8_1.z SC1/vss sg13_lv_nmos ad=95f pd=0.88u as=95f ps=0.88u w=0.5u l=0.13u
X60 vdd nl_sw[0] SC1/buf_32_0.z vdd sg13_lv_pmos ad=0.19p pd=1.38u as=0.19p ps=1.38u w=1u l=0.13u
X61 SC1/buf_32_1.z nh_sw[0] vdd vdd sg13_lv_pmos ad=0.19p pd=1.38u as=0.19p ps=1.38u w=1u l=0.13u
X62 vdd nl_sw[5] SC1/buf_8_4.z vdd sg13_lv_pmos ad=0.19p pd=1.38u as=0.19p ps=1.38u w=1u l=0.13u
X63 vdd nh_sw[2] SC1/buf_16_0.z vdd sg13_lv_pmos ad=0.19p pd=1.38u as=0.19p ps=1.38u w=1u l=0.13u
X64 SC1/buf_8_5.z nh_sw[5] SC1/vss SC1/vss sg13_lv_nmos ad=95f pd=0.88u as=95f ps=0.88u w=0.5u l=0.13u
X65 SC1/buf_32_0.z nl_sw[0] vdd vdd sg13_lv_pmos ad=0.19p pd=1.38u as=0.19p ps=1.38u w=1u l=0.13u
X66 SC1/vss nl_sw[4] SC1/buf_8_0.z SC1/vss sg13_lv_nmos ad=95f pd=0.88u as=0.17p ps=1.68u w=0.5u l=0.13u
X67 SC1/buf_16_3.z nh_sw[1] SC1/vss SC1/vss sg13_lv_nmos ad=95f pd=0.88u as=95f ps=0.88u w=0.5u l=0.13u
X68 vdd nh_sw[0] SC1/buf_32_1.z vdd sg13_lv_pmos ad=0.19p pd=1.38u as=0.19p ps=1.38u w=1u l=0.13u
X69 SC1/vss nl_sw[0] SC1/buf_32_0.z SC1/vss sg13_lv_nmos ad=95f pd=0.88u as=0.17p ps=1.68u w=0.5u l=0.13u
X70 SC1/buf_16_0.z nh_sw[2] SC1/vss SC1/vss sg13_lv_nmos ad=95f pd=0.88u as=95f ps=0.88u w=0.5u l=0.13u
X71 SC1/vss nh_sw[0] SC1/buf_32_1.z SC1/vss sg13_lv_nmos ad=95f pd=0.88u as=95f ps=0.88u w=0.5u l=0.13u
X72 SC1/buf_2_1.z nl_sw[8] SC1/vss SC1/vss sg13_lv_nmos ad=0.17p pd=1.68u as=95f ps=0.88u w=0.5u l=0.13u
X73 vdd nl_sw[0] SC1/buf_32_0.z vdd sg13_lv_pmos ad=0.19p pd=1.38u as=0.19p ps=1.38u w=1u l=0.13u
X74 SC1/buf_4_3.z nl_sw[6] SC1/vss SC1/vss sg13_lv_nmos ad=95f pd=0.88u as=95f ps=0.88u w=0.5u l=0.13u
X75 SC1/buf_8_1.z nl_sw[3] vdd vdd sg13_lv_pmos ad=0.34p pd=2.68u as=0.19p ps=1.38u w=1u l=0.13u
X76 SC1/buf_32_1.z nh_sw[0] vdd vdd sg13_lv_pmos ad=0.19p pd=1.38u as=0.19p ps=1.38u w=1u l=0.13u
X77 SC1/buf_4_2.z nh_sw[7] vdd vdd sg13_lv_pmos ad=0.19p pd=1.38u as=0.19p ps=1.38u w=1u l=0.13u
X78 SC1/vss nh_sw[1] SC1/buf_16_3.z SC1/vss sg13_lv_nmos ad=95f pd=0.88u as=95f ps=0.88u w=0.5u l=0.13u
X79 SC1/buf_32_0.z nl_sw[0] SC1/vss SC1/vss sg13_lv_nmos ad=95f pd=0.88u as=95f ps=0.88u w=0.5u l=0.13u
X80 SC1/vss nh_sw[4] SC1/buf_8_2.z SC1/vss sg13_lv_nmos ad=95f pd=0.88u as=95f ps=0.88u w=0.5u l=0.13u
X81 SC1/buf_32_1.z nh_sw[0] SC1/vss SC1/vss sg13_lv_nmos ad=95f pd=0.88u as=95f ps=0.88u w=0.5u l=0.13u
X82 SC1/buf_32_1.z nh_sw[0] vdd vdd sg13_lv_pmos ad=0.19p pd=1.38u as=0.19p ps=1.38u w=1u l=0.13u
X83 vdd nh_sw[2] SC1/buf_16_0.z vdd sg13_lv_pmos ad=0.19p pd=1.38u as=0.19p ps=1.38u w=1u l=0.13u
X84 SC1/vss nh_sw[0] SC1/buf_32_1.z SC1/vss sg13_lv_nmos ad=95f pd=0.88u as=95f ps=0.88u w=0.5u l=0.13u
X85 vdd nh_sw[5] SC1/buf_8_5.z vdd sg13_lv_pmos ad=0.19p pd=1.38u as=0.19p ps=1.38u w=1u l=0.13u
X86 SC1/buf_16_2.z nl_sw[1] SC1/vss SC1/vss sg13_lv_nmos ad=95f pd=0.88u as=95f ps=0.88u w=0.5u l=0.13u
X87 vdd nh_sw[0] SC1/buf_32_1.z vdd sg13_lv_pmos ad=0.19p pd=1.38u as=0.19p ps=1.38u w=1u l=0.13u
X88 vdd nl_sw[1] SC1/buf_16_2.z vdd sg13_lv_pmos ad=0.19p pd=1.38u as=0.19p ps=1.38u w=1u l=0.13u
X89 SC1/vss nl_sw[0] SC1/buf_32_0.z SC1/vss sg13_lv_nmos ad=95f pd=0.88u as=95f ps=0.88u w=0.5u l=0.13u
X90 SC1/buf_8_3.z nh_sw[3] vdd vdd sg13_lv_pmos ad=0.19p pd=1.38u as=0.19p ps=1.38u w=1u l=0.13u
X91 SC1/buf_4_0.z nl_sw[7] SC1/vss SC1/vss sg13_lv_nmos ad=0.17p pd=1.68u as=95f ps=0.88u w=0.5u l=0.13u
X92 vdd nl_sw[5] SC1/buf_8_4.z vdd sg13_lv_pmos ad=0.19p pd=1.38u as=0.19p ps=1.38u w=1u l=0.13u
X93 vdd nh_sw[1] SC1/buf_16_3.z vdd sg13_lv_pmos ad=0.19p pd=1.38u as=0.19p ps=1.38u w=1u l=0.13u
X94 SC1/buf_32_1.z nh_sw[0] vdd vdd sg13_lv_pmos ad=0.19p pd=1.38u as=0.19p ps=1.38u w=1u l=0.13u
X95 SC1/vss nh_sw[1] SC1/buf_16_3.z SC1/vss sg13_lv_nmos ad=95f pd=0.88u as=95f ps=0.88u w=0.5u l=0.13u
X96 SC1/vss nh_sw[4] SC1/buf_8_2.z SC1/vss sg13_lv_nmos ad=95f pd=0.88u as=0.17p ps=1.68u w=0.5u l=0.13u
X97 SC1/buf_8_0.z nl_sw[4] vdd vdd sg13_lv_pmos ad=0.19p pd=1.38u as=0.19p ps=1.38u w=1u l=0.13u
X98 SC1/buf_32_0.z nl_sw[0] SC1/vss SC1/vss sg13_lv_nmos ad=95f pd=0.88u as=95f ps=0.88u w=0.5u l=0.13u
X99 vdd nh_sw[2] SC1/buf_16_0.z vdd sg13_lv_pmos ad=0.19p pd=1.38u as=0.19p ps=1.38u w=1u l=0.13u
X100 SC1/buf_16_1.z nl_sw[2] SC1/vss SC1/vss sg13_lv_nmos ad=95f pd=0.88u as=95f ps=0.88u w=0.5u l=0.13u
X101 SC1/buf_16_2.z nl_sw[1] SC1/vss SC1/vss sg13_lv_nmos ad=95f pd=0.88u as=95f ps=0.88u w=0.5u l=0.13u
X102 vdd nh_sw[5] SC1/buf_8_5.z vdd sg13_lv_pmos ad=0.19p pd=1.38u as=0.19p ps=1.38u w=1u l=0.13u
X103 SC1/buf_16_1.z nl_sw[2] vdd vdd sg13_lv_pmos ad=0.19p pd=1.38u as=0.19p ps=1.38u w=1u l=0.13u
X104 SC1/buf_16_2.z nl_sw[1] vdd vdd sg13_lv_pmos ad=0.19p pd=1.38u as=0.19p ps=1.38u w=1u l=0.13u
X105 SC1/buf_8_0.z nl_sw[4] SC1/vss SC1/vss sg13_lv_nmos ad=95f pd=0.88u as=95f ps=0.88u w=0.5u l=0.13u
X106 SC1/vss nl_sw[5] SC1/buf_8_4.z SC1/vss sg13_lv_nmos ad=95f pd=0.88u as=0.17p ps=1.68u w=0.5u l=0.13u
X107 SC1/buf_8_1.z nl_sw[3] SC1/vss SC1/vss sg13_lv_nmos ad=95f pd=0.88u as=95f ps=0.88u w=0.5u l=0.13u
X108 SC1/buf_8_2.z nh_sw[4] vdd vdd sg13_lv_pmos ad=0.19p pd=1.38u as=0.19p ps=1.38u w=1u l=0.13u
X109 vdd nh_sw[9] SC1/buf_2_3.z vdd sg13_lv_pmos ad=0.19p pd=1.38u as=0.34p ps=2.68u w=1u l=0.13u
X110 SC1/buf_8_4.z nl_sw[5] vdd vdd sg13_lv_pmos ad=0.19p pd=1.38u as=0.19p ps=1.38u w=1u l=0.13u
X111 SC1/vss nh_sw[0] SC1/buf_32_1.z SC1/vss sg13_lv_nmos ad=95f pd=0.88u as=95f ps=0.88u w=0.5u l=0.13u
X112 SC1/vss nh_sw[5] SC1/buf_8_5.z SC1/vss sg13_lv_nmos ad=95f pd=0.88u as=95f ps=0.88u w=0.5u l=0.13u
X113 vdd nl_sw[0] SC1/buf_32_0.z vdd sg13_lv_pmos ad=0.19p pd=1.38u as=0.19p ps=1.38u w=1u l=0.13u
X114 SC1/buf_16_1.z nl_sw[2] SC1/vss SC1/vss sg13_lv_nmos ad=95f pd=0.88u as=95f ps=0.88u w=0.5u l=0.13u
X115 SC1/vss nh_sw[2] SC1/buf_16_0.z SC1/vss sg13_lv_nmos ad=95f pd=0.88u as=95f ps=0.88u w=0.5u l=0.13u
X116 SC1/vss nh_sw[2] SC1/buf_16_0.z SC1/vss sg13_lv_nmos ad=95f pd=0.88u as=95f ps=0.88u w=0.5u l=0.13u
X117 SC1/buf_32_1.z nh_sw[0] SC1/vss SC1/vss sg13_lv_nmos ad=95f pd=0.88u as=95f ps=0.88u w=0.5u l=0.13u
X118 SC1/buf_4_1.z nh_sw[6] SC1/vss SC1/vss sg13_lv_nmos ad=95f pd=0.88u as=95f ps=0.88u w=0.5u l=0.13u
X119 SC1/buf_16_1.z nl_sw[2] SC1/vss SC1/vss sg13_lv_nmos ad=0.17p pd=1.68u as=95f ps=0.88u w=0.5u l=0.13u
X120 vdd nl_sw[0] SC1/buf_32_0.z vdd sg13_lv_pmos ad=0.19p pd=1.38u as=0.19p ps=1.38u w=1u l=0.13u
X121 vdd nl_sw[3] SC1/buf_8_1.z vdd sg13_lv_pmos ad=0.19p pd=1.38u as=0.19p ps=1.38u w=1u l=0.13u
X122 SC1/buf_32_0.z nl_sw[0] vdd vdd sg13_lv_pmos ad=0.19p pd=1.38u as=0.19p ps=1.38u w=1u l=0.13u
X123 SC1/vss nl_sw[0] SC1/buf_32_0.z SC1/vss sg13_lv_nmos ad=95f pd=0.88u as=95f ps=0.88u w=0.5u l=0.13u
X124 SC1/vss nh_sw[0] SC1/buf_32_1.z SC1/vss sg13_lv_nmos ad=95f pd=0.88u as=95f ps=0.88u w=0.5u l=0.13u
X125 SC1/buf_16_3.z nh_sw[1] vdd vdd sg13_lv_pmos ad=0.34p pd=2.68u as=0.19p ps=1.38u w=1u l=0.13u
X126 SC1/vss nh_sw[5] SC1/buf_8_5.z SC1/vss sg13_lv_nmos ad=95f pd=0.88u as=0.17p ps=1.68u w=0.5u l=0.13u
X127 SC1/buf_32_1.z nh_sw[0] SC1/vss SC1/vss sg13_lv_nmos ad=95f pd=0.88u as=95f ps=0.88u w=0.5u l=0.13u
X128 SC1/buf_8_3.z nh_sw[3] SC1/vss SC1/vss sg13_lv_nmos ad=0.17p pd=1.68u as=95f ps=0.88u w=0.5u l=0.13u
X129 SC1/buf_32_0.z nl_sw[0] SC1/vss SC1/vss sg13_lv_nmos ad=95f pd=0.88u as=95f ps=0.88u w=0.5u l=0.13u
X130 SC1/buf_4_3.z nl_sw[6] vdd vdd sg13_lv_pmos ad=0.19p pd=1.38u as=0.19p ps=1.38u w=1u l=0.13u
X131 SC1/buf_32_1.z nh_sw[0] vdd vdd sg13_lv_pmos ad=0.19p pd=1.38u as=0.19p ps=1.38u w=1u l=0.13u
X132 SC1/vss nl_sw[7] SC1/buf_4_0.z SC1/vss sg13_lv_nmos ad=95f pd=0.88u as=0.17p ps=1.68u w=0.5u l=0.13u
X133 vdd nh_sw[0] SC1/buf_32_1.z vdd sg13_lv_pmos ad=0.19p pd=1.38u as=0.19p ps=1.38u w=1u l=0.13u
X134 SC1/buf_16_3.z nh_sw[1] SC1/vss SC1/vss sg13_lv_nmos ad=95f pd=0.88u as=95f ps=0.88u w=0.5u l=0.13u
X135 vdd nh_sw[6] SC1/buf_4_1.z vdd sg13_lv_pmos ad=0.19p pd=1.38u as=0.19p ps=1.38u w=1u l=0.13u
X136 SC1/buf_16_0.z nh_sw[2] vdd vdd sg13_lv_pmos ad=0.19p pd=1.38u as=0.19p ps=1.38u w=1u l=0.13u
X137 SC1/vss nh_sw[8] SC1/buf_2_0.z SC1/vss sg13_lv_nmos ad=95f pd=0.88u as=0.17p ps=1.68u w=0.5u l=0.13u
X138 SC1/buf_16_2.z nl_sw[1] SC1/vss SC1/vss sg13_lv_nmos ad=0.17p pd=1.68u as=95f ps=0.88u w=0.5u l=0.13u
X139 SC1/buf_8_3.z nh_sw[3] SC1/vss SC1/vss sg13_lv_nmos ad=95f pd=0.88u as=95f ps=0.88u w=0.5u l=0.13u
X140 vdd nl_sw[2] SC1/buf_16_1.z vdd sg13_lv_pmos ad=0.19p pd=1.38u as=0.19p ps=1.38u w=1u l=0.13u
X141 SC1/buf_8_5.z nh_sw[5] vdd vdd sg13_lv_pmos ad=0.19p pd=1.38u as=0.19p ps=1.38u w=1u l=0.13u
X142 SC1/buf_8_4.z nl_sw[5] SC1/vss SC1/vss sg13_lv_nmos ad=95f pd=0.88u as=95f ps=0.88u w=0.5u l=0.13u
X143 SC1/vss nl_sw[1] SC1/buf_16_2.z SC1/vss sg13_lv_nmos ad=95f pd=0.88u as=95f ps=0.88u w=0.5u l=0.13u
X144 SC1/buf_16_2.z nl_sw[1] vdd vdd sg13_lv_pmos ad=0.19p pd=1.38u as=0.19p ps=1.38u w=1u l=0.13u
X145 SC1/buf_16_1.z nl_sw[2] vdd vdd sg13_lv_pmos ad=0.34p pd=2.68u as=0.19p ps=1.38u w=1u l=0.13u
X146 vdd nl_sw[0] SC1/buf_32_0.z vdd sg13_lv_pmos ad=0.19p pd=1.38u as=0.19p ps=1.38u w=1u l=0.13u
X147 SC1/buf_16_3.z nh_sw[1] vdd vdd sg13_lv_pmos ad=0.19p pd=1.38u as=0.19p ps=1.38u w=1u l=0.13u
X148 SC1/buf_32_1.z nh_sw[0] SC1/vss SC1/vss sg13_lv_nmos ad=95f pd=0.88u as=95f ps=0.88u w=0.5u l=0.13u
X149 SC1/buf_4_0.z nl_sw[7] vdd vdd sg13_lv_pmos ad=0.34p pd=2.68u as=0.19p ps=1.38u w=1u l=0.13u
X150 SC1/buf_8_0.z nl_sw[4] vdd vdd sg13_lv_pmos ad=0.19p pd=1.38u as=0.19p ps=1.38u w=1u l=0.13u
X151 SC1/buf_32_0.z nl_sw[0] vdd vdd sg13_lv_pmos ad=0.19p pd=1.38u as=0.19p ps=1.38u w=1u l=0.13u
X152 SC1/vss nl_sw[2] SC1/buf_16_1.z SC1/vss sg13_lv_nmos ad=95f pd=0.88u as=95f ps=0.88u w=0.5u l=0.13u
X153 SC1/vss nl_sw[0] SC1/buf_32_0.z SC1/vss sg13_lv_nmos ad=95f pd=0.88u as=95f ps=0.88u w=0.5u l=0.13u
X154 SC1/buf_4_2.z nh_sw[7] vdd vdd sg13_lv_pmos ad=0.34p pd=2.68u as=0.19p ps=1.38u w=1u l=0.13u
X155 SC1/buf_16_0.z nh_sw[2] SC1/vss SC1/vss sg13_lv_nmos ad=95f pd=0.88u as=95f ps=0.88u w=0.5u l=0.13u
X156 SC1/buf_16_0.z nh_sw[2] SC1/vss SC1/vss sg13_lv_nmos ad=95f pd=0.88u as=95f ps=0.88u w=0.5u l=0.13u
X157 SC1/vss nh_sw[0] SC1/buf_32_1.z SC1/vss sg13_lv_nmos ad=95f pd=0.88u as=95f ps=0.88u w=0.5u l=0.13u
X158 SC1/vss nl_sw[2] SC1/buf_16_1.z SC1/vss sg13_lv_nmos ad=95f pd=0.88u as=95f ps=0.88u w=0.5u l=0.13u
X159 SC1/buf_2_3.z nh_sw[9] SC1/vss SC1/vss sg13_lv_nmos ad=0.17p pd=1.68u as=95f ps=0.88u w=0.5u l=0.13u
X160 SC1/buf_32_0.z nl_sw[0] vdd vdd sg13_lv_pmos ad=0.19p pd=1.38u as=0.19p ps=1.38u w=1u l=0.13u
X161 vdd nl_sw[0] SC1/buf_32_0.z vdd sg13_lv_pmos ad=0.19p pd=1.38u as=0.19p ps=1.38u w=1u l=0.13u
X162 SC1/vss nl_sw[9] SC1/buf_2_2.z SC1/vss sg13_lv_nmos ad=95f pd=0.88u as=0.17p ps=1.68u w=0.5u l=0.13u
X163 SC1/buf_32_1.z nh_sw[0] vdd vdd sg13_lv_pmos ad=0.19p pd=1.38u as=0.19p ps=1.38u w=1u l=0.13u
X164 SC1/buf_32_0.z nl_sw[0] SC1/vss SC1/vss sg13_lv_nmos ad=95f pd=0.88u as=95f ps=0.88u w=0.5u l=0.13u
X165 SC1/vss nh_sw[4] SC1/buf_8_2.z SC1/vss sg13_lv_nmos ad=95f pd=0.88u as=95f ps=0.88u w=0.5u l=0.13u
X166 SC1/buf_32_1.z nh_sw[0] SC1/vss SC1/vss sg13_lv_nmos ad=95f pd=0.88u as=95f ps=0.88u w=0.5u l=0.13u
X167 vdd nh_sw[2] SC1/buf_16_0.z vdd sg13_lv_pmos ad=0.19p pd=1.38u as=0.19p ps=1.38u w=1u l=0.13u
X168 vdd nh_sw[1] SC1/buf_16_3.z vdd sg13_lv_pmos ad=0.19p pd=1.38u as=0.19p ps=1.38u w=1u l=0.13u
X169 SC1/buf_16_3.z nh_sw[1] SC1/vss SC1/vss sg13_lv_nmos ad=0.17p pd=1.68u as=95f ps=0.88u w=0.5u l=0.13u
X170 SC1/vss nl_sw[4] SC1/buf_8_0.z SC1/vss sg13_lv_nmos ad=95f pd=0.88u as=95f ps=0.88u w=0.5u l=0.13u
X171 vdd nh_sw[0] SC1/buf_32_1.z vdd sg13_lv_pmos ad=0.19p pd=1.38u as=0.19p ps=1.38u w=1u l=0.13u
X172 SC1/vss nl_sw[0] SC1/buf_32_0.z SC1/vss sg13_lv_nmos ad=95f pd=0.88u as=95f ps=0.88u w=0.5u l=0.13u
X173 vdd nl_sw[8] SC1/buf_2_1.z vdd sg13_lv_pmos ad=0.19p pd=1.38u as=0.34p ps=2.68u w=1u l=0.13u
X174 SC1/buf_16_0.z nh_sw[2] SC1/vss SC1/vss sg13_lv_nmos ad=95f pd=0.88u as=95f ps=0.88u w=0.5u l=0.13u
X175 SC1/vss nh_sw[0] SC1/buf_32_1.z SC1/vss sg13_lv_nmos ad=95f pd=0.88u as=95f ps=0.88u w=0.5u l=0.13u
X176 SC1/vss nl_sw[3] SC1/buf_8_1.z SC1/vss sg13_lv_nmos ad=95f pd=0.88u as=0.17p ps=1.68u w=0.5u l=0.13u
X177 SC1/buf_4_3.z nl_sw[6] SC1/vss SC1/vss sg13_lv_nmos ad=0.17p pd=1.68u as=95f ps=0.88u w=0.5u l=0.13u
X178 SC1/buf_8_1.z nl_sw[3] vdd vdd sg13_lv_pmos ad=0.19p pd=1.38u as=0.19p ps=1.38u w=1u l=0.13u
X179 SC1/vss nl_sw[1] SC1/buf_16_2.z SC1/vss sg13_lv_nmos ad=95f pd=0.88u as=0.17p ps=1.68u w=0.5u l=0.13u
X180 SC1/buf_32_1.z nh_sw[0] vdd vdd sg13_lv_pmos ad=0.19p pd=1.38u as=0.19p ps=1.38u w=1u l=0.13u
X181 SC1/vss nh_sw[1] SC1/buf_16_3.z SC1/vss sg13_lv_nmos ad=95f pd=0.88u as=95f ps=0.88u w=0.5u l=0.13u
X182 SC1/buf_32_0.z nl_sw[0] SC1/vss SC1/vss sg13_lv_nmos ad=95f pd=0.88u as=95f ps=0.88u w=0.5u l=0.13u
X183 SC1/vss nh_sw[4] SC1/buf_8_2.z SC1/vss sg13_lv_nmos ad=95f pd=0.88u as=95f ps=0.88u w=0.5u l=0.13u
X184 SC1/buf_32_1.z nh_sw[0] SC1/vss SC1/vss sg13_lv_nmos ad=95f pd=0.88u as=95f ps=0.88u w=0.5u l=0.13u
X185 SC1/buf_32_1.z nh_sw[0] vdd vdd sg13_lv_pmos ad=0.19p pd=1.38u as=0.19p ps=1.38u w=1u l=0.13u
X186 vdd nh_sw[2] SC1/buf_16_0.z vdd sg13_lv_pmos ad=0.19p pd=1.38u as=0.19p ps=1.38u w=1u l=0.13u
X187 SC1/vss nl_sw[1] SC1/buf_16_2.z SC1/vss sg13_lv_nmos ad=95f pd=0.88u as=95f ps=0.88u w=0.5u l=0.13u
X188 SC1/buf_16_2.z nl_sw[1] SC1/vss SC1/vss sg13_lv_nmos ad=95f pd=0.88u as=95f ps=0.88u w=0.5u l=0.13u
X189 SC1/vss nh_sw[3] SC1/buf_8_3.z SC1/vss sg13_lv_nmos ad=95f pd=0.88u as=95f ps=0.88u w=0.5u l=0.13u
X190 SC1/vss nl_sw[0] SC1/buf_32_0.z SC1/vss sg13_lv_nmos ad=95f pd=0.88u as=95f ps=0.88u w=0.5u l=0.13u
X191 vdd nl_sw[1] SC1/buf_16_2.z vdd sg13_lv_pmos ad=0.19p pd=1.38u as=0.19p ps=1.38u w=1u l=0.13u
X192 SC1/buf_8_3.z nh_sw[3] vdd vdd sg13_lv_pmos ad=0.19p pd=1.38u as=0.19p ps=1.38u w=1u l=0.13u
X193 vdd nl_sw[2] SC1/buf_16_1.z vdd sg13_lv_pmos ad=0.19p pd=1.38u as=0.19p ps=1.38u w=1u l=0.13u
X194 SC1/buf_32_0.z nl_sw[0] vdd vdd sg13_lv_pmos ad=0.19p pd=1.38u as=0.19p ps=1.38u w=1u l=0.13u
X195 SC1/buf_8_2.z nh_sw[4] vdd vdd sg13_lv_pmos ad=0.34p pd=2.68u as=0.19p ps=1.38u w=1u l=0.13u
X196 SC1/buf_4_2.z nh_sw[7] SC1/vss SC1/vss sg13_lv_nmos ad=95f pd=0.88u as=95f ps=0.88u w=0.5u l=0.13u
X197 SC1/vss nl_sw[2] SC1/buf_16_1.z SC1/vss sg13_lv_nmos ad=95f pd=0.88u as=0.17p ps=1.68u w=0.5u l=0.13u
X198 vdd nh_sw[1] SC1/buf_16_3.z vdd sg13_lv_pmos ad=0.19p pd=1.38u as=0.19p ps=1.38u w=1u l=0.13u
X199 vdd nl_sw[9] SC1/buf_2_2.z vdd sg13_lv_pmos ad=0.19p pd=1.38u as=0.34p ps=2.68u w=1u l=0.13u
X200 SC1/buf_4_1.z nh_sw[6] SC1/vss SC1/vss sg13_lv_nmos ad=0.17p pd=1.68u as=95f ps=0.88u w=0.5u l=0.13u
X201 SC1/buf_32_1.z nh_sw[0] vdd vdd sg13_lv_pmos ad=0.19p pd=1.38u as=0.19p ps=1.38u w=1u l=0.13u
X202 vdd nl_sw[7] SC1/buf_4_0.z vdd sg13_lv_pmos ad=0.19p pd=1.38u as=0.34p ps=2.68u w=1u l=0.13u
X203 SC1/buf_32_0.z nl_sw[0] SC1/vss SC1/vss sg13_lv_nmos ad=95f pd=0.88u as=95f ps=0.88u w=0.5u l=0.13u
X204 SC1/vss nh_sw[5] SC1/buf_8_5.z SC1/vss sg13_lv_nmos ad=95f pd=0.88u as=95f ps=0.88u w=0.5u l=0.13u
X205 vdd nl_sw[0] SC1/buf_32_0.z vdd sg13_lv_pmos ad=0.19p pd=1.38u as=0.19p ps=1.38u w=1u l=0.13u
X206 SC1/buf_16_1.z nl_sw[2] SC1/vss SC1/vss sg13_lv_nmos ad=95f pd=0.88u as=95f ps=0.88u w=0.5u l=0.13u
X207 SC1/vss nh_sw[3] SC1/buf_8_3.z SC1/vss sg13_lv_nmos ad=95f pd=0.88u as=0.17p ps=1.68u w=0.5u l=0.13u
X208 SC1/buf_16_1.z nl_sw[2] vdd vdd sg13_lv_pmos ad=0.19p pd=1.38u as=0.19p ps=1.38u w=1u l=0.13u
X209 SC1/buf_16_2.z nl_sw[1] vdd vdd sg13_lv_pmos ad=0.19p pd=1.38u as=0.19p ps=1.38u w=1u l=0.13u
X210 SC1/vss nl_sw[5] SC1/buf_8_4.z SC1/vss sg13_lv_nmos ad=95f pd=0.88u as=95f ps=0.88u w=0.5u l=0.13u
X211 SC1/buf_8_0.z nl_sw[4] SC1/vss SC1/vss sg13_lv_nmos ad=0.17p pd=1.68u as=95f ps=0.88u w=0.5u l=0.13u
X212 SC1/buf_8_1.z nl_sw[3] SC1/vss SC1/vss sg13_lv_nmos ad=95f pd=0.88u as=95f ps=0.88u w=0.5u l=0.13u
X213 SC1/buf_32_0.z nl_sw[0] vdd vdd sg13_lv_pmos ad=0.19p pd=1.38u as=0.19p ps=1.38u w=1u l=0.13u
X214 SC1/buf_8_2.z nh_sw[4] vdd vdd sg13_lv_pmos ad=0.19p pd=1.38u as=0.19p ps=1.38u w=1u l=0.13u
X215 vdd nh_sw[0] SC1/buf_32_1.z vdd sg13_lv_pmos ad=0.19p pd=1.38u as=0.19p ps=1.38u w=1u l=0.13u
X216 SC1/buf_8_4.z nl_sw[5] vdd vdd sg13_lv_pmos ad=0.19p pd=1.38u as=0.19p ps=1.38u w=1u l=0.13u
X217 vdd nh_sw[10] SC1/buf_1_1.z vdd sg13_lv_pmos ad=0.34p pd=2.68u as=0.34p ps=2.68u w=1u l=0.13u
X218 SC1/buf_16_0.z nh_sw[2] vdd vdd sg13_lv_pmos ad=0.19p pd=1.38u as=0.19p ps=1.38u w=1u l=0.13u
X219 SC1/vss nh_sw[5] SC1/buf_8_5.z SC1/vss sg13_lv_nmos ad=95f pd=0.88u as=95f ps=0.88u w=0.5u l=0.13u
X220 vdd nl_sw[0] SC1/buf_32_0.z vdd sg13_lv_pmos ad=0.19p pd=1.38u as=0.19p ps=1.38u w=1u l=0.13u
X221 SC1/vss nh_sw[1] SC1/buf_16_3.z SC1/vss sg13_lv_nmos ad=95f pd=0.88u as=95f ps=0.88u w=0.5u l=0.13u
X222 SC1/vss nh_sw[2] SC1/buf_16_0.z SC1/vss sg13_lv_nmos ad=95f pd=0.88u as=95f ps=0.88u w=0.5u l=0.13u
X223 SC1/buf_32_1.z nh_sw[0] SC1/vss SC1/vss sg13_lv_nmos ad=95f pd=0.88u as=95f ps=0.88u w=0.5u l=0.13u
X224 SC1/vss nl_sw[8] SC1/buf_2_1.z SC1/vss sg13_lv_nmos ad=95f pd=0.88u as=0.17p ps=1.68u w=0.5u l=0.13u
X225 SC1/buf_32_0.z nl_sw[0] vdd vdd sg13_lv_pmos ad=0.19p pd=1.38u as=0.19p ps=1.38u w=1u l=0.13u
X226 SC1/vss nl_sw[6] SC1/buf_4_3.z SC1/vss sg13_lv_nmos ad=95f pd=0.88u as=0.17p ps=1.68u w=0.5u l=0.13u
X227 vdd nl_sw[3] SC1/buf_8_1.z vdd sg13_lv_pmos ad=0.19p pd=1.38u as=0.19p ps=1.38u w=1u l=0.13u
X228 vdd nh_sw[0] SC1/buf_32_1.z vdd sg13_lv_pmos ad=0.19p pd=1.38u as=0.34p ps=2.68u w=1u l=0.13u
X229 vdd nh_sw[7] SC1/buf_4_2.z vdd sg13_lv_pmos ad=0.19p pd=1.38u as=0.34p ps=2.68u w=1u l=0.13u
X230 SC1/vss nl_sw[0] SC1/buf_32_0.z SC1/vss sg13_lv_nmos ad=95f pd=0.88u as=95f ps=0.88u w=0.5u l=0.13u
X231 SC1/vss nh_sw[0] SC1/buf_32_1.z SC1/vss sg13_lv_nmos ad=95f pd=0.88u as=95f ps=0.88u w=0.5u l=0.13u
X232 SC1/buf_8_2.z nh_sw[4] SC1/vss SC1/vss sg13_lv_nmos ad=95f pd=0.88u as=95f ps=0.88u w=0.5u l=0.13u
X233 SC1/buf_32_1.z nh_sw[0] SC1/vss SC1/vss sg13_lv_nmos ad=95f pd=0.88u as=95f ps=0.88u w=0.5u l=0.13u
X234 SC1/buf_4_3.z nl_sw[6] vdd vdd sg13_lv_pmos ad=0.34p pd=2.68u as=0.19p ps=1.38u w=1u l=0.13u
X235 SC1/vss nl_sw[1] SC1/buf_16_2.z SC1/vss sg13_lv_nmos ad=95f pd=0.88u as=95f ps=0.88u w=0.5u l=0.13u
X236 SC1/buf_32_1.z nh_sw[0] vdd vdd sg13_lv_pmos ad=0.19p pd=1.38u as=0.19p ps=1.38u w=1u l=0.13u
X237 SC1/buf_16_2.z nl_sw[1] vdd vdd sg13_lv_pmos ad=0.19p pd=1.38u as=0.19p ps=1.38u w=1u l=0.13u
X238 SC1/buf_32_0.z nl_sw[0] SC1/vss SC1/vss sg13_lv_nmos ad=95f pd=0.88u as=95f ps=0.88u w=0.5u l=0.13u
X239 SC1/vss nl_sw[7] SC1/buf_4_0.z SC1/vss sg13_lv_nmos ad=95f pd=0.88u as=95f ps=0.88u w=0.5u l=0.13u
X240 SC1/buf_8_4.z nl_sw[5] vdd vdd sg13_lv_pmos ad=0.19p pd=1.38u as=0.19p ps=1.38u w=1u l=0.13u
X241 SC1/buf_16_3.z nh_sw[1] vdd vdd sg13_lv_pmos ad=0.19p pd=1.38u as=0.19p ps=1.38u w=1u l=0.13u
X242 vdd nh_sw[0] SC1/buf_32_1.z vdd sg13_lv_pmos ad=0.19p pd=1.38u as=0.19p ps=1.38u w=1u l=0.13u
X243 SC1/buf_16_3.z nh_sw[1] SC1/vss SC1/vss sg13_lv_nmos ad=95f pd=0.88u as=95f ps=0.88u w=0.5u l=0.13u
X244 vdd nl_sw[4] SC1/buf_8_0.z vdd sg13_lv_pmos ad=0.19p pd=1.38u as=0.34p ps=2.68u w=1u l=0.13u
X245 SC1/buf_16_0.z nh_sw[2] vdd vdd sg13_lv_pmos ad=0.19p pd=1.38u as=0.19p ps=1.38u w=1u l=0.13u
X246 SC1/vss nl_sw[2] SC1/buf_16_1.z SC1/vss sg13_lv_nmos ad=95f pd=0.88u as=95f ps=0.88u w=0.5u l=0.13u
X247 SC1/buf_8_5.z nh_sw[5] vdd vdd sg13_lv_pmos ad=0.19p pd=1.38u as=0.19p ps=1.38u w=1u l=0.13u
X248 SC1/buf_8_4.z nl_sw[5] SC1/vss SC1/vss sg13_lv_nmos ad=0.17p pd=1.68u as=95f ps=0.88u w=0.5u l=0.13u
X249 vdd nl_sw[2] SC1/buf_16_1.z vdd sg13_lv_pmos ad=0.19p pd=1.38u as=0.19p ps=1.38u w=1u l=0.13u
X250 SC1/vss nl_sw[1] SC1/buf_16_2.z SC1/vss sg13_lv_nmos ad=95f pd=0.88u as=95f ps=0.88u w=0.5u l=0.13u
X251 SC1/vss nl_sw[4] SC1/buf_8_0.z SC1/vss sg13_lv_nmos ad=95f pd=0.88u as=95f ps=0.88u w=0.5u l=0.13u
X252 SC1/buf_16_2.z nl_sw[1] vdd vdd sg13_lv_pmos ad=0.19p pd=1.38u as=0.19p ps=1.38u w=1u l=0.13u
X253 vdd nh_sw[4] SC1/buf_8_2.z vdd sg13_lv_pmos ad=0.19p pd=1.38u as=0.19p ps=1.38u w=1u l=0.13u
X254 SC1/buf_16_3.z nh_sw[1] vdd vdd sg13_lv_pmos ad=0.19p pd=1.38u as=0.19p ps=1.38u w=1u l=0.13u
X255 SC1/vss nh_sw[2] SC1/buf_16_0.z SC1/vss sg13_lv_nmos ad=95f pd=0.88u as=0.17p ps=1.68u w=0.5u l=0.13u
X256 SC1/buf_32_1.z nh_sw[0] SC1/vss SC1/vss sg13_lv_nmos ad=95f pd=0.88u as=95f ps=0.88u w=0.5u l=0.13u
X257 SC1/buf_8_0.z nl_sw[4] vdd vdd sg13_lv_pmos ad=0.34p pd=2.68u as=0.19p ps=1.38u w=1u l=0.13u
X258 SC1/buf_8_5.z nh_sw[5] SC1/vss SC1/vss sg13_lv_nmos ad=95f pd=0.88u as=95f ps=0.88u w=0.5u l=0.13u
X259 SC1/buf_32_0.z nl_sw[0] vdd vdd sg13_lv_pmos ad=0.19p pd=1.38u as=0.19p ps=1.38u w=1u l=0.13u
X260 SC1/vss nl_sw[2] SC1/buf_16_1.z SC1/vss sg13_lv_nmos ad=95f pd=0.88u as=95f ps=0.88u w=0.5u l=0.13u
X261 SC1/vss nl_sw[0] SC1/buf_32_0.z SC1/vss sg13_lv_nmos ad=95f pd=0.88u as=95f ps=0.88u w=0.5u l=0.13u
X262 SC1/buf_16_0.z nh_sw[2] SC1/vss SC1/vss sg13_lv_nmos ad=95f pd=0.88u as=95f ps=0.88u w=0.5u l=0.13u
X263 SC1/buf_16_0.z nh_sw[2] SC1/vss SC1/vss sg13_lv_nmos ad=95f pd=0.88u as=95f ps=0.88u w=0.5u l=0.13u
X264 SC1/vss nh_sw[0] SC1/buf_32_1.z SC1/vss sg13_lv_nmos ad=95f pd=0.88u as=95f ps=0.88u w=0.5u l=0.13u
X265 vdd nl_sw[10] SC1/buf_1_0.z vdd sg13_lv_pmos ad=0.34p pd=2.68u as=0.34p ps=2.68u w=1u l=0.13u
X266 SC1/vss nh_sw[6] SC1/buf_4_1.z SC1/vss sg13_lv_nmos ad=95f pd=0.88u as=0.17p ps=1.68u w=0.5u l=0.13u
X267 SC1/vss nl_sw[2] SC1/buf_16_1.z SC1/vss sg13_lv_nmos ad=95f pd=0.88u as=95f ps=0.88u w=0.5u l=0.13u
X268 SC1/buf_32_0.z nl_sw[0] vdd vdd sg13_lv_pmos ad=0.19p pd=1.38u as=0.19p ps=1.38u w=1u l=0.13u
X269 vdd nl_sw[0] SC1/buf_32_0.z vdd sg13_lv_pmos ad=0.19p pd=1.38u as=0.19p ps=1.38u w=1u l=0.13u
X270 vdd nh_sw[4] SC1/buf_8_2.z vdd sg13_lv_pmos ad=0.19p pd=1.38u as=0.34p ps=2.68u w=1u l=0.13u
X271 SC1/buf_8_1.z nl_sw[3] vdd vdd sg13_lv_pmos ad=0.19p pd=1.38u as=0.19p ps=1.38u w=1u l=0.13u
X272 SC1/buf_32_0.z nl_sw[0] SC1/vss SC1/vss sg13_lv_nmos ad=95f pd=0.88u as=95f ps=0.88u w=0.5u l=0.13u
X273 SC1/buf_32_1.z nh_sw[0] SC1/vss SC1/vss sg13_lv_nmos ad=95f pd=0.88u as=95f ps=0.88u w=0.5u l=0.13u
X274 SC1/buf_4_2.z nh_sw[7] SC1/vss SC1/vss sg13_lv_nmos ad=0.17p pd=1.68u as=95f ps=0.88u w=0.5u l=0.13u
X275 vdd nh_sw[1] SC1/buf_16_3.z vdd sg13_lv_pmos ad=0.19p pd=1.38u as=0.19p ps=1.38u w=1u l=0.13u
X276 vdd nh_sw[0] SC1/buf_32_1.z vdd sg13_lv_pmos ad=0.19p pd=1.38u as=0.19p ps=1.38u w=1u l=0.13u
X277 SC1/vss nh_sw[3] SC1/buf_8_3.z SC1/vss sg13_lv_nmos ad=95f pd=0.88u as=95f ps=0.88u w=0.5u l=0.13u
X278 vdd nl_sw[6] SC1/buf_4_3.z vdd sg13_lv_pmos ad=0.19p pd=1.38u as=0.34p ps=2.68u w=1u l=0.13u
X279 SC1/vss nl_sw[0] SC1/buf_32_0.z SC1/vss sg13_lv_nmos ad=95f pd=0.88u as=95f ps=0.88u w=0.5u l=0.13u
X280 SC1/buf_8_3.z nh_sw[3] vdd vdd sg13_lv_pmos ad=0.34p pd=2.68u as=0.19p ps=1.38u w=1u l=0.13u
X281 SC1/vss nl_sw[3] SC1/buf_8_1.z SC1/vss sg13_lv_nmos ad=95f pd=0.88u as=95f ps=0.88u w=0.5u l=0.13u
X282 SC1/buf_32_1.z nh_sw[0] vdd vdd sg13_lv_pmos ad=0.19p pd=1.38u as=0.19p ps=1.38u w=1u l=0.13u
X283 SC1/vss nh_sw[1] SC1/buf_16_3.z SC1/vss sg13_lv_nmos ad=95f pd=0.88u as=95f ps=0.88u w=0.5u l=0.13u
X284 SC1/buf_32_1.z nh_sw[0] SC1/vss SC1/vss sg13_lv_nmos ad=95f pd=0.88u as=95f ps=0.88u w=0.5u l=0.13u
X285 SC1/buf_32_1.z nh_sw[0] vdd vdd sg13_lv_pmos ad=0.34p pd=2.68u as=0.19p ps=1.38u w=1u l=0.13u
X286 vdd nh_sw[2] SC1/buf_16_0.z vdd sg13_lv_pmos ad=0.19p pd=1.38u as=0.19p ps=1.38u w=1u l=0.13u
X287 SC1/buf_4_1.z nh_sw[6] vdd vdd sg13_lv_pmos ad=0.19p pd=1.38u as=0.19p ps=1.38u w=1u l=0.13u
X288 SC1/vss nl_sw[1] SC1/buf_16_2.z SC1/vss sg13_lv_nmos ad=95f pd=0.88u as=95f ps=0.88u w=0.5u l=0.13u
X289 SC1/vss nh_sw[3] SC1/buf_8_3.z SC1/vss sg13_lv_nmos ad=95f pd=0.88u as=95f ps=0.88u w=0.5u l=0.13u
X290 SC1/buf_16_1.z nl_sw[2] vdd vdd sg13_lv_pmos ad=0.19p pd=1.38u as=0.19p ps=1.38u w=1u l=0.13u
X291 SC1/buf_16_2.z nl_sw[1] SC1/vss SC1/vss sg13_lv_nmos ad=95f pd=0.88u as=95f ps=0.88u w=0.5u l=0.13u
X292 SC1/buf_8_3.z nh_sw[3] vdd vdd sg13_lv_pmos ad=0.19p pd=1.38u as=0.19p ps=1.38u w=1u l=0.13u
X293 SC1/vss nl_sw[5] SC1/buf_8_4.z SC1/vss sg13_lv_nmos ad=95f pd=0.88u as=95f ps=0.88u w=0.5u l=0.13u
X294 vdd nl_sw[1] SC1/buf_16_2.z vdd sg13_lv_pmos ad=0.19p pd=1.38u as=0.19p ps=1.38u w=1u l=0.13u
X295 vdd nl_sw[2] SC1/buf_16_1.z vdd sg13_lv_pmos ad=0.19p pd=1.38u as=0.19p ps=1.38u w=1u l=0.13u
X296 SC1/buf_32_0.z nl_sw[0] vdd vdd sg13_lv_pmos ad=0.19p pd=1.38u as=0.19p ps=1.38u w=1u l=0.13u
X297 vdd nh_sw[1] SC1/buf_16_3.z vdd sg13_lv_pmos ad=0.19p pd=1.38u as=0.19p ps=1.38u w=1u l=0.13u
X298 SC1/vss nh_sw[0] SC1/buf_32_1.z SC1/vss sg13_lv_nmos ad=95f pd=0.88u as=95f ps=0.88u w=0.5u l=0.13u
X299 vdd nl_sw[7] SC1/buf_4_0.z vdd sg13_lv_pmos ad=0.19p pd=1.38u as=0.19p ps=1.38u w=1u l=0.13u
X300 SC1/buf_32_0.z nl_sw[0] SC1/vss SC1/vss sg13_lv_nmos ad=0.17p pd=1.68u as=95f ps=0.88u w=0.5u l=0.13u
X301 SC1/buf_2_0.z nh_sw[8] vdd vdd sg13_lv_pmos ad=0.34p pd=2.68u as=0.19p ps=1.38u w=1u l=0.13u
X302 vdd nl_sw[4] SC1/buf_8_0.z vdd sg13_lv_pmos ad=0.19p pd=1.38u as=0.19p ps=1.38u w=1u l=0.13u
X303 vdd nl_sw[0] SC1/buf_32_0.z vdd sg13_lv_pmos ad=0.19p pd=1.38u as=0.19p ps=1.38u w=1u l=0.13u
X304 SC1/vss nh_sw[10] SC1/buf_1_1.z SC1/vss sg13_lv_nmos ad=0.17p pd=1.68u as=0.17p ps=1.68u w=0.5u l=0.13u
X305 SC1/buf_16_1.z nl_sw[2] SC1/vss SC1/vss sg13_lv_nmos ad=95f pd=0.88u as=95f ps=0.88u w=0.5u l=0.13u
X306 SC1/buf_32_0.z nl_sw[0] SC1/vss SC1/vss sg13_lv_nmos ad=95f pd=0.88u as=95f ps=0.88u w=0.5u l=0.13u
X307 SC1/vss nh_sw[2] SC1/buf_16_0.z SC1/vss sg13_lv_nmos ad=95f pd=0.88u as=95f ps=0.88u w=0.5u l=0.13u
X308 SC1/buf_16_1.z nl_sw[2] vdd vdd sg13_lv_pmos ad=0.19p pd=1.38u as=0.19p ps=1.38u w=1u l=0.13u
X309 SC1/buf_16_2.z nl_sw[1] vdd vdd sg13_lv_pmos ad=0.34p pd=2.68u as=0.19p ps=1.38u w=1u l=0.13u
X310 SC1/buf_16_1.z nl_sw[2] SC1/vss SC1/vss sg13_lv_nmos ad=95f pd=0.88u as=95f ps=0.88u w=0.5u l=0.13u
X311 SC1/vss nh_sw[9] SC1/buf_2_3.z SC1/vss sg13_lv_nmos ad=95f pd=0.88u as=0.17p ps=1.68u w=0.5u l=0.13u
X312 SC1/buf_8_1.z nl_sw[3] SC1/vss SC1/vss sg13_lv_nmos ad=0.17p pd=1.68u as=95f ps=0.88u w=0.5u l=0.13u
X313 SC1/vss nl_sw[10] SC1/buf_1_0.z SC1/vss sg13_lv_nmos ad=0.17p pd=1.68u as=0.17p ps=1.68u w=0.5u l=0.13u
X314 SC1/buf_32_0.z nl_sw[0] vdd vdd sg13_lv_pmos ad=0.19p pd=1.38u as=0.19p ps=1.38u w=1u l=0.13u
X315 vdd nh_sw[0] SC1/buf_32_1.z vdd sg13_lv_pmos ad=0.19p pd=1.38u as=0.19p ps=1.38u w=1u l=0.13u
X316 SC1/buf_8_4.z nl_sw[5] vdd vdd sg13_lv_pmos ad=0.34p pd=2.68u as=0.19p ps=1.38u w=1u l=0.13u
X317 SC1/vss nl_sw[0] SC1/buf_32_0.z SC1/vss sg13_lv_nmos ad=95f pd=0.88u as=95f ps=0.88u w=0.5u l=0.13u
X318 SC1/vss nh_sw[0] SC1/buf_32_1.z SC1/vss sg13_lv_nmos ad=95f pd=0.88u as=0.17p ps=1.68u w=0.5u l=0.13u
X319 SC1/buf_16_0.z nh_sw[2] vdd vdd sg13_lv_pmos ad=0.19p pd=1.38u as=0.19p ps=1.38u w=1u l=0.13u
X320 SC1/buf_16_3.z nh_sw[1] vdd vdd sg13_lv_pmos ad=0.19p pd=1.38u as=0.19p ps=1.38u w=1u l=0.13u
X321 SC1/vss nh_sw[1] SC1/buf_16_3.z SC1/vss sg13_lv_nmos ad=95f pd=0.88u as=95f ps=0.88u w=0.5u l=0.13u
X322 SC1/buf_32_1.z nh_sw[0] vdd vdd sg13_lv_pmos ad=0.19p pd=1.38u as=0.19p ps=1.38u w=1u l=0.13u
X323 SC1/buf_8_0.z nl_sw[4] SC1/vss SC1/vss sg13_lv_nmos ad=95f pd=0.88u as=95f ps=0.88u w=0.5u l=0.13u
X324 SC1/buf_32_0.z nl_sw[0] SC1/vss SC1/vss sg13_lv_nmos ad=95f pd=0.88u as=95f ps=0.88u w=0.5u l=0.13u
X325 SC1/vss nh_sw[2] SC1/buf_16_0.z SC1/vss sg13_lv_nmos ad=95f pd=0.88u as=95f ps=0.88u w=0.5u l=0.13u
X326 SC1/buf_32_1.z nh_sw[0] SC1/vss SC1/vss sg13_lv_nmos ad=95f pd=0.88u as=95f ps=0.88u w=0.5u l=0.13u
X327 SC1/vss nl_sw[6] SC1/buf_4_3.z SC1/vss sg13_lv_nmos ad=95f pd=0.88u as=95f ps=0.88u w=0.5u l=0.13u
X328 SC1/buf_32_0.z nl_sw[0] vdd vdd sg13_lv_pmos ad=0.19p pd=1.38u as=0.19p ps=1.38u w=1u l=0.13u
X329 vdd nl_sw[3] SC1/buf_8_1.z vdd sg13_lv_pmos ad=0.19p pd=1.38u as=0.34p ps=2.68u w=1u l=0.13u
X330 vdd nh_sw[0] SC1/buf_32_1.z vdd sg13_lv_pmos ad=0.19p pd=1.38u as=0.19p ps=1.38u w=1u l=0.13u
X331 vdd nl_sw[1] SC1/buf_16_2.z vdd sg13_lv_pmos ad=0.19p pd=1.38u as=0.34p ps=2.68u w=1u l=0.13u
X332 vdd nh_sw[7] SC1/buf_4_2.z vdd sg13_lv_pmos ad=0.19p pd=1.38u as=0.19p ps=1.38u w=1u l=0.13u
X333 SC1/buf_16_3.z nh_sw[1] SC1/vss SC1/vss sg13_lv_nmos ad=95f pd=0.88u as=95f ps=0.88u w=0.5u l=0.13u
X334 SC1/vss nl_sw[0] SC1/buf_32_0.z SC1/vss sg13_lv_nmos ad=95f pd=0.88u as=95f ps=0.88u w=0.5u l=0.13u
X335 SC1/buf_8_2.z nh_sw[4] SC1/vss SC1/vss sg13_lv_nmos ad=95f pd=0.88u as=95f ps=0.88u w=0.5u l=0.13u
X336 SC1/vss nh_sw[0] SC1/buf_32_1.z SC1/vss sg13_lv_nmos ad=95f pd=0.88u as=95f ps=0.88u w=0.5u l=0.13u
X337 vdd nh_sw[0] SC1/buf_32_1.z vdd sg13_lv_pmos ad=0.19p pd=1.38u as=0.19p ps=1.38u w=1u l=0.13u
X338 SC1/buf_16_0.z nh_sw[2] vdd vdd sg13_lv_pmos ad=0.19p pd=1.38u as=0.19p ps=1.38u w=1u l=0.13u
X339 SC1/buf_32_1.z nh_sw[0] SC1/vss SC1/vss sg13_lv_nmos ad=0.17p pd=1.68u as=95f ps=0.88u w=0.5u l=0.13u
X340 vdd nh_sw[1] SC1/buf_16_3.z vdd sg13_lv_pmos ad=0.19p pd=1.38u as=0.34p ps=2.68u w=1u l=0.13u
X341 SC1/buf_16_2.z nl_sw[1] SC1/vss SC1/vss sg13_lv_nmos ad=95f pd=0.88u as=95f ps=0.88u w=0.5u l=0.13u
X342 SC1/buf_8_5.z nh_sw[5] vdd vdd sg13_lv_pmos ad=0.34p pd=2.68u as=0.19p ps=1.38u w=1u l=0.13u
X343 SC1/vss nl_sw[1] SC1/buf_16_2.z SC1/vss sg13_lv_nmos ad=95f pd=0.88u as=95f ps=0.88u w=0.5u l=0.13u
X344 SC1/buf_32_1.z nh_sw[0] vdd vdd sg13_lv_pmos ad=0.19p pd=1.38u as=0.19p ps=1.38u w=1u l=0.13u
X345 SC1/buf_8_3.z nh_sw[3] SC1/vss SC1/vss sg13_lv_nmos ad=95f pd=0.88u as=95f ps=0.88u w=0.5u l=0.13u
X346 SC1/buf_32_0.z nl_sw[0] SC1/vss SC1/vss sg13_lv_nmos ad=95f pd=0.88u as=95f ps=0.88u w=0.5u l=0.13u
X347 vdd nh_sw[3] SC1/buf_8_3.z vdd sg13_lv_pmos ad=0.19p pd=1.38u as=0.19p ps=1.38u w=1u l=0.13u
X348 SC1/buf_16_2.z nl_sw[1] vdd vdd sg13_lv_pmos ad=0.19p pd=1.38u as=0.19p ps=1.38u w=1u l=0.13u
X349 SC1/buf_16_1.z nl_sw[2] vdd vdd sg13_lv_pmos ad=0.19p pd=1.38u as=0.19p ps=1.38u w=1u l=0.13u
X350 vdd nl_sw[0] SC1/buf_32_0.z vdd sg13_lv_pmos ad=0.19p pd=1.38u as=0.19p ps=1.38u w=1u l=0.13u
X351 vdd nh_sw[4] SC1/buf_8_2.z vdd sg13_lv_pmos ad=0.19p pd=1.38u as=0.19p ps=1.38u w=1u l=0.13u
X352 SC1/vss nh_sw[7] SC1/buf_4_2.z SC1/vss sg13_lv_nmos ad=95f pd=0.88u as=0.17p ps=1.68u w=0.5u l=0.13u
X353 SC1/buf_16_3.z nh_sw[1] vdd vdd sg13_lv_pmos ad=0.19p pd=1.38u as=0.19p ps=1.38u w=1u l=0.13u
X354 vdd nh_sw[0] SC1/buf_32_1.z vdd sg13_lv_pmos ad=0.19p pd=1.38u as=0.19p ps=1.38u w=1u l=0.13u
X355 SC1/buf_16_3.z nh_sw[1] SC1/vss SC1/vss sg13_lv_nmos ad=95f pd=0.88u as=95f ps=0.88u w=0.5u l=0.13u
X356 vdd nl_sw[4] SC1/buf_8_0.z vdd sg13_lv_pmos ad=0.19p pd=1.38u as=0.19p ps=1.38u w=1u l=0.13u
X357 SC1/vss nl_sw[0] SC1/buf_32_0.z SC1/vss sg13_lv_nmos ad=95f pd=0.88u as=95f ps=0.88u w=0.5u l=0.13u
X358 SC1/buf_16_0.z nh_sw[2] vdd vdd sg13_lv_pmos ad=0.19p pd=1.38u as=0.19p ps=1.38u w=1u l=0.13u
X359 SC1/vss nl_sw[2] SC1/buf_16_1.z SC1/vss sg13_lv_nmos ad=95f pd=0.88u as=95f ps=0.88u w=0.5u l=0.13u
X360 SC1/buf_8_5.z nh_sw[5] vdd vdd sg13_lv_pmos ad=0.19p pd=1.38u as=0.19p ps=1.38u w=1u l=0.13u
X361 SC1/vss nl_sw[4] SC1/buf_8_0.z SC1/vss sg13_lv_nmos ad=95f pd=0.88u as=95f ps=0.88u w=0.5u l=0.13u
X362 vdd nl_sw[2] SC1/buf_16_1.z vdd sg13_lv_pmos ad=0.19p pd=1.38u as=0.19p ps=1.38u w=1u l=0.13u
X363 vdd nl_sw[1] SC1/buf_16_2.z vdd sg13_lv_pmos ad=0.19p pd=1.38u as=0.19p ps=1.38u w=1u l=0.13u
X364 vdd nh_sw[3] SC1/buf_8_3.z vdd sg13_lv_pmos ad=0.19p pd=1.38u as=0.34p ps=2.68u w=1u l=0.13u
X365 SC1/buf_8_4.z nl_sw[5] SC1/vss SC1/vss sg13_lv_nmos ad=95f pd=0.88u as=95f ps=0.88u w=0.5u l=0.13u
X366 SC1/vss nl_sw[3] SC1/buf_8_1.z SC1/vss sg13_lv_nmos ad=95f pd=0.88u as=95f ps=0.88u w=0.5u l=0.13u
X367 vdd nl_sw[0] SC1/buf_32_0.z vdd sg13_lv_pmos ad=0.19p pd=1.38u as=0.34p ps=2.68u w=1u l=0.13u
X368 vdd nh_sw[4] SC1/buf_8_2.z vdd sg13_lv_pmos ad=0.19p pd=1.38u as=0.19p ps=1.38u w=1u l=0.13u
X369 SC1/buf_2_3.z nh_sw[9] vdd vdd sg13_lv_pmos ad=0.34p pd=2.68u as=0.19p ps=1.38u w=1u l=0.13u
X370 vdd nl_sw[5] SC1/buf_8_4.z vdd sg13_lv_pmos ad=0.19p pd=1.38u as=0.19p ps=1.38u w=1u l=0.13u
X371 SC1/buf_8_5.z nh_sw[5] SC1/vss SC1/vss sg13_lv_nmos ad=95f pd=0.88u as=95f ps=0.88u w=0.5u l=0.13u
X372 SC1/buf_32_0.z nl_sw[0] vdd vdd sg13_lv_pmos ad=0.19p pd=1.38u as=0.19p ps=1.38u w=1u l=0.13u
X373 SC1/buf_16_3.z nh_sw[1] SC1/vss SC1/vss sg13_lv_nmos ad=95f pd=0.88u as=95f ps=0.88u w=0.5u l=0.13u
X374 SC1/buf_16_0.z nh_sw[2] SC1/vss SC1/vss sg13_lv_nmos ad=0.17p pd=1.68u as=95f ps=0.88u w=0.5u l=0.13u
X375 SC1/buf_16_0.z nh_sw[2] SC1/vss SC1/vss sg13_lv_nmos ad=95f pd=0.88u as=95f ps=0.88u w=0.5u l=0.13u
X376 SC1/vss nh_sw[6] SC1/buf_4_1.z SC1/vss sg13_lv_nmos ad=95f pd=0.88u as=95f ps=0.88u w=0.5u l=0.13u
X377 SC1/vss nh_sw[0] SC1/buf_32_1.z SC1/vss sg13_lv_nmos ad=95f pd=0.88u as=95f ps=0.88u w=0.5u l=0.13u
X378 SC1/buf_32_0.z nl_sw[0] vdd vdd sg13_lv_pmos ad=0.34p pd=2.68u as=0.19p ps=1.38u w=1u l=0.13u
X379 SC1/buf_4_1.z nh_sw[6] vdd vdd sg13_lv_pmos ad=0.34p pd=2.68u as=0.19p ps=1.38u w=1u l=0.13u
X380 SC1/buf_8_1.z nl_sw[3] vdd vdd sg13_lv_pmos ad=0.19p pd=1.38u as=0.19p ps=1.38u w=1u l=0.13u
X381 vdd nl_sw[0] SC1/buf_32_0.z vdd sg13_lv_pmos ad=0.19p pd=1.38u as=0.19p ps=1.38u w=1u l=0.13u
X382 SC1/buf_32_0.z nl_sw[0] SC1/vss SC1/vss sg13_lv_nmos ad=95f pd=0.88u as=95f ps=0.88u w=0.5u l=0.13u
X383 SC1/buf_32_1.z nh_sw[0] SC1/vss SC1/vss sg13_lv_nmos ad=95f pd=0.88u as=95f ps=0.88u w=0.5u l=0.13u
X384 SC1/vss nh_sw[0] SC1/buf_32_1.z SC1/vss sg13_lv_nmos ad=95f pd=0.88u as=95f ps=0.88u w=0.5u l=0.13u
X385 vdd nl_sw[6] SC1/buf_4_3.z vdd sg13_lv_pmos ad=0.19p pd=1.38u as=0.19p ps=1.38u w=1u l=0.13u
X386 vdd nh_sw[0] SC1/buf_32_1.z vdd sg13_lv_pmos ad=0.19p pd=1.38u as=0.19p ps=1.38u w=1u l=0.13u
X387 SC1/vss nl_sw[0] SC1/buf_32_0.z SC1/vss sg13_lv_nmos ad=95f pd=0.88u as=95f ps=0.88u w=0.5u l=0.13u
X388 vdd nl_sw[1] SC1/buf_16_2.z vdd sg13_lv_pmos ad=0.19p pd=1.38u as=0.19p ps=1.38u w=1u l=0.13u
X389 SC1/buf_4_0.z nl_sw[7] SC1/vss SC1/vss sg13_lv_nmos ad=95f pd=0.88u as=95f ps=0.88u w=0.5u l=0.13u
X390 vdd nl_sw[5] SC1/buf_8_4.z vdd sg13_lv_pmos ad=0.19p pd=1.38u as=0.34p ps=2.68u w=1u l=0.13u
X391 vdd nh_sw[1] SC1/buf_16_3.z vdd sg13_lv_pmos ad=0.19p pd=1.38u as=0.19p ps=1.38u w=1u l=0.13u
X392 vdd nl_sw[2] SC1/buf_16_1.z vdd sg13_lv_pmos ad=0.19p pd=1.38u as=0.34p ps=2.68u w=1u l=0.13u
X393 SC1/buf_32_1.z nh_sw[0] vdd vdd sg13_lv_pmos ad=0.19p pd=1.38u as=0.19p ps=1.38u w=1u l=0.13u
X394 SC1/vss nh_sw[1] SC1/buf_16_3.z SC1/vss sg13_lv_nmos ad=95f pd=0.88u as=95f ps=0.88u w=0.5u l=0.13u
X395 vdd nh_sw[2] SC1/buf_16_0.z vdd sg13_lv_pmos ad=0.19p pd=1.38u as=0.19p ps=1.38u w=1u l=0.13u
X396 SC1/buf_2_0.z nh_sw[8] SC1/vss SC1/vss sg13_lv_nmos ad=0.17p pd=1.68u as=95f ps=0.88u w=0.5u l=0.13u
X397 SC1/buf_16_1.z nl_sw[2] vdd vdd sg13_lv_pmos ad=0.19p pd=1.38u as=0.19p ps=1.38u w=1u l=0.13u
X398 vdd nh_sw[5] SC1/buf_8_5.z vdd sg13_lv_pmos ad=0.19p pd=1.38u as=0.19p ps=1.38u w=1u l=0.13u
X399 SC1/vss nl_sw[5] SC1/buf_8_4.z SC1/vss sg13_lv_nmos ad=95f pd=0.88u as=95f ps=0.88u w=0.5u l=0.13u
X400 SC1/buf_16_2.z nl_sw[1] SC1/vss SC1/vss sg13_lv_nmos ad=95f pd=0.88u as=95f ps=0.88u w=0.5u l=0.13u
X401 SC1/buf_8_0.z nl_sw[4] SC1/vss SC1/vss sg13_lv_nmos ad=95f pd=0.88u as=95f ps=0.88u w=0.5u l=0.13u
X402 vdd nl_sw[1] SC1/buf_16_2.z vdd sg13_lv_pmos ad=0.19p pd=1.38u as=0.19p ps=1.38u w=1u l=0.13u
X403 SC1/buf_8_2.z nh_sw[4] vdd vdd sg13_lv_pmos ad=0.19p pd=1.38u as=0.19p ps=1.38u w=1u l=0.13u
X0 vdd DBS/a_946_4012# DBS/a_878_4048# DBS/vss sg13_lv_nmos ad=0.442p pd=3.28u as=0.442p ps=3.28u w=1.3u l=0.13u
X1 _vin DBS/a_2906_942# DBS/a_2150_942# DBS/vss sg13_lv_nmos ad=1.02p pd=6.68u as=1.02p ps=6.68u w=3u l=0.13u
X2 DBS/a_4042_6270# DBS/single_bsw_0.sg13cmos5l_inv_1$1_0.A DBS/vss DBS/vss sg13_lv_nmos ad=95f pd=0.88u as=0.17p ps=1.68u w=0.5u l=0.13u
X3 DBS/single_bsw_1.sg13cmos5l_inv_1$1_2.Y DBS/single_bsw_1.sg13cmos5l_inv_1$1_2.A DBS/vss DBS/vss sg13_lv_nmos ad=0.2516p pd=2.16u as=0.2516p ps=2.16u w=0.74u l=0.13u
X4 DBS/vss vdd DBS/vss DBS/vss sg13_lv_nmos ad=0.1428p pd=1.52u as=81.33254p ps=0.54442m w=0.42u l=1u
X5 vdd DBS/vss vdd vdd sg13_lv_pmos ad=0.34p pd=2.68u as=31.4284p ps=0.1861m w=1u l=1u
X6 DBS/a_2150_6110# DBS/single_bsw_0.sg13cmos5l_inv_1$1_0.A DBS/vss DBS/vss sg13_lv_nmos ad=0.442p pd=3.28u as=0.442p ps=3.28u w=1.3u l=0.4u
X7 vdd DBS/vss vdd vdd sg13_lv_pmos ad=0.34p pd=2.68u as=0 ps=0 w=1u l=1u
X8 DBS/vss vdd DBS/vss DBS/vss sg13_lv_nmos ad=0.1428p pd=1.52u as=0 ps=0 w=0.42u l=1u
X9 DBS/a_946_2908# DBS/a_878_3004# vdd DBS/vss sg13_lv_nmos ad=0.442p pd=3.28u as=0.442p ps=3.28u w=1.3u l=0.13u
X10 DBS/single_bsw_1.sg13cmos5l_inv_1$1_2.Y DBS/single_bsw_1.sg13cmos5l_inv_1$1_2.A vdd vdd sg13_lv_pmos ad=0.3808p pd=2.92u as=0.3808p ps=2.92u w=1.12u l=0.13u
X11 DBS/single_bsw_0.sg13cmos5l_inv_1$1_2.Y DBS/single_bsw_0.sg13cmos5l_inv_1$1_2.A DBS/vss DBS/vss sg13_lv_nmos ad=0.2516p pd=2.16u as=0.2516p ps=2.16u w=0.74u l=0.13u
X12 DBS/vss vdd DBS/vss DBS/vss sg13_lv_nmos ad=0.1428p pd=1.52u as=0 ps=0 w=0.42u l=1u
X13 DBS/a_3000_5770# vdd DBS/a_2906_4128# DBS/vss sg13_lv_nmos ad=0.57p pd=3.38u as=1.02p ps=6.68u w=3u l=0.13u
X14 DBS/a_946_4012# DBS/a_878_4048# vdd DBS/vss sg13_lv_nmos ad=0.442p pd=3.28u as=0.442p ps=3.28u w=1.3u l=0.13u
X15 _vin DBS/a_4144_942# vcn DBS/vss sg13_lv_nmos ad=0.85p pd=5.68u as=0.85p ps=5.68u w=2.5u l=0.13u
X16 DBS/single_bsw_1.sg13cmos5l_inv_1$1_0.A _cks vdd vdd sg13_lv_pmos ad=0.3808p pd=2.92u as=0.3808p ps=2.92u w=1.12u l=0.13u
X17 DBS/a_4144_5246# vdd DBS/a_4042_6270# DBS/vss sg13_lv_nmos ad=0.17p pd=1.68u as=95f ps=0.88u w=0.5u l=0.13u
X18 DBS/single_bsw_0.sg13cmos5l_inv_1$1_2.Y DBS/single_bsw_0.sg13cmos5l_inv_1$1_2.A vdd vdd sg13_lv_pmos ad=0.3808p pd=2.92u as=0.3808p ps=2.92u w=1.12u l=0.13u
X19 DBS/a_4144_5246# DBS/single_bsw_0.sg13cmos5l_inv_1$1_2.Y DBS/w_3740_4936# DBS/w_3740_4936# sg13_lv_pmos ad=0.17p pd=1.68u as=0.17p ps=1.68u w=0.5u l=0.13u
X20 DBS/single_bsw_1.sg13cmos5l_inv_1$1_0.Y DBS/single_bsw_1.sg13cmos5l_inv_1$1_0.A vdd vdd sg13_lv_pmos ad=0.3808p pd=2.92u as=0.3808p ps=2.92u w=1.12u l=0.13u
X21 vdd DBS/vss vdd vdd sg13_lv_pmos ad=0.34p pd=2.68u as=0 ps=0 w=1u l=1u
X22 vdd DBS/single_bsw_0.sg13cmos5l_inv_1$1_2.A DBS/a_2906_4128# vdd sg13_lv_pmos ad=0.17p pd=1.68u as=0.17p ps=1.68u w=0.5u l=0.13u
X23 DBS/vss DBS/single_bsw_1.sg13cmos5l_inv_1$1_0.A DBS/a_3000_942# DBS/vss sg13_lv_nmos ad=1.02p pd=6.68u as=0.57p ps=3.38u w=3u l=0.13u
X24 DBS/single_bsw_1.sg13cmos5l_inv_1$1_0.A _cks DBS/vss DBS/vss sg13_lv_nmos ad=0.2516p pd=2.16u as=0.2516p ps=2.16u w=0.74u l=0.13u
X25 DBS/single_bsw_1.sg13cmos5l_inv_1$1_0.Y DBS/single_bsw_1.sg13cmos5l_inv_1$1_0.A DBS/vss DBS/vss sg13_lv_nmos ad=0.2516p pd=2.16u as=0.2516p ps=2.16u w=0.74u l=0.13u
X26 DBS/single_bsw_0.sg13cmos5l_inv_1$1_0.A _cks vdd vdd sg13_lv_pmos ad=0.3808p pd=2.92u as=0.3808p ps=2.92u w=1.12u l=0.13u
X27 vdd DBS/single_bsw_1.sg13cmos5l_inv_1$1_2.A DBS/a_2906_942# vdd sg13_lv_pmos ad=0.17p pd=1.68u as=0.17p ps=1.68u w=0.5u l=0.13u
X28 DBS/a_2150_942# DBS/single_bsw_1.sg13cmos5l_inv_1$1_0.A DBS/vss DBS/vss sg13_lv_nmos ad=0.442p pd=3.28u as=0.442p ps=3.28u w=1.3u l=0.4u
X29 DBS/single_bsw_0.sg13cmos5l_inv_1$1_0.A _cks DBS/vss DBS/vss sg13_lv_nmos ad=0.2516p pd=2.16u as=0.2516p ps=2.16u w=0.74u l=0.13u
X30 DBS/a_3000_942# vdd DBS/a_2906_942# DBS/vss sg13_lv_nmos ad=0.57p pd=3.38u as=1.02p ps=6.68u w=3u l=0.13u
X31 DBS/single_bsw_0.sg13cmos5l_inv_1$1_0.Y DBS/single_bsw_0.sg13cmos5l_inv_1$1_0.A vdd vdd sg13_lv_pmos ad=0.3808p pd=2.92u as=0.3808p ps=2.92u w=1.12u l=0.13u
X32 vdd DBS/vss vdd vdd sg13_lv_pmos ad=0.34p pd=2.68u as=0 ps=0 w=1u l=1u
X33 DBS/a_4144_942# DBS/single_bsw_1.sg13cmos5l_inv_1$1_2.Y DBS/w_3740_1656# DBS/w_3740_1656# sg13_lv_pmos ad=0.17p pd=1.68u as=0.17p ps=1.68u w=0.5u l=0.13u
X34 DBS/single_bsw_0.sg13cmos5l_inv_1$1_0.Y DBS/single_bsw_0.sg13cmos5l_inv_1$1_0.A DBS/vss DBS/vss sg13_lv_nmos ad=0.2516p pd=2.16u as=0.2516p ps=2.16u w=0.74u l=0.13u
X35 DBS/w_3740_1656# DBS/a_878_3004# vdd DBS/vss sg13_lv_nmos ad=0.442p pd=3.28u as=0.442p ps=3.28u w=1.3u l=0.13u
X36 DBS/a_4042_942# DBS/single_bsw_1.sg13cmos5l_inv_1$1_0.A DBS/vss DBS/vss sg13_lv_nmos ad=95f pd=0.88u as=0.17p ps=1.68u w=0.5u l=0.13u
X37 vdd DBS/vss vdd vdd sg13_lv_pmos ad=0.34p pd=2.68u as=0 ps=0 w=1u l=1u
X38 _vip DBS/a_2906_4128# DBS/a_2150_6110# DBS/vss sg13_lv_nmos ad=1.02p pd=6.68u as=1.02p ps=6.68u w=3u l=0.13u
X39 DBS/a_4144_942# vdd DBS/a_4042_942# DBS/vss sg13_lv_nmos ad=0.17p pd=1.68u as=95f ps=0.88u w=0.5u l=0.13u
X40 DBS/w_3740_4936# DBS/a_878_4048# vdd DBS/vss sg13_lv_nmos ad=0.442p pd=3.28u as=0.442p ps=3.28u w=1.3u l=0.13u
X41 DBS/vss DBS/single_bsw_0.sg13cmos5l_inv_1$1_0.A DBS/a_3000_5770# DBS/vss sg13_lv_nmos ad=1.02p pd=6.68u as=0.57p ps=3.38u w=3u l=0.13u
X42 _vip DBS/a_4144_5246# vcp DBS/vss sg13_lv_nmos ad=0.85p pd=5.68u as=0.85p ps=5.68u w=2.5u l=0.13u
X43 DBS/vss vdd DBS/vss DBS/vss sg13_lv_nmos ad=0.1428p pd=1.52u as=0 ps=0 w=0.42u l=1u
X44 DBS/vss vdd DBS/vss DBS/vss sg13_lv_nmos ad=0.1428p pd=1.52u as=0 ps=0 w=0.42u l=1u
X45 vdd DBS/a_946_2908# DBS/a_878_3004# DBS/vss sg13_lv_nmos ad=0.442p pd=3.28u as=0.442p ps=3.28u w=1.3u l=0.13u
X46 DBS/vss vdd DBS/vss DBS/vss sg13_lv_nmos ad=0.1428p pd=1.52u as=0 ps=0 w=0.42u l=1u
X47 vdd DBS/vss vdd vdd sg13_lv_pmos ad=0.34p pd=2.68u as=0 ps=0 w=1u l=1u
X0 comp_p ckc vdd vdd sg13_lv_pmos ad=0.17p pd=1.68u as=95f ps=0.88u w=0.5u l=0.13u
X1 CMP/vss CMP/a_581042_926846# CMP/a_581154_926910# CMP/vss sg13_lv_nmos ad=0.1426p pd=1.16u as=0.1428p ps=1.52u w=0.42u l=0.5u
X2 CMP/sg13cmos5l_or2_1$1_0.X CMP/a_579900_927220# CMP/vss CMP/vss sg13_lv_nmos ad=0.2516p pd=2.16u as=0.1469p ps=1.155u w=0.74u l=0.13u
X3 CMP/vss vdd CMP/vss CMP/vss sg13_lv_nmos ad=0.1428p pd=1.52u as=41.9265p ps=0.27795m w=0.42u l=1u
X4 vdd ckc CMP/a_574318_928566# vdd sg13_lv_pmos ad=95f pd=0.88u as=0.17p ps=1.68u w=0.5u l=0.13u
X5 CMP/a_574934_925864# ckc CMP/vss CMP/vss sg13_lv_nmos ad=0.17p pd=1.68u as=95f ps=0.88u w=0.5u l=0.13u
X6 CMP/a_574934_925864# ckc CMP/vss CMP/vss sg13_lv_nmos ad=95f pd=0.88u as=95f ps=0.88u w=0.5u l=0.13u
X7 rdy CMP/a_581154_926910# vdd vdd sg13_lv_pmos ad=0.4256p pd=3u as=0.2254p ps=1.53u w=1.12u l=0.13u
X8 CMP/sg13cmos5l_inv_1$1_1.Y comp_n CMP/vss CMP/vss sg13_lv_nmos ad=0.2516p pd=2.16u as=0.2516p ps=2.16u w=0.74u l=0.13u
X9 CMP/a_577144_925864# vcp CMP/a_574934_925864# CMP/vss sg13_lv_nmos ad=1.7p pd=10.68u as=0.95p ps=5.38u w=5u l=0.13u
X10 CMP/vss CMP/sg13cmos5l_inv_1$1_0.Y CMP/a_579900_927220# CMP/vss sg13_lv_nmos ad=0.1469p pd=1.155u as=0.1045p ps=0.93u w=0.55u l=0.13u
X11 comp_n ckc vdd vdd sg13_lv_pmos ad=0.17p pd=1.68u as=95f ps=0.88u w=0.5u l=0.13u
X12 comp_n comp_p vdd vdd sg13_lv_pmos ad=0.425p pd=3.18u as=0.2375p ps=1.63u w=1.25u l=0.13u
X13 CMP/sg13cmos5l_inv_1$1_1.Y comp_n vdd vdd sg13_lv_pmos ad=0.3808p pd=2.92u as=0.3808p ps=2.92u w=1.12u l=0.13u
X14 CMP/a_577144_925864# comp_p comp_n CMP/vss sg13_lv_nmos ad=1.7p pd=10.68u as=0.95p ps=5.38u w=5u l=0.13u
X15 comp_p comp_n CMP/a_574318_928566# CMP/vss sg13_lv_nmos ad=0.95p pd=5.38u as=1.7p ps=10.68u w=5u l=0.13u
X16 CMP/a_579900_927220# CMP/sg13cmos5l_inv_1$1_1.Y CMP/vss CMP/vss sg13_lv_nmos ad=0.1045p pd=0.93u as=0.187p ps=1.78u w=0.55u l=0.13u
X17 CMP/vss CMP/sg13cmos5l_or2_1$1_0.X CMP/a_580772_926846# CMP/vss sg13_lv_nmos ad=79.8f pd=0.8u as=0.1428p ps=1.52u w=0.42u l=0.13u
X18 vdd comp_n comp_p vdd sg13_lv_pmos ad=0.2375p pd=1.63u as=0.425p ps=3.18u w=1.25u l=0.13u
X19 vdd ckc comp_p vdd sg13_lv_pmos ad=95f pd=0.88u as=0.17p ps=1.68u w=0.5u l=0.13u
X20 vdd CMP/a_581042_926846# CMP/a_581154_926910# vdd sg13_lv_pmos ad=0.2254p pd=1.53u as=0.34p ps=2.68u w=1u l=0.5u
X21 vdd CMP/vss vdd vdd sg13_lv_pmos ad=0.34p pd=2.68u as=42.0809p ps=0.28309m w=1u l=1u
X22 vdd CMP/sg13cmos5l_or2_1$1_0.X CMP/a_580772_926846# vdd sg13_lv_pmos ad=0.1523p pd=1.38u as=0.1428p ps=1.52u w=0.42u l=0.13u
X23 CMP/sg13cmos5l_inv_1$1_0.Y comp_p CMP/vss CMP/vss sg13_lv_nmos ad=0.2516p pd=2.16u as=0.2516p ps=2.16u w=0.74u l=0.13u
X24 rdy CMP/a_581154_926910# CMP/vss CMP/vss sg13_lv_nmos ad=0.2516p pd=2.16u as=0.1426p ps=1.16u w=0.74u l=0.13u
X25 CMP/a_574318_928566# ckc vdd vdd sg13_lv_pmos ad=0.17p pd=1.68u as=95f ps=0.88u w=0.5u l=0.13u
X26 comp_p comp_n vdd vdd sg13_lv_pmos ad=0.425p pd=3.18u as=0.2375p ps=1.63u w=1.25u l=0.13u
X27 CMP/vss ckc CMP/a_574934_925864# CMP/vss sg13_lv_nmos ad=95f pd=0.88u as=95f ps=0.88u w=0.5u l=0.13u
X28 CMP/vss ckc CMP/a_574934_925864# CMP/vss sg13_lv_nmos ad=95f pd=0.88u as=0.17p ps=1.68u w=0.5u l=0.13u
X29 CMP/sg13cmos5l_inv_1$1_0.Y comp_p vdd vdd sg13_lv_pmos ad=0.3808p pd=2.92u as=0.3808p ps=2.92u w=1.12u l=0.13u
X30 vdd CMP/sg13cmos5l_inv_1$1_0.Y CMP/a_579994_927220# vdd sg13_lv_pmos ad=0.2226p pd=1.535u as=0.1596p ps=1.22u w=0.84u l=0.13u
X31 CMP/a_574934_925864# vcn CMP/a_574318_928566# CMP/vss sg13_lv_nmos ad=0.95p pd=5.38u as=1.7p ps=10.68u w=5u l=0.13u
X32 CMP/vss vdd CMP/vss CMP/vss sg13_lv_nmos ad=0.1428p pd=1.52u as=0 ps=0 w=0.42u l=1u
X33 CMP/a_577144_925864# ckc vdd vdd sg13_lv_pmos ad=0.17p pd=1.68u as=95f ps=0.88u w=0.5u l=0.13u
X34 CMP/a_574934_925864# vcp CMP/a_577144_925864# CMP/vss sg13_lv_nmos ad=0.95p pd=5.38u as=1.7p ps=10.68u w=5u l=0.13u
X35 CMP/a_581042_926846# CMP/a_580772_926846# vdd vdd sg13_lv_pmos ad=0.34p pd=2.68u as=0.1523p ps=1.38u w=1u l=0.5u
X36 vdd ckc comp_n vdd sg13_lv_pmos ad=95f pd=0.88u as=0.17p ps=1.68u w=0.5u l=0.13u
X37 vdd comp_p comp_n vdd sg13_lv_pmos ad=0.2375p pd=1.63u as=0.425p ps=3.18u w=1.25u l=0.13u
X38 comp_n comp_p CMP/a_577144_925864# CMP/vss sg13_lv_nmos ad=0.95p pd=5.38u as=1.7p ps=10.68u w=5u l=0.13u
X39 CMP/a_579994_927220# CMP/sg13cmos5l_inv_1$1_1.Y CMP/a_579900_927220# vdd sg13_lv_pmos ad=0.1596p pd=1.22u as=0.2856p ps=2.36u w=0.84u l=0.13u
X40 CMP/a_574318_928566# comp_n comp_p CMP/vss sg13_lv_nmos ad=1.7p pd=10.68u as=0.95p ps=5.38u w=5u l=0.13u
X41 CMP/a_581042_926846# CMP/a_580772_926846# CMP/vss CMP/vss sg13_lv_nmos ad=0.1428p pd=1.52u as=79.8f ps=0.8u w=0.42u l=0.5u
X42 vdd ckc CMP/a_577144_925864# vdd sg13_lv_pmos ad=95f pd=0.88u as=0.17p ps=1.68u w=0.5u l=0.13u
X43 vdd CMP/vss vdd vdd sg13_lv_pmos ad=0.34p pd=2.68u as=0 ps=0 w=1u l=1u
X44 CMP/sg13cmos5l_or2_1$1_0.X CMP/a_579900_927220# vdd vdd sg13_lv_pmos ad=0.3976p pd=2.95u as=0.2226p ps=1.535u w=1.12u l=0.13u
X45 CMP/a_574318_928566# vcn CMP/a_574934_925864# CMP/vss sg13_lv_nmos ad=1.7p pd=10.68u as=0.95p ps=5.38u w=5u l=0.13u
X0 P0/iovdd_uq0 P0/a_5044_13476# vip P0/iovdd_uq0 sg13_hv_pmos ad=2.1312p pd=7.3u as=3.9294p ps=7.84u w=6.66u l=0.6u
X1 vip P0/a_5044_1676# vss vss sg13_hv_nmos ad=2.596p pd=5.58u as=1.408p ps=5.04u w=4.4u l=0.6u
X2 vip P0/a_5044_13476# P0/iovdd_uq0 P0/iovdd_uq0 sg13_hv_pmos ad=3.9294p pd=7.84u as=2.1312p ps=7.3u w=6.66u l=0.6u
X3 P0/iovdd_uq0 P0/a_5044_13476# vip P0/iovdd_uq0 sg13_hv_pmos ad=2.1312p pd=7.3u as=3.9294p ps=7.84u w=6.66u l=0.6u
X4 P0/iovdd_uq0 P0/a_5044_13476# vip P0/iovdd_uq0 sg13_hv_pmos ad=2.1312p pd=7.3u as=3.9294p ps=7.84u w=6.66u l=0.6u
X5 vip P0/a_5044_1676# vss vss sg13_hv_nmos ad=2.596p pd=5.58u as=1.408p ps=5.04u w=4.4u l=0.6u
X6 vip P0/a_5044_13476# P0/iovdd_uq0 P0/iovdd_uq0 sg13_hv_pmos ad=3.9294p pd=7.84u as=2.1312p ps=7.3u w=6.66u l=0.6u
X7 P0/iovdd_uq0 P0/a_5044_13476# vip P0/iovdd_uq0 sg13_hv_pmos ad=2.1312p pd=7.3u as=3.9294p ps=7.84u w=6.66u l=0.6u
X8 vip P0/a_5044_1676# vss vss sg13_hv_nmos ad=2.596p pd=5.58u as=1.408p ps=5.04u w=4.4u l=0.6u
X9 vss P0/a_5044_1676# vip vss sg13_hv_nmos ad=2.068p pd=9.74u as=2.596p ps=5.58u w=4.4u l=0.6u
X10 vip P0/a_5044_13476# P0/iovdd_uq0 P0/iovdd_uq0 sg13_hv_pmos ad=3.9294p pd=7.84u as=2.1312p ps=7.3u w=6.66u l=0.6u
X11 P0/a_5044_13476# P0/iovdd_uq0 P0/iovdd_uq0 P0/rppd l=12.9u w=0.5u
X12 vss P0/a_5044_1676# vip vss sg13_hv_nmos ad=1.408p pd=5.04u as=2.596p ps=5.58u w=4.4u l=0.6u
X13 vip P0/a_5044_13476# P0/iovdd_uq0 P0/iovdd_uq0 sg13_hv_pmos ad=3.9294p pd=7.84u as=2.1312p ps=7.3u w=6.66u l=0.6u
X14 vss P0/a_5222_4862# P0/dantenna P0/l=1.26u w=27.78u
X15 vss P0/a_5044_1676# vip vss sg13_hv_nmos ad=1.408p pd=5.04u as=2.596p ps=5.58u w=4.4u l=0.6u
X16 vip P0/a_5044_1676# vss vss sg13_hv_nmos ad=2.596p pd=5.58u as=1.408p ps=5.04u w=4.4u l=0.6u
X17 vss P0/a_5044_1676# vip vss sg13_hv_nmos ad=1.408p pd=5.04u as=2.596p ps=5.58u w=4.4u l=0.6u
X18 P0/iovdd_uq0 P0/a_5044_13476# vip P0/iovdd_uq0 sg13_hv_pmos ad=2.1312p pd=7.3u as=3.9294p ps=7.84u w=6.66u l=0.6u
X19 vip P0/a_5044_1676# vss vss sg13_hv_nmos ad=2.596p pd=5.58u as=1.408p ps=5.04u w=4.4u l=0.6u
X20 vip P0/a_5044_13476# P0/iovdd_uq0 P0/iovdd_uq0 sg13_hv_pmos ad=3.9294p pd=7.84u as=2.1312p ps=7.3u w=6.66u l=0.6u
X21 P0/iovdd_uq0 P0/a_5044_13476# vip P0/iovdd_uq0 sg13_hv_pmos ad=2.1312p pd=7.3u as=3.9294p ps=7.84u w=6.66u l=0.6u
X22 vip P0/a_5044_13476# P0/iovdd_uq0 P0/iovdd_uq0 sg13_hv_pmos ad=3.9294p pd=7.84u as=2.1312p ps=7.3u w=6.66u l=0.6u
X23 vip P0/a_5044_13476# P0/iovdd_uq0 P0/iovdd_uq0 sg13_hv_pmos ad=3.9294p pd=7.84u as=2.1312p ps=7.3u w=6.66u l=0.6u
X24 vss P0/a_5044_1676# vip vss sg13_hv_nmos ad=1.408p pd=5.04u as=2.596p ps=5.58u w=4.4u l=0.6u
X25 _vip P0/iovdd P0/dpantenna P0/l=0.64u w=4.98u
X26 P0/iovdd_uq0 P0/a_5044_13476# vip P0/iovdd_uq0 sg13_hv_pmos ad=2.1312p pd=7.3u as=3.9294p ps=7.84u w=6.66u l=0.6u
X27 vip P0/a_5044_13476# P0/iovdd_uq0 P0/iovdd_uq0 sg13_hv_pmos ad=3.9294p pd=7.84u as=2.1312p ps=7.3u w=6.66u l=0.6u
X28 vip P0/a_5044_13476# P0/iovdd_uq0 P0/iovdd_uq0 sg13_hv_pmos ad=3.9294p pd=7.84u as=2.1312p ps=7.3u w=6.66u l=0.6u
X29 vip P0/a_5044_1676# vss vss sg13_hv_nmos ad=2.596p pd=5.58u as=1.408p ps=5.04u w=4.4u l=0.6u
X30 P0/iovdd_uq0 P0/a_5044_13476# vip P0/iovdd_uq0 sg13_hv_pmos ad=2.1312p pd=7.3u as=3.9294p ps=7.84u w=6.66u l=0.6u
X31 _vip vip vss P0/rppd l=2u w=1u
X32 P0/iovdd_uq0 P0/a_5044_13476# vip P0/iovdd_uq0 sg13_hv_pmos ad=2.1312p pd=7.3u as=3.9294p ps=7.84u w=6.66u l=0.6u
X33 P0/iovdd_uq0 P0/a_5044_13476# vip P0/iovdd_uq0 sg13_hv_pmos ad=2.1312p pd=7.3u as=3.9294p ps=7.84u w=6.66u l=0.6u
X34 vip P0/a_5044_13476# P0/iovdd_uq0 P0/iovdd_uq0 sg13_hv_pmos ad=3.9294p pd=7.84u as=2.1312p ps=7.3u w=6.66u l=0.6u
X35 vip P0/a_5044_1676# vss vss sg13_hv_nmos ad=2.596p pd=5.58u as=1.408p ps=5.04u w=4.4u l=0.6u
X36 vss P0/a_5044_1676# vip vss sg13_hv_nmos ad=1.408p pd=5.04u as=2.596p ps=5.58u w=4.4u l=0.6u
X37 vip P0/a_5044_1676# vss vss sg13_hv_nmos ad=2.596p pd=5.58u as=1.408p ps=5.04u w=4.4u l=0.6u
X38 P0/iovdd_uq0 P0/a_5044_13476# vip P0/iovdd_uq0 sg13_hv_pmos ad=2.1312p pd=7.3u as=3.9294p ps=7.84u w=6.66u l=0.6u
X39 vip P0/a_5044_13476# P0/iovdd_uq0 P0/iovdd_uq0 sg13_hv_pmos ad=3.9294p pd=7.84u as=2.1312p ps=7.3u w=6.66u l=0.6u
X40 vip P0/iovdd_uq0 P0/dpantenna P0/l=1.26u w=27.78u
X41 vss P0/a_5044_1676# vip vss sg13_hv_nmos ad=1.408p pd=5.04u as=2.596p ps=5.58u w=4.4u l=0.6u
X42 P0/iovdd_uq0 P0/a_5044_13476# vip P0/iovdd_uq0 sg13_hv_pmos ad=2.1312p pd=7.3u as=3.9294p ps=7.84u w=6.66u l=0.6u
X43 vss P0/a_5044_1676# vip vss sg13_hv_nmos ad=1.408p pd=5.04u as=2.596p ps=5.58u w=4.4u l=0.6u
X44 vip P0/a_5044_13476# P0/iovdd_uq0 P0/iovdd_uq0 sg13_hv_pmos ad=3.9294p pd=7.84u as=2.1312p ps=7.3u w=6.66u l=0.6u
X45 P0/iovdd_uq0 P0/a_5044_13476# vip P0/iovdd_uq0 sg13_hv_pmos ad=2.1312p pd=7.3u as=3.9294p ps=7.84u w=6.66u l=0.6u
X46 vip P0/a_5044_13476# P0/iovdd_uq0 P0/iovdd_uq0 sg13_hv_pmos ad=3.9294p pd=7.84u as=2.1312p ps=7.3u w=6.66u l=0.6u
X47 vip P0/a_5044_1676# vss vss sg13_hv_nmos ad=2.596p pd=5.58u as=1.408p ps=5.04u w=4.4u l=0.6u
X48 vss P0/a_5044_1676# vip vss sg13_hv_nmos ad=1.408p pd=5.04u as=2.596p ps=5.58u w=4.4u l=0.6u
X49 vip P0/a_5044_13476# P0/iovdd_uq0 P0/iovdd_uq0 sg13_hv_pmos ad=3.9294p pd=7.84u as=3.1302p ps=14.26u w=6.66u l=0.6u
X50 P0/iovdd_uq0 P0/a_5044_13476# vip P0/iovdd_uq0 sg13_hv_pmos ad=3.1302p pd=14.26u as=3.9294p ps=7.84u w=6.66u l=0.6u
X51 P0/iovdd_uq0 P0/a_5044_13476# vip P0/iovdd_uq0 sg13_hv_pmos ad=2.1312p pd=7.3u as=3.9294p ps=7.84u w=6.66u l=0.6u
X52 vip P0/a_5044_13476# P0/iovdd_uq0 P0/iovdd_uq0 sg13_hv_pmos ad=3.9294p pd=7.84u as=2.1312p ps=7.3u w=6.66u l=0.6u
X53 vip P0/iovdd_uq0 P0/dpantenna P0/l=1.26u w=27.78u
X54 vip P0/a_5044_13476# P0/iovdd_uq0 P0/iovdd_uq0 sg13_hv_pmos ad=3.9294p pd=7.84u as=3.1302p ps=14.26u w=6.66u l=0.6u
X55 P0/iovdd_uq0 P0/a_5044_13476# vip P0/iovdd_uq0 sg13_hv_pmos ad=3.1302p pd=14.26u as=3.9294p ps=7.84u w=6.66u l=0.6u
X56 P0/iovdd_uq0 P0/a_5044_13476# vip P0/iovdd_uq0 sg13_hv_pmos ad=2.1312p pd=7.3u as=3.9294p ps=7.84u w=6.66u l=0.6u
X57 vip P0/a_5044_13476# P0/iovdd_uq0 P0/iovdd_uq0 sg13_hv_pmos ad=3.9294p pd=7.84u as=2.1312p ps=7.3u w=6.66u l=0.6u
X58 vss P0/a_11462_28198# P0/dantenna P0/l=3.1u w=0.64u
X59 vss P0/a_5222_3962# P0/dantenna P0/l=1.26u w=27.78u
X60 P0/a_5044_1676# vss vss P0/rppd l=3.54u w=0.5u
X61 P0/iovdd_uq0 P0/a_5044_13476# vip P0/iovdd_uq0 sg13_hv_pmos ad=2.1312p pd=7.3u as=3.9294p ps=7.84u w=6.66u l=0.6u
X62 P0/iovdd_uq0 P0/a_5044_13476# vip P0/iovdd_uq0 sg13_hv_pmos ad=2.1312p pd=7.3u as=3.9294p ps=7.84u w=6.66u l=0.6u
X63 vip P0/a_5044_1676# vss vss sg13_hv_nmos ad=2.596p pd=5.58u as=2.068p ps=9.74u w=4.4u l=0.6u
X64 P0/iovdd_uq0 P0/a_5044_13476# vip P0/iovdd_uq0 sg13_hv_pmos ad=2.1312p pd=7.3u as=3.9294p ps=7.84u w=6.66u l=0.6u
X65 vip P0/a_5044_13476# P0/iovdd_uq0 P0/iovdd_uq0 sg13_hv_pmos ad=3.9294p pd=7.84u as=2.1312p ps=7.3u w=6.66u l=0.6u
X66 vip P0/a_5044_13476# P0/iovdd_uq0 P0/iovdd_uq0 sg13_hv_pmos ad=3.9294p pd=7.84u as=2.1312p ps=7.3u w=6.66u l=0.6u
X67 vip P0/a_5044_13476# P0/iovdd_uq0 P0/iovdd_uq0 sg13_hv_pmos ad=3.9294p pd=7.84u as=2.1312p ps=7.3u w=6.66u l=0.6u
X68 vss P0/a_5044_1676# vip vss sg13_hv_nmos ad=1.408p pd=5.04u as=2.596p ps=5.58u w=4.4u l=0.6u
X0 P1/iovdd_uq0 P1/a_5044_13476# vin P1/iovdd_uq0 sg13_hv_pmos ad=2.1312p pd=7.3u as=3.9294p ps=7.84u w=6.66u l=0.6u
X1 vin P1/a_5044_1676# vss vss sg13_hv_nmos ad=2.596p pd=5.58u as=1.408p ps=5.04u w=4.4u l=0.6u
X2 vin P1/a_5044_13476# P1/iovdd_uq0 P1/iovdd_uq0 sg13_hv_pmos ad=3.9294p pd=7.84u as=2.1312p ps=7.3u w=6.66u l=0.6u
X3 P1/iovdd_uq0 P1/a_5044_13476# vin P1/iovdd_uq0 sg13_hv_pmos ad=2.1312p pd=7.3u as=3.9294p ps=7.84u w=6.66u l=0.6u
X4 P1/iovdd_uq0 P1/a_5044_13476# vin P1/iovdd_uq0 sg13_hv_pmos ad=2.1312p pd=7.3u as=3.9294p ps=7.84u w=6.66u l=0.6u
X5 vin P1/a_5044_1676# vss vss sg13_hv_nmos ad=2.596p pd=5.58u as=1.408p ps=5.04u w=4.4u l=0.6u
X6 vin P1/a_5044_13476# P1/iovdd_uq0 P1/iovdd_uq0 sg13_hv_pmos ad=3.9294p pd=7.84u as=2.1312p ps=7.3u w=6.66u l=0.6u
X7 P1/iovdd_uq0 P1/a_5044_13476# vin P1/iovdd_uq0 sg13_hv_pmos ad=2.1312p pd=7.3u as=3.9294p ps=7.84u w=6.66u l=0.6u
X8 vin P1/a_5044_1676# vss vss sg13_hv_nmos ad=2.596p pd=5.58u as=1.408p ps=5.04u w=4.4u l=0.6u
X9 vss P1/a_5044_1676# vin vss sg13_hv_nmos ad=2.068p pd=9.74u as=2.596p ps=5.58u w=4.4u l=0.6u
X10 vin P1/a_5044_13476# P1/iovdd_uq0 P1/iovdd_uq0 sg13_hv_pmos ad=3.9294p pd=7.84u as=2.1312p ps=7.3u w=6.66u l=0.6u
X11 P1/a_5044_13476# P1/iovdd_uq0 P1/iovdd_uq0 P1/rppd l=12.9u w=0.5u
X12 vss P1/a_5044_1676# vin vss sg13_hv_nmos ad=1.408p pd=5.04u as=2.596p ps=5.58u w=4.4u l=0.6u
X13 vin P1/a_5044_13476# P1/iovdd_uq0 P1/iovdd_uq0 sg13_hv_pmos ad=3.9294p pd=7.84u as=2.1312p ps=7.3u w=6.66u l=0.6u
X14 vss P1/a_5222_4862# P1/dantenna P1/l=1.26u w=27.78u
X15 vss P1/a_5044_1676# vin vss sg13_hv_nmos ad=1.408p pd=5.04u as=2.596p ps=5.58u w=4.4u l=0.6u
X16 vin P1/a_5044_1676# vss vss sg13_hv_nmos ad=2.596p pd=5.58u as=1.408p ps=5.04u w=4.4u l=0.6u
X17 vss P1/a_5044_1676# vin vss sg13_hv_nmos ad=1.408p pd=5.04u as=2.596p ps=5.58u w=4.4u l=0.6u
X18 P1/iovdd_uq0 P1/a_5044_13476# vin P1/iovdd_uq0 sg13_hv_pmos ad=2.1312p pd=7.3u as=3.9294p ps=7.84u w=6.66u l=0.6u
X19 vin P1/a_5044_1676# vss vss sg13_hv_nmos ad=2.596p pd=5.58u as=1.408p ps=5.04u w=4.4u l=0.6u
X20 vin P1/a_5044_13476# P1/iovdd_uq0 P1/iovdd_uq0 sg13_hv_pmos ad=3.9294p pd=7.84u as=2.1312p ps=7.3u w=6.66u l=0.6u
X21 P1/iovdd_uq0 P1/a_5044_13476# vin P1/iovdd_uq0 sg13_hv_pmos ad=2.1312p pd=7.3u as=3.9294p ps=7.84u w=6.66u l=0.6u
X22 vin P1/a_5044_13476# P1/iovdd_uq0 P1/iovdd_uq0 sg13_hv_pmos ad=3.9294p pd=7.84u as=2.1312p ps=7.3u w=6.66u l=0.6u
X23 vin P1/a_5044_13476# P1/iovdd_uq0 P1/iovdd_uq0 sg13_hv_pmos ad=3.9294p pd=7.84u as=2.1312p ps=7.3u w=6.66u l=0.6u
X24 vss P1/a_5044_1676# vin vss sg13_hv_nmos ad=1.408p pd=5.04u as=2.596p ps=5.58u w=4.4u l=0.6u
X25 _vin P1/iovdd P1/dpantenna P1/l=0.64u w=4.98u
X26 P1/iovdd_uq0 P1/a_5044_13476# vin P1/iovdd_uq0 sg13_hv_pmos ad=2.1312p pd=7.3u as=3.9294p ps=7.84u w=6.66u l=0.6u
X27 vin P1/a_5044_13476# P1/iovdd_uq0 P1/iovdd_uq0 sg13_hv_pmos ad=3.9294p pd=7.84u as=2.1312p ps=7.3u w=6.66u l=0.6u
X28 vin P1/a_5044_13476# P1/iovdd_uq0 P1/iovdd_uq0 sg13_hv_pmos ad=3.9294p pd=7.84u as=2.1312p ps=7.3u w=6.66u l=0.6u
X29 vin P1/a_5044_1676# vss vss sg13_hv_nmos ad=2.596p pd=5.58u as=1.408p ps=5.04u w=4.4u l=0.6u
X30 P1/iovdd_uq0 P1/a_5044_13476# vin P1/iovdd_uq0 sg13_hv_pmos ad=2.1312p pd=7.3u as=3.9294p ps=7.84u w=6.66u l=0.6u
X31 _vin vin vss P1/rppd l=2u w=1u
X32 P1/iovdd_uq0 P1/a_5044_13476# vin P1/iovdd_uq0 sg13_hv_pmos ad=2.1312p pd=7.3u as=3.9294p ps=7.84u w=6.66u l=0.6u
X33 P1/iovdd_uq0 P1/a_5044_13476# vin P1/iovdd_uq0 sg13_hv_pmos ad=2.1312p pd=7.3u as=3.9294p ps=7.84u w=6.66u l=0.6u
X34 vin P1/a_5044_13476# P1/iovdd_uq0 P1/iovdd_uq0 sg13_hv_pmos ad=3.9294p pd=7.84u as=2.1312p ps=7.3u w=6.66u l=0.6u
X35 vin P1/a_5044_1676# vss vss sg13_hv_nmos ad=2.596p pd=5.58u as=1.408p ps=5.04u w=4.4u l=0.6u
X36 vss P1/a_5044_1676# vin vss sg13_hv_nmos ad=1.408p pd=5.04u as=2.596p ps=5.58u w=4.4u l=0.6u
X37 vin P1/a_5044_1676# vss vss sg13_hv_nmos ad=2.596p pd=5.58u as=1.408p ps=5.04u w=4.4u l=0.6u
X38 P1/iovdd_uq0 P1/a_5044_13476# vin P1/iovdd_uq0 sg13_hv_pmos ad=2.1312p pd=7.3u as=3.9294p ps=7.84u w=6.66u l=0.6u
X39 vin P1/a_5044_13476# P1/iovdd_uq0 P1/iovdd_uq0 sg13_hv_pmos ad=3.9294p pd=7.84u as=2.1312p ps=7.3u w=6.66u l=0.6u
X40 vin P1/iovdd_uq0 P1/dpantenna P1/l=1.26u w=27.78u
X41 vss P1/a_5044_1676# vin vss sg13_hv_nmos ad=1.408p pd=5.04u as=2.596p ps=5.58u w=4.4u l=0.6u
X42 P1/iovdd_uq0 P1/a_5044_13476# vin P1/iovdd_uq0 sg13_hv_pmos ad=2.1312p pd=7.3u as=3.9294p ps=7.84u w=6.66u l=0.6u
X43 vss P1/a_5044_1676# vin vss sg13_hv_nmos ad=1.408p pd=5.04u as=2.596p ps=5.58u w=4.4u l=0.6u
X44 vin P1/a_5044_13476# P1/iovdd_uq0 P1/iovdd_uq0 sg13_hv_pmos ad=3.9294p pd=7.84u as=2.1312p ps=7.3u w=6.66u l=0.6u
X45 P1/iovdd_uq0 P1/a_5044_13476# vin P1/iovdd_uq0 sg13_hv_pmos ad=2.1312p pd=7.3u as=3.9294p ps=7.84u w=6.66u l=0.6u
X46 vin P1/a_5044_13476# P1/iovdd_uq0 P1/iovdd_uq0 sg13_hv_pmos ad=3.9294p pd=7.84u as=2.1312p ps=7.3u w=6.66u l=0.6u
X47 vin P1/a_5044_1676# vss vss sg13_hv_nmos ad=2.596p pd=5.58u as=1.408p ps=5.04u w=4.4u l=0.6u
X48 vss P1/a_5044_1676# vin vss sg13_hv_nmos ad=1.408p pd=5.04u as=2.596p ps=5.58u w=4.4u l=0.6u
X49 vin P1/a_5044_13476# P1/iovdd_uq0 P1/iovdd_uq0 sg13_hv_pmos ad=3.9294p pd=7.84u as=3.1302p ps=14.26u w=6.66u l=0.6u
X50 P1/iovdd_uq0 P1/a_5044_13476# vin P1/iovdd_uq0 sg13_hv_pmos ad=3.1302p pd=14.26u as=3.9294p ps=7.84u w=6.66u l=0.6u
X51 P1/iovdd_uq0 P1/a_5044_13476# vin P1/iovdd_uq0 sg13_hv_pmos ad=2.1312p pd=7.3u as=3.9294p ps=7.84u w=6.66u l=0.6u
X52 vin P1/a_5044_13476# P1/iovdd_uq0 P1/iovdd_uq0 sg13_hv_pmos ad=3.9294p pd=7.84u as=2.1312p ps=7.3u w=6.66u l=0.6u
X53 vin P1/iovdd_uq0 P1/dpantenna P1/l=1.26u w=27.78u
X54 vin P1/a_5044_13476# P1/iovdd_uq0 P1/iovdd_uq0 sg13_hv_pmos ad=3.9294p pd=7.84u as=3.1302p ps=14.26u w=6.66u l=0.6u
X55 P1/iovdd_uq0 P1/a_5044_13476# vin P1/iovdd_uq0 sg13_hv_pmos ad=3.1302p pd=14.26u as=3.9294p ps=7.84u w=6.66u l=0.6u
X56 P1/iovdd_uq0 P1/a_5044_13476# vin P1/iovdd_uq0 sg13_hv_pmos ad=2.1312p pd=7.3u as=3.9294p ps=7.84u w=6.66u l=0.6u
X57 vin P1/a_5044_13476# P1/iovdd_uq0 P1/iovdd_uq0 sg13_hv_pmos ad=3.9294p pd=7.84u as=2.1312p ps=7.3u w=6.66u l=0.6u
X58 vss P1/a_11462_28198# P1/dantenna P1/l=3.1u w=0.64u
X59 vss P1/a_5222_3962# P1/dantenna P1/l=1.26u w=27.78u
X60 P1/a_5044_1676# vss vss P1/rppd l=3.54u w=0.5u
X61 P1/iovdd_uq0 P1/a_5044_13476# vin P1/iovdd_uq0 sg13_hv_pmos ad=2.1312p pd=7.3u as=3.9294p ps=7.84u w=6.66u l=0.6u
X62 P1/iovdd_uq0 P1/a_5044_13476# vin P1/iovdd_uq0 sg13_hv_pmos ad=2.1312p pd=7.3u as=3.9294p ps=7.84u w=6.66u l=0.6u
X63 vin P1/a_5044_1676# vss vss sg13_hv_nmos ad=2.596p pd=5.58u as=2.068p ps=9.74u w=4.4u l=0.6u
X64 P1/iovdd_uq0 P1/a_5044_13476# vin P1/iovdd_uq0 sg13_hv_pmos ad=2.1312p pd=7.3u as=3.9294p ps=7.84u w=6.66u l=0.6u
X65 vin P1/a_5044_13476# P1/iovdd_uq0 P1/iovdd_uq0 sg13_hv_pmos ad=3.9294p pd=7.84u as=2.1312p ps=7.3u w=6.66u l=0.6u
X66 vin P1/a_5044_13476# P1/iovdd_uq0 P1/iovdd_uq0 sg13_hv_pmos ad=3.9294p pd=7.84u as=2.1312p ps=7.3u w=6.66u l=0.6u
X67 vin P1/a_5044_13476# P1/iovdd_uq0 P1/iovdd_uq0 sg13_hv_pmos ad=3.9294p pd=7.84u as=2.1312p ps=7.3u w=6.66u l=0.6u
X68 vss P1/a_5044_1676# vin vss sg13_hv_nmos ad=1.408p pd=5.04u as=2.596p ps=5.58u w=4.4u l=0.6u
X0 P2/iovdd_uq0 P2/a_5044_13476# cks P2/iovdd_uq0 sg13_hv_pmos ad=2.1312p pd=7.3u as=3.9294p ps=7.84u w=6.66u l=0.6u
X1 cks P2/a_5044_1676# vss vss sg13_hv_nmos ad=2.596p pd=5.58u as=1.408p ps=5.04u w=4.4u l=0.6u
X2 cks P2/a_5044_13476# P2/iovdd_uq0 P2/iovdd_uq0 sg13_hv_pmos ad=3.9294p pd=7.84u as=2.1312p ps=7.3u w=6.66u l=0.6u
X3 P2/iovdd_uq0 P2/a_5044_13476# cks P2/iovdd_uq0 sg13_hv_pmos ad=2.1312p pd=7.3u as=3.9294p ps=7.84u w=6.66u l=0.6u
X4 P2/iovdd_uq0 P2/a_5044_13476# cks P2/iovdd_uq0 sg13_hv_pmos ad=2.1312p pd=7.3u as=3.9294p ps=7.84u w=6.66u l=0.6u
X5 cks P2/a_5044_1676# vss vss sg13_hv_nmos ad=2.596p pd=5.58u as=1.408p ps=5.04u w=4.4u l=0.6u
X6 cks P2/a_5044_13476# P2/iovdd_uq0 P2/iovdd_uq0 sg13_hv_pmos ad=3.9294p pd=7.84u as=2.1312p ps=7.3u w=6.66u l=0.6u
X7 P2/iovdd_uq0 P2/a_5044_13476# cks P2/iovdd_uq0 sg13_hv_pmos ad=2.1312p pd=7.3u as=3.9294p ps=7.84u w=6.66u l=0.6u
X8 cks P2/a_5044_1676# vss vss sg13_hv_nmos ad=2.596p pd=5.58u as=1.408p ps=5.04u w=4.4u l=0.6u
X9 vss P2/a_5044_1676# cks vss sg13_hv_nmos ad=2.068p pd=9.74u as=2.596p ps=5.58u w=4.4u l=0.6u
X10 cks P2/a_5044_13476# P2/iovdd_uq0 P2/iovdd_uq0 sg13_hv_pmos ad=3.9294p pd=7.84u as=2.1312p ps=7.3u w=6.66u l=0.6u
X11 P2/a_5044_13476# P2/iovdd_uq0 P2/iovdd_uq0 P2/rppd l=12.9u w=0.5u
X12 vss P2/a_5044_1676# cks vss sg13_hv_nmos ad=1.408p pd=5.04u as=2.596p ps=5.58u w=4.4u l=0.6u
X13 cks P2/a_5044_13476# P2/iovdd_uq0 P2/iovdd_uq0 sg13_hv_pmos ad=3.9294p pd=7.84u as=2.1312p ps=7.3u w=6.66u l=0.6u
X14 vss P2/a_5222_4862# P2/dantenna P2/l=1.26u w=27.78u
X15 vss P2/a_5044_1676# cks vss sg13_hv_nmos ad=1.408p pd=5.04u as=2.596p ps=5.58u w=4.4u l=0.6u
X16 cks P2/a_5044_1676# vss vss sg13_hv_nmos ad=2.596p pd=5.58u as=1.408p ps=5.04u w=4.4u l=0.6u
X17 vss P2/a_5044_1676# cks vss sg13_hv_nmos ad=1.408p pd=5.04u as=2.596p ps=5.58u w=4.4u l=0.6u
X18 P2/iovdd_uq0 P2/a_5044_13476# cks P2/iovdd_uq0 sg13_hv_pmos ad=2.1312p pd=7.3u as=3.9294p ps=7.84u w=6.66u l=0.6u
X19 cks P2/a_5044_1676# vss vss sg13_hv_nmos ad=2.596p pd=5.58u as=1.408p ps=5.04u w=4.4u l=0.6u
X20 cks P2/a_5044_13476# P2/iovdd_uq0 P2/iovdd_uq0 sg13_hv_pmos ad=3.9294p pd=7.84u as=2.1312p ps=7.3u w=6.66u l=0.6u
X21 P2/iovdd_uq0 P2/a_5044_13476# cks P2/iovdd_uq0 sg13_hv_pmos ad=2.1312p pd=7.3u as=3.9294p ps=7.84u w=6.66u l=0.6u
X22 cks P2/a_5044_13476# P2/iovdd_uq0 P2/iovdd_uq0 sg13_hv_pmos ad=3.9294p pd=7.84u as=2.1312p ps=7.3u w=6.66u l=0.6u
X23 cks P2/a_5044_13476# P2/iovdd_uq0 P2/iovdd_uq0 sg13_hv_pmos ad=3.9294p pd=7.84u as=2.1312p ps=7.3u w=6.66u l=0.6u
X24 vss P2/a_5044_1676# cks vss sg13_hv_nmos ad=1.408p pd=5.04u as=2.596p ps=5.58u w=4.4u l=0.6u
X25 _cks P2/iovdd P2/dpantenna P2/l=0.64u w=4.98u
X26 P2/iovdd_uq0 P2/a_5044_13476# cks P2/iovdd_uq0 sg13_hv_pmos ad=2.1312p pd=7.3u as=3.9294p ps=7.84u w=6.66u l=0.6u
X27 cks P2/a_5044_13476# P2/iovdd_uq0 P2/iovdd_uq0 sg13_hv_pmos ad=3.9294p pd=7.84u as=2.1312p ps=7.3u w=6.66u l=0.6u
X28 cks P2/a_5044_13476# P2/iovdd_uq0 P2/iovdd_uq0 sg13_hv_pmos ad=3.9294p pd=7.84u as=2.1312p ps=7.3u w=6.66u l=0.6u
X29 cks P2/a_5044_1676# vss vss sg13_hv_nmos ad=2.596p pd=5.58u as=1.408p ps=5.04u w=4.4u l=0.6u
X30 P2/iovdd_uq0 P2/a_5044_13476# cks P2/iovdd_uq0 sg13_hv_pmos ad=2.1312p pd=7.3u as=3.9294p ps=7.84u w=6.66u l=0.6u
X31 _cks cks vss P2/rppd l=2u w=1u
X32 P2/iovdd_uq0 P2/a_5044_13476# cks P2/iovdd_uq0 sg13_hv_pmos ad=2.1312p pd=7.3u as=3.9294p ps=7.84u w=6.66u l=0.6u
X33 P2/iovdd_uq0 P2/a_5044_13476# cks P2/iovdd_uq0 sg13_hv_pmos ad=2.1312p pd=7.3u as=3.9294p ps=7.84u w=6.66u l=0.6u
X34 cks P2/a_5044_13476# P2/iovdd_uq0 P2/iovdd_uq0 sg13_hv_pmos ad=3.9294p pd=7.84u as=2.1312p ps=7.3u w=6.66u l=0.6u
X35 cks P2/a_5044_1676# vss vss sg13_hv_nmos ad=2.596p pd=5.58u as=1.408p ps=5.04u w=4.4u l=0.6u
X36 vss P2/a_5044_1676# cks vss sg13_hv_nmos ad=1.408p pd=5.04u as=2.596p ps=5.58u w=4.4u l=0.6u
X37 cks P2/a_5044_1676# vss vss sg13_hv_nmos ad=2.596p pd=5.58u as=1.408p ps=5.04u w=4.4u l=0.6u
X38 P2/iovdd_uq0 P2/a_5044_13476# cks P2/iovdd_uq0 sg13_hv_pmos ad=2.1312p pd=7.3u as=3.9294p ps=7.84u w=6.66u l=0.6u
X39 cks P2/a_5044_13476# P2/iovdd_uq0 P2/iovdd_uq0 sg13_hv_pmos ad=3.9294p pd=7.84u as=2.1312p ps=7.3u w=6.66u l=0.6u
X40 cks P2/iovdd_uq0 P2/dpantenna P2/l=1.26u w=27.78u
X41 vss P2/a_5044_1676# cks vss sg13_hv_nmos ad=1.408p pd=5.04u as=2.596p ps=5.58u w=4.4u l=0.6u
X42 P2/iovdd_uq0 P2/a_5044_13476# cks P2/iovdd_uq0 sg13_hv_pmos ad=2.1312p pd=7.3u as=3.9294p ps=7.84u w=6.66u l=0.6u
X43 vss P2/a_5044_1676# cks vss sg13_hv_nmos ad=1.408p pd=5.04u as=2.596p ps=5.58u w=4.4u l=0.6u
X44 cks P2/a_5044_13476# P2/iovdd_uq0 P2/iovdd_uq0 sg13_hv_pmos ad=3.9294p pd=7.84u as=2.1312p ps=7.3u w=6.66u l=0.6u
X45 P2/iovdd_uq0 P2/a_5044_13476# cks P2/iovdd_uq0 sg13_hv_pmos ad=2.1312p pd=7.3u as=3.9294p ps=7.84u w=6.66u l=0.6u
X46 cks P2/a_5044_13476# P2/iovdd_uq0 P2/iovdd_uq0 sg13_hv_pmos ad=3.9294p pd=7.84u as=2.1312p ps=7.3u w=6.66u l=0.6u
X47 cks P2/a_5044_1676# vss vss sg13_hv_nmos ad=2.596p pd=5.58u as=1.408p ps=5.04u w=4.4u l=0.6u
X48 vss P2/a_5044_1676# cks vss sg13_hv_nmos ad=1.408p pd=5.04u as=2.596p ps=5.58u w=4.4u l=0.6u
X49 cks P2/a_5044_13476# P2/iovdd_uq0 P2/iovdd_uq0 sg13_hv_pmos ad=3.9294p pd=7.84u as=3.1302p ps=14.26u w=6.66u l=0.6u
X50 P2/iovdd_uq0 P2/a_5044_13476# cks P2/iovdd_uq0 sg13_hv_pmos ad=3.1302p pd=14.26u as=3.9294p ps=7.84u w=6.66u l=0.6u
X51 P2/iovdd_uq0 P2/a_5044_13476# cks P2/iovdd_uq0 sg13_hv_pmos ad=2.1312p pd=7.3u as=3.9294p ps=7.84u w=6.66u l=0.6u
X52 cks P2/a_5044_13476# P2/iovdd_uq0 P2/iovdd_uq0 sg13_hv_pmos ad=3.9294p pd=7.84u as=2.1312p ps=7.3u w=6.66u l=0.6u
X53 cks P2/iovdd_uq0 P2/dpantenna P2/l=1.26u w=27.78u
X54 cks P2/a_5044_13476# P2/iovdd_uq0 P2/iovdd_uq0 sg13_hv_pmos ad=3.9294p pd=7.84u as=3.1302p ps=14.26u w=6.66u l=0.6u
X55 P2/iovdd_uq0 P2/a_5044_13476# cks P2/iovdd_uq0 sg13_hv_pmos ad=3.1302p pd=14.26u as=3.9294p ps=7.84u w=6.66u l=0.6u
X56 P2/iovdd_uq0 P2/a_5044_13476# cks P2/iovdd_uq0 sg13_hv_pmos ad=2.1312p pd=7.3u as=3.9294p ps=7.84u w=6.66u l=0.6u
X57 cks P2/a_5044_13476# P2/iovdd_uq0 P2/iovdd_uq0 sg13_hv_pmos ad=3.9294p pd=7.84u as=2.1312p ps=7.3u w=6.66u l=0.6u
X58 vss P2/a_11462_28198# P2/dantenna P2/l=3.1u w=0.64u
X59 vss P2/a_5222_3962# P2/dantenna P2/l=1.26u w=27.78u
X60 P2/a_5044_1676# vss vss P2/rppd l=3.54u w=0.5u
X61 P2/iovdd_uq0 P2/a_5044_13476# cks P2/iovdd_uq0 sg13_hv_pmos ad=2.1312p pd=7.3u as=3.9294p ps=7.84u w=6.66u l=0.6u
X62 P2/iovdd_uq0 P2/a_5044_13476# cks P2/iovdd_uq0 sg13_hv_pmos ad=2.1312p pd=7.3u as=3.9294p ps=7.84u w=6.66u l=0.6u
X63 cks P2/a_5044_1676# vss vss sg13_hv_nmos ad=2.596p pd=5.58u as=2.068p ps=9.74u w=4.4u l=0.6u
X64 P2/iovdd_uq0 P2/a_5044_13476# cks P2/iovdd_uq0 sg13_hv_pmos ad=2.1312p pd=7.3u as=3.9294p ps=7.84u w=6.66u l=0.6u
X65 cks P2/a_5044_13476# P2/iovdd_uq0 P2/iovdd_uq0 sg13_hv_pmos ad=3.9294p pd=7.84u as=2.1312p ps=7.3u w=6.66u l=0.6u
X66 cks P2/a_5044_13476# P2/iovdd_uq0 P2/iovdd_uq0 sg13_hv_pmos ad=3.9294p pd=7.84u as=2.1312p ps=7.3u w=6.66u l=0.6u
X67 cks P2/a_5044_13476# P2/iovdd_uq0 P2/iovdd_uq0 sg13_hv_pmos ad=3.9294p pd=7.84u as=2.1312p ps=7.3u w=6.66u l=0.6u
X68 vss P2/a_5044_1676# cks vss sg13_hv_nmos ad=1.408p pd=5.04u as=2.596p ps=5.58u w=4.4u l=0.6u
X0 P3/iovdd_uq0 P3/a_5044_13476# data[0] P3/iovdd_uq0 sg13_hv_pmos ad=2.1312p pd=7.3u as=3.9294p ps=7.84u w=6.66u l=0.6u
X1 data[0] P3/a_5044_1676# vss vss sg13_hv_nmos ad=2.596p pd=5.58u as=1.408p ps=5.04u w=4.4u l=0.6u
X2 data[0] P3/a_5044_13476# P3/iovdd_uq0 P3/iovdd_uq0 sg13_hv_pmos ad=3.9294p pd=7.84u as=2.1312p ps=7.3u w=6.66u l=0.6u
X3 P3/iovdd_uq0 P3/a_5044_13476# data[0] P3/iovdd_uq0 sg13_hv_pmos ad=2.1312p pd=7.3u as=3.9294p ps=7.84u w=6.66u l=0.6u
X4 P3/iovdd_uq0 P3/a_5044_13476# data[0] P3/iovdd_uq0 sg13_hv_pmos ad=2.1312p pd=7.3u as=3.9294p ps=7.84u w=6.66u l=0.6u
X5 data[0] P3/a_5044_1676# vss vss sg13_hv_nmos ad=2.596p pd=5.58u as=1.408p ps=5.04u w=4.4u l=0.6u
X6 data[0] P3/a_5044_13476# P3/iovdd_uq0 P3/iovdd_uq0 sg13_hv_pmos ad=3.9294p pd=7.84u as=2.1312p ps=7.3u w=6.66u l=0.6u
X7 P3/iovdd_uq0 P3/a_5044_13476# data[0] P3/iovdd_uq0 sg13_hv_pmos ad=2.1312p pd=7.3u as=3.9294p ps=7.84u w=6.66u l=0.6u
X8 data[0] P3/a_5044_1676# vss vss sg13_hv_nmos ad=2.596p pd=5.58u as=1.408p ps=5.04u w=4.4u l=0.6u
X9 vss P3/a_5044_1676# data[0] vss sg13_hv_nmos ad=2.068p pd=9.74u as=2.596p ps=5.58u w=4.4u l=0.6u
X10 data[0] P3/a_5044_13476# P3/iovdd_uq0 P3/iovdd_uq0 sg13_hv_pmos ad=3.9294p pd=7.84u as=2.1312p ps=7.3u w=6.66u l=0.6u
X11 P3/a_5044_13476# P3/iovdd_uq0 P3/iovdd_uq0 P3/rppd l=12.9u w=0.5u
X12 vss P3/a_5044_1676# data[0] vss sg13_hv_nmos ad=1.408p pd=5.04u as=2.596p ps=5.58u w=4.4u l=0.6u
X13 data[0] P3/a_5044_13476# P3/iovdd_uq0 P3/iovdd_uq0 sg13_hv_pmos ad=3.9294p pd=7.84u as=2.1312p ps=7.3u w=6.66u l=0.6u
X14 vss P3/a_5222_4862# P3/dantenna P3/l=1.26u w=27.78u
X15 vss P3/a_5044_1676# data[0] vss sg13_hv_nmos ad=1.408p pd=5.04u as=2.596p ps=5.58u w=4.4u l=0.6u
X16 data[0] P3/a_5044_1676# vss vss sg13_hv_nmos ad=2.596p pd=5.58u as=1.408p ps=5.04u w=4.4u l=0.6u
X17 vss P3/a_5044_1676# data[0] vss sg13_hv_nmos ad=1.408p pd=5.04u as=2.596p ps=5.58u w=4.4u l=0.6u
X18 P3/iovdd_uq0 P3/a_5044_13476# data[0] P3/iovdd_uq0 sg13_hv_pmos ad=2.1312p pd=7.3u as=3.9294p ps=7.84u w=6.66u l=0.6u
X19 data[0] P3/a_5044_1676# vss vss sg13_hv_nmos ad=2.596p pd=5.58u as=1.408p ps=5.04u w=4.4u l=0.6u
X20 data[0] P3/a_5044_13476# P3/iovdd_uq0 P3/iovdd_uq0 sg13_hv_pmos ad=3.9294p pd=7.84u as=2.1312p ps=7.3u w=6.66u l=0.6u
X21 P3/iovdd_uq0 P3/a_5044_13476# data[0] P3/iovdd_uq0 sg13_hv_pmos ad=2.1312p pd=7.3u as=3.9294p ps=7.84u w=6.66u l=0.6u
X22 data[0] P3/a_5044_13476# P3/iovdd_uq0 P3/iovdd_uq0 sg13_hv_pmos ad=3.9294p pd=7.84u as=2.1312p ps=7.3u w=6.66u l=0.6u
X23 data[0] P3/a_5044_13476# P3/iovdd_uq0 P3/iovdd_uq0 sg13_hv_pmos ad=3.9294p pd=7.84u as=2.1312p ps=7.3u w=6.66u l=0.6u
X24 vss P3/a_5044_1676# data[0] vss sg13_hv_nmos ad=1.408p pd=5.04u as=2.596p ps=5.58u w=4.4u l=0.6u
X25 _d0 P3/iovdd P3/dpantenna P3/l=0.64u w=4.98u
X26 P3/iovdd_uq0 P3/a_5044_13476# data[0] P3/iovdd_uq0 sg13_hv_pmos ad=2.1312p pd=7.3u as=3.9294p ps=7.84u w=6.66u l=0.6u
X27 data[0] P3/a_5044_13476# P3/iovdd_uq0 P3/iovdd_uq0 sg13_hv_pmos ad=3.9294p pd=7.84u as=2.1312p ps=7.3u w=6.66u l=0.6u
X28 data[0] P3/a_5044_13476# P3/iovdd_uq0 P3/iovdd_uq0 sg13_hv_pmos ad=3.9294p pd=7.84u as=2.1312p ps=7.3u w=6.66u l=0.6u
X29 data[0] P3/a_5044_1676# vss vss sg13_hv_nmos ad=2.596p pd=5.58u as=1.408p ps=5.04u w=4.4u l=0.6u
X30 P3/iovdd_uq0 P3/a_5044_13476# data[0] P3/iovdd_uq0 sg13_hv_pmos ad=2.1312p pd=7.3u as=3.9294p ps=7.84u w=6.66u l=0.6u
X31 _d0 data[0] vss P3/rppd l=2u w=1u
X32 P3/iovdd_uq0 P3/a_5044_13476# data[0] P3/iovdd_uq0 sg13_hv_pmos ad=2.1312p pd=7.3u as=3.9294p ps=7.84u w=6.66u l=0.6u
X33 P3/iovdd_uq0 P3/a_5044_13476# data[0] P3/iovdd_uq0 sg13_hv_pmos ad=2.1312p pd=7.3u as=3.9294p ps=7.84u w=6.66u l=0.6u
X34 data[0] P3/a_5044_13476# P3/iovdd_uq0 P3/iovdd_uq0 sg13_hv_pmos ad=3.9294p pd=7.84u as=2.1312p ps=7.3u w=6.66u l=0.6u
X35 data[0] P3/a_5044_1676# vss vss sg13_hv_nmos ad=2.596p pd=5.58u as=1.408p ps=5.04u w=4.4u l=0.6u
X36 vss P3/a_5044_1676# data[0] vss sg13_hv_nmos ad=1.408p pd=5.04u as=2.596p ps=5.58u w=4.4u l=0.6u
X37 data[0] P3/a_5044_1676# vss vss sg13_hv_nmos ad=2.596p pd=5.58u as=1.408p ps=5.04u w=4.4u l=0.6u
X38 P3/iovdd_uq0 P3/a_5044_13476# data[0] P3/iovdd_uq0 sg13_hv_pmos ad=2.1312p pd=7.3u as=3.9294p ps=7.84u w=6.66u l=0.6u
X39 data[0] P3/a_5044_13476# P3/iovdd_uq0 P3/iovdd_uq0 sg13_hv_pmos ad=3.9294p pd=7.84u as=2.1312p ps=7.3u w=6.66u l=0.6u
X40 data[0] P3/iovdd_uq0 P3/dpantenna P3/l=1.26u w=27.78u
X41 vss P3/a_5044_1676# data[0] vss sg13_hv_nmos ad=1.408p pd=5.04u as=2.596p ps=5.58u w=4.4u l=0.6u
X42 P3/iovdd_uq0 P3/a_5044_13476# data[0] P3/iovdd_uq0 sg13_hv_pmos ad=2.1312p pd=7.3u as=3.9294p ps=7.84u w=6.66u l=0.6u
X43 vss P3/a_5044_1676# data[0] vss sg13_hv_nmos ad=1.408p pd=5.04u as=2.596p ps=5.58u w=4.4u l=0.6u
X44 data[0] P3/a_5044_13476# P3/iovdd_uq0 P3/iovdd_uq0 sg13_hv_pmos ad=3.9294p pd=7.84u as=2.1312p ps=7.3u w=6.66u l=0.6u
X45 P3/iovdd_uq0 P3/a_5044_13476# data[0] P3/iovdd_uq0 sg13_hv_pmos ad=2.1312p pd=7.3u as=3.9294p ps=7.84u w=6.66u l=0.6u
X46 data[0] P3/a_5044_13476# P3/iovdd_uq0 P3/iovdd_uq0 sg13_hv_pmos ad=3.9294p pd=7.84u as=2.1312p ps=7.3u w=6.66u l=0.6u
X47 data[0] P3/a_5044_1676# vss vss sg13_hv_nmos ad=2.596p pd=5.58u as=1.408p ps=5.04u w=4.4u l=0.6u
X48 vss P3/a_5044_1676# data[0] vss sg13_hv_nmos ad=1.408p pd=5.04u as=2.596p ps=5.58u w=4.4u l=0.6u
X49 data[0] P3/a_5044_13476# P3/iovdd_uq0 P3/iovdd_uq0 sg13_hv_pmos ad=3.9294p pd=7.84u as=3.1302p ps=14.26u w=6.66u l=0.6u
X50 P3/iovdd_uq0 P3/a_5044_13476# data[0] P3/iovdd_uq0 sg13_hv_pmos ad=3.1302p pd=14.26u as=3.9294p ps=7.84u w=6.66u l=0.6u
X51 P3/iovdd_uq0 P3/a_5044_13476# data[0] P3/iovdd_uq0 sg13_hv_pmos ad=2.1312p pd=7.3u as=3.9294p ps=7.84u w=6.66u l=0.6u
X52 data[0] P3/a_5044_13476# P3/iovdd_uq0 P3/iovdd_uq0 sg13_hv_pmos ad=3.9294p pd=7.84u as=2.1312p ps=7.3u w=6.66u l=0.6u
X53 data[0] P3/iovdd_uq0 P3/dpantenna P3/l=1.26u w=27.78u
X54 data[0] P3/a_5044_13476# P3/iovdd_uq0 P3/iovdd_uq0 sg13_hv_pmos ad=3.9294p pd=7.84u as=3.1302p ps=14.26u w=6.66u l=0.6u
X55 P3/iovdd_uq0 P3/a_5044_13476# data[0] P3/iovdd_uq0 sg13_hv_pmos ad=3.1302p pd=14.26u as=3.9294p ps=7.84u w=6.66u l=0.6u
X56 P3/iovdd_uq0 P3/a_5044_13476# data[0] P3/iovdd_uq0 sg13_hv_pmos ad=2.1312p pd=7.3u as=3.9294p ps=7.84u w=6.66u l=0.6u
X57 data[0] P3/a_5044_13476# P3/iovdd_uq0 P3/iovdd_uq0 sg13_hv_pmos ad=3.9294p pd=7.84u as=2.1312p ps=7.3u w=6.66u l=0.6u
X58 vss P3/a_11462_28198# P3/dantenna P3/l=3.1u w=0.64u
X59 vss P3/a_5222_3962# P3/dantenna P3/l=1.26u w=27.78u
X60 P3/a_5044_1676# vss vss P3/rppd l=3.54u w=0.5u
X61 P3/iovdd_uq0 P3/a_5044_13476# data[0] P3/iovdd_uq0 sg13_hv_pmos ad=2.1312p pd=7.3u as=3.9294p ps=7.84u w=6.66u l=0.6u
X62 P3/iovdd_uq0 P3/a_5044_13476# data[0] P3/iovdd_uq0 sg13_hv_pmos ad=2.1312p pd=7.3u as=3.9294p ps=7.84u w=6.66u l=0.6u
X63 data[0] P3/a_5044_1676# vss vss sg13_hv_nmos ad=2.596p pd=5.58u as=2.068p ps=9.74u w=4.4u l=0.6u
X64 P3/iovdd_uq0 P3/a_5044_13476# data[0] P3/iovdd_uq0 sg13_hv_pmos ad=2.1312p pd=7.3u as=3.9294p ps=7.84u w=6.66u l=0.6u
X65 data[0] P3/a_5044_13476# P3/iovdd_uq0 P3/iovdd_uq0 sg13_hv_pmos ad=3.9294p pd=7.84u as=2.1312p ps=7.3u w=6.66u l=0.6u
X66 data[0] P3/a_5044_13476# P3/iovdd_uq0 P3/iovdd_uq0 sg13_hv_pmos ad=3.9294p pd=7.84u as=2.1312p ps=7.3u w=6.66u l=0.6u
X67 data[0] P3/a_5044_13476# P3/iovdd_uq0 P3/iovdd_uq0 sg13_hv_pmos ad=3.9294p pd=7.84u as=2.1312p ps=7.3u w=6.66u l=0.6u
X68 vss P3/a_5044_1676# data[0] vss sg13_hv_nmos ad=1.408p pd=5.04u as=2.596p ps=5.58u w=4.4u l=0.6u
X0 P4/iovdd_uq0 P4/a_5044_13476# data[1] P4/iovdd_uq0 sg13_hv_pmos ad=2.1312p pd=7.3u as=3.9294p ps=7.84u w=6.66u l=0.6u
X1 data[1] P4/a_5044_1676# vss vss sg13_hv_nmos ad=2.596p pd=5.58u as=1.408p ps=5.04u w=4.4u l=0.6u
X2 data[1] P4/a_5044_13476# P4/iovdd_uq0 P4/iovdd_uq0 sg13_hv_pmos ad=3.9294p pd=7.84u as=2.1312p ps=7.3u w=6.66u l=0.6u
X3 P4/iovdd_uq0 P4/a_5044_13476# data[1] P4/iovdd_uq0 sg13_hv_pmos ad=2.1312p pd=7.3u as=3.9294p ps=7.84u w=6.66u l=0.6u
X4 P4/iovdd_uq0 P4/a_5044_13476# data[1] P4/iovdd_uq0 sg13_hv_pmos ad=2.1312p pd=7.3u as=3.9294p ps=7.84u w=6.66u l=0.6u
X5 data[1] P4/a_5044_1676# vss vss sg13_hv_nmos ad=2.596p pd=5.58u as=1.408p ps=5.04u w=4.4u l=0.6u
X6 data[1] P4/a_5044_13476# P4/iovdd_uq0 P4/iovdd_uq0 sg13_hv_pmos ad=3.9294p pd=7.84u as=2.1312p ps=7.3u w=6.66u l=0.6u
X7 P4/iovdd_uq0 P4/a_5044_13476# data[1] P4/iovdd_uq0 sg13_hv_pmos ad=2.1312p pd=7.3u as=3.9294p ps=7.84u w=6.66u l=0.6u
X8 data[1] P4/a_5044_1676# vss vss sg13_hv_nmos ad=2.596p pd=5.58u as=1.408p ps=5.04u w=4.4u l=0.6u
X9 vss P4/a_5044_1676# data[1] vss sg13_hv_nmos ad=2.068p pd=9.74u as=2.596p ps=5.58u w=4.4u l=0.6u
X10 data[1] P4/a_5044_13476# P4/iovdd_uq0 P4/iovdd_uq0 sg13_hv_pmos ad=3.9294p pd=7.84u as=2.1312p ps=7.3u w=6.66u l=0.6u
X11 P4/a_5044_13476# P4/iovdd_uq0 P4/iovdd_uq0 P4/rppd l=12.9u w=0.5u
X12 vss P4/a_5044_1676# data[1] vss sg13_hv_nmos ad=1.408p pd=5.04u as=2.596p ps=5.58u w=4.4u l=0.6u
X13 data[1] P4/a_5044_13476# P4/iovdd_uq0 P4/iovdd_uq0 sg13_hv_pmos ad=3.9294p pd=7.84u as=2.1312p ps=7.3u w=6.66u l=0.6u
X14 vss P4/a_5222_4862# P4/dantenna P4/l=1.26u w=27.78u
X15 vss P4/a_5044_1676# data[1] vss sg13_hv_nmos ad=1.408p pd=5.04u as=2.596p ps=5.58u w=4.4u l=0.6u
X16 data[1] P4/a_5044_1676# vss vss sg13_hv_nmos ad=2.596p pd=5.58u as=1.408p ps=5.04u w=4.4u l=0.6u
X17 vss P4/a_5044_1676# data[1] vss sg13_hv_nmos ad=1.408p pd=5.04u as=2.596p ps=5.58u w=4.4u l=0.6u
X18 P4/iovdd_uq0 P4/a_5044_13476# data[1] P4/iovdd_uq0 sg13_hv_pmos ad=2.1312p pd=7.3u as=3.9294p ps=7.84u w=6.66u l=0.6u
X19 data[1] P4/a_5044_1676# vss vss sg13_hv_nmos ad=2.596p pd=5.58u as=1.408p ps=5.04u w=4.4u l=0.6u
X20 data[1] P4/a_5044_13476# P4/iovdd_uq0 P4/iovdd_uq0 sg13_hv_pmos ad=3.9294p pd=7.84u as=2.1312p ps=7.3u w=6.66u l=0.6u
X21 P4/iovdd_uq0 P4/a_5044_13476# data[1] P4/iovdd_uq0 sg13_hv_pmos ad=2.1312p pd=7.3u as=3.9294p ps=7.84u w=6.66u l=0.6u
X22 data[1] P4/a_5044_13476# P4/iovdd_uq0 P4/iovdd_uq0 sg13_hv_pmos ad=3.9294p pd=7.84u as=2.1312p ps=7.3u w=6.66u l=0.6u
X23 data[1] P4/a_5044_13476# P4/iovdd_uq0 P4/iovdd_uq0 sg13_hv_pmos ad=3.9294p pd=7.84u as=2.1312p ps=7.3u w=6.66u l=0.6u
X24 vss P4/a_5044_1676# data[1] vss sg13_hv_nmos ad=1.408p pd=5.04u as=2.596p ps=5.58u w=4.4u l=0.6u
X25 _d1 P4/iovdd P4/dpantenna P4/l=0.64u w=4.98u
X26 P4/iovdd_uq0 P4/a_5044_13476# data[1] P4/iovdd_uq0 sg13_hv_pmos ad=2.1312p pd=7.3u as=3.9294p ps=7.84u w=6.66u l=0.6u
X27 data[1] P4/a_5044_13476# P4/iovdd_uq0 P4/iovdd_uq0 sg13_hv_pmos ad=3.9294p pd=7.84u as=2.1312p ps=7.3u w=6.66u l=0.6u
X28 data[1] P4/a_5044_13476# P4/iovdd_uq0 P4/iovdd_uq0 sg13_hv_pmos ad=3.9294p pd=7.84u as=2.1312p ps=7.3u w=6.66u l=0.6u
X29 data[1] P4/a_5044_1676# vss vss sg13_hv_nmos ad=2.596p pd=5.58u as=1.408p ps=5.04u w=4.4u l=0.6u
X30 P4/iovdd_uq0 P4/a_5044_13476# data[1] P4/iovdd_uq0 sg13_hv_pmos ad=2.1312p pd=7.3u as=3.9294p ps=7.84u w=6.66u l=0.6u
X31 _d1 data[1] vss P4/rppd l=2u w=1u
X32 P4/iovdd_uq0 P4/a_5044_13476# data[1] P4/iovdd_uq0 sg13_hv_pmos ad=2.1312p pd=7.3u as=3.9294p ps=7.84u w=6.66u l=0.6u
X33 P4/iovdd_uq0 P4/a_5044_13476# data[1] P4/iovdd_uq0 sg13_hv_pmos ad=2.1312p pd=7.3u as=3.9294p ps=7.84u w=6.66u l=0.6u
X34 data[1] P4/a_5044_13476# P4/iovdd_uq0 P4/iovdd_uq0 sg13_hv_pmos ad=3.9294p pd=7.84u as=2.1312p ps=7.3u w=6.66u l=0.6u
X35 data[1] P4/a_5044_1676# vss vss sg13_hv_nmos ad=2.596p pd=5.58u as=1.408p ps=5.04u w=4.4u l=0.6u
X36 vss P4/a_5044_1676# data[1] vss sg13_hv_nmos ad=1.408p pd=5.04u as=2.596p ps=5.58u w=4.4u l=0.6u
X37 data[1] P4/a_5044_1676# vss vss sg13_hv_nmos ad=2.596p pd=5.58u as=1.408p ps=5.04u w=4.4u l=0.6u
X38 P4/iovdd_uq0 P4/a_5044_13476# data[1] P4/iovdd_uq0 sg13_hv_pmos ad=2.1312p pd=7.3u as=3.9294p ps=7.84u w=6.66u l=0.6u
X39 data[1] P4/a_5044_13476# P4/iovdd_uq0 P4/iovdd_uq0 sg13_hv_pmos ad=3.9294p pd=7.84u as=2.1312p ps=7.3u w=6.66u l=0.6u
X40 data[1] P4/iovdd_uq0 P4/dpantenna P4/l=1.26u w=27.78u
X41 vss P4/a_5044_1676# data[1] vss sg13_hv_nmos ad=1.408p pd=5.04u as=2.596p ps=5.58u w=4.4u l=0.6u
X42 P4/iovdd_uq0 P4/a_5044_13476# data[1] P4/iovdd_uq0 sg13_hv_pmos ad=2.1312p pd=7.3u as=3.9294p ps=7.84u w=6.66u l=0.6u
X43 vss P4/a_5044_1676# data[1] vss sg13_hv_nmos ad=1.408p pd=5.04u as=2.596p ps=5.58u w=4.4u l=0.6u
X44 data[1] P4/a_5044_13476# P4/iovdd_uq0 P4/iovdd_uq0 sg13_hv_pmos ad=3.9294p pd=7.84u as=2.1312p ps=7.3u w=6.66u l=0.6u
X45 P4/iovdd_uq0 P4/a_5044_13476# data[1] P4/iovdd_uq0 sg13_hv_pmos ad=2.1312p pd=7.3u as=3.9294p ps=7.84u w=6.66u l=0.6u
X46 data[1] P4/a_5044_13476# P4/iovdd_uq0 P4/iovdd_uq0 sg13_hv_pmos ad=3.9294p pd=7.84u as=2.1312p ps=7.3u w=6.66u l=0.6u
X47 data[1] P4/a_5044_1676# vss vss sg13_hv_nmos ad=2.596p pd=5.58u as=1.408p ps=5.04u w=4.4u l=0.6u
X48 vss P4/a_5044_1676# data[1] vss sg13_hv_nmos ad=1.408p pd=5.04u as=2.596p ps=5.58u w=4.4u l=0.6u
X49 data[1] P4/a_5044_13476# P4/iovdd_uq0 P4/iovdd_uq0 sg13_hv_pmos ad=3.9294p pd=7.84u as=3.1302p ps=14.26u w=6.66u l=0.6u
X50 P4/iovdd_uq0 P4/a_5044_13476# data[1] P4/iovdd_uq0 sg13_hv_pmos ad=3.1302p pd=14.26u as=3.9294p ps=7.84u w=6.66u l=0.6u
X51 P4/iovdd_uq0 P4/a_5044_13476# data[1] P4/iovdd_uq0 sg13_hv_pmos ad=2.1312p pd=7.3u as=3.9294p ps=7.84u w=6.66u l=0.6u
X52 data[1] P4/a_5044_13476# P4/iovdd_uq0 P4/iovdd_uq0 sg13_hv_pmos ad=3.9294p pd=7.84u as=2.1312p ps=7.3u w=6.66u l=0.6u
X53 data[1] P4/iovdd_uq0 P4/dpantenna P4/l=1.26u w=27.78u
X54 data[1] P4/a_5044_13476# P4/iovdd_uq0 P4/iovdd_uq0 sg13_hv_pmos ad=3.9294p pd=7.84u as=3.1302p ps=14.26u w=6.66u l=0.6u
X55 P4/iovdd_uq0 P4/a_5044_13476# data[1] P4/iovdd_uq0 sg13_hv_pmos ad=3.1302p pd=14.26u as=3.9294p ps=7.84u w=6.66u l=0.6u
X56 P4/iovdd_uq0 P4/a_5044_13476# data[1] P4/iovdd_uq0 sg13_hv_pmos ad=2.1312p pd=7.3u as=3.9294p ps=7.84u w=6.66u l=0.6u
X57 data[1] P4/a_5044_13476# P4/iovdd_uq0 P4/iovdd_uq0 sg13_hv_pmos ad=3.9294p pd=7.84u as=2.1312p ps=7.3u w=6.66u l=0.6u
X58 vss P4/a_11462_28198# P4/dantenna P4/l=3.1u w=0.64u
X59 vss P4/a_5222_3962# P4/dantenna P4/l=1.26u w=27.78u
X60 P4/a_5044_1676# vss vss P4/rppd l=3.54u w=0.5u
X61 P4/iovdd_uq0 P4/a_5044_13476# data[1] P4/iovdd_uq0 sg13_hv_pmos ad=2.1312p pd=7.3u as=3.9294p ps=7.84u w=6.66u l=0.6u
X62 P4/iovdd_uq0 P4/a_5044_13476# data[1] P4/iovdd_uq0 sg13_hv_pmos ad=2.1312p pd=7.3u as=3.9294p ps=7.84u w=6.66u l=0.6u
X63 data[1] P4/a_5044_1676# vss vss sg13_hv_nmos ad=2.596p pd=5.58u as=2.068p ps=9.74u w=4.4u l=0.6u
X64 P4/iovdd_uq0 P4/a_5044_13476# data[1] P4/iovdd_uq0 sg13_hv_pmos ad=2.1312p pd=7.3u as=3.9294p ps=7.84u w=6.66u l=0.6u
X65 data[1] P4/a_5044_13476# P4/iovdd_uq0 P4/iovdd_uq0 sg13_hv_pmos ad=3.9294p pd=7.84u as=2.1312p ps=7.3u w=6.66u l=0.6u
X66 data[1] P4/a_5044_13476# P4/iovdd_uq0 P4/iovdd_uq0 sg13_hv_pmos ad=3.9294p pd=7.84u as=2.1312p ps=7.3u w=6.66u l=0.6u
X67 data[1] P4/a_5044_13476# P4/iovdd_uq0 P4/iovdd_uq0 sg13_hv_pmos ad=3.9294p pd=7.84u as=2.1312p ps=7.3u w=6.66u l=0.6u
X68 vss P4/a_5044_1676# data[1] vss sg13_hv_nmos ad=1.408p pd=5.04u as=2.596p ps=5.58u w=4.4u l=0.6u
X0 P5/iovdd_uq0 P5/a_5044_13476# data[2] P5/iovdd_uq0 sg13_hv_pmos ad=2.1312p pd=7.3u as=3.9294p ps=7.84u w=6.66u l=0.6u
X1 data[2] P5/a_5044_1676# vss vss sg13_hv_nmos ad=2.596p pd=5.58u as=1.408p ps=5.04u w=4.4u l=0.6u
X2 data[2] P5/a_5044_13476# P5/iovdd_uq0 P5/iovdd_uq0 sg13_hv_pmos ad=3.9294p pd=7.84u as=2.1312p ps=7.3u w=6.66u l=0.6u
X3 P5/iovdd_uq0 P5/a_5044_13476# data[2] P5/iovdd_uq0 sg13_hv_pmos ad=2.1312p pd=7.3u as=3.9294p ps=7.84u w=6.66u l=0.6u
X4 P5/iovdd_uq0 P5/a_5044_13476# data[2] P5/iovdd_uq0 sg13_hv_pmos ad=2.1312p pd=7.3u as=3.9294p ps=7.84u w=6.66u l=0.6u
X5 data[2] P5/a_5044_1676# vss vss sg13_hv_nmos ad=2.596p pd=5.58u as=1.408p ps=5.04u w=4.4u l=0.6u
X6 data[2] P5/a_5044_13476# P5/iovdd_uq0 P5/iovdd_uq0 sg13_hv_pmos ad=3.9294p pd=7.84u as=2.1312p ps=7.3u w=6.66u l=0.6u
X7 P5/iovdd_uq0 P5/a_5044_13476# data[2] P5/iovdd_uq0 sg13_hv_pmos ad=2.1312p pd=7.3u as=3.9294p ps=7.84u w=6.66u l=0.6u
X8 data[2] P5/a_5044_1676# vss vss sg13_hv_nmos ad=2.596p pd=5.58u as=1.408p ps=5.04u w=4.4u l=0.6u
X9 vss P5/a_5044_1676# data[2] vss sg13_hv_nmos ad=2.068p pd=9.74u as=2.596p ps=5.58u w=4.4u l=0.6u
X10 data[2] P5/a_5044_13476# P5/iovdd_uq0 P5/iovdd_uq0 sg13_hv_pmos ad=3.9294p pd=7.84u as=2.1312p ps=7.3u w=6.66u l=0.6u
X11 P5/a_5044_13476# P5/iovdd_uq0 P5/iovdd_uq0 P5/rppd l=12.9u w=0.5u
X12 vss P5/a_5044_1676# data[2] vss sg13_hv_nmos ad=1.408p pd=5.04u as=2.596p ps=5.58u w=4.4u l=0.6u
X13 data[2] P5/a_5044_13476# P5/iovdd_uq0 P5/iovdd_uq0 sg13_hv_pmos ad=3.9294p pd=7.84u as=2.1312p ps=7.3u w=6.66u l=0.6u
X14 vss P5/a_5222_4862# P5/dantenna P5/l=1.26u w=27.78u
X15 vss P5/a_5044_1676# data[2] vss sg13_hv_nmos ad=1.408p pd=5.04u as=2.596p ps=5.58u w=4.4u l=0.6u
X16 data[2] P5/a_5044_1676# vss vss sg13_hv_nmos ad=2.596p pd=5.58u as=1.408p ps=5.04u w=4.4u l=0.6u
X17 vss P5/a_5044_1676# data[2] vss sg13_hv_nmos ad=1.408p pd=5.04u as=2.596p ps=5.58u w=4.4u l=0.6u
X18 P5/iovdd_uq0 P5/a_5044_13476# data[2] P5/iovdd_uq0 sg13_hv_pmos ad=2.1312p pd=7.3u as=3.9294p ps=7.84u w=6.66u l=0.6u
X19 data[2] P5/a_5044_1676# vss vss sg13_hv_nmos ad=2.596p pd=5.58u as=1.408p ps=5.04u w=4.4u l=0.6u
X20 data[2] P5/a_5044_13476# P5/iovdd_uq0 P5/iovdd_uq0 sg13_hv_pmos ad=3.9294p pd=7.84u as=2.1312p ps=7.3u w=6.66u l=0.6u
X21 P5/iovdd_uq0 P5/a_5044_13476# data[2] P5/iovdd_uq0 sg13_hv_pmos ad=2.1312p pd=7.3u as=3.9294p ps=7.84u w=6.66u l=0.6u
X22 data[2] P5/a_5044_13476# P5/iovdd_uq0 P5/iovdd_uq0 sg13_hv_pmos ad=3.9294p pd=7.84u as=2.1312p ps=7.3u w=6.66u l=0.6u
X23 data[2] P5/a_5044_13476# P5/iovdd_uq0 P5/iovdd_uq0 sg13_hv_pmos ad=3.9294p pd=7.84u as=2.1312p ps=7.3u w=6.66u l=0.6u
X24 vss P5/a_5044_1676# data[2] vss sg13_hv_nmos ad=1.408p pd=5.04u as=2.596p ps=5.58u w=4.4u l=0.6u
X25 _d2 P5/iovdd P5/dpantenna P5/l=0.64u w=4.98u
X26 P5/iovdd_uq0 P5/a_5044_13476# data[2] P5/iovdd_uq0 sg13_hv_pmos ad=2.1312p pd=7.3u as=3.9294p ps=7.84u w=6.66u l=0.6u
X27 data[2] P5/a_5044_13476# P5/iovdd_uq0 P5/iovdd_uq0 sg13_hv_pmos ad=3.9294p pd=7.84u as=2.1312p ps=7.3u w=6.66u l=0.6u
X28 data[2] P5/a_5044_13476# P5/iovdd_uq0 P5/iovdd_uq0 sg13_hv_pmos ad=3.9294p pd=7.84u as=2.1312p ps=7.3u w=6.66u l=0.6u
X29 data[2] P5/a_5044_1676# vss vss sg13_hv_nmos ad=2.596p pd=5.58u as=1.408p ps=5.04u w=4.4u l=0.6u
X30 P5/iovdd_uq0 P5/a_5044_13476# data[2] P5/iovdd_uq0 sg13_hv_pmos ad=2.1312p pd=7.3u as=3.9294p ps=7.84u w=6.66u l=0.6u
X31 _d2 data[2] vss P5/rppd l=2u w=1u
X32 P5/iovdd_uq0 P5/a_5044_13476# data[2] P5/iovdd_uq0 sg13_hv_pmos ad=2.1312p pd=7.3u as=3.9294p ps=7.84u w=6.66u l=0.6u
X33 P5/iovdd_uq0 P5/a_5044_13476# data[2] P5/iovdd_uq0 sg13_hv_pmos ad=2.1312p pd=7.3u as=3.9294p ps=7.84u w=6.66u l=0.6u
X34 data[2] P5/a_5044_13476# P5/iovdd_uq0 P5/iovdd_uq0 sg13_hv_pmos ad=3.9294p pd=7.84u as=2.1312p ps=7.3u w=6.66u l=0.6u
X35 data[2] P5/a_5044_1676# vss vss sg13_hv_nmos ad=2.596p pd=5.58u as=1.408p ps=5.04u w=4.4u l=0.6u
X36 vss P5/a_5044_1676# data[2] vss sg13_hv_nmos ad=1.408p pd=5.04u as=2.596p ps=5.58u w=4.4u l=0.6u
X37 data[2] P5/a_5044_1676# vss vss sg13_hv_nmos ad=2.596p pd=5.58u as=1.408p ps=5.04u w=4.4u l=0.6u
X38 P5/iovdd_uq0 P5/a_5044_13476# data[2] P5/iovdd_uq0 sg13_hv_pmos ad=2.1312p pd=7.3u as=3.9294p ps=7.84u w=6.66u l=0.6u
X39 data[2] P5/a_5044_13476# P5/iovdd_uq0 P5/iovdd_uq0 sg13_hv_pmos ad=3.9294p pd=7.84u as=2.1312p ps=7.3u w=6.66u l=0.6u
X40 data[2] P5/iovdd_uq0 P5/dpantenna P5/l=1.26u w=27.78u
X41 vss P5/a_5044_1676# data[2] vss sg13_hv_nmos ad=1.408p pd=5.04u as=2.596p ps=5.58u w=4.4u l=0.6u
X42 P5/iovdd_uq0 P5/a_5044_13476# data[2] P5/iovdd_uq0 sg13_hv_pmos ad=2.1312p pd=7.3u as=3.9294p ps=7.84u w=6.66u l=0.6u
X43 vss P5/a_5044_1676# data[2] vss sg13_hv_nmos ad=1.408p pd=5.04u as=2.596p ps=5.58u w=4.4u l=0.6u
X44 data[2] P5/a_5044_13476# P5/iovdd_uq0 P5/iovdd_uq0 sg13_hv_pmos ad=3.9294p pd=7.84u as=2.1312p ps=7.3u w=6.66u l=0.6u
X45 P5/iovdd_uq0 P5/a_5044_13476# data[2] P5/iovdd_uq0 sg13_hv_pmos ad=2.1312p pd=7.3u as=3.9294p ps=7.84u w=6.66u l=0.6u
X46 data[2] P5/a_5044_13476# P5/iovdd_uq0 P5/iovdd_uq0 sg13_hv_pmos ad=3.9294p pd=7.84u as=2.1312p ps=7.3u w=6.66u l=0.6u
X47 data[2] P5/a_5044_1676# vss vss sg13_hv_nmos ad=2.596p pd=5.58u as=1.408p ps=5.04u w=4.4u l=0.6u
X48 vss P5/a_5044_1676# data[2] vss sg13_hv_nmos ad=1.408p pd=5.04u as=2.596p ps=5.58u w=4.4u l=0.6u
X49 data[2] P5/a_5044_13476# P5/iovdd_uq0 P5/iovdd_uq0 sg13_hv_pmos ad=3.9294p pd=7.84u as=3.1302p ps=14.26u w=6.66u l=0.6u
X50 P5/iovdd_uq0 P5/a_5044_13476# data[2] P5/iovdd_uq0 sg13_hv_pmos ad=3.1302p pd=14.26u as=3.9294p ps=7.84u w=6.66u l=0.6u
X51 P5/iovdd_uq0 P5/a_5044_13476# data[2] P5/iovdd_uq0 sg13_hv_pmos ad=2.1312p pd=7.3u as=3.9294p ps=7.84u w=6.66u l=0.6u
X52 data[2] P5/a_5044_13476# P5/iovdd_uq0 P5/iovdd_uq0 sg13_hv_pmos ad=3.9294p pd=7.84u as=2.1312p ps=7.3u w=6.66u l=0.6u
X53 data[2] P5/iovdd_uq0 P5/dpantenna P5/l=1.26u w=27.78u
X54 data[2] P5/a_5044_13476# P5/iovdd_uq0 P5/iovdd_uq0 sg13_hv_pmos ad=3.9294p pd=7.84u as=3.1302p ps=14.26u w=6.66u l=0.6u
X55 P5/iovdd_uq0 P5/a_5044_13476# data[2] P5/iovdd_uq0 sg13_hv_pmos ad=3.1302p pd=14.26u as=3.9294p ps=7.84u w=6.66u l=0.6u
X56 P5/iovdd_uq0 P5/a_5044_13476# data[2] P5/iovdd_uq0 sg13_hv_pmos ad=2.1312p pd=7.3u as=3.9294p ps=7.84u w=6.66u l=0.6u
X57 data[2] P5/a_5044_13476# P5/iovdd_uq0 P5/iovdd_uq0 sg13_hv_pmos ad=3.9294p pd=7.84u as=2.1312p ps=7.3u w=6.66u l=0.6u
X58 vss P5/a_11462_28198# P5/dantenna P5/l=3.1u w=0.64u
X59 vss P5/a_5222_3962# P5/dantenna P5/l=1.26u w=27.78u
X60 P5/a_5044_1676# vss vss P5/rppd l=3.54u w=0.5u
X61 P5/iovdd_uq0 P5/a_5044_13476# data[2] P5/iovdd_uq0 sg13_hv_pmos ad=2.1312p pd=7.3u as=3.9294p ps=7.84u w=6.66u l=0.6u
X62 P5/iovdd_uq0 P5/a_5044_13476# data[2] P5/iovdd_uq0 sg13_hv_pmos ad=2.1312p pd=7.3u as=3.9294p ps=7.84u w=6.66u l=0.6u
X63 data[2] P5/a_5044_1676# vss vss sg13_hv_nmos ad=2.596p pd=5.58u as=2.068p ps=9.74u w=4.4u l=0.6u
X64 P5/iovdd_uq0 P5/a_5044_13476# data[2] P5/iovdd_uq0 sg13_hv_pmos ad=2.1312p pd=7.3u as=3.9294p ps=7.84u w=6.66u l=0.6u
X65 data[2] P5/a_5044_13476# P5/iovdd_uq0 P5/iovdd_uq0 sg13_hv_pmos ad=3.9294p pd=7.84u as=2.1312p ps=7.3u w=6.66u l=0.6u
X66 data[2] P5/a_5044_13476# P5/iovdd_uq0 P5/iovdd_uq0 sg13_hv_pmos ad=3.9294p pd=7.84u as=2.1312p ps=7.3u w=6.66u l=0.6u
X67 data[2] P5/a_5044_13476# P5/iovdd_uq0 P5/iovdd_uq0 sg13_hv_pmos ad=3.9294p pd=7.84u as=2.1312p ps=7.3u w=6.66u l=0.6u
X68 vss P5/a_5044_1676# data[2] vss sg13_hv_nmos ad=1.408p pd=5.04u as=2.596p ps=5.58u w=4.4u l=0.6u
X0 P6/iovdd_uq0 P6/a_5044_13476# cko P6/iovdd_uq0 sg13_hv_pmos ad=2.1312p pd=7.3u as=3.9294p ps=7.84u w=6.66u l=0.6u
X1 cko P6/a_5044_1676# vss vss sg13_hv_nmos ad=2.596p pd=5.58u as=1.408p ps=5.04u w=4.4u l=0.6u
X2 cko P6/a_5044_13476# P6/iovdd_uq0 P6/iovdd_uq0 sg13_hv_pmos ad=3.9294p pd=7.84u as=2.1312p ps=7.3u w=6.66u l=0.6u
X3 P6/iovdd_uq0 P6/a_5044_13476# cko P6/iovdd_uq0 sg13_hv_pmos ad=2.1312p pd=7.3u as=3.9294p ps=7.84u w=6.66u l=0.6u
X4 P6/iovdd_uq0 P6/a_5044_13476# cko P6/iovdd_uq0 sg13_hv_pmos ad=2.1312p pd=7.3u as=3.9294p ps=7.84u w=6.66u l=0.6u
X5 cko P6/a_5044_1676# vss vss sg13_hv_nmos ad=2.596p pd=5.58u as=1.408p ps=5.04u w=4.4u l=0.6u
X6 cko P6/a_5044_13476# P6/iovdd_uq0 P6/iovdd_uq0 sg13_hv_pmos ad=3.9294p pd=7.84u as=2.1312p ps=7.3u w=6.66u l=0.6u
X7 P6/iovdd_uq0 P6/a_5044_13476# cko P6/iovdd_uq0 sg13_hv_pmos ad=2.1312p pd=7.3u as=3.9294p ps=7.84u w=6.66u l=0.6u
X8 cko P6/a_5044_1676# vss vss sg13_hv_nmos ad=2.596p pd=5.58u as=1.408p ps=5.04u w=4.4u l=0.6u
X9 vss P6/a_5044_1676# cko vss sg13_hv_nmos ad=2.068p pd=9.74u as=2.596p ps=5.58u w=4.4u l=0.6u
X10 cko P6/a_5044_13476# P6/iovdd_uq0 P6/iovdd_uq0 sg13_hv_pmos ad=3.9294p pd=7.84u as=2.1312p ps=7.3u w=6.66u l=0.6u
X11 P6/a_5044_13476# P6/iovdd_uq0 P6/iovdd_uq0 P6/rppd l=12.9u w=0.5u
X12 vss P6/a_5044_1676# cko vss sg13_hv_nmos ad=1.408p pd=5.04u as=2.596p ps=5.58u w=4.4u l=0.6u
X13 cko P6/a_5044_13476# P6/iovdd_uq0 P6/iovdd_uq0 sg13_hv_pmos ad=3.9294p pd=7.84u as=2.1312p ps=7.3u w=6.66u l=0.6u
X14 vss P6/a_5222_4862# P6/dantenna P6/l=1.26u w=27.78u
X15 vss P6/a_5044_1676# cko vss sg13_hv_nmos ad=1.408p pd=5.04u as=2.596p ps=5.58u w=4.4u l=0.6u
X16 cko P6/a_5044_1676# vss vss sg13_hv_nmos ad=2.596p pd=5.58u as=1.408p ps=5.04u w=4.4u l=0.6u
X17 vss P6/a_5044_1676# cko vss sg13_hv_nmos ad=1.408p pd=5.04u as=2.596p ps=5.58u w=4.4u l=0.6u
X18 P6/iovdd_uq0 P6/a_5044_13476# cko P6/iovdd_uq0 sg13_hv_pmos ad=2.1312p pd=7.3u as=3.9294p ps=7.84u w=6.66u l=0.6u
X19 cko P6/a_5044_1676# vss vss sg13_hv_nmos ad=2.596p pd=5.58u as=1.408p ps=5.04u w=4.4u l=0.6u
X20 cko P6/a_5044_13476# P6/iovdd_uq0 P6/iovdd_uq0 sg13_hv_pmos ad=3.9294p pd=7.84u as=2.1312p ps=7.3u w=6.66u l=0.6u
X21 P6/iovdd_uq0 P6/a_5044_13476# cko P6/iovdd_uq0 sg13_hv_pmos ad=2.1312p pd=7.3u as=3.9294p ps=7.84u w=6.66u l=0.6u
X22 cko P6/a_5044_13476# P6/iovdd_uq0 P6/iovdd_uq0 sg13_hv_pmos ad=3.9294p pd=7.84u as=2.1312p ps=7.3u w=6.66u l=0.6u
X23 cko P6/a_5044_13476# P6/iovdd_uq0 P6/iovdd_uq0 sg13_hv_pmos ad=3.9294p pd=7.84u as=2.1312p ps=7.3u w=6.66u l=0.6u
X24 vss P6/a_5044_1676# cko vss sg13_hv_nmos ad=1.408p pd=5.04u as=2.596p ps=5.58u w=4.4u l=0.6u
X25 _cko P6/iovdd P6/dpantenna P6/l=0.64u w=4.98u
X26 P6/iovdd_uq0 P6/a_5044_13476# cko P6/iovdd_uq0 sg13_hv_pmos ad=2.1312p pd=7.3u as=3.9294p ps=7.84u w=6.66u l=0.6u
X27 cko P6/a_5044_13476# P6/iovdd_uq0 P6/iovdd_uq0 sg13_hv_pmos ad=3.9294p pd=7.84u as=2.1312p ps=7.3u w=6.66u l=0.6u
X28 cko P6/a_5044_13476# P6/iovdd_uq0 P6/iovdd_uq0 sg13_hv_pmos ad=3.9294p pd=7.84u as=2.1312p ps=7.3u w=6.66u l=0.6u
X29 cko P6/a_5044_1676# vss vss sg13_hv_nmos ad=2.596p pd=5.58u as=1.408p ps=5.04u w=4.4u l=0.6u
X30 P6/iovdd_uq0 P6/a_5044_13476# cko P6/iovdd_uq0 sg13_hv_pmos ad=2.1312p pd=7.3u as=3.9294p ps=7.84u w=6.66u l=0.6u
X31 _cko cko vss P6/rppd l=2u w=1u
X32 P6/iovdd_uq0 P6/a_5044_13476# cko P6/iovdd_uq0 sg13_hv_pmos ad=2.1312p pd=7.3u as=3.9294p ps=7.84u w=6.66u l=0.6u
X33 P6/iovdd_uq0 P6/a_5044_13476# cko P6/iovdd_uq0 sg13_hv_pmos ad=2.1312p pd=7.3u as=3.9294p ps=7.84u w=6.66u l=0.6u
X34 cko P6/a_5044_13476# P6/iovdd_uq0 P6/iovdd_uq0 sg13_hv_pmos ad=3.9294p pd=7.84u as=2.1312p ps=7.3u w=6.66u l=0.6u
X35 cko P6/a_5044_1676# vss vss sg13_hv_nmos ad=2.596p pd=5.58u as=1.408p ps=5.04u w=4.4u l=0.6u
X36 vss P6/a_5044_1676# cko vss sg13_hv_nmos ad=1.408p pd=5.04u as=2.596p ps=5.58u w=4.4u l=0.6u
X37 cko P6/a_5044_1676# vss vss sg13_hv_nmos ad=2.596p pd=5.58u as=1.408p ps=5.04u w=4.4u l=0.6u
X38 P6/iovdd_uq0 P6/a_5044_13476# cko P6/iovdd_uq0 sg13_hv_pmos ad=2.1312p pd=7.3u as=3.9294p ps=7.84u w=6.66u l=0.6u
X39 cko P6/a_5044_13476# P6/iovdd_uq0 P6/iovdd_uq0 sg13_hv_pmos ad=3.9294p pd=7.84u as=2.1312p ps=7.3u w=6.66u l=0.6u
X40 cko P6/iovdd_uq0 P6/dpantenna P6/l=1.26u w=27.78u
X41 vss P6/a_5044_1676# cko vss sg13_hv_nmos ad=1.408p pd=5.04u as=2.596p ps=5.58u w=4.4u l=0.6u
X42 P6/iovdd_uq0 P6/a_5044_13476# cko P6/iovdd_uq0 sg13_hv_pmos ad=2.1312p pd=7.3u as=3.9294p ps=7.84u w=6.66u l=0.6u
X43 vss P6/a_5044_1676# cko vss sg13_hv_nmos ad=1.408p pd=5.04u as=2.596p ps=5.58u w=4.4u l=0.6u
X44 cko P6/a_5044_13476# P6/iovdd_uq0 P6/iovdd_uq0 sg13_hv_pmos ad=3.9294p pd=7.84u as=2.1312p ps=7.3u w=6.66u l=0.6u
X45 P6/iovdd_uq0 P6/a_5044_13476# cko P6/iovdd_uq0 sg13_hv_pmos ad=2.1312p pd=7.3u as=3.9294p ps=7.84u w=6.66u l=0.6u
X46 cko P6/a_5044_13476# P6/iovdd_uq0 P6/iovdd_uq0 sg13_hv_pmos ad=3.9294p pd=7.84u as=2.1312p ps=7.3u w=6.66u l=0.6u
X47 cko P6/a_5044_1676# vss vss sg13_hv_nmos ad=2.596p pd=5.58u as=1.408p ps=5.04u w=4.4u l=0.6u
X48 vss P6/a_5044_1676# cko vss sg13_hv_nmos ad=1.408p pd=5.04u as=2.596p ps=5.58u w=4.4u l=0.6u
X49 cko P6/a_5044_13476# P6/iovdd_uq0 P6/iovdd_uq0 sg13_hv_pmos ad=3.9294p pd=7.84u as=3.1302p ps=14.26u w=6.66u l=0.6u
X50 P6/iovdd_uq0 P6/a_5044_13476# cko P6/iovdd_uq0 sg13_hv_pmos ad=3.1302p pd=14.26u as=3.9294p ps=7.84u w=6.66u l=0.6u
X51 P6/iovdd_uq0 P6/a_5044_13476# cko P6/iovdd_uq0 sg13_hv_pmos ad=2.1312p pd=7.3u as=3.9294p ps=7.84u w=6.66u l=0.6u
X52 cko P6/a_5044_13476# P6/iovdd_uq0 P6/iovdd_uq0 sg13_hv_pmos ad=3.9294p pd=7.84u as=2.1312p ps=7.3u w=6.66u l=0.6u
X53 cko P6/iovdd_uq0 P6/dpantenna P6/l=1.26u w=27.78u
X54 cko P6/a_5044_13476# P6/iovdd_uq0 P6/iovdd_uq0 sg13_hv_pmos ad=3.9294p pd=7.84u as=3.1302p ps=14.26u w=6.66u l=0.6u
X55 P6/iovdd_uq0 P6/a_5044_13476# cko P6/iovdd_uq0 sg13_hv_pmos ad=3.1302p pd=14.26u as=3.9294p ps=7.84u w=6.66u l=0.6u
X56 P6/iovdd_uq0 P6/a_5044_13476# cko P6/iovdd_uq0 sg13_hv_pmos ad=2.1312p pd=7.3u as=3.9294p ps=7.84u w=6.66u l=0.6u
X57 cko P6/a_5044_13476# P6/iovdd_uq0 P6/iovdd_uq0 sg13_hv_pmos ad=3.9294p pd=7.84u as=2.1312p ps=7.3u w=6.66u l=0.6u
X58 vss P6/a_11462_28198# P6/dantenna P6/l=3.1u w=0.64u
X59 vss P6/a_5222_3962# P6/dantenna P6/l=1.26u w=27.78u
X60 P6/a_5044_1676# vss vss P6/rppd l=3.54u w=0.5u
X61 P6/iovdd_uq0 P6/a_5044_13476# cko P6/iovdd_uq0 sg13_hv_pmos ad=2.1312p pd=7.3u as=3.9294p ps=7.84u w=6.66u l=0.6u
X62 P6/iovdd_uq0 P6/a_5044_13476# cko P6/iovdd_uq0 sg13_hv_pmos ad=2.1312p pd=7.3u as=3.9294p ps=7.84u w=6.66u l=0.6u
X63 cko P6/a_5044_1676# vss vss sg13_hv_nmos ad=2.596p pd=5.58u as=2.068p ps=9.74u w=4.4u l=0.6u
X64 P6/iovdd_uq0 P6/a_5044_13476# cko P6/iovdd_uq0 sg13_hv_pmos ad=2.1312p pd=7.3u as=3.9294p ps=7.84u w=6.66u l=0.6u
X65 cko P6/a_5044_13476# P6/iovdd_uq0 P6/iovdd_uq0 sg13_hv_pmos ad=3.9294p pd=7.84u as=2.1312p ps=7.3u w=6.66u l=0.6u
X66 cko P6/a_5044_13476# P6/iovdd_uq0 P6/iovdd_uq0 sg13_hv_pmos ad=3.9294p pd=7.84u as=2.1312p ps=7.3u w=6.66u l=0.6u
X67 cko P6/a_5044_13476# P6/iovdd_uq0 P6/iovdd_uq0 sg13_hv_pmos ad=3.9294p pd=7.84u as=2.1312p ps=7.3u w=6.66u l=0.6u
X68 vss P6/a_5044_1676# cko vss sg13_hv_nmos ad=1.408p pd=5.04u as=2.596p ps=5.58u w=4.4u l=0.6u
X0 P7/iovdd_uq0 P7/a_5044_13476# frame P7/iovdd_uq0 sg13_hv_pmos ad=2.1312p pd=7.3u as=3.9294p ps=7.84u w=6.66u l=0.6u
X1 frame P7/a_5044_1676# vss vss sg13_hv_nmos ad=2.596p pd=5.58u as=1.408p ps=5.04u w=4.4u l=0.6u
X2 frame P7/a_5044_13476# P7/iovdd_uq0 P7/iovdd_uq0 sg13_hv_pmos ad=3.9294p pd=7.84u as=2.1312p ps=7.3u w=6.66u l=0.6u
X3 P7/iovdd_uq0 P7/a_5044_13476# frame P7/iovdd_uq0 sg13_hv_pmos ad=2.1312p pd=7.3u as=3.9294p ps=7.84u w=6.66u l=0.6u
X4 P7/iovdd_uq0 P7/a_5044_13476# frame P7/iovdd_uq0 sg13_hv_pmos ad=2.1312p pd=7.3u as=3.9294p ps=7.84u w=6.66u l=0.6u
X5 frame P7/a_5044_1676# vss vss sg13_hv_nmos ad=2.596p pd=5.58u as=1.408p ps=5.04u w=4.4u l=0.6u
X6 frame P7/a_5044_13476# P7/iovdd_uq0 P7/iovdd_uq0 sg13_hv_pmos ad=3.9294p pd=7.84u as=2.1312p ps=7.3u w=6.66u l=0.6u
X7 P7/iovdd_uq0 P7/a_5044_13476# frame P7/iovdd_uq0 sg13_hv_pmos ad=2.1312p pd=7.3u as=3.9294p ps=7.84u w=6.66u l=0.6u
X8 frame P7/a_5044_1676# vss vss sg13_hv_nmos ad=2.596p pd=5.58u as=1.408p ps=5.04u w=4.4u l=0.6u
X9 vss P7/a_5044_1676# frame vss sg13_hv_nmos ad=2.068p pd=9.74u as=2.596p ps=5.58u w=4.4u l=0.6u
X10 frame P7/a_5044_13476# P7/iovdd_uq0 P7/iovdd_uq0 sg13_hv_pmos ad=3.9294p pd=7.84u as=2.1312p ps=7.3u w=6.66u l=0.6u
X11 P7/a_5044_13476# P7/iovdd_uq0 P7/iovdd_uq0 P7/rppd l=12.9u w=0.5u
X12 vss P7/a_5044_1676# frame vss sg13_hv_nmos ad=1.408p pd=5.04u as=2.596p ps=5.58u w=4.4u l=0.6u
X13 frame P7/a_5044_13476# P7/iovdd_uq0 P7/iovdd_uq0 sg13_hv_pmos ad=3.9294p pd=7.84u as=2.1312p ps=7.3u w=6.66u l=0.6u
X14 vss P7/a_5222_4862# P7/dantenna P7/l=1.26u w=27.78u
X15 vss P7/a_5044_1676# frame vss sg13_hv_nmos ad=1.408p pd=5.04u as=2.596p ps=5.58u w=4.4u l=0.6u
X16 frame P7/a_5044_1676# vss vss sg13_hv_nmos ad=2.596p pd=5.58u as=1.408p ps=5.04u w=4.4u l=0.6u
X17 vss P7/a_5044_1676# frame vss sg13_hv_nmos ad=1.408p pd=5.04u as=2.596p ps=5.58u w=4.4u l=0.6u
X18 P7/iovdd_uq0 P7/a_5044_13476# frame P7/iovdd_uq0 sg13_hv_pmos ad=2.1312p pd=7.3u as=3.9294p ps=7.84u w=6.66u l=0.6u
X19 frame P7/a_5044_1676# vss vss sg13_hv_nmos ad=2.596p pd=5.58u as=1.408p ps=5.04u w=4.4u l=0.6u
X20 frame P7/a_5044_13476# P7/iovdd_uq0 P7/iovdd_uq0 sg13_hv_pmos ad=3.9294p pd=7.84u as=2.1312p ps=7.3u w=6.66u l=0.6u
X21 P7/iovdd_uq0 P7/a_5044_13476# frame P7/iovdd_uq0 sg13_hv_pmos ad=2.1312p pd=7.3u as=3.9294p ps=7.84u w=6.66u l=0.6u
X22 frame P7/a_5044_13476# P7/iovdd_uq0 P7/iovdd_uq0 sg13_hv_pmos ad=3.9294p pd=7.84u as=2.1312p ps=7.3u w=6.66u l=0.6u
X23 frame P7/a_5044_13476# P7/iovdd_uq0 P7/iovdd_uq0 sg13_hv_pmos ad=3.9294p pd=7.84u as=2.1312p ps=7.3u w=6.66u l=0.6u
X24 vss P7/a_5044_1676# frame vss sg13_hv_nmos ad=1.408p pd=5.04u as=2.596p ps=5.58u w=4.4u l=0.6u
X25 _frm P7/iovdd P7/dpantenna P7/l=0.64u w=4.98u
X26 P7/iovdd_uq0 P7/a_5044_13476# frame P7/iovdd_uq0 sg13_hv_pmos ad=2.1312p pd=7.3u as=3.9294p ps=7.84u w=6.66u l=0.6u
X27 frame P7/a_5044_13476# P7/iovdd_uq0 P7/iovdd_uq0 sg13_hv_pmos ad=3.9294p pd=7.84u as=2.1312p ps=7.3u w=6.66u l=0.6u
X28 frame P7/a_5044_13476# P7/iovdd_uq0 P7/iovdd_uq0 sg13_hv_pmos ad=3.9294p pd=7.84u as=2.1312p ps=7.3u w=6.66u l=0.6u
X29 frame P7/a_5044_1676# vss vss sg13_hv_nmos ad=2.596p pd=5.58u as=1.408p ps=5.04u w=4.4u l=0.6u
X30 P7/iovdd_uq0 P7/a_5044_13476# frame P7/iovdd_uq0 sg13_hv_pmos ad=2.1312p pd=7.3u as=3.9294p ps=7.84u w=6.66u l=0.6u
X31 _frm frame vss P7/rppd l=2u w=1u
X32 P7/iovdd_uq0 P7/a_5044_13476# frame P7/iovdd_uq0 sg13_hv_pmos ad=2.1312p pd=7.3u as=3.9294p ps=7.84u w=6.66u l=0.6u
X33 P7/iovdd_uq0 P7/a_5044_13476# frame P7/iovdd_uq0 sg13_hv_pmos ad=2.1312p pd=7.3u as=3.9294p ps=7.84u w=6.66u l=0.6u
X34 frame P7/a_5044_13476# P7/iovdd_uq0 P7/iovdd_uq0 sg13_hv_pmos ad=3.9294p pd=7.84u as=2.1312p ps=7.3u w=6.66u l=0.6u
X35 frame P7/a_5044_1676# vss vss sg13_hv_nmos ad=2.596p pd=5.58u as=1.408p ps=5.04u w=4.4u l=0.6u
X36 vss P7/a_5044_1676# frame vss sg13_hv_nmos ad=1.408p pd=5.04u as=2.596p ps=5.58u w=4.4u l=0.6u
X37 frame P7/a_5044_1676# vss vss sg13_hv_nmos ad=2.596p pd=5.58u as=1.408p ps=5.04u w=4.4u l=0.6u
X38 P7/iovdd_uq0 P7/a_5044_13476# frame P7/iovdd_uq0 sg13_hv_pmos ad=2.1312p pd=7.3u as=3.9294p ps=7.84u w=6.66u l=0.6u
X39 frame P7/a_5044_13476# P7/iovdd_uq0 P7/iovdd_uq0 sg13_hv_pmos ad=3.9294p pd=7.84u as=2.1312p ps=7.3u w=6.66u l=0.6u
X40 frame P7/iovdd_uq0 P7/dpantenna P7/l=1.26u w=27.78u
X41 vss P7/a_5044_1676# frame vss sg13_hv_nmos ad=1.408p pd=5.04u as=2.596p ps=5.58u w=4.4u l=0.6u
X42 P7/iovdd_uq0 P7/a_5044_13476# frame P7/iovdd_uq0 sg13_hv_pmos ad=2.1312p pd=7.3u as=3.9294p ps=7.84u w=6.66u l=0.6u
X43 vss P7/a_5044_1676# frame vss sg13_hv_nmos ad=1.408p pd=5.04u as=2.596p ps=5.58u w=4.4u l=0.6u
X44 frame P7/a_5044_13476# P7/iovdd_uq0 P7/iovdd_uq0 sg13_hv_pmos ad=3.9294p pd=7.84u as=2.1312p ps=7.3u w=6.66u l=0.6u
X45 P7/iovdd_uq0 P7/a_5044_13476# frame P7/iovdd_uq0 sg13_hv_pmos ad=2.1312p pd=7.3u as=3.9294p ps=7.84u w=6.66u l=0.6u
X46 frame P7/a_5044_13476# P7/iovdd_uq0 P7/iovdd_uq0 sg13_hv_pmos ad=3.9294p pd=7.84u as=2.1312p ps=7.3u w=6.66u l=0.6u
X47 frame P7/a_5044_1676# vss vss sg13_hv_nmos ad=2.596p pd=5.58u as=1.408p ps=5.04u w=4.4u l=0.6u
X48 vss P7/a_5044_1676# frame vss sg13_hv_nmos ad=1.408p pd=5.04u as=2.596p ps=5.58u w=4.4u l=0.6u
X49 frame P7/a_5044_13476# P7/iovdd_uq0 P7/iovdd_uq0 sg13_hv_pmos ad=3.9294p pd=7.84u as=3.1302p ps=14.26u w=6.66u l=0.6u
X50 P7/iovdd_uq0 P7/a_5044_13476# frame P7/iovdd_uq0 sg13_hv_pmos ad=3.1302p pd=14.26u as=3.9294p ps=7.84u w=6.66u l=0.6u
X51 P7/iovdd_uq0 P7/a_5044_13476# frame P7/iovdd_uq0 sg13_hv_pmos ad=2.1312p pd=7.3u as=3.9294p ps=7.84u w=6.66u l=0.6u
X52 frame P7/a_5044_13476# P7/iovdd_uq0 P7/iovdd_uq0 sg13_hv_pmos ad=3.9294p pd=7.84u as=2.1312p ps=7.3u w=6.66u l=0.6u
X53 frame P7/iovdd_uq0 P7/dpantenna P7/l=1.26u w=27.78u
X54 frame P7/a_5044_13476# P7/iovdd_uq0 P7/iovdd_uq0 sg13_hv_pmos ad=3.9294p pd=7.84u as=3.1302p ps=14.26u w=6.66u l=0.6u
X55 P7/iovdd_uq0 P7/a_5044_13476# frame P7/iovdd_uq0 sg13_hv_pmos ad=3.1302p pd=14.26u as=3.9294p ps=7.84u w=6.66u l=0.6u
X56 P7/iovdd_uq0 P7/a_5044_13476# frame P7/iovdd_uq0 sg13_hv_pmos ad=2.1312p pd=7.3u as=3.9294p ps=7.84u w=6.66u l=0.6u
X57 frame P7/a_5044_13476# P7/iovdd_uq0 P7/iovdd_uq0 sg13_hv_pmos ad=3.9294p pd=7.84u as=2.1312p ps=7.3u w=6.66u l=0.6u
X58 vss P7/a_11462_28198# P7/dantenna P7/l=3.1u w=0.64u
X59 vss P7/a_5222_3962# P7/dantenna P7/l=1.26u w=27.78u
X60 P7/a_5044_1676# vss vss P7/rppd l=3.54u w=0.5u
X61 P7/iovdd_uq0 P7/a_5044_13476# frame P7/iovdd_uq0 sg13_hv_pmos ad=2.1312p pd=7.3u as=3.9294p ps=7.84u w=6.66u l=0.6u
X62 P7/iovdd_uq0 P7/a_5044_13476# frame P7/iovdd_uq0 sg13_hv_pmos ad=2.1312p pd=7.3u as=3.9294p ps=7.84u w=6.66u l=0.6u
X63 frame P7/a_5044_1676# vss vss sg13_hv_nmos ad=2.596p pd=5.58u as=2.068p ps=9.74u w=4.4u l=0.6u
X64 P7/iovdd_uq0 P7/a_5044_13476# frame P7/iovdd_uq0 sg13_hv_pmos ad=2.1312p pd=7.3u as=3.9294p ps=7.84u w=6.66u l=0.6u
X65 frame P7/a_5044_13476# P7/iovdd_uq0 P7/iovdd_uq0 sg13_hv_pmos ad=3.9294p pd=7.84u as=2.1312p ps=7.3u w=6.66u l=0.6u
X66 frame P7/a_5044_13476# P7/iovdd_uq0 P7/iovdd_uq0 sg13_hv_pmos ad=3.9294p pd=7.84u as=2.1312p ps=7.3u w=6.66u l=0.6u
X67 frame P7/a_5044_13476# P7/iovdd_uq0 P7/iovdd_uq0 sg13_hv_pmos ad=3.9294p pd=7.84u as=2.1312p ps=7.3u w=6.66u l=0.6u
X68 vss P7/a_5044_1676# frame vss sg13_hv_nmos ad=1.408p pd=5.04u as=2.596p ps=5.58u w=4.4u l=0.6u
X0 P8/iovdd_uq0 P8/a_5044_13476# vddr P8/iovdd_uq0 sg13_hv_pmos ad=2.1312p pd=7.3u as=3.9294p ps=7.84u w=6.66u l=0.6u
X1 vddr P8/a_5044_1676# vss vss sg13_hv_nmos ad=2.596p pd=5.58u as=1.408p ps=5.04u w=4.4u l=0.6u
X2 vddr P8/a_5044_13476# P8/iovdd_uq0 P8/iovdd_uq0 sg13_hv_pmos ad=3.9294p pd=7.84u as=2.1312p ps=7.3u w=6.66u l=0.6u
X3 P8/iovdd_uq0 P8/a_5044_13476# vddr P8/iovdd_uq0 sg13_hv_pmos ad=2.1312p pd=7.3u as=3.9294p ps=7.84u w=6.66u l=0.6u
X4 P8/iovdd_uq0 P8/a_5044_13476# vddr P8/iovdd_uq0 sg13_hv_pmos ad=2.1312p pd=7.3u as=3.9294p ps=7.84u w=6.66u l=0.6u
X5 vddr P8/a_5044_1676# vss vss sg13_hv_nmos ad=2.596p pd=5.58u as=1.408p ps=5.04u w=4.4u l=0.6u
X6 vddr P8/a_5044_13476# P8/iovdd_uq0 P8/iovdd_uq0 sg13_hv_pmos ad=3.9294p pd=7.84u as=2.1312p ps=7.3u w=6.66u l=0.6u
X7 P8/iovdd_uq0 P8/a_5044_13476# vddr P8/iovdd_uq0 sg13_hv_pmos ad=2.1312p pd=7.3u as=3.9294p ps=7.84u w=6.66u l=0.6u
X8 vddr P8/a_5044_1676# vss vss sg13_hv_nmos ad=2.596p pd=5.58u as=1.408p ps=5.04u w=4.4u l=0.6u
X9 vss P8/a_5044_1676# vddr vss sg13_hv_nmos ad=2.068p pd=9.74u as=2.596p ps=5.58u w=4.4u l=0.6u
X10 vddr P8/a_5044_13476# P8/iovdd_uq0 P8/iovdd_uq0 sg13_hv_pmos ad=3.9294p pd=7.84u as=2.1312p ps=7.3u w=6.66u l=0.6u
X11 P8/a_5044_13476# P8/iovdd_uq0 P8/iovdd_uq0 P8/rppd l=12.9u w=0.5u
X12 vss P8/a_5044_1676# vddr vss sg13_hv_nmos ad=1.408p pd=5.04u as=2.596p ps=5.58u w=4.4u l=0.6u
X13 vddr P8/a_5044_13476# P8/iovdd_uq0 P8/iovdd_uq0 sg13_hv_pmos ad=3.9294p pd=7.84u as=2.1312p ps=7.3u w=6.66u l=0.6u
X14 vss P8/a_5222_4862# P8/dantenna P8/l=1.26u w=27.78u
X15 vss P8/a_5044_1676# vddr vss sg13_hv_nmos ad=1.408p pd=5.04u as=2.596p ps=5.58u w=4.4u l=0.6u
X16 vddr P8/a_5044_1676# vss vss sg13_hv_nmos ad=2.596p pd=5.58u as=1.408p ps=5.04u w=4.4u l=0.6u
X17 vss P8/a_5044_1676# vddr vss sg13_hv_nmos ad=1.408p pd=5.04u as=2.596p ps=5.58u w=4.4u l=0.6u
X18 P8/iovdd_uq0 P8/a_5044_13476# vddr P8/iovdd_uq0 sg13_hv_pmos ad=2.1312p pd=7.3u as=3.9294p ps=7.84u w=6.66u l=0.6u
X19 vddr P8/a_5044_1676# vss vss sg13_hv_nmos ad=2.596p pd=5.58u as=1.408p ps=5.04u w=4.4u l=0.6u
X20 vddr P8/a_5044_13476# P8/iovdd_uq0 P8/iovdd_uq0 sg13_hv_pmos ad=3.9294p pd=7.84u as=2.1312p ps=7.3u w=6.66u l=0.6u
X21 P8/iovdd_uq0 P8/a_5044_13476# vddr P8/iovdd_uq0 sg13_hv_pmos ad=2.1312p pd=7.3u as=3.9294p ps=7.84u w=6.66u l=0.6u
X22 vddr P8/a_5044_13476# P8/iovdd_uq0 P8/iovdd_uq0 sg13_hv_pmos ad=3.9294p pd=7.84u as=2.1312p ps=7.3u w=6.66u l=0.6u
X23 vddr P8/a_5044_13476# P8/iovdd_uq0 P8/iovdd_uq0 sg13_hv_pmos ad=3.9294p pd=7.84u as=2.1312p ps=7.3u w=6.66u l=0.6u
X24 vss P8/a_5044_1676# vddr vss sg13_hv_nmos ad=1.408p pd=5.04u as=2.596p ps=5.58u w=4.4u l=0.6u
X25 vddr P8/iovdd P8/dpantenna P8/l=0.64u w=4.98u
X26 P8/iovdd_uq0 P8/a_5044_13476# vddr P8/iovdd_uq0 sg13_hv_pmos ad=2.1312p pd=7.3u as=3.9294p ps=7.84u w=6.66u l=0.6u
X27 vddr P8/a_5044_13476# P8/iovdd_uq0 P8/iovdd_uq0 sg13_hv_pmos ad=3.9294p pd=7.84u as=2.1312p ps=7.3u w=6.66u l=0.6u
X28 vddr P8/a_5044_13476# P8/iovdd_uq0 P8/iovdd_uq0 sg13_hv_pmos ad=3.9294p pd=7.84u as=2.1312p ps=7.3u w=6.66u l=0.6u
X29 vddr P8/a_5044_1676# vss vss sg13_hv_nmos ad=2.596p pd=5.58u as=1.408p ps=5.04u w=4.4u l=0.6u
X30 P8/iovdd_uq0 P8/a_5044_13476# vddr P8/iovdd_uq0 sg13_hv_pmos ad=2.1312p pd=7.3u as=3.9294p ps=7.84u w=6.66u l=0.6u
X31 vddr vddr vss P8/rppd l=2u w=1u
X32 P8/iovdd_uq0 P8/a_5044_13476# vddr P8/iovdd_uq0 sg13_hv_pmos ad=2.1312p pd=7.3u as=3.9294p ps=7.84u w=6.66u l=0.6u
X33 P8/iovdd_uq0 P8/a_5044_13476# vddr P8/iovdd_uq0 sg13_hv_pmos ad=2.1312p pd=7.3u as=3.9294p ps=7.84u w=6.66u l=0.6u
X34 vddr P8/a_5044_13476# P8/iovdd_uq0 P8/iovdd_uq0 sg13_hv_pmos ad=3.9294p pd=7.84u as=2.1312p ps=7.3u w=6.66u l=0.6u
X35 vddr P8/a_5044_1676# vss vss sg13_hv_nmos ad=2.596p pd=5.58u as=1.408p ps=5.04u w=4.4u l=0.6u
X36 vss P8/a_5044_1676# vddr vss sg13_hv_nmos ad=1.408p pd=5.04u as=2.596p ps=5.58u w=4.4u l=0.6u
X37 vddr P8/a_5044_1676# vss vss sg13_hv_nmos ad=2.596p pd=5.58u as=1.408p ps=5.04u w=4.4u l=0.6u
X38 P8/iovdd_uq0 P8/a_5044_13476# vddr P8/iovdd_uq0 sg13_hv_pmos ad=2.1312p pd=7.3u as=3.9294p ps=7.84u w=6.66u l=0.6u
X39 vddr P8/a_5044_13476# P8/iovdd_uq0 P8/iovdd_uq0 sg13_hv_pmos ad=3.9294p pd=7.84u as=2.1312p ps=7.3u w=6.66u l=0.6u
X40 vddr P8/iovdd_uq0 P8/dpantenna P8/l=1.26u w=27.78u
X41 vss P8/a_5044_1676# vddr vss sg13_hv_nmos ad=1.408p pd=5.04u as=2.596p ps=5.58u w=4.4u l=0.6u
X42 P8/iovdd_uq0 P8/a_5044_13476# vddr P8/iovdd_uq0 sg13_hv_pmos ad=2.1312p pd=7.3u as=3.9294p ps=7.84u w=6.66u l=0.6u
X43 vss P8/a_5044_1676# vddr vss sg13_hv_nmos ad=1.408p pd=5.04u as=2.596p ps=5.58u w=4.4u l=0.6u
X44 vddr P8/a_5044_13476# P8/iovdd_uq0 P8/iovdd_uq0 sg13_hv_pmos ad=3.9294p pd=7.84u as=2.1312p ps=7.3u w=6.66u l=0.6u
X45 P8/iovdd_uq0 P8/a_5044_13476# vddr P8/iovdd_uq0 sg13_hv_pmos ad=2.1312p pd=7.3u as=3.9294p ps=7.84u w=6.66u l=0.6u
X46 vddr P8/a_5044_13476# P8/iovdd_uq0 P8/iovdd_uq0 sg13_hv_pmos ad=3.9294p pd=7.84u as=2.1312p ps=7.3u w=6.66u l=0.6u
X47 vddr P8/a_5044_1676# vss vss sg13_hv_nmos ad=2.596p pd=5.58u as=1.408p ps=5.04u w=4.4u l=0.6u
X48 vss P8/a_5044_1676# vddr vss sg13_hv_nmos ad=1.408p pd=5.04u as=2.596p ps=5.58u w=4.4u l=0.6u
X49 vddr P8/a_5044_13476# P8/iovdd_uq0 P8/iovdd_uq0 sg13_hv_pmos ad=3.9294p pd=7.84u as=3.1302p ps=14.26u w=6.66u l=0.6u
X50 P8/iovdd_uq0 P8/a_5044_13476# vddr P8/iovdd_uq0 sg13_hv_pmos ad=3.1302p pd=14.26u as=3.9294p ps=7.84u w=6.66u l=0.6u
X51 P8/iovdd_uq0 P8/a_5044_13476# vddr P8/iovdd_uq0 sg13_hv_pmos ad=2.1312p pd=7.3u as=3.9294p ps=7.84u w=6.66u l=0.6u
X52 vddr P8/a_5044_13476# P8/iovdd_uq0 P8/iovdd_uq0 sg13_hv_pmos ad=3.9294p pd=7.84u as=2.1312p ps=7.3u w=6.66u l=0.6u
X53 vddr P8/iovdd_uq0 P8/dpantenna P8/l=1.26u w=27.78u
X54 vddr P8/a_5044_13476# P8/iovdd_uq0 P8/iovdd_uq0 sg13_hv_pmos ad=3.9294p pd=7.84u as=3.1302p ps=14.26u w=6.66u l=0.6u
X55 P8/iovdd_uq0 P8/a_5044_13476# vddr P8/iovdd_uq0 sg13_hv_pmos ad=3.1302p pd=14.26u as=3.9294p ps=7.84u w=6.66u l=0.6u
X56 P8/iovdd_uq0 P8/a_5044_13476# vddr P8/iovdd_uq0 sg13_hv_pmos ad=2.1312p pd=7.3u as=3.9294p ps=7.84u w=6.66u l=0.6u
X57 vddr P8/a_5044_13476# P8/iovdd_uq0 P8/iovdd_uq0 sg13_hv_pmos ad=3.9294p pd=7.84u as=2.1312p ps=7.3u w=6.66u l=0.6u
X58 vss P8/a_11462_28198# P8/dantenna P8/l=3.1u w=0.64u
X59 vss P8/a_5222_3962# P8/dantenna P8/l=1.26u w=27.78u
X60 P8/a_5044_1676# vss vss P8/rppd l=3.54u w=0.5u
X61 P8/iovdd_uq0 P8/a_5044_13476# vddr P8/iovdd_uq0 sg13_hv_pmos ad=2.1312p pd=7.3u as=3.9294p ps=7.84u w=6.66u l=0.6u
X62 P8/iovdd_uq0 P8/a_5044_13476# vddr P8/iovdd_uq0 sg13_hv_pmos ad=2.1312p pd=7.3u as=3.9294p ps=7.84u w=6.66u l=0.6u
X63 vddr P8/a_5044_1676# vss vss sg13_hv_nmos ad=2.596p pd=5.58u as=2.068p ps=9.74u w=4.4u l=0.6u
X64 P8/iovdd_uq0 P8/a_5044_13476# vddr P8/iovdd_uq0 sg13_hv_pmos ad=2.1312p pd=7.3u as=3.9294p ps=7.84u w=6.66u l=0.6u
X65 vddr P8/a_5044_13476# P8/iovdd_uq0 P8/iovdd_uq0 sg13_hv_pmos ad=3.9294p pd=7.84u as=2.1312p ps=7.3u w=6.66u l=0.6u
X66 vddr P8/a_5044_13476# P8/iovdd_uq0 P8/iovdd_uq0 sg13_hv_pmos ad=3.9294p pd=7.84u as=2.1312p ps=7.3u w=6.66u l=0.6u
X67 vddr P8/a_5044_13476# P8/iovdd_uq0 P8/iovdd_uq0 sg13_hv_pmos ad=3.9294p pd=7.84u as=2.1312p ps=7.3u w=6.66u l=0.6u
X68 vss P8/a_5044_1676# vddr vss sg13_hv_nmos ad=1.408p pd=5.04u as=2.596p ps=5.58u w=4.4u l=0.6u
X0 D0/iovdd_uq0 D0/a_5044_13476# _n1 D0/iovdd_uq0 sg13_hv_pmos ad=2.1312p pd=7.3u as=3.9294p ps=7.84u w=6.66u l=0.6u
X1 _n1 D0/a_5044_1676# vss vss sg13_hv_nmos ad=2.596p pd=5.58u as=1.408p ps=5.04u w=4.4u l=0.6u
X2 _n1 D0/a_5044_13476# D0/iovdd_uq0 D0/iovdd_uq0 sg13_hv_pmos ad=3.9294p pd=7.84u as=2.1312p ps=7.3u w=6.66u l=0.6u
X3 D0/iovdd_uq0 D0/a_5044_13476# _n1 D0/iovdd_uq0 sg13_hv_pmos ad=2.1312p pd=7.3u as=3.9294p ps=7.84u w=6.66u l=0.6u
X4 D0/iovdd_uq0 D0/a_5044_13476# _n1 D0/iovdd_uq0 sg13_hv_pmos ad=2.1312p pd=7.3u as=3.9294p ps=7.84u w=6.66u l=0.6u
X5 _n1 D0/a_5044_1676# vss vss sg13_hv_nmos ad=2.596p pd=5.58u as=1.408p ps=5.04u w=4.4u l=0.6u
X6 _n1 D0/a_5044_13476# D0/iovdd_uq0 D0/iovdd_uq0 sg13_hv_pmos ad=3.9294p pd=7.84u as=2.1312p ps=7.3u w=6.66u l=0.6u
X7 D0/iovdd_uq0 D0/a_5044_13476# _n1 D0/iovdd_uq0 sg13_hv_pmos ad=2.1312p pd=7.3u as=3.9294p ps=7.84u w=6.66u l=0.6u
X8 _n1 D0/a_5044_1676# vss vss sg13_hv_nmos ad=2.596p pd=5.58u as=1.408p ps=5.04u w=4.4u l=0.6u
X9 vss D0/a_5044_1676# _n1 vss sg13_hv_nmos ad=2.068p pd=9.74u as=2.596p ps=5.58u w=4.4u l=0.6u
X10 _n1 D0/a_5044_13476# D0/iovdd_uq0 D0/iovdd_uq0 sg13_hv_pmos ad=3.9294p pd=7.84u as=2.1312p ps=7.3u w=6.66u l=0.6u
X11 D0/a_5044_13476# D0/iovdd_uq0 D0/iovdd_uq0 D0/rppd l=12.9u w=0.5u
X12 vss D0/a_5044_1676# _n1 vss sg13_hv_nmos ad=1.408p pd=5.04u as=2.596p ps=5.58u w=4.4u l=0.6u
X13 _n1 D0/a_5044_13476# D0/iovdd_uq0 D0/iovdd_uq0 sg13_hv_pmos ad=3.9294p pd=7.84u as=2.1312p ps=7.3u w=6.66u l=0.6u
X14 vss D0/a_5222_4862# D0/dantenna D0/l=1.26u w=27.78u
X15 vss D0/a_5044_1676# _n1 vss sg13_hv_nmos ad=1.408p pd=5.04u as=2.596p ps=5.58u w=4.4u l=0.6u
X16 _n1 D0/a_5044_1676# vss vss sg13_hv_nmos ad=2.596p pd=5.58u as=1.408p ps=5.04u w=4.4u l=0.6u
X17 vss D0/a_5044_1676# _n1 vss sg13_hv_nmos ad=1.408p pd=5.04u as=2.596p ps=5.58u w=4.4u l=0.6u
X18 D0/iovdd_uq0 D0/a_5044_13476# _n1 D0/iovdd_uq0 sg13_hv_pmos ad=2.1312p pd=7.3u as=3.9294p ps=7.84u w=6.66u l=0.6u
X19 _n1 D0/a_5044_1676# vss vss sg13_hv_nmos ad=2.596p pd=5.58u as=1.408p ps=5.04u w=4.4u l=0.6u
X20 _n1 D0/a_5044_13476# D0/iovdd_uq0 D0/iovdd_uq0 sg13_hv_pmos ad=3.9294p pd=7.84u as=2.1312p ps=7.3u w=6.66u l=0.6u
X21 D0/iovdd_uq0 D0/a_5044_13476# _n1 D0/iovdd_uq0 sg13_hv_pmos ad=2.1312p pd=7.3u as=3.9294p ps=7.84u w=6.66u l=0.6u
X22 _n1 D0/a_5044_13476# D0/iovdd_uq0 D0/iovdd_uq0 sg13_hv_pmos ad=3.9294p pd=7.84u as=2.1312p ps=7.3u w=6.66u l=0.6u
X23 _n1 D0/a_5044_13476# D0/iovdd_uq0 D0/iovdd_uq0 sg13_hv_pmos ad=3.9294p pd=7.84u as=2.1312p ps=7.3u w=6.66u l=0.6u
X24 vss D0/a_5044_1676# _n1 vss sg13_hv_nmos ad=1.408p pd=5.04u as=2.596p ps=5.58u w=4.4u l=0.6u
X25 _n1c D0/iovdd D0/dpantenna D0/l=0.64u w=4.98u
X26 D0/iovdd_uq0 D0/a_5044_13476# _n1 D0/iovdd_uq0 sg13_hv_pmos ad=2.1312p pd=7.3u as=3.9294p ps=7.84u w=6.66u l=0.6u
X27 _n1 D0/a_5044_13476# D0/iovdd_uq0 D0/iovdd_uq0 sg13_hv_pmos ad=3.9294p pd=7.84u as=2.1312p ps=7.3u w=6.66u l=0.6u
X28 _n1 D0/a_5044_13476# D0/iovdd_uq0 D0/iovdd_uq0 sg13_hv_pmos ad=3.9294p pd=7.84u as=2.1312p ps=7.3u w=6.66u l=0.6u
X29 _n1 D0/a_5044_1676# vss vss sg13_hv_nmos ad=2.596p pd=5.58u as=1.408p ps=5.04u w=4.4u l=0.6u
X30 D0/iovdd_uq0 D0/a_5044_13476# _n1 D0/iovdd_uq0 sg13_hv_pmos ad=2.1312p pd=7.3u as=3.9294p ps=7.84u w=6.66u l=0.6u
X31 _n1c _n1 vss D0/rppd l=2u w=1u
X32 D0/iovdd_uq0 D0/a_5044_13476# _n1 D0/iovdd_uq0 sg13_hv_pmos ad=2.1312p pd=7.3u as=3.9294p ps=7.84u w=6.66u l=0.6u
X33 D0/iovdd_uq0 D0/a_5044_13476# _n1 D0/iovdd_uq0 sg13_hv_pmos ad=2.1312p pd=7.3u as=3.9294p ps=7.84u w=6.66u l=0.6u
X34 _n1 D0/a_5044_13476# D0/iovdd_uq0 D0/iovdd_uq0 sg13_hv_pmos ad=3.9294p pd=7.84u as=2.1312p ps=7.3u w=6.66u l=0.6u
X35 _n1 D0/a_5044_1676# vss vss sg13_hv_nmos ad=2.596p pd=5.58u as=1.408p ps=5.04u w=4.4u l=0.6u
X36 vss D0/a_5044_1676# _n1 vss sg13_hv_nmos ad=1.408p pd=5.04u as=2.596p ps=5.58u w=4.4u l=0.6u
X37 _n1 D0/a_5044_1676# vss vss sg13_hv_nmos ad=2.596p pd=5.58u as=1.408p ps=5.04u w=4.4u l=0.6u
X38 D0/iovdd_uq0 D0/a_5044_13476# _n1 D0/iovdd_uq0 sg13_hv_pmos ad=2.1312p pd=7.3u as=3.9294p ps=7.84u w=6.66u l=0.6u
X39 _n1 D0/a_5044_13476# D0/iovdd_uq0 D0/iovdd_uq0 sg13_hv_pmos ad=3.9294p pd=7.84u as=2.1312p ps=7.3u w=6.66u l=0.6u
X40 _n1 D0/iovdd_uq0 D0/dpantenna D0/l=1.26u w=27.78u
X41 vss D0/a_5044_1676# _n1 vss sg13_hv_nmos ad=1.408p pd=5.04u as=2.596p ps=5.58u w=4.4u l=0.6u
X42 D0/iovdd_uq0 D0/a_5044_13476# _n1 D0/iovdd_uq0 sg13_hv_pmos ad=2.1312p pd=7.3u as=3.9294p ps=7.84u w=6.66u l=0.6u
X43 vss D0/a_5044_1676# _n1 vss sg13_hv_nmos ad=1.408p pd=5.04u as=2.596p ps=5.58u w=4.4u l=0.6u
X44 _n1 D0/a_5044_13476# D0/iovdd_uq0 D0/iovdd_uq0 sg13_hv_pmos ad=3.9294p pd=7.84u as=2.1312p ps=7.3u w=6.66u l=0.6u
X45 D0/iovdd_uq0 D0/a_5044_13476# _n1 D0/iovdd_uq0 sg13_hv_pmos ad=2.1312p pd=7.3u as=3.9294p ps=7.84u w=6.66u l=0.6u
X46 _n1 D0/a_5044_13476# D0/iovdd_uq0 D0/iovdd_uq0 sg13_hv_pmos ad=3.9294p pd=7.84u as=2.1312p ps=7.3u w=6.66u l=0.6u
X47 _n1 D0/a_5044_1676# vss vss sg13_hv_nmos ad=2.596p pd=5.58u as=1.408p ps=5.04u w=4.4u l=0.6u
X48 vss D0/a_5044_1676# _n1 vss sg13_hv_nmos ad=1.408p pd=5.04u as=2.596p ps=5.58u w=4.4u l=0.6u
X49 _n1 D0/a_5044_13476# D0/iovdd_uq0 D0/iovdd_uq0 sg13_hv_pmos ad=3.9294p pd=7.84u as=3.1302p ps=14.26u w=6.66u l=0.6u
X50 D0/iovdd_uq0 D0/a_5044_13476# _n1 D0/iovdd_uq0 sg13_hv_pmos ad=3.1302p pd=14.26u as=3.9294p ps=7.84u w=6.66u l=0.6u
X51 D0/iovdd_uq0 D0/a_5044_13476# _n1 D0/iovdd_uq0 sg13_hv_pmos ad=2.1312p pd=7.3u as=3.9294p ps=7.84u w=6.66u l=0.6u
X52 _n1 D0/a_5044_13476# D0/iovdd_uq0 D0/iovdd_uq0 sg13_hv_pmos ad=3.9294p pd=7.84u as=2.1312p ps=7.3u w=6.66u l=0.6u
X53 _n1 D0/iovdd_uq0 D0/dpantenna D0/l=1.26u w=27.78u
X54 _n1 D0/a_5044_13476# D0/iovdd_uq0 D0/iovdd_uq0 sg13_hv_pmos ad=3.9294p pd=7.84u as=3.1302p ps=14.26u w=6.66u l=0.6u
X55 D0/iovdd_uq0 D0/a_5044_13476# _n1 D0/iovdd_uq0 sg13_hv_pmos ad=3.1302p pd=14.26u as=3.9294p ps=7.84u w=6.66u l=0.6u
X56 D0/iovdd_uq0 D0/a_5044_13476# _n1 D0/iovdd_uq0 sg13_hv_pmos ad=2.1312p pd=7.3u as=3.9294p ps=7.84u w=6.66u l=0.6u
X57 _n1 D0/a_5044_13476# D0/iovdd_uq0 D0/iovdd_uq0 sg13_hv_pmos ad=3.9294p pd=7.84u as=2.1312p ps=7.3u w=6.66u l=0.6u
X58 vss D0/a_11462_28198# D0/dantenna D0/l=3.1u w=0.64u
X59 vss D0/a_5222_3962# D0/dantenna D0/l=1.26u w=27.78u
X60 D0/a_5044_1676# vss vss D0/rppd l=3.54u w=0.5u
X61 D0/iovdd_uq0 D0/a_5044_13476# _n1 D0/iovdd_uq0 sg13_hv_pmos ad=2.1312p pd=7.3u as=3.9294p ps=7.84u w=6.66u l=0.6u
X62 D0/iovdd_uq0 D0/a_5044_13476# _n1 D0/iovdd_uq0 sg13_hv_pmos ad=2.1312p pd=7.3u as=3.9294p ps=7.84u w=6.66u l=0.6u
X63 _n1 D0/a_5044_1676# vss vss sg13_hv_nmos ad=2.596p pd=5.58u as=2.068p ps=9.74u w=4.4u l=0.6u
X64 D0/iovdd_uq0 D0/a_5044_13476# _n1 D0/iovdd_uq0 sg13_hv_pmos ad=2.1312p pd=7.3u as=3.9294p ps=7.84u w=6.66u l=0.6u
X65 _n1 D0/a_5044_13476# D0/iovdd_uq0 D0/iovdd_uq0 sg13_hv_pmos ad=3.9294p pd=7.84u as=2.1312p ps=7.3u w=6.66u l=0.6u
X66 _n1 D0/a_5044_13476# D0/iovdd_uq0 D0/iovdd_uq0 sg13_hv_pmos ad=3.9294p pd=7.84u as=2.1312p ps=7.3u w=6.66u l=0.6u
X67 _n1 D0/a_5044_13476# D0/iovdd_uq0 D0/iovdd_uq0 sg13_hv_pmos ad=3.9294p pd=7.84u as=2.1312p ps=7.3u w=6.66u l=0.6u
X68 vss D0/a_5044_1676# _n1 vss sg13_hv_nmos ad=1.408p pd=5.04u as=2.596p ps=5.58u w=4.4u l=0.6u
X0 D1/iovdd_uq0 D1/a_5044_13476# _n2 D1/iovdd_uq0 sg13_hv_pmos ad=2.1312p pd=7.3u as=3.9294p ps=7.84u w=6.66u l=0.6u
X1 _n2 D1/a_5044_1676# vss vss sg13_hv_nmos ad=2.596p pd=5.58u as=1.408p ps=5.04u w=4.4u l=0.6u
X2 _n2 D1/a_5044_13476# D1/iovdd_uq0 D1/iovdd_uq0 sg13_hv_pmos ad=3.9294p pd=7.84u as=2.1312p ps=7.3u w=6.66u l=0.6u
X3 D1/iovdd_uq0 D1/a_5044_13476# _n2 D1/iovdd_uq0 sg13_hv_pmos ad=2.1312p pd=7.3u as=3.9294p ps=7.84u w=6.66u l=0.6u
X4 D1/iovdd_uq0 D1/a_5044_13476# _n2 D1/iovdd_uq0 sg13_hv_pmos ad=2.1312p pd=7.3u as=3.9294p ps=7.84u w=6.66u l=0.6u
X5 _n2 D1/a_5044_1676# vss vss sg13_hv_nmos ad=2.596p pd=5.58u as=1.408p ps=5.04u w=4.4u l=0.6u
X6 _n2 D1/a_5044_13476# D1/iovdd_uq0 D1/iovdd_uq0 sg13_hv_pmos ad=3.9294p pd=7.84u as=2.1312p ps=7.3u w=6.66u l=0.6u
X7 D1/iovdd_uq0 D1/a_5044_13476# _n2 D1/iovdd_uq0 sg13_hv_pmos ad=2.1312p pd=7.3u as=3.9294p ps=7.84u w=6.66u l=0.6u
X8 _n2 D1/a_5044_1676# vss vss sg13_hv_nmos ad=2.596p pd=5.58u as=1.408p ps=5.04u w=4.4u l=0.6u
X9 vss D1/a_5044_1676# _n2 vss sg13_hv_nmos ad=2.068p pd=9.74u as=2.596p ps=5.58u w=4.4u l=0.6u
X10 _n2 D1/a_5044_13476# D1/iovdd_uq0 D1/iovdd_uq0 sg13_hv_pmos ad=3.9294p pd=7.84u as=2.1312p ps=7.3u w=6.66u l=0.6u
X11 D1/a_5044_13476# D1/iovdd_uq0 D1/iovdd_uq0 D1/rppd l=12.9u w=0.5u
X12 vss D1/a_5044_1676# _n2 vss sg13_hv_nmos ad=1.408p pd=5.04u as=2.596p ps=5.58u w=4.4u l=0.6u
X13 _n2 D1/a_5044_13476# D1/iovdd_uq0 D1/iovdd_uq0 sg13_hv_pmos ad=3.9294p pd=7.84u as=2.1312p ps=7.3u w=6.66u l=0.6u
X14 vss D1/a_5222_4862# D1/dantenna D1/l=1.26u w=27.78u
X15 vss D1/a_5044_1676# _n2 vss sg13_hv_nmos ad=1.408p pd=5.04u as=2.596p ps=5.58u w=4.4u l=0.6u
X16 _n2 D1/a_5044_1676# vss vss sg13_hv_nmos ad=2.596p pd=5.58u as=1.408p ps=5.04u w=4.4u l=0.6u
X17 vss D1/a_5044_1676# _n2 vss sg13_hv_nmos ad=1.408p pd=5.04u as=2.596p ps=5.58u w=4.4u l=0.6u
X18 D1/iovdd_uq0 D1/a_5044_13476# _n2 D1/iovdd_uq0 sg13_hv_pmos ad=2.1312p pd=7.3u as=3.9294p ps=7.84u w=6.66u l=0.6u
X19 _n2 D1/a_5044_1676# vss vss sg13_hv_nmos ad=2.596p pd=5.58u as=1.408p ps=5.04u w=4.4u l=0.6u
X20 _n2 D1/a_5044_13476# D1/iovdd_uq0 D1/iovdd_uq0 sg13_hv_pmos ad=3.9294p pd=7.84u as=2.1312p ps=7.3u w=6.66u l=0.6u
X21 D1/iovdd_uq0 D1/a_5044_13476# _n2 D1/iovdd_uq0 sg13_hv_pmos ad=2.1312p pd=7.3u as=3.9294p ps=7.84u w=6.66u l=0.6u
X22 _n2 D1/a_5044_13476# D1/iovdd_uq0 D1/iovdd_uq0 sg13_hv_pmos ad=3.9294p pd=7.84u as=2.1312p ps=7.3u w=6.66u l=0.6u
X23 _n2 D1/a_5044_13476# D1/iovdd_uq0 D1/iovdd_uq0 sg13_hv_pmos ad=3.9294p pd=7.84u as=2.1312p ps=7.3u w=6.66u l=0.6u
X24 vss D1/a_5044_1676# _n2 vss sg13_hv_nmos ad=1.408p pd=5.04u as=2.596p ps=5.58u w=4.4u l=0.6u
X25 _n2c D1/iovdd D1/dpantenna D1/l=0.64u w=4.98u
X26 D1/iovdd_uq0 D1/a_5044_13476# _n2 D1/iovdd_uq0 sg13_hv_pmos ad=2.1312p pd=7.3u as=3.9294p ps=7.84u w=6.66u l=0.6u
X27 _n2 D1/a_5044_13476# D1/iovdd_uq0 D1/iovdd_uq0 sg13_hv_pmos ad=3.9294p pd=7.84u as=2.1312p ps=7.3u w=6.66u l=0.6u
X28 _n2 D1/a_5044_13476# D1/iovdd_uq0 D1/iovdd_uq0 sg13_hv_pmos ad=3.9294p pd=7.84u as=2.1312p ps=7.3u w=6.66u l=0.6u
X29 _n2 D1/a_5044_1676# vss vss sg13_hv_nmos ad=2.596p pd=5.58u as=1.408p ps=5.04u w=4.4u l=0.6u
X30 D1/iovdd_uq0 D1/a_5044_13476# _n2 D1/iovdd_uq0 sg13_hv_pmos ad=2.1312p pd=7.3u as=3.9294p ps=7.84u w=6.66u l=0.6u
X31 _n2c _n2 vss D1/rppd l=2u w=1u
X32 D1/iovdd_uq0 D1/a_5044_13476# _n2 D1/iovdd_uq0 sg13_hv_pmos ad=2.1312p pd=7.3u as=3.9294p ps=7.84u w=6.66u l=0.6u
X33 D1/iovdd_uq0 D1/a_5044_13476# _n2 D1/iovdd_uq0 sg13_hv_pmos ad=2.1312p pd=7.3u as=3.9294p ps=7.84u w=6.66u l=0.6u
X34 _n2 D1/a_5044_13476# D1/iovdd_uq0 D1/iovdd_uq0 sg13_hv_pmos ad=3.9294p pd=7.84u as=2.1312p ps=7.3u w=6.66u l=0.6u
X35 _n2 D1/a_5044_1676# vss vss sg13_hv_nmos ad=2.596p pd=5.58u as=1.408p ps=5.04u w=4.4u l=0.6u
X36 vss D1/a_5044_1676# _n2 vss sg13_hv_nmos ad=1.408p pd=5.04u as=2.596p ps=5.58u w=4.4u l=0.6u
X37 _n2 D1/a_5044_1676# vss vss sg13_hv_nmos ad=2.596p pd=5.58u as=1.408p ps=5.04u w=4.4u l=0.6u
X38 D1/iovdd_uq0 D1/a_5044_13476# _n2 D1/iovdd_uq0 sg13_hv_pmos ad=2.1312p pd=7.3u as=3.9294p ps=7.84u w=6.66u l=0.6u
X39 _n2 D1/a_5044_13476# D1/iovdd_uq0 D1/iovdd_uq0 sg13_hv_pmos ad=3.9294p pd=7.84u as=2.1312p ps=7.3u w=6.66u l=0.6u
X40 _n2 D1/iovdd_uq0 D1/dpantenna D1/l=1.26u w=27.78u
X41 vss D1/a_5044_1676# _n2 vss sg13_hv_nmos ad=1.408p pd=5.04u as=2.596p ps=5.58u w=4.4u l=0.6u
X42 D1/iovdd_uq0 D1/a_5044_13476# _n2 D1/iovdd_uq0 sg13_hv_pmos ad=2.1312p pd=7.3u as=3.9294p ps=7.84u w=6.66u l=0.6u
X43 vss D1/a_5044_1676# _n2 vss sg13_hv_nmos ad=1.408p pd=5.04u as=2.596p ps=5.58u w=4.4u l=0.6u
X44 _n2 D1/a_5044_13476# D1/iovdd_uq0 D1/iovdd_uq0 sg13_hv_pmos ad=3.9294p pd=7.84u as=2.1312p ps=7.3u w=6.66u l=0.6u
X45 D1/iovdd_uq0 D1/a_5044_13476# _n2 D1/iovdd_uq0 sg13_hv_pmos ad=2.1312p pd=7.3u as=3.9294p ps=7.84u w=6.66u l=0.6u
X46 _n2 D1/a_5044_13476# D1/iovdd_uq0 D1/iovdd_uq0 sg13_hv_pmos ad=3.9294p pd=7.84u as=2.1312p ps=7.3u w=6.66u l=0.6u
X47 _n2 D1/a_5044_1676# vss vss sg13_hv_nmos ad=2.596p pd=5.58u as=1.408p ps=5.04u w=4.4u l=0.6u
X48 vss D1/a_5044_1676# _n2 vss sg13_hv_nmos ad=1.408p pd=5.04u as=2.596p ps=5.58u w=4.4u l=0.6u
X49 _n2 D1/a_5044_13476# D1/iovdd_uq0 D1/iovdd_uq0 sg13_hv_pmos ad=3.9294p pd=7.84u as=3.1302p ps=14.26u w=6.66u l=0.6u
X50 D1/iovdd_uq0 D1/a_5044_13476# _n2 D1/iovdd_uq0 sg13_hv_pmos ad=3.1302p pd=14.26u as=3.9294p ps=7.84u w=6.66u l=0.6u
X51 D1/iovdd_uq0 D1/a_5044_13476# _n2 D1/iovdd_uq0 sg13_hv_pmos ad=2.1312p pd=7.3u as=3.9294p ps=7.84u w=6.66u l=0.6u
X52 _n2 D1/a_5044_13476# D1/iovdd_uq0 D1/iovdd_uq0 sg13_hv_pmos ad=3.9294p pd=7.84u as=2.1312p ps=7.3u w=6.66u l=0.6u
X53 _n2 D1/iovdd_uq0 D1/dpantenna D1/l=1.26u w=27.78u
X54 _n2 D1/a_5044_13476# D1/iovdd_uq0 D1/iovdd_uq0 sg13_hv_pmos ad=3.9294p pd=7.84u as=3.1302p ps=14.26u w=6.66u l=0.6u
X55 D1/iovdd_uq0 D1/a_5044_13476# _n2 D1/iovdd_uq0 sg13_hv_pmos ad=3.1302p pd=14.26u as=3.9294p ps=7.84u w=6.66u l=0.6u
X56 D1/iovdd_uq0 D1/a_5044_13476# _n2 D1/iovdd_uq0 sg13_hv_pmos ad=2.1312p pd=7.3u as=3.9294p ps=7.84u w=6.66u l=0.6u
X57 _n2 D1/a_5044_13476# D1/iovdd_uq0 D1/iovdd_uq0 sg13_hv_pmos ad=3.9294p pd=7.84u as=2.1312p ps=7.3u w=6.66u l=0.6u
X58 vss D1/a_11462_28198# D1/dantenna D1/l=3.1u w=0.64u
X59 vss D1/a_5222_3962# D1/dantenna D1/l=1.26u w=27.78u
X60 D1/a_5044_1676# vss vss D1/rppd l=3.54u w=0.5u
X61 D1/iovdd_uq0 D1/a_5044_13476# _n2 D1/iovdd_uq0 sg13_hv_pmos ad=2.1312p pd=7.3u as=3.9294p ps=7.84u w=6.66u l=0.6u
X62 D1/iovdd_uq0 D1/a_5044_13476# _n2 D1/iovdd_uq0 sg13_hv_pmos ad=2.1312p pd=7.3u as=3.9294p ps=7.84u w=6.66u l=0.6u
X63 _n2 D1/a_5044_1676# vss vss sg13_hv_nmos ad=2.596p pd=5.58u as=2.068p ps=9.74u w=4.4u l=0.6u
X64 D1/iovdd_uq0 D1/a_5044_13476# _n2 D1/iovdd_uq0 sg13_hv_pmos ad=2.1312p pd=7.3u as=3.9294p ps=7.84u w=6.66u l=0.6u
X65 _n2 D1/a_5044_13476# D1/iovdd_uq0 D1/iovdd_uq0 sg13_hv_pmos ad=3.9294p pd=7.84u as=2.1312p ps=7.3u w=6.66u l=0.6u
X66 _n2 D1/a_5044_13476# D1/iovdd_uq0 D1/iovdd_uq0 sg13_hv_pmos ad=3.9294p pd=7.84u as=2.1312p ps=7.3u w=6.66u l=0.6u
X67 _n2 D1/a_5044_13476# D1/iovdd_uq0 D1/iovdd_uq0 sg13_hv_pmos ad=3.9294p pd=7.84u as=2.1312p ps=7.3u w=6.66u l=0.6u
X68 vss D1/a_5044_1676# _n2 vss sg13_hv_nmos ad=1.408p pd=5.04u as=2.596p ps=5.58u w=4.4u l=0.6u
X0 D2/iovdd_uq0 D2/a_5044_13476# _n3 D2/iovdd_uq0 sg13_hv_pmos ad=2.1312p pd=7.3u as=3.9294p ps=7.84u w=6.66u l=0.6u
X1 _n3 D2/a_5044_1676# vss vss sg13_hv_nmos ad=2.596p pd=5.58u as=1.408p ps=5.04u w=4.4u l=0.6u
X2 _n3 D2/a_5044_13476# D2/iovdd_uq0 D2/iovdd_uq0 sg13_hv_pmos ad=3.9294p pd=7.84u as=2.1312p ps=7.3u w=6.66u l=0.6u
X3 D2/iovdd_uq0 D2/a_5044_13476# _n3 D2/iovdd_uq0 sg13_hv_pmos ad=2.1312p pd=7.3u as=3.9294p ps=7.84u w=6.66u l=0.6u
X4 D2/iovdd_uq0 D2/a_5044_13476# _n3 D2/iovdd_uq0 sg13_hv_pmos ad=2.1312p pd=7.3u as=3.9294p ps=7.84u w=6.66u l=0.6u
X5 _n3 D2/a_5044_1676# vss vss sg13_hv_nmos ad=2.596p pd=5.58u as=1.408p ps=5.04u w=4.4u l=0.6u
X6 _n3 D2/a_5044_13476# D2/iovdd_uq0 D2/iovdd_uq0 sg13_hv_pmos ad=3.9294p pd=7.84u as=2.1312p ps=7.3u w=6.66u l=0.6u
X7 D2/iovdd_uq0 D2/a_5044_13476# _n3 D2/iovdd_uq0 sg13_hv_pmos ad=2.1312p pd=7.3u as=3.9294p ps=7.84u w=6.66u l=0.6u
X8 _n3 D2/a_5044_1676# vss vss sg13_hv_nmos ad=2.596p pd=5.58u as=1.408p ps=5.04u w=4.4u l=0.6u
X9 vss D2/a_5044_1676# _n3 vss sg13_hv_nmos ad=2.068p pd=9.74u as=2.596p ps=5.58u w=4.4u l=0.6u
X10 _n3 D2/a_5044_13476# D2/iovdd_uq0 D2/iovdd_uq0 sg13_hv_pmos ad=3.9294p pd=7.84u as=2.1312p ps=7.3u w=6.66u l=0.6u
X11 D2/a_5044_13476# D2/iovdd_uq0 D2/iovdd_uq0 D2/rppd l=12.9u w=0.5u
X12 vss D2/a_5044_1676# _n3 vss sg13_hv_nmos ad=1.408p pd=5.04u as=2.596p ps=5.58u w=4.4u l=0.6u
X13 _n3 D2/a_5044_13476# D2/iovdd_uq0 D2/iovdd_uq0 sg13_hv_pmos ad=3.9294p pd=7.84u as=2.1312p ps=7.3u w=6.66u l=0.6u
X14 vss D2/a_5222_4862# D2/dantenna D2/l=1.26u w=27.78u
X15 vss D2/a_5044_1676# _n3 vss sg13_hv_nmos ad=1.408p pd=5.04u as=2.596p ps=5.58u w=4.4u l=0.6u
X16 _n3 D2/a_5044_1676# vss vss sg13_hv_nmos ad=2.596p pd=5.58u as=1.408p ps=5.04u w=4.4u l=0.6u
X17 vss D2/a_5044_1676# _n3 vss sg13_hv_nmos ad=1.408p pd=5.04u as=2.596p ps=5.58u w=4.4u l=0.6u
X18 D2/iovdd_uq0 D2/a_5044_13476# _n3 D2/iovdd_uq0 sg13_hv_pmos ad=2.1312p pd=7.3u as=3.9294p ps=7.84u w=6.66u l=0.6u
X19 _n3 D2/a_5044_1676# vss vss sg13_hv_nmos ad=2.596p pd=5.58u as=1.408p ps=5.04u w=4.4u l=0.6u
X20 _n3 D2/a_5044_13476# D2/iovdd_uq0 D2/iovdd_uq0 sg13_hv_pmos ad=3.9294p pd=7.84u as=2.1312p ps=7.3u w=6.66u l=0.6u
X21 D2/iovdd_uq0 D2/a_5044_13476# _n3 D2/iovdd_uq0 sg13_hv_pmos ad=2.1312p pd=7.3u as=3.9294p ps=7.84u w=6.66u l=0.6u
X22 _n3 D2/a_5044_13476# D2/iovdd_uq0 D2/iovdd_uq0 sg13_hv_pmos ad=3.9294p pd=7.84u as=2.1312p ps=7.3u w=6.66u l=0.6u
X23 _n3 D2/a_5044_13476# D2/iovdd_uq0 D2/iovdd_uq0 sg13_hv_pmos ad=3.9294p pd=7.84u as=2.1312p ps=7.3u w=6.66u l=0.6u
X24 vss D2/a_5044_1676# _n3 vss sg13_hv_nmos ad=1.408p pd=5.04u as=2.596p ps=5.58u w=4.4u l=0.6u
X25 _n3c D2/iovdd D2/dpantenna D2/l=0.64u w=4.98u
X26 D2/iovdd_uq0 D2/a_5044_13476# _n3 D2/iovdd_uq0 sg13_hv_pmos ad=2.1312p pd=7.3u as=3.9294p ps=7.84u w=6.66u l=0.6u
X27 _n3 D2/a_5044_13476# D2/iovdd_uq0 D2/iovdd_uq0 sg13_hv_pmos ad=3.9294p pd=7.84u as=2.1312p ps=7.3u w=6.66u l=0.6u
X28 _n3 D2/a_5044_13476# D2/iovdd_uq0 D2/iovdd_uq0 sg13_hv_pmos ad=3.9294p pd=7.84u as=2.1312p ps=7.3u w=6.66u l=0.6u
X29 _n3 D2/a_5044_1676# vss vss sg13_hv_nmos ad=2.596p pd=5.58u as=1.408p ps=5.04u w=4.4u l=0.6u
X30 D2/iovdd_uq0 D2/a_5044_13476# _n3 D2/iovdd_uq0 sg13_hv_pmos ad=2.1312p pd=7.3u as=3.9294p ps=7.84u w=6.66u l=0.6u
X31 _n3c _n3 vss D2/rppd l=2u w=1u
X32 D2/iovdd_uq0 D2/a_5044_13476# _n3 D2/iovdd_uq0 sg13_hv_pmos ad=2.1312p pd=7.3u as=3.9294p ps=7.84u w=6.66u l=0.6u
X33 D2/iovdd_uq0 D2/a_5044_13476# _n3 D2/iovdd_uq0 sg13_hv_pmos ad=2.1312p pd=7.3u as=3.9294p ps=7.84u w=6.66u l=0.6u
X34 _n3 D2/a_5044_13476# D2/iovdd_uq0 D2/iovdd_uq0 sg13_hv_pmos ad=3.9294p pd=7.84u as=2.1312p ps=7.3u w=6.66u l=0.6u
X35 _n3 D2/a_5044_1676# vss vss sg13_hv_nmos ad=2.596p pd=5.58u as=1.408p ps=5.04u w=4.4u l=0.6u
X36 vss D2/a_5044_1676# _n3 vss sg13_hv_nmos ad=1.408p pd=5.04u as=2.596p ps=5.58u w=4.4u l=0.6u
X37 _n3 D2/a_5044_1676# vss vss sg13_hv_nmos ad=2.596p pd=5.58u as=1.408p ps=5.04u w=4.4u l=0.6u
X38 D2/iovdd_uq0 D2/a_5044_13476# _n3 D2/iovdd_uq0 sg13_hv_pmos ad=2.1312p pd=7.3u as=3.9294p ps=7.84u w=6.66u l=0.6u
X39 _n3 D2/a_5044_13476# D2/iovdd_uq0 D2/iovdd_uq0 sg13_hv_pmos ad=3.9294p pd=7.84u as=2.1312p ps=7.3u w=6.66u l=0.6u
X40 _n3 D2/iovdd_uq0 D2/dpantenna D2/l=1.26u w=27.78u
X41 vss D2/a_5044_1676# _n3 vss sg13_hv_nmos ad=1.408p pd=5.04u as=2.596p ps=5.58u w=4.4u l=0.6u
X42 D2/iovdd_uq0 D2/a_5044_13476# _n3 D2/iovdd_uq0 sg13_hv_pmos ad=2.1312p pd=7.3u as=3.9294p ps=7.84u w=6.66u l=0.6u
X43 vss D2/a_5044_1676# _n3 vss sg13_hv_nmos ad=1.408p pd=5.04u as=2.596p ps=5.58u w=4.4u l=0.6u
X44 _n3 D2/a_5044_13476# D2/iovdd_uq0 D2/iovdd_uq0 sg13_hv_pmos ad=3.9294p pd=7.84u as=2.1312p ps=7.3u w=6.66u l=0.6u
X45 D2/iovdd_uq0 D2/a_5044_13476# _n3 D2/iovdd_uq0 sg13_hv_pmos ad=2.1312p pd=7.3u as=3.9294p ps=7.84u w=6.66u l=0.6u
X46 _n3 D2/a_5044_13476# D2/iovdd_uq0 D2/iovdd_uq0 sg13_hv_pmos ad=3.9294p pd=7.84u as=2.1312p ps=7.3u w=6.66u l=0.6u
X47 _n3 D2/a_5044_1676# vss vss sg13_hv_nmos ad=2.596p pd=5.58u as=1.408p ps=5.04u w=4.4u l=0.6u
X48 vss D2/a_5044_1676# _n3 vss sg13_hv_nmos ad=1.408p pd=5.04u as=2.596p ps=5.58u w=4.4u l=0.6u
X49 _n3 D2/a_5044_13476# D2/iovdd_uq0 D2/iovdd_uq0 sg13_hv_pmos ad=3.9294p pd=7.84u as=3.1302p ps=14.26u w=6.66u l=0.6u
X50 D2/iovdd_uq0 D2/a_5044_13476# _n3 D2/iovdd_uq0 sg13_hv_pmos ad=3.1302p pd=14.26u as=3.9294p ps=7.84u w=6.66u l=0.6u
X51 D2/iovdd_uq0 D2/a_5044_13476# _n3 D2/iovdd_uq0 sg13_hv_pmos ad=2.1312p pd=7.3u as=3.9294p ps=7.84u w=6.66u l=0.6u
X52 _n3 D2/a_5044_13476# D2/iovdd_uq0 D2/iovdd_uq0 sg13_hv_pmos ad=3.9294p pd=7.84u as=2.1312p ps=7.3u w=6.66u l=0.6u
X53 _n3 D2/iovdd_uq0 D2/dpantenna D2/l=1.26u w=27.78u
X54 _n3 D2/a_5044_13476# D2/iovdd_uq0 D2/iovdd_uq0 sg13_hv_pmos ad=3.9294p pd=7.84u as=3.1302p ps=14.26u w=6.66u l=0.6u
X55 D2/iovdd_uq0 D2/a_5044_13476# _n3 D2/iovdd_uq0 sg13_hv_pmos ad=3.1302p pd=14.26u as=3.9294p ps=7.84u w=6.66u l=0.6u
X56 D2/iovdd_uq0 D2/a_5044_13476# _n3 D2/iovdd_uq0 sg13_hv_pmos ad=2.1312p pd=7.3u as=3.9294p ps=7.84u w=6.66u l=0.6u
X57 _n3 D2/a_5044_13476# D2/iovdd_uq0 D2/iovdd_uq0 sg13_hv_pmos ad=3.9294p pd=7.84u as=2.1312p ps=7.3u w=6.66u l=0.6u
X58 vss D2/a_11462_28198# D2/dantenna D2/l=3.1u w=0.64u
X59 vss D2/a_5222_3962# D2/dantenna D2/l=1.26u w=27.78u
X60 D2/a_5044_1676# vss vss D2/rppd l=3.54u w=0.5u
X61 D2/iovdd_uq0 D2/a_5044_13476# _n3 D2/iovdd_uq0 sg13_hv_pmos ad=2.1312p pd=7.3u as=3.9294p ps=7.84u w=6.66u l=0.6u
X62 D2/iovdd_uq0 D2/a_5044_13476# _n3 D2/iovdd_uq0 sg13_hv_pmos ad=2.1312p pd=7.3u as=3.9294p ps=7.84u w=6.66u l=0.6u
X63 _n3 D2/a_5044_1676# vss vss sg13_hv_nmos ad=2.596p pd=5.58u as=2.068p ps=9.74u w=4.4u l=0.6u
X64 D2/iovdd_uq0 D2/a_5044_13476# _n3 D2/iovdd_uq0 sg13_hv_pmos ad=2.1312p pd=7.3u as=3.9294p ps=7.84u w=6.66u l=0.6u
X65 _n3 D2/a_5044_13476# D2/iovdd_uq0 D2/iovdd_uq0 sg13_hv_pmos ad=3.9294p pd=7.84u as=2.1312p ps=7.3u w=6.66u l=0.6u
X66 _n3 D2/a_5044_13476# D2/iovdd_uq0 D2/iovdd_uq0 sg13_hv_pmos ad=3.9294p pd=7.84u as=2.1312p ps=7.3u w=6.66u l=0.6u
X67 _n3 D2/a_5044_13476# D2/iovdd_uq0 D2/iovdd_uq0 sg13_hv_pmos ad=3.9294p pd=7.84u as=2.1312p ps=7.3u w=6.66u l=0.6u
X68 vss D2/a_5044_1676# _n3 vss sg13_hv_nmos ad=1.408p pd=5.04u as=2.596p ps=5.58u w=4.4u l=0.6u
X0 D3/iovdd_uq0 D3/a_5044_13476# _n4 D3/iovdd_uq0 sg13_hv_pmos ad=2.1312p pd=7.3u as=3.9294p ps=7.84u w=6.66u l=0.6u
X1 _n4 D3/a_5044_1676# vss vss sg13_hv_nmos ad=2.596p pd=5.58u as=1.408p ps=5.04u w=4.4u l=0.6u
X2 _n4 D3/a_5044_13476# D3/iovdd_uq0 D3/iovdd_uq0 sg13_hv_pmos ad=3.9294p pd=7.84u as=2.1312p ps=7.3u w=6.66u l=0.6u
X3 D3/iovdd_uq0 D3/a_5044_13476# _n4 D3/iovdd_uq0 sg13_hv_pmos ad=2.1312p pd=7.3u as=3.9294p ps=7.84u w=6.66u l=0.6u
X4 D3/iovdd_uq0 D3/a_5044_13476# _n4 D3/iovdd_uq0 sg13_hv_pmos ad=2.1312p pd=7.3u as=3.9294p ps=7.84u w=6.66u l=0.6u
X5 _n4 D3/a_5044_1676# vss vss sg13_hv_nmos ad=2.596p pd=5.58u as=1.408p ps=5.04u w=4.4u l=0.6u
X6 _n4 D3/a_5044_13476# D3/iovdd_uq0 D3/iovdd_uq0 sg13_hv_pmos ad=3.9294p pd=7.84u as=2.1312p ps=7.3u w=6.66u l=0.6u
X7 D3/iovdd_uq0 D3/a_5044_13476# _n4 D3/iovdd_uq0 sg13_hv_pmos ad=2.1312p pd=7.3u as=3.9294p ps=7.84u w=6.66u l=0.6u
X8 _n4 D3/a_5044_1676# vss vss sg13_hv_nmos ad=2.596p pd=5.58u as=1.408p ps=5.04u w=4.4u l=0.6u
X9 vss D3/a_5044_1676# _n4 vss sg13_hv_nmos ad=2.068p pd=9.74u as=2.596p ps=5.58u w=4.4u l=0.6u
X10 _n4 D3/a_5044_13476# D3/iovdd_uq0 D3/iovdd_uq0 sg13_hv_pmos ad=3.9294p pd=7.84u as=2.1312p ps=7.3u w=6.66u l=0.6u
X11 D3/a_5044_13476# D3/iovdd_uq0 D3/iovdd_uq0 D3/rppd l=12.9u w=0.5u
X12 vss D3/a_5044_1676# _n4 vss sg13_hv_nmos ad=1.408p pd=5.04u as=2.596p ps=5.58u w=4.4u l=0.6u
X13 _n4 D3/a_5044_13476# D3/iovdd_uq0 D3/iovdd_uq0 sg13_hv_pmos ad=3.9294p pd=7.84u as=2.1312p ps=7.3u w=6.66u l=0.6u
X14 vss D3/a_5222_4862# D3/dantenna D3/l=1.26u w=27.78u
X15 vss D3/a_5044_1676# _n4 vss sg13_hv_nmos ad=1.408p pd=5.04u as=2.596p ps=5.58u w=4.4u l=0.6u
X16 _n4 D3/a_5044_1676# vss vss sg13_hv_nmos ad=2.596p pd=5.58u as=1.408p ps=5.04u w=4.4u l=0.6u
X17 vss D3/a_5044_1676# _n4 vss sg13_hv_nmos ad=1.408p pd=5.04u as=2.596p ps=5.58u w=4.4u l=0.6u
X18 D3/iovdd_uq0 D3/a_5044_13476# _n4 D3/iovdd_uq0 sg13_hv_pmos ad=2.1312p pd=7.3u as=3.9294p ps=7.84u w=6.66u l=0.6u
X19 _n4 D3/a_5044_1676# vss vss sg13_hv_nmos ad=2.596p pd=5.58u as=1.408p ps=5.04u w=4.4u l=0.6u
X20 _n4 D3/a_5044_13476# D3/iovdd_uq0 D3/iovdd_uq0 sg13_hv_pmos ad=3.9294p pd=7.84u as=2.1312p ps=7.3u w=6.66u l=0.6u
X21 D3/iovdd_uq0 D3/a_5044_13476# _n4 D3/iovdd_uq0 sg13_hv_pmos ad=2.1312p pd=7.3u as=3.9294p ps=7.84u w=6.66u l=0.6u
X22 _n4 D3/a_5044_13476# D3/iovdd_uq0 D3/iovdd_uq0 sg13_hv_pmos ad=3.9294p pd=7.84u as=2.1312p ps=7.3u w=6.66u l=0.6u
X23 _n4 D3/a_5044_13476# D3/iovdd_uq0 D3/iovdd_uq0 sg13_hv_pmos ad=3.9294p pd=7.84u as=2.1312p ps=7.3u w=6.66u l=0.6u
X24 vss D3/a_5044_1676# _n4 vss sg13_hv_nmos ad=1.408p pd=5.04u as=2.596p ps=5.58u w=4.4u l=0.6u
X25 _n4c D3/iovdd D3/dpantenna D3/l=0.64u w=4.98u
X26 D3/iovdd_uq0 D3/a_5044_13476# _n4 D3/iovdd_uq0 sg13_hv_pmos ad=2.1312p pd=7.3u as=3.9294p ps=7.84u w=6.66u l=0.6u
X27 _n4 D3/a_5044_13476# D3/iovdd_uq0 D3/iovdd_uq0 sg13_hv_pmos ad=3.9294p pd=7.84u as=2.1312p ps=7.3u w=6.66u l=0.6u
X28 _n4 D3/a_5044_13476# D3/iovdd_uq0 D3/iovdd_uq0 sg13_hv_pmos ad=3.9294p pd=7.84u as=2.1312p ps=7.3u w=6.66u l=0.6u
X29 _n4 D3/a_5044_1676# vss vss sg13_hv_nmos ad=2.596p pd=5.58u as=1.408p ps=5.04u w=4.4u l=0.6u
X30 D3/iovdd_uq0 D3/a_5044_13476# _n4 D3/iovdd_uq0 sg13_hv_pmos ad=2.1312p pd=7.3u as=3.9294p ps=7.84u w=6.66u l=0.6u
X31 _n4c _n4 vss D3/rppd l=2u w=1u
X32 D3/iovdd_uq0 D3/a_5044_13476# _n4 D3/iovdd_uq0 sg13_hv_pmos ad=2.1312p pd=7.3u as=3.9294p ps=7.84u w=6.66u l=0.6u
X33 D3/iovdd_uq0 D3/a_5044_13476# _n4 D3/iovdd_uq0 sg13_hv_pmos ad=2.1312p pd=7.3u as=3.9294p ps=7.84u w=6.66u l=0.6u
X34 _n4 D3/a_5044_13476# D3/iovdd_uq0 D3/iovdd_uq0 sg13_hv_pmos ad=3.9294p pd=7.84u as=2.1312p ps=7.3u w=6.66u l=0.6u
X35 _n4 D3/a_5044_1676# vss vss sg13_hv_nmos ad=2.596p pd=5.58u as=1.408p ps=5.04u w=4.4u l=0.6u
X36 vss D3/a_5044_1676# _n4 vss sg13_hv_nmos ad=1.408p pd=5.04u as=2.596p ps=5.58u w=4.4u l=0.6u
X37 _n4 D3/a_5044_1676# vss vss sg13_hv_nmos ad=2.596p pd=5.58u as=1.408p ps=5.04u w=4.4u l=0.6u
X38 D3/iovdd_uq0 D3/a_5044_13476# _n4 D3/iovdd_uq0 sg13_hv_pmos ad=2.1312p pd=7.3u as=3.9294p ps=7.84u w=6.66u l=0.6u
X39 _n4 D3/a_5044_13476# D3/iovdd_uq0 D3/iovdd_uq0 sg13_hv_pmos ad=3.9294p pd=7.84u as=2.1312p ps=7.3u w=6.66u l=0.6u
X40 _n4 D3/iovdd_uq0 D3/dpantenna D3/l=1.26u w=27.78u
X41 vss D3/a_5044_1676# _n4 vss sg13_hv_nmos ad=1.408p pd=5.04u as=2.596p ps=5.58u w=4.4u l=0.6u
X42 D3/iovdd_uq0 D3/a_5044_13476# _n4 D3/iovdd_uq0 sg13_hv_pmos ad=2.1312p pd=7.3u as=3.9294p ps=7.84u w=6.66u l=0.6u
X43 vss D3/a_5044_1676# _n4 vss sg13_hv_nmos ad=1.408p pd=5.04u as=2.596p ps=5.58u w=4.4u l=0.6u
X44 _n4 D3/a_5044_13476# D3/iovdd_uq0 D3/iovdd_uq0 sg13_hv_pmos ad=3.9294p pd=7.84u as=2.1312p ps=7.3u w=6.66u l=0.6u
X45 D3/iovdd_uq0 D3/a_5044_13476# _n4 D3/iovdd_uq0 sg13_hv_pmos ad=2.1312p pd=7.3u as=3.9294p ps=7.84u w=6.66u l=0.6u
X46 _n4 D3/a_5044_13476# D3/iovdd_uq0 D3/iovdd_uq0 sg13_hv_pmos ad=3.9294p pd=7.84u as=2.1312p ps=7.3u w=6.66u l=0.6u
X47 _n4 D3/a_5044_1676# vss vss sg13_hv_nmos ad=2.596p pd=5.58u as=1.408p ps=5.04u w=4.4u l=0.6u
X48 vss D3/a_5044_1676# _n4 vss sg13_hv_nmos ad=1.408p pd=5.04u as=2.596p ps=5.58u w=4.4u l=0.6u
X49 _n4 D3/a_5044_13476# D3/iovdd_uq0 D3/iovdd_uq0 sg13_hv_pmos ad=3.9294p pd=7.84u as=3.1302p ps=14.26u w=6.66u l=0.6u
X50 D3/iovdd_uq0 D3/a_5044_13476# _n4 D3/iovdd_uq0 sg13_hv_pmos ad=3.1302p pd=14.26u as=3.9294p ps=7.84u w=6.66u l=0.6u
X51 D3/iovdd_uq0 D3/a_5044_13476# _n4 D3/iovdd_uq0 sg13_hv_pmos ad=2.1312p pd=7.3u as=3.9294p ps=7.84u w=6.66u l=0.6u
X52 _n4 D3/a_5044_13476# D3/iovdd_uq0 D3/iovdd_uq0 sg13_hv_pmos ad=3.9294p pd=7.84u as=2.1312p ps=7.3u w=6.66u l=0.6u
X53 _n4 D3/iovdd_uq0 D3/dpantenna D3/l=1.26u w=27.78u
X54 _n4 D3/a_5044_13476# D3/iovdd_uq0 D3/iovdd_uq0 sg13_hv_pmos ad=3.9294p pd=7.84u as=3.1302p ps=14.26u w=6.66u l=0.6u
X55 D3/iovdd_uq0 D3/a_5044_13476# _n4 D3/iovdd_uq0 sg13_hv_pmos ad=3.1302p pd=14.26u as=3.9294p ps=7.84u w=6.66u l=0.6u
X56 D3/iovdd_uq0 D3/a_5044_13476# _n4 D3/iovdd_uq0 sg13_hv_pmos ad=2.1312p pd=7.3u as=3.9294p ps=7.84u w=6.66u l=0.6u
X57 _n4 D3/a_5044_13476# D3/iovdd_uq0 D3/iovdd_uq0 sg13_hv_pmos ad=3.9294p pd=7.84u as=2.1312p ps=7.3u w=6.66u l=0.6u
X58 vss D3/a_11462_28198# D3/dantenna D3/l=3.1u w=0.64u
X59 vss D3/a_5222_3962# D3/dantenna D3/l=1.26u w=27.78u
X60 D3/a_5044_1676# vss vss D3/rppd l=3.54u w=0.5u
X61 D3/iovdd_uq0 D3/a_5044_13476# _n4 D3/iovdd_uq0 sg13_hv_pmos ad=2.1312p pd=7.3u as=3.9294p ps=7.84u w=6.66u l=0.6u
X62 D3/iovdd_uq0 D3/a_5044_13476# _n4 D3/iovdd_uq0 sg13_hv_pmos ad=2.1312p pd=7.3u as=3.9294p ps=7.84u w=6.66u l=0.6u
X63 _n4 D3/a_5044_1676# vss vss sg13_hv_nmos ad=2.596p pd=5.58u as=2.068p ps=9.74u w=4.4u l=0.6u
X64 D3/iovdd_uq0 D3/a_5044_13476# _n4 D3/iovdd_uq0 sg13_hv_pmos ad=2.1312p pd=7.3u as=3.9294p ps=7.84u w=6.66u l=0.6u
X65 _n4 D3/a_5044_13476# D3/iovdd_uq0 D3/iovdd_uq0 sg13_hv_pmos ad=3.9294p pd=7.84u as=2.1312p ps=7.3u w=6.66u l=0.6u
X66 _n4 D3/a_5044_13476# D3/iovdd_uq0 D3/iovdd_uq0 sg13_hv_pmos ad=3.9294p pd=7.84u as=2.1312p ps=7.3u w=6.66u l=0.6u
X67 _n4 D3/a_5044_13476# D3/iovdd_uq0 D3/iovdd_uq0 sg13_hv_pmos ad=3.9294p pd=7.84u as=2.1312p ps=7.3u w=6.66u l=0.6u
X68 vss D3/a_5044_1676# _n4 vss sg13_hv_nmos ad=1.408p pd=5.04u as=2.596p ps=5.58u w=4.4u l=0.6u
X0 D4/iovdd_uq0 D4/a_5044_13476# _n5 D4/iovdd_uq0 sg13_hv_pmos ad=2.1312p pd=7.3u as=3.9294p ps=7.84u w=6.66u l=0.6u
X1 _n5 D4/a_5044_1676# vss vss sg13_hv_nmos ad=2.596p pd=5.58u as=1.408p ps=5.04u w=4.4u l=0.6u
X2 _n5 D4/a_5044_13476# D4/iovdd_uq0 D4/iovdd_uq0 sg13_hv_pmos ad=3.9294p pd=7.84u as=2.1312p ps=7.3u w=6.66u l=0.6u
X3 D4/iovdd_uq0 D4/a_5044_13476# _n5 D4/iovdd_uq0 sg13_hv_pmos ad=2.1312p pd=7.3u as=3.9294p ps=7.84u w=6.66u l=0.6u
X4 D4/iovdd_uq0 D4/a_5044_13476# _n5 D4/iovdd_uq0 sg13_hv_pmos ad=2.1312p pd=7.3u as=3.9294p ps=7.84u w=6.66u l=0.6u
X5 _n5 D4/a_5044_1676# vss vss sg13_hv_nmos ad=2.596p pd=5.58u as=1.408p ps=5.04u w=4.4u l=0.6u
X6 _n5 D4/a_5044_13476# D4/iovdd_uq0 D4/iovdd_uq0 sg13_hv_pmos ad=3.9294p pd=7.84u as=2.1312p ps=7.3u w=6.66u l=0.6u
X7 D4/iovdd_uq0 D4/a_5044_13476# _n5 D4/iovdd_uq0 sg13_hv_pmos ad=2.1312p pd=7.3u as=3.9294p ps=7.84u w=6.66u l=0.6u
X8 _n5 D4/a_5044_1676# vss vss sg13_hv_nmos ad=2.596p pd=5.58u as=1.408p ps=5.04u w=4.4u l=0.6u
X9 vss D4/a_5044_1676# _n5 vss sg13_hv_nmos ad=2.068p pd=9.74u as=2.596p ps=5.58u w=4.4u l=0.6u
X10 _n5 D4/a_5044_13476# D4/iovdd_uq0 D4/iovdd_uq0 sg13_hv_pmos ad=3.9294p pd=7.84u as=2.1312p ps=7.3u w=6.66u l=0.6u
X11 D4/a_5044_13476# D4/iovdd_uq0 D4/iovdd_uq0 D4/rppd l=12.9u w=0.5u
X12 vss D4/a_5044_1676# _n5 vss sg13_hv_nmos ad=1.408p pd=5.04u as=2.596p ps=5.58u w=4.4u l=0.6u
X13 _n5 D4/a_5044_13476# D4/iovdd_uq0 D4/iovdd_uq0 sg13_hv_pmos ad=3.9294p pd=7.84u as=2.1312p ps=7.3u w=6.66u l=0.6u
X14 vss D4/a_5222_4862# D4/dantenna D4/l=1.26u w=27.78u
X15 vss D4/a_5044_1676# _n5 vss sg13_hv_nmos ad=1.408p pd=5.04u as=2.596p ps=5.58u w=4.4u l=0.6u
X16 _n5 D4/a_5044_1676# vss vss sg13_hv_nmos ad=2.596p pd=5.58u as=1.408p ps=5.04u w=4.4u l=0.6u
X17 vss D4/a_5044_1676# _n5 vss sg13_hv_nmos ad=1.408p pd=5.04u as=2.596p ps=5.58u w=4.4u l=0.6u
X18 D4/iovdd_uq0 D4/a_5044_13476# _n5 D4/iovdd_uq0 sg13_hv_pmos ad=2.1312p pd=7.3u as=3.9294p ps=7.84u w=6.66u l=0.6u
X19 _n5 D4/a_5044_1676# vss vss sg13_hv_nmos ad=2.596p pd=5.58u as=1.408p ps=5.04u w=4.4u l=0.6u
X20 _n5 D4/a_5044_13476# D4/iovdd_uq0 D4/iovdd_uq0 sg13_hv_pmos ad=3.9294p pd=7.84u as=2.1312p ps=7.3u w=6.66u l=0.6u
X21 D4/iovdd_uq0 D4/a_5044_13476# _n5 D4/iovdd_uq0 sg13_hv_pmos ad=2.1312p pd=7.3u as=3.9294p ps=7.84u w=6.66u l=0.6u
X22 _n5 D4/a_5044_13476# D4/iovdd_uq0 D4/iovdd_uq0 sg13_hv_pmos ad=3.9294p pd=7.84u as=2.1312p ps=7.3u w=6.66u l=0.6u
X23 _n5 D4/a_5044_13476# D4/iovdd_uq0 D4/iovdd_uq0 sg13_hv_pmos ad=3.9294p pd=7.84u as=2.1312p ps=7.3u w=6.66u l=0.6u
X24 vss D4/a_5044_1676# _n5 vss sg13_hv_nmos ad=1.408p pd=5.04u as=2.596p ps=5.58u w=4.4u l=0.6u
X25 _n5c D4/iovdd D4/dpantenna D4/l=0.64u w=4.98u
X26 D4/iovdd_uq0 D4/a_5044_13476# _n5 D4/iovdd_uq0 sg13_hv_pmos ad=2.1312p pd=7.3u as=3.9294p ps=7.84u w=6.66u l=0.6u
X27 _n5 D4/a_5044_13476# D4/iovdd_uq0 D4/iovdd_uq0 sg13_hv_pmos ad=3.9294p pd=7.84u as=2.1312p ps=7.3u w=6.66u l=0.6u
X28 _n5 D4/a_5044_13476# D4/iovdd_uq0 D4/iovdd_uq0 sg13_hv_pmos ad=3.9294p pd=7.84u as=2.1312p ps=7.3u w=6.66u l=0.6u
X29 _n5 D4/a_5044_1676# vss vss sg13_hv_nmos ad=2.596p pd=5.58u as=1.408p ps=5.04u w=4.4u l=0.6u
X30 D4/iovdd_uq0 D4/a_5044_13476# _n5 D4/iovdd_uq0 sg13_hv_pmos ad=2.1312p pd=7.3u as=3.9294p ps=7.84u w=6.66u l=0.6u
X31 _n5c _n5 vss D4/rppd l=2u w=1u
X32 D4/iovdd_uq0 D4/a_5044_13476# _n5 D4/iovdd_uq0 sg13_hv_pmos ad=2.1312p pd=7.3u as=3.9294p ps=7.84u w=6.66u l=0.6u
X33 D4/iovdd_uq0 D4/a_5044_13476# _n5 D4/iovdd_uq0 sg13_hv_pmos ad=2.1312p pd=7.3u as=3.9294p ps=7.84u w=6.66u l=0.6u
X34 _n5 D4/a_5044_13476# D4/iovdd_uq0 D4/iovdd_uq0 sg13_hv_pmos ad=3.9294p pd=7.84u as=2.1312p ps=7.3u w=6.66u l=0.6u
X35 _n5 D4/a_5044_1676# vss vss sg13_hv_nmos ad=2.596p pd=5.58u as=1.408p ps=5.04u w=4.4u l=0.6u
X36 vss D4/a_5044_1676# _n5 vss sg13_hv_nmos ad=1.408p pd=5.04u as=2.596p ps=5.58u w=4.4u l=0.6u
X37 _n5 D4/a_5044_1676# vss vss sg13_hv_nmos ad=2.596p pd=5.58u as=1.408p ps=5.04u w=4.4u l=0.6u
X38 D4/iovdd_uq0 D4/a_5044_13476# _n5 D4/iovdd_uq0 sg13_hv_pmos ad=2.1312p pd=7.3u as=3.9294p ps=7.84u w=6.66u l=0.6u
X39 _n5 D4/a_5044_13476# D4/iovdd_uq0 D4/iovdd_uq0 sg13_hv_pmos ad=3.9294p pd=7.84u as=2.1312p ps=7.3u w=6.66u l=0.6u
X40 _n5 D4/iovdd_uq0 D4/dpantenna D4/l=1.26u w=27.78u
X41 vss D4/a_5044_1676# _n5 vss sg13_hv_nmos ad=1.408p pd=5.04u as=2.596p ps=5.58u w=4.4u l=0.6u
X42 D4/iovdd_uq0 D4/a_5044_13476# _n5 D4/iovdd_uq0 sg13_hv_pmos ad=2.1312p pd=7.3u as=3.9294p ps=7.84u w=6.66u l=0.6u
X43 vss D4/a_5044_1676# _n5 vss sg13_hv_nmos ad=1.408p pd=5.04u as=2.596p ps=5.58u w=4.4u l=0.6u
X44 _n5 D4/a_5044_13476# D4/iovdd_uq0 D4/iovdd_uq0 sg13_hv_pmos ad=3.9294p pd=7.84u as=2.1312p ps=7.3u w=6.66u l=0.6u
X45 D4/iovdd_uq0 D4/a_5044_13476# _n5 D4/iovdd_uq0 sg13_hv_pmos ad=2.1312p pd=7.3u as=3.9294p ps=7.84u w=6.66u l=0.6u
X46 _n5 D4/a_5044_13476# D4/iovdd_uq0 D4/iovdd_uq0 sg13_hv_pmos ad=3.9294p pd=7.84u as=2.1312p ps=7.3u w=6.66u l=0.6u
X47 _n5 D4/a_5044_1676# vss vss sg13_hv_nmos ad=2.596p pd=5.58u as=1.408p ps=5.04u w=4.4u l=0.6u
X48 vss D4/a_5044_1676# _n5 vss sg13_hv_nmos ad=1.408p pd=5.04u as=2.596p ps=5.58u w=4.4u l=0.6u
X49 _n5 D4/a_5044_13476# D4/iovdd_uq0 D4/iovdd_uq0 sg13_hv_pmos ad=3.9294p pd=7.84u as=3.1302p ps=14.26u w=6.66u l=0.6u
X50 D4/iovdd_uq0 D4/a_5044_13476# _n5 D4/iovdd_uq0 sg13_hv_pmos ad=3.1302p pd=14.26u as=3.9294p ps=7.84u w=6.66u l=0.6u
X51 D4/iovdd_uq0 D4/a_5044_13476# _n5 D4/iovdd_uq0 sg13_hv_pmos ad=2.1312p pd=7.3u as=3.9294p ps=7.84u w=6.66u l=0.6u
X52 _n5 D4/a_5044_13476# D4/iovdd_uq0 D4/iovdd_uq0 sg13_hv_pmos ad=3.9294p pd=7.84u as=2.1312p ps=7.3u w=6.66u l=0.6u
X53 _n5 D4/iovdd_uq0 D4/dpantenna D4/l=1.26u w=27.78u
X54 _n5 D4/a_5044_13476# D4/iovdd_uq0 D4/iovdd_uq0 sg13_hv_pmos ad=3.9294p pd=7.84u as=3.1302p ps=14.26u w=6.66u l=0.6u
X55 D4/iovdd_uq0 D4/a_5044_13476# _n5 D4/iovdd_uq0 sg13_hv_pmos ad=3.1302p pd=14.26u as=3.9294p ps=7.84u w=6.66u l=0.6u
X56 D4/iovdd_uq0 D4/a_5044_13476# _n5 D4/iovdd_uq0 sg13_hv_pmos ad=2.1312p pd=7.3u as=3.9294p ps=7.84u w=6.66u l=0.6u
X57 _n5 D4/a_5044_13476# D4/iovdd_uq0 D4/iovdd_uq0 sg13_hv_pmos ad=3.9294p pd=7.84u as=2.1312p ps=7.3u w=6.66u l=0.6u
X58 vss D4/a_11462_28198# D4/dantenna D4/l=3.1u w=0.64u
X59 vss D4/a_5222_3962# D4/dantenna D4/l=1.26u w=27.78u
X60 D4/a_5044_1676# vss vss D4/rppd l=3.54u w=0.5u
X61 D4/iovdd_uq0 D4/a_5044_13476# _n5 D4/iovdd_uq0 sg13_hv_pmos ad=2.1312p pd=7.3u as=3.9294p ps=7.84u w=6.66u l=0.6u
X62 D4/iovdd_uq0 D4/a_5044_13476# _n5 D4/iovdd_uq0 sg13_hv_pmos ad=2.1312p pd=7.3u as=3.9294p ps=7.84u w=6.66u l=0.6u
X63 _n5 D4/a_5044_1676# vss vss sg13_hv_nmos ad=2.596p pd=5.58u as=2.068p ps=9.74u w=4.4u l=0.6u
X64 D4/iovdd_uq0 D4/a_5044_13476# _n5 D4/iovdd_uq0 sg13_hv_pmos ad=2.1312p pd=7.3u as=3.9294p ps=7.84u w=6.66u l=0.6u
X65 _n5 D4/a_5044_13476# D4/iovdd_uq0 D4/iovdd_uq0 sg13_hv_pmos ad=3.9294p pd=7.84u as=2.1312p ps=7.3u w=6.66u l=0.6u
X66 _n5 D4/a_5044_13476# D4/iovdd_uq0 D4/iovdd_uq0 sg13_hv_pmos ad=3.9294p pd=7.84u as=2.1312p ps=7.3u w=6.66u l=0.6u
X67 _n5 D4/a_5044_13476# D4/iovdd_uq0 D4/iovdd_uq0 sg13_hv_pmos ad=3.9294p pd=7.84u as=2.1312p ps=7.3u w=6.66u l=0.6u
X68 vss D4/a_5044_1676# _n5 vss sg13_hv_nmos ad=1.408p pd=5.04u as=2.596p ps=5.58u w=4.4u l=0.6u
X0 D5/iovdd_uq0 D5/a_5044_13476# _n6 D5/iovdd_uq0 sg13_hv_pmos ad=2.1312p pd=7.3u as=3.9294p ps=7.84u w=6.66u l=0.6u
X1 _n6 D5/a_5044_1676# vss vss sg13_hv_nmos ad=2.596p pd=5.58u as=1.408p ps=5.04u w=4.4u l=0.6u
X2 _n6 D5/a_5044_13476# D5/iovdd_uq0 D5/iovdd_uq0 sg13_hv_pmos ad=3.9294p pd=7.84u as=2.1312p ps=7.3u w=6.66u l=0.6u
X3 D5/iovdd_uq0 D5/a_5044_13476# _n6 D5/iovdd_uq0 sg13_hv_pmos ad=2.1312p pd=7.3u as=3.9294p ps=7.84u w=6.66u l=0.6u
X4 D5/iovdd_uq0 D5/a_5044_13476# _n6 D5/iovdd_uq0 sg13_hv_pmos ad=2.1312p pd=7.3u as=3.9294p ps=7.84u w=6.66u l=0.6u
X5 _n6 D5/a_5044_1676# vss vss sg13_hv_nmos ad=2.596p pd=5.58u as=1.408p ps=5.04u w=4.4u l=0.6u
X6 _n6 D5/a_5044_13476# D5/iovdd_uq0 D5/iovdd_uq0 sg13_hv_pmos ad=3.9294p pd=7.84u as=2.1312p ps=7.3u w=6.66u l=0.6u
X7 D5/iovdd_uq0 D5/a_5044_13476# _n6 D5/iovdd_uq0 sg13_hv_pmos ad=2.1312p pd=7.3u as=3.9294p ps=7.84u w=6.66u l=0.6u
X8 _n6 D5/a_5044_1676# vss vss sg13_hv_nmos ad=2.596p pd=5.58u as=1.408p ps=5.04u w=4.4u l=0.6u
X9 vss D5/a_5044_1676# _n6 vss sg13_hv_nmos ad=2.068p pd=9.74u as=2.596p ps=5.58u w=4.4u l=0.6u
X10 _n6 D5/a_5044_13476# D5/iovdd_uq0 D5/iovdd_uq0 sg13_hv_pmos ad=3.9294p pd=7.84u as=2.1312p ps=7.3u w=6.66u l=0.6u
X11 D5/a_5044_13476# D5/iovdd_uq0 D5/iovdd_uq0 D5/rppd l=12.9u w=0.5u
X12 vss D5/a_5044_1676# _n6 vss sg13_hv_nmos ad=1.408p pd=5.04u as=2.596p ps=5.58u w=4.4u l=0.6u
X13 _n6 D5/a_5044_13476# D5/iovdd_uq0 D5/iovdd_uq0 sg13_hv_pmos ad=3.9294p pd=7.84u as=2.1312p ps=7.3u w=6.66u l=0.6u
X14 vss D5/a_5222_4862# D5/dantenna D5/l=1.26u w=27.78u
X15 vss D5/a_5044_1676# _n6 vss sg13_hv_nmos ad=1.408p pd=5.04u as=2.596p ps=5.58u w=4.4u l=0.6u
X16 _n6 D5/a_5044_1676# vss vss sg13_hv_nmos ad=2.596p pd=5.58u as=1.408p ps=5.04u w=4.4u l=0.6u
X17 vss D5/a_5044_1676# _n6 vss sg13_hv_nmos ad=1.408p pd=5.04u as=2.596p ps=5.58u w=4.4u l=0.6u
X18 D5/iovdd_uq0 D5/a_5044_13476# _n6 D5/iovdd_uq0 sg13_hv_pmos ad=2.1312p pd=7.3u as=3.9294p ps=7.84u w=6.66u l=0.6u
X19 _n6 D5/a_5044_1676# vss vss sg13_hv_nmos ad=2.596p pd=5.58u as=1.408p ps=5.04u w=4.4u l=0.6u
X20 _n6 D5/a_5044_13476# D5/iovdd_uq0 D5/iovdd_uq0 sg13_hv_pmos ad=3.9294p pd=7.84u as=2.1312p ps=7.3u w=6.66u l=0.6u
X21 D5/iovdd_uq0 D5/a_5044_13476# _n6 D5/iovdd_uq0 sg13_hv_pmos ad=2.1312p pd=7.3u as=3.9294p ps=7.84u w=6.66u l=0.6u
X22 _n6 D5/a_5044_13476# D5/iovdd_uq0 D5/iovdd_uq0 sg13_hv_pmos ad=3.9294p pd=7.84u as=2.1312p ps=7.3u w=6.66u l=0.6u
X23 _n6 D5/a_5044_13476# D5/iovdd_uq0 D5/iovdd_uq0 sg13_hv_pmos ad=3.9294p pd=7.84u as=2.1312p ps=7.3u w=6.66u l=0.6u
X24 vss D5/a_5044_1676# _n6 vss sg13_hv_nmos ad=1.408p pd=5.04u as=2.596p ps=5.58u w=4.4u l=0.6u
X25 _n6c D5/iovdd D5/dpantenna D5/l=0.64u w=4.98u
X26 D5/iovdd_uq0 D5/a_5044_13476# _n6 D5/iovdd_uq0 sg13_hv_pmos ad=2.1312p pd=7.3u as=3.9294p ps=7.84u w=6.66u l=0.6u
X27 _n6 D5/a_5044_13476# D5/iovdd_uq0 D5/iovdd_uq0 sg13_hv_pmos ad=3.9294p pd=7.84u as=2.1312p ps=7.3u w=6.66u l=0.6u
X28 _n6 D5/a_5044_13476# D5/iovdd_uq0 D5/iovdd_uq0 sg13_hv_pmos ad=3.9294p pd=7.84u as=2.1312p ps=7.3u w=6.66u l=0.6u
X29 _n6 D5/a_5044_1676# vss vss sg13_hv_nmos ad=2.596p pd=5.58u as=1.408p ps=5.04u w=4.4u l=0.6u
X30 D5/iovdd_uq0 D5/a_5044_13476# _n6 D5/iovdd_uq0 sg13_hv_pmos ad=2.1312p pd=7.3u as=3.9294p ps=7.84u w=6.66u l=0.6u
X31 _n6c _n6 vss D5/rppd l=2u w=1u
X32 D5/iovdd_uq0 D5/a_5044_13476# _n6 D5/iovdd_uq0 sg13_hv_pmos ad=2.1312p pd=7.3u as=3.9294p ps=7.84u w=6.66u l=0.6u
X33 D5/iovdd_uq0 D5/a_5044_13476# _n6 D5/iovdd_uq0 sg13_hv_pmos ad=2.1312p pd=7.3u as=3.9294p ps=7.84u w=6.66u l=0.6u
X34 _n6 D5/a_5044_13476# D5/iovdd_uq0 D5/iovdd_uq0 sg13_hv_pmos ad=3.9294p pd=7.84u as=2.1312p ps=7.3u w=6.66u l=0.6u
X35 _n6 D5/a_5044_1676# vss vss sg13_hv_nmos ad=2.596p pd=5.58u as=1.408p ps=5.04u w=4.4u l=0.6u
X36 vss D5/a_5044_1676# _n6 vss sg13_hv_nmos ad=1.408p pd=5.04u as=2.596p ps=5.58u w=4.4u l=0.6u
X37 _n6 D5/a_5044_1676# vss vss sg13_hv_nmos ad=2.596p pd=5.58u as=1.408p ps=5.04u w=4.4u l=0.6u
X38 D5/iovdd_uq0 D5/a_5044_13476# _n6 D5/iovdd_uq0 sg13_hv_pmos ad=2.1312p pd=7.3u as=3.9294p ps=7.84u w=6.66u l=0.6u
X39 _n6 D5/a_5044_13476# D5/iovdd_uq0 D5/iovdd_uq0 sg13_hv_pmos ad=3.9294p pd=7.84u as=2.1312p ps=7.3u w=6.66u l=0.6u
X40 _n6 D5/iovdd_uq0 D5/dpantenna D5/l=1.26u w=27.78u
X41 vss D5/a_5044_1676# _n6 vss sg13_hv_nmos ad=1.408p pd=5.04u as=2.596p ps=5.58u w=4.4u l=0.6u
X42 D5/iovdd_uq0 D5/a_5044_13476# _n6 D5/iovdd_uq0 sg13_hv_pmos ad=2.1312p pd=7.3u as=3.9294p ps=7.84u w=6.66u l=0.6u
X43 vss D5/a_5044_1676# _n6 vss sg13_hv_nmos ad=1.408p pd=5.04u as=2.596p ps=5.58u w=4.4u l=0.6u
X44 _n6 D5/a_5044_13476# D5/iovdd_uq0 D5/iovdd_uq0 sg13_hv_pmos ad=3.9294p pd=7.84u as=2.1312p ps=7.3u w=6.66u l=0.6u
X45 D5/iovdd_uq0 D5/a_5044_13476# _n6 D5/iovdd_uq0 sg13_hv_pmos ad=2.1312p pd=7.3u as=3.9294p ps=7.84u w=6.66u l=0.6u
X46 _n6 D5/a_5044_13476# D5/iovdd_uq0 D5/iovdd_uq0 sg13_hv_pmos ad=3.9294p pd=7.84u as=2.1312p ps=7.3u w=6.66u l=0.6u
X47 _n6 D5/a_5044_1676# vss vss sg13_hv_nmos ad=2.596p pd=5.58u as=1.408p ps=5.04u w=4.4u l=0.6u
X48 vss D5/a_5044_1676# _n6 vss sg13_hv_nmos ad=1.408p pd=5.04u as=2.596p ps=5.58u w=4.4u l=0.6u
X49 _n6 D5/a_5044_13476# D5/iovdd_uq0 D5/iovdd_uq0 sg13_hv_pmos ad=3.9294p pd=7.84u as=3.1302p ps=14.26u w=6.66u l=0.6u
X50 D5/iovdd_uq0 D5/a_5044_13476# _n6 D5/iovdd_uq0 sg13_hv_pmos ad=3.1302p pd=14.26u as=3.9294p ps=7.84u w=6.66u l=0.6u
X51 D5/iovdd_uq0 D5/a_5044_13476# _n6 D5/iovdd_uq0 sg13_hv_pmos ad=2.1312p pd=7.3u as=3.9294p ps=7.84u w=6.66u l=0.6u
X52 _n6 D5/a_5044_13476# D5/iovdd_uq0 D5/iovdd_uq0 sg13_hv_pmos ad=3.9294p pd=7.84u as=2.1312p ps=7.3u w=6.66u l=0.6u
X53 _n6 D5/iovdd_uq0 D5/dpantenna D5/l=1.26u w=27.78u
X54 _n6 D5/a_5044_13476# D5/iovdd_uq0 D5/iovdd_uq0 sg13_hv_pmos ad=3.9294p pd=7.84u as=3.1302p ps=14.26u w=6.66u l=0.6u
X55 D5/iovdd_uq0 D5/a_5044_13476# _n6 D5/iovdd_uq0 sg13_hv_pmos ad=3.1302p pd=14.26u as=3.9294p ps=7.84u w=6.66u l=0.6u
X56 D5/iovdd_uq0 D5/a_5044_13476# _n6 D5/iovdd_uq0 sg13_hv_pmos ad=2.1312p pd=7.3u as=3.9294p ps=7.84u w=6.66u l=0.6u
X57 _n6 D5/a_5044_13476# D5/iovdd_uq0 D5/iovdd_uq0 sg13_hv_pmos ad=3.9294p pd=7.84u as=2.1312p ps=7.3u w=6.66u l=0.6u
X58 vss D5/a_11462_28198# D5/dantenna D5/l=3.1u w=0.64u
X59 vss D5/a_5222_3962# D5/dantenna D5/l=1.26u w=27.78u
X60 D5/a_5044_1676# vss vss D5/rppd l=3.54u w=0.5u
X61 D5/iovdd_uq0 D5/a_5044_13476# _n6 D5/iovdd_uq0 sg13_hv_pmos ad=2.1312p pd=7.3u as=3.9294p ps=7.84u w=6.66u l=0.6u
X62 D5/iovdd_uq0 D5/a_5044_13476# _n6 D5/iovdd_uq0 sg13_hv_pmos ad=2.1312p pd=7.3u as=3.9294p ps=7.84u w=6.66u l=0.6u
X63 _n6 D5/a_5044_1676# vss vss sg13_hv_nmos ad=2.596p pd=5.58u as=2.068p ps=9.74u w=4.4u l=0.6u
X64 D5/iovdd_uq0 D5/a_5044_13476# _n6 D5/iovdd_uq0 sg13_hv_pmos ad=2.1312p pd=7.3u as=3.9294p ps=7.84u w=6.66u l=0.6u
X65 _n6 D5/a_5044_13476# D5/iovdd_uq0 D5/iovdd_uq0 sg13_hv_pmos ad=3.9294p pd=7.84u as=2.1312p ps=7.3u w=6.66u l=0.6u
X66 _n6 D5/a_5044_13476# D5/iovdd_uq0 D5/iovdd_uq0 sg13_hv_pmos ad=3.9294p pd=7.84u as=2.1312p ps=7.3u w=6.66u l=0.6u
X67 _n6 D5/a_5044_13476# D5/iovdd_uq0 D5/iovdd_uq0 sg13_hv_pmos ad=3.9294p pd=7.84u as=2.1312p ps=7.3u w=6.66u l=0.6u
X68 vss D5/a_5044_1676# _n6 vss sg13_hv_nmos ad=1.408p pd=5.04u as=2.596p ps=5.58u w=4.4u l=0.6u
X0 D6/iovdd_uq0 D6/a_5044_13476# _n7 D6/iovdd_uq0 sg13_hv_pmos ad=2.1312p pd=7.3u as=3.9294p ps=7.84u w=6.66u l=0.6u
X1 _n7 D6/a_5044_1676# vss vss sg13_hv_nmos ad=2.596p pd=5.58u as=1.408p ps=5.04u w=4.4u l=0.6u
X2 _n7 D6/a_5044_13476# D6/iovdd_uq0 D6/iovdd_uq0 sg13_hv_pmos ad=3.9294p pd=7.84u as=2.1312p ps=7.3u w=6.66u l=0.6u
X3 D6/iovdd_uq0 D6/a_5044_13476# _n7 D6/iovdd_uq0 sg13_hv_pmos ad=2.1312p pd=7.3u as=3.9294p ps=7.84u w=6.66u l=0.6u
X4 D6/iovdd_uq0 D6/a_5044_13476# _n7 D6/iovdd_uq0 sg13_hv_pmos ad=2.1312p pd=7.3u as=3.9294p ps=7.84u w=6.66u l=0.6u
X5 _n7 D6/a_5044_1676# vss vss sg13_hv_nmos ad=2.596p pd=5.58u as=1.408p ps=5.04u w=4.4u l=0.6u
X6 _n7 D6/a_5044_13476# D6/iovdd_uq0 D6/iovdd_uq0 sg13_hv_pmos ad=3.9294p pd=7.84u as=2.1312p ps=7.3u w=6.66u l=0.6u
X7 D6/iovdd_uq0 D6/a_5044_13476# _n7 D6/iovdd_uq0 sg13_hv_pmos ad=2.1312p pd=7.3u as=3.9294p ps=7.84u w=6.66u l=0.6u
X8 _n7 D6/a_5044_1676# vss vss sg13_hv_nmos ad=2.596p pd=5.58u as=1.408p ps=5.04u w=4.4u l=0.6u
X9 vss D6/a_5044_1676# _n7 vss sg13_hv_nmos ad=2.068p pd=9.74u as=2.596p ps=5.58u w=4.4u l=0.6u
X10 _n7 D6/a_5044_13476# D6/iovdd_uq0 D6/iovdd_uq0 sg13_hv_pmos ad=3.9294p pd=7.84u as=2.1312p ps=7.3u w=6.66u l=0.6u
X11 D6/a_5044_13476# D6/iovdd_uq0 D6/iovdd_uq0 D6/rppd l=12.9u w=0.5u
X12 vss D6/a_5044_1676# _n7 vss sg13_hv_nmos ad=1.408p pd=5.04u as=2.596p ps=5.58u w=4.4u l=0.6u
X13 _n7 D6/a_5044_13476# D6/iovdd_uq0 D6/iovdd_uq0 sg13_hv_pmos ad=3.9294p pd=7.84u as=2.1312p ps=7.3u w=6.66u l=0.6u
X14 vss D6/a_5222_4862# D6/dantenna D6/l=1.26u w=27.78u
X15 vss D6/a_5044_1676# _n7 vss sg13_hv_nmos ad=1.408p pd=5.04u as=2.596p ps=5.58u w=4.4u l=0.6u
X16 _n7 D6/a_5044_1676# vss vss sg13_hv_nmos ad=2.596p pd=5.58u as=1.408p ps=5.04u w=4.4u l=0.6u
X17 vss D6/a_5044_1676# _n7 vss sg13_hv_nmos ad=1.408p pd=5.04u as=2.596p ps=5.58u w=4.4u l=0.6u
X18 D6/iovdd_uq0 D6/a_5044_13476# _n7 D6/iovdd_uq0 sg13_hv_pmos ad=2.1312p pd=7.3u as=3.9294p ps=7.84u w=6.66u l=0.6u
X19 _n7 D6/a_5044_1676# vss vss sg13_hv_nmos ad=2.596p pd=5.58u as=1.408p ps=5.04u w=4.4u l=0.6u
X20 _n7 D6/a_5044_13476# D6/iovdd_uq0 D6/iovdd_uq0 sg13_hv_pmos ad=3.9294p pd=7.84u as=2.1312p ps=7.3u w=6.66u l=0.6u
X21 D6/iovdd_uq0 D6/a_5044_13476# _n7 D6/iovdd_uq0 sg13_hv_pmos ad=2.1312p pd=7.3u as=3.9294p ps=7.84u w=6.66u l=0.6u
X22 _n7 D6/a_5044_13476# D6/iovdd_uq0 D6/iovdd_uq0 sg13_hv_pmos ad=3.9294p pd=7.84u as=2.1312p ps=7.3u w=6.66u l=0.6u
X23 _n7 D6/a_5044_13476# D6/iovdd_uq0 D6/iovdd_uq0 sg13_hv_pmos ad=3.9294p pd=7.84u as=2.1312p ps=7.3u w=6.66u l=0.6u
X24 vss D6/a_5044_1676# _n7 vss sg13_hv_nmos ad=1.408p pd=5.04u as=2.596p ps=5.58u w=4.4u l=0.6u
X25 _n7c D6/iovdd D6/dpantenna D6/l=0.64u w=4.98u
X26 D6/iovdd_uq0 D6/a_5044_13476# _n7 D6/iovdd_uq0 sg13_hv_pmos ad=2.1312p pd=7.3u as=3.9294p ps=7.84u w=6.66u l=0.6u
X27 _n7 D6/a_5044_13476# D6/iovdd_uq0 D6/iovdd_uq0 sg13_hv_pmos ad=3.9294p pd=7.84u as=2.1312p ps=7.3u w=6.66u l=0.6u
X28 _n7 D6/a_5044_13476# D6/iovdd_uq0 D6/iovdd_uq0 sg13_hv_pmos ad=3.9294p pd=7.84u as=2.1312p ps=7.3u w=6.66u l=0.6u
X29 _n7 D6/a_5044_1676# vss vss sg13_hv_nmos ad=2.596p pd=5.58u as=1.408p ps=5.04u w=4.4u l=0.6u
X30 D6/iovdd_uq0 D6/a_5044_13476# _n7 D6/iovdd_uq0 sg13_hv_pmos ad=2.1312p pd=7.3u as=3.9294p ps=7.84u w=6.66u l=0.6u
X31 _n7c _n7 vss D6/rppd l=2u w=1u
X32 D6/iovdd_uq0 D6/a_5044_13476# _n7 D6/iovdd_uq0 sg13_hv_pmos ad=2.1312p pd=7.3u as=3.9294p ps=7.84u w=6.66u l=0.6u
X33 D6/iovdd_uq0 D6/a_5044_13476# _n7 D6/iovdd_uq0 sg13_hv_pmos ad=2.1312p pd=7.3u as=3.9294p ps=7.84u w=6.66u l=0.6u
X34 _n7 D6/a_5044_13476# D6/iovdd_uq0 D6/iovdd_uq0 sg13_hv_pmos ad=3.9294p pd=7.84u as=2.1312p ps=7.3u w=6.66u l=0.6u
X35 _n7 D6/a_5044_1676# vss vss sg13_hv_nmos ad=2.596p pd=5.58u as=1.408p ps=5.04u w=4.4u l=0.6u
X36 vss D6/a_5044_1676# _n7 vss sg13_hv_nmos ad=1.408p pd=5.04u as=2.596p ps=5.58u w=4.4u l=0.6u
X37 _n7 D6/a_5044_1676# vss vss sg13_hv_nmos ad=2.596p pd=5.58u as=1.408p ps=5.04u w=4.4u l=0.6u
X38 D6/iovdd_uq0 D6/a_5044_13476# _n7 D6/iovdd_uq0 sg13_hv_pmos ad=2.1312p pd=7.3u as=3.9294p ps=7.84u w=6.66u l=0.6u
X39 _n7 D6/a_5044_13476# D6/iovdd_uq0 D6/iovdd_uq0 sg13_hv_pmos ad=3.9294p pd=7.84u as=2.1312p ps=7.3u w=6.66u l=0.6u
X40 _n7 D6/iovdd_uq0 D6/dpantenna D6/l=1.26u w=27.78u
X41 vss D6/a_5044_1676# _n7 vss sg13_hv_nmos ad=1.408p pd=5.04u as=2.596p ps=5.58u w=4.4u l=0.6u
X42 D6/iovdd_uq0 D6/a_5044_13476# _n7 D6/iovdd_uq0 sg13_hv_pmos ad=2.1312p pd=7.3u as=3.9294p ps=7.84u w=6.66u l=0.6u
X43 vss D6/a_5044_1676# _n7 vss sg13_hv_nmos ad=1.408p pd=5.04u as=2.596p ps=5.58u w=4.4u l=0.6u
X44 _n7 D6/a_5044_13476# D6/iovdd_uq0 D6/iovdd_uq0 sg13_hv_pmos ad=3.9294p pd=7.84u as=2.1312p ps=7.3u w=6.66u l=0.6u
X45 D6/iovdd_uq0 D6/a_5044_13476# _n7 D6/iovdd_uq0 sg13_hv_pmos ad=2.1312p pd=7.3u as=3.9294p ps=7.84u w=6.66u l=0.6u
X46 _n7 D6/a_5044_13476# D6/iovdd_uq0 D6/iovdd_uq0 sg13_hv_pmos ad=3.9294p pd=7.84u as=2.1312p ps=7.3u w=6.66u l=0.6u
X47 _n7 D6/a_5044_1676# vss vss sg13_hv_nmos ad=2.596p pd=5.58u as=1.408p ps=5.04u w=4.4u l=0.6u
X48 vss D6/a_5044_1676# _n7 vss sg13_hv_nmos ad=1.408p pd=5.04u as=2.596p ps=5.58u w=4.4u l=0.6u
X49 _n7 D6/a_5044_13476# D6/iovdd_uq0 D6/iovdd_uq0 sg13_hv_pmos ad=3.9294p pd=7.84u as=3.1302p ps=14.26u w=6.66u l=0.6u
X50 D6/iovdd_uq0 D6/a_5044_13476# _n7 D6/iovdd_uq0 sg13_hv_pmos ad=3.1302p pd=14.26u as=3.9294p ps=7.84u w=6.66u l=0.6u
X51 D6/iovdd_uq0 D6/a_5044_13476# _n7 D6/iovdd_uq0 sg13_hv_pmos ad=2.1312p pd=7.3u as=3.9294p ps=7.84u w=6.66u l=0.6u
X52 _n7 D6/a_5044_13476# D6/iovdd_uq0 D6/iovdd_uq0 sg13_hv_pmos ad=3.9294p pd=7.84u as=2.1312p ps=7.3u w=6.66u l=0.6u
X53 _n7 D6/iovdd_uq0 D6/dpantenna D6/l=1.26u w=27.78u
X54 _n7 D6/a_5044_13476# D6/iovdd_uq0 D6/iovdd_uq0 sg13_hv_pmos ad=3.9294p pd=7.84u as=3.1302p ps=14.26u w=6.66u l=0.6u
X55 D6/iovdd_uq0 D6/a_5044_13476# _n7 D6/iovdd_uq0 sg13_hv_pmos ad=3.1302p pd=14.26u as=3.9294p ps=7.84u w=6.66u l=0.6u
X56 D6/iovdd_uq0 D6/a_5044_13476# _n7 D6/iovdd_uq0 sg13_hv_pmos ad=2.1312p pd=7.3u as=3.9294p ps=7.84u w=6.66u l=0.6u
X57 _n7 D6/a_5044_13476# D6/iovdd_uq0 D6/iovdd_uq0 sg13_hv_pmos ad=3.9294p pd=7.84u as=2.1312p ps=7.3u w=6.66u l=0.6u
X58 vss D6/a_11462_28198# D6/dantenna D6/l=3.1u w=0.64u
X59 vss D6/a_5222_3962# D6/dantenna D6/l=1.26u w=27.78u
X60 D6/a_5044_1676# vss vss D6/rppd l=3.54u w=0.5u
X61 D6/iovdd_uq0 D6/a_5044_13476# _n7 D6/iovdd_uq0 sg13_hv_pmos ad=2.1312p pd=7.3u as=3.9294p ps=7.84u w=6.66u l=0.6u
X62 D6/iovdd_uq0 D6/a_5044_13476# _n7 D6/iovdd_uq0 sg13_hv_pmos ad=2.1312p pd=7.3u as=3.9294p ps=7.84u w=6.66u l=0.6u
X63 _n7 D6/a_5044_1676# vss vss sg13_hv_nmos ad=2.596p pd=5.58u as=2.068p ps=9.74u w=4.4u l=0.6u
X64 D6/iovdd_uq0 D6/a_5044_13476# _n7 D6/iovdd_uq0 sg13_hv_pmos ad=2.1312p pd=7.3u as=3.9294p ps=7.84u w=6.66u l=0.6u
X65 _n7 D6/a_5044_13476# D6/iovdd_uq0 D6/iovdd_uq0 sg13_hv_pmos ad=3.9294p pd=7.84u as=2.1312p ps=7.3u w=6.66u l=0.6u
X66 _n7 D6/a_5044_13476# D6/iovdd_uq0 D6/iovdd_uq0 sg13_hv_pmos ad=3.9294p pd=7.84u as=2.1312p ps=7.3u w=6.66u l=0.6u
X67 _n7 D6/a_5044_13476# D6/iovdd_uq0 D6/iovdd_uq0 sg13_hv_pmos ad=3.9294p pd=7.84u as=2.1312p ps=7.3u w=6.66u l=0.6u
X68 vss D6/a_5044_1676# _n7 vss sg13_hv_nmos ad=1.408p pd=5.04u as=2.596p ps=5.58u w=4.4u l=0.6u
X0 D7/iovdd_uq0 D7/a_5044_13476# _n8 D7/iovdd_uq0 sg13_hv_pmos ad=2.1312p pd=7.3u as=3.9294p ps=7.84u w=6.66u l=0.6u
X1 _n8 D7/a_5044_1676# vss vss sg13_hv_nmos ad=2.596p pd=5.58u as=1.408p ps=5.04u w=4.4u l=0.6u
X2 _n8 D7/a_5044_13476# D7/iovdd_uq0 D7/iovdd_uq0 sg13_hv_pmos ad=3.9294p pd=7.84u as=2.1312p ps=7.3u w=6.66u l=0.6u
X3 D7/iovdd_uq0 D7/a_5044_13476# _n8 D7/iovdd_uq0 sg13_hv_pmos ad=2.1312p pd=7.3u as=3.9294p ps=7.84u w=6.66u l=0.6u
X4 D7/iovdd_uq0 D7/a_5044_13476# _n8 D7/iovdd_uq0 sg13_hv_pmos ad=2.1312p pd=7.3u as=3.9294p ps=7.84u w=6.66u l=0.6u
X5 _n8 D7/a_5044_1676# vss vss sg13_hv_nmos ad=2.596p pd=5.58u as=1.408p ps=5.04u w=4.4u l=0.6u
X6 _n8 D7/a_5044_13476# D7/iovdd_uq0 D7/iovdd_uq0 sg13_hv_pmos ad=3.9294p pd=7.84u as=2.1312p ps=7.3u w=6.66u l=0.6u
X7 D7/iovdd_uq0 D7/a_5044_13476# _n8 D7/iovdd_uq0 sg13_hv_pmos ad=2.1312p pd=7.3u as=3.9294p ps=7.84u w=6.66u l=0.6u
X8 _n8 D7/a_5044_1676# vss vss sg13_hv_nmos ad=2.596p pd=5.58u as=1.408p ps=5.04u w=4.4u l=0.6u
X9 vss D7/a_5044_1676# _n8 vss sg13_hv_nmos ad=2.068p pd=9.74u as=2.596p ps=5.58u w=4.4u l=0.6u
X10 _n8 D7/a_5044_13476# D7/iovdd_uq0 D7/iovdd_uq0 sg13_hv_pmos ad=3.9294p pd=7.84u as=2.1312p ps=7.3u w=6.66u l=0.6u
X11 D7/a_5044_13476# D7/iovdd_uq0 D7/iovdd_uq0 D7/rppd l=12.9u w=0.5u
X12 vss D7/a_5044_1676# _n8 vss sg13_hv_nmos ad=1.408p pd=5.04u as=2.596p ps=5.58u w=4.4u l=0.6u
X13 _n8 D7/a_5044_13476# D7/iovdd_uq0 D7/iovdd_uq0 sg13_hv_pmos ad=3.9294p pd=7.84u as=2.1312p ps=7.3u w=6.66u l=0.6u
X14 vss D7/a_5222_4862# D7/dantenna D7/l=1.26u w=27.78u
X15 vss D7/a_5044_1676# _n8 vss sg13_hv_nmos ad=1.408p pd=5.04u as=2.596p ps=5.58u w=4.4u l=0.6u
X16 _n8 D7/a_5044_1676# vss vss sg13_hv_nmos ad=2.596p pd=5.58u as=1.408p ps=5.04u w=4.4u l=0.6u
X17 vss D7/a_5044_1676# _n8 vss sg13_hv_nmos ad=1.408p pd=5.04u as=2.596p ps=5.58u w=4.4u l=0.6u
X18 D7/iovdd_uq0 D7/a_5044_13476# _n8 D7/iovdd_uq0 sg13_hv_pmos ad=2.1312p pd=7.3u as=3.9294p ps=7.84u w=6.66u l=0.6u
X19 _n8 D7/a_5044_1676# vss vss sg13_hv_nmos ad=2.596p pd=5.58u as=1.408p ps=5.04u w=4.4u l=0.6u
X20 _n8 D7/a_5044_13476# D7/iovdd_uq0 D7/iovdd_uq0 sg13_hv_pmos ad=3.9294p pd=7.84u as=2.1312p ps=7.3u w=6.66u l=0.6u
X21 D7/iovdd_uq0 D7/a_5044_13476# _n8 D7/iovdd_uq0 sg13_hv_pmos ad=2.1312p pd=7.3u as=3.9294p ps=7.84u w=6.66u l=0.6u
X22 _n8 D7/a_5044_13476# D7/iovdd_uq0 D7/iovdd_uq0 sg13_hv_pmos ad=3.9294p pd=7.84u as=2.1312p ps=7.3u w=6.66u l=0.6u
X23 _n8 D7/a_5044_13476# D7/iovdd_uq0 D7/iovdd_uq0 sg13_hv_pmos ad=3.9294p pd=7.84u as=2.1312p ps=7.3u w=6.66u l=0.6u
X24 vss D7/a_5044_1676# _n8 vss sg13_hv_nmos ad=1.408p pd=5.04u as=2.596p ps=5.58u w=4.4u l=0.6u
X25 _n8c D7/iovdd D7/dpantenna D7/l=0.64u w=4.98u
X26 D7/iovdd_uq0 D7/a_5044_13476# _n8 D7/iovdd_uq0 sg13_hv_pmos ad=2.1312p pd=7.3u as=3.9294p ps=7.84u w=6.66u l=0.6u
X27 _n8 D7/a_5044_13476# D7/iovdd_uq0 D7/iovdd_uq0 sg13_hv_pmos ad=3.9294p pd=7.84u as=2.1312p ps=7.3u w=6.66u l=0.6u
X28 _n8 D7/a_5044_13476# D7/iovdd_uq0 D7/iovdd_uq0 sg13_hv_pmos ad=3.9294p pd=7.84u as=2.1312p ps=7.3u w=6.66u l=0.6u
X29 _n8 D7/a_5044_1676# vss vss sg13_hv_nmos ad=2.596p pd=5.58u as=1.408p ps=5.04u w=4.4u l=0.6u
X30 D7/iovdd_uq0 D7/a_5044_13476# _n8 D7/iovdd_uq0 sg13_hv_pmos ad=2.1312p pd=7.3u as=3.9294p ps=7.84u w=6.66u l=0.6u
X31 _n8c _n8 vss D7/rppd l=2u w=1u
X32 D7/iovdd_uq0 D7/a_5044_13476# _n8 D7/iovdd_uq0 sg13_hv_pmos ad=2.1312p pd=7.3u as=3.9294p ps=7.84u w=6.66u l=0.6u
X33 D7/iovdd_uq0 D7/a_5044_13476# _n8 D7/iovdd_uq0 sg13_hv_pmos ad=2.1312p pd=7.3u as=3.9294p ps=7.84u w=6.66u l=0.6u
X34 _n8 D7/a_5044_13476# D7/iovdd_uq0 D7/iovdd_uq0 sg13_hv_pmos ad=3.9294p pd=7.84u as=2.1312p ps=7.3u w=6.66u l=0.6u
X35 _n8 D7/a_5044_1676# vss vss sg13_hv_nmos ad=2.596p pd=5.58u as=1.408p ps=5.04u w=4.4u l=0.6u
X36 vss D7/a_5044_1676# _n8 vss sg13_hv_nmos ad=1.408p pd=5.04u as=2.596p ps=5.58u w=4.4u l=0.6u
X37 _n8 D7/a_5044_1676# vss vss sg13_hv_nmos ad=2.596p pd=5.58u as=1.408p ps=5.04u w=4.4u l=0.6u
X38 D7/iovdd_uq0 D7/a_5044_13476# _n8 D7/iovdd_uq0 sg13_hv_pmos ad=2.1312p pd=7.3u as=3.9294p ps=7.84u w=6.66u l=0.6u
X39 _n8 D7/a_5044_13476# D7/iovdd_uq0 D7/iovdd_uq0 sg13_hv_pmos ad=3.9294p pd=7.84u as=2.1312p ps=7.3u w=6.66u l=0.6u
X40 _n8 D7/iovdd_uq0 D7/dpantenna D7/l=1.26u w=27.78u
X41 vss D7/a_5044_1676# _n8 vss sg13_hv_nmos ad=1.408p pd=5.04u as=2.596p ps=5.58u w=4.4u l=0.6u
X42 D7/iovdd_uq0 D7/a_5044_13476# _n8 D7/iovdd_uq0 sg13_hv_pmos ad=2.1312p pd=7.3u as=3.9294p ps=7.84u w=6.66u l=0.6u
X43 vss D7/a_5044_1676# _n8 vss sg13_hv_nmos ad=1.408p pd=5.04u as=2.596p ps=5.58u w=4.4u l=0.6u
X44 _n8 D7/a_5044_13476# D7/iovdd_uq0 D7/iovdd_uq0 sg13_hv_pmos ad=3.9294p pd=7.84u as=2.1312p ps=7.3u w=6.66u l=0.6u
X45 D7/iovdd_uq0 D7/a_5044_13476# _n8 D7/iovdd_uq0 sg13_hv_pmos ad=2.1312p pd=7.3u as=3.9294p ps=7.84u w=6.66u l=0.6u
X46 _n8 D7/a_5044_13476# D7/iovdd_uq0 D7/iovdd_uq0 sg13_hv_pmos ad=3.9294p pd=7.84u as=2.1312p ps=7.3u w=6.66u l=0.6u
X47 _n8 D7/a_5044_1676# vss vss sg13_hv_nmos ad=2.596p pd=5.58u as=1.408p ps=5.04u w=4.4u l=0.6u
X48 vss D7/a_5044_1676# _n8 vss sg13_hv_nmos ad=1.408p pd=5.04u as=2.596p ps=5.58u w=4.4u l=0.6u
X49 _n8 D7/a_5044_13476# D7/iovdd_uq0 D7/iovdd_uq0 sg13_hv_pmos ad=3.9294p pd=7.84u as=3.1302p ps=14.26u w=6.66u l=0.6u
X50 D7/iovdd_uq0 D7/a_5044_13476# _n8 D7/iovdd_uq0 sg13_hv_pmos ad=3.1302p pd=14.26u as=3.9294p ps=7.84u w=6.66u l=0.6u
X51 D7/iovdd_uq0 D7/a_5044_13476# _n8 D7/iovdd_uq0 sg13_hv_pmos ad=2.1312p pd=7.3u as=3.9294p ps=7.84u w=6.66u l=0.6u
X52 _n8 D7/a_5044_13476# D7/iovdd_uq0 D7/iovdd_uq0 sg13_hv_pmos ad=3.9294p pd=7.84u as=2.1312p ps=7.3u w=6.66u l=0.6u
X53 _n8 D7/iovdd_uq0 D7/dpantenna D7/l=1.26u w=27.78u
X54 _n8 D7/a_5044_13476# D7/iovdd_uq0 D7/iovdd_uq0 sg13_hv_pmos ad=3.9294p pd=7.84u as=3.1302p ps=14.26u w=6.66u l=0.6u
X55 D7/iovdd_uq0 D7/a_5044_13476# _n8 D7/iovdd_uq0 sg13_hv_pmos ad=3.1302p pd=14.26u as=3.9294p ps=7.84u w=6.66u l=0.6u
X56 D7/iovdd_uq0 D7/a_5044_13476# _n8 D7/iovdd_uq0 sg13_hv_pmos ad=2.1312p pd=7.3u as=3.9294p ps=7.84u w=6.66u l=0.6u
X57 _n8 D7/a_5044_13476# D7/iovdd_uq0 D7/iovdd_uq0 sg13_hv_pmos ad=3.9294p pd=7.84u as=2.1312p ps=7.3u w=6.66u l=0.6u
X58 vss D7/a_11462_28198# D7/dantenna D7/l=3.1u w=0.64u
X59 vss D7/a_5222_3962# D7/dantenna D7/l=1.26u w=27.78u
X60 D7/a_5044_1676# vss vss D7/rppd l=3.54u w=0.5u
X61 D7/iovdd_uq0 D7/a_5044_13476# _n8 D7/iovdd_uq0 sg13_hv_pmos ad=2.1312p pd=7.3u as=3.9294p ps=7.84u w=6.66u l=0.6u
X62 D7/iovdd_uq0 D7/a_5044_13476# _n8 D7/iovdd_uq0 sg13_hv_pmos ad=2.1312p pd=7.3u as=3.9294p ps=7.84u w=6.66u l=0.6u
X63 _n8 D7/a_5044_1676# vss vss sg13_hv_nmos ad=2.596p pd=5.58u as=2.068p ps=9.74u w=4.4u l=0.6u
X64 D7/iovdd_uq0 D7/a_5044_13476# _n8 D7/iovdd_uq0 sg13_hv_pmos ad=2.1312p pd=7.3u as=3.9294p ps=7.84u w=6.66u l=0.6u
X65 _n8 D7/a_5044_13476# D7/iovdd_uq0 D7/iovdd_uq0 sg13_hv_pmos ad=3.9294p pd=7.84u as=2.1312p ps=7.3u w=6.66u l=0.6u
X66 _n8 D7/a_5044_13476# D7/iovdd_uq0 D7/iovdd_uq0 sg13_hv_pmos ad=3.9294p pd=7.84u as=2.1312p ps=7.3u w=6.66u l=0.6u
X67 _n8 D7/a_5044_13476# D7/iovdd_uq0 D7/iovdd_uq0 sg13_hv_pmos ad=3.9294p pd=7.84u as=2.1312p ps=7.3u w=6.66u l=0.6u
X68 vss D7/a_5044_1676# _n8 vss sg13_hv_nmos ad=1.408p pd=5.04u as=2.596p ps=5.58u w=4.4u l=0.6u
X0 D8/iovdd_uq0 D8/a_5044_13476# _n9 D8/iovdd_uq0 sg13_hv_pmos ad=2.1312p pd=7.3u as=3.9294p ps=7.84u w=6.66u l=0.6u
X1 _n9 D8/a_5044_1676# vss vss sg13_hv_nmos ad=2.596p pd=5.58u as=1.408p ps=5.04u w=4.4u l=0.6u
X2 _n9 D8/a_5044_13476# D8/iovdd_uq0 D8/iovdd_uq0 sg13_hv_pmos ad=3.9294p pd=7.84u as=2.1312p ps=7.3u w=6.66u l=0.6u
X3 D8/iovdd_uq0 D8/a_5044_13476# _n9 D8/iovdd_uq0 sg13_hv_pmos ad=2.1312p pd=7.3u as=3.9294p ps=7.84u w=6.66u l=0.6u
X4 D8/iovdd_uq0 D8/a_5044_13476# _n9 D8/iovdd_uq0 sg13_hv_pmos ad=2.1312p pd=7.3u as=3.9294p ps=7.84u w=6.66u l=0.6u
X5 _n9 D8/a_5044_1676# vss vss sg13_hv_nmos ad=2.596p pd=5.58u as=1.408p ps=5.04u w=4.4u l=0.6u
X6 _n9 D8/a_5044_13476# D8/iovdd_uq0 D8/iovdd_uq0 sg13_hv_pmos ad=3.9294p pd=7.84u as=2.1312p ps=7.3u w=6.66u l=0.6u
X7 D8/iovdd_uq0 D8/a_5044_13476# _n9 D8/iovdd_uq0 sg13_hv_pmos ad=2.1312p pd=7.3u as=3.9294p ps=7.84u w=6.66u l=0.6u
X8 _n9 D8/a_5044_1676# vss vss sg13_hv_nmos ad=2.596p pd=5.58u as=1.408p ps=5.04u w=4.4u l=0.6u
X9 vss D8/a_5044_1676# _n9 vss sg13_hv_nmos ad=2.068p pd=9.74u as=2.596p ps=5.58u w=4.4u l=0.6u
X10 _n9 D8/a_5044_13476# D8/iovdd_uq0 D8/iovdd_uq0 sg13_hv_pmos ad=3.9294p pd=7.84u as=2.1312p ps=7.3u w=6.66u l=0.6u
X11 D8/a_5044_13476# D8/iovdd_uq0 D8/iovdd_uq0 D8/rppd l=12.9u w=0.5u
X12 vss D8/a_5044_1676# _n9 vss sg13_hv_nmos ad=1.408p pd=5.04u as=2.596p ps=5.58u w=4.4u l=0.6u
X13 _n9 D8/a_5044_13476# D8/iovdd_uq0 D8/iovdd_uq0 sg13_hv_pmos ad=3.9294p pd=7.84u as=2.1312p ps=7.3u w=6.66u l=0.6u
X14 vss D8/a_5222_4862# D8/dantenna D8/l=1.26u w=27.78u
X15 vss D8/a_5044_1676# _n9 vss sg13_hv_nmos ad=1.408p pd=5.04u as=2.596p ps=5.58u w=4.4u l=0.6u
X16 _n9 D8/a_5044_1676# vss vss sg13_hv_nmos ad=2.596p pd=5.58u as=1.408p ps=5.04u w=4.4u l=0.6u
X17 vss D8/a_5044_1676# _n9 vss sg13_hv_nmos ad=1.408p pd=5.04u as=2.596p ps=5.58u w=4.4u l=0.6u
X18 D8/iovdd_uq0 D8/a_5044_13476# _n9 D8/iovdd_uq0 sg13_hv_pmos ad=2.1312p pd=7.3u as=3.9294p ps=7.84u w=6.66u l=0.6u
X19 _n9 D8/a_5044_1676# vss vss sg13_hv_nmos ad=2.596p pd=5.58u as=1.408p ps=5.04u w=4.4u l=0.6u
X20 _n9 D8/a_5044_13476# D8/iovdd_uq0 D8/iovdd_uq0 sg13_hv_pmos ad=3.9294p pd=7.84u as=2.1312p ps=7.3u w=6.66u l=0.6u
X21 D8/iovdd_uq0 D8/a_5044_13476# _n9 D8/iovdd_uq0 sg13_hv_pmos ad=2.1312p pd=7.3u as=3.9294p ps=7.84u w=6.66u l=0.6u
X22 _n9 D8/a_5044_13476# D8/iovdd_uq0 D8/iovdd_uq0 sg13_hv_pmos ad=3.9294p pd=7.84u as=2.1312p ps=7.3u w=6.66u l=0.6u
X23 _n9 D8/a_5044_13476# D8/iovdd_uq0 D8/iovdd_uq0 sg13_hv_pmos ad=3.9294p pd=7.84u as=2.1312p ps=7.3u w=6.66u l=0.6u
X24 vss D8/a_5044_1676# _n9 vss sg13_hv_nmos ad=1.408p pd=5.04u as=2.596p ps=5.58u w=4.4u l=0.6u
X25 _n9c D8/iovdd D8/dpantenna D8/l=0.64u w=4.98u
X26 D8/iovdd_uq0 D8/a_5044_13476# _n9 D8/iovdd_uq0 sg13_hv_pmos ad=2.1312p pd=7.3u as=3.9294p ps=7.84u w=6.66u l=0.6u
X27 _n9 D8/a_5044_13476# D8/iovdd_uq0 D8/iovdd_uq0 sg13_hv_pmos ad=3.9294p pd=7.84u as=2.1312p ps=7.3u w=6.66u l=0.6u
X28 _n9 D8/a_5044_13476# D8/iovdd_uq0 D8/iovdd_uq0 sg13_hv_pmos ad=3.9294p pd=7.84u as=2.1312p ps=7.3u w=6.66u l=0.6u
X29 _n9 D8/a_5044_1676# vss vss sg13_hv_nmos ad=2.596p pd=5.58u as=1.408p ps=5.04u w=4.4u l=0.6u
X30 D8/iovdd_uq0 D8/a_5044_13476# _n9 D8/iovdd_uq0 sg13_hv_pmos ad=2.1312p pd=7.3u as=3.9294p ps=7.84u w=6.66u l=0.6u
X31 _n9c _n9 vss D8/rppd l=2u w=1u
X32 D8/iovdd_uq0 D8/a_5044_13476# _n9 D8/iovdd_uq0 sg13_hv_pmos ad=2.1312p pd=7.3u as=3.9294p ps=7.84u w=6.66u l=0.6u
X33 D8/iovdd_uq0 D8/a_5044_13476# _n9 D8/iovdd_uq0 sg13_hv_pmos ad=2.1312p pd=7.3u as=3.9294p ps=7.84u w=6.66u l=0.6u
X34 _n9 D8/a_5044_13476# D8/iovdd_uq0 D8/iovdd_uq0 sg13_hv_pmos ad=3.9294p pd=7.84u as=2.1312p ps=7.3u w=6.66u l=0.6u
X35 _n9 D8/a_5044_1676# vss vss sg13_hv_nmos ad=2.596p pd=5.58u as=1.408p ps=5.04u w=4.4u l=0.6u
X36 vss D8/a_5044_1676# _n9 vss sg13_hv_nmos ad=1.408p pd=5.04u as=2.596p ps=5.58u w=4.4u l=0.6u
X37 _n9 D8/a_5044_1676# vss vss sg13_hv_nmos ad=2.596p pd=5.58u as=1.408p ps=5.04u w=4.4u l=0.6u
X38 D8/iovdd_uq0 D8/a_5044_13476# _n9 D8/iovdd_uq0 sg13_hv_pmos ad=2.1312p pd=7.3u as=3.9294p ps=7.84u w=6.66u l=0.6u
X39 _n9 D8/a_5044_13476# D8/iovdd_uq0 D8/iovdd_uq0 sg13_hv_pmos ad=3.9294p pd=7.84u as=2.1312p ps=7.3u w=6.66u l=0.6u
X40 _n9 D8/iovdd_uq0 D8/dpantenna D8/l=1.26u w=27.78u
X41 vss D8/a_5044_1676# _n9 vss sg13_hv_nmos ad=1.408p pd=5.04u as=2.596p ps=5.58u w=4.4u l=0.6u
X42 D8/iovdd_uq0 D8/a_5044_13476# _n9 D8/iovdd_uq0 sg13_hv_pmos ad=2.1312p pd=7.3u as=3.9294p ps=7.84u w=6.66u l=0.6u
X43 vss D8/a_5044_1676# _n9 vss sg13_hv_nmos ad=1.408p pd=5.04u as=2.596p ps=5.58u w=4.4u l=0.6u
X44 _n9 D8/a_5044_13476# D8/iovdd_uq0 D8/iovdd_uq0 sg13_hv_pmos ad=3.9294p pd=7.84u as=2.1312p ps=7.3u w=6.66u l=0.6u
X45 D8/iovdd_uq0 D8/a_5044_13476# _n9 D8/iovdd_uq0 sg13_hv_pmos ad=2.1312p pd=7.3u as=3.9294p ps=7.84u w=6.66u l=0.6u
X46 _n9 D8/a_5044_13476# D8/iovdd_uq0 D8/iovdd_uq0 sg13_hv_pmos ad=3.9294p pd=7.84u as=2.1312p ps=7.3u w=6.66u l=0.6u
X47 _n9 D8/a_5044_1676# vss vss sg13_hv_nmos ad=2.596p pd=5.58u as=1.408p ps=5.04u w=4.4u l=0.6u
X48 vss D8/a_5044_1676# _n9 vss sg13_hv_nmos ad=1.408p pd=5.04u as=2.596p ps=5.58u w=4.4u l=0.6u
X49 _n9 D8/a_5044_13476# D8/iovdd_uq0 D8/iovdd_uq0 sg13_hv_pmos ad=3.9294p pd=7.84u as=3.1302p ps=14.26u w=6.66u l=0.6u
X50 D8/iovdd_uq0 D8/a_5044_13476# _n9 D8/iovdd_uq0 sg13_hv_pmos ad=3.1302p pd=14.26u as=3.9294p ps=7.84u w=6.66u l=0.6u
X51 D8/iovdd_uq0 D8/a_5044_13476# _n9 D8/iovdd_uq0 sg13_hv_pmos ad=2.1312p pd=7.3u as=3.9294p ps=7.84u w=6.66u l=0.6u
X52 _n9 D8/a_5044_13476# D8/iovdd_uq0 D8/iovdd_uq0 sg13_hv_pmos ad=3.9294p pd=7.84u as=2.1312p ps=7.3u w=6.66u l=0.6u
X53 _n9 D8/iovdd_uq0 D8/dpantenna D8/l=1.26u w=27.78u
X54 _n9 D8/a_5044_13476# D8/iovdd_uq0 D8/iovdd_uq0 sg13_hv_pmos ad=3.9294p pd=7.84u as=3.1302p ps=14.26u w=6.66u l=0.6u
X55 D8/iovdd_uq0 D8/a_5044_13476# _n9 D8/iovdd_uq0 sg13_hv_pmos ad=3.1302p pd=14.26u as=3.9294p ps=7.84u w=6.66u l=0.6u
X56 D8/iovdd_uq0 D8/a_5044_13476# _n9 D8/iovdd_uq0 sg13_hv_pmos ad=2.1312p pd=7.3u as=3.9294p ps=7.84u w=6.66u l=0.6u
X57 _n9 D8/a_5044_13476# D8/iovdd_uq0 D8/iovdd_uq0 sg13_hv_pmos ad=3.9294p pd=7.84u as=2.1312p ps=7.3u w=6.66u l=0.6u
X58 vss D8/a_11462_28198# D8/dantenna D8/l=3.1u w=0.64u
X59 vss D8/a_5222_3962# D8/dantenna D8/l=1.26u w=27.78u
X60 D8/a_5044_1676# vss vss D8/rppd l=3.54u w=0.5u
X61 D8/iovdd_uq0 D8/a_5044_13476# _n9 D8/iovdd_uq0 sg13_hv_pmos ad=2.1312p pd=7.3u as=3.9294p ps=7.84u w=6.66u l=0.6u
X62 D8/iovdd_uq0 D8/a_5044_13476# _n9 D8/iovdd_uq0 sg13_hv_pmos ad=2.1312p pd=7.3u as=3.9294p ps=7.84u w=6.66u l=0.6u
X63 _n9 D8/a_5044_1676# vss vss sg13_hv_nmos ad=2.596p pd=5.58u as=2.068p ps=9.74u w=4.4u l=0.6u
X64 D8/iovdd_uq0 D8/a_5044_13476# _n9 D8/iovdd_uq0 sg13_hv_pmos ad=2.1312p pd=7.3u as=3.9294p ps=7.84u w=6.66u l=0.6u
X65 _n9 D8/a_5044_13476# D8/iovdd_uq0 D8/iovdd_uq0 sg13_hv_pmos ad=3.9294p pd=7.84u as=2.1312p ps=7.3u w=6.66u l=0.6u
X66 _n9 D8/a_5044_13476# D8/iovdd_uq0 D8/iovdd_uq0 sg13_hv_pmos ad=3.9294p pd=7.84u as=2.1312p ps=7.3u w=6.66u l=0.6u
X67 _n9 D8/a_5044_13476# D8/iovdd_uq0 D8/iovdd_uq0 sg13_hv_pmos ad=3.9294p pd=7.84u as=2.1312p ps=7.3u w=6.66u l=0.6u
X68 vss D8/a_5044_1676# _n9 vss sg13_hv_nmos ad=1.408p pd=5.04u as=2.596p ps=5.58u w=4.4u l=0.6u
X0 vdd PVDD/sg13cmos5l_RCClampInverter_0.in PVDD/sg13cmos5l_Clamp_N43N43D4R_0.gate vdd sg13_hv_pmos ad=1.33p pd=7.38u as=1.33p ps=7.38u w=7u l=0.5u
X1 PVDD/a_8065_11542# PVDD/a_7735_7456# vss PVDD/rppd l=20u w=1u
X2 vss PVDD/sg13cmos5l_Clamp_N43N43D4R_0.gate vdd vss sg13_hv_nmos ad=1.408p pd=5.04u as=2.596p ps=5.58u w=4.4u l=0.6u
X3 vss PVDD/sg13cmos5l_Clamp_N43N43D4R_0.gate vdd vss sg13_hv_nmos ad=1.408p pd=5.04u as=2.596p ps=5.58u w=4.4u l=0.6u
X4 vss PVDD/sg13cmos5l_Clamp_N43N43D4R_0.gate vdd vss sg13_hv_nmos ad=1.408p pd=5.04u as=2.596p ps=5.58u w=4.4u l=0.6u
X5 vdd PVDD/sg13cmos5l_RCClampInverter_0.in PVDD/sg13cmos5l_Clamp_N43N43D4R_0.gate vdd sg13_hv_pmos ad=1.33p pd=7.38u as=1.33p ps=7.38u w=7u l=0.5u
X6 vdd PVDD/sg13cmos5l_Clamp_N43N43D4R_0.gate vss vss sg13_hv_nmos ad=2.596p pd=5.58u as=1.408p ps=5.04u w=4.4u l=0.6u
X7 vss PVDD/sg13cmos5l_Clamp_N43N43D4R_0.gate vdd vss sg13_hv_nmos ad=1.408p pd=5.04u as=2.596p ps=5.58u w=4.4u l=0.6u
X8 vdd PVDD/sg13cmos5l_RCClampInverter_0.in PVDD/sg13cmos5l_Clamp_N43N43D4R_0.gate vdd sg13_hv_pmos ad=1.33p pd=7.38u as=1.33p ps=7.38u w=7u l=0.5u
X9 vdd PVDD/sg13cmos5l_Clamp_N43N43D4R_0.gate vss vss sg13_hv_nmos ad=2.596p pd=5.58u as=1.408p ps=5.04u w=4.4u l=0.6u
X10 vss PVDD/sg13cmos5l_Clamp_N43N43D4R_0.gate vdd vss sg13_hv_nmos ad=1.408p pd=5.04u as=2.596p ps=5.58u w=4.4u l=0.6u
X11 vdd PVDD/sg13cmos5l_RCClampInverter_0.in PVDD/sg13cmos5l_Clamp_N43N43D4R_0.gate vdd sg13_hv_pmos ad=1.33p pd=7.38u as=1.33p ps=7.38u w=7u l=0.5u
X12 vss PVDD/sg13cmos5l_Clamp_N43N43D4R_0.gate vdd vss sg13_hv_nmos ad=1.408p pd=5.04u as=2.596p ps=5.58u w=4.4u l=0.6u
X13 vdd PVDD/sg13cmos5l_RCClampInverter_0.in PVDD/sg13cmos5l_Clamp_N43N43D4R_0.gate vdd sg13_hv_pmos ad=1.33p pd=7.38u as=1.33p ps=7.38u w=7u l=0.5u
X14 vdd PVDD/sg13cmos5l_RCClampInverter_0.in PVDD/sg13cmos5l_Clamp_N43N43D4R_0.gate vdd sg13_hv_pmos ad=1.33p pd=7.38u as=1.33p ps=7.38u w=7u l=0.5u
X15 vss PVDD/sg13cmos5l_Clamp_N43N43D4R_0.gate vdd vss sg13_hv_nmos ad=1.408p pd=5.04u as=2.596p ps=5.58u w=4.4u l=0.6u
X16 vdd PVDD/sg13cmos5l_Clamp_N43N43D4R_0.gate vss vss sg13_hv_nmos ad=2.596p pd=5.58u as=1.408p ps=5.04u w=4.4u l=0.6u
X17 vss PVDD/sg13cmos5l_Clamp_N43N43D4R_0.gate vdd vss sg13_hv_nmos ad=1.408p pd=5.04u as=2.596p ps=5.58u w=4.4u l=0.6u
X18 vss PVDD/sg13cmos5l_Clamp_N43N43D4R_0.gate vdd vss sg13_hv_nmos ad=1.408p pd=5.04u as=2.596p ps=5.58u w=4.4u l=0.6u
X19 vdd PVDD/sg13cmos5l_Clamp_N43N43D4R_0.gate vss vss sg13_hv_nmos ad=2.596p pd=5.58u as=1.408p ps=5.04u w=4.4u l=0.6u
X20 vdd PVDD/sg13cmos5l_RCClampInverter_0.in PVDD/sg13cmos5l_Clamp_N43N43D4R_0.gate vdd sg13_hv_pmos ad=1.33p pd=7.38u as=1.33p ps=7.38u w=7u l=0.5u
X21 PVDD/a_6745_11542# PVDD/a_6415_7456# vss PVDD/rppd l=20u w=1u
X22 vss PVDD/sg13cmos5l_Clamp_N43N43D4R_0.gate vdd vss sg13_hv_nmos ad=1.408p pd=5.04u as=2.596p ps=5.58u w=4.4u l=0.6u
X23 vdd PVDD/sg13cmos5l_RCClampInverter_0.in PVDD/sg13cmos5l_Clamp_N43N43D4R_0.gate vdd sg13_hv_pmos ad=1.33p pd=7.38u as=1.33p ps=7.38u w=7u l=0.5u
X24 vdd PVDD/sg13cmos5l_Clamp_N43N43D4R_0.gate vss vss sg13_hv_nmos ad=2.596p pd=5.58u as=1.408p ps=5.04u w=4.4u l=0.6u
X25 vss PVDD/sg13cmos5l_Clamp_N43N43D4R_0.gate vdd vss sg13_hv_nmos ad=1.408p pd=5.04u as=2.596p ps=5.58u w=4.4u l=0.6u
X26 vdd PVDD/sg13cmos5l_RCClampInverter_0.in PVDD/sg13cmos5l_Clamp_N43N43D4R_0.gate vdd sg13_hv_pmos ad=1.33p pd=7.38u as=1.33p ps=7.38u w=7u l=0.5u
X27 vdd PVDD/sg13cmos5l_Clamp_N43N43D4R_0.gate vss vss sg13_hv_nmos ad=2.596p pd=5.58u as=1.408p ps=5.04u w=4.4u l=0.6u
X28 vdd PVDD/sg13cmos5l_Clamp_N43N43D4R_0.gate vss vss sg13_hv_nmos ad=2.596p pd=5.58u as=1.408p ps=5.04u w=4.4u l=0.6u
X29 vss PVDD/sg13cmos5l_Clamp_N43N43D4R_0.gate vdd vss sg13_hv_nmos ad=1.408p pd=5.04u as=2.596p ps=5.58u w=4.4u l=0.6u
X30 vss PVDD/sg13cmos5l_Clamp_N43N43D4R_0.gate vdd vss sg13_hv_nmos ad=1.408p pd=5.04u as=2.596p ps=5.58u w=4.4u l=0.6u
X31 vdd PVDD/sg13cmos5l_Clamp_N43N43D4R_0.gate vss vss sg13_hv_nmos ad=2.596p pd=5.58u as=1.408p ps=5.04u w=4.4u l=0.6u
X32 vss PVDD/sg13cmos5l_Clamp_N43N43D4R_0.gate vdd vss sg13_hv_nmos ad=1.408p pd=5.04u as=2.596p ps=5.58u w=4.4u l=0.6u
X33 vdd PVDD/sg13cmos5l_Clamp_N43N43D4R_0.gate vss vss sg13_hv_nmos ad=2.596p pd=5.58u as=1.408p ps=5.04u w=4.4u l=0.6u
X34 vdd PVDD/sg13cmos5l_RCClampInverter_0.in PVDD/sg13cmos5l_Clamp_N43N43D4R_0.gate vdd sg13_hv_pmos ad=1.33p pd=7.38u as=1.33p ps=7.38u w=7u l=0.5u
X35 vdd PVDD/sg13cmos5l_RCClampInverter_0.in PVDD/sg13cmos5l_Clamp_N43N43D4R_0.gate vdd sg13_hv_pmos ad=1.33p pd=7.38u as=1.33p ps=7.38u w=7u l=0.5u
X36 vss PVDD/sg13cmos5l_Clamp_N43N43D4R_0.gate vdd vss sg13_hv_nmos ad=1.408p pd=5.04u as=2.596p ps=5.58u w=4.4u l=0.6u
X37 vss PVDD/sg13cmos5l_Clamp_N43N43D4R_0.gate vdd vss sg13_hv_nmos ad=1.408p pd=5.04u as=2.596p ps=5.58u w=4.4u l=0.6u
X38 vss PVDD/sg13cmos5l_RCClampInverter_0.in vss vss sg13_hv_nmos ad=1.71p pd=9.38u as=2.24759n ps=2.5228m w=9u l=9.5u
X39 vdd PVDD/sg13cmos5l_RCClampInverter_0.in PVDD/sg13cmos5l_Clamp_N43N43D4R_0.gate vdd sg13_hv_pmos ad=2.38p pd=14.68u as=1.33p ps=7.38u w=7u l=0.5u
X40 vss PVDD/sg13cmos5l_RCClampInverter_0.in vss vss sg13_hv_nmos ad=1.71p pd=9.38u as=0 ps=0 w=9u l=9.5u
X41 vdd PVDD/sg13cmos5l_RCClampInverter_0.in PVDD/sg13cmos5l_Clamp_N43N43D4R_0.gate vdd sg13_hv_pmos ad=1.33p pd=7.38u as=1.33p ps=7.38u w=7u l=0.5u
X42 vss PVDD/sg13cmos5l_Clamp_N43N43D4R_0.gate vdd vss sg13_hv_nmos ad=1.408p pd=5.04u as=2.596p ps=5.58u w=4.4u l=0.6u
X43 vdd PVDD/sg13cmos5l_Clamp_N43N43D4R_0.gate vss vss sg13_hv_nmos ad=2.596p pd=5.58u as=1.408p ps=5.04u w=4.4u l=0.6u
X44 PVDD/a_11365_11542# PVDD/a_11695_7456# vss PVDD/rppd l=20u w=1u
X45 vss PVDD/sg13cmos5l_Clamp_N43N43D4R_0.gate vdd vss sg13_hv_nmos ad=1.408p pd=5.04u as=2.596p ps=5.58u w=4.4u l=0.6u
X46 vdd PVDD/sg13cmos5l_Clamp_N43N43D4R_0.gate vss vss sg13_hv_nmos ad=2.596p pd=5.58u as=1.408p ps=5.04u w=4.4u l=0.6u
X47 vdd PVDD/sg13cmos5l_Clamp_N43N43D4R_0.gate vss vss sg13_hv_nmos ad=3.256p pd=10.28u as=1.408p ps=5.04u w=4.4u l=0.6u
X48 vdd PVDD/sg13cmos5l_Clamp_N43N43D4R_0.gate vss vss sg13_hv_nmos ad=2.596p pd=5.58u as=1.408p ps=5.04u w=4.4u l=0.6u
X49 vdd PVDD/sg13cmos5l_Clamp_N43N43D4R_0.gate vss vss sg13_hv_nmos ad=2.596p pd=5.58u as=1.408p ps=5.04u w=4.4u l=0.6u
X50 vss PVDD/sg13cmos5l_Clamp_N43N43D4R_0.gate vdd vss sg13_hv_nmos ad=1.408p pd=5.04u as=2.596p ps=5.58u w=4.4u l=0.6u
X51 vdd PVDD/sg13cmos5l_Clamp_N43N43D4R_0.gate vss vss sg13_hv_nmos ad=2.596p pd=5.58u as=1.408p ps=5.04u w=4.4u l=0.6u
X52 vss PVDD/sg13cmos5l_Clamp_N43N43D4R_0.gate vdd vss sg13_hv_nmos ad=1.408p pd=5.04u as=2.596p ps=5.58u w=4.4u l=0.6u
X53 vss PVDD/sg13cmos5l_Clamp_N43N43D4R_0.gate vdd vss sg13_hv_nmos ad=1.408p pd=5.04u as=2.596p ps=5.58u w=4.4u l=0.6u
X54 vss PVDD/sg13cmos5l_RCClampInverter_0.in PVDD/sg13cmos5l_Clamp_N43N43D4R_0.gate vss sg13_hv_nmos ad=1.71p pd=9.38u as=1.71p ps=9.38u w=9u l=0.5u
X55 PVDD/a_8725_11542# PVDD/a_9055_7456# vss PVDD/rppd l=20u w=1u
X56 vss PVDD/sg13cmos5l_Clamp_N43N43D4R_0.gate vdd vss sg13_hv_nmos ad=1.408p pd=5.04u as=2.596p ps=5.58u w=4.4u l=0.6u
X57 vss PVDD/sg13cmos5l_RCClampInverter_0.in PVDD/sg13cmos5l_Clamp_N43N43D4R_0.gate vss sg13_hv_nmos ad=1.71p pd=9.38u as=1.71p ps=9.38u w=9u l=0.5u
X58 vdd PVDD/sg13cmos5l_Clamp_N43N43D4R_0.gate vss vss sg13_hv_nmos ad=2.596p pd=5.58u as=1.408p ps=5.04u w=4.4u l=0.6u
X59 vss PVDD/sg13cmos5l_RCClampInverter_0.in PVDD/sg13cmos5l_Clamp_N43N43D4R_0.gate vss sg13_hv_nmos ad=1.71p pd=9.38u as=1.71p ps=9.38u w=9u l=0.5u
X60 PVDD/a_10045_11542# PVDD/a_9715_7456# vss PVDD/rppd l=20u w=1u
X61 vdd PVDD/sg13cmos5l_RCClampInverter_0.in PVDD/sg13cmos5l_Clamp_N43N43D4R_0.gate vdd sg13_hv_pmos ad=1.33p pd=7.38u as=1.33p ps=7.38u w=7u l=0.5u
X62 vss PVDD/sg13cmos5l_RCClampInverter_0.in vss vss sg13_hv_nmos ad=1.71p pd=9.38u as=0 ps=0 w=9u l=9.5u
X63 vss PVDD/sg13cmos5l_Clamp_N43N43D4R_0.gate vdd vss sg13_hv_nmos ad=1.408p pd=5.04u as=2.596p ps=5.58u w=4.4u l=0.6u
X64 vdd PVDD/sg13cmos5l_Clamp_N43N43D4R_0.gate vss vss sg13_hv_nmos ad=2.596p pd=5.58u as=1.408p ps=5.04u w=4.4u l=0.6u
X65 vss PVDD/sg13cmos5l_RCClampInverter_0.in PVDD/sg13cmos5l_Clamp_N43N43D4R_0.gate vss sg13_hv_nmos ad=1.71p pd=9.38u as=1.71p ps=9.38u w=9u l=0.5u
X66 vdd PVDD/sg13cmos5l_Clamp_N43N43D4R_0.gate vss vss sg13_hv_nmos ad=2.596p pd=5.58u as=1.408p ps=5.04u w=4.4u l=0.6u
X67 vss PVDD/sg13cmos5l_RCClampInverter_0.in vss vss sg13_hv_nmos ad=1.71p pd=9.38u as=0 ps=0 w=9u l=9.5u
X68 vdd PVDD/sg13cmos5l_Clamp_N43N43D4R_0.gate vss vss sg13_hv_nmos ad=2.596p pd=5.58u as=2.068p ps=9.74u w=4.4u l=0.6u
X69 vdd PVDD/sg13cmos5l_RCClampInverter_0.in PVDD/sg13cmos5l_Clamp_N43N43D4R_0.gate vdd sg13_hv_pmos ad=1.33p pd=7.38u as=1.33p ps=7.38u w=7u l=0.5u
X70 vss PVDD/sg13cmos5l_RCClampInverter_0.in vss vss sg13_hv_nmos ad=1.71p pd=9.38u as=0 ps=0 w=9u l=9.5u
X71 vdd PVDD/sg13cmos5l_Clamp_N43N43D4R_0.gate vss vss sg13_hv_nmos ad=2.596p pd=5.58u as=1.408p ps=5.04u w=4.4u l=0.6u
X72 vdd PVDD/sg13cmos5l_Clamp_N43N43D4R_0.gate vss vss sg13_hv_nmos ad=2.596p pd=5.58u as=1.408p ps=5.04u w=4.4u l=0.6u
X73 vdd PVDD/sg13cmos5l_Clamp_N43N43D4R_0.gate vss vss sg13_hv_nmos ad=2.596p pd=5.58u as=1.408p ps=5.04u w=4.4u l=0.6u
X74 vss PVDD/sg13cmos5l_Clamp_N43N43D4R_0.gate vdd vss sg13_hv_nmos ad=1.408p pd=5.04u as=2.596p ps=5.58u w=4.4u l=0.6u
X75 vss PVDD/sg13cmos5l_RCClampInverter_0.in vss vss sg13_hv_nmos ad=1.71p pd=9.38u as=0 ps=0 w=9u l=9.5u
X76 vdd PVDD/sg13cmos5l_Clamp_N43N43D4R_0.gate vss vss sg13_hv_nmos ad=2.596p pd=5.58u as=1.408p ps=5.04u w=4.4u l=0.6u
X77 vdd PVDD/sg13cmos5l_Clamp_N43N43D4R_0.gate vss vss sg13_hv_nmos ad=2.596p pd=5.58u as=1.408p ps=5.04u w=4.4u l=0.6u
X78 vdd PVDD/sg13cmos5l_Clamp_N43N43D4R_0.gate vss vss sg13_hv_nmos ad=2.596p pd=5.58u as=1.408p ps=5.04u w=4.4u l=0.6u
X79 vss PVDD/sg13cmos5l_Clamp_N43N43D4R_0.gate vdd vss sg13_hv_nmos ad=1.408p pd=5.04u as=2.596p ps=5.58u w=4.4u l=0.6u
X80 vdd PVDD/sg13cmos5l_RCClampInverter_0.in PVDD/sg13cmos5l_Clamp_N43N43D4R_0.gate vdd sg13_hv_pmos ad=1.33p pd=7.38u as=1.33p ps=7.38u w=7u l=0.5u
X81 PVDD/a_4105_11542# PVDD/a_4435_7456# vss PVDD/rppd l=20u w=1u
X82 PVDD/a_7405_11542# PVDD/a_7735_7456# vss PVDD/rppd l=20u w=1u
X83 vdd PVDD/sg13cmos5l_RCClampInverter_0.in PVDD/sg13cmos5l_Clamp_N43N43D4R_0.gate vdd sg13_hv_pmos ad=1.33p pd=7.38u as=1.33p ps=7.38u w=7u l=0.5u
X84 vss PVDD/sg13cmos5l_RCClampInverter_0.in PVDD/sg13cmos5l_Clamp_N43N43D4R_0.gate vss sg13_hv_nmos ad=1.71p pd=9.38u as=1.71p ps=9.38u w=9u l=0.5u
X85 vss PVDD/sg13cmos5l_Clamp_N43N43D4R_0.gate vdd vss sg13_hv_nmos ad=1.408p pd=5.04u as=2.596p ps=5.58u w=4.4u l=0.6u
X86 vdd PVDD/sg13cmos5l_Clamp_N43N43D4R_0.gate vss vss sg13_hv_nmos ad=2.596p pd=5.58u as=1.408p ps=5.04u w=4.4u l=0.6u
X87 vss PVDD/sg13cmos5l_RCClampInverter_0.in PVDD/sg13cmos5l_Clamp_N43N43D4R_0.gate vss sg13_hv_nmos ad=1.71p pd=9.38u as=1.71p ps=9.38u w=9u l=0.5u
X88 vdd PVDD/sg13cmos5l_Clamp_N43N43D4R_0.gate vss vss sg13_hv_nmos ad=2.596p pd=5.58u as=1.408p ps=5.04u w=4.4u l=0.6u
X89 vdd PVDD/sg13cmos5l_Clamp_N43N43D4R_0.gate vss vss sg13_hv_nmos ad=2.596p pd=5.58u as=1.408p ps=5.04u w=4.4u l=0.6u
X90 vdd PVDD/sg13cmos5l_Clamp_N43N43D4R_0.gate vss vss sg13_hv_nmos ad=2.596p pd=5.58u as=1.408p ps=5.04u w=4.4u l=0.6u
X91 vdd PVDD/sg13cmos5l_Clamp_N43N43D4R_0.gate vss vss sg13_hv_nmos ad=2.596p pd=5.58u as=1.408p ps=5.04u w=4.4u l=0.6u
X92 vdd PVDD/sg13cmos5l_Clamp_N43N43D4R_0.gate vss vss sg13_hv_nmos ad=2.596p pd=5.58u as=1.408p ps=5.04u w=4.4u l=0.6u
X93 vdd PVDD/sg13cmos5l_Clamp_N43N43D4R_0.gate vss vss sg13_hv_nmos ad=2.596p pd=5.58u as=1.408p ps=5.04u w=4.4u l=0.6u
X94 vss PVDD/sg13cmos5l_Clamp_N43N43D4R_0.gate vdd vss sg13_hv_nmos ad=1.408p pd=5.04u as=2.596p ps=5.58u w=4.4u l=0.6u
X95 vss PVDD/sg13cmos5l_Clamp_N43N43D4R_0.gate vdd vss sg13_hv_nmos ad=1.408p pd=5.04u as=2.596p ps=5.58u w=4.4u l=0.6u
X96 vdd PVDD/sg13cmos5l_RCClampInverter_0.in PVDD/sg13cmos5l_Clamp_N43N43D4R_0.gate vdd sg13_hv_pmos ad=1.33p pd=7.38u as=1.33p ps=7.38u w=7u l=0.5u
X97 vdd PVDD/sg13cmos5l_RCClampInverter_0.in PVDD/sg13cmos5l_Clamp_N43N43D4R_0.gate vdd sg13_hv_pmos ad=1.33p pd=7.38u as=1.33p ps=7.38u w=7u l=0.5u
X98 vss PVDD/sg13cmos5l_Clamp_N43N43D4R_0.gate vdd vss sg13_hv_nmos ad=1.408p pd=5.04u as=2.596p ps=5.58u w=4.4u l=0.6u
X99 vss PVDD/sg13cmos5l_Clamp_N43N43D4R_0.gate vdd vss sg13_hv_nmos ad=1.408p pd=5.04u as=2.596p ps=5.58u w=4.4u l=0.6u
X100 PVDD/a_4765_11542# PVDD/a_5095_7456# vss PVDD/rppd l=20u w=1u
X101 PVDD/a_8065_11542# PVDD/a_8395_7456# vss PVDD/rppd l=20u w=1u
X102 vdd PVDD/sg13cmos5l_Clamp_N43N43D4R_0.gate vss vss sg13_hv_nmos ad=2.596p pd=5.58u as=1.408p ps=5.04u w=4.4u l=0.6u
X103 vss PVDD/sg13cmos5l_Clamp_N43N43D4R_0.gate vdd vss sg13_hv_nmos ad=1.408p pd=5.04u as=2.596p ps=5.58u w=4.4u l=0.6u
X104 PVDD/sg13cmos5l_Clamp_N43N43D4R_0.gate PVDD/sg13cmos5l_RCClampInverter_0.in vdd vdd sg13_hv_pmos ad=1.33p pd=7.38u as=1.33p ps=7.38u w=7u l=0.5u
X105 vdd PVDD/sg13cmos5l_RCClampInverter_0.in PVDD/sg13cmos5l_Clamp_N43N43D4R_0.gate vdd sg13_hv_pmos ad=1.33p pd=7.38u as=1.33p ps=7.38u w=7u l=0.5u
X106 vdd PVDD/sg13cmos5l_Clamp_N43N43D4R_0.gate vss vss sg13_hv_nmos ad=3.256p pd=10.28u as=1.408p ps=5.04u w=4.4u l=0.6u
X107 PVDD/sg13cmos5l_Clamp_N43N43D4R_0.gate PVDD/sg13cmos5l_RCClampInverter_0.in vdd vdd sg13_hv_pmos ad=1.33p pd=7.38u as=1.33p ps=7.38u w=7u l=0.5u
X108 vdd PVDD/sg13cmos5l_Clamp_N43N43D4R_0.gate vss vss sg13_hv_nmos ad=2.596p pd=5.58u as=1.408p ps=5.04u w=4.4u l=0.6u
X109 vdd PVDD/sg13cmos5l_Clamp_N43N43D4R_0.gate vss vss sg13_hv_nmos ad=2.596p pd=5.58u as=1.408p ps=5.04u w=4.4u l=0.6u
X110 vdd PVDD/sg13cmos5l_Clamp_N43N43D4R_0.gate vss vss sg13_hv_nmos ad=2.596p pd=5.58u as=1.408p ps=5.04u w=4.4u l=0.6u
X111 vdd PVDD/sg13cmos5l_Clamp_N43N43D4R_0.gate vss vss sg13_hv_nmos ad=2.596p pd=5.58u as=1.408p ps=5.04u w=4.4u l=0.6u
X112 vss PVDD/sg13cmos5l_Clamp_N43N43D4R_0.gate vdd vss sg13_hv_nmos ad=1.408p pd=5.04u as=2.596p ps=5.58u w=4.4u l=0.6u
X113 vss PVDD/sg13cmos5l_Clamp_N43N43D4R_0.gate vdd vss sg13_hv_nmos ad=1.408p pd=5.04u as=2.596p ps=5.58u w=4.4u l=0.6u
X114 vss PVDD/sg13cmos5l_Clamp_N43N43D4R_0.gate vdd vss sg13_hv_nmos ad=1.408p pd=5.04u as=2.596p ps=5.58u w=4.4u l=0.6u
X115 vdd PVDD/sg13cmos5l_Clamp_N43N43D4R_0.gate vss vss sg13_hv_nmos ad=2.596p pd=5.58u as=1.408p ps=5.04u w=4.4u l=0.6u
X116 vss PVDD/sg13cmos5l_Clamp_N43N43D4R_0.gate vdd vss sg13_hv_nmos ad=1.408p pd=5.04u as=2.596p ps=5.58u w=4.4u l=0.6u
X117 vss PVDD/sg13cmos5l_RCClampInverter_0.in vss vss sg13_hv_nmos ad=1.71p pd=9.38u as=0 ps=0 w=9u l=9.5u
X118 vdd PVDD/sg13cmos5l_RCClampInverter_0.in PVDD/sg13cmos5l_Clamp_N43N43D4R_0.gate vdd sg13_hv_pmos ad=1.33p pd=7.38u as=1.33p ps=7.38u w=7u l=0.5u
X119 vss PVDD/sg13cmos5l_RCClampInverter_0.in vss vss sg13_hv_nmos ad=1.71p pd=9.38u as=0 ps=0 w=9u l=9.5u
X120 PVDD/a_10705_11542# PVDD/a_11035_7456# vss PVDD/rppd l=20u w=1u
X121 vdd PVDD/sg13cmos5l_Clamp_N43N43D4R_0.gate vss vss sg13_hv_nmos ad=2.596p pd=5.58u as=1.408p ps=5.04u w=4.4u l=0.6u
X122 vss PVDD/sg13cmos5l_Clamp_N43N43D4R_0.gate vdd vss sg13_hv_nmos ad=1.408p pd=5.04u as=2.596p ps=5.58u w=4.4u l=0.6u
X123 vss PVDD/sg13cmos5l_Clamp_N43N43D4R_0.gate vdd vss sg13_hv_nmos ad=1.408p pd=5.04u as=2.596p ps=5.58u w=4.4u l=0.6u
X124 PVDD/sg13cmos5l_Clamp_N43N43D4R_0.gate PVDD/sg13cmos5l_RCClampInverter_0.in vdd vdd sg13_hv_pmos ad=1.33p pd=7.38u as=1.33p ps=7.38u w=7u l=0.5u
X125 vss PVDD/sg13cmos5l_Clamp_N43N43D4R_0.gate vdd vss sg13_hv_nmos ad=1.408p pd=5.04u as=2.596p ps=5.58u w=4.4u l=0.6u
X126 vdd PVDD/a_3775_7456# vss PVDD/rppd l=20u w=1u
X127 vdd PVDD/sg13cmos5l_Clamp_N43N43D4R_0.gate vss vss sg13_hv_nmos ad=2.596p pd=5.58u as=2.068p ps=9.74u w=4.4u l=0.6u
X128 vdd PVDD/sg13cmos5l_Clamp_N43N43D4R_0.gate vss vss sg13_hv_nmos ad=2.596p pd=5.58u as=1.408p ps=5.04u w=4.4u l=0.6u
X129 vdd PVDD/sg13cmos5l_Clamp_N43N43D4R_0.gate vss vss sg13_hv_nmos ad=2.596p pd=5.58u as=1.408p ps=5.04u w=4.4u l=0.6u
X130 vss PVDD/sg13cmos5l_Clamp_N43N43D4R_0.gate vdd vss sg13_hv_nmos ad=1.408p pd=5.04u as=2.596p ps=5.58u w=4.4u l=0.6u
X131 vss PVDD/sg13cmos5l_Clamp_N43N43D4R_0.gate vdd vss sg13_hv_nmos ad=1.408p pd=5.04u as=2.596p ps=5.58u w=4.4u l=0.6u
X132 vdd PVDD/sg13cmos5l_Clamp_N43N43D4R_0.gate vss vss sg13_hv_nmos ad=2.596p pd=5.58u as=1.408p ps=5.04u w=4.4u l=0.6u
X133 vss PVDD/sg13cmos5l_Clamp_N43N43D4R_0.gate vdd vss sg13_hv_nmos ad=1.408p pd=5.04u as=2.596p ps=5.58u w=4.4u l=0.6u
X134 vss PVDD/sg13cmos5l_Clamp_N43N43D4R_0.gate vdd vss sg13_hv_nmos ad=1.408p pd=5.04u as=2.596p ps=5.58u w=4.4u l=0.6u
X135 PVDD/a_8725_11542# PVDD/a_8395_7456# vss PVDD/rppd l=20u w=1u
X136 vss PVDD/sg13cmos5l_Clamp_N43N43D4R_0.gate vdd vss sg13_hv_nmos ad=1.408p pd=5.04u as=2.596p ps=5.58u w=4.4u l=0.6u
X137 vss PVDD/sg13cmos5l_Clamp_N43N43D4R_0.gate vdd vss sg13_hv_nmos ad=1.408p pd=5.04u as=2.596p ps=5.58u w=4.4u l=0.6u
X138 PVDD/sg13cmos5l_Clamp_N43N43D4R_0.gate PVDD/sg13cmos5l_RCClampInverter_0.in vdd vdd sg13_hv_pmos ad=1.33p pd=7.38u as=1.33p ps=7.38u w=7u l=0.5u
X139 PVDD/sg13cmos5l_Clamp_N43N43D4R_0.gate PVDD/sg13cmos5l_RCClampInverter_0.in vdd vdd sg13_hv_pmos ad=1.33p pd=7.38u as=1.33p ps=7.38u w=7u l=0.5u
X140 PVDD/a_5425_11542# PVDD/a_5095_7456# vss PVDD/rppd l=20u w=1u
X141 vss PVDD/sg13cmos5l_Clamp_N43N43D4R_0.gate vdd vss sg13_hv_nmos ad=1.408p pd=5.04u as=2.596p ps=5.58u w=4.4u l=0.6u
X142 PVDD/sg13cmos5l_Clamp_N43N43D4R_0.gate PVDD/sg13cmos5l_RCClampInverter_0.in vdd vdd sg13_hv_pmos ad=1.33p pd=7.38u as=1.33p ps=7.38u w=7u l=0.5u
X143 PVDD/sg13cmos5l_Clamp_N43N43D4R_0.gate PVDD/sg13cmos5l_RCClampInverter_0.in vdd vdd sg13_hv_pmos ad=1.33p pd=7.38u as=1.33p ps=7.38u w=7u l=0.5u
X144 vdd PVDD/sg13cmos5l_Clamp_N43N43D4R_0.gate vss vss sg13_hv_nmos ad=2.596p pd=5.58u as=1.408p ps=5.04u w=4.4u l=0.6u
X145 vss PVDD/sg13cmos5l_Clamp_N43N43D4R_0.gate vdd vss sg13_hv_nmos ad=1.408p pd=5.04u as=2.596p ps=5.58u w=4.4u l=0.6u
X146 vss PVDD/sg13cmos5l_Clamp_N43N43D4R_0.gate vdd vss sg13_hv_nmos ad=1.408p pd=5.04u as=2.596p ps=5.58u w=4.4u l=0.6u
X147 PVDD/sg13cmos5l_Clamp_N43N43D4R_0.gate PVDD/sg13cmos5l_RCClampInverter_0.in vdd vdd sg13_hv_pmos ad=1.33p pd=7.38u as=1.33p ps=7.38u w=7u l=0.5u
X148 vss PVDD/sg13cmos5l_Clamp_N43N43D4R_0.gate vdd vss sg13_hv_nmos ad=1.408p pd=5.04u as=2.596p ps=5.58u w=4.4u l=0.6u
X149 vdd PVDD/sg13cmos5l_Clamp_N43N43D4R_0.gate vss vss sg13_hv_nmos ad=2.596p pd=5.58u as=1.408p ps=5.04u w=4.4u l=0.6u
X150 PVDD/sg13cmos5l_Clamp_N43N43D4R_0.gate PVDD/sg13cmos5l_RCClampInverter_0.in vdd vdd sg13_hv_pmos ad=1.33p pd=7.38u as=1.33p ps=7.38u w=7u l=0.5u
X151 vss PVDD/sg13cmos5l_Clamp_N43N43D4R_0.gate vdd vss sg13_hv_nmos ad=1.408p pd=5.04u as=2.596p ps=5.58u w=4.4u l=0.6u
X152 vss PVDD/sg13cmos5l_Clamp_N43N43D4R_0.gate vdd vss sg13_hv_nmos ad=1.408p pd=5.04u as=2.596p ps=5.58u w=4.4u l=0.6u
X153 vss PVDD/sg13cmos5l_Clamp_N43N43D4R_0.gate vdd vss sg13_hv_nmos ad=1.408p pd=5.04u as=2.596p ps=5.58u w=4.4u l=0.6u
X154 vss PVDD/sg13cmos5l_Clamp_N43N43D4R_0.gate vdd vss sg13_hv_nmos ad=1.408p pd=5.04u as=2.596p ps=5.58u w=4.4u l=0.6u
X155 vss PVDD/sg13cmos5l_Clamp_N43N43D4R_0.gate vdd vss sg13_hv_nmos ad=1.408p pd=5.04u as=2.596p ps=5.58u w=4.4u l=0.6u
X156 vdd PVDD/sg13cmos5l_Clamp_N43N43D4R_0.gate vss vss sg13_hv_nmos ad=2.596p pd=5.58u as=1.408p ps=5.04u w=4.4u l=0.6u
X157 PVDD/sg13cmos5l_Clamp_N43N43D4R_0.gate PVDD/sg13cmos5l_RCClampInverter_0.in vdd vdd sg13_hv_pmos ad=1.33p pd=7.38u as=1.33p ps=7.38u w=7u l=0.5u
X158 PVDD/a_9385_11542# PVDD/a_9055_7456# vss PVDD/rppd l=20u w=1u
X159 PVDD/sg13cmos5l_Clamp_N43N43D4R_0.gate PVDD/sg13cmos5l_RCClampInverter_0.in vdd vdd sg13_hv_pmos ad=1.33p pd=7.38u as=1.33p ps=7.38u w=7u l=0.5u
X160 PVDD/a_6085_11542# PVDD/a_5755_7456# vss PVDD/rppd l=20u w=1u
X161 vdd PVDD/sg13cmos5l_Clamp_N43N43D4R_0.gate vss vss sg13_hv_nmos ad=2.596p pd=5.58u as=1.408p ps=5.04u w=4.4u l=0.6u
X162 vss PVDD/sg13cmos5l_RCClampInverter_0.in vss vss sg13_hv_nmos ad=1.71p pd=9.38u as=0 ps=0 w=9u l=9.5u
X163 PVDD/sg13cmos5l_Clamp_N43N43D4R_0.gate PVDD/sg13cmos5l_RCClampInverter_0.in vdd vdd sg13_hv_pmos ad=1.33p pd=7.38u as=1.33p ps=7.38u w=7u l=0.5u
X164 PVDD/a_10045_11542# PVDD/a_10375_7456# vss PVDD/rppd l=20u w=1u
X165 PVDD/sg13cmos5l_Clamp_N43N43D4R_0.gate PVDD/sg13cmos5l_RCClampInverter_0.in vdd vdd sg13_hv_pmos ad=1.33p pd=7.38u as=1.33p ps=7.38u w=7u l=0.5u
X166 PVDD/sg13cmos5l_Clamp_N43N43D4R_0.gate PVDD/sg13cmos5l_RCClampInverter_0.in vdd vdd sg13_hv_pmos ad=1.33p pd=7.38u as=1.33p ps=7.38u w=7u l=0.5u
X167 vss PVDD/sg13cmos5l_RCClampInverter_0.in vss vss sg13_hv_nmos ad=1.71p pd=9.38u as=0 ps=0 w=9u l=9.5u
X168 vss PVDD/sg13cmos5l_Clamp_N43N43D4R_0.gate vdd vss sg13_hv_nmos ad=1.408p pd=5.04u as=2.596p ps=5.58u w=4.4u l=0.6u
X169 vdd PVDD/sg13cmos5l_Clamp_N43N43D4R_0.gate vss vss sg13_hv_nmos ad=2.596p pd=5.58u as=1.408p ps=5.04u w=4.4u l=0.6u
X170 vss PVDD/sg13cmos5l_Clamp_N43N43D4R_0.gate vdd vss sg13_hv_nmos ad=1.408p pd=5.04u as=2.596p ps=5.58u w=4.4u l=0.6u
X171 vdd PVDD/sg13cmos5l_Clamp_N43N43D4R_0.gate vss vss sg13_hv_nmos ad=2.596p pd=5.58u as=1.408p ps=5.04u w=4.4u l=0.6u
X172 vdd PVDD/sg13cmos5l_Clamp_N43N43D4R_0.gate vss vss sg13_hv_nmos ad=2.596p pd=5.58u as=1.408p ps=5.04u w=4.4u l=0.6u
X173 vdd PVDD/sg13cmos5l_Clamp_N43N43D4R_0.gate vss vss sg13_hv_nmos ad=2.596p pd=5.58u as=1.408p ps=5.04u w=4.4u l=0.6u
X174 vss PVDD/sg13cmos5l_Clamp_N43N43D4R_0.gate vdd vss sg13_hv_nmos ad=1.408p pd=5.04u as=2.596p ps=5.58u w=4.4u l=0.6u
X175 PVDD/sg13cmos5l_Clamp_N43N43D4R_0.gate PVDD/sg13cmos5l_RCClampInverter_0.in vdd vdd sg13_hv_pmos ad=1.33p pd=7.38u as=1.33p ps=7.38u w=7u l=0.5u
X176 vdd PVDD/sg13cmos5l_Clamp_N43N43D4R_0.gate vss vss sg13_hv_nmos ad=2.596p pd=5.58u as=1.408p ps=5.04u w=4.4u l=0.6u
X177 vss PVDD/sg13cmos5l_Clamp_N43N43D4R_0.gate vdd vss sg13_hv_nmos ad=1.408p pd=5.04u as=2.596p ps=5.58u w=4.4u l=0.6u
X178 PVDD/sg13cmos5l_Clamp_N43N43D4R_0.gate PVDD/sg13cmos5l_RCClampInverter_0.in vdd vdd sg13_hv_pmos ad=1.33p pd=7.38u as=1.33p ps=7.38u w=7u l=0.5u
X179 PVDD/sg13cmos5l_RCClampInverter_0.in PVDD/a_11695_7456# vss PVDD/rppd l=20u w=1u
X180 vss PVDD/sg13cmos5l_Clamp_N43N43D4R_0.gate vdd vss sg13_hv_nmos ad=1.408p pd=5.04u as=2.596p ps=5.58u w=4.4u l=0.6u
X181 vss PVDD/sg13cmos5l_Clamp_N43N43D4R_0.gate vdd vss sg13_hv_nmos ad=1.408p pd=5.04u as=2.596p ps=5.58u w=4.4u l=0.6u
X182 PVDD/sg13cmos5l_Clamp_N43N43D4R_0.gate PVDD/sg13cmos5l_RCClampInverter_0.in vdd vdd sg13_hv_pmos ad=1.33p pd=7.38u as=1.33p ps=7.38u w=7u l=0.5u
X183 vdd PVDD/sg13cmos5l_Clamp_N43N43D4R_0.gate vss vss sg13_hv_nmos ad=2.596p pd=5.58u as=1.408p ps=5.04u w=4.4u l=0.6u
X184 PVDD/sg13cmos5l_Clamp_N43N43D4R_0.gate PVDD/sg13cmos5l_RCClampInverter_0.in vdd vdd sg13_hv_pmos ad=1.33p pd=7.38u as=1.33p ps=7.38u w=7u l=0.5u
X185 PVDD/a_4765_11542# PVDD/a_4435_7456# vss PVDD/rppd l=20u w=1u
X186 vdd PVDD/sg13cmos5l_Clamp_N43N43D4R_0.gate vss vss sg13_hv_nmos ad=2.596p pd=5.58u as=1.408p ps=5.04u w=4.4u l=0.6u
X187 vss PVDD/sg13cmos5l_Clamp_N43N43D4R_0.gate vdd vss sg13_hv_nmos ad=1.408p pd=5.04u as=2.596p ps=5.58u w=4.4u l=0.6u
X188 vdd PVDD/sg13cmos5l_Clamp_N43N43D4R_0.gate vss vss sg13_hv_nmos ad=2.596p pd=5.58u as=1.408p ps=5.04u w=4.4u l=0.6u
X189 PVDD/sg13cmos5l_Clamp_N43N43D4R_0.gate PVDD/sg13cmos5l_RCClampInverter_0.in vdd vdd sg13_hv_pmos ad=1.33p pd=7.38u as=1.33p ps=7.38u w=7u l=0.5u
X190 vss PVDD/sg13cmos5l_Clamp_N43N43D4R_0.gate vdd vss sg13_hv_nmos ad=1.408p pd=5.04u as=2.596p ps=5.58u w=4.4u l=0.6u
X191 vdd PVDD/sg13cmos5l_Clamp_N43N43D4R_0.gate vss vss sg13_hv_nmos ad=2.596p pd=5.58u as=1.408p ps=5.04u w=4.4u l=0.6u
X192 vdd PVDD/sg13cmos5l_Clamp_N43N43D4R_0.gate vss vss sg13_hv_nmos ad=2.596p pd=5.58u as=1.408p ps=5.04u w=4.4u l=0.6u
X193 PVDD/sg13cmos5l_Clamp_N43N43D4R_0.gate PVDD/sg13cmos5l_RCClampInverter_0.in vss vss sg13_hv_nmos ad=1.71p pd=9.38u as=1.71p ps=9.38u w=9u l=0.5u
X194 PVDD/a_6085_11542# PVDD/a_6415_7456# vss PVDD/rppd l=20u w=1u
X195 PVDD/a_9385_11542# PVDD/a_9715_7456# vss PVDD/rppd l=20u w=1u
X196 vss PVDD/sg13cmos5l_Clamp_N43N43D4R_0.gate vdd vss sg13_hv_nmos ad=1.408p pd=5.04u as=2.596p ps=5.58u w=4.4u l=0.6u
X197 vss PVDD/sg13cmos5l_RCClampInverter_0.in vss vss sg13_hv_nmos ad=1.71p pd=9.38u as=0 ps=0 w=9u l=9.5u
X198 PVDD/sg13cmos5l_Clamp_N43N43D4R_0.gate PVDD/sg13cmos5l_RCClampInverter_0.in vss vss sg13_hv_nmos ad=1.71p pd=9.38u as=1.71p ps=9.38u w=9u l=0.5u
X199 vss PVDD/sg13cmos5l_RCClampInverter_0.in vss vss sg13_hv_nmos ad=1.71p pd=9.38u as=0 ps=0 w=9u l=9.5u
X200 PVDD/a_10705_11542# PVDD/a_10375_7456# vss PVDD/rppd l=20u w=1u
X201 PVDD/sg13cmos5l_Clamp_N43N43D4R_0.gate PVDD/sg13cmos5l_RCClampInverter_0.in vss vss sg13_hv_nmos ad=1.71p pd=9.38u as=3.06p ps=18.68u w=9u l=0.5u
X202 vss PVDD/sg13cmos5l_Clamp_N43N43D4R_0.gate vdd vss sg13_hv_nmos ad=1.408p pd=5.04u as=2.596p ps=5.58u w=4.4u l=0.6u
X203 PVDD/sg13cmos5l_Clamp_N43N43D4R_0.gate PVDD/sg13cmos5l_RCClampInverter_0.in vdd vdd sg13_hv_pmos ad=1.33p pd=7.38u as=2.38p ps=14.68u w=7u l=0.5u
X204 vdd PVDD/sg13cmos5l_Clamp_N43N43D4R_0.gate vss vss sg13_hv_nmos ad=3.256p pd=10.28u as=1.408p ps=5.04u w=4.4u l=0.6u
X205 PVDD/sg13cmos5l_Clamp_N43N43D4R_0.gate PVDD/sg13cmos5l_RCClampInverter_0.in vss vss sg13_hv_nmos ad=1.71p pd=9.38u as=3.06p ps=18.68u w=9u l=0.5u
X206 vdd PVDD/sg13cmos5l_Clamp_N43N43D4R_0.gate vss vss sg13_hv_nmos ad=2.596p pd=5.58u as=1.408p ps=5.04u w=4.4u l=0.6u
X207 vdd PVDD/sg13cmos5l_Clamp_N43N43D4R_0.gate vss vss sg13_hv_nmos ad=2.596p pd=5.58u as=1.408p ps=5.04u w=4.4u l=0.6u
X208 vdd PVDD/sg13cmos5l_Clamp_N43N43D4R_0.gate vss vss sg13_hv_nmos ad=2.596p pd=5.58u as=1.408p ps=5.04u w=4.4u l=0.6u
X209 vdd PVDD/sg13cmos5l_Clamp_N43N43D4R_0.gate vss vss sg13_hv_nmos ad=2.596p pd=5.58u as=1.408p ps=5.04u w=4.4u l=0.6u
X210 vdd PVDD/sg13cmos5l_Clamp_N43N43D4R_0.gate vss vss sg13_hv_nmos ad=2.596p pd=5.58u as=1.408p ps=5.04u w=4.4u l=0.6u
X211 vdd PVDD/sg13cmos5l_Clamp_N43N43D4R_0.gate vss vss sg13_hv_nmos ad=2.596p pd=5.58u as=1.408p ps=5.04u w=4.4u l=0.6u
X212 vss PVDD/sg13cmos5l_Clamp_N43N43D4R_0.gate vdd vss sg13_hv_nmos ad=1.408p pd=5.04u as=2.596p ps=5.58u w=4.4u l=0.6u
X213 vdd PVDD/sg13cmos5l_Clamp_N43N43D4R_0.gate vss vss sg13_hv_nmos ad=2.596p pd=5.58u as=1.408p ps=5.04u w=4.4u l=0.6u
X214 vss PVDD/sg13cmos5l_Clamp_N43N43D4R_0.gate vdd vss sg13_hv_nmos ad=1.408p pd=5.04u as=2.596p ps=5.58u w=4.4u l=0.6u
X215 vdd PVDD/sg13cmos5l_Clamp_N43N43D4R_0.gate vss vss sg13_hv_nmos ad=2.596p pd=5.58u as=1.408p ps=5.04u w=4.4u l=0.6u
X216 vss PVDD/sg13cmos5l_RCClampInverter_0.in vss vss sg13_hv_nmos ad=1.71p pd=9.38u as=0 ps=0 w=9u l=9.5u
X217 PVDD/a_6745_11542# PVDD/a_7075_7456# vss PVDD/rppd l=20u w=1u
X218 vdd PVDD/sg13cmos5l_Clamp_N43N43D4R_0.gate vss vss sg13_hv_nmos ad=2.596p pd=5.58u as=1.408p ps=5.04u w=4.4u l=0.6u
X219 vss PVDD/sg13cmos5l_Clamp_N43N43D4R_0.gate vdd vss sg13_hv_nmos ad=1.408p pd=5.04u as=2.596p ps=5.58u w=4.4u l=0.6u
X220 PVDD/sg13cmos5l_Clamp_N43N43D4R_0.gate PVDD/sg13cmos5l_RCClampInverter_0.in vdd vdd sg13_hv_pmos ad=1.33p pd=7.38u as=1.33p ps=7.38u w=7u l=0.5u
X221 vss PVDD/sg13cmos5l_RCClampInverter_0.in vss vss sg13_hv_nmos ad=1.71p pd=9.38u as=0 ps=0 w=9u l=9.5u
X222 vss PVDD/sg13cmos5l_Clamp_N43N43D4R_0.gate vdd vss sg13_hv_nmos ad=1.408p pd=5.04u as=2.596p ps=5.58u w=4.4u l=0.6u
X223 PVDD/a_11365_11542# PVDD/a_11035_7456# vss PVDD/rppd l=20u w=1u
X224 vdd PVDD/sg13cmos5l_Clamp_N43N43D4R_0.gate vss vss sg13_hv_nmos ad=2.596p pd=5.58u as=1.408p ps=5.04u w=4.4u l=0.6u
X225 vdd PVDD/sg13cmos5l_Clamp_N43N43D4R_0.gate vss vss sg13_hv_nmos ad=2.596p pd=5.58u as=2.068p ps=9.74u w=4.4u l=0.6u
X226 PVDD/sg13cmos5l_Clamp_N43N43D4R_0.gate PVDD/sg13cmos5l_RCClampInverter_0.in vdd vdd sg13_hv_pmos ad=1.33p pd=7.38u as=1.33p ps=7.38u w=7u l=0.5u
X227 vdd PVDD/sg13cmos5l_Clamp_N43N43D4R_0.gate vss vss sg13_hv_nmos ad=2.596p pd=5.58u as=1.408p ps=5.04u w=4.4u l=0.6u
X228 vss PVDD/sg13cmos5l_Clamp_N43N43D4R_0.gate vdd vss sg13_hv_nmos ad=1.408p pd=5.04u as=2.596p ps=5.58u w=4.4u l=0.6u
X229 vdd PVDD/sg13cmos5l_RCClampInverter_0.in PVDD/sg13cmos5l_Clamp_N43N43D4R_0.gate vdd sg13_hv_pmos ad=1.33p pd=7.38u as=1.33p ps=7.38u w=7u l=0.5u
X230 PVDD/sg13cmos5l_Clamp_N43N43D4R_0.gate PVDD/sg13cmos5l_RCClampInverter_0.in vdd vdd sg13_hv_pmos ad=1.33p pd=7.38u as=1.33p ps=7.38u w=7u l=0.5u
X231 vdd PVDD/sg13cmos5l_Clamp_N43N43D4R_0.gate vss vss sg13_hv_nmos ad=2.596p pd=5.58u as=1.408p ps=5.04u w=4.4u l=0.6u
X232 vdd PVDD/sg13cmos5l_Clamp_N43N43D4R_0.gate vss vss sg13_hv_nmos ad=2.596p pd=5.58u as=1.408p ps=5.04u w=4.4u l=0.6u
X233 vdd PVDD/sg13cmos5l_Clamp_N43N43D4R_0.gate vss vss sg13_hv_nmos ad=3.256p pd=10.28u as=1.408p ps=5.04u w=4.4u l=0.6u
X234 vdd PVDD/sg13cmos5l_Clamp_N43N43D4R_0.gate vss vss sg13_hv_nmos ad=2.596p pd=5.58u as=1.408p ps=5.04u w=4.4u l=0.6u
X235 vss PVDD/sg13cmos5l_Clamp_N43N43D4R_0.gate vdd vss sg13_hv_nmos ad=1.408p pd=5.04u as=2.596p ps=5.58u w=4.4u l=0.6u
X236 vdd PVDD/sg13cmos5l_Clamp_N43N43D4R_0.gate vss vss sg13_hv_nmos ad=2.596p pd=5.58u as=1.408p ps=5.04u w=4.4u l=0.6u
X237 PVDD/sg13cmos5l_Clamp_N43N43D4R_0.gate PVDD/sg13cmos5l_RCClampInverter_0.in vdd vdd sg13_hv_pmos ad=1.33p pd=7.38u as=1.33p ps=7.38u w=7u l=0.5u
X238 vss PVDD/sg13cmos5l_Clamp_N43N43D4R_0.gate vdd vss sg13_hv_nmos ad=1.408p pd=5.04u as=2.596p ps=5.58u w=4.4u l=0.6u
X239 vss PVDD/sg13cmos5l_Clamp_N43N43D4R_0.gate vdd vss sg13_hv_nmos ad=1.408p pd=5.04u as=2.596p ps=5.58u w=4.4u l=0.6u
X240 vss PVDD/sg13cmos5l_Clamp_N43N43D4R_0.gate vdd vss sg13_hv_nmos ad=1.408p pd=5.04u as=2.596p ps=5.58u w=4.4u l=0.6u
X241 PVDD/a_5425_11542# PVDD/a_5755_7456# vss PVDD/rppd l=20u w=1u
X242 vdd PVDD/sg13cmos5l_Clamp_N43N43D4R_0.gate vss vss sg13_hv_nmos ad=2.596p pd=5.58u as=1.408p ps=5.04u w=4.4u l=0.6u
X243 vdd PVDD/sg13cmos5l_RCClampInverter_0.in PVDD/sg13cmos5l_Clamp_N43N43D4R_0.gate vdd sg13_hv_pmos ad=1.33p pd=7.38u as=1.33p ps=7.38u w=7u l=0.5u
X244 PVDD/sg13cmos5l_Clamp_N43N43D4R_0.gate PVDD/sg13cmos5l_RCClampInverter_0.in vdd vdd sg13_hv_pmos ad=1.33p pd=7.38u as=1.33p ps=7.38u w=7u l=0.5u
X245 vdd PVDD/sg13cmos5l_Clamp_N43N43D4R_0.gate vss vss sg13_hv_nmos ad=2.596p pd=5.58u as=1.408p ps=5.04u w=4.4u l=0.6u
X246 vss PVDD/sg13cmos5l_Clamp_N43N43D4R_0.gate vdd vss sg13_hv_nmos ad=1.408p pd=5.04u as=2.596p ps=5.58u w=4.4u l=0.6u
X247 vdd PVDD/sg13cmos5l_Clamp_N43N43D4R_0.gate vss vss sg13_hv_nmos ad=2.596p pd=5.58u as=1.408p ps=5.04u w=4.4u l=0.6u
X248 vdd PVDD/sg13cmos5l_Clamp_N43N43D4R_0.gate vss vss sg13_hv_nmos ad=2.596p pd=5.58u as=2.068p ps=9.74u w=4.4u l=0.6u
X249 vss PVDD/sg13cmos5l_Clamp_N43N43D4R_0.gate vdd vss sg13_hv_nmos ad=1.408p pd=5.04u as=2.596p ps=5.58u w=4.4u l=0.6u
X250 vdd PVDD/sg13cmos5l_Clamp_N43N43D4R_0.gate vss vss sg13_hv_nmos ad=2.596p pd=5.58u as=1.408p ps=5.04u w=4.4u l=0.6u
X251 vdd PVDD/sg13cmos5l_Clamp_N43N43D4R_0.gate vss vss sg13_hv_nmos ad=2.596p pd=5.58u as=1.408p ps=5.04u w=4.4u l=0.6u
X252 vss PVDD/sg13cmos5l_Clamp_N43N43D4R_0.gate vdd vss sg13_hv_nmos ad=1.408p pd=5.04u as=2.596p ps=5.58u w=4.4u l=0.6u
X253 PVDD/a_4105_11542# PVDD/a_3775_7456# vss PVDD/rppd l=20u w=1u
X254 PVDD/a_7405_11542# PVDD/a_7075_7456# vss PVDD/rppd l=20u w=1u
X255 vss PVDD/sg13cmos5l_Clamp_N43N43D4R_0.gate vdd vss sg13_hv_nmos ad=1.408p pd=5.04u as=2.596p ps=5.58u w=4.4u l=0.6u
X256 vss PVDD/sg13cmos5l_Clamp_N43N43D4R_0.gate vdd vss sg13_hv_nmos ad=1.408p pd=5.04u as=2.596p ps=5.58u w=4.4u l=0.6u
X257 vdd PVDD/sg13cmos5l_Clamp_N43N43D4R_0.gate vss vss sg13_hv_nmos ad=2.596p pd=5.58u as=1.408p ps=5.04u w=4.4u l=0.6u
X258 vss PVDD/sg13cmos5l_Clamp_N43N43D4R_0.gate vdd vss sg13_hv_nmos ad=1.408p pd=5.04u as=2.596p ps=5.58u w=4.4u l=0.6u
X259 vss PVDD/sg13cmos5l_Clamp_N43N43D4R_0.gate vdd vss sg13_hv_nmos ad=1.408p pd=5.04u as=2.596p ps=5.58u w=4.4u l=0.6u
X260 vdd PVDD/sg13cmos5l_RCClampInverter_0.in PVDD/sg13cmos5l_Clamp_N43N43D4R_0.gate vdd sg13_hv_pmos ad=1.33p pd=7.38u as=1.33p ps=7.38u w=7u l=0.5u
X261 vdd PVDD/sg13cmos5l_Clamp_N43N43D4R_0.gate vss vss sg13_hv_nmos ad=2.596p pd=5.58u as=1.408p ps=5.04u w=4.4u l=0.6u
X262 vdd PVDD/sg13cmos5l_Clamp_N43N43D4R_0.gate vss vss sg13_hv_nmos ad=2.596p pd=5.58u as=1.408p ps=5.04u w=4.4u l=0.6u
X263 vdd PVDD/sg13cmos5l_Clamp_N43N43D4R_0.gate vss vss sg13_hv_nmos ad=2.596p pd=5.58u as=1.408p ps=5.04u w=4.4u l=0.6u
X264 vss PVDD/sg13cmos5l_Clamp_N43N43D4R_0.gate vdd vss sg13_hv_nmos ad=1.408p pd=5.04u as=2.596p ps=5.58u w=4.4u l=0.6u
X265 vdd PVDD/sg13cmos5l_RCClampInverter_0.in PVDD/sg13cmos5l_Clamp_N43N43D4R_0.gate vdd sg13_hv_pmos ad=1.33p pd=7.38u as=1.33p ps=7.38u w=7u l=0.5u
X266 vdd PVDD/sg13cmos5l_Clamp_N43N43D4R_0.gate vss vss sg13_hv_nmos ad=2.596p pd=5.58u as=1.408p ps=5.04u w=4.4u l=0.6u
X267 vdd PVDD/sg13cmos5l_Clamp_N43N43D4R_0.gate vss vss sg13_hv_nmos ad=2.596p pd=5.58u as=1.408p ps=5.04u w=4.4u l=0.6u
X268 vss PVDD/a_906_5348# PVDD/dantenna PVDD/l=0.48u w=0.48u
X269 vss PVDD/sg13cmos5l_Clamp_N43N43D4R_0.gate vdd vss sg13_hv_nmos ad=1.408p pd=5.04u as=2.596p ps=5.58u w=4.4u l=0.6u
X270 PVDD/sg13cmos5l_Clamp_N43N43D4R_0.gate PVDD/sg13cmos5l_RCClampInverter_0.in vss vss sg13_hv_nmos ad=1.71p pd=9.38u as=1.71p ps=9.38u w=9u l=0.5u
X271 vss PVDD/sg13cmos5l_Clamp_N43N43D4R_0.gate vdd vss sg13_hv_nmos ad=1.408p pd=5.04u as=2.596p ps=5.58u w=4.4u l=0.6u
X272 vss PVDD/sg13cmos5l_Clamp_N43N43D4R_0.gate vdd vss sg13_hv_nmos ad=1.408p pd=5.04u as=2.596p ps=5.58u w=4.4u l=0.6u
X273 vss PVDD/sg13cmos5l_Clamp_N43N43D4R_0.gate vdd vss sg13_hv_nmos ad=1.408p pd=5.04u as=2.596p ps=5.58u w=4.4u l=0.6u
X274 PVDD/sg13cmos5l_Clamp_N43N43D4R_0.gate PVDD/sg13cmos5l_RCClampInverter_0.in vss vss sg13_hv_nmos ad=1.71p pd=9.38u as=1.71p ps=9.38u w=9u l=0.5u
X0 vss PVSS/iovdd PVSS/dpantenna PVSS/l=27.78u w=1.26u
X1 vss PVSS/iovdd PVSS/dpantenna PVSS/l=27.78u w=1.26u
X2 vss PVSS/a_1682_2060# PVSS/dantenna PVSS/l=27.78u w=1.26u
X3 vss PVSS/a_782_2060# PVSS/dantenna PVSS/l=27.78u w=1.26u
.ends
