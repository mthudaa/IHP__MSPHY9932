* Extracted by KLayout with SG13CMOS5L LVS runset on : 11/07/2026 19:07

.SUBCKT side_cap8b
M$1
+ BOTTOM|TOP|h_sw[0]|h_sw[10]|h_sw[1]|h_sw[2]|h_sw[3]|h_sw[4]|h_sw[5]|h_sw[6]|h_sw[7]|h_sw[8]|h_sw[9]|l_sw[0]|l_sw[10]|l_sw[1]|l_sw[2]|l_sw[3]|l_sw[4]|l_sw[5]|l_sw[6]|l_sw[7]|l_sw[8]|l_sw[9]|vc|vdd|vss|z
+ in_l_sw[0]|x
+ BOTTOM|TOP|h_sw[0]|h_sw[10]|h_sw[1]|h_sw[2]|h_sw[3]|h_sw[4]|h_sw[5]|h_sw[6]|h_sw[7]|h_sw[8]|h_sw[9]|l_sw[0]|l_sw[10]|l_sw[1]|l_sw[2]|l_sw[3]|l_sw[4]|l_sw[5]|l_sw[6]|l_sw[7]|l_sw[8]|l_sw[9]|vc|vdd|vss|z
+ \$1 sg13_lv_nmos L=0.13u W=0.5u AS=0.17p AD=0.095p PS=1.68u PD=0.88u rfmode=0
M$2
+ BOTTOM|TOP|h_sw[0]|h_sw[10]|h_sw[1]|h_sw[2]|h_sw[3]|h_sw[4]|h_sw[5]|h_sw[6]|h_sw[7]|h_sw[8]|h_sw[9]|l_sw[0]|l_sw[10]|l_sw[1]|l_sw[2]|l_sw[3]|l_sw[4]|l_sw[5]|l_sw[6]|l_sw[7]|l_sw[8]|l_sw[9]|vc|vdd|vss|z
+ in_l_sw[0]|x
+ BOTTOM|TOP|h_sw[0]|h_sw[10]|h_sw[1]|h_sw[2]|h_sw[3]|h_sw[4]|h_sw[5]|h_sw[6]|h_sw[7]|h_sw[8]|h_sw[9]|l_sw[0]|l_sw[10]|l_sw[1]|l_sw[2]|l_sw[3]|l_sw[4]|l_sw[5]|l_sw[6]|l_sw[7]|l_sw[8]|l_sw[9]|vc|vdd|vss|z
+ \$1 sg13_lv_nmos L=0.13u W=0.5u AS=0.095p AD=0.095p PS=0.88u PD=0.88u rfmode=0
M$3
+ BOTTOM|TOP|h_sw[0]|h_sw[10]|h_sw[1]|h_sw[2]|h_sw[3]|h_sw[4]|h_sw[5]|h_sw[6]|h_sw[7]|h_sw[8]|h_sw[9]|l_sw[0]|l_sw[10]|l_sw[1]|l_sw[2]|l_sw[3]|l_sw[4]|l_sw[5]|l_sw[6]|l_sw[7]|l_sw[8]|l_sw[9]|vc|vdd|vss|z
+ in_l_sw[0]|x
+ BOTTOM|TOP|h_sw[0]|h_sw[10]|h_sw[1]|h_sw[2]|h_sw[3]|h_sw[4]|h_sw[5]|h_sw[6]|h_sw[7]|h_sw[8]|h_sw[9]|l_sw[0]|l_sw[10]|l_sw[1]|l_sw[2]|l_sw[3]|l_sw[4]|l_sw[5]|l_sw[6]|l_sw[7]|l_sw[8]|l_sw[9]|vc|vdd|vss|z
+ \$1 sg13_lv_nmos L=0.13u W=0.5u AS=0.095p AD=0.095p PS=0.88u PD=0.88u rfmode=0
M$4
+ BOTTOM|TOP|h_sw[0]|h_sw[10]|h_sw[1]|h_sw[2]|h_sw[3]|h_sw[4]|h_sw[5]|h_sw[6]|h_sw[7]|h_sw[8]|h_sw[9]|l_sw[0]|l_sw[10]|l_sw[1]|l_sw[2]|l_sw[3]|l_sw[4]|l_sw[5]|l_sw[6]|l_sw[7]|l_sw[8]|l_sw[9]|vc|vdd|vss|z
+ in_l_sw[0]|x
+ BOTTOM|TOP|h_sw[0]|h_sw[10]|h_sw[1]|h_sw[2]|h_sw[3]|h_sw[4]|h_sw[5]|h_sw[6]|h_sw[7]|h_sw[8]|h_sw[9]|l_sw[0]|l_sw[10]|l_sw[1]|l_sw[2]|l_sw[3]|l_sw[4]|l_sw[5]|l_sw[6]|l_sw[7]|l_sw[8]|l_sw[9]|vc|vdd|vss|z
+ \$1 sg13_lv_nmos L=0.13u W=0.5u AS=0.095p AD=0.095p PS=0.88u PD=0.88u rfmode=0
M$5
+ BOTTOM|TOP|h_sw[0]|h_sw[10]|h_sw[1]|h_sw[2]|h_sw[3]|h_sw[4]|h_sw[5]|h_sw[6]|h_sw[7]|h_sw[8]|h_sw[9]|l_sw[0]|l_sw[10]|l_sw[1]|l_sw[2]|l_sw[3]|l_sw[4]|l_sw[5]|l_sw[6]|l_sw[7]|l_sw[8]|l_sw[9]|vc|vdd|vss|z
+ in_l_sw[0]|x
+ BOTTOM|TOP|h_sw[0]|h_sw[10]|h_sw[1]|h_sw[2]|h_sw[3]|h_sw[4]|h_sw[5]|h_sw[6]|h_sw[7]|h_sw[8]|h_sw[9]|l_sw[0]|l_sw[10]|l_sw[1]|l_sw[2]|l_sw[3]|l_sw[4]|l_sw[5]|l_sw[6]|l_sw[7]|l_sw[8]|l_sw[9]|vc|vdd|vss|z
+ \$1 sg13_lv_nmos L=0.13u W=0.5u AS=0.095p AD=0.095p PS=0.88u PD=0.88u rfmode=0
M$6
+ BOTTOM|TOP|h_sw[0]|h_sw[10]|h_sw[1]|h_sw[2]|h_sw[3]|h_sw[4]|h_sw[5]|h_sw[6]|h_sw[7]|h_sw[8]|h_sw[9]|l_sw[0]|l_sw[10]|l_sw[1]|l_sw[2]|l_sw[3]|l_sw[4]|l_sw[5]|l_sw[6]|l_sw[7]|l_sw[8]|l_sw[9]|vc|vdd|vss|z
+ in_l_sw[0]|x
+ BOTTOM|TOP|h_sw[0]|h_sw[10]|h_sw[1]|h_sw[2]|h_sw[3]|h_sw[4]|h_sw[5]|h_sw[6]|h_sw[7]|h_sw[8]|h_sw[9]|l_sw[0]|l_sw[10]|l_sw[1]|l_sw[2]|l_sw[3]|l_sw[4]|l_sw[5]|l_sw[6]|l_sw[7]|l_sw[8]|l_sw[9]|vc|vdd|vss|z
+ \$1 sg13_lv_nmos L=0.13u W=0.5u AS=0.095p AD=0.095p PS=0.88u PD=0.88u rfmode=0
M$7
+ BOTTOM|TOP|h_sw[0]|h_sw[10]|h_sw[1]|h_sw[2]|h_sw[3]|h_sw[4]|h_sw[5]|h_sw[6]|h_sw[7]|h_sw[8]|h_sw[9]|l_sw[0]|l_sw[10]|l_sw[1]|l_sw[2]|l_sw[3]|l_sw[4]|l_sw[5]|l_sw[6]|l_sw[7]|l_sw[8]|l_sw[9]|vc|vdd|vss|z
+ in_l_sw[0]|x
+ BOTTOM|TOP|h_sw[0]|h_sw[10]|h_sw[1]|h_sw[2]|h_sw[3]|h_sw[4]|h_sw[5]|h_sw[6]|h_sw[7]|h_sw[8]|h_sw[9]|l_sw[0]|l_sw[10]|l_sw[1]|l_sw[2]|l_sw[3]|l_sw[4]|l_sw[5]|l_sw[6]|l_sw[7]|l_sw[8]|l_sw[9]|vc|vdd|vss|z
+ \$1 sg13_lv_nmos L=0.13u W=0.5u AS=0.095p AD=0.095p PS=0.88u PD=0.88u rfmode=0
M$8
+ BOTTOM|TOP|h_sw[0]|h_sw[10]|h_sw[1]|h_sw[2]|h_sw[3]|h_sw[4]|h_sw[5]|h_sw[6]|h_sw[7]|h_sw[8]|h_sw[9]|l_sw[0]|l_sw[10]|l_sw[1]|l_sw[2]|l_sw[3]|l_sw[4]|l_sw[5]|l_sw[6]|l_sw[7]|l_sw[8]|l_sw[9]|vc|vdd|vss|z
+ in_l_sw[0]|x
+ BOTTOM|TOP|h_sw[0]|h_sw[10]|h_sw[1]|h_sw[2]|h_sw[3]|h_sw[4]|h_sw[5]|h_sw[6]|h_sw[7]|h_sw[8]|h_sw[9]|l_sw[0]|l_sw[10]|l_sw[1]|l_sw[2]|l_sw[3]|l_sw[4]|l_sw[5]|l_sw[6]|l_sw[7]|l_sw[8]|l_sw[9]|vc|vdd|vss|z
+ \$1 sg13_lv_nmos L=0.13u W=0.5u AS=0.095p AD=0.095p PS=0.88u PD=0.88u rfmode=0
M$9
+ BOTTOM|TOP|h_sw[0]|h_sw[10]|h_sw[1]|h_sw[2]|h_sw[3]|h_sw[4]|h_sw[5]|h_sw[6]|h_sw[7]|h_sw[8]|h_sw[9]|l_sw[0]|l_sw[10]|l_sw[1]|l_sw[2]|l_sw[3]|l_sw[4]|l_sw[5]|l_sw[6]|l_sw[7]|l_sw[8]|l_sw[9]|vc|vdd|vss|z
+ in_l_sw[0]|x
+ BOTTOM|TOP|h_sw[0]|h_sw[10]|h_sw[1]|h_sw[2]|h_sw[3]|h_sw[4]|h_sw[5]|h_sw[6]|h_sw[7]|h_sw[8]|h_sw[9]|l_sw[0]|l_sw[10]|l_sw[1]|l_sw[2]|l_sw[3]|l_sw[4]|l_sw[5]|l_sw[6]|l_sw[7]|l_sw[8]|l_sw[9]|vc|vdd|vss|z
+ \$1 sg13_lv_nmos L=0.13u W=0.5u AS=0.095p AD=0.095p PS=0.88u PD=0.88u rfmode=0
M$10
+ BOTTOM|TOP|h_sw[0]|h_sw[10]|h_sw[1]|h_sw[2]|h_sw[3]|h_sw[4]|h_sw[5]|h_sw[6]|h_sw[7]|h_sw[8]|h_sw[9]|l_sw[0]|l_sw[10]|l_sw[1]|l_sw[2]|l_sw[3]|l_sw[4]|l_sw[5]|l_sw[6]|l_sw[7]|l_sw[8]|l_sw[9]|vc|vdd|vss|z
+ in_l_sw[0]|x
+ BOTTOM|TOP|h_sw[0]|h_sw[10]|h_sw[1]|h_sw[2]|h_sw[3]|h_sw[4]|h_sw[5]|h_sw[6]|h_sw[7]|h_sw[8]|h_sw[9]|l_sw[0]|l_sw[10]|l_sw[1]|l_sw[2]|l_sw[3]|l_sw[4]|l_sw[5]|l_sw[6]|l_sw[7]|l_sw[8]|l_sw[9]|vc|vdd|vss|z
+ \$1 sg13_lv_nmos L=0.13u W=0.5u AS=0.095p AD=0.095p PS=0.88u PD=0.88u rfmode=0
M$11
+ BOTTOM|TOP|h_sw[0]|h_sw[10]|h_sw[1]|h_sw[2]|h_sw[3]|h_sw[4]|h_sw[5]|h_sw[6]|h_sw[7]|h_sw[8]|h_sw[9]|l_sw[0]|l_sw[10]|l_sw[1]|l_sw[2]|l_sw[3]|l_sw[4]|l_sw[5]|l_sw[6]|l_sw[7]|l_sw[8]|l_sw[9]|vc|vdd|vss|z
+ in_l_sw[0]|x
+ BOTTOM|TOP|h_sw[0]|h_sw[10]|h_sw[1]|h_sw[2]|h_sw[3]|h_sw[4]|h_sw[5]|h_sw[6]|h_sw[7]|h_sw[8]|h_sw[9]|l_sw[0]|l_sw[10]|l_sw[1]|l_sw[2]|l_sw[3]|l_sw[4]|l_sw[5]|l_sw[6]|l_sw[7]|l_sw[8]|l_sw[9]|vc|vdd|vss|z
+ \$1 sg13_lv_nmos L=0.13u W=0.5u AS=0.095p AD=0.095p PS=0.88u PD=0.88u rfmode=0
M$12
+ BOTTOM|TOP|h_sw[0]|h_sw[10]|h_sw[1]|h_sw[2]|h_sw[3]|h_sw[4]|h_sw[5]|h_sw[6]|h_sw[7]|h_sw[8]|h_sw[9]|l_sw[0]|l_sw[10]|l_sw[1]|l_sw[2]|l_sw[3]|l_sw[4]|l_sw[5]|l_sw[6]|l_sw[7]|l_sw[8]|l_sw[9]|vc|vdd|vss|z
+ in_l_sw[0]|x
+ BOTTOM|TOP|h_sw[0]|h_sw[10]|h_sw[1]|h_sw[2]|h_sw[3]|h_sw[4]|h_sw[5]|h_sw[6]|h_sw[7]|h_sw[8]|h_sw[9]|l_sw[0]|l_sw[10]|l_sw[1]|l_sw[2]|l_sw[3]|l_sw[4]|l_sw[5]|l_sw[6]|l_sw[7]|l_sw[8]|l_sw[9]|vc|vdd|vss|z
+ \$1 sg13_lv_nmos L=0.13u W=0.5u AS=0.095p AD=0.095p PS=0.88u PD=0.88u rfmode=0
M$13
+ BOTTOM|TOP|h_sw[0]|h_sw[10]|h_sw[1]|h_sw[2]|h_sw[3]|h_sw[4]|h_sw[5]|h_sw[6]|h_sw[7]|h_sw[8]|h_sw[9]|l_sw[0]|l_sw[10]|l_sw[1]|l_sw[2]|l_sw[3]|l_sw[4]|l_sw[5]|l_sw[6]|l_sw[7]|l_sw[8]|l_sw[9]|vc|vdd|vss|z
+ in_l_sw[0]|x
+ BOTTOM|TOP|h_sw[0]|h_sw[10]|h_sw[1]|h_sw[2]|h_sw[3]|h_sw[4]|h_sw[5]|h_sw[6]|h_sw[7]|h_sw[8]|h_sw[9]|l_sw[0]|l_sw[10]|l_sw[1]|l_sw[2]|l_sw[3]|l_sw[4]|l_sw[5]|l_sw[6]|l_sw[7]|l_sw[8]|l_sw[9]|vc|vdd|vss|z
+ \$1 sg13_lv_nmos L=0.13u W=0.5u AS=0.095p AD=0.095p PS=0.88u PD=0.88u rfmode=0
M$14
+ BOTTOM|TOP|h_sw[0]|h_sw[10]|h_sw[1]|h_sw[2]|h_sw[3]|h_sw[4]|h_sw[5]|h_sw[6]|h_sw[7]|h_sw[8]|h_sw[9]|l_sw[0]|l_sw[10]|l_sw[1]|l_sw[2]|l_sw[3]|l_sw[4]|l_sw[5]|l_sw[6]|l_sw[7]|l_sw[8]|l_sw[9]|vc|vdd|vss|z
+ in_l_sw[0]|x
+ BOTTOM|TOP|h_sw[0]|h_sw[10]|h_sw[1]|h_sw[2]|h_sw[3]|h_sw[4]|h_sw[5]|h_sw[6]|h_sw[7]|h_sw[8]|h_sw[9]|l_sw[0]|l_sw[10]|l_sw[1]|l_sw[2]|l_sw[3]|l_sw[4]|l_sw[5]|l_sw[6]|l_sw[7]|l_sw[8]|l_sw[9]|vc|vdd|vss|z
+ \$1 sg13_lv_nmos L=0.13u W=0.5u AS=0.095p AD=0.095p PS=0.88u PD=0.88u rfmode=0
M$15
+ BOTTOM|TOP|h_sw[0]|h_sw[10]|h_sw[1]|h_sw[2]|h_sw[3]|h_sw[4]|h_sw[5]|h_sw[6]|h_sw[7]|h_sw[8]|h_sw[9]|l_sw[0]|l_sw[10]|l_sw[1]|l_sw[2]|l_sw[3]|l_sw[4]|l_sw[5]|l_sw[6]|l_sw[7]|l_sw[8]|l_sw[9]|vc|vdd|vss|z
+ in_l_sw[0]|x
+ BOTTOM|TOP|h_sw[0]|h_sw[10]|h_sw[1]|h_sw[2]|h_sw[3]|h_sw[4]|h_sw[5]|h_sw[6]|h_sw[7]|h_sw[8]|h_sw[9]|l_sw[0]|l_sw[10]|l_sw[1]|l_sw[2]|l_sw[3]|l_sw[4]|l_sw[5]|l_sw[6]|l_sw[7]|l_sw[8]|l_sw[9]|vc|vdd|vss|z
+ \$1 sg13_lv_nmos L=0.13u W=0.5u AS=0.095p AD=0.095p PS=0.88u PD=0.88u rfmode=0
M$16
+ BOTTOM|TOP|h_sw[0]|h_sw[10]|h_sw[1]|h_sw[2]|h_sw[3]|h_sw[4]|h_sw[5]|h_sw[6]|h_sw[7]|h_sw[8]|h_sw[9]|l_sw[0]|l_sw[10]|l_sw[1]|l_sw[2]|l_sw[3]|l_sw[4]|l_sw[5]|l_sw[6]|l_sw[7]|l_sw[8]|l_sw[9]|vc|vdd|vss|z
+ in_l_sw[0]|x
+ BOTTOM|TOP|h_sw[0]|h_sw[10]|h_sw[1]|h_sw[2]|h_sw[3]|h_sw[4]|h_sw[5]|h_sw[6]|h_sw[7]|h_sw[8]|h_sw[9]|l_sw[0]|l_sw[10]|l_sw[1]|l_sw[2]|l_sw[3]|l_sw[4]|l_sw[5]|l_sw[6]|l_sw[7]|l_sw[8]|l_sw[9]|vc|vdd|vss|z
+ \$1 sg13_lv_nmos L=0.13u W=0.5u AS=0.095p AD=0.095p PS=0.88u PD=0.88u rfmode=0
M$17
+ BOTTOM|TOP|h_sw[0]|h_sw[10]|h_sw[1]|h_sw[2]|h_sw[3]|h_sw[4]|h_sw[5]|h_sw[6]|h_sw[7]|h_sw[8]|h_sw[9]|l_sw[0]|l_sw[10]|l_sw[1]|l_sw[2]|l_sw[3]|l_sw[4]|l_sw[5]|l_sw[6]|l_sw[7]|l_sw[8]|l_sw[9]|vc|vdd|vss|z
+ in_l_sw[0]|x
+ BOTTOM|TOP|h_sw[0]|h_sw[10]|h_sw[1]|h_sw[2]|h_sw[3]|h_sw[4]|h_sw[5]|h_sw[6]|h_sw[7]|h_sw[8]|h_sw[9]|l_sw[0]|l_sw[10]|l_sw[1]|l_sw[2]|l_sw[3]|l_sw[4]|l_sw[5]|l_sw[6]|l_sw[7]|l_sw[8]|l_sw[9]|vc|vdd|vss|z
+ \$1 sg13_lv_nmos L=0.13u W=0.5u AS=0.095p AD=0.095p PS=0.88u PD=0.88u rfmode=0
M$18
+ BOTTOM|TOP|h_sw[0]|h_sw[10]|h_sw[1]|h_sw[2]|h_sw[3]|h_sw[4]|h_sw[5]|h_sw[6]|h_sw[7]|h_sw[8]|h_sw[9]|l_sw[0]|l_sw[10]|l_sw[1]|l_sw[2]|l_sw[3]|l_sw[4]|l_sw[5]|l_sw[6]|l_sw[7]|l_sw[8]|l_sw[9]|vc|vdd|vss|z
+ in_l_sw[0]|x
+ BOTTOM|TOP|h_sw[0]|h_sw[10]|h_sw[1]|h_sw[2]|h_sw[3]|h_sw[4]|h_sw[5]|h_sw[6]|h_sw[7]|h_sw[8]|h_sw[9]|l_sw[0]|l_sw[10]|l_sw[1]|l_sw[2]|l_sw[3]|l_sw[4]|l_sw[5]|l_sw[6]|l_sw[7]|l_sw[8]|l_sw[9]|vc|vdd|vss|z
+ \$1 sg13_lv_nmos L=0.13u W=0.5u AS=0.095p AD=0.095p PS=0.88u PD=0.88u rfmode=0
M$19
+ BOTTOM|TOP|h_sw[0]|h_sw[10]|h_sw[1]|h_sw[2]|h_sw[3]|h_sw[4]|h_sw[5]|h_sw[6]|h_sw[7]|h_sw[8]|h_sw[9]|l_sw[0]|l_sw[10]|l_sw[1]|l_sw[2]|l_sw[3]|l_sw[4]|l_sw[5]|l_sw[6]|l_sw[7]|l_sw[8]|l_sw[9]|vc|vdd|vss|z
+ in_l_sw[0]|x
+ BOTTOM|TOP|h_sw[0]|h_sw[10]|h_sw[1]|h_sw[2]|h_sw[3]|h_sw[4]|h_sw[5]|h_sw[6]|h_sw[7]|h_sw[8]|h_sw[9]|l_sw[0]|l_sw[10]|l_sw[1]|l_sw[2]|l_sw[3]|l_sw[4]|l_sw[5]|l_sw[6]|l_sw[7]|l_sw[8]|l_sw[9]|vc|vdd|vss|z
+ \$1 sg13_lv_nmos L=0.13u W=0.5u AS=0.095p AD=0.095p PS=0.88u PD=0.88u rfmode=0
M$20
+ BOTTOM|TOP|h_sw[0]|h_sw[10]|h_sw[1]|h_sw[2]|h_sw[3]|h_sw[4]|h_sw[5]|h_sw[6]|h_sw[7]|h_sw[8]|h_sw[9]|l_sw[0]|l_sw[10]|l_sw[1]|l_sw[2]|l_sw[3]|l_sw[4]|l_sw[5]|l_sw[6]|l_sw[7]|l_sw[8]|l_sw[9]|vc|vdd|vss|z
+ in_l_sw[0]|x
+ BOTTOM|TOP|h_sw[0]|h_sw[10]|h_sw[1]|h_sw[2]|h_sw[3]|h_sw[4]|h_sw[5]|h_sw[6]|h_sw[7]|h_sw[8]|h_sw[9]|l_sw[0]|l_sw[10]|l_sw[1]|l_sw[2]|l_sw[3]|l_sw[4]|l_sw[5]|l_sw[6]|l_sw[7]|l_sw[8]|l_sw[9]|vc|vdd|vss|z
+ \$1 sg13_lv_nmos L=0.13u W=0.5u AS=0.095p AD=0.095p PS=0.88u PD=0.88u rfmode=0
M$21
+ BOTTOM|TOP|h_sw[0]|h_sw[10]|h_sw[1]|h_sw[2]|h_sw[3]|h_sw[4]|h_sw[5]|h_sw[6]|h_sw[7]|h_sw[8]|h_sw[9]|l_sw[0]|l_sw[10]|l_sw[1]|l_sw[2]|l_sw[3]|l_sw[4]|l_sw[5]|l_sw[6]|l_sw[7]|l_sw[8]|l_sw[9]|vc|vdd|vss|z
+ in_l_sw[0]|x
+ BOTTOM|TOP|h_sw[0]|h_sw[10]|h_sw[1]|h_sw[2]|h_sw[3]|h_sw[4]|h_sw[5]|h_sw[6]|h_sw[7]|h_sw[8]|h_sw[9]|l_sw[0]|l_sw[10]|l_sw[1]|l_sw[2]|l_sw[3]|l_sw[4]|l_sw[5]|l_sw[6]|l_sw[7]|l_sw[8]|l_sw[9]|vc|vdd|vss|z
+ \$1 sg13_lv_nmos L=0.13u W=0.5u AS=0.095p AD=0.095p PS=0.88u PD=0.88u rfmode=0
M$22
+ BOTTOM|TOP|h_sw[0]|h_sw[10]|h_sw[1]|h_sw[2]|h_sw[3]|h_sw[4]|h_sw[5]|h_sw[6]|h_sw[7]|h_sw[8]|h_sw[9]|l_sw[0]|l_sw[10]|l_sw[1]|l_sw[2]|l_sw[3]|l_sw[4]|l_sw[5]|l_sw[6]|l_sw[7]|l_sw[8]|l_sw[9]|vc|vdd|vss|z
+ in_l_sw[0]|x
+ BOTTOM|TOP|h_sw[0]|h_sw[10]|h_sw[1]|h_sw[2]|h_sw[3]|h_sw[4]|h_sw[5]|h_sw[6]|h_sw[7]|h_sw[8]|h_sw[9]|l_sw[0]|l_sw[10]|l_sw[1]|l_sw[2]|l_sw[3]|l_sw[4]|l_sw[5]|l_sw[6]|l_sw[7]|l_sw[8]|l_sw[9]|vc|vdd|vss|z
+ \$1 sg13_lv_nmos L=0.13u W=0.5u AS=0.095p AD=0.095p PS=0.88u PD=0.88u rfmode=0
M$23
+ BOTTOM|TOP|h_sw[0]|h_sw[10]|h_sw[1]|h_sw[2]|h_sw[3]|h_sw[4]|h_sw[5]|h_sw[6]|h_sw[7]|h_sw[8]|h_sw[9]|l_sw[0]|l_sw[10]|l_sw[1]|l_sw[2]|l_sw[3]|l_sw[4]|l_sw[5]|l_sw[6]|l_sw[7]|l_sw[8]|l_sw[9]|vc|vdd|vss|z
+ in_l_sw[0]|x
+ BOTTOM|TOP|h_sw[0]|h_sw[10]|h_sw[1]|h_sw[2]|h_sw[3]|h_sw[4]|h_sw[5]|h_sw[6]|h_sw[7]|h_sw[8]|h_sw[9]|l_sw[0]|l_sw[10]|l_sw[1]|l_sw[2]|l_sw[3]|l_sw[4]|l_sw[5]|l_sw[6]|l_sw[7]|l_sw[8]|l_sw[9]|vc|vdd|vss|z
+ \$1 sg13_lv_nmos L=0.13u W=0.5u AS=0.095p AD=0.095p PS=0.88u PD=0.88u rfmode=0
M$24
+ BOTTOM|TOP|h_sw[0]|h_sw[10]|h_sw[1]|h_sw[2]|h_sw[3]|h_sw[4]|h_sw[5]|h_sw[6]|h_sw[7]|h_sw[8]|h_sw[9]|l_sw[0]|l_sw[10]|l_sw[1]|l_sw[2]|l_sw[3]|l_sw[4]|l_sw[5]|l_sw[6]|l_sw[7]|l_sw[8]|l_sw[9]|vc|vdd|vss|z
+ in_l_sw[0]|x
+ BOTTOM|TOP|h_sw[0]|h_sw[10]|h_sw[1]|h_sw[2]|h_sw[3]|h_sw[4]|h_sw[5]|h_sw[6]|h_sw[7]|h_sw[8]|h_sw[9]|l_sw[0]|l_sw[10]|l_sw[1]|l_sw[2]|l_sw[3]|l_sw[4]|l_sw[5]|l_sw[6]|l_sw[7]|l_sw[8]|l_sw[9]|vc|vdd|vss|z
+ \$1 sg13_lv_nmos L=0.13u W=0.5u AS=0.095p AD=0.095p PS=0.88u PD=0.88u rfmode=0
M$25
+ BOTTOM|TOP|h_sw[0]|h_sw[10]|h_sw[1]|h_sw[2]|h_sw[3]|h_sw[4]|h_sw[5]|h_sw[6]|h_sw[7]|h_sw[8]|h_sw[9]|l_sw[0]|l_sw[10]|l_sw[1]|l_sw[2]|l_sw[3]|l_sw[4]|l_sw[5]|l_sw[6]|l_sw[7]|l_sw[8]|l_sw[9]|vc|vdd|vss|z
+ in_l_sw[0]|x
+ BOTTOM|TOP|h_sw[0]|h_sw[10]|h_sw[1]|h_sw[2]|h_sw[3]|h_sw[4]|h_sw[5]|h_sw[6]|h_sw[7]|h_sw[8]|h_sw[9]|l_sw[0]|l_sw[10]|l_sw[1]|l_sw[2]|l_sw[3]|l_sw[4]|l_sw[5]|l_sw[6]|l_sw[7]|l_sw[8]|l_sw[9]|vc|vdd|vss|z
+ \$1 sg13_lv_nmos L=0.13u W=0.5u AS=0.095p AD=0.095p PS=0.88u PD=0.88u rfmode=0
M$26
+ BOTTOM|TOP|h_sw[0]|h_sw[10]|h_sw[1]|h_sw[2]|h_sw[3]|h_sw[4]|h_sw[5]|h_sw[6]|h_sw[7]|h_sw[8]|h_sw[9]|l_sw[0]|l_sw[10]|l_sw[1]|l_sw[2]|l_sw[3]|l_sw[4]|l_sw[5]|l_sw[6]|l_sw[7]|l_sw[8]|l_sw[9]|vc|vdd|vss|z
+ in_l_sw[0]|x
+ BOTTOM|TOP|h_sw[0]|h_sw[10]|h_sw[1]|h_sw[2]|h_sw[3]|h_sw[4]|h_sw[5]|h_sw[6]|h_sw[7]|h_sw[8]|h_sw[9]|l_sw[0]|l_sw[10]|l_sw[1]|l_sw[2]|l_sw[3]|l_sw[4]|l_sw[5]|l_sw[6]|l_sw[7]|l_sw[8]|l_sw[9]|vc|vdd|vss|z
+ \$1 sg13_lv_nmos L=0.13u W=0.5u AS=0.095p AD=0.095p PS=0.88u PD=0.88u rfmode=0
M$27
+ BOTTOM|TOP|h_sw[0]|h_sw[10]|h_sw[1]|h_sw[2]|h_sw[3]|h_sw[4]|h_sw[5]|h_sw[6]|h_sw[7]|h_sw[8]|h_sw[9]|l_sw[0]|l_sw[10]|l_sw[1]|l_sw[2]|l_sw[3]|l_sw[4]|l_sw[5]|l_sw[6]|l_sw[7]|l_sw[8]|l_sw[9]|vc|vdd|vss|z
+ in_l_sw[0]|x
+ BOTTOM|TOP|h_sw[0]|h_sw[10]|h_sw[1]|h_sw[2]|h_sw[3]|h_sw[4]|h_sw[5]|h_sw[6]|h_sw[7]|h_sw[8]|h_sw[9]|l_sw[0]|l_sw[10]|l_sw[1]|l_sw[2]|l_sw[3]|l_sw[4]|l_sw[5]|l_sw[6]|l_sw[7]|l_sw[8]|l_sw[9]|vc|vdd|vss|z
+ \$1 sg13_lv_nmos L=0.13u W=0.5u AS=0.095p AD=0.095p PS=0.88u PD=0.88u rfmode=0
M$28
+ BOTTOM|TOP|h_sw[0]|h_sw[10]|h_sw[1]|h_sw[2]|h_sw[3]|h_sw[4]|h_sw[5]|h_sw[6]|h_sw[7]|h_sw[8]|h_sw[9]|l_sw[0]|l_sw[10]|l_sw[1]|l_sw[2]|l_sw[3]|l_sw[4]|l_sw[5]|l_sw[6]|l_sw[7]|l_sw[8]|l_sw[9]|vc|vdd|vss|z
+ in_l_sw[0]|x
+ BOTTOM|TOP|h_sw[0]|h_sw[10]|h_sw[1]|h_sw[2]|h_sw[3]|h_sw[4]|h_sw[5]|h_sw[6]|h_sw[7]|h_sw[8]|h_sw[9]|l_sw[0]|l_sw[10]|l_sw[1]|l_sw[2]|l_sw[3]|l_sw[4]|l_sw[5]|l_sw[6]|l_sw[7]|l_sw[8]|l_sw[9]|vc|vdd|vss|z
+ \$1 sg13_lv_nmos L=0.13u W=0.5u AS=0.095p AD=0.095p PS=0.88u PD=0.88u rfmode=0
M$29
+ BOTTOM|TOP|h_sw[0]|h_sw[10]|h_sw[1]|h_sw[2]|h_sw[3]|h_sw[4]|h_sw[5]|h_sw[6]|h_sw[7]|h_sw[8]|h_sw[9]|l_sw[0]|l_sw[10]|l_sw[1]|l_sw[2]|l_sw[3]|l_sw[4]|l_sw[5]|l_sw[6]|l_sw[7]|l_sw[8]|l_sw[9]|vc|vdd|vss|z
+ in_l_sw[0]|x
+ BOTTOM|TOP|h_sw[0]|h_sw[10]|h_sw[1]|h_sw[2]|h_sw[3]|h_sw[4]|h_sw[5]|h_sw[6]|h_sw[7]|h_sw[8]|h_sw[9]|l_sw[0]|l_sw[10]|l_sw[1]|l_sw[2]|l_sw[3]|l_sw[4]|l_sw[5]|l_sw[6]|l_sw[7]|l_sw[8]|l_sw[9]|vc|vdd|vss|z
+ \$1 sg13_lv_nmos L=0.13u W=0.5u AS=0.095p AD=0.095p PS=0.88u PD=0.88u rfmode=0
M$30
+ BOTTOM|TOP|h_sw[0]|h_sw[10]|h_sw[1]|h_sw[2]|h_sw[3]|h_sw[4]|h_sw[5]|h_sw[6]|h_sw[7]|h_sw[8]|h_sw[9]|l_sw[0]|l_sw[10]|l_sw[1]|l_sw[2]|l_sw[3]|l_sw[4]|l_sw[5]|l_sw[6]|l_sw[7]|l_sw[8]|l_sw[9]|vc|vdd|vss|z
+ in_l_sw[0]|x
+ BOTTOM|TOP|h_sw[0]|h_sw[10]|h_sw[1]|h_sw[2]|h_sw[3]|h_sw[4]|h_sw[5]|h_sw[6]|h_sw[7]|h_sw[8]|h_sw[9]|l_sw[0]|l_sw[10]|l_sw[1]|l_sw[2]|l_sw[3]|l_sw[4]|l_sw[5]|l_sw[6]|l_sw[7]|l_sw[8]|l_sw[9]|vc|vdd|vss|z
+ \$1 sg13_lv_nmos L=0.13u W=0.5u AS=0.095p AD=0.095p PS=0.88u PD=0.88u rfmode=0
M$31
+ BOTTOM|TOP|h_sw[0]|h_sw[10]|h_sw[1]|h_sw[2]|h_sw[3]|h_sw[4]|h_sw[5]|h_sw[6]|h_sw[7]|h_sw[8]|h_sw[9]|l_sw[0]|l_sw[10]|l_sw[1]|l_sw[2]|l_sw[3]|l_sw[4]|l_sw[5]|l_sw[6]|l_sw[7]|l_sw[8]|l_sw[9]|vc|vdd|vss|z
+ in_l_sw[0]|x
+ BOTTOM|TOP|h_sw[0]|h_sw[10]|h_sw[1]|h_sw[2]|h_sw[3]|h_sw[4]|h_sw[5]|h_sw[6]|h_sw[7]|h_sw[8]|h_sw[9]|l_sw[0]|l_sw[10]|l_sw[1]|l_sw[2]|l_sw[3]|l_sw[4]|l_sw[5]|l_sw[6]|l_sw[7]|l_sw[8]|l_sw[9]|vc|vdd|vss|z
+ \$1 sg13_lv_nmos L=0.13u W=0.5u AS=0.095p AD=0.095p PS=0.88u PD=0.88u rfmode=0
M$32
+ BOTTOM|TOP|h_sw[0]|h_sw[10]|h_sw[1]|h_sw[2]|h_sw[3]|h_sw[4]|h_sw[5]|h_sw[6]|h_sw[7]|h_sw[8]|h_sw[9]|l_sw[0]|l_sw[10]|l_sw[1]|l_sw[2]|l_sw[3]|l_sw[4]|l_sw[5]|l_sw[6]|l_sw[7]|l_sw[8]|l_sw[9]|vc|vdd|vss|z
+ in_l_sw[0]|x
+ BOTTOM|TOP|h_sw[0]|h_sw[10]|h_sw[1]|h_sw[2]|h_sw[3]|h_sw[4]|h_sw[5]|h_sw[6]|h_sw[7]|h_sw[8]|h_sw[9]|l_sw[0]|l_sw[10]|l_sw[1]|l_sw[2]|l_sw[3]|l_sw[4]|l_sw[5]|l_sw[6]|l_sw[7]|l_sw[8]|l_sw[9]|vc|vdd|vss|z
+ \$1 sg13_lv_nmos L=0.13u W=0.5u AS=0.095p AD=0.17p PS=0.88u PD=1.68u rfmode=0
M$33
+ BOTTOM|TOP|h_sw[0]|h_sw[10]|h_sw[1]|h_sw[2]|h_sw[3]|h_sw[4]|h_sw[5]|h_sw[6]|h_sw[7]|h_sw[8]|h_sw[9]|l_sw[0]|l_sw[10]|l_sw[1]|l_sw[2]|l_sw[3]|l_sw[4]|l_sw[5]|l_sw[6]|l_sw[7]|l_sw[8]|l_sw[9]|vc|vdd|vss|z
+ in_h_sw[0]|x
+ BOTTOM|TOP|h_sw[0]|h_sw[10]|h_sw[1]|h_sw[2]|h_sw[3]|h_sw[4]|h_sw[5]|h_sw[6]|h_sw[7]|h_sw[8]|h_sw[9]|l_sw[0]|l_sw[10]|l_sw[1]|l_sw[2]|l_sw[3]|l_sw[4]|l_sw[5]|l_sw[6]|l_sw[7]|l_sw[8]|l_sw[9]|vc|vdd|vss|z
+ \$1 sg13_lv_nmos L=0.13u W=0.5u AS=0.17p AD=0.095p PS=1.68u PD=0.88u rfmode=0
M$34
+ BOTTOM|TOP|h_sw[0]|h_sw[10]|h_sw[1]|h_sw[2]|h_sw[3]|h_sw[4]|h_sw[5]|h_sw[6]|h_sw[7]|h_sw[8]|h_sw[9]|l_sw[0]|l_sw[10]|l_sw[1]|l_sw[2]|l_sw[3]|l_sw[4]|l_sw[5]|l_sw[6]|l_sw[7]|l_sw[8]|l_sw[9]|vc|vdd|vss|z
+ in_h_sw[0]|x
+ BOTTOM|TOP|h_sw[0]|h_sw[10]|h_sw[1]|h_sw[2]|h_sw[3]|h_sw[4]|h_sw[5]|h_sw[6]|h_sw[7]|h_sw[8]|h_sw[9]|l_sw[0]|l_sw[10]|l_sw[1]|l_sw[2]|l_sw[3]|l_sw[4]|l_sw[5]|l_sw[6]|l_sw[7]|l_sw[8]|l_sw[9]|vc|vdd|vss|z
+ \$1 sg13_lv_nmos L=0.13u W=0.5u AS=0.095p AD=0.095p PS=0.88u PD=0.88u rfmode=0
M$35
+ BOTTOM|TOP|h_sw[0]|h_sw[10]|h_sw[1]|h_sw[2]|h_sw[3]|h_sw[4]|h_sw[5]|h_sw[6]|h_sw[7]|h_sw[8]|h_sw[9]|l_sw[0]|l_sw[10]|l_sw[1]|l_sw[2]|l_sw[3]|l_sw[4]|l_sw[5]|l_sw[6]|l_sw[7]|l_sw[8]|l_sw[9]|vc|vdd|vss|z
+ in_h_sw[0]|x
+ BOTTOM|TOP|h_sw[0]|h_sw[10]|h_sw[1]|h_sw[2]|h_sw[3]|h_sw[4]|h_sw[5]|h_sw[6]|h_sw[7]|h_sw[8]|h_sw[9]|l_sw[0]|l_sw[10]|l_sw[1]|l_sw[2]|l_sw[3]|l_sw[4]|l_sw[5]|l_sw[6]|l_sw[7]|l_sw[8]|l_sw[9]|vc|vdd|vss|z
+ \$1 sg13_lv_nmos L=0.13u W=0.5u AS=0.095p AD=0.095p PS=0.88u PD=0.88u rfmode=0
M$36
+ BOTTOM|TOP|h_sw[0]|h_sw[10]|h_sw[1]|h_sw[2]|h_sw[3]|h_sw[4]|h_sw[5]|h_sw[6]|h_sw[7]|h_sw[8]|h_sw[9]|l_sw[0]|l_sw[10]|l_sw[1]|l_sw[2]|l_sw[3]|l_sw[4]|l_sw[5]|l_sw[6]|l_sw[7]|l_sw[8]|l_sw[9]|vc|vdd|vss|z
+ in_h_sw[0]|x
+ BOTTOM|TOP|h_sw[0]|h_sw[10]|h_sw[1]|h_sw[2]|h_sw[3]|h_sw[4]|h_sw[5]|h_sw[6]|h_sw[7]|h_sw[8]|h_sw[9]|l_sw[0]|l_sw[10]|l_sw[1]|l_sw[2]|l_sw[3]|l_sw[4]|l_sw[5]|l_sw[6]|l_sw[7]|l_sw[8]|l_sw[9]|vc|vdd|vss|z
+ \$1 sg13_lv_nmos L=0.13u W=0.5u AS=0.095p AD=0.095p PS=0.88u PD=0.88u rfmode=0
M$37
+ BOTTOM|TOP|h_sw[0]|h_sw[10]|h_sw[1]|h_sw[2]|h_sw[3]|h_sw[4]|h_sw[5]|h_sw[6]|h_sw[7]|h_sw[8]|h_sw[9]|l_sw[0]|l_sw[10]|l_sw[1]|l_sw[2]|l_sw[3]|l_sw[4]|l_sw[5]|l_sw[6]|l_sw[7]|l_sw[8]|l_sw[9]|vc|vdd|vss|z
+ in_h_sw[0]|x
+ BOTTOM|TOP|h_sw[0]|h_sw[10]|h_sw[1]|h_sw[2]|h_sw[3]|h_sw[4]|h_sw[5]|h_sw[6]|h_sw[7]|h_sw[8]|h_sw[9]|l_sw[0]|l_sw[10]|l_sw[1]|l_sw[2]|l_sw[3]|l_sw[4]|l_sw[5]|l_sw[6]|l_sw[7]|l_sw[8]|l_sw[9]|vc|vdd|vss|z
+ \$1 sg13_lv_nmos L=0.13u W=0.5u AS=0.095p AD=0.095p PS=0.88u PD=0.88u rfmode=0
M$38
+ BOTTOM|TOP|h_sw[0]|h_sw[10]|h_sw[1]|h_sw[2]|h_sw[3]|h_sw[4]|h_sw[5]|h_sw[6]|h_sw[7]|h_sw[8]|h_sw[9]|l_sw[0]|l_sw[10]|l_sw[1]|l_sw[2]|l_sw[3]|l_sw[4]|l_sw[5]|l_sw[6]|l_sw[7]|l_sw[8]|l_sw[9]|vc|vdd|vss|z
+ in_h_sw[0]|x
+ BOTTOM|TOP|h_sw[0]|h_sw[10]|h_sw[1]|h_sw[2]|h_sw[3]|h_sw[4]|h_sw[5]|h_sw[6]|h_sw[7]|h_sw[8]|h_sw[9]|l_sw[0]|l_sw[10]|l_sw[1]|l_sw[2]|l_sw[3]|l_sw[4]|l_sw[5]|l_sw[6]|l_sw[7]|l_sw[8]|l_sw[9]|vc|vdd|vss|z
+ \$1 sg13_lv_nmos L=0.13u W=0.5u AS=0.095p AD=0.095p PS=0.88u PD=0.88u rfmode=0
M$39
+ BOTTOM|TOP|h_sw[0]|h_sw[10]|h_sw[1]|h_sw[2]|h_sw[3]|h_sw[4]|h_sw[5]|h_sw[6]|h_sw[7]|h_sw[8]|h_sw[9]|l_sw[0]|l_sw[10]|l_sw[1]|l_sw[2]|l_sw[3]|l_sw[4]|l_sw[5]|l_sw[6]|l_sw[7]|l_sw[8]|l_sw[9]|vc|vdd|vss|z
+ in_h_sw[0]|x
+ BOTTOM|TOP|h_sw[0]|h_sw[10]|h_sw[1]|h_sw[2]|h_sw[3]|h_sw[4]|h_sw[5]|h_sw[6]|h_sw[7]|h_sw[8]|h_sw[9]|l_sw[0]|l_sw[10]|l_sw[1]|l_sw[2]|l_sw[3]|l_sw[4]|l_sw[5]|l_sw[6]|l_sw[7]|l_sw[8]|l_sw[9]|vc|vdd|vss|z
+ \$1 sg13_lv_nmos L=0.13u W=0.5u AS=0.095p AD=0.095p PS=0.88u PD=0.88u rfmode=0
M$40
+ BOTTOM|TOP|h_sw[0]|h_sw[10]|h_sw[1]|h_sw[2]|h_sw[3]|h_sw[4]|h_sw[5]|h_sw[6]|h_sw[7]|h_sw[8]|h_sw[9]|l_sw[0]|l_sw[10]|l_sw[1]|l_sw[2]|l_sw[3]|l_sw[4]|l_sw[5]|l_sw[6]|l_sw[7]|l_sw[8]|l_sw[9]|vc|vdd|vss|z
+ in_h_sw[0]|x
+ BOTTOM|TOP|h_sw[0]|h_sw[10]|h_sw[1]|h_sw[2]|h_sw[3]|h_sw[4]|h_sw[5]|h_sw[6]|h_sw[7]|h_sw[8]|h_sw[9]|l_sw[0]|l_sw[10]|l_sw[1]|l_sw[2]|l_sw[3]|l_sw[4]|l_sw[5]|l_sw[6]|l_sw[7]|l_sw[8]|l_sw[9]|vc|vdd|vss|z
+ \$1 sg13_lv_nmos L=0.13u W=0.5u AS=0.095p AD=0.095p PS=0.88u PD=0.88u rfmode=0
M$41
+ BOTTOM|TOP|h_sw[0]|h_sw[10]|h_sw[1]|h_sw[2]|h_sw[3]|h_sw[4]|h_sw[5]|h_sw[6]|h_sw[7]|h_sw[8]|h_sw[9]|l_sw[0]|l_sw[10]|l_sw[1]|l_sw[2]|l_sw[3]|l_sw[4]|l_sw[5]|l_sw[6]|l_sw[7]|l_sw[8]|l_sw[9]|vc|vdd|vss|z
+ in_h_sw[0]|x
+ BOTTOM|TOP|h_sw[0]|h_sw[10]|h_sw[1]|h_sw[2]|h_sw[3]|h_sw[4]|h_sw[5]|h_sw[6]|h_sw[7]|h_sw[8]|h_sw[9]|l_sw[0]|l_sw[10]|l_sw[1]|l_sw[2]|l_sw[3]|l_sw[4]|l_sw[5]|l_sw[6]|l_sw[7]|l_sw[8]|l_sw[9]|vc|vdd|vss|z
+ \$1 sg13_lv_nmos L=0.13u W=0.5u AS=0.095p AD=0.095p PS=0.88u PD=0.88u rfmode=0
M$42
+ BOTTOM|TOP|h_sw[0]|h_sw[10]|h_sw[1]|h_sw[2]|h_sw[3]|h_sw[4]|h_sw[5]|h_sw[6]|h_sw[7]|h_sw[8]|h_sw[9]|l_sw[0]|l_sw[10]|l_sw[1]|l_sw[2]|l_sw[3]|l_sw[4]|l_sw[5]|l_sw[6]|l_sw[7]|l_sw[8]|l_sw[9]|vc|vdd|vss|z
+ in_h_sw[0]|x
+ BOTTOM|TOP|h_sw[0]|h_sw[10]|h_sw[1]|h_sw[2]|h_sw[3]|h_sw[4]|h_sw[5]|h_sw[6]|h_sw[7]|h_sw[8]|h_sw[9]|l_sw[0]|l_sw[10]|l_sw[1]|l_sw[2]|l_sw[3]|l_sw[4]|l_sw[5]|l_sw[6]|l_sw[7]|l_sw[8]|l_sw[9]|vc|vdd|vss|z
+ \$1 sg13_lv_nmos L=0.13u W=0.5u AS=0.095p AD=0.095p PS=0.88u PD=0.88u rfmode=0
M$43
+ BOTTOM|TOP|h_sw[0]|h_sw[10]|h_sw[1]|h_sw[2]|h_sw[3]|h_sw[4]|h_sw[5]|h_sw[6]|h_sw[7]|h_sw[8]|h_sw[9]|l_sw[0]|l_sw[10]|l_sw[1]|l_sw[2]|l_sw[3]|l_sw[4]|l_sw[5]|l_sw[6]|l_sw[7]|l_sw[8]|l_sw[9]|vc|vdd|vss|z
+ in_h_sw[0]|x
+ BOTTOM|TOP|h_sw[0]|h_sw[10]|h_sw[1]|h_sw[2]|h_sw[3]|h_sw[4]|h_sw[5]|h_sw[6]|h_sw[7]|h_sw[8]|h_sw[9]|l_sw[0]|l_sw[10]|l_sw[1]|l_sw[2]|l_sw[3]|l_sw[4]|l_sw[5]|l_sw[6]|l_sw[7]|l_sw[8]|l_sw[9]|vc|vdd|vss|z
+ \$1 sg13_lv_nmos L=0.13u W=0.5u AS=0.095p AD=0.095p PS=0.88u PD=0.88u rfmode=0
M$44
+ BOTTOM|TOP|h_sw[0]|h_sw[10]|h_sw[1]|h_sw[2]|h_sw[3]|h_sw[4]|h_sw[5]|h_sw[6]|h_sw[7]|h_sw[8]|h_sw[9]|l_sw[0]|l_sw[10]|l_sw[1]|l_sw[2]|l_sw[3]|l_sw[4]|l_sw[5]|l_sw[6]|l_sw[7]|l_sw[8]|l_sw[9]|vc|vdd|vss|z
+ in_h_sw[0]|x
+ BOTTOM|TOP|h_sw[0]|h_sw[10]|h_sw[1]|h_sw[2]|h_sw[3]|h_sw[4]|h_sw[5]|h_sw[6]|h_sw[7]|h_sw[8]|h_sw[9]|l_sw[0]|l_sw[10]|l_sw[1]|l_sw[2]|l_sw[3]|l_sw[4]|l_sw[5]|l_sw[6]|l_sw[7]|l_sw[8]|l_sw[9]|vc|vdd|vss|z
+ \$1 sg13_lv_nmos L=0.13u W=0.5u AS=0.095p AD=0.095p PS=0.88u PD=0.88u rfmode=0
M$45
+ BOTTOM|TOP|h_sw[0]|h_sw[10]|h_sw[1]|h_sw[2]|h_sw[3]|h_sw[4]|h_sw[5]|h_sw[6]|h_sw[7]|h_sw[8]|h_sw[9]|l_sw[0]|l_sw[10]|l_sw[1]|l_sw[2]|l_sw[3]|l_sw[4]|l_sw[5]|l_sw[6]|l_sw[7]|l_sw[8]|l_sw[9]|vc|vdd|vss|z
+ in_h_sw[0]|x
+ BOTTOM|TOP|h_sw[0]|h_sw[10]|h_sw[1]|h_sw[2]|h_sw[3]|h_sw[4]|h_sw[5]|h_sw[6]|h_sw[7]|h_sw[8]|h_sw[9]|l_sw[0]|l_sw[10]|l_sw[1]|l_sw[2]|l_sw[3]|l_sw[4]|l_sw[5]|l_sw[6]|l_sw[7]|l_sw[8]|l_sw[9]|vc|vdd|vss|z
+ \$1 sg13_lv_nmos L=0.13u W=0.5u AS=0.095p AD=0.095p PS=0.88u PD=0.88u rfmode=0
M$46
+ BOTTOM|TOP|h_sw[0]|h_sw[10]|h_sw[1]|h_sw[2]|h_sw[3]|h_sw[4]|h_sw[5]|h_sw[6]|h_sw[7]|h_sw[8]|h_sw[9]|l_sw[0]|l_sw[10]|l_sw[1]|l_sw[2]|l_sw[3]|l_sw[4]|l_sw[5]|l_sw[6]|l_sw[7]|l_sw[8]|l_sw[9]|vc|vdd|vss|z
+ in_h_sw[0]|x
+ BOTTOM|TOP|h_sw[0]|h_sw[10]|h_sw[1]|h_sw[2]|h_sw[3]|h_sw[4]|h_sw[5]|h_sw[6]|h_sw[7]|h_sw[8]|h_sw[9]|l_sw[0]|l_sw[10]|l_sw[1]|l_sw[2]|l_sw[3]|l_sw[4]|l_sw[5]|l_sw[6]|l_sw[7]|l_sw[8]|l_sw[9]|vc|vdd|vss|z
+ \$1 sg13_lv_nmos L=0.13u W=0.5u AS=0.095p AD=0.095p PS=0.88u PD=0.88u rfmode=0
M$47
+ BOTTOM|TOP|h_sw[0]|h_sw[10]|h_sw[1]|h_sw[2]|h_sw[3]|h_sw[4]|h_sw[5]|h_sw[6]|h_sw[7]|h_sw[8]|h_sw[9]|l_sw[0]|l_sw[10]|l_sw[1]|l_sw[2]|l_sw[3]|l_sw[4]|l_sw[5]|l_sw[6]|l_sw[7]|l_sw[8]|l_sw[9]|vc|vdd|vss|z
+ in_h_sw[0]|x
+ BOTTOM|TOP|h_sw[0]|h_sw[10]|h_sw[1]|h_sw[2]|h_sw[3]|h_sw[4]|h_sw[5]|h_sw[6]|h_sw[7]|h_sw[8]|h_sw[9]|l_sw[0]|l_sw[10]|l_sw[1]|l_sw[2]|l_sw[3]|l_sw[4]|l_sw[5]|l_sw[6]|l_sw[7]|l_sw[8]|l_sw[9]|vc|vdd|vss|z
+ \$1 sg13_lv_nmos L=0.13u W=0.5u AS=0.095p AD=0.095p PS=0.88u PD=0.88u rfmode=0
M$48
+ BOTTOM|TOP|h_sw[0]|h_sw[10]|h_sw[1]|h_sw[2]|h_sw[3]|h_sw[4]|h_sw[5]|h_sw[6]|h_sw[7]|h_sw[8]|h_sw[9]|l_sw[0]|l_sw[10]|l_sw[1]|l_sw[2]|l_sw[3]|l_sw[4]|l_sw[5]|l_sw[6]|l_sw[7]|l_sw[8]|l_sw[9]|vc|vdd|vss|z
+ in_h_sw[0]|x
+ BOTTOM|TOP|h_sw[0]|h_sw[10]|h_sw[1]|h_sw[2]|h_sw[3]|h_sw[4]|h_sw[5]|h_sw[6]|h_sw[7]|h_sw[8]|h_sw[9]|l_sw[0]|l_sw[10]|l_sw[1]|l_sw[2]|l_sw[3]|l_sw[4]|l_sw[5]|l_sw[6]|l_sw[7]|l_sw[8]|l_sw[9]|vc|vdd|vss|z
+ \$1 sg13_lv_nmos L=0.13u W=0.5u AS=0.095p AD=0.095p PS=0.88u PD=0.88u rfmode=0
M$49
+ BOTTOM|TOP|h_sw[0]|h_sw[10]|h_sw[1]|h_sw[2]|h_sw[3]|h_sw[4]|h_sw[5]|h_sw[6]|h_sw[7]|h_sw[8]|h_sw[9]|l_sw[0]|l_sw[10]|l_sw[1]|l_sw[2]|l_sw[3]|l_sw[4]|l_sw[5]|l_sw[6]|l_sw[7]|l_sw[8]|l_sw[9]|vc|vdd|vss|z
+ in_h_sw[0]|x
+ BOTTOM|TOP|h_sw[0]|h_sw[10]|h_sw[1]|h_sw[2]|h_sw[3]|h_sw[4]|h_sw[5]|h_sw[6]|h_sw[7]|h_sw[8]|h_sw[9]|l_sw[0]|l_sw[10]|l_sw[1]|l_sw[2]|l_sw[3]|l_sw[4]|l_sw[5]|l_sw[6]|l_sw[7]|l_sw[8]|l_sw[9]|vc|vdd|vss|z
+ \$1 sg13_lv_nmos L=0.13u W=0.5u AS=0.095p AD=0.095p PS=0.88u PD=0.88u rfmode=0
M$50
+ BOTTOM|TOP|h_sw[0]|h_sw[10]|h_sw[1]|h_sw[2]|h_sw[3]|h_sw[4]|h_sw[5]|h_sw[6]|h_sw[7]|h_sw[8]|h_sw[9]|l_sw[0]|l_sw[10]|l_sw[1]|l_sw[2]|l_sw[3]|l_sw[4]|l_sw[5]|l_sw[6]|l_sw[7]|l_sw[8]|l_sw[9]|vc|vdd|vss|z
+ in_h_sw[0]|x
+ BOTTOM|TOP|h_sw[0]|h_sw[10]|h_sw[1]|h_sw[2]|h_sw[3]|h_sw[4]|h_sw[5]|h_sw[6]|h_sw[7]|h_sw[8]|h_sw[9]|l_sw[0]|l_sw[10]|l_sw[1]|l_sw[2]|l_sw[3]|l_sw[4]|l_sw[5]|l_sw[6]|l_sw[7]|l_sw[8]|l_sw[9]|vc|vdd|vss|z
+ \$1 sg13_lv_nmos L=0.13u W=0.5u AS=0.095p AD=0.095p PS=0.88u PD=0.88u rfmode=0
M$51
+ BOTTOM|TOP|h_sw[0]|h_sw[10]|h_sw[1]|h_sw[2]|h_sw[3]|h_sw[4]|h_sw[5]|h_sw[6]|h_sw[7]|h_sw[8]|h_sw[9]|l_sw[0]|l_sw[10]|l_sw[1]|l_sw[2]|l_sw[3]|l_sw[4]|l_sw[5]|l_sw[6]|l_sw[7]|l_sw[8]|l_sw[9]|vc|vdd|vss|z
+ in_h_sw[0]|x
+ BOTTOM|TOP|h_sw[0]|h_sw[10]|h_sw[1]|h_sw[2]|h_sw[3]|h_sw[4]|h_sw[5]|h_sw[6]|h_sw[7]|h_sw[8]|h_sw[9]|l_sw[0]|l_sw[10]|l_sw[1]|l_sw[2]|l_sw[3]|l_sw[4]|l_sw[5]|l_sw[6]|l_sw[7]|l_sw[8]|l_sw[9]|vc|vdd|vss|z
+ \$1 sg13_lv_nmos L=0.13u W=0.5u AS=0.095p AD=0.095p PS=0.88u PD=0.88u rfmode=0
M$52
+ BOTTOM|TOP|h_sw[0]|h_sw[10]|h_sw[1]|h_sw[2]|h_sw[3]|h_sw[4]|h_sw[5]|h_sw[6]|h_sw[7]|h_sw[8]|h_sw[9]|l_sw[0]|l_sw[10]|l_sw[1]|l_sw[2]|l_sw[3]|l_sw[4]|l_sw[5]|l_sw[6]|l_sw[7]|l_sw[8]|l_sw[9]|vc|vdd|vss|z
+ in_h_sw[0]|x
+ BOTTOM|TOP|h_sw[0]|h_sw[10]|h_sw[1]|h_sw[2]|h_sw[3]|h_sw[4]|h_sw[5]|h_sw[6]|h_sw[7]|h_sw[8]|h_sw[9]|l_sw[0]|l_sw[10]|l_sw[1]|l_sw[2]|l_sw[3]|l_sw[4]|l_sw[5]|l_sw[6]|l_sw[7]|l_sw[8]|l_sw[9]|vc|vdd|vss|z
+ \$1 sg13_lv_nmos L=0.13u W=0.5u AS=0.095p AD=0.095p PS=0.88u PD=0.88u rfmode=0
M$53
+ BOTTOM|TOP|h_sw[0]|h_sw[10]|h_sw[1]|h_sw[2]|h_sw[3]|h_sw[4]|h_sw[5]|h_sw[6]|h_sw[7]|h_sw[8]|h_sw[9]|l_sw[0]|l_sw[10]|l_sw[1]|l_sw[2]|l_sw[3]|l_sw[4]|l_sw[5]|l_sw[6]|l_sw[7]|l_sw[8]|l_sw[9]|vc|vdd|vss|z
+ in_h_sw[0]|x
+ BOTTOM|TOP|h_sw[0]|h_sw[10]|h_sw[1]|h_sw[2]|h_sw[3]|h_sw[4]|h_sw[5]|h_sw[6]|h_sw[7]|h_sw[8]|h_sw[9]|l_sw[0]|l_sw[10]|l_sw[1]|l_sw[2]|l_sw[3]|l_sw[4]|l_sw[5]|l_sw[6]|l_sw[7]|l_sw[8]|l_sw[9]|vc|vdd|vss|z
+ \$1 sg13_lv_nmos L=0.13u W=0.5u AS=0.095p AD=0.095p PS=0.88u PD=0.88u rfmode=0
M$54
+ BOTTOM|TOP|h_sw[0]|h_sw[10]|h_sw[1]|h_sw[2]|h_sw[3]|h_sw[4]|h_sw[5]|h_sw[6]|h_sw[7]|h_sw[8]|h_sw[9]|l_sw[0]|l_sw[10]|l_sw[1]|l_sw[2]|l_sw[3]|l_sw[4]|l_sw[5]|l_sw[6]|l_sw[7]|l_sw[8]|l_sw[9]|vc|vdd|vss|z
+ in_h_sw[0]|x
+ BOTTOM|TOP|h_sw[0]|h_sw[10]|h_sw[1]|h_sw[2]|h_sw[3]|h_sw[4]|h_sw[5]|h_sw[6]|h_sw[7]|h_sw[8]|h_sw[9]|l_sw[0]|l_sw[10]|l_sw[1]|l_sw[2]|l_sw[3]|l_sw[4]|l_sw[5]|l_sw[6]|l_sw[7]|l_sw[8]|l_sw[9]|vc|vdd|vss|z
+ \$1 sg13_lv_nmos L=0.13u W=0.5u AS=0.095p AD=0.095p PS=0.88u PD=0.88u rfmode=0
M$55
+ BOTTOM|TOP|h_sw[0]|h_sw[10]|h_sw[1]|h_sw[2]|h_sw[3]|h_sw[4]|h_sw[5]|h_sw[6]|h_sw[7]|h_sw[8]|h_sw[9]|l_sw[0]|l_sw[10]|l_sw[1]|l_sw[2]|l_sw[3]|l_sw[4]|l_sw[5]|l_sw[6]|l_sw[7]|l_sw[8]|l_sw[9]|vc|vdd|vss|z
+ in_h_sw[0]|x
+ BOTTOM|TOP|h_sw[0]|h_sw[10]|h_sw[1]|h_sw[2]|h_sw[3]|h_sw[4]|h_sw[5]|h_sw[6]|h_sw[7]|h_sw[8]|h_sw[9]|l_sw[0]|l_sw[10]|l_sw[1]|l_sw[2]|l_sw[3]|l_sw[4]|l_sw[5]|l_sw[6]|l_sw[7]|l_sw[8]|l_sw[9]|vc|vdd|vss|z
+ \$1 sg13_lv_nmos L=0.13u W=0.5u AS=0.095p AD=0.095p PS=0.88u PD=0.88u rfmode=0
M$56
+ BOTTOM|TOP|h_sw[0]|h_sw[10]|h_sw[1]|h_sw[2]|h_sw[3]|h_sw[4]|h_sw[5]|h_sw[6]|h_sw[7]|h_sw[8]|h_sw[9]|l_sw[0]|l_sw[10]|l_sw[1]|l_sw[2]|l_sw[3]|l_sw[4]|l_sw[5]|l_sw[6]|l_sw[7]|l_sw[8]|l_sw[9]|vc|vdd|vss|z
+ in_h_sw[0]|x
+ BOTTOM|TOP|h_sw[0]|h_sw[10]|h_sw[1]|h_sw[2]|h_sw[3]|h_sw[4]|h_sw[5]|h_sw[6]|h_sw[7]|h_sw[8]|h_sw[9]|l_sw[0]|l_sw[10]|l_sw[1]|l_sw[2]|l_sw[3]|l_sw[4]|l_sw[5]|l_sw[6]|l_sw[7]|l_sw[8]|l_sw[9]|vc|vdd|vss|z
+ \$1 sg13_lv_nmos L=0.13u W=0.5u AS=0.095p AD=0.095p PS=0.88u PD=0.88u rfmode=0
M$57
+ BOTTOM|TOP|h_sw[0]|h_sw[10]|h_sw[1]|h_sw[2]|h_sw[3]|h_sw[4]|h_sw[5]|h_sw[6]|h_sw[7]|h_sw[8]|h_sw[9]|l_sw[0]|l_sw[10]|l_sw[1]|l_sw[2]|l_sw[3]|l_sw[4]|l_sw[5]|l_sw[6]|l_sw[7]|l_sw[8]|l_sw[9]|vc|vdd|vss|z
+ in_h_sw[0]|x
+ BOTTOM|TOP|h_sw[0]|h_sw[10]|h_sw[1]|h_sw[2]|h_sw[3]|h_sw[4]|h_sw[5]|h_sw[6]|h_sw[7]|h_sw[8]|h_sw[9]|l_sw[0]|l_sw[10]|l_sw[1]|l_sw[2]|l_sw[3]|l_sw[4]|l_sw[5]|l_sw[6]|l_sw[7]|l_sw[8]|l_sw[9]|vc|vdd|vss|z
+ \$1 sg13_lv_nmos L=0.13u W=0.5u AS=0.095p AD=0.095p PS=0.88u PD=0.88u rfmode=0
M$58
+ BOTTOM|TOP|h_sw[0]|h_sw[10]|h_sw[1]|h_sw[2]|h_sw[3]|h_sw[4]|h_sw[5]|h_sw[6]|h_sw[7]|h_sw[8]|h_sw[9]|l_sw[0]|l_sw[10]|l_sw[1]|l_sw[2]|l_sw[3]|l_sw[4]|l_sw[5]|l_sw[6]|l_sw[7]|l_sw[8]|l_sw[9]|vc|vdd|vss|z
+ in_h_sw[0]|x
+ BOTTOM|TOP|h_sw[0]|h_sw[10]|h_sw[1]|h_sw[2]|h_sw[3]|h_sw[4]|h_sw[5]|h_sw[6]|h_sw[7]|h_sw[8]|h_sw[9]|l_sw[0]|l_sw[10]|l_sw[1]|l_sw[2]|l_sw[3]|l_sw[4]|l_sw[5]|l_sw[6]|l_sw[7]|l_sw[8]|l_sw[9]|vc|vdd|vss|z
+ \$1 sg13_lv_nmos L=0.13u W=0.5u AS=0.095p AD=0.095p PS=0.88u PD=0.88u rfmode=0
M$59
+ BOTTOM|TOP|h_sw[0]|h_sw[10]|h_sw[1]|h_sw[2]|h_sw[3]|h_sw[4]|h_sw[5]|h_sw[6]|h_sw[7]|h_sw[8]|h_sw[9]|l_sw[0]|l_sw[10]|l_sw[1]|l_sw[2]|l_sw[3]|l_sw[4]|l_sw[5]|l_sw[6]|l_sw[7]|l_sw[8]|l_sw[9]|vc|vdd|vss|z
+ in_h_sw[0]|x
+ BOTTOM|TOP|h_sw[0]|h_sw[10]|h_sw[1]|h_sw[2]|h_sw[3]|h_sw[4]|h_sw[5]|h_sw[6]|h_sw[7]|h_sw[8]|h_sw[9]|l_sw[0]|l_sw[10]|l_sw[1]|l_sw[2]|l_sw[3]|l_sw[4]|l_sw[5]|l_sw[6]|l_sw[7]|l_sw[8]|l_sw[9]|vc|vdd|vss|z
+ \$1 sg13_lv_nmos L=0.13u W=0.5u AS=0.095p AD=0.095p PS=0.88u PD=0.88u rfmode=0
M$60
+ BOTTOM|TOP|h_sw[0]|h_sw[10]|h_sw[1]|h_sw[2]|h_sw[3]|h_sw[4]|h_sw[5]|h_sw[6]|h_sw[7]|h_sw[8]|h_sw[9]|l_sw[0]|l_sw[10]|l_sw[1]|l_sw[2]|l_sw[3]|l_sw[4]|l_sw[5]|l_sw[6]|l_sw[7]|l_sw[8]|l_sw[9]|vc|vdd|vss|z
+ in_h_sw[0]|x
+ BOTTOM|TOP|h_sw[0]|h_sw[10]|h_sw[1]|h_sw[2]|h_sw[3]|h_sw[4]|h_sw[5]|h_sw[6]|h_sw[7]|h_sw[8]|h_sw[9]|l_sw[0]|l_sw[10]|l_sw[1]|l_sw[2]|l_sw[3]|l_sw[4]|l_sw[5]|l_sw[6]|l_sw[7]|l_sw[8]|l_sw[9]|vc|vdd|vss|z
+ \$1 sg13_lv_nmos L=0.13u W=0.5u AS=0.095p AD=0.095p PS=0.88u PD=0.88u rfmode=0
M$61
+ BOTTOM|TOP|h_sw[0]|h_sw[10]|h_sw[1]|h_sw[2]|h_sw[3]|h_sw[4]|h_sw[5]|h_sw[6]|h_sw[7]|h_sw[8]|h_sw[9]|l_sw[0]|l_sw[10]|l_sw[1]|l_sw[2]|l_sw[3]|l_sw[4]|l_sw[5]|l_sw[6]|l_sw[7]|l_sw[8]|l_sw[9]|vc|vdd|vss|z
+ in_h_sw[0]|x
+ BOTTOM|TOP|h_sw[0]|h_sw[10]|h_sw[1]|h_sw[2]|h_sw[3]|h_sw[4]|h_sw[5]|h_sw[6]|h_sw[7]|h_sw[8]|h_sw[9]|l_sw[0]|l_sw[10]|l_sw[1]|l_sw[2]|l_sw[3]|l_sw[4]|l_sw[5]|l_sw[6]|l_sw[7]|l_sw[8]|l_sw[9]|vc|vdd|vss|z
+ \$1 sg13_lv_nmos L=0.13u W=0.5u AS=0.095p AD=0.095p PS=0.88u PD=0.88u rfmode=0
M$62
+ BOTTOM|TOP|h_sw[0]|h_sw[10]|h_sw[1]|h_sw[2]|h_sw[3]|h_sw[4]|h_sw[5]|h_sw[6]|h_sw[7]|h_sw[8]|h_sw[9]|l_sw[0]|l_sw[10]|l_sw[1]|l_sw[2]|l_sw[3]|l_sw[4]|l_sw[5]|l_sw[6]|l_sw[7]|l_sw[8]|l_sw[9]|vc|vdd|vss|z
+ in_h_sw[0]|x
+ BOTTOM|TOP|h_sw[0]|h_sw[10]|h_sw[1]|h_sw[2]|h_sw[3]|h_sw[4]|h_sw[5]|h_sw[6]|h_sw[7]|h_sw[8]|h_sw[9]|l_sw[0]|l_sw[10]|l_sw[1]|l_sw[2]|l_sw[3]|l_sw[4]|l_sw[5]|l_sw[6]|l_sw[7]|l_sw[8]|l_sw[9]|vc|vdd|vss|z
+ \$1 sg13_lv_nmos L=0.13u W=0.5u AS=0.095p AD=0.095p PS=0.88u PD=0.88u rfmode=0
M$63
+ BOTTOM|TOP|h_sw[0]|h_sw[10]|h_sw[1]|h_sw[2]|h_sw[3]|h_sw[4]|h_sw[5]|h_sw[6]|h_sw[7]|h_sw[8]|h_sw[9]|l_sw[0]|l_sw[10]|l_sw[1]|l_sw[2]|l_sw[3]|l_sw[4]|l_sw[5]|l_sw[6]|l_sw[7]|l_sw[8]|l_sw[9]|vc|vdd|vss|z
+ in_h_sw[0]|x
+ BOTTOM|TOP|h_sw[0]|h_sw[10]|h_sw[1]|h_sw[2]|h_sw[3]|h_sw[4]|h_sw[5]|h_sw[6]|h_sw[7]|h_sw[8]|h_sw[9]|l_sw[0]|l_sw[10]|l_sw[1]|l_sw[2]|l_sw[3]|l_sw[4]|l_sw[5]|l_sw[6]|l_sw[7]|l_sw[8]|l_sw[9]|vc|vdd|vss|z
+ \$1 sg13_lv_nmos L=0.13u W=0.5u AS=0.095p AD=0.095p PS=0.88u PD=0.88u rfmode=0
M$64
+ BOTTOM|TOP|h_sw[0]|h_sw[10]|h_sw[1]|h_sw[2]|h_sw[3]|h_sw[4]|h_sw[5]|h_sw[6]|h_sw[7]|h_sw[8]|h_sw[9]|l_sw[0]|l_sw[10]|l_sw[1]|l_sw[2]|l_sw[3]|l_sw[4]|l_sw[5]|l_sw[6]|l_sw[7]|l_sw[8]|l_sw[9]|vc|vdd|vss|z
+ in_h_sw[0]|x
+ BOTTOM|TOP|h_sw[0]|h_sw[10]|h_sw[1]|h_sw[2]|h_sw[3]|h_sw[4]|h_sw[5]|h_sw[6]|h_sw[7]|h_sw[8]|h_sw[9]|l_sw[0]|l_sw[10]|l_sw[1]|l_sw[2]|l_sw[3]|l_sw[4]|l_sw[5]|l_sw[6]|l_sw[7]|l_sw[8]|l_sw[9]|vc|vdd|vss|z
+ \$1 sg13_lv_nmos L=0.13u W=0.5u AS=0.095p AD=0.17p PS=0.88u PD=1.68u rfmode=0
M$65
+ BOTTOM|TOP|h_sw[0]|h_sw[10]|h_sw[1]|h_sw[2]|h_sw[3]|h_sw[4]|h_sw[5]|h_sw[6]|h_sw[7]|h_sw[8]|h_sw[9]|l_sw[0]|l_sw[10]|l_sw[1]|l_sw[2]|l_sw[3]|l_sw[4]|l_sw[5]|l_sw[6]|l_sw[7]|l_sw[8]|l_sw[9]|vc|vdd|vss|z
+ in_h_sw[3]|x
+ BOTTOM|TOP|h_sw[0]|h_sw[10]|h_sw[1]|h_sw[2]|h_sw[3]|h_sw[4]|h_sw[5]|h_sw[6]|h_sw[7]|h_sw[8]|h_sw[9]|l_sw[0]|l_sw[10]|l_sw[1]|l_sw[2]|l_sw[3]|l_sw[4]|l_sw[5]|l_sw[6]|l_sw[7]|l_sw[8]|l_sw[9]|vc|vdd|vss|z
+ \$1 sg13_lv_nmos L=0.13u W=0.5u AS=0.17p AD=0.095p PS=1.68u PD=0.88u rfmode=0
M$66
+ BOTTOM|TOP|h_sw[0]|h_sw[10]|h_sw[1]|h_sw[2]|h_sw[3]|h_sw[4]|h_sw[5]|h_sw[6]|h_sw[7]|h_sw[8]|h_sw[9]|l_sw[0]|l_sw[10]|l_sw[1]|l_sw[2]|l_sw[3]|l_sw[4]|l_sw[5]|l_sw[6]|l_sw[7]|l_sw[8]|l_sw[9]|vc|vdd|vss|z
+ in_h_sw[3]|x
+ BOTTOM|TOP|h_sw[0]|h_sw[10]|h_sw[1]|h_sw[2]|h_sw[3]|h_sw[4]|h_sw[5]|h_sw[6]|h_sw[7]|h_sw[8]|h_sw[9]|l_sw[0]|l_sw[10]|l_sw[1]|l_sw[2]|l_sw[3]|l_sw[4]|l_sw[5]|l_sw[6]|l_sw[7]|l_sw[8]|l_sw[9]|vc|vdd|vss|z
+ \$1 sg13_lv_nmos L=0.13u W=0.5u AS=0.095p AD=0.095p PS=0.88u PD=0.88u rfmode=0
M$67
+ BOTTOM|TOP|h_sw[0]|h_sw[10]|h_sw[1]|h_sw[2]|h_sw[3]|h_sw[4]|h_sw[5]|h_sw[6]|h_sw[7]|h_sw[8]|h_sw[9]|l_sw[0]|l_sw[10]|l_sw[1]|l_sw[2]|l_sw[3]|l_sw[4]|l_sw[5]|l_sw[6]|l_sw[7]|l_sw[8]|l_sw[9]|vc|vdd|vss|z
+ in_h_sw[3]|x
+ BOTTOM|TOP|h_sw[0]|h_sw[10]|h_sw[1]|h_sw[2]|h_sw[3]|h_sw[4]|h_sw[5]|h_sw[6]|h_sw[7]|h_sw[8]|h_sw[9]|l_sw[0]|l_sw[10]|l_sw[1]|l_sw[2]|l_sw[3]|l_sw[4]|l_sw[5]|l_sw[6]|l_sw[7]|l_sw[8]|l_sw[9]|vc|vdd|vss|z
+ \$1 sg13_lv_nmos L=0.13u W=0.5u AS=0.095p AD=0.095p PS=0.88u PD=0.88u rfmode=0
M$68
+ BOTTOM|TOP|h_sw[0]|h_sw[10]|h_sw[1]|h_sw[2]|h_sw[3]|h_sw[4]|h_sw[5]|h_sw[6]|h_sw[7]|h_sw[8]|h_sw[9]|l_sw[0]|l_sw[10]|l_sw[1]|l_sw[2]|l_sw[3]|l_sw[4]|l_sw[5]|l_sw[6]|l_sw[7]|l_sw[8]|l_sw[9]|vc|vdd|vss|z
+ in_h_sw[3]|x
+ BOTTOM|TOP|h_sw[0]|h_sw[10]|h_sw[1]|h_sw[2]|h_sw[3]|h_sw[4]|h_sw[5]|h_sw[6]|h_sw[7]|h_sw[8]|h_sw[9]|l_sw[0]|l_sw[10]|l_sw[1]|l_sw[2]|l_sw[3]|l_sw[4]|l_sw[5]|l_sw[6]|l_sw[7]|l_sw[8]|l_sw[9]|vc|vdd|vss|z
+ \$1 sg13_lv_nmos L=0.13u W=0.5u AS=0.095p AD=0.095p PS=0.88u PD=0.88u rfmode=0
M$69
+ BOTTOM|TOP|h_sw[0]|h_sw[10]|h_sw[1]|h_sw[2]|h_sw[3]|h_sw[4]|h_sw[5]|h_sw[6]|h_sw[7]|h_sw[8]|h_sw[9]|l_sw[0]|l_sw[10]|l_sw[1]|l_sw[2]|l_sw[3]|l_sw[4]|l_sw[5]|l_sw[6]|l_sw[7]|l_sw[8]|l_sw[9]|vc|vdd|vss|z
+ in_h_sw[3]|x
+ BOTTOM|TOP|h_sw[0]|h_sw[10]|h_sw[1]|h_sw[2]|h_sw[3]|h_sw[4]|h_sw[5]|h_sw[6]|h_sw[7]|h_sw[8]|h_sw[9]|l_sw[0]|l_sw[10]|l_sw[1]|l_sw[2]|l_sw[3]|l_sw[4]|l_sw[5]|l_sw[6]|l_sw[7]|l_sw[8]|l_sw[9]|vc|vdd|vss|z
+ \$1 sg13_lv_nmos L=0.13u W=0.5u AS=0.095p AD=0.095p PS=0.88u PD=0.88u rfmode=0
M$70
+ BOTTOM|TOP|h_sw[0]|h_sw[10]|h_sw[1]|h_sw[2]|h_sw[3]|h_sw[4]|h_sw[5]|h_sw[6]|h_sw[7]|h_sw[8]|h_sw[9]|l_sw[0]|l_sw[10]|l_sw[1]|l_sw[2]|l_sw[3]|l_sw[4]|l_sw[5]|l_sw[6]|l_sw[7]|l_sw[8]|l_sw[9]|vc|vdd|vss|z
+ in_h_sw[3]|x
+ BOTTOM|TOP|h_sw[0]|h_sw[10]|h_sw[1]|h_sw[2]|h_sw[3]|h_sw[4]|h_sw[5]|h_sw[6]|h_sw[7]|h_sw[8]|h_sw[9]|l_sw[0]|l_sw[10]|l_sw[1]|l_sw[2]|l_sw[3]|l_sw[4]|l_sw[5]|l_sw[6]|l_sw[7]|l_sw[8]|l_sw[9]|vc|vdd|vss|z
+ \$1 sg13_lv_nmos L=0.13u W=0.5u AS=0.095p AD=0.095p PS=0.88u PD=0.88u rfmode=0
M$71
+ BOTTOM|TOP|h_sw[0]|h_sw[10]|h_sw[1]|h_sw[2]|h_sw[3]|h_sw[4]|h_sw[5]|h_sw[6]|h_sw[7]|h_sw[8]|h_sw[9]|l_sw[0]|l_sw[10]|l_sw[1]|l_sw[2]|l_sw[3]|l_sw[4]|l_sw[5]|l_sw[6]|l_sw[7]|l_sw[8]|l_sw[9]|vc|vdd|vss|z
+ in_h_sw[3]|x
+ BOTTOM|TOP|h_sw[0]|h_sw[10]|h_sw[1]|h_sw[2]|h_sw[3]|h_sw[4]|h_sw[5]|h_sw[6]|h_sw[7]|h_sw[8]|h_sw[9]|l_sw[0]|l_sw[10]|l_sw[1]|l_sw[2]|l_sw[3]|l_sw[4]|l_sw[5]|l_sw[6]|l_sw[7]|l_sw[8]|l_sw[9]|vc|vdd|vss|z
+ \$1 sg13_lv_nmos L=0.13u W=0.5u AS=0.095p AD=0.095p PS=0.88u PD=0.88u rfmode=0
M$72
+ BOTTOM|TOP|h_sw[0]|h_sw[10]|h_sw[1]|h_sw[2]|h_sw[3]|h_sw[4]|h_sw[5]|h_sw[6]|h_sw[7]|h_sw[8]|h_sw[9]|l_sw[0]|l_sw[10]|l_sw[1]|l_sw[2]|l_sw[3]|l_sw[4]|l_sw[5]|l_sw[6]|l_sw[7]|l_sw[8]|l_sw[9]|vc|vdd|vss|z
+ in_h_sw[3]|x
+ BOTTOM|TOP|h_sw[0]|h_sw[10]|h_sw[1]|h_sw[2]|h_sw[3]|h_sw[4]|h_sw[5]|h_sw[6]|h_sw[7]|h_sw[8]|h_sw[9]|l_sw[0]|l_sw[10]|l_sw[1]|l_sw[2]|l_sw[3]|l_sw[4]|l_sw[5]|l_sw[6]|l_sw[7]|l_sw[8]|l_sw[9]|vc|vdd|vss|z
+ \$1 sg13_lv_nmos L=0.13u W=0.5u AS=0.095p AD=0.17p PS=0.88u PD=1.68u rfmode=0
M$73
+ BOTTOM|TOP|h_sw[0]|h_sw[10]|h_sw[1]|h_sw[2]|h_sw[3]|h_sw[4]|h_sw[5]|h_sw[6]|h_sw[7]|h_sw[8]|h_sw[9]|l_sw[0]|l_sw[10]|l_sw[1]|l_sw[2]|l_sw[3]|l_sw[4]|l_sw[5]|l_sw[6]|l_sw[7]|l_sw[8]|l_sw[9]|vc|vdd|vss|z
+ in_h_sw[4]|x
+ BOTTOM|TOP|h_sw[0]|h_sw[10]|h_sw[1]|h_sw[2]|h_sw[3]|h_sw[4]|h_sw[5]|h_sw[6]|h_sw[7]|h_sw[8]|h_sw[9]|l_sw[0]|l_sw[10]|l_sw[1]|l_sw[2]|l_sw[3]|l_sw[4]|l_sw[5]|l_sw[6]|l_sw[7]|l_sw[8]|l_sw[9]|vc|vdd|vss|z
+ \$1 sg13_lv_nmos L=0.13u W=0.5u AS=0.17p AD=0.095p PS=1.68u PD=0.88u rfmode=0
M$74
+ BOTTOM|TOP|h_sw[0]|h_sw[10]|h_sw[1]|h_sw[2]|h_sw[3]|h_sw[4]|h_sw[5]|h_sw[6]|h_sw[7]|h_sw[8]|h_sw[9]|l_sw[0]|l_sw[10]|l_sw[1]|l_sw[2]|l_sw[3]|l_sw[4]|l_sw[5]|l_sw[6]|l_sw[7]|l_sw[8]|l_sw[9]|vc|vdd|vss|z
+ in_h_sw[4]|x
+ BOTTOM|TOP|h_sw[0]|h_sw[10]|h_sw[1]|h_sw[2]|h_sw[3]|h_sw[4]|h_sw[5]|h_sw[6]|h_sw[7]|h_sw[8]|h_sw[9]|l_sw[0]|l_sw[10]|l_sw[1]|l_sw[2]|l_sw[3]|l_sw[4]|l_sw[5]|l_sw[6]|l_sw[7]|l_sw[8]|l_sw[9]|vc|vdd|vss|z
+ \$1 sg13_lv_nmos L=0.13u W=0.5u AS=0.095p AD=0.095p PS=0.88u PD=0.88u rfmode=0
M$75
+ BOTTOM|TOP|h_sw[0]|h_sw[10]|h_sw[1]|h_sw[2]|h_sw[3]|h_sw[4]|h_sw[5]|h_sw[6]|h_sw[7]|h_sw[8]|h_sw[9]|l_sw[0]|l_sw[10]|l_sw[1]|l_sw[2]|l_sw[3]|l_sw[4]|l_sw[5]|l_sw[6]|l_sw[7]|l_sw[8]|l_sw[9]|vc|vdd|vss|z
+ in_h_sw[4]|x
+ BOTTOM|TOP|h_sw[0]|h_sw[10]|h_sw[1]|h_sw[2]|h_sw[3]|h_sw[4]|h_sw[5]|h_sw[6]|h_sw[7]|h_sw[8]|h_sw[9]|l_sw[0]|l_sw[10]|l_sw[1]|l_sw[2]|l_sw[3]|l_sw[4]|l_sw[5]|l_sw[6]|l_sw[7]|l_sw[8]|l_sw[9]|vc|vdd|vss|z
+ \$1 sg13_lv_nmos L=0.13u W=0.5u AS=0.095p AD=0.095p PS=0.88u PD=0.88u rfmode=0
M$76
+ BOTTOM|TOP|h_sw[0]|h_sw[10]|h_sw[1]|h_sw[2]|h_sw[3]|h_sw[4]|h_sw[5]|h_sw[6]|h_sw[7]|h_sw[8]|h_sw[9]|l_sw[0]|l_sw[10]|l_sw[1]|l_sw[2]|l_sw[3]|l_sw[4]|l_sw[5]|l_sw[6]|l_sw[7]|l_sw[8]|l_sw[9]|vc|vdd|vss|z
+ in_h_sw[4]|x
+ BOTTOM|TOP|h_sw[0]|h_sw[10]|h_sw[1]|h_sw[2]|h_sw[3]|h_sw[4]|h_sw[5]|h_sw[6]|h_sw[7]|h_sw[8]|h_sw[9]|l_sw[0]|l_sw[10]|l_sw[1]|l_sw[2]|l_sw[3]|l_sw[4]|l_sw[5]|l_sw[6]|l_sw[7]|l_sw[8]|l_sw[9]|vc|vdd|vss|z
+ \$1 sg13_lv_nmos L=0.13u W=0.5u AS=0.095p AD=0.095p PS=0.88u PD=0.88u rfmode=0
M$77
+ BOTTOM|TOP|h_sw[0]|h_sw[10]|h_sw[1]|h_sw[2]|h_sw[3]|h_sw[4]|h_sw[5]|h_sw[6]|h_sw[7]|h_sw[8]|h_sw[9]|l_sw[0]|l_sw[10]|l_sw[1]|l_sw[2]|l_sw[3]|l_sw[4]|l_sw[5]|l_sw[6]|l_sw[7]|l_sw[8]|l_sw[9]|vc|vdd|vss|z
+ in_h_sw[4]|x
+ BOTTOM|TOP|h_sw[0]|h_sw[10]|h_sw[1]|h_sw[2]|h_sw[3]|h_sw[4]|h_sw[5]|h_sw[6]|h_sw[7]|h_sw[8]|h_sw[9]|l_sw[0]|l_sw[10]|l_sw[1]|l_sw[2]|l_sw[3]|l_sw[4]|l_sw[5]|l_sw[6]|l_sw[7]|l_sw[8]|l_sw[9]|vc|vdd|vss|z
+ \$1 sg13_lv_nmos L=0.13u W=0.5u AS=0.095p AD=0.095p PS=0.88u PD=0.88u rfmode=0
M$78
+ BOTTOM|TOP|h_sw[0]|h_sw[10]|h_sw[1]|h_sw[2]|h_sw[3]|h_sw[4]|h_sw[5]|h_sw[6]|h_sw[7]|h_sw[8]|h_sw[9]|l_sw[0]|l_sw[10]|l_sw[1]|l_sw[2]|l_sw[3]|l_sw[4]|l_sw[5]|l_sw[6]|l_sw[7]|l_sw[8]|l_sw[9]|vc|vdd|vss|z
+ in_h_sw[4]|x
+ BOTTOM|TOP|h_sw[0]|h_sw[10]|h_sw[1]|h_sw[2]|h_sw[3]|h_sw[4]|h_sw[5]|h_sw[6]|h_sw[7]|h_sw[8]|h_sw[9]|l_sw[0]|l_sw[10]|l_sw[1]|l_sw[2]|l_sw[3]|l_sw[4]|l_sw[5]|l_sw[6]|l_sw[7]|l_sw[8]|l_sw[9]|vc|vdd|vss|z
+ \$1 sg13_lv_nmos L=0.13u W=0.5u AS=0.095p AD=0.095p PS=0.88u PD=0.88u rfmode=0
M$79
+ BOTTOM|TOP|h_sw[0]|h_sw[10]|h_sw[1]|h_sw[2]|h_sw[3]|h_sw[4]|h_sw[5]|h_sw[6]|h_sw[7]|h_sw[8]|h_sw[9]|l_sw[0]|l_sw[10]|l_sw[1]|l_sw[2]|l_sw[3]|l_sw[4]|l_sw[5]|l_sw[6]|l_sw[7]|l_sw[8]|l_sw[9]|vc|vdd|vss|z
+ in_h_sw[4]|x
+ BOTTOM|TOP|h_sw[0]|h_sw[10]|h_sw[1]|h_sw[2]|h_sw[3]|h_sw[4]|h_sw[5]|h_sw[6]|h_sw[7]|h_sw[8]|h_sw[9]|l_sw[0]|l_sw[10]|l_sw[1]|l_sw[2]|l_sw[3]|l_sw[4]|l_sw[5]|l_sw[6]|l_sw[7]|l_sw[8]|l_sw[9]|vc|vdd|vss|z
+ \$1 sg13_lv_nmos L=0.13u W=0.5u AS=0.095p AD=0.095p PS=0.88u PD=0.88u rfmode=0
M$80
+ BOTTOM|TOP|h_sw[0]|h_sw[10]|h_sw[1]|h_sw[2]|h_sw[3]|h_sw[4]|h_sw[5]|h_sw[6]|h_sw[7]|h_sw[8]|h_sw[9]|l_sw[0]|l_sw[10]|l_sw[1]|l_sw[2]|l_sw[3]|l_sw[4]|l_sw[5]|l_sw[6]|l_sw[7]|l_sw[8]|l_sw[9]|vc|vdd|vss|z
+ in_h_sw[4]|x
+ BOTTOM|TOP|h_sw[0]|h_sw[10]|h_sw[1]|h_sw[2]|h_sw[3]|h_sw[4]|h_sw[5]|h_sw[6]|h_sw[7]|h_sw[8]|h_sw[9]|l_sw[0]|l_sw[10]|l_sw[1]|l_sw[2]|l_sw[3]|l_sw[4]|l_sw[5]|l_sw[6]|l_sw[7]|l_sw[8]|l_sw[9]|vc|vdd|vss|z
+ \$1 sg13_lv_nmos L=0.13u W=0.5u AS=0.095p AD=0.17p PS=0.88u PD=1.68u rfmode=0
M$81
+ BOTTOM|TOP|h_sw[0]|h_sw[10]|h_sw[1]|h_sw[2]|h_sw[3]|h_sw[4]|h_sw[5]|h_sw[6]|h_sw[7]|h_sw[8]|h_sw[9]|l_sw[0]|l_sw[10]|l_sw[1]|l_sw[2]|l_sw[3]|l_sw[4]|l_sw[5]|l_sw[6]|l_sw[7]|l_sw[8]|l_sw[9]|vc|vdd|vss|z
+ in_h_sw[5]|x
+ BOTTOM|TOP|h_sw[0]|h_sw[10]|h_sw[1]|h_sw[2]|h_sw[3]|h_sw[4]|h_sw[5]|h_sw[6]|h_sw[7]|h_sw[8]|h_sw[9]|l_sw[0]|l_sw[10]|l_sw[1]|l_sw[2]|l_sw[3]|l_sw[4]|l_sw[5]|l_sw[6]|l_sw[7]|l_sw[8]|l_sw[9]|vc|vdd|vss|z
+ \$1 sg13_lv_nmos L=0.13u W=0.5u AS=0.17p AD=0.095p PS=1.68u PD=0.88u rfmode=0
M$82
+ BOTTOM|TOP|h_sw[0]|h_sw[10]|h_sw[1]|h_sw[2]|h_sw[3]|h_sw[4]|h_sw[5]|h_sw[6]|h_sw[7]|h_sw[8]|h_sw[9]|l_sw[0]|l_sw[10]|l_sw[1]|l_sw[2]|l_sw[3]|l_sw[4]|l_sw[5]|l_sw[6]|l_sw[7]|l_sw[8]|l_sw[9]|vc|vdd|vss|z
+ in_h_sw[5]|x
+ BOTTOM|TOP|h_sw[0]|h_sw[10]|h_sw[1]|h_sw[2]|h_sw[3]|h_sw[4]|h_sw[5]|h_sw[6]|h_sw[7]|h_sw[8]|h_sw[9]|l_sw[0]|l_sw[10]|l_sw[1]|l_sw[2]|l_sw[3]|l_sw[4]|l_sw[5]|l_sw[6]|l_sw[7]|l_sw[8]|l_sw[9]|vc|vdd|vss|z
+ \$1 sg13_lv_nmos L=0.13u W=0.5u AS=0.095p AD=0.095p PS=0.88u PD=0.88u rfmode=0
M$83
+ BOTTOM|TOP|h_sw[0]|h_sw[10]|h_sw[1]|h_sw[2]|h_sw[3]|h_sw[4]|h_sw[5]|h_sw[6]|h_sw[7]|h_sw[8]|h_sw[9]|l_sw[0]|l_sw[10]|l_sw[1]|l_sw[2]|l_sw[3]|l_sw[4]|l_sw[5]|l_sw[6]|l_sw[7]|l_sw[8]|l_sw[9]|vc|vdd|vss|z
+ in_h_sw[5]|x
+ BOTTOM|TOP|h_sw[0]|h_sw[10]|h_sw[1]|h_sw[2]|h_sw[3]|h_sw[4]|h_sw[5]|h_sw[6]|h_sw[7]|h_sw[8]|h_sw[9]|l_sw[0]|l_sw[10]|l_sw[1]|l_sw[2]|l_sw[3]|l_sw[4]|l_sw[5]|l_sw[6]|l_sw[7]|l_sw[8]|l_sw[9]|vc|vdd|vss|z
+ \$1 sg13_lv_nmos L=0.13u W=0.5u AS=0.095p AD=0.095p PS=0.88u PD=0.88u rfmode=0
M$84
+ BOTTOM|TOP|h_sw[0]|h_sw[10]|h_sw[1]|h_sw[2]|h_sw[3]|h_sw[4]|h_sw[5]|h_sw[6]|h_sw[7]|h_sw[8]|h_sw[9]|l_sw[0]|l_sw[10]|l_sw[1]|l_sw[2]|l_sw[3]|l_sw[4]|l_sw[5]|l_sw[6]|l_sw[7]|l_sw[8]|l_sw[9]|vc|vdd|vss|z
+ in_h_sw[5]|x
+ BOTTOM|TOP|h_sw[0]|h_sw[10]|h_sw[1]|h_sw[2]|h_sw[3]|h_sw[4]|h_sw[5]|h_sw[6]|h_sw[7]|h_sw[8]|h_sw[9]|l_sw[0]|l_sw[10]|l_sw[1]|l_sw[2]|l_sw[3]|l_sw[4]|l_sw[5]|l_sw[6]|l_sw[7]|l_sw[8]|l_sw[9]|vc|vdd|vss|z
+ \$1 sg13_lv_nmos L=0.13u W=0.5u AS=0.095p AD=0.095p PS=0.88u PD=0.88u rfmode=0
M$85
+ BOTTOM|TOP|h_sw[0]|h_sw[10]|h_sw[1]|h_sw[2]|h_sw[3]|h_sw[4]|h_sw[5]|h_sw[6]|h_sw[7]|h_sw[8]|h_sw[9]|l_sw[0]|l_sw[10]|l_sw[1]|l_sw[2]|l_sw[3]|l_sw[4]|l_sw[5]|l_sw[6]|l_sw[7]|l_sw[8]|l_sw[9]|vc|vdd|vss|z
+ in_h_sw[5]|x
+ BOTTOM|TOP|h_sw[0]|h_sw[10]|h_sw[1]|h_sw[2]|h_sw[3]|h_sw[4]|h_sw[5]|h_sw[6]|h_sw[7]|h_sw[8]|h_sw[9]|l_sw[0]|l_sw[10]|l_sw[1]|l_sw[2]|l_sw[3]|l_sw[4]|l_sw[5]|l_sw[6]|l_sw[7]|l_sw[8]|l_sw[9]|vc|vdd|vss|z
+ \$1 sg13_lv_nmos L=0.13u W=0.5u AS=0.095p AD=0.095p PS=0.88u PD=0.88u rfmode=0
M$86
+ BOTTOM|TOP|h_sw[0]|h_sw[10]|h_sw[1]|h_sw[2]|h_sw[3]|h_sw[4]|h_sw[5]|h_sw[6]|h_sw[7]|h_sw[8]|h_sw[9]|l_sw[0]|l_sw[10]|l_sw[1]|l_sw[2]|l_sw[3]|l_sw[4]|l_sw[5]|l_sw[6]|l_sw[7]|l_sw[8]|l_sw[9]|vc|vdd|vss|z
+ in_h_sw[5]|x
+ BOTTOM|TOP|h_sw[0]|h_sw[10]|h_sw[1]|h_sw[2]|h_sw[3]|h_sw[4]|h_sw[5]|h_sw[6]|h_sw[7]|h_sw[8]|h_sw[9]|l_sw[0]|l_sw[10]|l_sw[1]|l_sw[2]|l_sw[3]|l_sw[4]|l_sw[5]|l_sw[6]|l_sw[7]|l_sw[8]|l_sw[9]|vc|vdd|vss|z
+ \$1 sg13_lv_nmos L=0.13u W=0.5u AS=0.095p AD=0.095p PS=0.88u PD=0.88u rfmode=0
M$87
+ BOTTOM|TOP|h_sw[0]|h_sw[10]|h_sw[1]|h_sw[2]|h_sw[3]|h_sw[4]|h_sw[5]|h_sw[6]|h_sw[7]|h_sw[8]|h_sw[9]|l_sw[0]|l_sw[10]|l_sw[1]|l_sw[2]|l_sw[3]|l_sw[4]|l_sw[5]|l_sw[6]|l_sw[7]|l_sw[8]|l_sw[9]|vc|vdd|vss|z
+ in_h_sw[5]|x
+ BOTTOM|TOP|h_sw[0]|h_sw[10]|h_sw[1]|h_sw[2]|h_sw[3]|h_sw[4]|h_sw[5]|h_sw[6]|h_sw[7]|h_sw[8]|h_sw[9]|l_sw[0]|l_sw[10]|l_sw[1]|l_sw[2]|l_sw[3]|l_sw[4]|l_sw[5]|l_sw[6]|l_sw[7]|l_sw[8]|l_sw[9]|vc|vdd|vss|z
+ \$1 sg13_lv_nmos L=0.13u W=0.5u AS=0.095p AD=0.095p PS=0.88u PD=0.88u rfmode=0
M$88
+ BOTTOM|TOP|h_sw[0]|h_sw[10]|h_sw[1]|h_sw[2]|h_sw[3]|h_sw[4]|h_sw[5]|h_sw[6]|h_sw[7]|h_sw[8]|h_sw[9]|l_sw[0]|l_sw[10]|l_sw[1]|l_sw[2]|l_sw[3]|l_sw[4]|l_sw[5]|l_sw[6]|l_sw[7]|l_sw[8]|l_sw[9]|vc|vdd|vss|z
+ in_h_sw[5]|x
+ BOTTOM|TOP|h_sw[0]|h_sw[10]|h_sw[1]|h_sw[2]|h_sw[3]|h_sw[4]|h_sw[5]|h_sw[6]|h_sw[7]|h_sw[8]|h_sw[9]|l_sw[0]|l_sw[10]|l_sw[1]|l_sw[2]|l_sw[3]|l_sw[4]|l_sw[5]|l_sw[6]|l_sw[7]|l_sw[8]|l_sw[9]|vc|vdd|vss|z
+ \$1 sg13_lv_nmos L=0.13u W=0.5u AS=0.095p AD=0.17p PS=0.88u PD=1.68u rfmode=0
M$89
+ BOTTOM|TOP|h_sw[0]|h_sw[10]|h_sw[1]|h_sw[2]|h_sw[3]|h_sw[4]|h_sw[5]|h_sw[6]|h_sw[7]|h_sw[8]|h_sw[9]|l_sw[0]|l_sw[10]|l_sw[1]|l_sw[2]|l_sw[3]|l_sw[4]|l_sw[5]|l_sw[6]|l_sw[7]|l_sw[8]|l_sw[9]|vc|vdd|vss|z
+ in_l_sw[1]|x
+ BOTTOM|TOP|h_sw[0]|h_sw[10]|h_sw[1]|h_sw[2]|h_sw[3]|h_sw[4]|h_sw[5]|h_sw[6]|h_sw[7]|h_sw[8]|h_sw[9]|l_sw[0]|l_sw[10]|l_sw[1]|l_sw[2]|l_sw[3]|l_sw[4]|l_sw[5]|l_sw[6]|l_sw[7]|l_sw[8]|l_sw[9]|vc|vdd|vss|z
+ \$1 sg13_lv_nmos L=0.13u W=0.5u AS=0.17p AD=0.095p PS=1.68u PD=0.88u rfmode=0
M$90
+ BOTTOM|TOP|h_sw[0]|h_sw[10]|h_sw[1]|h_sw[2]|h_sw[3]|h_sw[4]|h_sw[5]|h_sw[6]|h_sw[7]|h_sw[8]|h_sw[9]|l_sw[0]|l_sw[10]|l_sw[1]|l_sw[2]|l_sw[3]|l_sw[4]|l_sw[5]|l_sw[6]|l_sw[7]|l_sw[8]|l_sw[9]|vc|vdd|vss|z
+ in_l_sw[1]|x
+ BOTTOM|TOP|h_sw[0]|h_sw[10]|h_sw[1]|h_sw[2]|h_sw[3]|h_sw[4]|h_sw[5]|h_sw[6]|h_sw[7]|h_sw[8]|h_sw[9]|l_sw[0]|l_sw[10]|l_sw[1]|l_sw[2]|l_sw[3]|l_sw[4]|l_sw[5]|l_sw[6]|l_sw[7]|l_sw[8]|l_sw[9]|vc|vdd|vss|z
+ \$1 sg13_lv_nmos L=0.13u W=0.5u AS=0.095p AD=0.095p PS=0.88u PD=0.88u rfmode=0
M$91
+ BOTTOM|TOP|h_sw[0]|h_sw[10]|h_sw[1]|h_sw[2]|h_sw[3]|h_sw[4]|h_sw[5]|h_sw[6]|h_sw[7]|h_sw[8]|h_sw[9]|l_sw[0]|l_sw[10]|l_sw[1]|l_sw[2]|l_sw[3]|l_sw[4]|l_sw[5]|l_sw[6]|l_sw[7]|l_sw[8]|l_sw[9]|vc|vdd|vss|z
+ in_l_sw[1]|x
+ BOTTOM|TOP|h_sw[0]|h_sw[10]|h_sw[1]|h_sw[2]|h_sw[3]|h_sw[4]|h_sw[5]|h_sw[6]|h_sw[7]|h_sw[8]|h_sw[9]|l_sw[0]|l_sw[10]|l_sw[1]|l_sw[2]|l_sw[3]|l_sw[4]|l_sw[5]|l_sw[6]|l_sw[7]|l_sw[8]|l_sw[9]|vc|vdd|vss|z
+ \$1 sg13_lv_nmos L=0.13u W=0.5u AS=0.095p AD=0.095p PS=0.88u PD=0.88u rfmode=0
M$92
+ BOTTOM|TOP|h_sw[0]|h_sw[10]|h_sw[1]|h_sw[2]|h_sw[3]|h_sw[4]|h_sw[5]|h_sw[6]|h_sw[7]|h_sw[8]|h_sw[9]|l_sw[0]|l_sw[10]|l_sw[1]|l_sw[2]|l_sw[3]|l_sw[4]|l_sw[5]|l_sw[6]|l_sw[7]|l_sw[8]|l_sw[9]|vc|vdd|vss|z
+ in_l_sw[1]|x
+ BOTTOM|TOP|h_sw[0]|h_sw[10]|h_sw[1]|h_sw[2]|h_sw[3]|h_sw[4]|h_sw[5]|h_sw[6]|h_sw[7]|h_sw[8]|h_sw[9]|l_sw[0]|l_sw[10]|l_sw[1]|l_sw[2]|l_sw[3]|l_sw[4]|l_sw[5]|l_sw[6]|l_sw[7]|l_sw[8]|l_sw[9]|vc|vdd|vss|z
+ \$1 sg13_lv_nmos L=0.13u W=0.5u AS=0.095p AD=0.095p PS=0.88u PD=0.88u rfmode=0
M$93
+ BOTTOM|TOP|h_sw[0]|h_sw[10]|h_sw[1]|h_sw[2]|h_sw[3]|h_sw[4]|h_sw[5]|h_sw[6]|h_sw[7]|h_sw[8]|h_sw[9]|l_sw[0]|l_sw[10]|l_sw[1]|l_sw[2]|l_sw[3]|l_sw[4]|l_sw[5]|l_sw[6]|l_sw[7]|l_sw[8]|l_sw[9]|vc|vdd|vss|z
+ in_l_sw[1]|x
+ BOTTOM|TOP|h_sw[0]|h_sw[10]|h_sw[1]|h_sw[2]|h_sw[3]|h_sw[4]|h_sw[5]|h_sw[6]|h_sw[7]|h_sw[8]|h_sw[9]|l_sw[0]|l_sw[10]|l_sw[1]|l_sw[2]|l_sw[3]|l_sw[4]|l_sw[5]|l_sw[6]|l_sw[7]|l_sw[8]|l_sw[9]|vc|vdd|vss|z
+ \$1 sg13_lv_nmos L=0.13u W=0.5u AS=0.095p AD=0.095p PS=0.88u PD=0.88u rfmode=0
M$94
+ BOTTOM|TOP|h_sw[0]|h_sw[10]|h_sw[1]|h_sw[2]|h_sw[3]|h_sw[4]|h_sw[5]|h_sw[6]|h_sw[7]|h_sw[8]|h_sw[9]|l_sw[0]|l_sw[10]|l_sw[1]|l_sw[2]|l_sw[3]|l_sw[4]|l_sw[5]|l_sw[6]|l_sw[7]|l_sw[8]|l_sw[9]|vc|vdd|vss|z
+ in_l_sw[1]|x
+ BOTTOM|TOP|h_sw[0]|h_sw[10]|h_sw[1]|h_sw[2]|h_sw[3]|h_sw[4]|h_sw[5]|h_sw[6]|h_sw[7]|h_sw[8]|h_sw[9]|l_sw[0]|l_sw[10]|l_sw[1]|l_sw[2]|l_sw[3]|l_sw[4]|l_sw[5]|l_sw[6]|l_sw[7]|l_sw[8]|l_sw[9]|vc|vdd|vss|z
+ \$1 sg13_lv_nmos L=0.13u W=0.5u AS=0.095p AD=0.095p PS=0.88u PD=0.88u rfmode=0
M$95
+ BOTTOM|TOP|h_sw[0]|h_sw[10]|h_sw[1]|h_sw[2]|h_sw[3]|h_sw[4]|h_sw[5]|h_sw[6]|h_sw[7]|h_sw[8]|h_sw[9]|l_sw[0]|l_sw[10]|l_sw[1]|l_sw[2]|l_sw[3]|l_sw[4]|l_sw[5]|l_sw[6]|l_sw[7]|l_sw[8]|l_sw[9]|vc|vdd|vss|z
+ in_l_sw[1]|x
+ BOTTOM|TOP|h_sw[0]|h_sw[10]|h_sw[1]|h_sw[2]|h_sw[3]|h_sw[4]|h_sw[5]|h_sw[6]|h_sw[7]|h_sw[8]|h_sw[9]|l_sw[0]|l_sw[10]|l_sw[1]|l_sw[2]|l_sw[3]|l_sw[4]|l_sw[5]|l_sw[6]|l_sw[7]|l_sw[8]|l_sw[9]|vc|vdd|vss|z
+ \$1 sg13_lv_nmos L=0.13u W=0.5u AS=0.095p AD=0.095p PS=0.88u PD=0.88u rfmode=0
M$96
+ BOTTOM|TOP|h_sw[0]|h_sw[10]|h_sw[1]|h_sw[2]|h_sw[3]|h_sw[4]|h_sw[5]|h_sw[6]|h_sw[7]|h_sw[8]|h_sw[9]|l_sw[0]|l_sw[10]|l_sw[1]|l_sw[2]|l_sw[3]|l_sw[4]|l_sw[5]|l_sw[6]|l_sw[7]|l_sw[8]|l_sw[9]|vc|vdd|vss|z
+ in_l_sw[1]|x
+ BOTTOM|TOP|h_sw[0]|h_sw[10]|h_sw[1]|h_sw[2]|h_sw[3]|h_sw[4]|h_sw[5]|h_sw[6]|h_sw[7]|h_sw[8]|h_sw[9]|l_sw[0]|l_sw[10]|l_sw[1]|l_sw[2]|l_sw[3]|l_sw[4]|l_sw[5]|l_sw[6]|l_sw[7]|l_sw[8]|l_sw[9]|vc|vdd|vss|z
+ \$1 sg13_lv_nmos L=0.13u W=0.5u AS=0.095p AD=0.095p PS=0.88u PD=0.88u rfmode=0
M$97
+ BOTTOM|TOP|h_sw[0]|h_sw[10]|h_sw[1]|h_sw[2]|h_sw[3]|h_sw[4]|h_sw[5]|h_sw[6]|h_sw[7]|h_sw[8]|h_sw[9]|l_sw[0]|l_sw[10]|l_sw[1]|l_sw[2]|l_sw[3]|l_sw[4]|l_sw[5]|l_sw[6]|l_sw[7]|l_sw[8]|l_sw[9]|vc|vdd|vss|z
+ in_l_sw[1]|x
+ BOTTOM|TOP|h_sw[0]|h_sw[10]|h_sw[1]|h_sw[2]|h_sw[3]|h_sw[4]|h_sw[5]|h_sw[6]|h_sw[7]|h_sw[8]|h_sw[9]|l_sw[0]|l_sw[10]|l_sw[1]|l_sw[2]|l_sw[3]|l_sw[4]|l_sw[5]|l_sw[6]|l_sw[7]|l_sw[8]|l_sw[9]|vc|vdd|vss|z
+ \$1 sg13_lv_nmos L=0.13u W=0.5u AS=0.095p AD=0.095p PS=0.88u PD=0.88u rfmode=0
M$98
+ BOTTOM|TOP|h_sw[0]|h_sw[10]|h_sw[1]|h_sw[2]|h_sw[3]|h_sw[4]|h_sw[5]|h_sw[6]|h_sw[7]|h_sw[8]|h_sw[9]|l_sw[0]|l_sw[10]|l_sw[1]|l_sw[2]|l_sw[3]|l_sw[4]|l_sw[5]|l_sw[6]|l_sw[7]|l_sw[8]|l_sw[9]|vc|vdd|vss|z
+ in_l_sw[1]|x
+ BOTTOM|TOP|h_sw[0]|h_sw[10]|h_sw[1]|h_sw[2]|h_sw[3]|h_sw[4]|h_sw[5]|h_sw[6]|h_sw[7]|h_sw[8]|h_sw[9]|l_sw[0]|l_sw[10]|l_sw[1]|l_sw[2]|l_sw[3]|l_sw[4]|l_sw[5]|l_sw[6]|l_sw[7]|l_sw[8]|l_sw[9]|vc|vdd|vss|z
+ \$1 sg13_lv_nmos L=0.13u W=0.5u AS=0.095p AD=0.095p PS=0.88u PD=0.88u rfmode=0
M$99
+ BOTTOM|TOP|h_sw[0]|h_sw[10]|h_sw[1]|h_sw[2]|h_sw[3]|h_sw[4]|h_sw[5]|h_sw[6]|h_sw[7]|h_sw[8]|h_sw[9]|l_sw[0]|l_sw[10]|l_sw[1]|l_sw[2]|l_sw[3]|l_sw[4]|l_sw[5]|l_sw[6]|l_sw[7]|l_sw[8]|l_sw[9]|vc|vdd|vss|z
+ in_l_sw[1]|x
+ BOTTOM|TOP|h_sw[0]|h_sw[10]|h_sw[1]|h_sw[2]|h_sw[3]|h_sw[4]|h_sw[5]|h_sw[6]|h_sw[7]|h_sw[8]|h_sw[9]|l_sw[0]|l_sw[10]|l_sw[1]|l_sw[2]|l_sw[3]|l_sw[4]|l_sw[5]|l_sw[6]|l_sw[7]|l_sw[8]|l_sw[9]|vc|vdd|vss|z
+ \$1 sg13_lv_nmos L=0.13u W=0.5u AS=0.095p AD=0.095p PS=0.88u PD=0.88u rfmode=0
M$100
+ BOTTOM|TOP|h_sw[0]|h_sw[10]|h_sw[1]|h_sw[2]|h_sw[3]|h_sw[4]|h_sw[5]|h_sw[6]|h_sw[7]|h_sw[8]|h_sw[9]|l_sw[0]|l_sw[10]|l_sw[1]|l_sw[2]|l_sw[3]|l_sw[4]|l_sw[5]|l_sw[6]|l_sw[7]|l_sw[8]|l_sw[9]|vc|vdd|vss|z
+ in_l_sw[1]|x
+ BOTTOM|TOP|h_sw[0]|h_sw[10]|h_sw[1]|h_sw[2]|h_sw[3]|h_sw[4]|h_sw[5]|h_sw[6]|h_sw[7]|h_sw[8]|h_sw[9]|l_sw[0]|l_sw[10]|l_sw[1]|l_sw[2]|l_sw[3]|l_sw[4]|l_sw[5]|l_sw[6]|l_sw[7]|l_sw[8]|l_sw[9]|vc|vdd|vss|z
+ \$1 sg13_lv_nmos L=0.13u W=0.5u AS=0.095p AD=0.095p PS=0.88u PD=0.88u rfmode=0
M$101
+ BOTTOM|TOP|h_sw[0]|h_sw[10]|h_sw[1]|h_sw[2]|h_sw[3]|h_sw[4]|h_sw[5]|h_sw[6]|h_sw[7]|h_sw[8]|h_sw[9]|l_sw[0]|l_sw[10]|l_sw[1]|l_sw[2]|l_sw[3]|l_sw[4]|l_sw[5]|l_sw[6]|l_sw[7]|l_sw[8]|l_sw[9]|vc|vdd|vss|z
+ in_l_sw[1]|x
+ BOTTOM|TOP|h_sw[0]|h_sw[10]|h_sw[1]|h_sw[2]|h_sw[3]|h_sw[4]|h_sw[5]|h_sw[6]|h_sw[7]|h_sw[8]|h_sw[9]|l_sw[0]|l_sw[10]|l_sw[1]|l_sw[2]|l_sw[3]|l_sw[4]|l_sw[5]|l_sw[6]|l_sw[7]|l_sw[8]|l_sw[9]|vc|vdd|vss|z
+ \$1 sg13_lv_nmos L=0.13u W=0.5u AS=0.095p AD=0.095p PS=0.88u PD=0.88u rfmode=0
M$102
+ BOTTOM|TOP|h_sw[0]|h_sw[10]|h_sw[1]|h_sw[2]|h_sw[3]|h_sw[4]|h_sw[5]|h_sw[6]|h_sw[7]|h_sw[8]|h_sw[9]|l_sw[0]|l_sw[10]|l_sw[1]|l_sw[2]|l_sw[3]|l_sw[4]|l_sw[5]|l_sw[6]|l_sw[7]|l_sw[8]|l_sw[9]|vc|vdd|vss|z
+ in_l_sw[1]|x
+ BOTTOM|TOP|h_sw[0]|h_sw[10]|h_sw[1]|h_sw[2]|h_sw[3]|h_sw[4]|h_sw[5]|h_sw[6]|h_sw[7]|h_sw[8]|h_sw[9]|l_sw[0]|l_sw[10]|l_sw[1]|l_sw[2]|l_sw[3]|l_sw[4]|l_sw[5]|l_sw[6]|l_sw[7]|l_sw[8]|l_sw[9]|vc|vdd|vss|z
+ \$1 sg13_lv_nmos L=0.13u W=0.5u AS=0.095p AD=0.095p PS=0.88u PD=0.88u rfmode=0
M$103
+ BOTTOM|TOP|h_sw[0]|h_sw[10]|h_sw[1]|h_sw[2]|h_sw[3]|h_sw[4]|h_sw[5]|h_sw[6]|h_sw[7]|h_sw[8]|h_sw[9]|l_sw[0]|l_sw[10]|l_sw[1]|l_sw[2]|l_sw[3]|l_sw[4]|l_sw[5]|l_sw[6]|l_sw[7]|l_sw[8]|l_sw[9]|vc|vdd|vss|z
+ in_l_sw[1]|x
+ BOTTOM|TOP|h_sw[0]|h_sw[10]|h_sw[1]|h_sw[2]|h_sw[3]|h_sw[4]|h_sw[5]|h_sw[6]|h_sw[7]|h_sw[8]|h_sw[9]|l_sw[0]|l_sw[10]|l_sw[1]|l_sw[2]|l_sw[3]|l_sw[4]|l_sw[5]|l_sw[6]|l_sw[7]|l_sw[8]|l_sw[9]|vc|vdd|vss|z
+ \$1 sg13_lv_nmos L=0.13u W=0.5u AS=0.095p AD=0.095p PS=0.88u PD=0.88u rfmode=0
M$104
+ BOTTOM|TOP|h_sw[0]|h_sw[10]|h_sw[1]|h_sw[2]|h_sw[3]|h_sw[4]|h_sw[5]|h_sw[6]|h_sw[7]|h_sw[8]|h_sw[9]|l_sw[0]|l_sw[10]|l_sw[1]|l_sw[2]|l_sw[3]|l_sw[4]|l_sw[5]|l_sw[6]|l_sw[7]|l_sw[8]|l_sw[9]|vc|vdd|vss|z
+ in_l_sw[1]|x
+ BOTTOM|TOP|h_sw[0]|h_sw[10]|h_sw[1]|h_sw[2]|h_sw[3]|h_sw[4]|h_sw[5]|h_sw[6]|h_sw[7]|h_sw[8]|h_sw[9]|l_sw[0]|l_sw[10]|l_sw[1]|l_sw[2]|l_sw[3]|l_sw[4]|l_sw[5]|l_sw[6]|l_sw[7]|l_sw[8]|l_sw[9]|vc|vdd|vss|z
+ \$1 sg13_lv_nmos L=0.13u W=0.5u AS=0.095p AD=0.17p PS=0.88u PD=1.68u rfmode=0
M$105
+ BOTTOM|TOP|h_sw[0]|h_sw[10]|h_sw[1]|h_sw[2]|h_sw[3]|h_sw[4]|h_sw[5]|h_sw[6]|h_sw[7]|h_sw[8]|h_sw[9]|l_sw[0]|l_sw[10]|l_sw[1]|l_sw[2]|l_sw[3]|l_sw[4]|l_sw[5]|l_sw[6]|l_sw[7]|l_sw[8]|l_sw[9]|vc|vdd|vss|z
+ in_h_sw[1]|x
+ BOTTOM|TOP|h_sw[0]|h_sw[10]|h_sw[1]|h_sw[2]|h_sw[3]|h_sw[4]|h_sw[5]|h_sw[6]|h_sw[7]|h_sw[8]|h_sw[9]|l_sw[0]|l_sw[10]|l_sw[1]|l_sw[2]|l_sw[3]|l_sw[4]|l_sw[5]|l_sw[6]|l_sw[7]|l_sw[8]|l_sw[9]|vc|vdd|vss|z
+ \$1 sg13_lv_nmos L=0.13u W=0.5u AS=0.17p AD=0.095p PS=1.68u PD=0.88u rfmode=0
M$106
+ BOTTOM|TOP|h_sw[0]|h_sw[10]|h_sw[1]|h_sw[2]|h_sw[3]|h_sw[4]|h_sw[5]|h_sw[6]|h_sw[7]|h_sw[8]|h_sw[9]|l_sw[0]|l_sw[10]|l_sw[1]|l_sw[2]|l_sw[3]|l_sw[4]|l_sw[5]|l_sw[6]|l_sw[7]|l_sw[8]|l_sw[9]|vc|vdd|vss|z
+ in_h_sw[1]|x
+ BOTTOM|TOP|h_sw[0]|h_sw[10]|h_sw[1]|h_sw[2]|h_sw[3]|h_sw[4]|h_sw[5]|h_sw[6]|h_sw[7]|h_sw[8]|h_sw[9]|l_sw[0]|l_sw[10]|l_sw[1]|l_sw[2]|l_sw[3]|l_sw[4]|l_sw[5]|l_sw[6]|l_sw[7]|l_sw[8]|l_sw[9]|vc|vdd|vss|z
+ \$1 sg13_lv_nmos L=0.13u W=0.5u AS=0.095p AD=0.095p PS=0.88u PD=0.88u rfmode=0
M$107
+ BOTTOM|TOP|h_sw[0]|h_sw[10]|h_sw[1]|h_sw[2]|h_sw[3]|h_sw[4]|h_sw[5]|h_sw[6]|h_sw[7]|h_sw[8]|h_sw[9]|l_sw[0]|l_sw[10]|l_sw[1]|l_sw[2]|l_sw[3]|l_sw[4]|l_sw[5]|l_sw[6]|l_sw[7]|l_sw[8]|l_sw[9]|vc|vdd|vss|z
+ in_h_sw[1]|x
+ BOTTOM|TOP|h_sw[0]|h_sw[10]|h_sw[1]|h_sw[2]|h_sw[3]|h_sw[4]|h_sw[5]|h_sw[6]|h_sw[7]|h_sw[8]|h_sw[9]|l_sw[0]|l_sw[10]|l_sw[1]|l_sw[2]|l_sw[3]|l_sw[4]|l_sw[5]|l_sw[6]|l_sw[7]|l_sw[8]|l_sw[9]|vc|vdd|vss|z
+ \$1 sg13_lv_nmos L=0.13u W=0.5u AS=0.095p AD=0.095p PS=0.88u PD=0.88u rfmode=0
M$108
+ BOTTOM|TOP|h_sw[0]|h_sw[10]|h_sw[1]|h_sw[2]|h_sw[3]|h_sw[4]|h_sw[5]|h_sw[6]|h_sw[7]|h_sw[8]|h_sw[9]|l_sw[0]|l_sw[10]|l_sw[1]|l_sw[2]|l_sw[3]|l_sw[4]|l_sw[5]|l_sw[6]|l_sw[7]|l_sw[8]|l_sw[9]|vc|vdd|vss|z
+ in_h_sw[1]|x
+ BOTTOM|TOP|h_sw[0]|h_sw[10]|h_sw[1]|h_sw[2]|h_sw[3]|h_sw[4]|h_sw[5]|h_sw[6]|h_sw[7]|h_sw[8]|h_sw[9]|l_sw[0]|l_sw[10]|l_sw[1]|l_sw[2]|l_sw[3]|l_sw[4]|l_sw[5]|l_sw[6]|l_sw[7]|l_sw[8]|l_sw[9]|vc|vdd|vss|z
+ \$1 sg13_lv_nmos L=0.13u W=0.5u AS=0.095p AD=0.095p PS=0.88u PD=0.88u rfmode=0
M$109
+ BOTTOM|TOP|h_sw[0]|h_sw[10]|h_sw[1]|h_sw[2]|h_sw[3]|h_sw[4]|h_sw[5]|h_sw[6]|h_sw[7]|h_sw[8]|h_sw[9]|l_sw[0]|l_sw[10]|l_sw[1]|l_sw[2]|l_sw[3]|l_sw[4]|l_sw[5]|l_sw[6]|l_sw[7]|l_sw[8]|l_sw[9]|vc|vdd|vss|z
+ in_h_sw[1]|x
+ BOTTOM|TOP|h_sw[0]|h_sw[10]|h_sw[1]|h_sw[2]|h_sw[3]|h_sw[4]|h_sw[5]|h_sw[6]|h_sw[7]|h_sw[8]|h_sw[9]|l_sw[0]|l_sw[10]|l_sw[1]|l_sw[2]|l_sw[3]|l_sw[4]|l_sw[5]|l_sw[6]|l_sw[7]|l_sw[8]|l_sw[9]|vc|vdd|vss|z
+ \$1 sg13_lv_nmos L=0.13u W=0.5u AS=0.095p AD=0.095p PS=0.88u PD=0.88u rfmode=0
M$110
+ BOTTOM|TOP|h_sw[0]|h_sw[10]|h_sw[1]|h_sw[2]|h_sw[3]|h_sw[4]|h_sw[5]|h_sw[6]|h_sw[7]|h_sw[8]|h_sw[9]|l_sw[0]|l_sw[10]|l_sw[1]|l_sw[2]|l_sw[3]|l_sw[4]|l_sw[5]|l_sw[6]|l_sw[7]|l_sw[8]|l_sw[9]|vc|vdd|vss|z
+ in_h_sw[1]|x
+ BOTTOM|TOP|h_sw[0]|h_sw[10]|h_sw[1]|h_sw[2]|h_sw[3]|h_sw[4]|h_sw[5]|h_sw[6]|h_sw[7]|h_sw[8]|h_sw[9]|l_sw[0]|l_sw[10]|l_sw[1]|l_sw[2]|l_sw[3]|l_sw[4]|l_sw[5]|l_sw[6]|l_sw[7]|l_sw[8]|l_sw[9]|vc|vdd|vss|z
+ \$1 sg13_lv_nmos L=0.13u W=0.5u AS=0.095p AD=0.095p PS=0.88u PD=0.88u rfmode=0
M$111
+ BOTTOM|TOP|h_sw[0]|h_sw[10]|h_sw[1]|h_sw[2]|h_sw[3]|h_sw[4]|h_sw[5]|h_sw[6]|h_sw[7]|h_sw[8]|h_sw[9]|l_sw[0]|l_sw[10]|l_sw[1]|l_sw[2]|l_sw[3]|l_sw[4]|l_sw[5]|l_sw[6]|l_sw[7]|l_sw[8]|l_sw[9]|vc|vdd|vss|z
+ in_h_sw[1]|x
+ BOTTOM|TOP|h_sw[0]|h_sw[10]|h_sw[1]|h_sw[2]|h_sw[3]|h_sw[4]|h_sw[5]|h_sw[6]|h_sw[7]|h_sw[8]|h_sw[9]|l_sw[0]|l_sw[10]|l_sw[1]|l_sw[2]|l_sw[3]|l_sw[4]|l_sw[5]|l_sw[6]|l_sw[7]|l_sw[8]|l_sw[9]|vc|vdd|vss|z
+ \$1 sg13_lv_nmos L=0.13u W=0.5u AS=0.095p AD=0.095p PS=0.88u PD=0.88u rfmode=0
M$112
+ BOTTOM|TOP|h_sw[0]|h_sw[10]|h_sw[1]|h_sw[2]|h_sw[3]|h_sw[4]|h_sw[5]|h_sw[6]|h_sw[7]|h_sw[8]|h_sw[9]|l_sw[0]|l_sw[10]|l_sw[1]|l_sw[2]|l_sw[3]|l_sw[4]|l_sw[5]|l_sw[6]|l_sw[7]|l_sw[8]|l_sw[9]|vc|vdd|vss|z
+ in_h_sw[1]|x
+ BOTTOM|TOP|h_sw[0]|h_sw[10]|h_sw[1]|h_sw[2]|h_sw[3]|h_sw[4]|h_sw[5]|h_sw[6]|h_sw[7]|h_sw[8]|h_sw[9]|l_sw[0]|l_sw[10]|l_sw[1]|l_sw[2]|l_sw[3]|l_sw[4]|l_sw[5]|l_sw[6]|l_sw[7]|l_sw[8]|l_sw[9]|vc|vdd|vss|z
+ \$1 sg13_lv_nmos L=0.13u W=0.5u AS=0.095p AD=0.095p PS=0.88u PD=0.88u rfmode=0
M$113
+ BOTTOM|TOP|h_sw[0]|h_sw[10]|h_sw[1]|h_sw[2]|h_sw[3]|h_sw[4]|h_sw[5]|h_sw[6]|h_sw[7]|h_sw[8]|h_sw[9]|l_sw[0]|l_sw[10]|l_sw[1]|l_sw[2]|l_sw[3]|l_sw[4]|l_sw[5]|l_sw[6]|l_sw[7]|l_sw[8]|l_sw[9]|vc|vdd|vss|z
+ in_h_sw[1]|x
+ BOTTOM|TOP|h_sw[0]|h_sw[10]|h_sw[1]|h_sw[2]|h_sw[3]|h_sw[4]|h_sw[5]|h_sw[6]|h_sw[7]|h_sw[8]|h_sw[9]|l_sw[0]|l_sw[10]|l_sw[1]|l_sw[2]|l_sw[3]|l_sw[4]|l_sw[5]|l_sw[6]|l_sw[7]|l_sw[8]|l_sw[9]|vc|vdd|vss|z
+ \$1 sg13_lv_nmos L=0.13u W=0.5u AS=0.095p AD=0.095p PS=0.88u PD=0.88u rfmode=0
M$114
+ BOTTOM|TOP|h_sw[0]|h_sw[10]|h_sw[1]|h_sw[2]|h_sw[3]|h_sw[4]|h_sw[5]|h_sw[6]|h_sw[7]|h_sw[8]|h_sw[9]|l_sw[0]|l_sw[10]|l_sw[1]|l_sw[2]|l_sw[3]|l_sw[4]|l_sw[5]|l_sw[6]|l_sw[7]|l_sw[8]|l_sw[9]|vc|vdd|vss|z
+ in_h_sw[1]|x
+ BOTTOM|TOP|h_sw[0]|h_sw[10]|h_sw[1]|h_sw[2]|h_sw[3]|h_sw[4]|h_sw[5]|h_sw[6]|h_sw[7]|h_sw[8]|h_sw[9]|l_sw[0]|l_sw[10]|l_sw[1]|l_sw[2]|l_sw[3]|l_sw[4]|l_sw[5]|l_sw[6]|l_sw[7]|l_sw[8]|l_sw[9]|vc|vdd|vss|z
+ \$1 sg13_lv_nmos L=0.13u W=0.5u AS=0.095p AD=0.095p PS=0.88u PD=0.88u rfmode=0
M$115
+ BOTTOM|TOP|h_sw[0]|h_sw[10]|h_sw[1]|h_sw[2]|h_sw[3]|h_sw[4]|h_sw[5]|h_sw[6]|h_sw[7]|h_sw[8]|h_sw[9]|l_sw[0]|l_sw[10]|l_sw[1]|l_sw[2]|l_sw[3]|l_sw[4]|l_sw[5]|l_sw[6]|l_sw[7]|l_sw[8]|l_sw[9]|vc|vdd|vss|z
+ in_h_sw[1]|x
+ BOTTOM|TOP|h_sw[0]|h_sw[10]|h_sw[1]|h_sw[2]|h_sw[3]|h_sw[4]|h_sw[5]|h_sw[6]|h_sw[7]|h_sw[8]|h_sw[9]|l_sw[0]|l_sw[10]|l_sw[1]|l_sw[2]|l_sw[3]|l_sw[4]|l_sw[5]|l_sw[6]|l_sw[7]|l_sw[8]|l_sw[9]|vc|vdd|vss|z
+ \$1 sg13_lv_nmos L=0.13u W=0.5u AS=0.095p AD=0.095p PS=0.88u PD=0.88u rfmode=0
M$116
+ BOTTOM|TOP|h_sw[0]|h_sw[10]|h_sw[1]|h_sw[2]|h_sw[3]|h_sw[4]|h_sw[5]|h_sw[6]|h_sw[7]|h_sw[8]|h_sw[9]|l_sw[0]|l_sw[10]|l_sw[1]|l_sw[2]|l_sw[3]|l_sw[4]|l_sw[5]|l_sw[6]|l_sw[7]|l_sw[8]|l_sw[9]|vc|vdd|vss|z
+ in_h_sw[1]|x
+ BOTTOM|TOP|h_sw[0]|h_sw[10]|h_sw[1]|h_sw[2]|h_sw[3]|h_sw[4]|h_sw[5]|h_sw[6]|h_sw[7]|h_sw[8]|h_sw[9]|l_sw[0]|l_sw[10]|l_sw[1]|l_sw[2]|l_sw[3]|l_sw[4]|l_sw[5]|l_sw[6]|l_sw[7]|l_sw[8]|l_sw[9]|vc|vdd|vss|z
+ \$1 sg13_lv_nmos L=0.13u W=0.5u AS=0.095p AD=0.095p PS=0.88u PD=0.88u rfmode=0
M$117
+ BOTTOM|TOP|h_sw[0]|h_sw[10]|h_sw[1]|h_sw[2]|h_sw[3]|h_sw[4]|h_sw[5]|h_sw[6]|h_sw[7]|h_sw[8]|h_sw[9]|l_sw[0]|l_sw[10]|l_sw[1]|l_sw[2]|l_sw[3]|l_sw[4]|l_sw[5]|l_sw[6]|l_sw[7]|l_sw[8]|l_sw[9]|vc|vdd|vss|z
+ in_h_sw[1]|x
+ BOTTOM|TOP|h_sw[0]|h_sw[10]|h_sw[1]|h_sw[2]|h_sw[3]|h_sw[4]|h_sw[5]|h_sw[6]|h_sw[7]|h_sw[8]|h_sw[9]|l_sw[0]|l_sw[10]|l_sw[1]|l_sw[2]|l_sw[3]|l_sw[4]|l_sw[5]|l_sw[6]|l_sw[7]|l_sw[8]|l_sw[9]|vc|vdd|vss|z
+ \$1 sg13_lv_nmos L=0.13u W=0.5u AS=0.095p AD=0.095p PS=0.88u PD=0.88u rfmode=0
M$118
+ BOTTOM|TOP|h_sw[0]|h_sw[10]|h_sw[1]|h_sw[2]|h_sw[3]|h_sw[4]|h_sw[5]|h_sw[6]|h_sw[7]|h_sw[8]|h_sw[9]|l_sw[0]|l_sw[10]|l_sw[1]|l_sw[2]|l_sw[3]|l_sw[4]|l_sw[5]|l_sw[6]|l_sw[7]|l_sw[8]|l_sw[9]|vc|vdd|vss|z
+ in_h_sw[1]|x
+ BOTTOM|TOP|h_sw[0]|h_sw[10]|h_sw[1]|h_sw[2]|h_sw[3]|h_sw[4]|h_sw[5]|h_sw[6]|h_sw[7]|h_sw[8]|h_sw[9]|l_sw[0]|l_sw[10]|l_sw[1]|l_sw[2]|l_sw[3]|l_sw[4]|l_sw[5]|l_sw[6]|l_sw[7]|l_sw[8]|l_sw[9]|vc|vdd|vss|z
+ \$1 sg13_lv_nmos L=0.13u W=0.5u AS=0.095p AD=0.095p PS=0.88u PD=0.88u rfmode=0
M$119
+ BOTTOM|TOP|h_sw[0]|h_sw[10]|h_sw[1]|h_sw[2]|h_sw[3]|h_sw[4]|h_sw[5]|h_sw[6]|h_sw[7]|h_sw[8]|h_sw[9]|l_sw[0]|l_sw[10]|l_sw[1]|l_sw[2]|l_sw[3]|l_sw[4]|l_sw[5]|l_sw[6]|l_sw[7]|l_sw[8]|l_sw[9]|vc|vdd|vss|z
+ in_h_sw[1]|x
+ BOTTOM|TOP|h_sw[0]|h_sw[10]|h_sw[1]|h_sw[2]|h_sw[3]|h_sw[4]|h_sw[5]|h_sw[6]|h_sw[7]|h_sw[8]|h_sw[9]|l_sw[0]|l_sw[10]|l_sw[1]|l_sw[2]|l_sw[3]|l_sw[4]|l_sw[5]|l_sw[6]|l_sw[7]|l_sw[8]|l_sw[9]|vc|vdd|vss|z
+ \$1 sg13_lv_nmos L=0.13u W=0.5u AS=0.095p AD=0.095p PS=0.88u PD=0.88u rfmode=0
M$120
+ BOTTOM|TOP|h_sw[0]|h_sw[10]|h_sw[1]|h_sw[2]|h_sw[3]|h_sw[4]|h_sw[5]|h_sw[6]|h_sw[7]|h_sw[8]|h_sw[9]|l_sw[0]|l_sw[10]|l_sw[1]|l_sw[2]|l_sw[3]|l_sw[4]|l_sw[5]|l_sw[6]|l_sw[7]|l_sw[8]|l_sw[9]|vc|vdd|vss|z
+ in_h_sw[1]|x
+ BOTTOM|TOP|h_sw[0]|h_sw[10]|h_sw[1]|h_sw[2]|h_sw[3]|h_sw[4]|h_sw[5]|h_sw[6]|h_sw[7]|h_sw[8]|h_sw[9]|l_sw[0]|l_sw[10]|l_sw[1]|l_sw[2]|l_sw[3]|l_sw[4]|l_sw[5]|l_sw[6]|l_sw[7]|l_sw[8]|l_sw[9]|vc|vdd|vss|z
+ \$1 sg13_lv_nmos L=0.13u W=0.5u AS=0.095p AD=0.17p PS=0.88u PD=1.68u rfmode=0
M$121
+ BOTTOM|TOP|h_sw[0]|h_sw[10]|h_sw[1]|h_sw[2]|h_sw[3]|h_sw[4]|h_sw[5]|h_sw[6]|h_sw[7]|h_sw[8]|h_sw[9]|l_sw[0]|l_sw[10]|l_sw[1]|l_sw[2]|l_sw[3]|l_sw[4]|l_sw[5]|l_sw[6]|l_sw[7]|l_sw[8]|l_sw[9]|vc|vdd|vss|z
+ in_l_sw[2]|x
+ BOTTOM|TOP|h_sw[0]|h_sw[10]|h_sw[1]|h_sw[2]|h_sw[3]|h_sw[4]|h_sw[5]|h_sw[6]|h_sw[7]|h_sw[8]|h_sw[9]|l_sw[0]|l_sw[10]|l_sw[1]|l_sw[2]|l_sw[3]|l_sw[4]|l_sw[5]|l_sw[6]|l_sw[7]|l_sw[8]|l_sw[9]|vc|vdd|vss|z
+ \$1 sg13_lv_nmos L=0.13u W=0.5u AS=0.17p AD=0.095p PS=1.68u PD=0.88u rfmode=0
M$122
+ BOTTOM|TOP|h_sw[0]|h_sw[10]|h_sw[1]|h_sw[2]|h_sw[3]|h_sw[4]|h_sw[5]|h_sw[6]|h_sw[7]|h_sw[8]|h_sw[9]|l_sw[0]|l_sw[10]|l_sw[1]|l_sw[2]|l_sw[3]|l_sw[4]|l_sw[5]|l_sw[6]|l_sw[7]|l_sw[8]|l_sw[9]|vc|vdd|vss|z
+ in_l_sw[2]|x
+ BOTTOM|TOP|h_sw[0]|h_sw[10]|h_sw[1]|h_sw[2]|h_sw[3]|h_sw[4]|h_sw[5]|h_sw[6]|h_sw[7]|h_sw[8]|h_sw[9]|l_sw[0]|l_sw[10]|l_sw[1]|l_sw[2]|l_sw[3]|l_sw[4]|l_sw[5]|l_sw[6]|l_sw[7]|l_sw[8]|l_sw[9]|vc|vdd|vss|z
+ \$1 sg13_lv_nmos L=0.13u W=0.5u AS=0.095p AD=0.095p PS=0.88u PD=0.88u rfmode=0
M$123
+ BOTTOM|TOP|h_sw[0]|h_sw[10]|h_sw[1]|h_sw[2]|h_sw[3]|h_sw[4]|h_sw[5]|h_sw[6]|h_sw[7]|h_sw[8]|h_sw[9]|l_sw[0]|l_sw[10]|l_sw[1]|l_sw[2]|l_sw[3]|l_sw[4]|l_sw[5]|l_sw[6]|l_sw[7]|l_sw[8]|l_sw[9]|vc|vdd|vss|z
+ in_l_sw[2]|x
+ BOTTOM|TOP|h_sw[0]|h_sw[10]|h_sw[1]|h_sw[2]|h_sw[3]|h_sw[4]|h_sw[5]|h_sw[6]|h_sw[7]|h_sw[8]|h_sw[9]|l_sw[0]|l_sw[10]|l_sw[1]|l_sw[2]|l_sw[3]|l_sw[4]|l_sw[5]|l_sw[6]|l_sw[7]|l_sw[8]|l_sw[9]|vc|vdd|vss|z
+ \$1 sg13_lv_nmos L=0.13u W=0.5u AS=0.095p AD=0.095p PS=0.88u PD=0.88u rfmode=0
M$124
+ BOTTOM|TOP|h_sw[0]|h_sw[10]|h_sw[1]|h_sw[2]|h_sw[3]|h_sw[4]|h_sw[5]|h_sw[6]|h_sw[7]|h_sw[8]|h_sw[9]|l_sw[0]|l_sw[10]|l_sw[1]|l_sw[2]|l_sw[3]|l_sw[4]|l_sw[5]|l_sw[6]|l_sw[7]|l_sw[8]|l_sw[9]|vc|vdd|vss|z
+ in_l_sw[2]|x
+ BOTTOM|TOP|h_sw[0]|h_sw[10]|h_sw[1]|h_sw[2]|h_sw[3]|h_sw[4]|h_sw[5]|h_sw[6]|h_sw[7]|h_sw[8]|h_sw[9]|l_sw[0]|l_sw[10]|l_sw[1]|l_sw[2]|l_sw[3]|l_sw[4]|l_sw[5]|l_sw[6]|l_sw[7]|l_sw[8]|l_sw[9]|vc|vdd|vss|z
+ \$1 sg13_lv_nmos L=0.13u W=0.5u AS=0.095p AD=0.095p PS=0.88u PD=0.88u rfmode=0
M$125
+ BOTTOM|TOP|h_sw[0]|h_sw[10]|h_sw[1]|h_sw[2]|h_sw[3]|h_sw[4]|h_sw[5]|h_sw[6]|h_sw[7]|h_sw[8]|h_sw[9]|l_sw[0]|l_sw[10]|l_sw[1]|l_sw[2]|l_sw[3]|l_sw[4]|l_sw[5]|l_sw[6]|l_sw[7]|l_sw[8]|l_sw[9]|vc|vdd|vss|z
+ in_l_sw[2]|x
+ BOTTOM|TOP|h_sw[0]|h_sw[10]|h_sw[1]|h_sw[2]|h_sw[3]|h_sw[4]|h_sw[5]|h_sw[6]|h_sw[7]|h_sw[8]|h_sw[9]|l_sw[0]|l_sw[10]|l_sw[1]|l_sw[2]|l_sw[3]|l_sw[4]|l_sw[5]|l_sw[6]|l_sw[7]|l_sw[8]|l_sw[9]|vc|vdd|vss|z
+ \$1 sg13_lv_nmos L=0.13u W=0.5u AS=0.095p AD=0.095p PS=0.88u PD=0.88u rfmode=0
M$126
+ BOTTOM|TOP|h_sw[0]|h_sw[10]|h_sw[1]|h_sw[2]|h_sw[3]|h_sw[4]|h_sw[5]|h_sw[6]|h_sw[7]|h_sw[8]|h_sw[9]|l_sw[0]|l_sw[10]|l_sw[1]|l_sw[2]|l_sw[3]|l_sw[4]|l_sw[5]|l_sw[6]|l_sw[7]|l_sw[8]|l_sw[9]|vc|vdd|vss|z
+ in_l_sw[2]|x
+ BOTTOM|TOP|h_sw[0]|h_sw[10]|h_sw[1]|h_sw[2]|h_sw[3]|h_sw[4]|h_sw[5]|h_sw[6]|h_sw[7]|h_sw[8]|h_sw[9]|l_sw[0]|l_sw[10]|l_sw[1]|l_sw[2]|l_sw[3]|l_sw[4]|l_sw[5]|l_sw[6]|l_sw[7]|l_sw[8]|l_sw[9]|vc|vdd|vss|z
+ \$1 sg13_lv_nmos L=0.13u W=0.5u AS=0.095p AD=0.095p PS=0.88u PD=0.88u rfmode=0
M$127
+ BOTTOM|TOP|h_sw[0]|h_sw[10]|h_sw[1]|h_sw[2]|h_sw[3]|h_sw[4]|h_sw[5]|h_sw[6]|h_sw[7]|h_sw[8]|h_sw[9]|l_sw[0]|l_sw[10]|l_sw[1]|l_sw[2]|l_sw[3]|l_sw[4]|l_sw[5]|l_sw[6]|l_sw[7]|l_sw[8]|l_sw[9]|vc|vdd|vss|z
+ in_l_sw[2]|x
+ BOTTOM|TOP|h_sw[0]|h_sw[10]|h_sw[1]|h_sw[2]|h_sw[3]|h_sw[4]|h_sw[5]|h_sw[6]|h_sw[7]|h_sw[8]|h_sw[9]|l_sw[0]|l_sw[10]|l_sw[1]|l_sw[2]|l_sw[3]|l_sw[4]|l_sw[5]|l_sw[6]|l_sw[7]|l_sw[8]|l_sw[9]|vc|vdd|vss|z
+ \$1 sg13_lv_nmos L=0.13u W=0.5u AS=0.095p AD=0.095p PS=0.88u PD=0.88u rfmode=0
M$128
+ BOTTOM|TOP|h_sw[0]|h_sw[10]|h_sw[1]|h_sw[2]|h_sw[3]|h_sw[4]|h_sw[5]|h_sw[6]|h_sw[7]|h_sw[8]|h_sw[9]|l_sw[0]|l_sw[10]|l_sw[1]|l_sw[2]|l_sw[3]|l_sw[4]|l_sw[5]|l_sw[6]|l_sw[7]|l_sw[8]|l_sw[9]|vc|vdd|vss|z
+ in_l_sw[2]|x
+ BOTTOM|TOP|h_sw[0]|h_sw[10]|h_sw[1]|h_sw[2]|h_sw[3]|h_sw[4]|h_sw[5]|h_sw[6]|h_sw[7]|h_sw[8]|h_sw[9]|l_sw[0]|l_sw[10]|l_sw[1]|l_sw[2]|l_sw[3]|l_sw[4]|l_sw[5]|l_sw[6]|l_sw[7]|l_sw[8]|l_sw[9]|vc|vdd|vss|z
+ \$1 sg13_lv_nmos L=0.13u W=0.5u AS=0.095p AD=0.095p PS=0.88u PD=0.88u rfmode=0
M$129
+ BOTTOM|TOP|h_sw[0]|h_sw[10]|h_sw[1]|h_sw[2]|h_sw[3]|h_sw[4]|h_sw[5]|h_sw[6]|h_sw[7]|h_sw[8]|h_sw[9]|l_sw[0]|l_sw[10]|l_sw[1]|l_sw[2]|l_sw[3]|l_sw[4]|l_sw[5]|l_sw[6]|l_sw[7]|l_sw[8]|l_sw[9]|vc|vdd|vss|z
+ in_l_sw[2]|x
+ BOTTOM|TOP|h_sw[0]|h_sw[10]|h_sw[1]|h_sw[2]|h_sw[3]|h_sw[4]|h_sw[5]|h_sw[6]|h_sw[7]|h_sw[8]|h_sw[9]|l_sw[0]|l_sw[10]|l_sw[1]|l_sw[2]|l_sw[3]|l_sw[4]|l_sw[5]|l_sw[6]|l_sw[7]|l_sw[8]|l_sw[9]|vc|vdd|vss|z
+ \$1 sg13_lv_nmos L=0.13u W=0.5u AS=0.095p AD=0.095p PS=0.88u PD=0.88u rfmode=0
M$130
+ BOTTOM|TOP|h_sw[0]|h_sw[10]|h_sw[1]|h_sw[2]|h_sw[3]|h_sw[4]|h_sw[5]|h_sw[6]|h_sw[7]|h_sw[8]|h_sw[9]|l_sw[0]|l_sw[10]|l_sw[1]|l_sw[2]|l_sw[3]|l_sw[4]|l_sw[5]|l_sw[6]|l_sw[7]|l_sw[8]|l_sw[9]|vc|vdd|vss|z
+ in_l_sw[2]|x
+ BOTTOM|TOP|h_sw[0]|h_sw[10]|h_sw[1]|h_sw[2]|h_sw[3]|h_sw[4]|h_sw[5]|h_sw[6]|h_sw[7]|h_sw[8]|h_sw[9]|l_sw[0]|l_sw[10]|l_sw[1]|l_sw[2]|l_sw[3]|l_sw[4]|l_sw[5]|l_sw[6]|l_sw[7]|l_sw[8]|l_sw[9]|vc|vdd|vss|z
+ \$1 sg13_lv_nmos L=0.13u W=0.5u AS=0.095p AD=0.095p PS=0.88u PD=0.88u rfmode=0
M$131
+ BOTTOM|TOP|h_sw[0]|h_sw[10]|h_sw[1]|h_sw[2]|h_sw[3]|h_sw[4]|h_sw[5]|h_sw[6]|h_sw[7]|h_sw[8]|h_sw[9]|l_sw[0]|l_sw[10]|l_sw[1]|l_sw[2]|l_sw[3]|l_sw[4]|l_sw[5]|l_sw[6]|l_sw[7]|l_sw[8]|l_sw[9]|vc|vdd|vss|z
+ in_l_sw[2]|x
+ BOTTOM|TOP|h_sw[0]|h_sw[10]|h_sw[1]|h_sw[2]|h_sw[3]|h_sw[4]|h_sw[5]|h_sw[6]|h_sw[7]|h_sw[8]|h_sw[9]|l_sw[0]|l_sw[10]|l_sw[1]|l_sw[2]|l_sw[3]|l_sw[4]|l_sw[5]|l_sw[6]|l_sw[7]|l_sw[8]|l_sw[9]|vc|vdd|vss|z
+ \$1 sg13_lv_nmos L=0.13u W=0.5u AS=0.095p AD=0.095p PS=0.88u PD=0.88u rfmode=0
M$132
+ BOTTOM|TOP|h_sw[0]|h_sw[10]|h_sw[1]|h_sw[2]|h_sw[3]|h_sw[4]|h_sw[5]|h_sw[6]|h_sw[7]|h_sw[8]|h_sw[9]|l_sw[0]|l_sw[10]|l_sw[1]|l_sw[2]|l_sw[3]|l_sw[4]|l_sw[5]|l_sw[6]|l_sw[7]|l_sw[8]|l_sw[9]|vc|vdd|vss|z
+ in_l_sw[2]|x
+ BOTTOM|TOP|h_sw[0]|h_sw[10]|h_sw[1]|h_sw[2]|h_sw[3]|h_sw[4]|h_sw[5]|h_sw[6]|h_sw[7]|h_sw[8]|h_sw[9]|l_sw[0]|l_sw[10]|l_sw[1]|l_sw[2]|l_sw[3]|l_sw[4]|l_sw[5]|l_sw[6]|l_sw[7]|l_sw[8]|l_sw[9]|vc|vdd|vss|z
+ \$1 sg13_lv_nmos L=0.13u W=0.5u AS=0.095p AD=0.095p PS=0.88u PD=0.88u rfmode=0
M$133
+ BOTTOM|TOP|h_sw[0]|h_sw[10]|h_sw[1]|h_sw[2]|h_sw[3]|h_sw[4]|h_sw[5]|h_sw[6]|h_sw[7]|h_sw[8]|h_sw[9]|l_sw[0]|l_sw[10]|l_sw[1]|l_sw[2]|l_sw[3]|l_sw[4]|l_sw[5]|l_sw[6]|l_sw[7]|l_sw[8]|l_sw[9]|vc|vdd|vss|z
+ in_l_sw[2]|x
+ BOTTOM|TOP|h_sw[0]|h_sw[10]|h_sw[1]|h_sw[2]|h_sw[3]|h_sw[4]|h_sw[5]|h_sw[6]|h_sw[7]|h_sw[8]|h_sw[9]|l_sw[0]|l_sw[10]|l_sw[1]|l_sw[2]|l_sw[3]|l_sw[4]|l_sw[5]|l_sw[6]|l_sw[7]|l_sw[8]|l_sw[9]|vc|vdd|vss|z
+ \$1 sg13_lv_nmos L=0.13u W=0.5u AS=0.095p AD=0.095p PS=0.88u PD=0.88u rfmode=0
M$134
+ BOTTOM|TOP|h_sw[0]|h_sw[10]|h_sw[1]|h_sw[2]|h_sw[3]|h_sw[4]|h_sw[5]|h_sw[6]|h_sw[7]|h_sw[8]|h_sw[9]|l_sw[0]|l_sw[10]|l_sw[1]|l_sw[2]|l_sw[3]|l_sw[4]|l_sw[5]|l_sw[6]|l_sw[7]|l_sw[8]|l_sw[9]|vc|vdd|vss|z
+ in_l_sw[2]|x
+ BOTTOM|TOP|h_sw[0]|h_sw[10]|h_sw[1]|h_sw[2]|h_sw[3]|h_sw[4]|h_sw[5]|h_sw[6]|h_sw[7]|h_sw[8]|h_sw[9]|l_sw[0]|l_sw[10]|l_sw[1]|l_sw[2]|l_sw[3]|l_sw[4]|l_sw[5]|l_sw[6]|l_sw[7]|l_sw[8]|l_sw[9]|vc|vdd|vss|z
+ \$1 sg13_lv_nmos L=0.13u W=0.5u AS=0.095p AD=0.095p PS=0.88u PD=0.88u rfmode=0
M$135
+ BOTTOM|TOP|h_sw[0]|h_sw[10]|h_sw[1]|h_sw[2]|h_sw[3]|h_sw[4]|h_sw[5]|h_sw[6]|h_sw[7]|h_sw[8]|h_sw[9]|l_sw[0]|l_sw[10]|l_sw[1]|l_sw[2]|l_sw[3]|l_sw[4]|l_sw[5]|l_sw[6]|l_sw[7]|l_sw[8]|l_sw[9]|vc|vdd|vss|z
+ in_l_sw[2]|x
+ BOTTOM|TOP|h_sw[0]|h_sw[10]|h_sw[1]|h_sw[2]|h_sw[3]|h_sw[4]|h_sw[5]|h_sw[6]|h_sw[7]|h_sw[8]|h_sw[9]|l_sw[0]|l_sw[10]|l_sw[1]|l_sw[2]|l_sw[3]|l_sw[4]|l_sw[5]|l_sw[6]|l_sw[7]|l_sw[8]|l_sw[9]|vc|vdd|vss|z
+ \$1 sg13_lv_nmos L=0.13u W=0.5u AS=0.095p AD=0.095p PS=0.88u PD=0.88u rfmode=0
M$136
+ BOTTOM|TOP|h_sw[0]|h_sw[10]|h_sw[1]|h_sw[2]|h_sw[3]|h_sw[4]|h_sw[5]|h_sw[6]|h_sw[7]|h_sw[8]|h_sw[9]|l_sw[0]|l_sw[10]|l_sw[1]|l_sw[2]|l_sw[3]|l_sw[4]|l_sw[5]|l_sw[6]|l_sw[7]|l_sw[8]|l_sw[9]|vc|vdd|vss|z
+ in_l_sw[2]|x
+ BOTTOM|TOP|h_sw[0]|h_sw[10]|h_sw[1]|h_sw[2]|h_sw[3]|h_sw[4]|h_sw[5]|h_sw[6]|h_sw[7]|h_sw[8]|h_sw[9]|l_sw[0]|l_sw[10]|l_sw[1]|l_sw[2]|l_sw[3]|l_sw[4]|l_sw[5]|l_sw[6]|l_sw[7]|l_sw[8]|l_sw[9]|vc|vdd|vss|z
+ \$1 sg13_lv_nmos L=0.13u W=0.5u AS=0.095p AD=0.17p PS=0.88u PD=1.68u rfmode=0
M$137
+ BOTTOM|TOP|h_sw[0]|h_sw[10]|h_sw[1]|h_sw[2]|h_sw[3]|h_sw[4]|h_sw[5]|h_sw[6]|h_sw[7]|h_sw[8]|h_sw[9]|l_sw[0]|l_sw[10]|l_sw[1]|l_sw[2]|l_sw[3]|l_sw[4]|l_sw[5]|l_sw[6]|l_sw[7]|l_sw[8]|l_sw[9]|vc|vdd|vss|z
+ in_h_sw[2]|x
+ BOTTOM|TOP|h_sw[0]|h_sw[10]|h_sw[1]|h_sw[2]|h_sw[3]|h_sw[4]|h_sw[5]|h_sw[6]|h_sw[7]|h_sw[8]|h_sw[9]|l_sw[0]|l_sw[10]|l_sw[1]|l_sw[2]|l_sw[3]|l_sw[4]|l_sw[5]|l_sw[6]|l_sw[7]|l_sw[8]|l_sw[9]|vc|vdd|vss|z
+ \$1 sg13_lv_nmos L=0.13u W=0.5u AS=0.17p AD=0.095p PS=1.68u PD=0.88u rfmode=0
M$138
+ BOTTOM|TOP|h_sw[0]|h_sw[10]|h_sw[1]|h_sw[2]|h_sw[3]|h_sw[4]|h_sw[5]|h_sw[6]|h_sw[7]|h_sw[8]|h_sw[9]|l_sw[0]|l_sw[10]|l_sw[1]|l_sw[2]|l_sw[3]|l_sw[4]|l_sw[5]|l_sw[6]|l_sw[7]|l_sw[8]|l_sw[9]|vc|vdd|vss|z
+ in_h_sw[2]|x
+ BOTTOM|TOP|h_sw[0]|h_sw[10]|h_sw[1]|h_sw[2]|h_sw[3]|h_sw[4]|h_sw[5]|h_sw[6]|h_sw[7]|h_sw[8]|h_sw[9]|l_sw[0]|l_sw[10]|l_sw[1]|l_sw[2]|l_sw[3]|l_sw[4]|l_sw[5]|l_sw[6]|l_sw[7]|l_sw[8]|l_sw[9]|vc|vdd|vss|z
+ \$1 sg13_lv_nmos L=0.13u W=0.5u AS=0.095p AD=0.095p PS=0.88u PD=0.88u rfmode=0
M$139
+ BOTTOM|TOP|h_sw[0]|h_sw[10]|h_sw[1]|h_sw[2]|h_sw[3]|h_sw[4]|h_sw[5]|h_sw[6]|h_sw[7]|h_sw[8]|h_sw[9]|l_sw[0]|l_sw[10]|l_sw[1]|l_sw[2]|l_sw[3]|l_sw[4]|l_sw[5]|l_sw[6]|l_sw[7]|l_sw[8]|l_sw[9]|vc|vdd|vss|z
+ in_h_sw[2]|x
+ BOTTOM|TOP|h_sw[0]|h_sw[10]|h_sw[1]|h_sw[2]|h_sw[3]|h_sw[4]|h_sw[5]|h_sw[6]|h_sw[7]|h_sw[8]|h_sw[9]|l_sw[0]|l_sw[10]|l_sw[1]|l_sw[2]|l_sw[3]|l_sw[4]|l_sw[5]|l_sw[6]|l_sw[7]|l_sw[8]|l_sw[9]|vc|vdd|vss|z
+ \$1 sg13_lv_nmos L=0.13u W=0.5u AS=0.095p AD=0.095p PS=0.88u PD=0.88u rfmode=0
M$140
+ BOTTOM|TOP|h_sw[0]|h_sw[10]|h_sw[1]|h_sw[2]|h_sw[3]|h_sw[4]|h_sw[5]|h_sw[6]|h_sw[7]|h_sw[8]|h_sw[9]|l_sw[0]|l_sw[10]|l_sw[1]|l_sw[2]|l_sw[3]|l_sw[4]|l_sw[5]|l_sw[6]|l_sw[7]|l_sw[8]|l_sw[9]|vc|vdd|vss|z
+ in_h_sw[2]|x
+ BOTTOM|TOP|h_sw[0]|h_sw[10]|h_sw[1]|h_sw[2]|h_sw[3]|h_sw[4]|h_sw[5]|h_sw[6]|h_sw[7]|h_sw[8]|h_sw[9]|l_sw[0]|l_sw[10]|l_sw[1]|l_sw[2]|l_sw[3]|l_sw[4]|l_sw[5]|l_sw[6]|l_sw[7]|l_sw[8]|l_sw[9]|vc|vdd|vss|z
+ \$1 sg13_lv_nmos L=0.13u W=0.5u AS=0.095p AD=0.095p PS=0.88u PD=0.88u rfmode=0
M$141
+ BOTTOM|TOP|h_sw[0]|h_sw[10]|h_sw[1]|h_sw[2]|h_sw[3]|h_sw[4]|h_sw[5]|h_sw[6]|h_sw[7]|h_sw[8]|h_sw[9]|l_sw[0]|l_sw[10]|l_sw[1]|l_sw[2]|l_sw[3]|l_sw[4]|l_sw[5]|l_sw[6]|l_sw[7]|l_sw[8]|l_sw[9]|vc|vdd|vss|z
+ in_h_sw[2]|x
+ BOTTOM|TOP|h_sw[0]|h_sw[10]|h_sw[1]|h_sw[2]|h_sw[3]|h_sw[4]|h_sw[5]|h_sw[6]|h_sw[7]|h_sw[8]|h_sw[9]|l_sw[0]|l_sw[10]|l_sw[1]|l_sw[2]|l_sw[3]|l_sw[4]|l_sw[5]|l_sw[6]|l_sw[7]|l_sw[8]|l_sw[9]|vc|vdd|vss|z
+ \$1 sg13_lv_nmos L=0.13u W=0.5u AS=0.095p AD=0.095p PS=0.88u PD=0.88u rfmode=0
M$142
+ BOTTOM|TOP|h_sw[0]|h_sw[10]|h_sw[1]|h_sw[2]|h_sw[3]|h_sw[4]|h_sw[5]|h_sw[6]|h_sw[7]|h_sw[8]|h_sw[9]|l_sw[0]|l_sw[10]|l_sw[1]|l_sw[2]|l_sw[3]|l_sw[4]|l_sw[5]|l_sw[6]|l_sw[7]|l_sw[8]|l_sw[9]|vc|vdd|vss|z
+ in_h_sw[2]|x
+ BOTTOM|TOP|h_sw[0]|h_sw[10]|h_sw[1]|h_sw[2]|h_sw[3]|h_sw[4]|h_sw[5]|h_sw[6]|h_sw[7]|h_sw[8]|h_sw[9]|l_sw[0]|l_sw[10]|l_sw[1]|l_sw[2]|l_sw[3]|l_sw[4]|l_sw[5]|l_sw[6]|l_sw[7]|l_sw[8]|l_sw[9]|vc|vdd|vss|z
+ \$1 sg13_lv_nmos L=0.13u W=0.5u AS=0.095p AD=0.095p PS=0.88u PD=0.88u rfmode=0
M$143
+ BOTTOM|TOP|h_sw[0]|h_sw[10]|h_sw[1]|h_sw[2]|h_sw[3]|h_sw[4]|h_sw[5]|h_sw[6]|h_sw[7]|h_sw[8]|h_sw[9]|l_sw[0]|l_sw[10]|l_sw[1]|l_sw[2]|l_sw[3]|l_sw[4]|l_sw[5]|l_sw[6]|l_sw[7]|l_sw[8]|l_sw[9]|vc|vdd|vss|z
+ in_h_sw[2]|x
+ BOTTOM|TOP|h_sw[0]|h_sw[10]|h_sw[1]|h_sw[2]|h_sw[3]|h_sw[4]|h_sw[5]|h_sw[6]|h_sw[7]|h_sw[8]|h_sw[9]|l_sw[0]|l_sw[10]|l_sw[1]|l_sw[2]|l_sw[3]|l_sw[4]|l_sw[5]|l_sw[6]|l_sw[7]|l_sw[8]|l_sw[9]|vc|vdd|vss|z
+ \$1 sg13_lv_nmos L=0.13u W=0.5u AS=0.095p AD=0.095p PS=0.88u PD=0.88u rfmode=0
M$144
+ BOTTOM|TOP|h_sw[0]|h_sw[10]|h_sw[1]|h_sw[2]|h_sw[3]|h_sw[4]|h_sw[5]|h_sw[6]|h_sw[7]|h_sw[8]|h_sw[9]|l_sw[0]|l_sw[10]|l_sw[1]|l_sw[2]|l_sw[3]|l_sw[4]|l_sw[5]|l_sw[6]|l_sw[7]|l_sw[8]|l_sw[9]|vc|vdd|vss|z
+ in_h_sw[2]|x
+ BOTTOM|TOP|h_sw[0]|h_sw[10]|h_sw[1]|h_sw[2]|h_sw[3]|h_sw[4]|h_sw[5]|h_sw[6]|h_sw[7]|h_sw[8]|h_sw[9]|l_sw[0]|l_sw[10]|l_sw[1]|l_sw[2]|l_sw[3]|l_sw[4]|l_sw[5]|l_sw[6]|l_sw[7]|l_sw[8]|l_sw[9]|vc|vdd|vss|z
+ \$1 sg13_lv_nmos L=0.13u W=0.5u AS=0.095p AD=0.095p PS=0.88u PD=0.88u rfmode=0
M$145
+ BOTTOM|TOP|h_sw[0]|h_sw[10]|h_sw[1]|h_sw[2]|h_sw[3]|h_sw[4]|h_sw[5]|h_sw[6]|h_sw[7]|h_sw[8]|h_sw[9]|l_sw[0]|l_sw[10]|l_sw[1]|l_sw[2]|l_sw[3]|l_sw[4]|l_sw[5]|l_sw[6]|l_sw[7]|l_sw[8]|l_sw[9]|vc|vdd|vss|z
+ in_h_sw[2]|x
+ BOTTOM|TOP|h_sw[0]|h_sw[10]|h_sw[1]|h_sw[2]|h_sw[3]|h_sw[4]|h_sw[5]|h_sw[6]|h_sw[7]|h_sw[8]|h_sw[9]|l_sw[0]|l_sw[10]|l_sw[1]|l_sw[2]|l_sw[3]|l_sw[4]|l_sw[5]|l_sw[6]|l_sw[7]|l_sw[8]|l_sw[9]|vc|vdd|vss|z
+ \$1 sg13_lv_nmos L=0.13u W=0.5u AS=0.095p AD=0.095p PS=0.88u PD=0.88u rfmode=0
M$146
+ BOTTOM|TOP|h_sw[0]|h_sw[10]|h_sw[1]|h_sw[2]|h_sw[3]|h_sw[4]|h_sw[5]|h_sw[6]|h_sw[7]|h_sw[8]|h_sw[9]|l_sw[0]|l_sw[10]|l_sw[1]|l_sw[2]|l_sw[3]|l_sw[4]|l_sw[5]|l_sw[6]|l_sw[7]|l_sw[8]|l_sw[9]|vc|vdd|vss|z
+ in_h_sw[2]|x
+ BOTTOM|TOP|h_sw[0]|h_sw[10]|h_sw[1]|h_sw[2]|h_sw[3]|h_sw[4]|h_sw[5]|h_sw[6]|h_sw[7]|h_sw[8]|h_sw[9]|l_sw[0]|l_sw[10]|l_sw[1]|l_sw[2]|l_sw[3]|l_sw[4]|l_sw[5]|l_sw[6]|l_sw[7]|l_sw[8]|l_sw[9]|vc|vdd|vss|z
+ \$1 sg13_lv_nmos L=0.13u W=0.5u AS=0.095p AD=0.095p PS=0.88u PD=0.88u rfmode=0
M$147
+ BOTTOM|TOP|h_sw[0]|h_sw[10]|h_sw[1]|h_sw[2]|h_sw[3]|h_sw[4]|h_sw[5]|h_sw[6]|h_sw[7]|h_sw[8]|h_sw[9]|l_sw[0]|l_sw[10]|l_sw[1]|l_sw[2]|l_sw[3]|l_sw[4]|l_sw[5]|l_sw[6]|l_sw[7]|l_sw[8]|l_sw[9]|vc|vdd|vss|z
+ in_h_sw[2]|x
+ BOTTOM|TOP|h_sw[0]|h_sw[10]|h_sw[1]|h_sw[2]|h_sw[3]|h_sw[4]|h_sw[5]|h_sw[6]|h_sw[7]|h_sw[8]|h_sw[9]|l_sw[0]|l_sw[10]|l_sw[1]|l_sw[2]|l_sw[3]|l_sw[4]|l_sw[5]|l_sw[6]|l_sw[7]|l_sw[8]|l_sw[9]|vc|vdd|vss|z
+ \$1 sg13_lv_nmos L=0.13u W=0.5u AS=0.095p AD=0.095p PS=0.88u PD=0.88u rfmode=0
M$148
+ BOTTOM|TOP|h_sw[0]|h_sw[10]|h_sw[1]|h_sw[2]|h_sw[3]|h_sw[4]|h_sw[5]|h_sw[6]|h_sw[7]|h_sw[8]|h_sw[9]|l_sw[0]|l_sw[10]|l_sw[1]|l_sw[2]|l_sw[3]|l_sw[4]|l_sw[5]|l_sw[6]|l_sw[7]|l_sw[8]|l_sw[9]|vc|vdd|vss|z
+ in_h_sw[2]|x
+ BOTTOM|TOP|h_sw[0]|h_sw[10]|h_sw[1]|h_sw[2]|h_sw[3]|h_sw[4]|h_sw[5]|h_sw[6]|h_sw[7]|h_sw[8]|h_sw[9]|l_sw[0]|l_sw[10]|l_sw[1]|l_sw[2]|l_sw[3]|l_sw[4]|l_sw[5]|l_sw[6]|l_sw[7]|l_sw[8]|l_sw[9]|vc|vdd|vss|z
+ \$1 sg13_lv_nmos L=0.13u W=0.5u AS=0.095p AD=0.095p PS=0.88u PD=0.88u rfmode=0
M$149
+ BOTTOM|TOP|h_sw[0]|h_sw[10]|h_sw[1]|h_sw[2]|h_sw[3]|h_sw[4]|h_sw[5]|h_sw[6]|h_sw[7]|h_sw[8]|h_sw[9]|l_sw[0]|l_sw[10]|l_sw[1]|l_sw[2]|l_sw[3]|l_sw[4]|l_sw[5]|l_sw[6]|l_sw[7]|l_sw[8]|l_sw[9]|vc|vdd|vss|z
+ in_h_sw[2]|x
+ BOTTOM|TOP|h_sw[0]|h_sw[10]|h_sw[1]|h_sw[2]|h_sw[3]|h_sw[4]|h_sw[5]|h_sw[6]|h_sw[7]|h_sw[8]|h_sw[9]|l_sw[0]|l_sw[10]|l_sw[1]|l_sw[2]|l_sw[3]|l_sw[4]|l_sw[5]|l_sw[6]|l_sw[7]|l_sw[8]|l_sw[9]|vc|vdd|vss|z
+ \$1 sg13_lv_nmos L=0.13u W=0.5u AS=0.095p AD=0.095p PS=0.88u PD=0.88u rfmode=0
M$150
+ BOTTOM|TOP|h_sw[0]|h_sw[10]|h_sw[1]|h_sw[2]|h_sw[3]|h_sw[4]|h_sw[5]|h_sw[6]|h_sw[7]|h_sw[8]|h_sw[9]|l_sw[0]|l_sw[10]|l_sw[1]|l_sw[2]|l_sw[3]|l_sw[4]|l_sw[5]|l_sw[6]|l_sw[7]|l_sw[8]|l_sw[9]|vc|vdd|vss|z
+ in_h_sw[2]|x
+ BOTTOM|TOP|h_sw[0]|h_sw[10]|h_sw[1]|h_sw[2]|h_sw[3]|h_sw[4]|h_sw[5]|h_sw[6]|h_sw[7]|h_sw[8]|h_sw[9]|l_sw[0]|l_sw[10]|l_sw[1]|l_sw[2]|l_sw[3]|l_sw[4]|l_sw[5]|l_sw[6]|l_sw[7]|l_sw[8]|l_sw[9]|vc|vdd|vss|z
+ \$1 sg13_lv_nmos L=0.13u W=0.5u AS=0.095p AD=0.095p PS=0.88u PD=0.88u rfmode=0
M$151
+ BOTTOM|TOP|h_sw[0]|h_sw[10]|h_sw[1]|h_sw[2]|h_sw[3]|h_sw[4]|h_sw[5]|h_sw[6]|h_sw[7]|h_sw[8]|h_sw[9]|l_sw[0]|l_sw[10]|l_sw[1]|l_sw[2]|l_sw[3]|l_sw[4]|l_sw[5]|l_sw[6]|l_sw[7]|l_sw[8]|l_sw[9]|vc|vdd|vss|z
+ in_h_sw[2]|x
+ BOTTOM|TOP|h_sw[0]|h_sw[10]|h_sw[1]|h_sw[2]|h_sw[3]|h_sw[4]|h_sw[5]|h_sw[6]|h_sw[7]|h_sw[8]|h_sw[9]|l_sw[0]|l_sw[10]|l_sw[1]|l_sw[2]|l_sw[3]|l_sw[4]|l_sw[5]|l_sw[6]|l_sw[7]|l_sw[8]|l_sw[9]|vc|vdd|vss|z
+ \$1 sg13_lv_nmos L=0.13u W=0.5u AS=0.095p AD=0.095p PS=0.88u PD=0.88u rfmode=0
M$152
+ BOTTOM|TOP|h_sw[0]|h_sw[10]|h_sw[1]|h_sw[2]|h_sw[3]|h_sw[4]|h_sw[5]|h_sw[6]|h_sw[7]|h_sw[8]|h_sw[9]|l_sw[0]|l_sw[10]|l_sw[1]|l_sw[2]|l_sw[3]|l_sw[4]|l_sw[5]|l_sw[6]|l_sw[7]|l_sw[8]|l_sw[9]|vc|vdd|vss|z
+ in_h_sw[2]|x
+ BOTTOM|TOP|h_sw[0]|h_sw[10]|h_sw[1]|h_sw[2]|h_sw[3]|h_sw[4]|h_sw[5]|h_sw[6]|h_sw[7]|h_sw[8]|h_sw[9]|l_sw[0]|l_sw[10]|l_sw[1]|l_sw[2]|l_sw[3]|l_sw[4]|l_sw[5]|l_sw[6]|l_sw[7]|l_sw[8]|l_sw[9]|vc|vdd|vss|z
+ \$1 sg13_lv_nmos L=0.13u W=0.5u AS=0.095p AD=0.17p PS=0.88u PD=1.68u rfmode=0
M$153
+ BOTTOM|TOP|h_sw[0]|h_sw[10]|h_sw[1]|h_sw[2]|h_sw[3]|h_sw[4]|h_sw[5]|h_sw[6]|h_sw[7]|h_sw[8]|h_sw[9]|l_sw[0]|l_sw[10]|l_sw[1]|l_sw[2]|l_sw[3]|l_sw[4]|l_sw[5]|l_sw[6]|l_sw[7]|l_sw[8]|l_sw[9]|vc|vdd|vss|z
+ in_h_sw[6]|x
+ BOTTOM|TOP|h_sw[0]|h_sw[10]|h_sw[1]|h_sw[2]|h_sw[3]|h_sw[4]|h_sw[5]|h_sw[6]|h_sw[7]|h_sw[8]|h_sw[9]|l_sw[0]|l_sw[10]|l_sw[1]|l_sw[2]|l_sw[3]|l_sw[4]|l_sw[5]|l_sw[6]|l_sw[7]|l_sw[8]|l_sw[9]|vc|vdd|vss|z
+ \$1 sg13_lv_nmos L=0.13u W=0.5u AS=0.17p AD=0.095p PS=1.68u PD=0.88u rfmode=0
M$154
+ BOTTOM|TOP|h_sw[0]|h_sw[10]|h_sw[1]|h_sw[2]|h_sw[3]|h_sw[4]|h_sw[5]|h_sw[6]|h_sw[7]|h_sw[8]|h_sw[9]|l_sw[0]|l_sw[10]|l_sw[1]|l_sw[2]|l_sw[3]|l_sw[4]|l_sw[5]|l_sw[6]|l_sw[7]|l_sw[8]|l_sw[9]|vc|vdd|vss|z
+ in_h_sw[6]|x
+ BOTTOM|TOP|h_sw[0]|h_sw[10]|h_sw[1]|h_sw[2]|h_sw[3]|h_sw[4]|h_sw[5]|h_sw[6]|h_sw[7]|h_sw[8]|h_sw[9]|l_sw[0]|l_sw[10]|l_sw[1]|l_sw[2]|l_sw[3]|l_sw[4]|l_sw[5]|l_sw[6]|l_sw[7]|l_sw[8]|l_sw[9]|vc|vdd|vss|z
+ \$1 sg13_lv_nmos L=0.13u W=0.5u AS=0.095p AD=0.095p PS=0.88u PD=0.88u rfmode=0
M$155
+ BOTTOM|TOP|h_sw[0]|h_sw[10]|h_sw[1]|h_sw[2]|h_sw[3]|h_sw[4]|h_sw[5]|h_sw[6]|h_sw[7]|h_sw[8]|h_sw[9]|l_sw[0]|l_sw[10]|l_sw[1]|l_sw[2]|l_sw[3]|l_sw[4]|l_sw[5]|l_sw[6]|l_sw[7]|l_sw[8]|l_sw[9]|vc|vdd|vss|z
+ in_h_sw[6]|x
+ BOTTOM|TOP|h_sw[0]|h_sw[10]|h_sw[1]|h_sw[2]|h_sw[3]|h_sw[4]|h_sw[5]|h_sw[6]|h_sw[7]|h_sw[8]|h_sw[9]|l_sw[0]|l_sw[10]|l_sw[1]|l_sw[2]|l_sw[3]|l_sw[4]|l_sw[5]|l_sw[6]|l_sw[7]|l_sw[8]|l_sw[9]|vc|vdd|vss|z
+ \$1 sg13_lv_nmos L=0.13u W=0.5u AS=0.095p AD=0.095p PS=0.88u PD=0.88u rfmode=0
M$156
+ BOTTOM|TOP|h_sw[0]|h_sw[10]|h_sw[1]|h_sw[2]|h_sw[3]|h_sw[4]|h_sw[5]|h_sw[6]|h_sw[7]|h_sw[8]|h_sw[9]|l_sw[0]|l_sw[10]|l_sw[1]|l_sw[2]|l_sw[3]|l_sw[4]|l_sw[5]|l_sw[6]|l_sw[7]|l_sw[8]|l_sw[9]|vc|vdd|vss|z
+ in_h_sw[6]|x
+ BOTTOM|TOP|h_sw[0]|h_sw[10]|h_sw[1]|h_sw[2]|h_sw[3]|h_sw[4]|h_sw[5]|h_sw[6]|h_sw[7]|h_sw[8]|h_sw[9]|l_sw[0]|l_sw[10]|l_sw[1]|l_sw[2]|l_sw[3]|l_sw[4]|l_sw[5]|l_sw[6]|l_sw[7]|l_sw[8]|l_sw[9]|vc|vdd|vss|z
+ \$1 sg13_lv_nmos L=0.13u W=0.5u AS=0.095p AD=0.17p PS=0.88u PD=1.68u rfmode=0
M$157
+ BOTTOM|TOP|h_sw[0]|h_sw[10]|h_sw[1]|h_sw[2]|h_sw[3]|h_sw[4]|h_sw[5]|h_sw[6]|h_sw[7]|h_sw[8]|h_sw[9]|l_sw[0]|l_sw[10]|l_sw[1]|l_sw[2]|l_sw[3]|l_sw[4]|l_sw[5]|l_sw[6]|l_sw[7]|l_sw[8]|l_sw[9]|vc|vdd|vss|z
+ in_h_sw[7]|x
+ BOTTOM|TOP|h_sw[0]|h_sw[10]|h_sw[1]|h_sw[2]|h_sw[3]|h_sw[4]|h_sw[5]|h_sw[6]|h_sw[7]|h_sw[8]|h_sw[9]|l_sw[0]|l_sw[10]|l_sw[1]|l_sw[2]|l_sw[3]|l_sw[4]|l_sw[5]|l_sw[6]|l_sw[7]|l_sw[8]|l_sw[9]|vc|vdd|vss|z
+ \$1 sg13_lv_nmos L=0.13u W=0.5u AS=0.17p AD=0.095p PS=1.68u PD=0.88u rfmode=0
M$158
+ BOTTOM|TOP|h_sw[0]|h_sw[10]|h_sw[1]|h_sw[2]|h_sw[3]|h_sw[4]|h_sw[5]|h_sw[6]|h_sw[7]|h_sw[8]|h_sw[9]|l_sw[0]|l_sw[10]|l_sw[1]|l_sw[2]|l_sw[3]|l_sw[4]|l_sw[5]|l_sw[6]|l_sw[7]|l_sw[8]|l_sw[9]|vc|vdd|vss|z
+ in_h_sw[7]|x
+ BOTTOM|TOP|h_sw[0]|h_sw[10]|h_sw[1]|h_sw[2]|h_sw[3]|h_sw[4]|h_sw[5]|h_sw[6]|h_sw[7]|h_sw[8]|h_sw[9]|l_sw[0]|l_sw[10]|l_sw[1]|l_sw[2]|l_sw[3]|l_sw[4]|l_sw[5]|l_sw[6]|l_sw[7]|l_sw[8]|l_sw[9]|vc|vdd|vss|z
+ \$1 sg13_lv_nmos L=0.13u W=0.5u AS=0.095p AD=0.095p PS=0.88u PD=0.88u rfmode=0
M$159
+ BOTTOM|TOP|h_sw[0]|h_sw[10]|h_sw[1]|h_sw[2]|h_sw[3]|h_sw[4]|h_sw[5]|h_sw[6]|h_sw[7]|h_sw[8]|h_sw[9]|l_sw[0]|l_sw[10]|l_sw[1]|l_sw[2]|l_sw[3]|l_sw[4]|l_sw[5]|l_sw[6]|l_sw[7]|l_sw[8]|l_sw[9]|vc|vdd|vss|z
+ in_h_sw[7]|x
+ BOTTOM|TOP|h_sw[0]|h_sw[10]|h_sw[1]|h_sw[2]|h_sw[3]|h_sw[4]|h_sw[5]|h_sw[6]|h_sw[7]|h_sw[8]|h_sw[9]|l_sw[0]|l_sw[10]|l_sw[1]|l_sw[2]|l_sw[3]|l_sw[4]|l_sw[5]|l_sw[6]|l_sw[7]|l_sw[8]|l_sw[9]|vc|vdd|vss|z
+ \$1 sg13_lv_nmos L=0.13u W=0.5u AS=0.095p AD=0.095p PS=0.88u PD=0.88u rfmode=0
M$160
+ BOTTOM|TOP|h_sw[0]|h_sw[10]|h_sw[1]|h_sw[2]|h_sw[3]|h_sw[4]|h_sw[5]|h_sw[6]|h_sw[7]|h_sw[8]|h_sw[9]|l_sw[0]|l_sw[10]|l_sw[1]|l_sw[2]|l_sw[3]|l_sw[4]|l_sw[5]|l_sw[6]|l_sw[7]|l_sw[8]|l_sw[9]|vc|vdd|vss|z
+ in_h_sw[7]|x
+ BOTTOM|TOP|h_sw[0]|h_sw[10]|h_sw[1]|h_sw[2]|h_sw[3]|h_sw[4]|h_sw[5]|h_sw[6]|h_sw[7]|h_sw[8]|h_sw[9]|l_sw[0]|l_sw[10]|l_sw[1]|l_sw[2]|l_sw[3]|l_sw[4]|l_sw[5]|l_sw[6]|l_sw[7]|l_sw[8]|l_sw[9]|vc|vdd|vss|z
+ \$1 sg13_lv_nmos L=0.13u W=0.5u AS=0.095p AD=0.17p PS=0.88u PD=1.68u rfmode=0
M$161
+ BOTTOM|TOP|h_sw[0]|h_sw[10]|h_sw[1]|h_sw[2]|h_sw[3]|h_sw[4]|h_sw[5]|h_sw[6]|h_sw[7]|h_sw[8]|h_sw[9]|l_sw[0]|l_sw[10]|l_sw[1]|l_sw[2]|l_sw[3]|l_sw[4]|l_sw[5]|l_sw[6]|l_sw[7]|l_sw[8]|l_sw[9]|vc|vdd|vss|z
+ in_h_sw[8]|x
+ BOTTOM|TOP|h_sw[0]|h_sw[10]|h_sw[1]|h_sw[2]|h_sw[3]|h_sw[4]|h_sw[5]|h_sw[6]|h_sw[7]|h_sw[8]|h_sw[9]|l_sw[0]|l_sw[10]|l_sw[1]|l_sw[2]|l_sw[3]|l_sw[4]|l_sw[5]|l_sw[6]|l_sw[7]|l_sw[8]|l_sw[9]|vc|vdd|vss|z
+ \$1 sg13_lv_nmos L=0.13u W=0.5u AS=0.17p AD=0.095p PS=1.68u PD=0.88u rfmode=0
M$162
+ BOTTOM|TOP|h_sw[0]|h_sw[10]|h_sw[1]|h_sw[2]|h_sw[3]|h_sw[4]|h_sw[5]|h_sw[6]|h_sw[7]|h_sw[8]|h_sw[9]|l_sw[0]|l_sw[10]|l_sw[1]|l_sw[2]|l_sw[3]|l_sw[4]|l_sw[5]|l_sw[6]|l_sw[7]|l_sw[8]|l_sw[9]|vc|vdd|vss|z
+ in_h_sw[8]|x
+ BOTTOM|TOP|h_sw[0]|h_sw[10]|h_sw[1]|h_sw[2]|h_sw[3]|h_sw[4]|h_sw[5]|h_sw[6]|h_sw[7]|h_sw[8]|h_sw[9]|l_sw[0]|l_sw[10]|l_sw[1]|l_sw[2]|l_sw[3]|l_sw[4]|l_sw[5]|l_sw[6]|l_sw[7]|l_sw[8]|l_sw[9]|vc|vdd|vss|z
+ \$1 sg13_lv_nmos L=0.13u W=0.5u AS=0.095p AD=0.17p PS=0.88u PD=1.68u rfmode=0
M$163
+ BOTTOM|TOP|h_sw[0]|h_sw[10]|h_sw[1]|h_sw[2]|h_sw[3]|h_sw[4]|h_sw[5]|h_sw[6]|h_sw[7]|h_sw[8]|h_sw[9]|l_sw[0]|l_sw[10]|l_sw[1]|l_sw[2]|l_sw[3]|l_sw[4]|l_sw[5]|l_sw[6]|l_sw[7]|l_sw[8]|l_sw[9]|vc|vdd|vss|z
+ in_h_sw[9]|x
+ BOTTOM|TOP|h_sw[0]|h_sw[10]|h_sw[1]|h_sw[2]|h_sw[3]|h_sw[4]|h_sw[5]|h_sw[6]|h_sw[7]|h_sw[8]|h_sw[9]|l_sw[0]|l_sw[10]|l_sw[1]|l_sw[2]|l_sw[3]|l_sw[4]|l_sw[5]|l_sw[6]|l_sw[7]|l_sw[8]|l_sw[9]|vc|vdd|vss|z
+ \$1 sg13_lv_nmos L=0.13u W=0.5u AS=0.17p AD=0.095p PS=1.68u PD=0.88u rfmode=0
M$164
+ BOTTOM|TOP|h_sw[0]|h_sw[10]|h_sw[1]|h_sw[2]|h_sw[3]|h_sw[4]|h_sw[5]|h_sw[6]|h_sw[7]|h_sw[8]|h_sw[9]|l_sw[0]|l_sw[10]|l_sw[1]|l_sw[2]|l_sw[3]|l_sw[4]|l_sw[5]|l_sw[6]|l_sw[7]|l_sw[8]|l_sw[9]|vc|vdd|vss|z
+ in_h_sw[9]|x
+ BOTTOM|TOP|h_sw[0]|h_sw[10]|h_sw[1]|h_sw[2]|h_sw[3]|h_sw[4]|h_sw[5]|h_sw[6]|h_sw[7]|h_sw[8]|h_sw[9]|l_sw[0]|l_sw[10]|l_sw[1]|l_sw[2]|l_sw[3]|l_sw[4]|l_sw[5]|l_sw[6]|l_sw[7]|l_sw[8]|l_sw[9]|vc|vdd|vss|z
+ \$1 sg13_lv_nmos L=0.13u W=0.5u AS=0.095p AD=0.17p PS=0.88u PD=1.68u rfmode=0
M$165
+ BOTTOM|TOP|h_sw[0]|h_sw[10]|h_sw[1]|h_sw[2]|h_sw[3]|h_sw[4]|h_sw[5]|h_sw[6]|h_sw[7]|h_sw[8]|h_sw[9]|l_sw[0]|l_sw[10]|l_sw[1]|l_sw[2]|l_sw[3]|l_sw[4]|l_sw[5]|l_sw[6]|l_sw[7]|l_sw[8]|l_sw[9]|vc|vdd|vss|z
+ in_l_sw[3]|x
+ BOTTOM|TOP|h_sw[0]|h_sw[10]|h_sw[1]|h_sw[2]|h_sw[3]|h_sw[4]|h_sw[5]|h_sw[6]|h_sw[7]|h_sw[8]|h_sw[9]|l_sw[0]|l_sw[10]|l_sw[1]|l_sw[2]|l_sw[3]|l_sw[4]|l_sw[5]|l_sw[6]|l_sw[7]|l_sw[8]|l_sw[9]|vc|vdd|vss|z
+ \$1 sg13_lv_nmos L=0.13u W=0.5u AS=0.17p AD=0.095p PS=1.68u PD=0.88u rfmode=0
M$166
+ BOTTOM|TOP|h_sw[0]|h_sw[10]|h_sw[1]|h_sw[2]|h_sw[3]|h_sw[4]|h_sw[5]|h_sw[6]|h_sw[7]|h_sw[8]|h_sw[9]|l_sw[0]|l_sw[10]|l_sw[1]|l_sw[2]|l_sw[3]|l_sw[4]|l_sw[5]|l_sw[6]|l_sw[7]|l_sw[8]|l_sw[9]|vc|vdd|vss|z
+ in_l_sw[3]|x
+ BOTTOM|TOP|h_sw[0]|h_sw[10]|h_sw[1]|h_sw[2]|h_sw[3]|h_sw[4]|h_sw[5]|h_sw[6]|h_sw[7]|h_sw[8]|h_sw[9]|l_sw[0]|l_sw[10]|l_sw[1]|l_sw[2]|l_sw[3]|l_sw[4]|l_sw[5]|l_sw[6]|l_sw[7]|l_sw[8]|l_sw[9]|vc|vdd|vss|z
+ \$1 sg13_lv_nmos L=0.13u W=0.5u AS=0.095p AD=0.095p PS=0.88u PD=0.88u rfmode=0
M$167
+ BOTTOM|TOP|h_sw[0]|h_sw[10]|h_sw[1]|h_sw[2]|h_sw[3]|h_sw[4]|h_sw[5]|h_sw[6]|h_sw[7]|h_sw[8]|h_sw[9]|l_sw[0]|l_sw[10]|l_sw[1]|l_sw[2]|l_sw[3]|l_sw[4]|l_sw[5]|l_sw[6]|l_sw[7]|l_sw[8]|l_sw[9]|vc|vdd|vss|z
+ in_l_sw[3]|x
+ BOTTOM|TOP|h_sw[0]|h_sw[10]|h_sw[1]|h_sw[2]|h_sw[3]|h_sw[4]|h_sw[5]|h_sw[6]|h_sw[7]|h_sw[8]|h_sw[9]|l_sw[0]|l_sw[10]|l_sw[1]|l_sw[2]|l_sw[3]|l_sw[4]|l_sw[5]|l_sw[6]|l_sw[7]|l_sw[8]|l_sw[9]|vc|vdd|vss|z
+ \$1 sg13_lv_nmos L=0.13u W=0.5u AS=0.095p AD=0.095p PS=0.88u PD=0.88u rfmode=0
M$168
+ BOTTOM|TOP|h_sw[0]|h_sw[10]|h_sw[1]|h_sw[2]|h_sw[3]|h_sw[4]|h_sw[5]|h_sw[6]|h_sw[7]|h_sw[8]|h_sw[9]|l_sw[0]|l_sw[10]|l_sw[1]|l_sw[2]|l_sw[3]|l_sw[4]|l_sw[5]|l_sw[6]|l_sw[7]|l_sw[8]|l_sw[9]|vc|vdd|vss|z
+ in_l_sw[3]|x
+ BOTTOM|TOP|h_sw[0]|h_sw[10]|h_sw[1]|h_sw[2]|h_sw[3]|h_sw[4]|h_sw[5]|h_sw[6]|h_sw[7]|h_sw[8]|h_sw[9]|l_sw[0]|l_sw[10]|l_sw[1]|l_sw[2]|l_sw[3]|l_sw[4]|l_sw[5]|l_sw[6]|l_sw[7]|l_sw[8]|l_sw[9]|vc|vdd|vss|z
+ \$1 sg13_lv_nmos L=0.13u W=0.5u AS=0.095p AD=0.095p PS=0.88u PD=0.88u rfmode=0
M$169
+ BOTTOM|TOP|h_sw[0]|h_sw[10]|h_sw[1]|h_sw[2]|h_sw[3]|h_sw[4]|h_sw[5]|h_sw[6]|h_sw[7]|h_sw[8]|h_sw[9]|l_sw[0]|l_sw[10]|l_sw[1]|l_sw[2]|l_sw[3]|l_sw[4]|l_sw[5]|l_sw[6]|l_sw[7]|l_sw[8]|l_sw[9]|vc|vdd|vss|z
+ in_l_sw[3]|x
+ BOTTOM|TOP|h_sw[0]|h_sw[10]|h_sw[1]|h_sw[2]|h_sw[3]|h_sw[4]|h_sw[5]|h_sw[6]|h_sw[7]|h_sw[8]|h_sw[9]|l_sw[0]|l_sw[10]|l_sw[1]|l_sw[2]|l_sw[3]|l_sw[4]|l_sw[5]|l_sw[6]|l_sw[7]|l_sw[8]|l_sw[9]|vc|vdd|vss|z
+ \$1 sg13_lv_nmos L=0.13u W=0.5u AS=0.095p AD=0.095p PS=0.88u PD=0.88u rfmode=0
M$170
+ BOTTOM|TOP|h_sw[0]|h_sw[10]|h_sw[1]|h_sw[2]|h_sw[3]|h_sw[4]|h_sw[5]|h_sw[6]|h_sw[7]|h_sw[8]|h_sw[9]|l_sw[0]|l_sw[10]|l_sw[1]|l_sw[2]|l_sw[3]|l_sw[4]|l_sw[5]|l_sw[6]|l_sw[7]|l_sw[8]|l_sw[9]|vc|vdd|vss|z
+ in_l_sw[3]|x
+ BOTTOM|TOP|h_sw[0]|h_sw[10]|h_sw[1]|h_sw[2]|h_sw[3]|h_sw[4]|h_sw[5]|h_sw[6]|h_sw[7]|h_sw[8]|h_sw[9]|l_sw[0]|l_sw[10]|l_sw[1]|l_sw[2]|l_sw[3]|l_sw[4]|l_sw[5]|l_sw[6]|l_sw[7]|l_sw[8]|l_sw[9]|vc|vdd|vss|z
+ \$1 sg13_lv_nmos L=0.13u W=0.5u AS=0.095p AD=0.095p PS=0.88u PD=0.88u rfmode=0
M$171
+ BOTTOM|TOP|h_sw[0]|h_sw[10]|h_sw[1]|h_sw[2]|h_sw[3]|h_sw[4]|h_sw[5]|h_sw[6]|h_sw[7]|h_sw[8]|h_sw[9]|l_sw[0]|l_sw[10]|l_sw[1]|l_sw[2]|l_sw[3]|l_sw[4]|l_sw[5]|l_sw[6]|l_sw[7]|l_sw[8]|l_sw[9]|vc|vdd|vss|z
+ in_l_sw[3]|x
+ BOTTOM|TOP|h_sw[0]|h_sw[10]|h_sw[1]|h_sw[2]|h_sw[3]|h_sw[4]|h_sw[5]|h_sw[6]|h_sw[7]|h_sw[8]|h_sw[9]|l_sw[0]|l_sw[10]|l_sw[1]|l_sw[2]|l_sw[3]|l_sw[4]|l_sw[5]|l_sw[6]|l_sw[7]|l_sw[8]|l_sw[9]|vc|vdd|vss|z
+ \$1 sg13_lv_nmos L=0.13u W=0.5u AS=0.095p AD=0.095p PS=0.88u PD=0.88u rfmode=0
M$172
+ BOTTOM|TOP|h_sw[0]|h_sw[10]|h_sw[1]|h_sw[2]|h_sw[3]|h_sw[4]|h_sw[5]|h_sw[6]|h_sw[7]|h_sw[8]|h_sw[9]|l_sw[0]|l_sw[10]|l_sw[1]|l_sw[2]|l_sw[3]|l_sw[4]|l_sw[5]|l_sw[6]|l_sw[7]|l_sw[8]|l_sw[9]|vc|vdd|vss|z
+ in_l_sw[3]|x
+ BOTTOM|TOP|h_sw[0]|h_sw[10]|h_sw[1]|h_sw[2]|h_sw[3]|h_sw[4]|h_sw[5]|h_sw[6]|h_sw[7]|h_sw[8]|h_sw[9]|l_sw[0]|l_sw[10]|l_sw[1]|l_sw[2]|l_sw[3]|l_sw[4]|l_sw[5]|l_sw[6]|l_sw[7]|l_sw[8]|l_sw[9]|vc|vdd|vss|z
+ \$1 sg13_lv_nmos L=0.13u W=0.5u AS=0.095p AD=0.17p PS=0.88u PD=1.68u rfmode=0
M$173
+ BOTTOM|TOP|h_sw[0]|h_sw[10]|h_sw[1]|h_sw[2]|h_sw[3]|h_sw[4]|h_sw[5]|h_sw[6]|h_sw[7]|h_sw[8]|h_sw[9]|l_sw[0]|l_sw[10]|l_sw[1]|l_sw[2]|l_sw[3]|l_sw[4]|l_sw[5]|l_sw[6]|l_sw[7]|l_sw[8]|l_sw[9]|vc|vdd|vss|z
+ in_l_sw[4]|x
+ BOTTOM|TOP|h_sw[0]|h_sw[10]|h_sw[1]|h_sw[2]|h_sw[3]|h_sw[4]|h_sw[5]|h_sw[6]|h_sw[7]|h_sw[8]|h_sw[9]|l_sw[0]|l_sw[10]|l_sw[1]|l_sw[2]|l_sw[3]|l_sw[4]|l_sw[5]|l_sw[6]|l_sw[7]|l_sw[8]|l_sw[9]|vc|vdd|vss|z
+ \$1 sg13_lv_nmos L=0.13u W=0.5u AS=0.17p AD=0.095p PS=1.68u PD=0.88u rfmode=0
M$174
+ BOTTOM|TOP|h_sw[0]|h_sw[10]|h_sw[1]|h_sw[2]|h_sw[3]|h_sw[4]|h_sw[5]|h_sw[6]|h_sw[7]|h_sw[8]|h_sw[9]|l_sw[0]|l_sw[10]|l_sw[1]|l_sw[2]|l_sw[3]|l_sw[4]|l_sw[5]|l_sw[6]|l_sw[7]|l_sw[8]|l_sw[9]|vc|vdd|vss|z
+ in_l_sw[4]|x
+ BOTTOM|TOP|h_sw[0]|h_sw[10]|h_sw[1]|h_sw[2]|h_sw[3]|h_sw[4]|h_sw[5]|h_sw[6]|h_sw[7]|h_sw[8]|h_sw[9]|l_sw[0]|l_sw[10]|l_sw[1]|l_sw[2]|l_sw[3]|l_sw[4]|l_sw[5]|l_sw[6]|l_sw[7]|l_sw[8]|l_sw[9]|vc|vdd|vss|z
+ \$1 sg13_lv_nmos L=0.13u W=0.5u AS=0.095p AD=0.095p PS=0.88u PD=0.88u rfmode=0
M$175
+ BOTTOM|TOP|h_sw[0]|h_sw[10]|h_sw[1]|h_sw[2]|h_sw[3]|h_sw[4]|h_sw[5]|h_sw[6]|h_sw[7]|h_sw[8]|h_sw[9]|l_sw[0]|l_sw[10]|l_sw[1]|l_sw[2]|l_sw[3]|l_sw[4]|l_sw[5]|l_sw[6]|l_sw[7]|l_sw[8]|l_sw[9]|vc|vdd|vss|z
+ in_l_sw[4]|x
+ BOTTOM|TOP|h_sw[0]|h_sw[10]|h_sw[1]|h_sw[2]|h_sw[3]|h_sw[4]|h_sw[5]|h_sw[6]|h_sw[7]|h_sw[8]|h_sw[9]|l_sw[0]|l_sw[10]|l_sw[1]|l_sw[2]|l_sw[3]|l_sw[4]|l_sw[5]|l_sw[6]|l_sw[7]|l_sw[8]|l_sw[9]|vc|vdd|vss|z
+ \$1 sg13_lv_nmos L=0.13u W=0.5u AS=0.095p AD=0.095p PS=0.88u PD=0.88u rfmode=0
M$176
+ BOTTOM|TOP|h_sw[0]|h_sw[10]|h_sw[1]|h_sw[2]|h_sw[3]|h_sw[4]|h_sw[5]|h_sw[6]|h_sw[7]|h_sw[8]|h_sw[9]|l_sw[0]|l_sw[10]|l_sw[1]|l_sw[2]|l_sw[3]|l_sw[4]|l_sw[5]|l_sw[6]|l_sw[7]|l_sw[8]|l_sw[9]|vc|vdd|vss|z
+ in_l_sw[4]|x
+ BOTTOM|TOP|h_sw[0]|h_sw[10]|h_sw[1]|h_sw[2]|h_sw[3]|h_sw[4]|h_sw[5]|h_sw[6]|h_sw[7]|h_sw[8]|h_sw[9]|l_sw[0]|l_sw[10]|l_sw[1]|l_sw[2]|l_sw[3]|l_sw[4]|l_sw[5]|l_sw[6]|l_sw[7]|l_sw[8]|l_sw[9]|vc|vdd|vss|z
+ \$1 sg13_lv_nmos L=0.13u W=0.5u AS=0.095p AD=0.095p PS=0.88u PD=0.88u rfmode=0
M$177
+ BOTTOM|TOP|h_sw[0]|h_sw[10]|h_sw[1]|h_sw[2]|h_sw[3]|h_sw[4]|h_sw[5]|h_sw[6]|h_sw[7]|h_sw[8]|h_sw[9]|l_sw[0]|l_sw[10]|l_sw[1]|l_sw[2]|l_sw[3]|l_sw[4]|l_sw[5]|l_sw[6]|l_sw[7]|l_sw[8]|l_sw[9]|vc|vdd|vss|z
+ in_l_sw[4]|x
+ BOTTOM|TOP|h_sw[0]|h_sw[10]|h_sw[1]|h_sw[2]|h_sw[3]|h_sw[4]|h_sw[5]|h_sw[6]|h_sw[7]|h_sw[8]|h_sw[9]|l_sw[0]|l_sw[10]|l_sw[1]|l_sw[2]|l_sw[3]|l_sw[4]|l_sw[5]|l_sw[6]|l_sw[7]|l_sw[8]|l_sw[9]|vc|vdd|vss|z
+ \$1 sg13_lv_nmos L=0.13u W=0.5u AS=0.095p AD=0.095p PS=0.88u PD=0.88u rfmode=0
M$178
+ BOTTOM|TOP|h_sw[0]|h_sw[10]|h_sw[1]|h_sw[2]|h_sw[3]|h_sw[4]|h_sw[5]|h_sw[6]|h_sw[7]|h_sw[8]|h_sw[9]|l_sw[0]|l_sw[10]|l_sw[1]|l_sw[2]|l_sw[3]|l_sw[4]|l_sw[5]|l_sw[6]|l_sw[7]|l_sw[8]|l_sw[9]|vc|vdd|vss|z
+ in_l_sw[4]|x
+ BOTTOM|TOP|h_sw[0]|h_sw[10]|h_sw[1]|h_sw[2]|h_sw[3]|h_sw[4]|h_sw[5]|h_sw[6]|h_sw[7]|h_sw[8]|h_sw[9]|l_sw[0]|l_sw[10]|l_sw[1]|l_sw[2]|l_sw[3]|l_sw[4]|l_sw[5]|l_sw[6]|l_sw[7]|l_sw[8]|l_sw[9]|vc|vdd|vss|z
+ \$1 sg13_lv_nmos L=0.13u W=0.5u AS=0.095p AD=0.095p PS=0.88u PD=0.88u rfmode=0
M$179
+ BOTTOM|TOP|h_sw[0]|h_sw[10]|h_sw[1]|h_sw[2]|h_sw[3]|h_sw[4]|h_sw[5]|h_sw[6]|h_sw[7]|h_sw[8]|h_sw[9]|l_sw[0]|l_sw[10]|l_sw[1]|l_sw[2]|l_sw[3]|l_sw[4]|l_sw[5]|l_sw[6]|l_sw[7]|l_sw[8]|l_sw[9]|vc|vdd|vss|z
+ in_l_sw[4]|x
+ BOTTOM|TOP|h_sw[0]|h_sw[10]|h_sw[1]|h_sw[2]|h_sw[3]|h_sw[4]|h_sw[5]|h_sw[6]|h_sw[7]|h_sw[8]|h_sw[9]|l_sw[0]|l_sw[10]|l_sw[1]|l_sw[2]|l_sw[3]|l_sw[4]|l_sw[5]|l_sw[6]|l_sw[7]|l_sw[8]|l_sw[9]|vc|vdd|vss|z
+ \$1 sg13_lv_nmos L=0.13u W=0.5u AS=0.095p AD=0.095p PS=0.88u PD=0.88u rfmode=0
M$180
+ BOTTOM|TOP|h_sw[0]|h_sw[10]|h_sw[1]|h_sw[2]|h_sw[3]|h_sw[4]|h_sw[5]|h_sw[6]|h_sw[7]|h_sw[8]|h_sw[9]|l_sw[0]|l_sw[10]|l_sw[1]|l_sw[2]|l_sw[3]|l_sw[4]|l_sw[5]|l_sw[6]|l_sw[7]|l_sw[8]|l_sw[9]|vc|vdd|vss|z
+ in_l_sw[4]|x
+ BOTTOM|TOP|h_sw[0]|h_sw[10]|h_sw[1]|h_sw[2]|h_sw[3]|h_sw[4]|h_sw[5]|h_sw[6]|h_sw[7]|h_sw[8]|h_sw[9]|l_sw[0]|l_sw[10]|l_sw[1]|l_sw[2]|l_sw[3]|l_sw[4]|l_sw[5]|l_sw[6]|l_sw[7]|l_sw[8]|l_sw[9]|vc|vdd|vss|z
+ \$1 sg13_lv_nmos L=0.13u W=0.5u AS=0.095p AD=0.17p PS=0.88u PD=1.68u rfmode=0
M$181
+ BOTTOM|TOP|h_sw[0]|h_sw[10]|h_sw[1]|h_sw[2]|h_sw[3]|h_sw[4]|h_sw[5]|h_sw[6]|h_sw[7]|h_sw[8]|h_sw[9]|l_sw[0]|l_sw[10]|l_sw[1]|l_sw[2]|l_sw[3]|l_sw[4]|l_sw[5]|l_sw[6]|l_sw[7]|l_sw[8]|l_sw[9]|vc|vdd|vss|z
+ in_l_sw[5]|x
+ BOTTOM|TOP|h_sw[0]|h_sw[10]|h_sw[1]|h_sw[2]|h_sw[3]|h_sw[4]|h_sw[5]|h_sw[6]|h_sw[7]|h_sw[8]|h_sw[9]|l_sw[0]|l_sw[10]|l_sw[1]|l_sw[2]|l_sw[3]|l_sw[4]|l_sw[5]|l_sw[6]|l_sw[7]|l_sw[8]|l_sw[9]|vc|vdd|vss|z
+ \$1 sg13_lv_nmos L=0.13u W=0.5u AS=0.17p AD=0.095p PS=1.68u PD=0.88u rfmode=0
M$182
+ BOTTOM|TOP|h_sw[0]|h_sw[10]|h_sw[1]|h_sw[2]|h_sw[3]|h_sw[4]|h_sw[5]|h_sw[6]|h_sw[7]|h_sw[8]|h_sw[9]|l_sw[0]|l_sw[10]|l_sw[1]|l_sw[2]|l_sw[3]|l_sw[4]|l_sw[5]|l_sw[6]|l_sw[7]|l_sw[8]|l_sw[9]|vc|vdd|vss|z
+ in_l_sw[5]|x
+ BOTTOM|TOP|h_sw[0]|h_sw[10]|h_sw[1]|h_sw[2]|h_sw[3]|h_sw[4]|h_sw[5]|h_sw[6]|h_sw[7]|h_sw[8]|h_sw[9]|l_sw[0]|l_sw[10]|l_sw[1]|l_sw[2]|l_sw[3]|l_sw[4]|l_sw[5]|l_sw[6]|l_sw[7]|l_sw[8]|l_sw[9]|vc|vdd|vss|z
+ \$1 sg13_lv_nmos L=0.13u W=0.5u AS=0.095p AD=0.095p PS=0.88u PD=0.88u rfmode=0
M$183
+ BOTTOM|TOP|h_sw[0]|h_sw[10]|h_sw[1]|h_sw[2]|h_sw[3]|h_sw[4]|h_sw[5]|h_sw[6]|h_sw[7]|h_sw[8]|h_sw[9]|l_sw[0]|l_sw[10]|l_sw[1]|l_sw[2]|l_sw[3]|l_sw[4]|l_sw[5]|l_sw[6]|l_sw[7]|l_sw[8]|l_sw[9]|vc|vdd|vss|z
+ in_l_sw[5]|x
+ BOTTOM|TOP|h_sw[0]|h_sw[10]|h_sw[1]|h_sw[2]|h_sw[3]|h_sw[4]|h_sw[5]|h_sw[6]|h_sw[7]|h_sw[8]|h_sw[9]|l_sw[0]|l_sw[10]|l_sw[1]|l_sw[2]|l_sw[3]|l_sw[4]|l_sw[5]|l_sw[6]|l_sw[7]|l_sw[8]|l_sw[9]|vc|vdd|vss|z
+ \$1 sg13_lv_nmos L=0.13u W=0.5u AS=0.095p AD=0.095p PS=0.88u PD=0.88u rfmode=0
M$184
+ BOTTOM|TOP|h_sw[0]|h_sw[10]|h_sw[1]|h_sw[2]|h_sw[3]|h_sw[4]|h_sw[5]|h_sw[6]|h_sw[7]|h_sw[8]|h_sw[9]|l_sw[0]|l_sw[10]|l_sw[1]|l_sw[2]|l_sw[3]|l_sw[4]|l_sw[5]|l_sw[6]|l_sw[7]|l_sw[8]|l_sw[9]|vc|vdd|vss|z
+ in_l_sw[5]|x
+ BOTTOM|TOP|h_sw[0]|h_sw[10]|h_sw[1]|h_sw[2]|h_sw[3]|h_sw[4]|h_sw[5]|h_sw[6]|h_sw[7]|h_sw[8]|h_sw[9]|l_sw[0]|l_sw[10]|l_sw[1]|l_sw[2]|l_sw[3]|l_sw[4]|l_sw[5]|l_sw[6]|l_sw[7]|l_sw[8]|l_sw[9]|vc|vdd|vss|z
+ \$1 sg13_lv_nmos L=0.13u W=0.5u AS=0.095p AD=0.095p PS=0.88u PD=0.88u rfmode=0
M$185
+ BOTTOM|TOP|h_sw[0]|h_sw[10]|h_sw[1]|h_sw[2]|h_sw[3]|h_sw[4]|h_sw[5]|h_sw[6]|h_sw[7]|h_sw[8]|h_sw[9]|l_sw[0]|l_sw[10]|l_sw[1]|l_sw[2]|l_sw[3]|l_sw[4]|l_sw[5]|l_sw[6]|l_sw[7]|l_sw[8]|l_sw[9]|vc|vdd|vss|z
+ in_l_sw[5]|x
+ BOTTOM|TOP|h_sw[0]|h_sw[10]|h_sw[1]|h_sw[2]|h_sw[3]|h_sw[4]|h_sw[5]|h_sw[6]|h_sw[7]|h_sw[8]|h_sw[9]|l_sw[0]|l_sw[10]|l_sw[1]|l_sw[2]|l_sw[3]|l_sw[4]|l_sw[5]|l_sw[6]|l_sw[7]|l_sw[8]|l_sw[9]|vc|vdd|vss|z
+ \$1 sg13_lv_nmos L=0.13u W=0.5u AS=0.095p AD=0.095p PS=0.88u PD=0.88u rfmode=0
M$186
+ BOTTOM|TOP|h_sw[0]|h_sw[10]|h_sw[1]|h_sw[2]|h_sw[3]|h_sw[4]|h_sw[5]|h_sw[6]|h_sw[7]|h_sw[8]|h_sw[9]|l_sw[0]|l_sw[10]|l_sw[1]|l_sw[2]|l_sw[3]|l_sw[4]|l_sw[5]|l_sw[6]|l_sw[7]|l_sw[8]|l_sw[9]|vc|vdd|vss|z
+ in_l_sw[5]|x
+ BOTTOM|TOP|h_sw[0]|h_sw[10]|h_sw[1]|h_sw[2]|h_sw[3]|h_sw[4]|h_sw[5]|h_sw[6]|h_sw[7]|h_sw[8]|h_sw[9]|l_sw[0]|l_sw[10]|l_sw[1]|l_sw[2]|l_sw[3]|l_sw[4]|l_sw[5]|l_sw[6]|l_sw[7]|l_sw[8]|l_sw[9]|vc|vdd|vss|z
+ \$1 sg13_lv_nmos L=0.13u W=0.5u AS=0.095p AD=0.095p PS=0.88u PD=0.88u rfmode=0
M$187
+ BOTTOM|TOP|h_sw[0]|h_sw[10]|h_sw[1]|h_sw[2]|h_sw[3]|h_sw[4]|h_sw[5]|h_sw[6]|h_sw[7]|h_sw[8]|h_sw[9]|l_sw[0]|l_sw[10]|l_sw[1]|l_sw[2]|l_sw[3]|l_sw[4]|l_sw[5]|l_sw[6]|l_sw[7]|l_sw[8]|l_sw[9]|vc|vdd|vss|z
+ in_l_sw[5]|x
+ BOTTOM|TOP|h_sw[0]|h_sw[10]|h_sw[1]|h_sw[2]|h_sw[3]|h_sw[4]|h_sw[5]|h_sw[6]|h_sw[7]|h_sw[8]|h_sw[9]|l_sw[0]|l_sw[10]|l_sw[1]|l_sw[2]|l_sw[3]|l_sw[4]|l_sw[5]|l_sw[6]|l_sw[7]|l_sw[8]|l_sw[9]|vc|vdd|vss|z
+ \$1 sg13_lv_nmos L=0.13u W=0.5u AS=0.095p AD=0.095p PS=0.88u PD=0.88u rfmode=0
M$188
+ BOTTOM|TOP|h_sw[0]|h_sw[10]|h_sw[1]|h_sw[2]|h_sw[3]|h_sw[4]|h_sw[5]|h_sw[6]|h_sw[7]|h_sw[8]|h_sw[9]|l_sw[0]|l_sw[10]|l_sw[1]|l_sw[2]|l_sw[3]|l_sw[4]|l_sw[5]|l_sw[6]|l_sw[7]|l_sw[8]|l_sw[9]|vc|vdd|vss|z
+ in_l_sw[5]|x
+ BOTTOM|TOP|h_sw[0]|h_sw[10]|h_sw[1]|h_sw[2]|h_sw[3]|h_sw[4]|h_sw[5]|h_sw[6]|h_sw[7]|h_sw[8]|h_sw[9]|l_sw[0]|l_sw[10]|l_sw[1]|l_sw[2]|l_sw[3]|l_sw[4]|l_sw[5]|l_sw[6]|l_sw[7]|l_sw[8]|l_sw[9]|vc|vdd|vss|z
+ \$1 sg13_lv_nmos L=0.13u W=0.5u AS=0.095p AD=0.17p PS=0.88u PD=1.68u rfmode=0
M$189
+ BOTTOM|TOP|h_sw[0]|h_sw[10]|h_sw[1]|h_sw[2]|h_sw[3]|h_sw[4]|h_sw[5]|h_sw[6]|h_sw[7]|h_sw[8]|h_sw[9]|l_sw[0]|l_sw[10]|l_sw[1]|l_sw[2]|l_sw[3]|l_sw[4]|l_sw[5]|l_sw[6]|l_sw[7]|l_sw[8]|l_sw[9]|vc|vdd|vss|z
+ in_h_sw[10]|x
+ BOTTOM|TOP|h_sw[0]|h_sw[10]|h_sw[1]|h_sw[2]|h_sw[3]|h_sw[4]|h_sw[5]|h_sw[6]|h_sw[7]|h_sw[8]|h_sw[9]|l_sw[0]|l_sw[10]|l_sw[1]|l_sw[2]|l_sw[3]|l_sw[4]|l_sw[5]|l_sw[6]|l_sw[7]|l_sw[8]|l_sw[9]|vc|vdd|vss|z
+ \$1 sg13_lv_nmos L=0.13u W=0.5u AS=0.17p AD=0.17p PS=1.68u PD=1.68u rfmode=0
M$190
+ BOTTOM|TOP|h_sw[0]|h_sw[10]|h_sw[1]|h_sw[2]|h_sw[3]|h_sw[4]|h_sw[5]|h_sw[6]|h_sw[7]|h_sw[8]|h_sw[9]|l_sw[0]|l_sw[10]|l_sw[1]|l_sw[2]|l_sw[3]|l_sw[4]|l_sw[5]|l_sw[6]|l_sw[7]|l_sw[8]|l_sw[9]|vc|vdd|vss|z
+ in_l_sw[6]|x
+ BOTTOM|TOP|h_sw[0]|h_sw[10]|h_sw[1]|h_sw[2]|h_sw[3]|h_sw[4]|h_sw[5]|h_sw[6]|h_sw[7]|h_sw[8]|h_sw[9]|l_sw[0]|l_sw[10]|l_sw[1]|l_sw[2]|l_sw[3]|l_sw[4]|l_sw[5]|l_sw[6]|l_sw[7]|l_sw[8]|l_sw[9]|vc|vdd|vss|z
+ \$1 sg13_lv_nmos L=0.13u W=0.5u AS=0.17p AD=0.095p PS=1.68u PD=0.88u rfmode=0
M$191
+ BOTTOM|TOP|h_sw[0]|h_sw[10]|h_sw[1]|h_sw[2]|h_sw[3]|h_sw[4]|h_sw[5]|h_sw[6]|h_sw[7]|h_sw[8]|h_sw[9]|l_sw[0]|l_sw[10]|l_sw[1]|l_sw[2]|l_sw[3]|l_sw[4]|l_sw[5]|l_sw[6]|l_sw[7]|l_sw[8]|l_sw[9]|vc|vdd|vss|z
+ in_l_sw[6]|x
+ BOTTOM|TOP|h_sw[0]|h_sw[10]|h_sw[1]|h_sw[2]|h_sw[3]|h_sw[4]|h_sw[5]|h_sw[6]|h_sw[7]|h_sw[8]|h_sw[9]|l_sw[0]|l_sw[10]|l_sw[1]|l_sw[2]|l_sw[3]|l_sw[4]|l_sw[5]|l_sw[6]|l_sw[7]|l_sw[8]|l_sw[9]|vc|vdd|vss|z
+ \$1 sg13_lv_nmos L=0.13u W=0.5u AS=0.095p AD=0.095p PS=0.88u PD=0.88u rfmode=0
M$192
+ BOTTOM|TOP|h_sw[0]|h_sw[10]|h_sw[1]|h_sw[2]|h_sw[3]|h_sw[4]|h_sw[5]|h_sw[6]|h_sw[7]|h_sw[8]|h_sw[9]|l_sw[0]|l_sw[10]|l_sw[1]|l_sw[2]|l_sw[3]|l_sw[4]|l_sw[5]|l_sw[6]|l_sw[7]|l_sw[8]|l_sw[9]|vc|vdd|vss|z
+ in_l_sw[6]|x
+ BOTTOM|TOP|h_sw[0]|h_sw[10]|h_sw[1]|h_sw[2]|h_sw[3]|h_sw[4]|h_sw[5]|h_sw[6]|h_sw[7]|h_sw[8]|h_sw[9]|l_sw[0]|l_sw[10]|l_sw[1]|l_sw[2]|l_sw[3]|l_sw[4]|l_sw[5]|l_sw[6]|l_sw[7]|l_sw[8]|l_sw[9]|vc|vdd|vss|z
+ \$1 sg13_lv_nmos L=0.13u W=0.5u AS=0.095p AD=0.095p PS=0.88u PD=0.88u rfmode=0
M$193
+ BOTTOM|TOP|h_sw[0]|h_sw[10]|h_sw[1]|h_sw[2]|h_sw[3]|h_sw[4]|h_sw[5]|h_sw[6]|h_sw[7]|h_sw[8]|h_sw[9]|l_sw[0]|l_sw[10]|l_sw[1]|l_sw[2]|l_sw[3]|l_sw[4]|l_sw[5]|l_sw[6]|l_sw[7]|l_sw[8]|l_sw[9]|vc|vdd|vss|z
+ in_l_sw[6]|x
+ BOTTOM|TOP|h_sw[0]|h_sw[10]|h_sw[1]|h_sw[2]|h_sw[3]|h_sw[4]|h_sw[5]|h_sw[6]|h_sw[7]|h_sw[8]|h_sw[9]|l_sw[0]|l_sw[10]|l_sw[1]|l_sw[2]|l_sw[3]|l_sw[4]|l_sw[5]|l_sw[6]|l_sw[7]|l_sw[8]|l_sw[9]|vc|vdd|vss|z
+ \$1 sg13_lv_nmos L=0.13u W=0.5u AS=0.095p AD=0.17p PS=0.88u PD=1.68u rfmode=0
M$194
+ BOTTOM|TOP|h_sw[0]|h_sw[10]|h_sw[1]|h_sw[2]|h_sw[3]|h_sw[4]|h_sw[5]|h_sw[6]|h_sw[7]|h_sw[8]|h_sw[9]|l_sw[0]|l_sw[10]|l_sw[1]|l_sw[2]|l_sw[3]|l_sw[4]|l_sw[5]|l_sw[6]|l_sw[7]|l_sw[8]|l_sw[9]|vc|vdd|vss|z
+ in_l_sw[7]|x
+ BOTTOM|TOP|h_sw[0]|h_sw[10]|h_sw[1]|h_sw[2]|h_sw[3]|h_sw[4]|h_sw[5]|h_sw[6]|h_sw[7]|h_sw[8]|h_sw[9]|l_sw[0]|l_sw[10]|l_sw[1]|l_sw[2]|l_sw[3]|l_sw[4]|l_sw[5]|l_sw[6]|l_sw[7]|l_sw[8]|l_sw[9]|vc|vdd|vss|z
+ \$1 sg13_lv_nmos L=0.13u W=0.5u AS=0.17p AD=0.095p PS=1.68u PD=0.88u rfmode=0
M$195
+ BOTTOM|TOP|h_sw[0]|h_sw[10]|h_sw[1]|h_sw[2]|h_sw[3]|h_sw[4]|h_sw[5]|h_sw[6]|h_sw[7]|h_sw[8]|h_sw[9]|l_sw[0]|l_sw[10]|l_sw[1]|l_sw[2]|l_sw[3]|l_sw[4]|l_sw[5]|l_sw[6]|l_sw[7]|l_sw[8]|l_sw[9]|vc|vdd|vss|z
+ in_l_sw[7]|x
+ BOTTOM|TOP|h_sw[0]|h_sw[10]|h_sw[1]|h_sw[2]|h_sw[3]|h_sw[4]|h_sw[5]|h_sw[6]|h_sw[7]|h_sw[8]|h_sw[9]|l_sw[0]|l_sw[10]|l_sw[1]|l_sw[2]|l_sw[3]|l_sw[4]|l_sw[5]|l_sw[6]|l_sw[7]|l_sw[8]|l_sw[9]|vc|vdd|vss|z
+ \$1 sg13_lv_nmos L=0.13u W=0.5u AS=0.095p AD=0.095p PS=0.88u PD=0.88u rfmode=0
M$196
+ BOTTOM|TOP|h_sw[0]|h_sw[10]|h_sw[1]|h_sw[2]|h_sw[3]|h_sw[4]|h_sw[5]|h_sw[6]|h_sw[7]|h_sw[8]|h_sw[9]|l_sw[0]|l_sw[10]|l_sw[1]|l_sw[2]|l_sw[3]|l_sw[4]|l_sw[5]|l_sw[6]|l_sw[7]|l_sw[8]|l_sw[9]|vc|vdd|vss|z
+ in_l_sw[7]|x
+ BOTTOM|TOP|h_sw[0]|h_sw[10]|h_sw[1]|h_sw[2]|h_sw[3]|h_sw[4]|h_sw[5]|h_sw[6]|h_sw[7]|h_sw[8]|h_sw[9]|l_sw[0]|l_sw[10]|l_sw[1]|l_sw[2]|l_sw[3]|l_sw[4]|l_sw[5]|l_sw[6]|l_sw[7]|l_sw[8]|l_sw[9]|vc|vdd|vss|z
+ \$1 sg13_lv_nmos L=0.13u W=0.5u AS=0.095p AD=0.095p PS=0.88u PD=0.88u rfmode=0
M$197
+ BOTTOM|TOP|h_sw[0]|h_sw[10]|h_sw[1]|h_sw[2]|h_sw[3]|h_sw[4]|h_sw[5]|h_sw[6]|h_sw[7]|h_sw[8]|h_sw[9]|l_sw[0]|l_sw[10]|l_sw[1]|l_sw[2]|l_sw[3]|l_sw[4]|l_sw[5]|l_sw[6]|l_sw[7]|l_sw[8]|l_sw[9]|vc|vdd|vss|z
+ in_l_sw[7]|x
+ BOTTOM|TOP|h_sw[0]|h_sw[10]|h_sw[1]|h_sw[2]|h_sw[3]|h_sw[4]|h_sw[5]|h_sw[6]|h_sw[7]|h_sw[8]|h_sw[9]|l_sw[0]|l_sw[10]|l_sw[1]|l_sw[2]|l_sw[3]|l_sw[4]|l_sw[5]|l_sw[6]|l_sw[7]|l_sw[8]|l_sw[9]|vc|vdd|vss|z
+ \$1 sg13_lv_nmos L=0.13u W=0.5u AS=0.095p AD=0.17p PS=0.88u PD=1.68u rfmode=0
M$198
+ BOTTOM|TOP|h_sw[0]|h_sw[10]|h_sw[1]|h_sw[2]|h_sw[3]|h_sw[4]|h_sw[5]|h_sw[6]|h_sw[7]|h_sw[8]|h_sw[9]|l_sw[0]|l_sw[10]|l_sw[1]|l_sw[2]|l_sw[3]|l_sw[4]|l_sw[5]|l_sw[6]|l_sw[7]|l_sw[8]|l_sw[9]|vc|vdd|vss|z
+ in_l_sw[8]|x
+ BOTTOM|TOP|h_sw[0]|h_sw[10]|h_sw[1]|h_sw[2]|h_sw[3]|h_sw[4]|h_sw[5]|h_sw[6]|h_sw[7]|h_sw[8]|h_sw[9]|l_sw[0]|l_sw[10]|l_sw[1]|l_sw[2]|l_sw[3]|l_sw[4]|l_sw[5]|l_sw[6]|l_sw[7]|l_sw[8]|l_sw[9]|vc|vdd|vss|z
+ \$1 sg13_lv_nmos L=0.13u W=0.5u AS=0.17p AD=0.095p PS=1.68u PD=0.88u rfmode=0
M$199
+ BOTTOM|TOP|h_sw[0]|h_sw[10]|h_sw[1]|h_sw[2]|h_sw[3]|h_sw[4]|h_sw[5]|h_sw[6]|h_sw[7]|h_sw[8]|h_sw[9]|l_sw[0]|l_sw[10]|l_sw[1]|l_sw[2]|l_sw[3]|l_sw[4]|l_sw[5]|l_sw[6]|l_sw[7]|l_sw[8]|l_sw[9]|vc|vdd|vss|z
+ in_l_sw[8]|x
+ BOTTOM|TOP|h_sw[0]|h_sw[10]|h_sw[1]|h_sw[2]|h_sw[3]|h_sw[4]|h_sw[5]|h_sw[6]|h_sw[7]|h_sw[8]|h_sw[9]|l_sw[0]|l_sw[10]|l_sw[1]|l_sw[2]|l_sw[3]|l_sw[4]|l_sw[5]|l_sw[6]|l_sw[7]|l_sw[8]|l_sw[9]|vc|vdd|vss|z
+ \$1 sg13_lv_nmos L=0.13u W=0.5u AS=0.095p AD=0.17p PS=0.88u PD=1.68u rfmode=0
M$200
+ BOTTOM|TOP|h_sw[0]|h_sw[10]|h_sw[1]|h_sw[2]|h_sw[3]|h_sw[4]|h_sw[5]|h_sw[6]|h_sw[7]|h_sw[8]|h_sw[9]|l_sw[0]|l_sw[10]|l_sw[1]|l_sw[2]|l_sw[3]|l_sw[4]|l_sw[5]|l_sw[6]|l_sw[7]|l_sw[8]|l_sw[9]|vc|vdd|vss|z
+ in_l_sw[9]|x
+ BOTTOM|TOP|h_sw[0]|h_sw[10]|h_sw[1]|h_sw[2]|h_sw[3]|h_sw[4]|h_sw[5]|h_sw[6]|h_sw[7]|h_sw[8]|h_sw[9]|l_sw[0]|l_sw[10]|l_sw[1]|l_sw[2]|l_sw[3]|l_sw[4]|l_sw[5]|l_sw[6]|l_sw[7]|l_sw[8]|l_sw[9]|vc|vdd|vss|z
+ \$1 sg13_lv_nmos L=0.13u W=0.5u AS=0.17p AD=0.095p PS=1.68u PD=0.88u rfmode=0
M$201
+ BOTTOM|TOP|h_sw[0]|h_sw[10]|h_sw[1]|h_sw[2]|h_sw[3]|h_sw[4]|h_sw[5]|h_sw[6]|h_sw[7]|h_sw[8]|h_sw[9]|l_sw[0]|l_sw[10]|l_sw[1]|l_sw[2]|l_sw[3]|l_sw[4]|l_sw[5]|l_sw[6]|l_sw[7]|l_sw[8]|l_sw[9]|vc|vdd|vss|z
+ in_l_sw[9]|x
+ BOTTOM|TOP|h_sw[0]|h_sw[10]|h_sw[1]|h_sw[2]|h_sw[3]|h_sw[4]|h_sw[5]|h_sw[6]|h_sw[7]|h_sw[8]|h_sw[9]|l_sw[0]|l_sw[10]|l_sw[1]|l_sw[2]|l_sw[3]|l_sw[4]|l_sw[5]|l_sw[6]|l_sw[7]|l_sw[8]|l_sw[9]|vc|vdd|vss|z
+ \$1 sg13_lv_nmos L=0.13u W=0.5u AS=0.095p AD=0.17p PS=0.88u PD=1.68u rfmode=0
M$202
+ BOTTOM|TOP|h_sw[0]|h_sw[10]|h_sw[1]|h_sw[2]|h_sw[3]|h_sw[4]|h_sw[5]|h_sw[6]|h_sw[7]|h_sw[8]|h_sw[9]|l_sw[0]|l_sw[10]|l_sw[1]|l_sw[2]|l_sw[3]|l_sw[4]|l_sw[5]|l_sw[6]|l_sw[7]|l_sw[8]|l_sw[9]|vc|vdd|vss|z
+ in_l_sw[10]|x
+ BOTTOM|TOP|h_sw[0]|h_sw[10]|h_sw[1]|h_sw[2]|h_sw[3]|h_sw[4]|h_sw[5]|h_sw[6]|h_sw[7]|h_sw[8]|h_sw[9]|l_sw[0]|l_sw[10]|l_sw[1]|l_sw[2]|l_sw[3]|l_sw[4]|l_sw[5]|l_sw[6]|l_sw[7]|l_sw[8]|l_sw[9]|vc|vdd|vss|z
+ \$1 sg13_lv_nmos L=0.13u W=0.5u AS=0.17p AD=0.17p PS=1.68u PD=1.68u rfmode=0
M$203
+ BOTTOM|TOP|h_sw[0]|h_sw[10]|h_sw[1]|h_sw[2]|h_sw[3]|h_sw[4]|h_sw[5]|h_sw[6]|h_sw[7]|h_sw[8]|h_sw[9]|l_sw[0]|l_sw[10]|l_sw[1]|l_sw[2]|l_sw[3]|l_sw[4]|l_sw[5]|l_sw[6]|l_sw[7]|l_sw[8]|l_sw[9]|vc|vdd|vss|z
+ in_l_sw[0]|x
+ BOTTOM|TOP|h_sw[0]|h_sw[10]|h_sw[1]|h_sw[2]|h_sw[3]|h_sw[4]|h_sw[5]|h_sw[6]|h_sw[7]|h_sw[8]|h_sw[9]|l_sw[0]|l_sw[10]|l_sw[1]|l_sw[2]|l_sw[3]|l_sw[4]|l_sw[5]|l_sw[6]|l_sw[7]|l_sw[8]|l_sw[9]|vc|vdd|vss|z
+ \$2 sg13_lv_pmos L=0.13u W=1u AS=0.34p AD=0.19p PS=2.68u PD=1.38u rfmode=0
M$204
+ BOTTOM|TOP|h_sw[0]|h_sw[10]|h_sw[1]|h_sw[2]|h_sw[3]|h_sw[4]|h_sw[5]|h_sw[6]|h_sw[7]|h_sw[8]|h_sw[9]|l_sw[0]|l_sw[10]|l_sw[1]|l_sw[2]|l_sw[3]|l_sw[4]|l_sw[5]|l_sw[6]|l_sw[7]|l_sw[8]|l_sw[9]|vc|vdd|vss|z
+ in_l_sw[0]|x
+ BOTTOM|TOP|h_sw[0]|h_sw[10]|h_sw[1]|h_sw[2]|h_sw[3]|h_sw[4]|h_sw[5]|h_sw[6]|h_sw[7]|h_sw[8]|h_sw[9]|l_sw[0]|l_sw[10]|l_sw[1]|l_sw[2]|l_sw[3]|l_sw[4]|l_sw[5]|l_sw[6]|l_sw[7]|l_sw[8]|l_sw[9]|vc|vdd|vss|z
+ \$2 sg13_lv_pmos L=0.13u W=1u AS=0.19p AD=0.19p PS=1.38u PD=1.38u rfmode=0
M$205
+ BOTTOM|TOP|h_sw[0]|h_sw[10]|h_sw[1]|h_sw[2]|h_sw[3]|h_sw[4]|h_sw[5]|h_sw[6]|h_sw[7]|h_sw[8]|h_sw[9]|l_sw[0]|l_sw[10]|l_sw[1]|l_sw[2]|l_sw[3]|l_sw[4]|l_sw[5]|l_sw[6]|l_sw[7]|l_sw[8]|l_sw[9]|vc|vdd|vss|z
+ in_l_sw[0]|x
+ BOTTOM|TOP|h_sw[0]|h_sw[10]|h_sw[1]|h_sw[2]|h_sw[3]|h_sw[4]|h_sw[5]|h_sw[6]|h_sw[7]|h_sw[8]|h_sw[9]|l_sw[0]|l_sw[10]|l_sw[1]|l_sw[2]|l_sw[3]|l_sw[4]|l_sw[5]|l_sw[6]|l_sw[7]|l_sw[8]|l_sw[9]|vc|vdd|vss|z
+ \$2 sg13_lv_pmos L=0.13u W=1u AS=0.19p AD=0.19p PS=1.38u PD=1.38u rfmode=0
M$206
+ BOTTOM|TOP|h_sw[0]|h_sw[10]|h_sw[1]|h_sw[2]|h_sw[3]|h_sw[4]|h_sw[5]|h_sw[6]|h_sw[7]|h_sw[8]|h_sw[9]|l_sw[0]|l_sw[10]|l_sw[1]|l_sw[2]|l_sw[3]|l_sw[4]|l_sw[5]|l_sw[6]|l_sw[7]|l_sw[8]|l_sw[9]|vc|vdd|vss|z
+ in_l_sw[0]|x
+ BOTTOM|TOP|h_sw[0]|h_sw[10]|h_sw[1]|h_sw[2]|h_sw[3]|h_sw[4]|h_sw[5]|h_sw[6]|h_sw[7]|h_sw[8]|h_sw[9]|l_sw[0]|l_sw[10]|l_sw[1]|l_sw[2]|l_sw[3]|l_sw[4]|l_sw[5]|l_sw[6]|l_sw[7]|l_sw[8]|l_sw[9]|vc|vdd|vss|z
+ \$2 sg13_lv_pmos L=0.13u W=1u AS=0.19p AD=0.19p PS=1.38u PD=1.38u rfmode=0
M$207
+ BOTTOM|TOP|h_sw[0]|h_sw[10]|h_sw[1]|h_sw[2]|h_sw[3]|h_sw[4]|h_sw[5]|h_sw[6]|h_sw[7]|h_sw[8]|h_sw[9]|l_sw[0]|l_sw[10]|l_sw[1]|l_sw[2]|l_sw[3]|l_sw[4]|l_sw[5]|l_sw[6]|l_sw[7]|l_sw[8]|l_sw[9]|vc|vdd|vss|z
+ in_l_sw[0]|x
+ BOTTOM|TOP|h_sw[0]|h_sw[10]|h_sw[1]|h_sw[2]|h_sw[3]|h_sw[4]|h_sw[5]|h_sw[6]|h_sw[7]|h_sw[8]|h_sw[9]|l_sw[0]|l_sw[10]|l_sw[1]|l_sw[2]|l_sw[3]|l_sw[4]|l_sw[5]|l_sw[6]|l_sw[7]|l_sw[8]|l_sw[9]|vc|vdd|vss|z
+ \$2 sg13_lv_pmos L=0.13u W=1u AS=0.19p AD=0.19p PS=1.38u PD=1.38u rfmode=0
M$208
+ BOTTOM|TOP|h_sw[0]|h_sw[10]|h_sw[1]|h_sw[2]|h_sw[3]|h_sw[4]|h_sw[5]|h_sw[6]|h_sw[7]|h_sw[8]|h_sw[9]|l_sw[0]|l_sw[10]|l_sw[1]|l_sw[2]|l_sw[3]|l_sw[4]|l_sw[5]|l_sw[6]|l_sw[7]|l_sw[8]|l_sw[9]|vc|vdd|vss|z
+ in_l_sw[0]|x
+ BOTTOM|TOP|h_sw[0]|h_sw[10]|h_sw[1]|h_sw[2]|h_sw[3]|h_sw[4]|h_sw[5]|h_sw[6]|h_sw[7]|h_sw[8]|h_sw[9]|l_sw[0]|l_sw[10]|l_sw[1]|l_sw[2]|l_sw[3]|l_sw[4]|l_sw[5]|l_sw[6]|l_sw[7]|l_sw[8]|l_sw[9]|vc|vdd|vss|z
+ \$2 sg13_lv_pmos L=0.13u W=1u AS=0.19p AD=0.19p PS=1.38u PD=1.38u rfmode=0
M$209
+ BOTTOM|TOP|h_sw[0]|h_sw[10]|h_sw[1]|h_sw[2]|h_sw[3]|h_sw[4]|h_sw[5]|h_sw[6]|h_sw[7]|h_sw[8]|h_sw[9]|l_sw[0]|l_sw[10]|l_sw[1]|l_sw[2]|l_sw[3]|l_sw[4]|l_sw[5]|l_sw[6]|l_sw[7]|l_sw[8]|l_sw[9]|vc|vdd|vss|z
+ in_l_sw[0]|x
+ BOTTOM|TOP|h_sw[0]|h_sw[10]|h_sw[1]|h_sw[2]|h_sw[3]|h_sw[4]|h_sw[5]|h_sw[6]|h_sw[7]|h_sw[8]|h_sw[9]|l_sw[0]|l_sw[10]|l_sw[1]|l_sw[2]|l_sw[3]|l_sw[4]|l_sw[5]|l_sw[6]|l_sw[7]|l_sw[8]|l_sw[9]|vc|vdd|vss|z
+ \$2 sg13_lv_pmos L=0.13u W=1u AS=0.19p AD=0.19p PS=1.38u PD=1.38u rfmode=0
M$210
+ BOTTOM|TOP|h_sw[0]|h_sw[10]|h_sw[1]|h_sw[2]|h_sw[3]|h_sw[4]|h_sw[5]|h_sw[6]|h_sw[7]|h_sw[8]|h_sw[9]|l_sw[0]|l_sw[10]|l_sw[1]|l_sw[2]|l_sw[3]|l_sw[4]|l_sw[5]|l_sw[6]|l_sw[7]|l_sw[8]|l_sw[9]|vc|vdd|vss|z
+ in_l_sw[0]|x
+ BOTTOM|TOP|h_sw[0]|h_sw[10]|h_sw[1]|h_sw[2]|h_sw[3]|h_sw[4]|h_sw[5]|h_sw[6]|h_sw[7]|h_sw[8]|h_sw[9]|l_sw[0]|l_sw[10]|l_sw[1]|l_sw[2]|l_sw[3]|l_sw[4]|l_sw[5]|l_sw[6]|l_sw[7]|l_sw[8]|l_sw[9]|vc|vdd|vss|z
+ \$2 sg13_lv_pmos L=0.13u W=1u AS=0.19p AD=0.19p PS=1.38u PD=1.38u rfmode=0
M$211
+ BOTTOM|TOP|h_sw[0]|h_sw[10]|h_sw[1]|h_sw[2]|h_sw[3]|h_sw[4]|h_sw[5]|h_sw[6]|h_sw[7]|h_sw[8]|h_sw[9]|l_sw[0]|l_sw[10]|l_sw[1]|l_sw[2]|l_sw[3]|l_sw[4]|l_sw[5]|l_sw[6]|l_sw[7]|l_sw[8]|l_sw[9]|vc|vdd|vss|z
+ in_l_sw[0]|x
+ BOTTOM|TOP|h_sw[0]|h_sw[10]|h_sw[1]|h_sw[2]|h_sw[3]|h_sw[4]|h_sw[5]|h_sw[6]|h_sw[7]|h_sw[8]|h_sw[9]|l_sw[0]|l_sw[10]|l_sw[1]|l_sw[2]|l_sw[3]|l_sw[4]|l_sw[5]|l_sw[6]|l_sw[7]|l_sw[8]|l_sw[9]|vc|vdd|vss|z
+ \$2 sg13_lv_pmos L=0.13u W=1u AS=0.19p AD=0.19p PS=1.38u PD=1.38u rfmode=0
M$212
+ BOTTOM|TOP|h_sw[0]|h_sw[10]|h_sw[1]|h_sw[2]|h_sw[3]|h_sw[4]|h_sw[5]|h_sw[6]|h_sw[7]|h_sw[8]|h_sw[9]|l_sw[0]|l_sw[10]|l_sw[1]|l_sw[2]|l_sw[3]|l_sw[4]|l_sw[5]|l_sw[6]|l_sw[7]|l_sw[8]|l_sw[9]|vc|vdd|vss|z
+ in_l_sw[0]|x
+ BOTTOM|TOP|h_sw[0]|h_sw[10]|h_sw[1]|h_sw[2]|h_sw[3]|h_sw[4]|h_sw[5]|h_sw[6]|h_sw[7]|h_sw[8]|h_sw[9]|l_sw[0]|l_sw[10]|l_sw[1]|l_sw[2]|l_sw[3]|l_sw[4]|l_sw[5]|l_sw[6]|l_sw[7]|l_sw[8]|l_sw[9]|vc|vdd|vss|z
+ \$2 sg13_lv_pmos L=0.13u W=1u AS=0.19p AD=0.19p PS=1.38u PD=1.38u rfmode=0
M$213
+ BOTTOM|TOP|h_sw[0]|h_sw[10]|h_sw[1]|h_sw[2]|h_sw[3]|h_sw[4]|h_sw[5]|h_sw[6]|h_sw[7]|h_sw[8]|h_sw[9]|l_sw[0]|l_sw[10]|l_sw[1]|l_sw[2]|l_sw[3]|l_sw[4]|l_sw[5]|l_sw[6]|l_sw[7]|l_sw[8]|l_sw[9]|vc|vdd|vss|z
+ in_l_sw[0]|x
+ BOTTOM|TOP|h_sw[0]|h_sw[10]|h_sw[1]|h_sw[2]|h_sw[3]|h_sw[4]|h_sw[5]|h_sw[6]|h_sw[7]|h_sw[8]|h_sw[9]|l_sw[0]|l_sw[10]|l_sw[1]|l_sw[2]|l_sw[3]|l_sw[4]|l_sw[5]|l_sw[6]|l_sw[7]|l_sw[8]|l_sw[9]|vc|vdd|vss|z
+ \$2 sg13_lv_pmos L=0.13u W=1u AS=0.19p AD=0.19p PS=1.38u PD=1.38u rfmode=0
M$214
+ BOTTOM|TOP|h_sw[0]|h_sw[10]|h_sw[1]|h_sw[2]|h_sw[3]|h_sw[4]|h_sw[5]|h_sw[6]|h_sw[7]|h_sw[8]|h_sw[9]|l_sw[0]|l_sw[10]|l_sw[1]|l_sw[2]|l_sw[3]|l_sw[4]|l_sw[5]|l_sw[6]|l_sw[7]|l_sw[8]|l_sw[9]|vc|vdd|vss|z
+ in_l_sw[0]|x
+ BOTTOM|TOP|h_sw[0]|h_sw[10]|h_sw[1]|h_sw[2]|h_sw[3]|h_sw[4]|h_sw[5]|h_sw[6]|h_sw[7]|h_sw[8]|h_sw[9]|l_sw[0]|l_sw[10]|l_sw[1]|l_sw[2]|l_sw[3]|l_sw[4]|l_sw[5]|l_sw[6]|l_sw[7]|l_sw[8]|l_sw[9]|vc|vdd|vss|z
+ \$2 sg13_lv_pmos L=0.13u W=1u AS=0.19p AD=0.19p PS=1.38u PD=1.38u rfmode=0
M$215
+ BOTTOM|TOP|h_sw[0]|h_sw[10]|h_sw[1]|h_sw[2]|h_sw[3]|h_sw[4]|h_sw[5]|h_sw[6]|h_sw[7]|h_sw[8]|h_sw[9]|l_sw[0]|l_sw[10]|l_sw[1]|l_sw[2]|l_sw[3]|l_sw[4]|l_sw[5]|l_sw[6]|l_sw[7]|l_sw[8]|l_sw[9]|vc|vdd|vss|z
+ in_l_sw[0]|x
+ BOTTOM|TOP|h_sw[0]|h_sw[10]|h_sw[1]|h_sw[2]|h_sw[3]|h_sw[4]|h_sw[5]|h_sw[6]|h_sw[7]|h_sw[8]|h_sw[9]|l_sw[0]|l_sw[10]|l_sw[1]|l_sw[2]|l_sw[3]|l_sw[4]|l_sw[5]|l_sw[6]|l_sw[7]|l_sw[8]|l_sw[9]|vc|vdd|vss|z
+ \$2 sg13_lv_pmos L=0.13u W=1u AS=0.19p AD=0.19p PS=1.38u PD=1.38u rfmode=0
M$216
+ BOTTOM|TOP|h_sw[0]|h_sw[10]|h_sw[1]|h_sw[2]|h_sw[3]|h_sw[4]|h_sw[5]|h_sw[6]|h_sw[7]|h_sw[8]|h_sw[9]|l_sw[0]|l_sw[10]|l_sw[1]|l_sw[2]|l_sw[3]|l_sw[4]|l_sw[5]|l_sw[6]|l_sw[7]|l_sw[8]|l_sw[9]|vc|vdd|vss|z
+ in_l_sw[0]|x
+ BOTTOM|TOP|h_sw[0]|h_sw[10]|h_sw[1]|h_sw[2]|h_sw[3]|h_sw[4]|h_sw[5]|h_sw[6]|h_sw[7]|h_sw[8]|h_sw[9]|l_sw[0]|l_sw[10]|l_sw[1]|l_sw[2]|l_sw[3]|l_sw[4]|l_sw[5]|l_sw[6]|l_sw[7]|l_sw[8]|l_sw[9]|vc|vdd|vss|z
+ \$2 sg13_lv_pmos L=0.13u W=1u AS=0.19p AD=0.19p PS=1.38u PD=1.38u rfmode=0
M$217
+ BOTTOM|TOP|h_sw[0]|h_sw[10]|h_sw[1]|h_sw[2]|h_sw[3]|h_sw[4]|h_sw[5]|h_sw[6]|h_sw[7]|h_sw[8]|h_sw[9]|l_sw[0]|l_sw[10]|l_sw[1]|l_sw[2]|l_sw[3]|l_sw[4]|l_sw[5]|l_sw[6]|l_sw[7]|l_sw[8]|l_sw[9]|vc|vdd|vss|z
+ in_l_sw[0]|x
+ BOTTOM|TOP|h_sw[0]|h_sw[10]|h_sw[1]|h_sw[2]|h_sw[3]|h_sw[4]|h_sw[5]|h_sw[6]|h_sw[7]|h_sw[8]|h_sw[9]|l_sw[0]|l_sw[10]|l_sw[1]|l_sw[2]|l_sw[3]|l_sw[4]|l_sw[5]|l_sw[6]|l_sw[7]|l_sw[8]|l_sw[9]|vc|vdd|vss|z
+ \$2 sg13_lv_pmos L=0.13u W=1u AS=0.19p AD=0.19p PS=1.38u PD=1.38u rfmode=0
M$218
+ BOTTOM|TOP|h_sw[0]|h_sw[10]|h_sw[1]|h_sw[2]|h_sw[3]|h_sw[4]|h_sw[5]|h_sw[6]|h_sw[7]|h_sw[8]|h_sw[9]|l_sw[0]|l_sw[10]|l_sw[1]|l_sw[2]|l_sw[3]|l_sw[4]|l_sw[5]|l_sw[6]|l_sw[7]|l_sw[8]|l_sw[9]|vc|vdd|vss|z
+ in_l_sw[0]|x
+ BOTTOM|TOP|h_sw[0]|h_sw[10]|h_sw[1]|h_sw[2]|h_sw[3]|h_sw[4]|h_sw[5]|h_sw[6]|h_sw[7]|h_sw[8]|h_sw[9]|l_sw[0]|l_sw[10]|l_sw[1]|l_sw[2]|l_sw[3]|l_sw[4]|l_sw[5]|l_sw[6]|l_sw[7]|l_sw[8]|l_sw[9]|vc|vdd|vss|z
+ \$2 sg13_lv_pmos L=0.13u W=1u AS=0.19p AD=0.19p PS=1.38u PD=1.38u rfmode=0
M$219
+ BOTTOM|TOP|h_sw[0]|h_sw[10]|h_sw[1]|h_sw[2]|h_sw[3]|h_sw[4]|h_sw[5]|h_sw[6]|h_sw[7]|h_sw[8]|h_sw[9]|l_sw[0]|l_sw[10]|l_sw[1]|l_sw[2]|l_sw[3]|l_sw[4]|l_sw[5]|l_sw[6]|l_sw[7]|l_sw[8]|l_sw[9]|vc|vdd|vss|z
+ in_l_sw[0]|x
+ BOTTOM|TOP|h_sw[0]|h_sw[10]|h_sw[1]|h_sw[2]|h_sw[3]|h_sw[4]|h_sw[5]|h_sw[6]|h_sw[7]|h_sw[8]|h_sw[9]|l_sw[0]|l_sw[10]|l_sw[1]|l_sw[2]|l_sw[3]|l_sw[4]|l_sw[5]|l_sw[6]|l_sw[7]|l_sw[8]|l_sw[9]|vc|vdd|vss|z
+ \$2 sg13_lv_pmos L=0.13u W=1u AS=0.19p AD=0.19p PS=1.38u PD=1.38u rfmode=0
M$220
+ BOTTOM|TOP|h_sw[0]|h_sw[10]|h_sw[1]|h_sw[2]|h_sw[3]|h_sw[4]|h_sw[5]|h_sw[6]|h_sw[7]|h_sw[8]|h_sw[9]|l_sw[0]|l_sw[10]|l_sw[1]|l_sw[2]|l_sw[3]|l_sw[4]|l_sw[5]|l_sw[6]|l_sw[7]|l_sw[8]|l_sw[9]|vc|vdd|vss|z
+ in_l_sw[0]|x
+ BOTTOM|TOP|h_sw[0]|h_sw[10]|h_sw[1]|h_sw[2]|h_sw[3]|h_sw[4]|h_sw[5]|h_sw[6]|h_sw[7]|h_sw[8]|h_sw[9]|l_sw[0]|l_sw[10]|l_sw[1]|l_sw[2]|l_sw[3]|l_sw[4]|l_sw[5]|l_sw[6]|l_sw[7]|l_sw[8]|l_sw[9]|vc|vdd|vss|z
+ \$2 sg13_lv_pmos L=0.13u W=1u AS=0.19p AD=0.19p PS=1.38u PD=1.38u rfmode=0
M$221
+ BOTTOM|TOP|h_sw[0]|h_sw[10]|h_sw[1]|h_sw[2]|h_sw[3]|h_sw[4]|h_sw[5]|h_sw[6]|h_sw[7]|h_sw[8]|h_sw[9]|l_sw[0]|l_sw[10]|l_sw[1]|l_sw[2]|l_sw[3]|l_sw[4]|l_sw[5]|l_sw[6]|l_sw[7]|l_sw[8]|l_sw[9]|vc|vdd|vss|z
+ in_l_sw[0]|x
+ BOTTOM|TOP|h_sw[0]|h_sw[10]|h_sw[1]|h_sw[2]|h_sw[3]|h_sw[4]|h_sw[5]|h_sw[6]|h_sw[7]|h_sw[8]|h_sw[9]|l_sw[0]|l_sw[10]|l_sw[1]|l_sw[2]|l_sw[3]|l_sw[4]|l_sw[5]|l_sw[6]|l_sw[7]|l_sw[8]|l_sw[9]|vc|vdd|vss|z
+ \$2 sg13_lv_pmos L=0.13u W=1u AS=0.19p AD=0.19p PS=1.38u PD=1.38u rfmode=0
M$222
+ BOTTOM|TOP|h_sw[0]|h_sw[10]|h_sw[1]|h_sw[2]|h_sw[3]|h_sw[4]|h_sw[5]|h_sw[6]|h_sw[7]|h_sw[8]|h_sw[9]|l_sw[0]|l_sw[10]|l_sw[1]|l_sw[2]|l_sw[3]|l_sw[4]|l_sw[5]|l_sw[6]|l_sw[7]|l_sw[8]|l_sw[9]|vc|vdd|vss|z
+ in_l_sw[0]|x
+ BOTTOM|TOP|h_sw[0]|h_sw[10]|h_sw[1]|h_sw[2]|h_sw[3]|h_sw[4]|h_sw[5]|h_sw[6]|h_sw[7]|h_sw[8]|h_sw[9]|l_sw[0]|l_sw[10]|l_sw[1]|l_sw[2]|l_sw[3]|l_sw[4]|l_sw[5]|l_sw[6]|l_sw[7]|l_sw[8]|l_sw[9]|vc|vdd|vss|z
+ \$2 sg13_lv_pmos L=0.13u W=1u AS=0.19p AD=0.19p PS=1.38u PD=1.38u rfmode=0
M$223
+ BOTTOM|TOP|h_sw[0]|h_sw[10]|h_sw[1]|h_sw[2]|h_sw[3]|h_sw[4]|h_sw[5]|h_sw[6]|h_sw[7]|h_sw[8]|h_sw[9]|l_sw[0]|l_sw[10]|l_sw[1]|l_sw[2]|l_sw[3]|l_sw[4]|l_sw[5]|l_sw[6]|l_sw[7]|l_sw[8]|l_sw[9]|vc|vdd|vss|z
+ in_l_sw[0]|x
+ BOTTOM|TOP|h_sw[0]|h_sw[10]|h_sw[1]|h_sw[2]|h_sw[3]|h_sw[4]|h_sw[5]|h_sw[6]|h_sw[7]|h_sw[8]|h_sw[9]|l_sw[0]|l_sw[10]|l_sw[1]|l_sw[2]|l_sw[3]|l_sw[4]|l_sw[5]|l_sw[6]|l_sw[7]|l_sw[8]|l_sw[9]|vc|vdd|vss|z
+ \$2 sg13_lv_pmos L=0.13u W=1u AS=0.19p AD=0.19p PS=1.38u PD=1.38u rfmode=0
M$224
+ BOTTOM|TOP|h_sw[0]|h_sw[10]|h_sw[1]|h_sw[2]|h_sw[3]|h_sw[4]|h_sw[5]|h_sw[6]|h_sw[7]|h_sw[8]|h_sw[9]|l_sw[0]|l_sw[10]|l_sw[1]|l_sw[2]|l_sw[3]|l_sw[4]|l_sw[5]|l_sw[6]|l_sw[7]|l_sw[8]|l_sw[9]|vc|vdd|vss|z
+ in_l_sw[0]|x
+ BOTTOM|TOP|h_sw[0]|h_sw[10]|h_sw[1]|h_sw[2]|h_sw[3]|h_sw[4]|h_sw[5]|h_sw[6]|h_sw[7]|h_sw[8]|h_sw[9]|l_sw[0]|l_sw[10]|l_sw[1]|l_sw[2]|l_sw[3]|l_sw[4]|l_sw[5]|l_sw[6]|l_sw[7]|l_sw[8]|l_sw[9]|vc|vdd|vss|z
+ \$2 sg13_lv_pmos L=0.13u W=1u AS=0.19p AD=0.19p PS=1.38u PD=1.38u rfmode=0
M$225
+ BOTTOM|TOP|h_sw[0]|h_sw[10]|h_sw[1]|h_sw[2]|h_sw[3]|h_sw[4]|h_sw[5]|h_sw[6]|h_sw[7]|h_sw[8]|h_sw[9]|l_sw[0]|l_sw[10]|l_sw[1]|l_sw[2]|l_sw[3]|l_sw[4]|l_sw[5]|l_sw[6]|l_sw[7]|l_sw[8]|l_sw[9]|vc|vdd|vss|z
+ in_l_sw[0]|x
+ BOTTOM|TOP|h_sw[0]|h_sw[10]|h_sw[1]|h_sw[2]|h_sw[3]|h_sw[4]|h_sw[5]|h_sw[6]|h_sw[7]|h_sw[8]|h_sw[9]|l_sw[0]|l_sw[10]|l_sw[1]|l_sw[2]|l_sw[3]|l_sw[4]|l_sw[5]|l_sw[6]|l_sw[7]|l_sw[8]|l_sw[9]|vc|vdd|vss|z
+ \$2 sg13_lv_pmos L=0.13u W=1u AS=0.19p AD=0.19p PS=1.38u PD=1.38u rfmode=0
M$226
+ BOTTOM|TOP|h_sw[0]|h_sw[10]|h_sw[1]|h_sw[2]|h_sw[3]|h_sw[4]|h_sw[5]|h_sw[6]|h_sw[7]|h_sw[8]|h_sw[9]|l_sw[0]|l_sw[10]|l_sw[1]|l_sw[2]|l_sw[3]|l_sw[4]|l_sw[5]|l_sw[6]|l_sw[7]|l_sw[8]|l_sw[9]|vc|vdd|vss|z
+ in_l_sw[0]|x
+ BOTTOM|TOP|h_sw[0]|h_sw[10]|h_sw[1]|h_sw[2]|h_sw[3]|h_sw[4]|h_sw[5]|h_sw[6]|h_sw[7]|h_sw[8]|h_sw[9]|l_sw[0]|l_sw[10]|l_sw[1]|l_sw[2]|l_sw[3]|l_sw[4]|l_sw[5]|l_sw[6]|l_sw[7]|l_sw[8]|l_sw[9]|vc|vdd|vss|z
+ \$2 sg13_lv_pmos L=0.13u W=1u AS=0.19p AD=0.19p PS=1.38u PD=1.38u rfmode=0
M$227
+ BOTTOM|TOP|h_sw[0]|h_sw[10]|h_sw[1]|h_sw[2]|h_sw[3]|h_sw[4]|h_sw[5]|h_sw[6]|h_sw[7]|h_sw[8]|h_sw[9]|l_sw[0]|l_sw[10]|l_sw[1]|l_sw[2]|l_sw[3]|l_sw[4]|l_sw[5]|l_sw[6]|l_sw[7]|l_sw[8]|l_sw[9]|vc|vdd|vss|z
+ in_l_sw[0]|x
+ BOTTOM|TOP|h_sw[0]|h_sw[10]|h_sw[1]|h_sw[2]|h_sw[3]|h_sw[4]|h_sw[5]|h_sw[6]|h_sw[7]|h_sw[8]|h_sw[9]|l_sw[0]|l_sw[10]|l_sw[1]|l_sw[2]|l_sw[3]|l_sw[4]|l_sw[5]|l_sw[6]|l_sw[7]|l_sw[8]|l_sw[9]|vc|vdd|vss|z
+ \$2 sg13_lv_pmos L=0.13u W=1u AS=0.19p AD=0.19p PS=1.38u PD=1.38u rfmode=0
M$228
+ BOTTOM|TOP|h_sw[0]|h_sw[10]|h_sw[1]|h_sw[2]|h_sw[3]|h_sw[4]|h_sw[5]|h_sw[6]|h_sw[7]|h_sw[8]|h_sw[9]|l_sw[0]|l_sw[10]|l_sw[1]|l_sw[2]|l_sw[3]|l_sw[4]|l_sw[5]|l_sw[6]|l_sw[7]|l_sw[8]|l_sw[9]|vc|vdd|vss|z
+ in_l_sw[0]|x
+ BOTTOM|TOP|h_sw[0]|h_sw[10]|h_sw[1]|h_sw[2]|h_sw[3]|h_sw[4]|h_sw[5]|h_sw[6]|h_sw[7]|h_sw[8]|h_sw[9]|l_sw[0]|l_sw[10]|l_sw[1]|l_sw[2]|l_sw[3]|l_sw[4]|l_sw[5]|l_sw[6]|l_sw[7]|l_sw[8]|l_sw[9]|vc|vdd|vss|z
+ \$2 sg13_lv_pmos L=0.13u W=1u AS=0.19p AD=0.19p PS=1.38u PD=1.38u rfmode=0
M$229
+ BOTTOM|TOP|h_sw[0]|h_sw[10]|h_sw[1]|h_sw[2]|h_sw[3]|h_sw[4]|h_sw[5]|h_sw[6]|h_sw[7]|h_sw[8]|h_sw[9]|l_sw[0]|l_sw[10]|l_sw[1]|l_sw[2]|l_sw[3]|l_sw[4]|l_sw[5]|l_sw[6]|l_sw[7]|l_sw[8]|l_sw[9]|vc|vdd|vss|z
+ in_l_sw[0]|x
+ BOTTOM|TOP|h_sw[0]|h_sw[10]|h_sw[1]|h_sw[2]|h_sw[3]|h_sw[4]|h_sw[5]|h_sw[6]|h_sw[7]|h_sw[8]|h_sw[9]|l_sw[0]|l_sw[10]|l_sw[1]|l_sw[2]|l_sw[3]|l_sw[4]|l_sw[5]|l_sw[6]|l_sw[7]|l_sw[8]|l_sw[9]|vc|vdd|vss|z
+ \$2 sg13_lv_pmos L=0.13u W=1u AS=0.19p AD=0.19p PS=1.38u PD=1.38u rfmode=0
M$230
+ BOTTOM|TOP|h_sw[0]|h_sw[10]|h_sw[1]|h_sw[2]|h_sw[3]|h_sw[4]|h_sw[5]|h_sw[6]|h_sw[7]|h_sw[8]|h_sw[9]|l_sw[0]|l_sw[10]|l_sw[1]|l_sw[2]|l_sw[3]|l_sw[4]|l_sw[5]|l_sw[6]|l_sw[7]|l_sw[8]|l_sw[9]|vc|vdd|vss|z
+ in_l_sw[0]|x
+ BOTTOM|TOP|h_sw[0]|h_sw[10]|h_sw[1]|h_sw[2]|h_sw[3]|h_sw[4]|h_sw[5]|h_sw[6]|h_sw[7]|h_sw[8]|h_sw[9]|l_sw[0]|l_sw[10]|l_sw[1]|l_sw[2]|l_sw[3]|l_sw[4]|l_sw[5]|l_sw[6]|l_sw[7]|l_sw[8]|l_sw[9]|vc|vdd|vss|z
+ \$2 sg13_lv_pmos L=0.13u W=1u AS=0.19p AD=0.19p PS=1.38u PD=1.38u rfmode=0
M$231
+ BOTTOM|TOP|h_sw[0]|h_sw[10]|h_sw[1]|h_sw[2]|h_sw[3]|h_sw[4]|h_sw[5]|h_sw[6]|h_sw[7]|h_sw[8]|h_sw[9]|l_sw[0]|l_sw[10]|l_sw[1]|l_sw[2]|l_sw[3]|l_sw[4]|l_sw[5]|l_sw[6]|l_sw[7]|l_sw[8]|l_sw[9]|vc|vdd|vss|z
+ in_l_sw[0]|x
+ BOTTOM|TOP|h_sw[0]|h_sw[10]|h_sw[1]|h_sw[2]|h_sw[3]|h_sw[4]|h_sw[5]|h_sw[6]|h_sw[7]|h_sw[8]|h_sw[9]|l_sw[0]|l_sw[10]|l_sw[1]|l_sw[2]|l_sw[3]|l_sw[4]|l_sw[5]|l_sw[6]|l_sw[7]|l_sw[8]|l_sw[9]|vc|vdd|vss|z
+ \$2 sg13_lv_pmos L=0.13u W=1u AS=0.19p AD=0.19p PS=1.38u PD=1.38u rfmode=0
M$232
+ BOTTOM|TOP|h_sw[0]|h_sw[10]|h_sw[1]|h_sw[2]|h_sw[3]|h_sw[4]|h_sw[5]|h_sw[6]|h_sw[7]|h_sw[8]|h_sw[9]|l_sw[0]|l_sw[10]|l_sw[1]|l_sw[2]|l_sw[3]|l_sw[4]|l_sw[5]|l_sw[6]|l_sw[7]|l_sw[8]|l_sw[9]|vc|vdd|vss|z
+ in_l_sw[0]|x
+ BOTTOM|TOP|h_sw[0]|h_sw[10]|h_sw[1]|h_sw[2]|h_sw[3]|h_sw[4]|h_sw[5]|h_sw[6]|h_sw[7]|h_sw[8]|h_sw[9]|l_sw[0]|l_sw[10]|l_sw[1]|l_sw[2]|l_sw[3]|l_sw[4]|l_sw[5]|l_sw[6]|l_sw[7]|l_sw[8]|l_sw[9]|vc|vdd|vss|z
+ \$2 sg13_lv_pmos L=0.13u W=1u AS=0.19p AD=0.19p PS=1.38u PD=1.38u rfmode=0
M$233
+ BOTTOM|TOP|h_sw[0]|h_sw[10]|h_sw[1]|h_sw[2]|h_sw[3]|h_sw[4]|h_sw[5]|h_sw[6]|h_sw[7]|h_sw[8]|h_sw[9]|l_sw[0]|l_sw[10]|l_sw[1]|l_sw[2]|l_sw[3]|l_sw[4]|l_sw[5]|l_sw[6]|l_sw[7]|l_sw[8]|l_sw[9]|vc|vdd|vss|z
+ in_l_sw[0]|x
+ BOTTOM|TOP|h_sw[0]|h_sw[10]|h_sw[1]|h_sw[2]|h_sw[3]|h_sw[4]|h_sw[5]|h_sw[6]|h_sw[7]|h_sw[8]|h_sw[9]|l_sw[0]|l_sw[10]|l_sw[1]|l_sw[2]|l_sw[3]|l_sw[4]|l_sw[5]|l_sw[6]|l_sw[7]|l_sw[8]|l_sw[9]|vc|vdd|vss|z
+ \$2 sg13_lv_pmos L=0.13u W=1u AS=0.19p AD=0.19p PS=1.38u PD=1.38u rfmode=0
M$234
+ BOTTOM|TOP|h_sw[0]|h_sw[10]|h_sw[1]|h_sw[2]|h_sw[3]|h_sw[4]|h_sw[5]|h_sw[6]|h_sw[7]|h_sw[8]|h_sw[9]|l_sw[0]|l_sw[10]|l_sw[1]|l_sw[2]|l_sw[3]|l_sw[4]|l_sw[5]|l_sw[6]|l_sw[7]|l_sw[8]|l_sw[9]|vc|vdd|vss|z
+ in_l_sw[0]|x
+ BOTTOM|TOP|h_sw[0]|h_sw[10]|h_sw[1]|h_sw[2]|h_sw[3]|h_sw[4]|h_sw[5]|h_sw[6]|h_sw[7]|h_sw[8]|h_sw[9]|l_sw[0]|l_sw[10]|l_sw[1]|l_sw[2]|l_sw[3]|l_sw[4]|l_sw[5]|l_sw[6]|l_sw[7]|l_sw[8]|l_sw[9]|vc|vdd|vss|z
+ \$2 sg13_lv_pmos L=0.13u W=1u AS=0.19p AD=0.34p PS=1.38u PD=2.68u rfmode=0
M$235
+ BOTTOM|TOP|h_sw[0]|h_sw[10]|h_sw[1]|h_sw[2]|h_sw[3]|h_sw[4]|h_sw[5]|h_sw[6]|h_sw[7]|h_sw[8]|h_sw[9]|l_sw[0]|l_sw[10]|l_sw[1]|l_sw[2]|l_sw[3]|l_sw[4]|l_sw[5]|l_sw[6]|l_sw[7]|l_sw[8]|l_sw[9]|vc|vdd|vss|z
+ in_h_sw[0]|x
+ BOTTOM|TOP|h_sw[0]|h_sw[10]|h_sw[1]|h_sw[2]|h_sw[3]|h_sw[4]|h_sw[5]|h_sw[6]|h_sw[7]|h_sw[8]|h_sw[9]|l_sw[0]|l_sw[10]|l_sw[1]|l_sw[2]|l_sw[3]|l_sw[4]|l_sw[5]|l_sw[6]|l_sw[7]|l_sw[8]|l_sw[9]|vc|vdd|vss|z
+ \$2 sg13_lv_pmos L=0.13u W=1u AS=0.34p AD=0.19p PS=2.68u PD=1.38u rfmode=0
M$236
+ BOTTOM|TOP|h_sw[0]|h_sw[10]|h_sw[1]|h_sw[2]|h_sw[3]|h_sw[4]|h_sw[5]|h_sw[6]|h_sw[7]|h_sw[8]|h_sw[9]|l_sw[0]|l_sw[10]|l_sw[1]|l_sw[2]|l_sw[3]|l_sw[4]|l_sw[5]|l_sw[6]|l_sw[7]|l_sw[8]|l_sw[9]|vc|vdd|vss|z
+ in_h_sw[0]|x
+ BOTTOM|TOP|h_sw[0]|h_sw[10]|h_sw[1]|h_sw[2]|h_sw[3]|h_sw[4]|h_sw[5]|h_sw[6]|h_sw[7]|h_sw[8]|h_sw[9]|l_sw[0]|l_sw[10]|l_sw[1]|l_sw[2]|l_sw[3]|l_sw[4]|l_sw[5]|l_sw[6]|l_sw[7]|l_sw[8]|l_sw[9]|vc|vdd|vss|z
+ \$2 sg13_lv_pmos L=0.13u W=1u AS=0.19p AD=0.19p PS=1.38u PD=1.38u rfmode=0
M$237
+ BOTTOM|TOP|h_sw[0]|h_sw[10]|h_sw[1]|h_sw[2]|h_sw[3]|h_sw[4]|h_sw[5]|h_sw[6]|h_sw[7]|h_sw[8]|h_sw[9]|l_sw[0]|l_sw[10]|l_sw[1]|l_sw[2]|l_sw[3]|l_sw[4]|l_sw[5]|l_sw[6]|l_sw[7]|l_sw[8]|l_sw[9]|vc|vdd|vss|z
+ in_h_sw[0]|x
+ BOTTOM|TOP|h_sw[0]|h_sw[10]|h_sw[1]|h_sw[2]|h_sw[3]|h_sw[4]|h_sw[5]|h_sw[6]|h_sw[7]|h_sw[8]|h_sw[9]|l_sw[0]|l_sw[10]|l_sw[1]|l_sw[2]|l_sw[3]|l_sw[4]|l_sw[5]|l_sw[6]|l_sw[7]|l_sw[8]|l_sw[9]|vc|vdd|vss|z
+ \$2 sg13_lv_pmos L=0.13u W=1u AS=0.19p AD=0.19p PS=1.38u PD=1.38u rfmode=0
M$238
+ BOTTOM|TOP|h_sw[0]|h_sw[10]|h_sw[1]|h_sw[2]|h_sw[3]|h_sw[4]|h_sw[5]|h_sw[6]|h_sw[7]|h_sw[8]|h_sw[9]|l_sw[0]|l_sw[10]|l_sw[1]|l_sw[2]|l_sw[3]|l_sw[4]|l_sw[5]|l_sw[6]|l_sw[7]|l_sw[8]|l_sw[9]|vc|vdd|vss|z
+ in_h_sw[0]|x
+ BOTTOM|TOP|h_sw[0]|h_sw[10]|h_sw[1]|h_sw[2]|h_sw[3]|h_sw[4]|h_sw[5]|h_sw[6]|h_sw[7]|h_sw[8]|h_sw[9]|l_sw[0]|l_sw[10]|l_sw[1]|l_sw[2]|l_sw[3]|l_sw[4]|l_sw[5]|l_sw[6]|l_sw[7]|l_sw[8]|l_sw[9]|vc|vdd|vss|z
+ \$2 sg13_lv_pmos L=0.13u W=1u AS=0.19p AD=0.19p PS=1.38u PD=1.38u rfmode=0
M$239
+ BOTTOM|TOP|h_sw[0]|h_sw[10]|h_sw[1]|h_sw[2]|h_sw[3]|h_sw[4]|h_sw[5]|h_sw[6]|h_sw[7]|h_sw[8]|h_sw[9]|l_sw[0]|l_sw[10]|l_sw[1]|l_sw[2]|l_sw[3]|l_sw[4]|l_sw[5]|l_sw[6]|l_sw[7]|l_sw[8]|l_sw[9]|vc|vdd|vss|z
+ in_h_sw[0]|x
+ BOTTOM|TOP|h_sw[0]|h_sw[10]|h_sw[1]|h_sw[2]|h_sw[3]|h_sw[4]|h_sw[5]|h_sw[6]|h_sw[7]|h_sw[8]|h_sw[9]|l_sw[0]|l_sw[10]|l_sw[1]|l_sw[2]|l_sw[3]|l_sw[4]|l_sw[5]|l_sw[6]|l_sw[7]|l_sw[8]|l_sw[9]|vc|vdd|vss|z
+ \$2 sg13_lv_pmos L=0.13u W=1u AS=0.19p AD=0.19p PS=1.38u PD=1.38u rfmode=0
M$240
+ BOTTOM|TOP|h_sw[0]|h_sw[10]|h_sw[1]|h_sw[2]|h_sw[3]|h_sw[4]|h_sw[5]|h_sw[6]|h_sw[7]|h_sw[8]|h_sw[9]|l_sw[0]|l_sw[10]|l_sw[1]|l_sw[2]|l_sw[3]|l_sw[4]|l_sw[5]|l_sw[6]|l_sw[7]|l_sw[8]|l_sw[9]|vc|vdd|vss|z
+ in_h_sw[0]|x
+ BOTTOM|TOP|h_sw[0]|h_sw[10]|h_sw[1]|h_sw[2]|h_sw[3]|h_sw[4]|h_sw[5]|h_sw[6]|h_sw[7]|h_sw[8]|h_sw[9]|l_sw[0]|l_sw[10]|l_sw[1]|l_sw[2]|l_sw[3]|l_sw[4]|l_sw[5]|l_sw[6]|l_sw[7]|l_sw[8]|l_sw[9]|vc|vdd|vss|z
+ \$2 sg13_lv_pmos L=0.13u W=1u AS=0.19p AD=0.19p PS=1.38u PD=1.38u rfmode=0
M$241
+ BOTTOM|TOP|h_sw[0]|h_sw[10]|h_sw[1]|h_sw[2]|h_sw[3]|h_sw[4]|h_sw[5]|h_sw[6]|h_sw[7]|h_sw[8]|h_sw[9]|l_sw[0]|l_sw[10]|l_sw[1]|l_sw[2]|l_sw[3]|l_sw[4]|l_sw[5]|l_sw[6]|l_sw[7]|l_sw[8]|l_sw[9]|vc|vdd|vss|z
+ in_h_sw[0]|x
+ BOTTOM|TOP|h_sw[0]|h_sw[10]|h_sw[1]|h_sw[2]|h_sw[3]|h_sw[4]|h_sw[5]|h_sw[6]|h_sw[7]|h_sw[8]|h_sw[9]|l_sw[0]|l_sw[10]|l_sw[1]|l_sw[2]|l_sw[3]|l_sw[4]|l_sw[5]|l_sw[6]|l_sw[7]|l_sw[8]|l_sw[9]|vc|vdd|vss|z
+ \$2 sg13_lv_pmos L=0.13u W=1u AS=0.19p AD=0.19p PS=1.38u PD=1.38u rfmode=0
M$242
+ BOTTOM|TOP|h_sw[0]|h_sw[10]|h_sw[1]|h_sw[2]|h_sw[3]|h_sw[4]|h_sw[5]|h_sw[6]|h_sw[7]|h_sw[8]|h_sw[9]|l_sw[0]|l_sw[10]|l_sw[1]|l_sw[2]|l_sw[3]|l_sw[4]|l_sw[5]|l_sw[6]|l_sw[7]|l_sw[8]|l_sw[9]|vc|vdd|vss|z
+ in_h_sw[0]|x
+ BOTTOM|TOP|h_sw[0]|h_sw[10]|h_sw[1]|h_sw[2]|h_sw[3]|h_sw[4]|h_sw[5]|h_sw[6]|h_sw[7]|h_sw[8]|h_sw[9]|l_sw[0]|l_sw[10]|l_sw[1]|l_sw[2]|l_sw[3]|l_sw[4]|l_sw[5]|l_sw[6]|l_sw[7]|l_sw[8]|l_sw[9]|vc|vdd|vss|z
+ \$2 sg13_lv_pmos L=0.13u W=1u AS=0.19p AD=0.19p PS=1.38u PD=1.38u rfmode=0
M$243
+ BOTTOM|TOP|h_sw[0]|h_sw[10]|h_sw[1]|h_sw[2]|h_sw[3]|h_sw[4]|h_sw[5]|h_sw[6]|h_sw[7]|h_sw[8]|h_sw[9]|l_sw[0]|l_sw[10]|l_sw[1]|l_sw[2]|l_sw[3]|l_sw[4]|l_sw[5]|l_sw[6]|l_sw[7]|l_sw[8]|l_sw[9]|vc|vdd|vss|z
+ in_h_sw[0]|x
+ BOTTOM|TOP|h_sw[0]|h_sw[10]|h_sw[1]|h_sw[2]|h_sw[3]|h_sw[4]|h_sw[5]|h_sw[6]|h_sw[7]|h_sw[8]|h_sw[9]|l_sw[0]|l_sw[10]|l_sw[1]|l_sw[2]|l_sw[3]|l_sw[4]|l_sw[5]|l_sw[6]|l_sw[7]|l_sw[8]|l_sw[9]|vc|vdd|vss|z
+ \$2 sg13_lv_pmos L=0.13u W=1u AS=0.19p AD=0.19p PS=1.38u PD=1.38u rfmode=0
M$244
+ BOTTOM|TOP|h_sw[0]|h_sw[10]|h_sw[1]|h_sw[2]|h_sw[3]|h_sw[4]|h_sw[5]|h_sw[6]|h_sw[7]|h_sw[8]|h_sw[9]|l_sw[0]|l_sw[10]|l_sw[1]|l_sw[2]|l_sw[3]|l_sw[4]|l_sw[5]|l_sw[6]|l_sw[7]|l_sw[8]|l_sw[9]|vc|vdd|vss|z
+ in_h_sw[0]|x
+ BOTTOM|TOP|h_sw[0]|h_sw[10]|h_sw[1]|h_sw[2]|h_sw[3]|h_sw[4]|h_sw[5]|h_sw[6]|h_sw[7]|h_sw[8]|h_sw[9]|l_sw[0]|l_sw[10]|l_sw[1]|l_sw[2]|l_sw[3]|l_sw[4]|l_sw[5]|l_sw[6]|l_sw[7]|l_sw[8]|l_sw[9]|vc|vdd|vss|z
+ \$2 sg13_lv_pmos L=0.13u W=1u AS=0.19p AD=0.19p PS=1.38u PD=1.38u rfmode=0
M$245
+ BOTTOM|TOP|h_sw[0]|h_sw[10]|h_sw[1]|h_sw[2]|h_sw[3]|h_sw[4]|h_sw[5]|h_sw[6]|h_sw[7]|h_sw[8]|h_sw[9]|l_sw[0]|l_sw[10]|l_sw[1]|l_sw[2]|l_sw[3]|l_sw[4]|l_sw[5]|l_sw[6]|l_sw[7]|l_sw[8]|l_sw[9]|vc|vdd|vss|z
+ in_h_sw[0]|x
+ BOTTOM|TOP|h_sw[0]|h_sw[10]|h_sw[1]|h_sw[2]|h_sw[3]|h_sw[4]|h_sw[5]|h_sw[6]|h_sw[7]|h_sw[8]|h_sw[9]|l_sw[0]|l_sw[10]|l_sw[1]|l_sw[2]|l_sw[3]|l_sw[4]|l_sw[5]|l_sw[6]|l_sw[7]|l_sw[8]|l_sw[9]|vc|vdd|vss|z
+ \$2 sg13_lv_pmos L=0.13u W=1u AS=0.19p AD=0.19p PS=1.38u PD=1.38u rfmode=0
M$246
+ BOTTOM|TOP|h_sw[0]|h_sw[10]|h_sw[1]|h_sw[2]|h_sw[3]|h_sw[4]|h_sw[5]|h_sw[6]|h_sw[7]|h_sw[8]|h_sw[9]|l_sw[0]|l_sw[10]|l_sw[1]|l_sw[2]|l_sw[3]|l_sw[4]|l_sw[5]|l_sw[6]|l_sw[7]|l_sw[8]|l_sw[9]|vc|vdd|vss|z
+ in_h_sw[0]|x
+ BOTTOM|TOP|h_sw[0]|h_sw[10]|h_sw[1]|h_sw[2]|h_sw[3]|h_sw[4]|h_sw[5]|h_sw[6]|h_sw[7]|h_sw[8]|h_sw[9]|l_sw[0]|l_sw[10]|l_sw[1]|l_sw[2]|l_sw[3]|l_sw[4]|l_sw[5]|l_sw[6]|l_sw[7]|l_sw[8]|l_sw[9]|vc|vdd|vss|z
+ \$2 sg13_lv_pmos L=0.13u W=1u AS=0.19p AD=0.19p PS=1.38u PD=1.38u rfmode=0
M$247
+ BOTTOM|TOP|h_sw[0]|h_sw[10]|h_sw[1]|h_sw[2]|h_sw[3]|h_sw[4]|h_sw[5]|h_sw[6]|h_sw[7]|h_sw[8]|h_sw[9]|l_sw[0]|l_sw[10]|l_sw[1]|l_sw[2]|l_sw[3]|l_sw[4]|l_sw[5]|l_sw[6]|l_sw[7]|l_sw[8]|l_sw[9]|vc|vdd|vss|z
+ in_h_sw[0]|x
+ BOTTOM|TOP|h_sw[0]|h_sw[10]|h_sw[1]|h_sw[2]|h_sw[3]|h_sw[4]|h_sw[5]|h_sw[6]|h_sw[7]|h_sw[8]|h_sw[9]|l_sw[0]|l_sw[10]|l_sw[1]|l_sw[2]|l_sw[3]|l_sw[4]|l_sw[5]|l_sw[6]|l_sw[7]|l_sw[8]|l_sw[9]|vc|vdd|vss|z
+ \$2 sg13_lv_pmos L=0.13u W=1u AS=0.19p AD=0.19p PS=1.38u PD=1.38u rfmode=0
M$248
+ BOTTOM|TOP|h_sw[0]|h_sw[10]|h_sw[1]|h_sw[2]|h_sw[3]|h_sw[4]|h_sw[5]|h_sw[6]|h_sw[7]|h_sw[8]|h_sw[9]|l_sw[0]|l_sw[10]|l_sw[1]|l_sw[2]|l_sw[3]|l_sw[4]|l_sw[5]|l_sw[6]|l_sw[7]|l_sw[8]|l_sw[9]|vc|vdd|vss|z
+ in_h_sw[0]|x
+ BOTTOM|TOP|h_sw[0]|h_sw[10]|h_sw[1]|h_sw[2]|h_sw[3]|h_sw[4]|h_sw[5]|h_sw[6]|h_sw[7]|h_sw[8]|h_sw[9]|l_sw[0]|l_sw[10]|l_sw[1]|l_sw[2]|l_sw[3]|l_sw[4]|l_sw[5]|l_sw[6]|l_sw[7]|l_sw[8]|l_sw[9]|vc|vdd|vss|z
+ \$2 sg13_lv_pmos L=0.13u W=1u AS=0.19p AD=0.19p PS=1.38u PD=1.38u rfmode=0
M$249
+ BOTTOM|TOP|h_sw[0]|h_sw[10]|h_sw[1]|h_sw[2]|h_sw[3]|h_sw[4]|h_sw[5]|h_sw[6]|h_sw[7]|h_sw[8]|h_sw[9]|l_sw[0]|l_sw[10]|l_sw[1]|l_sw[2]|l_sw[3]|l_sw[4]|l_sw[5]|l_sw[6]|l_sw[7]|l_sw[8]|l_sw[9]|vc|vdd|vss|z
+ in_h_sw[0]|x
+ BOTTOM|TOP|h_sw[0]|h_sw[10]|h_sw[1]|h_sw[2]|h_sw[3]|h_sw[4]|h_sw[5]|h_sw[6]|h_sw[7]|h_sw[8]|h_sw[9]|l_sw[0]|l_sw[10]|l_sw[1]|l_sw[2]|l_sw[3]|l_sw[4]|l_sw[5]|l_sw[6]|l_sw[7]|l_sw[8]|l_sw[9]|vc|vdd|vss|z
+ \$2 sg13_lv_pmos L=0.13u W=1u AS=0.19p AD=0.19p PS=1.38u PD=1.38u rfmode=0
M$250
+ BOTTOM|TOP|h_sw[0]|h_sw[10]|h_sw[1]|h_sw[2]|h_sw[3]|h_sw[4]|h_sw[5]|h_sw[6]|h_sw[7]|h_sw[8]|h_sw[9]|l_sw[0]|l_sw[10]|l_sw[1]|l_sw[2]|l_sw[3]|l_sw[4]|l_sw[5]|l_sw[6]|l_sw[7]|l_sw[8]|l_sw[9]|vc|vdd|vss|z
+ in_h_sw[0]|x
+ BOTTOM|TOP|h_sw[0]|h_sw[10]|h_sw[1]|h_sw[2]|h_sw[3]|h_sw[4]|h_sw[5]|h_sw[6]|h_sw[7]|h_sw[8]|h_sw[9]|l_sw[0]|l_sw[10]|l_sw[1]|l_sw[2]|l_sw[3]|l_sw[4]|l_sw[5]|l_sw[6]|l_sw[7]|l_sw[8]|l_sw[9]|vc|vdd|vss|z
+ \$2 sg13_lv_pmos L=0.13u W=1u AS=0.19p AD=0.19p PS=1.38u PD=1.38u rfmode=0
M$251
+ BOTTOM|TOP|h_sw[0]|h_sw[10]|h_sw[1]|h_sw[2]|h_sw[3]|h_sw[4]|h_sw[5]|h_sw[6]|h_sw[7]|h_sw[8]|h_sw[9]|l_sw[0]|l_sw[10]|l_sw[1]|l_sw[2]|l_sw[3]|l_sw[4]|l_sw[5]|l_sw[6]|l_sw[7]|l_sw[8]|l_sw[9]|vc|vdd|vss|z
+ in_h_sw[0]|x
+ BOTTOM|TOP|h_sw[0]|h_sw[10]|h_sw[1]|h_sw[2]|h_sw[3]|h_sw[4]|h_sw[5]|h_sw[6]|h_sw[7]|h_sw[8]|h_sw[9]|l_sw[0]|l_sw[10]|l_sw[1]|l_sw[2]|l_sw[3]|l_sw[4]|l_sw[5]|l_sw[6]|l_sw[7]|l_sw[8]|l_sw[9]|vc|vdd|vss|z
+ \$2 sg13_lv_pmos L=0.13u W=1u AS=0.19p AD=0.19p PS=1.38u PD=1.38u rfmode=0
M$252
+ BOTTOM|TOP|h_sw[0]|h_sw[10]|h_sw[1]|h_sw[2]|h_sw[3]|h_sw[4]|h_sw[5]|h_sw[6]|h_sw[7]|h_sw[8]|h_sw[9]|l_sw[0]|l_sw[10]|l_sw[1]|l_sw[2]|l_sw[3]|l_sw[4]|l_sw[5]|l_sw[6]|l_sw[7]|l_sw[8]|l_sw[9]|vc|vdd|vss|z
+ in_h_sw[0]|x
+ BOTTOM|TOP|h_sw[0]|h_sw[10]|h_sw[1]|h_sw[2]|h_sw[3]|h_sw[4]|h_sw[5]|h_sw[6]|h_sw[7]|h_sw[8]|h_sw[9]|l_sw[0]|l_sw[10]|l_sw[1]|l_sw[2]|l_sw[3]|l_sw[4]|l_sw[5]|l_sw[6]|l_sw[7]|l_sw[8]|l_sw[9]|vc|vdd|vss|z
+ \$2 sg13_lv_pmos L=0.13u W=1u AS=0.19p AD=0.19p PS=1.38u PD=1.38u rfmode=0
M$253
+ BOTTOM|TOP|h_sw[0]|h_sw[10]|h_sw[1]|h_sw[2]|h_sw[3]|h_sw[4]|h_sw[5]|h_sw[6]|h_sw[7]|h_sw[8]|h_sw[9]|l_sw[0]|l_sw[10]|l_sw[1]|l_sw[2]|l_sw[3]|l_sw[4]|l_sw[5]|l_sw[6]|l_sw[7]|l_sw[8]|l_sw[9]|vc|vdd|vss|z
+ in_h_sw[0]|x
+ BOTTOM|TOP|h_sw[0]|h_sw[10]|h_sw[1]|h_sw[2]|h_sw[3]|h_sw[4]|h_sw[5]|h_sw[6]|h_sw[7]|h_sw[8]|h_sw[9]|l_sw[0]|l_sw[10]|l_sw[1]|l_sw[2]|l_sw[3]|l_sw[4]|l_sw[5]|l_sw[6]|l_sw[7]|l_sw[8]|l_sw[9]|vc|vdd|vss|z
+ \$2 sg13_lv_pmos L=0.13u W=1u AS=0.19p AD=0.19p PS=1.38u PD=1.38u rfmode=0
M$254
+ BOTTOM|TOP|h_sw[0]|h_sw[10]|h_sw[1]|h_sw[2]|h_sw[3]|h_sw[4]|h_sw[5]|h_sw[6]|h_sw[7]|h_sw[8]|h_sw[9]|l_sw[0]|l_sw[10]|l_sw[1]|l_sw[2]|l_sw[3]|l_sw[4]|l_sw[5]|l_sw[6]|l_sw[7]|l_sw[8]|l_sw[9]|vc|vdd|vss|z
+ in_h_sw[0]|x
+ BOTTOM|TOP|h_sw[0]|h_sw[10]|h_sw[1]|h_sw[2]|h_sw[3]|h_sw[4]|h_sw[5]|h_sw[6]|h_sw[7]|h_sw[8]|h_sw[9]|l_sw[0]|l_sw[10]|l_sw[1]|l_sw[2]|l_sw[3]|l_sw[4]|l_sw[5]|l_sw[6]|l_sw[7]|l_sw[8]|l_sw[9]|vc|vdd|vss|z
+ \$2 sg13_lv_pmos L=0.13u W=1u AS=0.19p AD=0.19p PS=1.38u PD=1.38u rfmode=0
M$255
+ BOTTOM|TOP|h_sw[0]|h_sw[10]|h_sw[1]|h_sw[2]|h_sw[3]|h_sw[4]|h_sw[5]|h_sw[6]|h_sw[7]|h_sw[8]|h_sw[9]|l_sw[0]|l_sw[10]|l_sw[1]|l_sw[2]|l_sw[3]|l_sw[4]|l_sw[5]|l_sw[6]|l_sw[7]|l_sw[8]|l_sw[9]|vc|vdd|vss|z
+ in_h_sw[0]|x
+ BOTTOM|TOP|h_sw[0]|h_sw[10]|h_sw[1]|h_sw[2]|h_sw[3]|h_sw[4]|h_sw[5]|h_sw[6]|h_sw[7]|h_sw[8]|h_sw[9]|l_sw[0]|l_sw[10]|l_sw[1]|l_sw[2]|l_sw[3]|l_sw[4]|l_sw[5]|l_sw[6]|l_sw[7]|l_sw[8]|l_sw[9]|vc|vdd|vss|z
+ \$2 sg13_lv_pmos L=0.13u W=1u AS=0.19p AD=0.19p PS=1.38u PD=1.38u rfmode=0
M$256
+ BOTTOM|TOP|h_sw[0]|h_sw[10]|h_sw[1]|h_sw[2]|h_sw[3]|h_sw[4]|h_sw[5]|h_sw[6]|h_sw[7]|h_sw[8]|h_sw[9]|l_sw[0]|l_sw[10]|l_sw[1]|l_sw[2]|l_sw[3]|l_sw[4]|l_sw[5]|l_sw[6]|l_sw[7]|l_sw[8]|l_sw[9]|vc|vdd|vss|z
+ in_h_sw[0]|x
+ BOTTOM|TOP|h_sw[0]|h_sw[10]|h_sw[1]|h_sw[2]|h_sw[3]|h_sw[4]|h_sw[5]|h_sw[6]|h_sw[7]|h_sw[8]|h_sw[9]|l_sw[0]|l_sw[10]|l_sw[1]|l_sw[2]|l_sw[3]|l_sw[4]|l_sw[5]|l_sw[6]|l_sw[7]|l_sw[8]|l_sw[9]|vc|vdd|vss|z
+ \$2 sg13_lv_pmos L=0.13u W=1u AS=0.19p AD=0.19p PS=1.38u PD=1.38u rfmode=0
M$257
+ BOTTOM|TOP|h_sw[0]|h_sw[10]|h_sw[1]|h_sw[2]|h_sw[3]|h_sw[4]|h_sw[5]|h_sw[6]|h_sw[7]|h_sw[8]|h_sw[9]|l_sw[0]|l_sw[10]|l_sw[1]|l_sw[2]|l_sw[3]|l_sw[4]|l_sw[5]|l_sw[6]|l_sw[7]|l_sw[8]|l_sw[9]|vc|vdd|vss|z
+ in_h_sw[0]|x
+ BOTTOM|TOP|h_sw[0]|h_sw[10]|h_sw[1]|h_sw[2]|h_sw[3]|h_sw[4]|h_sw[5]|h_sw[6]|h_sw[7]|h_sw[8]|h_sw[9]|l_sw[0]|l_sw[10]|l_sw[1]|l_sw[2]|l_sw[3]|l_sw[4]|l_sw[5]|l_sw[6]|l_sw[7]|l_sw[8]|l_sw[9]|vc|vdd|vss|z
+ \$2 sg13_lv_pmos L=0.13u W=1u AS=0.19p AD=0.19p PS=1.38u PD=1.38u rfmode=0
M$258
+ BOTTOM|TOP|h_sw[0]|h_sw[10]|h_sw[1]|h_sw[2]|h_sw[3]|h_sw[4]|h_sw[5]|h_sw[6]|h_sw[7]|h_sw[8]|h_sw[9]|l_sw[0]|l_sw[10]|l_sw[1]|l_sw[2]|l_sw[3]|l_sw[4]|l_sw[5]|l_sw[6]|l_sw[7]|l_sw[8]|l_sw[9]|vc|vdd|vss|z
+ in_h_sw[0]|x
+ BOTTOM|TOP|h_sw[0]|h_sw[10]|h_sw[1]|h_sw[2]|h_sw[3]|h_sw[4]|h_sw[5]|h_sw[6]|h_sw[7]|h_sw[8]|h_sw[9]|l_sw[0]|l_sw[10]|l_sw[1]|l_sw[2]|l_sw[3]|l_sw[4]|l_sw[5]|l_sw[6]|l_sw[7]|l_sw[8]|l_sw[9]|vc|vdd|vss|z
+ \$2 sg13_lv_pmos L=0.13u W=1u AS=0.19p AD=0.19p PS=1.38u PD=1.38u rfmode=0
M$259
+ BOTTOM|TOP|h_sw[0]|h_sw[10]|h_sw[1]|h_sw[2]|h_sw[3]|h_sw[4]|h_sw[5]|h_sw[6]|h_sw[7]|h_sw[8]|h_sw[9]|l_sw[0]|l_sw[10]|l_sw[1]|l_sw[2]|l_sw[3]|l_sw[4]|l_sw[5]|l_sw[6]|l_sw[7]|l_sw[8]|l_sw[9]|vc|vdd|vss|z
+ in_h_sw[0]|x
+ BOTTOM|TOP|h_sw[0]|h_sw[10]|h_sw[1]|h_sw[2]|h_sw[3]|h_sw[4]|h_sw[5]|h_sw[6]|h_sw[7]|h_sw[8]|h_sw[9]|l_sw[0]|l_sw[10]|l_sw[1]|l_sw[2]|l_sw[3]|l_sw[4]|l_sw[5]|l_sw[6]|l_sw[7]|l_sw[8]|l_sw[9]|vc|vdd|vss|z
+ \$2 sg13_lv_pmos L=0.13u W=1u AS=0.19p AD=0.19p PS=1.38u PD=1.38u rfmode=0
M$260
+ BOTTOM|TOP|h_sw[0]|h_sw[10]|h_sw[1]|h_sw[2]|h_sw[3]|h_sw[4]|h_sw[5]|h_sw[6]|h_sw[7]|h_sw[8]|h_sw[9]|l_sw[0]|l_sw[10]|l_sw[1]|l_sw[2]|l_sw[3]|l_sw[4]|l_sw[5]|l_sw[6]|l_sw[7]|l_sw[8]|l_sw[9]|vc|vdd|vss|z
+ in_h_sw[0]|x
+ BOTTOM|TOP|h_sw[0]|h_sw[10]|h_sw[1]|h_sw[2]|h_sw[3]|h_sw[4]|h_sw[5]|h_sw[6]|h_sw[7]|h_sw[8]|h_sw[9]|l_sw[0]|l_sw[10]|l_sw[1]|l_sw[2]|l_sw[3]|l_sw[4]|l_sw[5]|l_sw[6]|l_sw[7]|l_sw[8]|l_sw[9]|vc|vdd|vss|z
+ \$2 sg13_lv_pmos L=0.13u W=1u AS=0.19p AD=0.19p PS=1.38u PD=1.38u rfmode=0
M$261
+ BOTTOM|TOP|h_sw[0]|h_sw[10]|h_sw[1]|h_sw[2]|h_sw[3]|h_sw[4]|h_sw[5]|h_sw[6]|h_sw[7]|h_sw[8]|h_sw[9]|l_sw[0]|l_sw[10]|l_sw[1]|l_sw[2]|l_sw[3]|l_sw[4]|l_sw[5]|l_sw[6]|l_sw[7]|l_sw[8]|l_sw[9]|vc|vdd|vss|z
+ in_h_sw[0]|x
+ BOTTOM|TOP|h_sw[0]|h_sw[10]|h_sw[1]|h_sw[2]|h_sw[3]|h_sw[4]|h_sw[5]|h_sw[6]|h_sw[7]|h_sw[8]|h_sw[9]|l_sw[0]|l_sw[10]|l_sw[1]|l_sw[2]|l_sw[3]|l_sw[4]|l_sw[5]|l_sw[6]|l_sw[7]|l_sw[8]|l_sw[9]|vc|vdd|vss|z
+ \$2 sg13_lv_pmos L=0.13u W=1u AS=0.19p AD=0.19p PS=1.38u PD=1.38u rfmode=0
M$262
+ BOTTOM|TOP|h_sw[0]|h_sw[10]|h_sw[1]|h_sw[2]|h_sw[3]|h_sw[4]|h_sw[5]|h_sw[6]|h_sw[7]|h_sw[8]|h_sw[9]|l_sw[0]|l_sw[10]|l_sw[1]|l_sw[2]|l_sw[3]|l_sw[4]|l_sw[5]|l_sw[6]|l_sw[7]|l_sw[8]|l_sw[9]|vc|vdd|vss|z
+ in_h_sw[0]|x
+ BOTTOM|TOP|h_sw[0]|h_sw[10]|h_sw[1]|h_sw[2]|h_sw[3]|h_sw[4]|h_sw[5]|h_sw[6]|h_sw[7]|h_sw[8]|h_sw[9]|l_sw[0]|l_sw[10]|l_sw[1]|l_sw[2]|l_sw[3]|l_sw[4]|l_sw[5]|l_sw[6]|l_sw[7]|l_sw[8]|l_sw[9]|vc|vdd|vss|z
+ \$2 sg13_lv_pmos L=0.13u W=1u AS=0.19p AD=0.19p PS=1.38u PD=1.38u rfmode=0
M$263
+ BOTTOM|TOP|h_sw[0]|h_sw[10]|h_sw[1]|h_sw[2]|h_sw[3]|h_sw[4]|h_sw[5]|h_sw[6]|h_sw[7]|h_sw[8]|h_sw[9]|l_sw[0]|l_sw[10]|l_sw[1]|l_sw[2]|l_sw[3]|l_sw[4]|l_sw[5]|l_sw[6]|l_sw[7]|l_sw[8]|l_sw[9]|vc|vdd|vss|z
+ in_h_sw[0]|x
+ BOTTOM|TOP|h_sw[0]|h_sw[10]|h_sw[1]|h_sw[2]|h_sw[3]|h_sw[4]|h_sw[5]|h_sw[6]|h_sw[7]|h_sw[8]|h_sw[9]|l_sw[0]|l_sw[10]|l_sw[1]|l_sw[2]|l_sw[3]|l_sw[4]|l_sw[5]|l_sw[6]|l_sw[7]|l_sw[8]|l_sw[9]|vc|vdd|vss|z
+ \$2 sg13_lv_pmos L=0.13u W=1u AS=0.19p AD=0.19p PS=1.38u PD=1.38u rfmode=0
M$264
+ BOTTOM|TOP|h_sw[0]|h_sw[10]|h_sw[1]|h_sw[2]|h_sw[3]|h_sw[4]|h_sw[5]|h_sw[6]|h_sw[7]|h_sw[8]|h_sw[9]|l_sw[0]|l_sw[10]|l_sw[1]|l_sw[2]|l_sw[3]|l_sw[4]|l_sw[5]|l_sw[6]|l_sw[7]|l_sw[8]|l_sw[9]|vc|vdd|vss|z
+ in_h_sw[0]|x
+ BOTTOM|TOP|h_sw[0]|h_sw[10]|h_sw[1]|h_sw[2]|h_sw[3]|h_sw[4]|h_sw[5]|h_sw[6]|h_sw[7]|h_sw[8]|h_sw[9]|l_sw[0]|l_sw[10]|l_sw[1]|l_sw[2]|l_sw[3]|l_sw[4]|l_sw[5]|l_sw[6]|l_sw[7]|l_sw[8]|l_sw[9]|vc|vdd|vss|z
+ \$2 sg13_lv_pmos L=0.13u W=1u AS=0.19p AD=0.19p PS=1.38u PD=1.38u rfmode=0
M$265
+ BOTTOM|TOP|h_sw[0]|h_sw[10]|h_sw[1]|h_sw[2]|h_sw[3]|h_sw[4]|h_sw[5]|h_sw[6]|h_sw[7]|h_sw[8]|h_sw[9]|l_sw[0]|l_sw[10]|l_sw[1]|l_sw[2]|l_sw[3]|l_sw[4]|l_sw[5]|l_sw[6]|l_sw[7]|l_sw[8]|l_sw[9]|vc|vdd|vss|z
+ in_h_sw[0]|x
+ BOTTOM|TOP|h_sw[0]|h_sw[10]|h_sw[1]|h_sw[2]|h_sw[3]|h_sw[4]|h_sw[5]|h_sw[6]|h_sw[7]|h_sw[8]|h_sw[9]|l_sw[0]|l_sw[10]|l_sw[1]|l_sw[2]|l_sw[3]|l_sw[4]|l_sw[5]|l_sw[6]|l_sw[7]|l_sw[8]|l_sw[9]|vc|vdd|vss|z
+ \$2 sg13_lv_pmos L=0.13u W=1u AS=0.19p AD=0.19p PS=1.38u PD=1.38u rfmode=0
M$266
+ BOTTOM|TOP|h_sw[0]|h_sw[10]|h_sw[1]|h_sw[2]|h_sw[3]|h_sw[4]|h_sw[5]|h_sw[6]|h_sw[7]|h_sw[8]|h_sw[9]|l_sw[0]|l_sw[10]|l_sw[1]|l_sw[2]|l_sw[3]|l_sw[4]|l_sw[5]|l_sw[6]|l_sw[7]|l_sw[8]|l_sw[9]|vc|vdd|vss|z
+ in_h_sw[0]|x
+ BOTTOM|TOP|h_sw[0]|h_sw[10]|h_sw[1]|h_sw[2]|h_sw[3]|h_sw[4]|h_sw[5]|h_sw[6]|h_sw[7]|h_sw[8]|h_sw[9]|l_sw[0]|l_sw[10]|l_sw[1]|l_sw[2]|l_sw[3]|l_sw[4]|l_sw[5]|l_sw[6]|l_sw[7]|l_sw[8]|l_sw[9]|vc|vdd|vss|z
+ \$2 sg13_lv_pmos L=0.13u W=1u AS=0.19p AD=0.34p PS=1.38u PD=2.68u rfmode=0
M$267
+ BOTTOM|TOP|h_sw[0]|h_sw[10]|h_sw[1]|h_sw[2]|h_sw[3]|h_sw[4]|h_sw[5]|h_sw[6]|h_sw[7]|h_sw[8]|h_sw[9]|l_sw[0]|l_sw[10]|l_sw[1]|l_sw[2]|l_sw[3]|l_sw[4]|l_sw[5]|l_sw[6]|l_sw[7]|l_sw[8]|l_sw[9]|vc|vdd|vss|z
+ in_h_sw[3]|x
+ BOTTOM|TOP|h_sw[0]|h_sw[10]|h_sw[1]|h_sw[2]|h_sw[3]|h_sw[4]|h_sw[5]|h_sw[6]|h_sw[7]|h_sw[8]|h_sw[9]|l_sw[0]|l_sw[10]|l_sw[1]|l_sw[2]|l_sw[3]|l_sw[4]|l_sw[5]|l_sw[6]|l_sw[7]|l_sw[8]|l_sw[9]|vc|vdd|vss|z
+ \$10 sg13_lv_pmos L=0.13u W=1u AS=0.34p AD=0.19p PS=2.68u PD=1.38u rfmode=0
M$268
+ BOTTOM|TOP|h_sw[0]|h_sw[10]|h_sw[1]|h_sw[2]|h_sw[3]|h_sw[4]|h_sw[5]|h_sw[6]|h_sw[7]|h_sw[8]|h_sw[9]|l_sw[0]|l_sw[10]|l_sw[1]|l_sw[2]|l_sw[3]|l_sw[4]|l_sw[5]|l_sw[6]|l_sw[7]|l_sw[8]|l_sw[9]|vc|vdd|vss|z
+ in_h_sw[3]|x
+ BOTTOM|TOP|h_sw[0]|h_sw[10]|h_sw[1]|h_sw[2]|h_sw[3]|h_sw[4]|h_sw[5]|h_sw[6]|h_sw[7]|h_sw[8]|h_sw[9]|l_sw[0]|l_sw[10]|l_sw[1]|l_sw[2]|l_sw[3]|l_sw[4]|l_sw[5]|l_sw[6]|l_sw[7]|l_sw[8]|l_sw[9]|vc|vdd|vss|z
+ \$10 sg13_lv_pmos L=0.13u W=1u AS=0.19p AD=0.19p PS=1.38u PD=1.38u rfmode=0
M$269
+ BOTTOM|TOP|h_sw[0]|h_sw[10]|h_sw[1]|h_sw[2]|h_sw[3]|h_sw[4]|h_sw[5]|h_sw[6]|h_sw[7]|h_sw[8]|h_sw[9]|l_sw[0]|l_sw[10]|l_sw[1]|l_sw[2]|l_sw[3]|l_sw[4]|l_sw[5]|l_sw[6]|l_sw[7]|l_sw[8]|l_sw[9]|vc|vdd|vss|z
+ in_h_sw[3]|x
+ BOTTOM|TOP|h_sw[0]|h_sw[10]|h_sw[1]|h_sw[2]|h_sw[3]|h_sw[4]|h_sw[5]|h_sw[6]|h_sw[7]|h_sw[8]|h_sw[9]|l_sw[0]|l_sw[10]|l_sw[1]|l_sw[2]|l_sw[3]|l_sw[4]|l_sw[5]|l_sw[6]|l_sw[7]|l_sw[8]|l_sw[9]|vc|vdd|vss|z
+ \$10 sg13_lv_pmos L=0.13u W=1u AS=0.19p AD=0.19p PS=1.38u PD=1.38u rfmode=0
M$270
+ BOTTOM|TOP|h_sw[0]|h_sw[10]|h_sw[1]|h_sw[2]|h_sw[3]|h_sw[4]|h_sw[5]|h_sw[6]|h_sw[7]|h_sw[8]|h_sw[9]|l_sw[0]|l_sw[10]|l_sw[1]|l_sw[2]|l_sw[3]|l_sw[4]|l_sw[5]|l_sw[6]|l_sw[7]|l_sw[8]|l_sw[9]|vc|vdd|vss|z
+ in_h_sw[3]|x
+ BOTTOM|TOP|h_sw[0]|h_sw[10]|h_sw[1]|h_sw[2]|h_sw[3]|h_sw[4]|h_sw[5]|h_sw[6]|h_sw[7]|h_sw[8]|h_sw[9]|l_sw[0]|l_sw[10]|l_sw[1]|l_sw[2]|l_sw[3]|l_sw[4]|l_sw[5]|l_sw[6]|l_sw[7]|l_sw[8]|l_sw[9]|vc|vdd|vss|z
+ \$10 sg13_lv_pmos L=0.13u W=1u AS=0.19p AD=0.19p PS=1.38u PD=1.38u rfmode=0
M$271
+ BOTTOM|TOP|h_sw[0]|h_sw[10]|h_sw[1]|h_sw[2]|h_sw[3]|h_sw[4]|h_sw[5]|h_sw[6]|h_sw[7]|h_sw[8]|h_sw[9]|l_sw[0]|l_sw[10]|l_sw[1]|l_sw[2]|l_sw[3]|l_sw[4]|l_sw[5]|l_sw[6]|l_sw[7]|l_sw[8]|l_sw[9]|vc|vdd|vss|z
+ in_h_sw[3]|x
+ BOTTOM|TOP|h_sw[0]|h_sw[10]|h_sw[1]|h_sw[2]|h_sw[3]|h_sw[4]|h_sw[5]|h_sw[6]|h_sw[7]|h_sw[8]|h_sw[9]|l_sw[0]|l_sw[10]|l_sw[1]|l_sw[2]|l_sw[3]|l_sw[4]|l_sw[5]|l_sw[6]|l_sw[7]|l_sw[8]|l_sw[9]|vc|vdd|vss|z
+ \$10 sg13_lv_pmos L=0.13u W=1u AS=0.19p AD=0.19p PS=1.38u PD=1.38u rfmode=0
M$272
+ BOTTOM|TOP|h_sw[0]|h_sw[10]|h_sw[1]|h_sw[2]|h_sw[3]|h_sw[4]|h_sw[5]|h_sw[6]|h_sw[7]|h_sw[8]|h_sw[9]|l_sw[0]|l_sw[10]|l_sw[1]|l_sw[2]|l_sw[3]|l_sw[4]|l_sw[5]|l_sw[6]|l_sw[7]|l_sw[8]|l_sw[9]|vc|vdd|vss|z
+ in_h_sw[3]|x
+ BOTTOM|TOP|h_sw[0]|h_sw[10]|h_sw[1]|h_sw[2]|h_sw[3]|h_sw[4]|h_sw[5]|h_sw[6]|h_sw[7]|h_sw[8]|h_sw[9]|l_sw[0]|l_sw[10]|l_sw[1]|l_sw[2]|l_sw[3]|l_sw[4]|l_sw[5]|l_sw[6]|l_sw[7]|l_sw[8]|l_sw[9]|vc|vdd|vss|z
+ \$10 sg13_lv_pmos L=0.13u W=1u AS=0.19p AD=0.19p PS=1.38u PD=1.38u rfmode=0
M$273
+ BOTTOM|TOP|h_sw[0]|h_sw[10]|h_sw[1]|h_sw[2]|h_sw[3]|h_sw[4]|h_sw[5]|h_sw[6]|h_sw[7]|h_sw[8]|h_sw[9]|l_sw[0]|l_sw[10]|l_sw[1]|l_sw[2]|l_sw[3]|l_sw[4]|l_sw[5]|l_sw[6]|l_sw[7]|l_sw[8]|l_sw[9]|vc|vdd|vss|z
+ in_h_sw[3]|x
+ BOTTOM|TOP|h_sw[0]|h_sw[10]|h_sw[1]|h_sw[2]|h_sw[3]|h_sw[4]|h_sw[5]|h_sw[6]|h_sw[7]|h_sw[8]|h_sw[9]|l_sw[0]|l_sw[10]|l_sw[1]|l_sw[2]|l_sw[3]|l_sw[4]|l_sw[5]|l_sw[6]|l_sw[7]|l_sw[8]|l_sw[9]|vc|vdd|vss|z
+ \$10 sg13_lv_pmos L=0.13u W=1u AS=0.19p AD=0.19p PS=1.38u PD=1.38u rfmode=0
M$274
+ BOTTOM|TOP|h_sw[0]|h_sw[10]|h_sw[1]|h_sw[2]|h_sw[3]|h_sw[4]|h_sw[5]|h_sw[6]|h_sw[7]|h_sw[8]|h_sw[9]|l_sw[0]|l_sw[10]|l_sw[1]|l_sw[2]|l_sw[3]|l_sw[4]|l_sw[5]|l_sw[6]|l_sw[7]|l_sw[8]|l_sw[9]|vc|vdd|vss|z
+ in_h_sw[3]|x
+ BOTTOM|TOP|h_sw[0]|h_sw[10]|h_sw[1]|h_sw[2]|h_sw[3]|h_sw[4]|h_sw[5]|h_sw[6]|h_sw[7]|h_sw[8]|h_sw[9]|l_sw[0]|l_sw[10]|l_sw[1]|l_sw[2]|l_sw[3]|l_sw[4]|l_sw[5]|l_sw[6]|l_sw[7]|l_sw[8]|l_sw[9]|vc|vdd|vss|z
+ \$10 sg13_lv_pmos L=0.13u W=1u AS=0.19p AD=0.34p PS=1.38u PD=2.68u rfmode=0
M$275
+ BOTTOM|TOP|h_sw[0]|h_sw[10]|h_sw[1]|h_sw[2]|h_sw[3]|h_sw[4]|h_sw[5]|h_sw[6]|h_sw[7]|h_sw[8]|h_sw[9]|l_sw[0]|l_sw[10]|l_sw[1]|l_sw[2]|l_sw[3]|l_sw[4]|l_sw[5]|l_sw[6]|l_sw[7]|l_sw[8]|l_sw[9]|vc|vdd|vss|z
+ in_h_sw[4]|x
+ BOTTOM|TOP|h_sw[0]|h_sw[10]|h_sw[1]|h_sw[2]|h_sw[3]|h_sw[4]|h_sw[5]|h_sw[6]|h_sw[7]|h_sw[8]|h_sw[9]|l_sw[0]|l_sw[10]|l_sw[1]|l_sw[2]|l_sw[3]|l_sw[4]|l_sw[5]|l_sw[6]|l_sw[7]|l_sw[8]|l_sw[9]|vc|vdd|vss|z
+ \$10 sg13_lv_pmos L=0.13u W=1u AS=0.34p AD=0.19p PS=2.68u PD=1.38u rfmode=0
M$276
+ BOTTOM|TOP|h_sw[0]|h_sw[10]|h_sw[1]|h_sw[2]|h_sw[3]|h_sw[4]|h_sw[5]|h_sw[6]|h_sw[7]|h_sw[8]|h_sw[9]|l_sw[0]|l_sw[10]|l_sw[1]|l_sw[2]|l_sw[3]|l_sw[4]|l_sw[5]|l_sw[6]|l_sw[7]|l_sw[8]|l_sw[9]|vc|vdd|vss|z
+ in_h_sw[4]|x
+ BOTTOM|TOP|h_sw[0]|h_sw[10]|h_sw[1]|h_sw[2]|h_sw[3]|h_sw[4]|h_sw[5]|h_sw[6]|h_sw[7]|h_sw[8]|h_sw[9]|l_sw[0]|l_sw[10]|l_sw[1]|l_sw[2]|l_sw[3]|l_sw[4]|l_sw[5]|l_sw[6]|l_sw[7]|l_sw[8]|l_sw[9]|vc|vdd|vss|z
+ \$10 sg13_lv_pmos L=0.13u W=1u AS=0.19p AD=0.19p PS=1.38u PD=1.38u rfmode=0
M$277
+ BOTTOM|TOP|h_sw[0]|h_sw[10]|h_sw[1]|h_sw[2]|h_sw[3]|h_sw[4]|h_sw[5]|h_sw[6]|h_sw[7]|h_sw[8]|h_sw[9]|l_sw[0]|l_sw[10]|l_sw[1]|l_sw[2]|l_sw[3]|l_sw[4]|l_sw[5]|l_sw[6]|l_sw[7]|l_sw[8]|l_sw[9]|vc|vdd|vss|z
+ in_h_sw[4]|x
+ BOTTOM|TOP|h_sw[0]|h_sw[10]|h_sw[1]|h_sw[2]|h_sw[3]|h_sw[4]|h_sw[5]|h_sw[6]|h_sw[7]|h_sw[8]|h_sw[9]|l_sw[0]|l_sw[10]|l_sw[1]|l_sw[2]|l_sw[3]|l_sw[4]|l_sw[5]|l_sw[6]|l_sw[7]|l_sw[8]|l_sw[9]|vc|vdd|vss|z
+ \$10 sg13_lv_pmos L=0.13u W=1u AS=0.19p AD=0.19p PS=1.38u PD=1.38u rfmode=0
M$278
+ BOTTOM|TOP|h_sw[0]|h_sw[10]|h_sw[1]|h_sw[2]|h_sw[3]|h_sw[4]|h_sw[5]|h_sw[6]|h_sw[7]|h_sw[8]|h_sw[9]|l_sw[0]|l_sw[10]|l_sw[1]|l_sw[2]|l_sw[3]|l_sw[4]|l_sw[5]|l_sw[6]|l_sw[7]|l_sw[8]|l_sw[9]|vc|vdd|vss|z
+ in_h_sw[4]|x
+ BOTTOM|TOP|h_sw[0]|h_sw[10]|h_sw[1]|h_sw[2]|h_sw[3]|h_sw[4]|h_sw[5]|h_sw[6]|h_sw[7]|h_sw[8]|h_sw[9]|l_sw[0]|l_sw[10]|l_sw[1]|l_sw[2]|l_sw[3]|l_sw[4]|l_sw[5]|l_sw[6]|l_sw[7]|l_sw[8]|l_sw[9]|vc|vdd|vss|z
+ \$10 sg13_lv_pmos L=0.13u W=1u AS=0.19p AD=0.19p PS=1.38u PD=1.38u rfmode=0
M$279
+ BOTTOM|TOP|h_sw[0]|h_sw[10]|h_sw[1]|h_sw[2]|h_sw[3]|h_sw[4]|h_sw[5]|h_sw[6]|h_sw[7]|h_sw[8]|h_sw[9]|l_sw[0]|l_sw[10]|l_sw[1]|l_sw[2]|l_sw[3]|l_sw[4]|l_sw[5]|l_sw[6]|l_sw[7]|l_sw[8]|l_sw[9]|vc|vdd|vss|z
+ in_h_sw[4]|x
+ BOTTOM|TOP|h_sw[0]|h_sw[10]|h_sw[1]|h_sw[2]|h_sw[3]|h_sw[4]|h_sw[5]|h_sw[6]|h_sw[7]|h_sw[8]|h_sw[9]|l_sw[0]|l_sw[10]|l_sw[1]|l_sw[2]|l_sw[3]|l_sw[4]|l_sw[5]|l_sw[6]|l_sw[7]|l_sw[8]|l_sw[9]|vc|vdd|vss|z
+ \$10 sg13_lv_pmos L=0.13u W=1u AS=0.19p AD=0.19p PS=1.38u PD=1.38u rfmode=0
M$280
+ BOTTOM|TOP|h_sw[0]|h_sw[10]|h_sw[1]|h_sw[2]|h_sw[3]|h_sw[4]|h_sw[5]|h_sw[6]|h_sw[7]|h_sw[8]|h_sw[9]|l_sw[0]|l_sw[10]|l_sw[1]|l_sw[2]|l_sw[3]|l_sw[4]|l_sw[5]|l_sw[6]|l_sw[7]|l_sw[8]|l_sw[9]|vc|vdd|vss|z
+ in_h_sw[4]|x
+ BOTTOM|TOP|h_sw[0]|h_sw[10]|h_sw[1]|h_sw[2]|h_sw[3]|h_sw[4]|h_sw[5]|h_sw[6]|h_sw[7]|h_sw[8]|h_sw[9]|l_sw[0]|l_sw[10]|l_sw[1]|l_sw[2]|l_sw[3]|l_sw[4]|l_sw[5]|l_sw[6]|l_sw[7]|l_sw[8]|l_sw[9]|vc|vdd|vss|z
+ \$10 sg13_lv_pmos L=0.13u W=1u AS=0.19p AD=0.19p PS=1.38u PD=1.38u rfmode=0
M$281
+ BOTTOM|TOP|h_sw[0]|h_sw[10]|h_sw[1]|h_sw[2]|h_sw[3]|h_sw[4]|h_sw[5]|h_sw[6]|h_sw[7]|h_sw[8]|h_sw[9]|l_sw[0]|l_sw[10]|l_sw[1]|l_sw[2]|l_sw[3]|l_sw[4]|l_sw[5]|l_sw[6]|l_sw[7]|l_sw[8]|l_sw[9]|vc|vdd|vss|z
+ in_h_sw[4]|x
+ BOTTOM|TOP|h_sw[0]|h_sw[10]|h_sw[1]|h_sw[2]|h_sw[3]|h_sw[4]|h_sw[5]|h_sw[6]|h_sw[7]|h_sw[8]|h_sw[9]|l_sw[0]|l_sw[10]|l_sw[1]|l_sw[2]|l_sw[3]|l_sw[4]|l_sw[5]|l_sw[6]|l_sw[7]|l_sw[8]|l_sw[9]|vc|vdd|vss|z
+ \$10 sg13_lv_pmos L=0.13u W=1u AS=0.19p AD=0.19p PS=1.38u PD=1.38u rfmode=0
M$282
+ BOTTOM|TOP|h_sw[0]|h_sw[10]|h_sw[1]|h_sw[2]|h_sw[3]|h_sw[4]|h_sw[5]|h_sw[6]|h_sw[7]|h_sw[8]|h_sw[9]|l_sw[0]|l_sw[10]|l_sw[1]|l_sw[2]|l_sw[3]|l_sw[4]|l_sw[5]|l_sw[6]|l_sw[7]|l_sw[8]|l_sw[9]|vc|vdd|vss|z
+ in_h_sw[4]|x
+ BOTTOM|TOP|h_sw[0]|h_sw[10]|h_sw[1]|h_sw[2]|h_sw[3]|h_sw[4]|h_sw[5]|h_sw[6]|h_sw[7]|h_sw[8]|h_sw[9]|l_sw[0]|l_sw[10]|l_sw[1]|l_sw[2]|l_sw[3]|l_sw[4]|l_sw[5]|l_sw[6]|l_sw[7]|l_sw[8]|l_sw[9]|vc|vdd|vss|z
+ \$10 sg13_lv_pmos L=0.13u W=1u AS=0.19p AD=0.34p PS=1.38u PD=2.68u rfmode=0
M$283
+ BOTTOM|TOP|h_sw[0]|h_sw[10]|h_sw[1]|h_sw[2]|h_sw[3]|h_sw[4]|h_sw[5]|h_sw[6]|h_sw[7]|h_sw[8]|h_sw[9]|l_sw[0]|l_sw[10]|l_sw[1]|l_sw[2]|l_sw[3]|l_sw[4]|l_sw[5]|l_sw[6]|l_sw[7]|l_sw[8]|l_sw[9]|vc|vdd|vss|z
+ in_h_sw[5]|x
+ BOTTOM|TOP|h_sw[0]|h_sw[10]|h_sw[1]|h_sw[2]|h_sw[3]|h_sw[4]|h_sw[5]|h_sw[6]|h_sw[7]|h_sw[8]|h_sw[9]|l_sw[0]|l_sw[10]|l_sw[1]|l_sw[2]|l_sw[3]|l_sw[4]|l_sw[5]|l_sw[6]|l_sw[7]|l_sw[8]|l_sw[9]|vc|vdd|vss|z
+ \$11 sg13_lv_pmos L=0.13u W=1u AS=0.34p AD=0.19p PS=2.68u PD=1.38u rfmode=0
M$284
+ BOTTOM|TOP|h_sw[0]|h_sw[10]|h_sw[1]|h_sw[2]|h_sw[3]|h_sw[4]|h_sw[5]|h_sw[6]|h_sw[7]|h_sw[8]|h_sw[9]|l_sw[0]|l_sw[10]|l_sw[1]|l_sw[2]|l_sw[3]|l_sw[4]|l_sw[5]|l_sw[6]|l_sw[7]|l_sw[8]|l_sw[9]|vc|vdd|vss|z
+ in_h_sw[5]|x
+ BOTTOM|TOP|h_sw[0]|h_sw[10]|h_sw[1]|h_sw[2]|h_sw[3]|h_sw[4]|h_sw[5]|h_sw[6]|h_sw[7]|h_sw[8]|h_sw[9]|l_sw[0]|l_sw[10]|l_sw[1]|l_sw[2]|l_sw[3]|l_sw[4]|l_sw[5]|l_sw[6]|l_sw[7]|l_sw[8]|l_sw[9]|vc|vdd|vss|z
+ \$11 sg13_lv_pmos L=0.13u W=1u AS=0.19p AD=0.19p PS=1.38u PD=1.38u rfmode=0
M$285
+ BOTTOM|TOP|h_sw[0]|h_sw[10]|h_sw[1]|h_sw[2]|h_sw[3]|h_sw[4]|h_sw[5]|h_sw[6]|h_sw[7]|h_sw[8]|h_sw[9]|l_sw[0]|l_sw[10]|l_sw[1]|l_sw[2]|l_sw[3]|l_sw[4]|l_sw[5]|l_sw[6]|l_sw[7]|l_sw[8]|l_sw[9]|vc|vdd|vss|z
+ in_h_sw[5]|x
+ BOTTOM|TOP|h_sw[0]|h_sw[10]|h_sw[1]|h_sw[2]|h_sw[3]|h_sw[4]|h_sw[5]|h_sw[6]|h_sw[7]|h_sw[8]|h_sw[9]|l_sw[0]|l_sw[10]|l_sw[1]|l_sw[2]|l_sw[3]|l_sw[4]|l_sw[5]|l_sw[6]|l_sw[7]|l_sw[8]|l_sw[9]|vc|vdd|vss|z
+ \$11 sg13_lv_pmos L=0.13u W=1u AS=0.19p AD=0.19p PS=1.38u PD=1.38u rfmode=0
M$286
+ BOTTOM|TOP|h_sw[0]|h_sw[10]|h_sw[1]|h_sw[2]|h_sw[3]|h_sw[4]|h_sw[5]|h_sw[6]|h_sw[7]|h_sw[8]|h_sw[9]|l_sw[0]|l_sw[10]|l_sw[1]|l_sw[2]|l_sw[3]|l_sw[4]|l_sw[5]|l_sw[6]|l_sw[7]|l_sw[8]|l_sw[9]|vc|vdd|vss|z
+ in_h_sw[5]|x
+ BOTTOM|TOP|h_sw[0]|h_sw[10]|h_sw[1]|h_sw[2]|h_sw[3]|h_sw[4]|h_sw[5]|h_sw[6]|h_sw[7]|h_sw[8]|h_sw[9]|l_sw[0]|l_sw[10]|l_sw[1]|l_sw[2]|l_sw[3]|l_sw[4]|l_sw[5]|l_sw[6]|l_sw[7]|l_sw[8]|l_sw[9]|vc|vdd|vss|z
+ \$11 sg13_lv_pmos L=0.13u W=1u AS=0.19p AD=0.19p PS=1.38u PD=1.38u rfmode=0
M$287
+ BOTTOM|TOP|h_sw[0]|h_sw[10]|h_sw[1]|h_sw[2]|h_sw[3]|h_sw[4]|h_sw[5]|h_sw[6]|h_sw[7]|h_sw[8]|h_sw[9]|l_sw[0]|l_sw[10]|l_sw[1]|l_sw[2]|l_sw[3]|l_sw[4]|l_sw[5]|l_sw[6]|l_sw[7]|l_sw[8]|l_sw[9]|vc|vdd|vss|z
+ in_h_sw[5]|x
+ BOTTOM|TOP|h_sw[0]|h_sw[10]|h_sw[1]|h_sw[2]|h_sw[3]|h_sw[4]|h_sw[5]|h_sw[6]|h_sw[7]|h_sw[8]|h_sw[9]|l_sw[0]|l_sw[10]|l_sw[1]|l_sw[2]|l_sw[3]|l_sw[4]|l_sw[5]|l_sw[6]|l_sw[7]|l_sw[8]|l_sw[9]|vc|vdd|vss|z
+ \$11 sg13_lv_pmos L=0.13u W=1u AS=0.19p AD=0.19p PS=1.38u PD=1.38u rfmode=0
M$288
+ BOTTOM|TOP|h_sw[0]|h_sw[10]|h_sw[1]|h_sw[2]|h_sw[3]|h_sw[4]|h_sw[5]|h_sw[6]|h_sw[7]|h_sw[8]|h_sw[9]|l_sw[0]|l_sw[10]|l_sw[1]|l_sw[2]|l_sw[3]|l_sw[4]|l_sw[5]|l_sw[6]|l_sw[7]|l_sw[8]|l_sw[9]|vc|vdd|vss|z
+ in_h_sw[5]|x
+ BOTTOM|TOP|h_sw[0]|h_sw[10]|h_sw[1]|h_sw[2]|h_sw[3]|h_sw[4]|h_sw[5]|h_sw[6]|h_sw[7]|h_sw[8]|h_sw[9]|l_sw[0]|l_sw[10]|l_sw[1]|l_sw[2]|l_sw[3]|l_sw[4]|l_sw[5]|l_sw[6]|l_sw[7]|l_sw[8]|l_sw[9]|vc|vdd|vss|z
+ \$11 sg13_lv_pmos L=0.13u W=1u AS=0.19p AD=0.19p PS=1.38u PD=1.38u rfmode=0
M$289
+ BOTTOM|TOP|h_sw[0]|h_sw[10]|h_sw[1]|h_sw[2]|h_sw[3]|h_sw[4]|h_sw[5]|h_sw[6]|h_sw[7]|h_sw[8]|h_sw[9]|l_sw[0]|l_sw[10]|l_sw[1]|l_sw[2]|l_sw[3]|l_sw[4]|l_sw[5]|l_sw[6]|l_sw[7]|l_sw[8]|l_sw[9]|vc|vdd|vss|z
+ in_h_sw[5]|x
+ BOTTOM|TOP|h_sw[0]|h_sw[10]|h_sw[1]|h_sw[2]|h_sw[3]|h_sw[4]|h_sw[5]|h_sw[6]|h_sw[7]|h_sw[8]|h_sw[9]|l_sw[0]|l_sw[10]|l_sw[1]|l_sw[2]|l_sw[3]|l_sw[4]|l_sw[5]|l_sw[6]|l_sw[7]|l_sw[8]|l_sw[9]|vc|vdd|vss|z
+ \$11 sg13_lv_pmos L=0.13u W=1u AS=0.19p AD=0.19p PS=1.38u PD=1.38u rfmode=0
M$290
+ BOTTOM|TOP|h_sw[0]|h_sw[10]|h_sw[1]|h_sw[2]|h_sw[3]|h_sw[4]|h_sw[5]|h_sw[6]|h_sw[7]|h_sw[8]|h_sw[9]|l_sw[0]|l_sw[10]|l_sw[1]|l_sw[2]|l_sw[3]|l_sw[4]|l_sw[5]|l_sw[6]|l_sw[7]|l_sw[8]|l_sw[9]|vc|vdd|vss|z
+ in_h_sw[5]|x
+ BOTTOM|TOP|h_sw[0]|h_sw[10]|h_sw[1]|h_sw[2]|h_sw[3]|h_sw[4]|h_sw[5]|h_sw[6]|h_sw[7]|h_sw[8]|h_sw[9]|l_sw[0]|l_sw[10]|l_sw[1]|l_sw[2]|l_sw[3]|l_sw[4]|l_sw[5]|l_sw[6]|l_sw[7]|l_sw[8]|l_sw[9]|vc|vdd|vss|z
+ \$11 sg13_lv_pmos L=0.13u W=1u AS=0.19p AD=0.34p PS=1.38u PD=2.68u rfmode=0
M$291
+ BOTTOM|TOP|h_sw[0]|h_sw[10]|h_sw[1]|h_sw[2]|h_sw[3]|h_sw[4]|h_sw[5]|h_sw[6]|h_sw[7]|h_sw[8]|h_sw[9]|l_sw[0]|l_sw[10]|l_sw[1]|l_sw[2]|l_sw[3]|l_sw[4]|l_sw[5]|l_sw[6]|l_sw[7]|l_sw[8]|l_sw[9]|vc|vdd|vss|z
+ in_l_sw[1]|x
+ BOTTOM|TOP|h_sw[0]|h_sw[10]|h_sw[1]|h_sw[2]|h_sw[3]|h_sw[4]|h_sw[5]|h_sw[6]|h_sw[7]|h_sw[8]|h_sw[9]|l_sw[0]|l_sw[10]|l_sw[1]|l_sw[2]|l_sw[3]|l_sw[4]|l_sw[5]|l_sw[6]|l_sw[7]|l_sw[8]|l_sw[9]|vc|vdd|vss|z
+ \$21 sg13_lv_pmos L=0.13u W=1u AS=0.34p AD=0.19p PS=2.68u PD=1.38u rfmode=0
M$292
+ BOTTOM|TOP|h_sw[0]|h_sw[10]|h_sw[1]|h_sw[2]|h_sw[3]|h_sw[4]|h_sw[5]|h_sw[6]|h_sw[7]|h_sw[8]|h_sw[9]|l_sw[0]|l_sw[10]|l_sw[1]|l_sw[2]|l_sw[3]|l_sw[4]|l_sw[5]|l_sw[6]|l_sw[7]|l_sw[8]|l_sw[9]|vc|vdd|vss|z
+ in_l_sw[1]|x
+ BOTTOM|TOP|h_sw[0]|h_sw[10]|h_sw[1]|h_sw[2]|h_sw[3]|h_sw[4]|h_sw[5]|h_sw[6]|h_sw[7]|h_sw[8]|h_sw[9]|l_sw[0]|l_sw[10]|l_sw[1]|l_sw[2]|l_sw[3]|l_sw[4]|l_sw[5]|l_sw[6]|l_sw[7]|l_sw[8]|l_sw[9]|vc|vdd|vss|z
+ \$21 sg13_lv_pmos L=0.13u W=1u AS=0.19p AD=0.19p PS=1.38u PD=1.38u rfmode=0
M$293
+ BOTTOM|TOP|h_sw[0]|h_sw[10]|h_sw[1]|h_sw[2]|h_sw[3]|h_sw[4]|h_sw[5]|h_sw[6]|h_sw[7]|h_sw[8]|h_sw[9]|l_sw[0]|l_sw[10]|l_sw[1]|l_sw[2]|l_sw[3]|l_sw[4]|l_sw[5]|l_sw[6]|l_sw[7]|l_sw[8]|l_sw[9]|vc|vdd|vss|z
+ in_l_sw[1]|x
+ BOTTOM|TOP|h_sw[0]|h_sw[10]|h_sw[1]|h_sw[2]|h_sw[3]|h_sw[4]|h_sw[5]|h_sw[6]|h_sw[7]|h_sw[8]|h_sw[9]|l_sw[0]|l_sw[10]|l_sw[1]|l_sw[2]|l_sw[3]|l_sw[4]|l_sw[5]|l_sw[6]|l_sw[7]|l_sw[8]|l_sw[9]|vc|vdd|vss|z
+ \$21 sg13_lv_pmos L=0.13u W=1u AS=0.19p AD=0.19p PS=1.38u PD=1.38u rfmode=0
M$294
+ BOTTOM|TOP|h_sw[0]|h_sw[10]|h_sw[1]|h_sw[2]|h_sw[3]|h_sw[4]|h_sw[5]|h_sw[6]|h_sw[7]|h_sw[8]|h_sw[9]|l_sw[0]|l_sw[10]|l_sw[1]|l_sw[2]|l_sw[3]|l_sw[4]|l_sw[5]|l_sw[6]|l_sw[7]|l_sw[8]|l_sw[9]|vc|vdd|vss|z
+ in_l_sw[1]|x
+ BOTTOM|TOP|h_sw[0]|h_sw[10]|h_sw[1]|h_sw[2]|h_sw[3]|h_sw[4]|h_sw[5]|h_sw[6]|h_sw[7]|h_sw[8]|h_sw[9]|l_sw[0]|l_sw[10]|l_sw[1]|l_sw[2]|l_sw[3]|l_sw[4]|l_sw[5]|l_sw[6]|l_sw[7]|l_sw[8]|l_sw[9]|vc|vdd|vss|z
+ \$21 sg13_lv_pmos L=0.13u W=1u AS=0.19p AD=0.19p PS=1.38u PD=1.38u rfmode=0
M$295
+ BOTTOM|TOP|h_sw[0]|h_sw[10]|h_sw[1]|h_sw[2]|h_sw[3]|h_sw[4]|h_sw[5]|h_sw[6]|h_sw[7]|h_sw[8]|h_sw[9]|l_sw[0]|l_sw[10]|l_sw[1]|l_sw[2]|l_sw[3]|l_sw[4]|l_sw[5]|l_sw[6]|l_sw[7]|l_sw[8]|l_sw[9]|vc|vdd|vss|z
+ in_l_sw[1]|x
+ BOTTOM|TOP|h_sw[0]|h_sw[10]|h_sw[1]|h_sw[2]|h_sw[3]|h_sw[4]|h_sw[5]|h_sw[6]|h_sw[7]|h_sw[8]|h_sw[9]|l_sw[0]|l_sw[10]|l_sw[1]|l_sw[2]|l_sw[3]|l_sw[4]|l_sw[5]|l_sw[6]|l_sw[7]|l_sw[8]|l_sw[9]|vc|vdd|vss|z
+ \$21 sg13_lv_pmos L=0.13u W=1u AS=0.19p AD=0.19p PS=1.38u PD=1.38u rfmode=0
M$296
+ BOTTOM|TOP|h_sw[0]|h_sw[10]|h_sw[1]|h_sw[2]|h_sw[3]|h_sw[4]|h_sw[5]|h_sw[6]|h_sw[7]|h_sw[8]|h_sw[9]|l_sw[0]|l_sw[10]|l_sw[1]|l_sw[2]|l_sw[3]|l_sw[4]|l_sw[5]|l_sw[6]|l_sw[7]|l_sw[8]|l_sw[9]|vc|vdd|vss|z
+ in_l_sw[1]|x
+ BOTTOM|TOP|h_sw[0]|h_sw[10]|h_sw[1]|h_sw[2]|h_sw[3]|h_sw[4]|h_sw[5]|h_sw[6]|h_sw[7]|h_sw[8]|h_sw[9]|l_sw[0]|l_sw[10]|l_sw[1]|l_sw[2]|l_sw[3]|l_sw[4]|l_sw[5]|l_sw[6]|l_sw[7]|l_sw[8]|l_sw[9]|vc|vdd|vss|z
+ \$21 sg13_lv_pmos L=0.13u W=1u AS=0.19p AD=0.19p PS=1.38u PD=1.38u rfmode=0
M$297
+ BOTTOM|TOP|h_sw[0]|h_sw[10]|h_sw[1]|h_sw[2]|h_sw[3]|h_sw[4]|h_sw[5]|h_sw[6]|h_sw[7]|h_sw[8]|h_sw[9]|l_sw[0]|l_sw[10]|l_sw[1]|l_sw[2]|l_sw[3]|l_sw[4]|l_sw[5]|l_sw[6]|l_sw[7]|l_sw[8]|l_sw[9]|vc|vdd|vss|z
+ in_l_sw[1]|x
+ BOTTOM|TOP|h_sw[0]|h_sw[10]|h_sw[1]|h_sw[2]|h_sw[3]|h_sw[4]|h_sw[5]|h_sw[6]|h_sw[7]|h_sw[8]|h_sw[9]|l_sw[0]|l_sw[10]|l_sw[1]|l_sw[2]|l_sw[3]|l_sw[4]|l_sw[5]|l_sw[6]|l_sw[7]|l_sw[8]|l_sw[9]|vc|vdd|vss|z
+ \$21 sg13_lv_pmos L=0.13u W=1u AS=0.19p AD=0.19p PS=1.38u PD=1.38u rfmode=0
M$298
+ BOTTOM|TOP|h_sw[0]|h_sw[10]|h_sw[1]|h_sw[2]|h_sw[3]|h_sw[4]|h_sw[5]|h_sw[6]|h_sw[7]|h_sw[8]|h_sw[9]|l_sw[0]|l_sw[10]|l_sw[1]|l_sw[2]|l_sw[3]|l_sw[4]|l_sw[5]|l_sw[6]|l_sw[7]|l_sw[8]|l_sw[9]|vc|vdd|vss|z
+ in_l_sw[1]|x
+ BOTTOM|TOP|h_sw[0]|h_sw[10]|h_sw[1]|h_sw[2]|h_sw[3]|h_sw[4]|h_sw[5]|h_sw[6]|h_sw[7]|h_sw[8]|h_sw[9]|l_sw[0]|l_sw[10]|l_sw[1]|l_sw[2]|l_sw[3]|l_sw[4]|l_sw[5]|l_sw[6]|l_sw[7]|l_sw[8]|l_sw[9]|vc|vdd|vss|z
+ \$21 sg13_lv_pmos L=0.13u W=1u AS=0.19p AD=0.19p PS=1.38u PD=1.38u rfmode=0
M$299
+ BOTTOM|TOP|h_sw[0]|h_sw[10]|h_sw[1]|h_sw[2]|h_sw[3]|h_sw[4]|h_sw[5]|h_sw[6]|h_sw[7]|h_sw[8]|h_sw[9]|l_sw[0]|l_sw[10]|l_sw[1]|l_sw[2]|l_sw[3]|l_sw[4]|l_sw[5]|l_sw[6]|l_sw[7]|l_sw[8]|l_sw[9]|vc|vdd|vss|z
+ in_l_sw[1]|x
+ BOTTOM|TOP|h_sw[0]|h_sw[10]|h_sw[1]|h_sw[2]|h_sw[3]|h_sw[4]|h_sw[5]|h_sw[6]|h_sw[7]|h_sw[8]|h_sw[9]|l_sw[0]|l_sw[10]|l_sw[1]|l_sw[2]|l_sw[3]|l_sw[4]|l_sw[5]|l_sw[6]|l_sw[7]|l_sw[8]|l_sw[9]|vc|vdd|vss|z
+ \$21 sg13_lv_pmos L=0.13u W=1u AS=0.19p AD=0.19p PS=1.38u PD=1.38u rfmode=0
M$300
+ BOTTOM|TOP|h_sw[0]|h_sw[10]|h_sw[1]|h_sw[2]|h_sw[3]|h_sw[4]|h_sw[5]|h_sw[6]|h_sw[7]|h_sw[8]|h_sw[9]|l_sw[0]|l_sw[10]|l_sw[1]|l_sw[2]|l_sw[3]|l_sw[4]|l_sw[5]|l_sw[6]|l_sw[7]|l_sw[8]|l_sw[9]|vc|vdd|vss|z
+ in_l_sw[1]|x
+ BOTTOM|TOP|h_sw[0]|h_sw[10]|h_sw[1]|h_sw[2]|h_sw[3]|h_sw[4]|h_sw[5]|h_sw[6]|h_sw[7]|h_sw[8]|h_sw[9]|l_sw[0]|l_sw[10]|l_sw[1]|l_sw[2]|l_sw[3]|l_sw[4]|l_sw[5]|l_sw[6]|l_sw[7]|l_sw[8]|l_sw[9]|vc|vdd|vss|z
+ \$21 sg13_lv_pmos L=0.13u W=1u AS=0.19p AD=0.19p PS=1.38u PD=1.38u rfmode=0
M$301
+ BOTTOM|TOP|h_sw[0]|h_sw[10]|h_sw[1]|h_sw[2]|h_sw[3]|h_sw[4]|h_sw[5]|h_sw[6]|h_sw[7]|h_sw[8]|h_sw[9]|l_sw[0]|l_sw[10]|l_sw[1]|l_sw[2]|l_sw[3]|l_sw[4]|l_sw[5]|l_sw[6]|l_sw[7]|l_sw[8]|l_sw[9]|vc|vdd|vss|z
+ in_l_sw[1]|x
+ BOTTOM|TOP|h_sw[0]|h_sw[10]|h_sw[1]|h_sw[2]|h_sw[3]|h_sw[4]|h_sw[5]|h_sw[6]|h_sw[7]|h_sw[8]|h_sw[9]|l_sw[0]|l_sw[10]|l_sw[1]|l_sw[2]|l_sw[3]|l_sw[4]|l_sw[5]|l_sw[6]|l_sw[7]|l_sw[8]|l_sw[9]|vc|vdd|vss|z
+ \$21 sg13_lv_pmos L=0.13u W=1u AS=0.19p AD=0.19p PS=1.38u PD=1.38u rfmode=0
M$302
+ BOTTOM|TOP|h_sw[0]|h_sw[10]|h_sw[1]|h_sw[2]|h_sw[3]|h_sw[4]|h_sw[5]|h_sw[6]|h_sw[7]|h_sw[8]|h_sw[9]|l_sw[0]|l_sw[10]|l_sw[1]|l_sw[2]|l_sw[3]|l_sw[4]|l_sw[5]|l_sw[6]|l_sw[7]|l_sw[8]|l_sw[9]|vc|vdd|vss|z
+ in_l_sw[1]|x
+ BOTTOM|TOP|h_sw[0]|h_sw[10]|h_sw[1]|h_sw[2]|h_sw[3]|h_sw[4]|h_sw[5]|h_sw[6]|h_sw[7]|h_sw[8]|h_sw[9]|l_sw[0]|l_sw[10]|l_sw[1]|l_sw[2]|l_sw[3]|l_sw[4]|l_sw[5]|l_sw[6]|l_sw[7]|l_sw[8]|l_sw[9]|vc|vdd|vss|z
+ \$21 sg13_lv_pmos L=0.13u W=1u AS=0.19p AD=0.19p PS=1.38u PD=1.38u rfmode=0
M$303
+ BOTTOM|TOP|h_sw[0]|h_sw[10]|h_sw[1]|h_sw[2]|h_sw[3]|h_sw[4]|h_sw[5]|h_sw[6]|h_sw[7]|h_sw[8]|h_sw[9]|l_sw[0]|l_sw[10]|l_sw[1]|l_sw[2]|l_sw[3]|l_sw[4]|l_sw[5]|l_sw[6]|l_sw[7]|l_sw[8]|l_sw[9]|vc|vdd|vss|z
+ in_l_sw[1]|x
+ BOTTOM|TOP|h_sw[0]|h_sw[10]|h_sw[1]|h_sw[2]|h_sw[3]|h_sw[4]|h_sw[5]|h_sw[6]|h_sw[7]|h_sw[8]|h_sw[9]|l_sw[0]|l_sw[10]|l_sw[1]|l_sw[2]|l_sw[3]|l_sw[4]|l_sw[5]|l_sw[6]|l_sw[7]|l_sw[8]|l_sw[9]|vc|vdd|vss|z
+ \$21 sg13_lv_pmos L=0.13u W=1u AS=0.19p AD=0.19p PS=1.38u PD=1.38u rfmode=0
M$304
+ BOTTOM|TOP|h_sw[0]|h_sw[10]|h_sw[1]|h_sw[2]|h_sw[3]|h_sw[4]|h_sw[5]|h_sw[6]|h_sw[7]|h_sw[8]|h_sw[9]|l_sw[0]|l_sw[10]|l_sw[1]|l_sw[2]|l_sw[3]|l_sw[4]|l_sw[5]|l_sw[6]|l_sw[7]|l_sw[8]|l_sw[9]|vc|vdd|vss|z
+ in_l_sw[1]|x
+ BOTTOM|TOP|h_sw[0]|h_sw[10]|h_sw[1]|h_sw[2]|h_sw[3]|h_sw[4]|h_sw[5]|h_sw[6]|h_sw[7]|h_sw[8]|h_sw[9]|l_sw[0]|l_sw[10]|l_sw[1]|l_sw[2]|l_sw[3]|l_sw[4]|l_sw[5]|l_sw[6]|l_sw[7]|l_sw[8]|l_sw[9]|vc|vdd|vss|z
+ \$21 sg13_lv_pmos L=0.13u W=1u AS=0.19p AD=0.19p PS=1.38u PD=1.38u rfmode=0
M$305
+ BOTTOM|TOP|h_sw[0]|h_sw[10]|h_sw[1]|h_sw[2]|h_sw[3]|h_sw[4]|h_sw[5]|h_sw[6]|h_sw[7]|h_sw[8]|h_sw[9]|l_sw[0]|l_sw[10]|l_sw[1]|l_sw[2]|l_sw[3]|l_sw[4]|l_sw[5]|l_sw[6]|l_sw[7]|l_sw[8]|l_sw[9]|vc|vdd|vss|z
+ in_l_sw[1]|x
+ BOTTOM|TOP|h_sw[0]|h_sw[10]|h_sw[1]|h_sw[2]|h_sw[3]|h_sw[4]|h_sw[5]|h_sw[6]|h_sw[7]|h_sw[8]|h_sw[9]|l_sw[0]|l_sw[10]|l_sw[1]|l_sw[2]|l_sw[3]|l_sw[4]|l_sw[5]|l_sw[6]|l_sw[7]|l_sw[8]|l_sw[9]|vc|vdd|vss|z
+ \$21 sg13_lv_pmos L=0.13u W=1u AS=0.19p AD=0.19p PS=1.38u PD=1.38u rfmode=0
M$306
+ BOTTOM|TOP|h_sw[0]|h_sw[10]|h_sw[1]|h_sw[2]|h_sw[3]|h_sw[4]|h_sw[5]|h_sw[6]|h_sw[7]|h_sw[8]|h_sw[9]|l_sw[0]|l_sw[10]|l_sw[1]|l_sw[2]|l_sw[3]|l_sw[4]|l_sw[5]|l_sw[6]|l_sw[7]|l_sw[8]|l_sw[9]|vc|vdd|vss|z
+ in_l_sw[1]|x
+ BOTTOM|TOP|h_sw[0]|h_sw[10]|h_sw[1]|h_sw[2]|h_sw[3]|h_sw[4]|h_sw[5]|h_sw[6]|h_sw[7]|h_sw[8]|h_sw[9]|l_sw[0]|l_sw[10]|l_sw[1]|l_sw[2]|l_sw[3]|l_sw[4]|l_sw[5]|l_sw[6]|l_sw[7]|l_sw[8]|l_sw[9]|vc|vdd|vss|z
+ \$21 sg13_lv_pmos L=0.13u W=1u AS=0.19p AD=0.34p PS=1.38u PD=2.68u rfmode=0
M$307
+ BOTTOM|TOP|h_sw[0]|h_sw[10]|h_sw[1]|h_sw[2]|h_sw[3]|h_sw[4]|h_sw[5]|h_sw[6]|h_sw[7]|h_sw[8]|h_sw[9]|l_sw[0]|l_sw[10]|l_sw[1]|l_sw[2]|l_sw[3]|l_sw[4]|l_sw[5]|l_sw[6]|l_sw[7]|l_sw[8]|l_sw[9]|vc|vdd|vss|z
+ in_h_sw[1]|x
+ BOTTOM|TOP|h_sw[0]|h_sw[10]|h_sw[1]|h_sw[2]|h_sw[3]|h_sw[4]|h_sw[5]|h_sw[6]|h_sw[7]|h_sw[8]|h_sw[9]|l_sw[0]|l_sw[10]|l_sw[1]|l_sw[2]|l_sw[3]|l_sw[4]|l_sw[5]|l_sw[6]|l_sw[7]|l_sw[8]|l_sw[9]|vc|vdd|vss|z
+ \$21 sg13_lv_pmos L=0.13u W=1u AS=0.34p AD=0.19p PS=2.68u PD=1.38u rfmode=0
M$308
+ BOTTOM|TOP|h_sw[0]|h_sw[10]|h_sw[1]|h_sw[2]|h_sw[3]|h_sw[4]|h_sw[5]|h_sw[6]|h_sw[7]|h_sw[8]|h_sw[9]|l_sw[0]|l_sw[10]|l_sw[1]|l_sw[2]|l_sw[3]|l_sw[4]|l_sw[5]|l_sw[6]|l_sw[7]|l_sw[8]|l_sw[9]|vc|vdd|vss|z
+ in_h_sw[1]|x
+ BOTTOM|TOP|h_sw[0]|h_sw[10]|h_sw[1]|h_sw[2]|h_sw[3]|h_sw[4]|h_sw[5]|h_sw[6]|h_sw[7]|h_sw[8]|h_sw[9]|l_sw[0]|l_sw[10]|l_sw[1]|l_sw[2]|l_sw[3]|l_sw[4]|l_sw[5]|l_sw[6]|l_sw[7]|l_sw[8]|l_sw[9]|vc|vdd|vss|z
+ \$21 sg13_lv_pmos L=0.13u W=1u AS=0.19p AD=0.19p PS=1.38u PD=1.38u rfmode=0
M$309
+ BOTTOM|TOP|h_sw[0]|h_sw[10]|h_sw[1]|h_sw[2]|h_sw[3]|h_sw[4]|h_sw[5]|h_sw[6]|h_sw[7]|h_sw[8]|h_sw[9]|l_sw[0]|l_sw[10]|l_sw[1]|l_sw[2]|l_sw[3]|l_sw[4]|l_sw[5]|l_sw[6]|l_sw[7]|l_sw[8]|l_sw[9]|vc|vdd|vss|z
+ in_h_sw[1]|x
+ BOTTOM|TOP|h_sw[0]|h_sw[10]|h_sw[1]|h_sw[2]|h_sw[3]|h_sw[4]|h_sw[5]|h_sw[6]|h_sw[7]|h_sw[8]|h_sw[9]|l_sw[0]|l_sw[10]|l_sw[1]|l_sw[2]|l_sw[3]|l_sw[4]|l_sw[5]|l_sw[6]|l_sw[7]|l_sw[8]|l_sw[9]|vc|vdd|vss|z
+ \$21 sg13_lv_pmos L=0.13u W=1u AS=0.19p AD=0.19p PS=1.38u PD=1.38u rfmode=0
M$310
+ BOTTOM|TOP|h_sw[0]|h_sw[10]|h_sw[1]|h_sw[2]|h_sw[3]|h_sw[4]|h_sw[5]|h_sw[6]|h_sw[7]|h_sw[8]|h_sw[9]|l_sw[0]|l_sw[10]|l_sw[1]|l_sw[2]|l_sw[3]|l_sw[4]|l_sw[5]|l_sw[6]|l_sw[7]|l_sw[8]|l_sw[9]|vc|vdd|vss|z
+ in_h_sw[1]|x
+ BOTTOM|TOP|h_sw[0]|h_sw[10]|h_sw[1]|h_sw[2]|h_sw[3]|h_sw[4]|h_sw[5]|h_sw[6]|h_sw[7]|h_sw[8]|h_sw[9]|l_sw[0]|l_sw[10]|l_sw[1]|l_sw[2]|l_sw[3]|l_sw[4]|l_sw[5]|l_sw[6]|l_sw[7]|l_sw[8]|l_sw[9]|vc|vdd|vss|z
+ \$21 sg13_lv_pmos L=0.13u W=1u AS=0.19p AD=0.19p PS=1.38u PD=1.38u rfmode=0
M$311
+ BOTTOM|TOP|h_sw[0]|h_sw[10]|h_sw[1]|h_sw[2]|h_sw[3]|h_sw[4]|h_sw[5]|h_sw[6]|h_sw[7]|h_sw[8]|h_sw[9]|l_sw[0]|l_sw[10]|l_sw[1]|l_sw[2]|l_sw[3]|l_sw[4]|l_sw[5]|l_sw[6]|l_sw[7]|l_sw[8]|l_sw[9]|vc|vdd|vss|z
+ in_h_sw[1]|x
+ BOTTOM|TOP|h_sw[0]|h_sw[10]|h_sw[1]|h_sw[2]|h_sw[3]|h_sw[4]|h_sw[5]|h_sw[6]|h_sw[7]|h_sw[8]|h_sw[9]|l_sw[0]|l_sw[10]|l_sw[1]|l_sw[2]|l_sw[3]|l_sw[4]|l_sw[5]|l_sw[6]|l_sw[7]|l_sw[8]|l_sw[9]|vc|vdd|vss|z
+ \$21 sg13_lv_pmos L=0.13u W=1u AS=0.19p AD=0.19p PS=1.38u PD=1.38u rfmode=0
M$312
+ BOTTOM|TOP|h_sw[0]|h_sw[10]|h_sw[1]|h_sw[2]|h_sw[3]|h_sw[4]|h_sw[5]|h_sw[6]|h_sw[7]|h_sw[8]|h_sw[9]|l_sw[0]|l_sw[10]|l_sw[1]|l_sw[2]|l_sw[3]|l_sw[4]|l_sw[5]|l_sw[6]|l_sw[7]|l_sw[8]|l_sw[9]|vc|vdd|vss|z
+ in_h_sw[1]|x
+ BOTTOM|TOP|h_sw[0]|h_sw[10]|h_sw[1]|h_sw[2]|h_sw[3]|h_sw[4]|h_sw[5]|h_sw[6]|h_sw[7]|h_sw[8]|h_sw[9]|l_sw[0]|l_sw[10]|l_sw[1]|l_sw[2]|l_sw[3]|l_sw[4]|l_sw[5]|l_sw[6]|l_sw[7]|l_sw[8]|l_sw[9]|vc|vdd|vss|z
+ \$21 sg13_lv_pmos L=0.13u W=1u AS=0.19p AD=0.19p PS=1.38u PD=1.38u rfmode=0
M$313
+ BOTTOM|TOP|h_sw[0]|h_sw[10]|h_sw[1]|h_sw[2]|h_sw[3]|h_sw[4]|h_sw[5]|h_sw[6]|h_sw[7]|h_sw[8]|h_sw[9]|l_sw[0]|l_sw[10]|l_sw[1]|l_sw[2]|l_sw[3]|l_sw[4]|l_sw[5]|l_sw[6]|l_sw[7]|l_sw[8]|l_sw[9]|vc|vdd|vss|z
+ in_h_sw[1]|x
+ BOTTOM|TOP|h_sw[0]|h_sw[10]|h_sw[1]|h_sw[2]|h_sw[3]|h_sw[4]|h_sw[5]|h_sw[6]|h_sw[7]|h_sw[8]|h_sw[9]|l_sw[0]|l_sw[10]|l_sw[1]|l_sw[2]|l_sw[3]|l_sw[4]|l_sw[5]|l_sw[6]|l_sw[7]|l_sw[8]|l_sw[9]|vc|vdd|vss|z
+ \$21 sg13_lv_pmos L=0.13u W=1u AS=0.19p AD=0.19p PS=1.38u PD=1.38u rfmode=0
M$314
+ BOTTOM|TOP|h_sw[0]|h_sw[10]|h_sw[1]|h_sw[2]|h_sw[3]|h_sw[4]|h_sw[5]|h_sw[6]|h_sw[7]|h_sw[8]|h_sw[9]|l_sw[0]|l_sw[10]|l_sw[1]|l_sw[2]|l_sw[3]|l_sw[4]|l_sw[5]|l_sw[6]|l_sw[7]|l_sw[8]|l_sw[9]|vc|vdd|vss|z
+ in_h_sw[1]|x
+ BOTTOM|TOP|h_sw[0]|h_sw[10]|h_sw[1]|h_sw[2]|h_sw[3]|h_sw[4]|h_sw[5]|h_sw[6]|h_sw[7]|h_sw[8]|h_sw[9]|l_sw[0]|l_sw[10]|l_sw[1]|l_sw[2]|l_sw[3]|l_sw[4]|l_sw[5]|l_sw[6]|l_sw[7]|l_sw[8]|l_sw[9]|vc|vdd|vss|z
+ \$21 sg13_lv_pmos L=0.13u W=1u AS=0.19p AD=0.19p PS=1.38u PD=1.38u rfmode=0
M$315
+ BOTTOM|TOP|h_sw[0]|h_sw[10]|h_sw[1]|h_sw[2]|h_sw[3]|h_sw[4]|h_sw[5]|h_sw[6]|h_sw[7]|h_sw[8]|h_sw[9]|l_sw[0]|l_sw[10]|l_sw[1]|l_sw[2]|l_sw[3]|l_sw[4]|l_sw[5]|l_sw[6]|l_sw[7]|l_sw[8]|l_sw[9]|vc|vdd|vss|z
+ in_h_sw[1]|x
+ BOTTOM|TOP|h_sw[0]|h_sw[10]|h_sw[1]|h_sw[2]|h_sw[3]|h_sw[4]|h_sw[5]|h_sw[6]|h_sw[7]|h_sw[8]|h_sw[9]|l_sw[0]|l_sw[10]|l_sw[1]|l_sw[2]|l_sw[3]|l_sw[4]|l_sw[5]|l_sw[6]|l_sw[7]|l_sw[8]|l_sw[9]|vc|vdd|vss|z
+ \$21 sg13_lv_pmos L=0.13u W=1u AS=0.19p AD=0.19p PS=1.38u PD=1.38u rfmode=0
M$316
+ BOTTOM|TOP|h_sw[0]|h_sw[10]|h_sw[1]|h_sw[2]|h_sw[3]|h_sw[4]|h_sw[5]|h_sw[6]|h_sw[7]|h_sw[8]|h_sw[9]|l_sw[0]|l_sw[10]|l_sw[1]|l_sw[2]|l_sw[3]|l_sw[4]|l_sw[5]|l_sw[6]|l_sw[7]|l_sw[8]|l_sw[9]|vc|vdd|vss|z
+ in_h_sw[1]|x
+ BOTTOM|TOP|h_sw[0]|h_sw[10]|h_sw[1]|h_sw[2]|h_sw[3]|h_sw[4]|h_sw[5]|h_sw[6]|h_sw[7]|h_sw[8]|h_sw[9]|l_sw[0]|l_sw[10]|l_sw[1]|l_sw[2]|l_sw[3]|l_sw[4]|l_sw[5]|l_sw[6]|l_sw[7]|l_sw[8]|l_sw[9]|vc|vdd|vss|z
+ \$21 sg13_lv_pmos L=0.13u W=1u AS=0.19p AD=0.19p PS=1.38u PD=1.38u rfmode=0
M$317
+ BOTTOM|TOP|h_sw[0]|h_sw[10]|h_sw[1]|h_sw[2]|h_sw[3]|h_sw[4]|h_sw[5]|h_sw[6]|h_sw[7]|h_sw[8]|h_sw[9]|l_sw[0]|l_sw[10]|l_sw[1]|l_sw[2]|l_sw[3]|l_sw[4]|l_sw[5]|l_sw[6]|l_sw[7]|l_sw[8]|l_sw[9]|vc|vdd|vss|z
+ in_h_sw[1]|x
+ BOTTOM|TOP|h_sw[0]|h_sw[10]|h_sw[1]|h_sw[2]|h_sw[3]|h_sw[4]|h_sw[5]|h_sw[6]|h_sw[7]|h_sw[8]|h_sw[9]|l_sw[0]|l_sw[10]|l_sw[1]|l_sw[2]|l_sw[3]|l_sw[4]|l_sw[5]|l_sw[6]|l_sw[7]|l_sw[8]|l_sw[9]|vc|vdd|vss|z
+ \$21 sg13_lv_pmos L=0.13u W=1u AS=0.19p AD=0.19p PS=1.38u PD=1.38u rfmode=0
M$318
+ BOTTOM|TOP|h_sw[0]|h_sw[10]|h_sw[1]|h_sw[2]|h_sw[3]|h_sw[4]|h_sw[5]|h_sw[6]|h_sw[7]|h_sw[8]|h_sw[9]|l_sw[0]|l_sw[10]|l_sw[1]|l_sw[2]|l_sw[3]|l_sw[4]|l_sw[5]|l_sw[6]|l_sw[7]|l_sw[8]|l_sw[9]|vc|vdd|vss|z
+ in_h_sw[1]|x
+ BOTTOM|TOP|h_sw[0]|h_sw[10]|h_sw[1]|h_sw[2]|h_sw[3]|h_sw[4]|h_sw[5]|h_sw[6]|h_sw[7]|h_sw[8]|h_sw[9]|l_sw[0]|l_sw[10]|l_sw[1]|l_sw[2]|l_sw[3]|l_sw[4]|l_sw[5]|l_sw[6]|l_sw[7]|l_sw[8]|l_sw[9]|vc|vdd|vss|z
+ \$21 sg13_lv_pmos L=0.13u W=1u AS=0.19p AD=0.19p PS=1.38u PD=1.38u rfmode=0
M$319
+ BOTTOM|TOP|h_sw[0]|h_sw[10]|h_sw[1]|h_sw[2]|h_sw[3]|h_sw[4]|h_sw[5]|h_sw[6]|h_sw[7]|h_sw[8]|h_sw[9]|l_sw[0]|l_sw[10]|l_sw[1]|l_sw[2]|l_sw[3]|l_sw[4]|l_sw[5]|l_sw[6]|l_sw[7]|l_sw[8]|l_sw[9]|vc|vdd|vss|z
+ in_h_sw[1]|x
+ BOTTOM|TOP|h_sw[0]|h_sw[10]|h_sw[1]|h_sw[2]|h_sw[3]|h_sw[4]|h_sw[5]|h_sw[6]|h_sw[7]|h_sw[8]|h_sw[9]|l_sw[0]|l_sw[10]|l_sw[1]|l_sw[2]|l_sw[3]|l_sw[4]|l_sw[5]|l_sw[6]|l_sw[7]|l_sw[8]|l_sw[9]|vc|vdd|vss|z
+ \$21 sg13_lv_pmos L=0.13u W=1u AS=0.19p AD=0.19p PS=1.38u PD=1.38u rfmode=0
M$320
+ BOTTOM|TOP|h_sw[0]|h_sw[10]|h_sw[1]|h_sw[2]|h_sw[3]|h_sw[4]|h_sw[5]|h_sw[6]|h_sw[7]|h_sw[8]|h_sw[9]|l_sw[0]|l_sw[10]|l_sw[1]|l_sw[2]|l_sw[3]|l_sw[4]|l_sw[5]|l_sw[6]|l_sw[7]|l_sw[8]|l_sw[9]|vc|vdd|vss|z
+ in_h_sw[1]|x
+ BOTTOM|TOP|h_sw[0]|h_sw[10]|h_sw[1]|h_sw[2]|h_sw[3]|h_sw[4]|h_sw[5]|h_sw[6]|h_sw[7]|h_sw[8]|h_sw[9]|l_sw[0]|l_sw[10]|l_sw[1]|l_sw[2]|l_sw[3]|l_sw[4]|l_sw[5]|l_sw[6]|l_sw[7]|l_sw[8]|l_sw[9]|vc|vdd|vss|z
+ \$21 sg13_lv_pmos L=0.13u W=1u AS=0.19p AD=0.19p PS=1.38u PD=1.38u rfmode=0
M$321
+ BOTTOM|TOP|h_sw[0]|h_sw[10]|h_sw[1]|h_sw[2]|h_sw[3]|h_sw[4]|h_sw[5]|h_sw[6]|h_sw[7]|h_sw[8]|h_sw[9]|l_sw[0]|l_sw[10]|l_sw[1]|l_sw[2]|l_sw[3]|l_sw[4]|l_sw[5]|l_sw[6]|l_sw[7]|l_sw[8]|l_sw[9]|vc|vdd|vss|z
+ in_h_sw[1]|x
+ BOTTOM|TOP|h_sw[0]|h_sw[10]|h_sw[1]|h_sw[2]|h_sw[3]|h_sw[4]|h_sw[5]|h_sw[6]|h_sw[7]|h_sw[8]|h_sw[9]|l_sw[0]|l_sw[10]|l_sw[1]|l_sw[2]|l_sw[3]|l_sw[4]|l_sw[5]|l_sw[6]|l_sw[7]|l_sw[8]|l_sw[9]|vc|vdd|vss|z
+ \$21 sg13_lv_pmos L=0.13u W=1u AS=0.19p AD=0.19p PS=1.38u PD=1.38u rfmode=0
M$322
+ BOTTOM|TOP|h_sw[0]|h_sw[10]|h_sw[1]|h_sw[2]|h_sw[3]|h_sw[4]|h_sw[5]|h_sw[6]|h_sw[7]|h_sw[8]|h_sw[9]|l_sw[0]|l_sw[10]|l_sw[1]|l_sw[2]|l_sw[3]|l_sw[4]|l_sw[5]|l_sw[6]|l_sw[7]|l_sw[8]|l_sw[9]|vc|vdd|vss|z
+ in_h_sw[1]|x
+ BOTTOM|TOP|h_sw[0]|h_sw[10]|h_sw[1]|h_sw[2]|h_sw[3]|h_sw[4]|h_sw[5]|h_sw[6]|h_sw[7]|h_sw[8]|h_sw[9]|l_sw[0]|l_sw[10]|l_sw[1]|l_sw[2]|l_sw[3]|l_sw[4]|l_sw[5]|l_sw[6]|l_sw[7]|l_sw[8]|l_sw[9]|vc|vdd|vss|z
+ \$21 sg13_lv_pmos L=0.13u W=1u AS=0.19p AD=0.34p PS=1.38u PD=2.68u rfmode=0
M$323
+ BOTTOM|TOP|h_sw[0]|h_sw[10]|h_sw[1]|h_sw[2]|h_sw[3]|h_sw[4]|h_sw[5]|h_sw[6]|h_sw[7]|h_sw[8]|h_sw[9]|l_sw[0]|l_sw[10]|l_sw[1]|l_sw[2]|l_sw[3]|l_sw[4]|l_sw[5]|l_sw[6]|l_sw[7]|l_sw[8]|l_sw[9]|vc|vdd|vss|z
+ in_l_sw[2]|x
+ BOTTOM|TOP|h_sw[0]|h_sw[10]|h_sw[1]|h_sw[2]|h_sw[3]|h_sw[4]|h_sw[5]|h_sw[6]|h_sw[7]|h_sw[8]|h_sw[9]|l_sw[0]|l_sw[10]|l_sw[1]|l_sw[2]|l_sw[3]|l_sw[4]|l_sw[5]|l_sw[6]|l_sw[7]|l_sw[8]|l_sw[9]|vc|vdd|vss|z
+ \$22 sg13_lv_pmos L=0.13u W=1u AS=0.34p AD=0.19p PS=2.68u PD=1.38u rfmode=0
M$324
+ BOTTOM|TOP|h_sw[0]|h_sw[10]|h_sw[1]|h_sw[2]|h_sw[3]|h_sw[4]|h_sw[5]|h_sw[6]|h_sw[7]|h_sw[8]|h_sw[9]|l_sw[0]|l_sw[10]|l_sw[1]|l_sw[2]|l_sw[3]|l_sw[4]|l_sw[5]|l_sw[6]|l_sw[7]|l_sw[8]|l_sw[9]|vc|vdd|vss|z
+ in_l_sw[2]|x
+ BOTTOM|TOP|h_sw[0]|h_sw[10]|h_sw[1]|h_sw[2]|h_sw[3]|h_sw[4]|h_sw[5]|h_sw[6]|h_sw[7]|h_sw[8]|h_sw[9]|l_sw[0]|l_sw[10]|l_sw[1]|l_sw[2]|l_sw[3]|l_sw[4]|l_sw[5]|l_sw[6]|l_sw[7]|l_sw[8]|l_sw[9]|vc|vdd|vss|z
+ \$22 sg13_lv_pmos L=0.13u W=1u AS=0.19p AD=0.19p PS=1.38u PD=1.38u rfmode=0
M$325
+ BOTTOM|TOP|h_sw[0]|h_sw[10]|h_sw[1]|h_sw[2]|h_sw[3]|h_sw[4]|h_sw[5]|h_sw[6]|h_sw[7]|h_sw[8]|h_sw[9]|l_sw[0]|l_sw[10]|l_sw[1]|l_sw[2]|l_sw[3]|l_sw[4]|l_sw[5]|l_sw[6]|l_sw[7]|l_sw[8]|l_sw[9]|vc|vdd|vss|z
+ in_l_sw[2]|x
+ BOTTOM|TOP|h_sw[0]|h_sw[10]|h_sw[1]|h_sw[2]|h_sw[3]|h_sw[4]|h_sw[5]|h_sw[6]|h_sw[7]|h_sw[8]|h_sw[9]|l_sw[0]|l_sw[10]|l_sw[1]|l_sw[2]|l_sw[3]|l_sw[4]|l_sw[5]|l_sw[6]|l_sw[7]|l_sw[8]|l_sw[9]|vc|vdd|vss|z
+ \$22 sg13_lv_pmos L=0.13u W=1u AS=0.19p AD=0.19p PS=1.38u PD=1.38u rfmode=0
M$326
+ BOTTOM|TOP|h_sw[0]|h_sw[10]|h_sw[1]|h_sw[2]|h_sw[3]|h_sw[4]|h_sw[5]|h_sw[6]|h_sw[7]|h_sw[8]|h_sw[9]|l_sw[0]|l_sw[10]|l_sw[1]|l_sw[2]|l_sw[3]|l_sw[4]|l_sw[5]|l_sw[6]|l_sw[7]|l_sw[8]|l_sw[9]|vc|vdd|vss|z
+ in_l_sw[2]|x
+ BOTTOM|TOP|h_sw[0]|h_sw[10]|h_sw[1]|h_sw[2]|h_sw[3]|h_sw[4]|h_sw[5]|h_sw[6]|h_sw[7]|h_sw[8]|h_sw[9]|l_sw[0]|l_sw[10]|l_sw[1]|l_sw[2]|l_sw[3]|l_sw[4]|l_sw[5]|l_sw[6]|l_sw[7]|l_sw[8]|l_sw[9]|vc|vdd|vss|z
+ \$22 sg13_lv_pmos L=0.13u W=1u AS=0.19p AD=0.19p PS=1.38u PD=1.38u rfmode=0
M$327
+ BOTTOM|TOP|h_sw[0]|h_sw[10]|h_sw[1]|h_sw[2]|h_sw[3]|h_sw[4]|h_sw[5]|h_sw[6]|h_sw[7]|h_sw[8]|h_sw[9]|l_sw[0]|l_sw[10]|l_sw[1]|l_sw[2]|l_sw[3]|l_sw[4]|l_sw[5]|l_sw[6]|l_sw[7]|l_sw[8]|l_sw[9]|vc|vdd|vss|z
+ in_l_sw[2]|x
+ BOTTOM|TOP|h_sw[0]|h_sw[10]|h_sw[1]|h_sw[2]|h_sw[3]|h_sw[4]|h_sw[5]|h_sw[6]|h_sw[7]|h_sw[8]|h_sw[9]|l_sw[0]|l_sw[10]|l_sw[1]|l_sw[2]|l_sw[3]|l_sw[4]|l_sw[5]|l_sw[6]|l_sw[7]|l_sw[8]|l_sw[9]|vc|vdd|vss|z
+ \$22 sg13_lv_pmos L=0.13u W=1u AS=0.19p AD=0.19p PS=1.38u PD=1.38u rfmode=0
M$328
+ BOTTOM|TOP|h_sw[0]|h_sw[10]|h_sw[1]|h_sw[2]|h_sw[3]|h_sw[4]|h_sw[5]|h_sw[6]|h_sw[7]|h_sw[8]|h_sw[9]|l_sw[0]|l_sw[10]|l_sw[1]|l_sw[2]|l_sw[3]|l_sw[4]|l_sw[5]|l_sw[6]|l_sw[7]|l_sw[8]|l_sw[9]|vc|vdd|vss|z
+ in_l_sw[2]|x
+ BOTTOM|TOP|h_sw[0]|h_sw[10]|h_sw[1]|h_sw[2]|h_sw[3]|h_sw[4]|h_sw[5]|h_sw[6]|h_sw[7]|h_sw[8]|h_sw[9]|l_sw[0]|l_sw[10]|l_sw[1]|l_sw[2]|l_sw[3]|l_sw[4]|l_sw[5]|l_sw[6]|l_sw[7]|l_sw[8]|l_sw[9]|vc|vdd|vss|z
+ \$22 sg13_lv_pmos L=0.13u W=1u AS=0.19p AD=0.19p PS=1.38u PD=1.38u rfmode=0
M$329
+ BOTTOM|TOP|h_sw[0]|h_sw[10]|h_sw[1]|h_sw[2]|h_sw[3]|h_sw[4]|h_sw[5]|h_sw[6]|h_sw[7]|h_sw[8]|h_sw[9]|l_sw[0]|l_sw[10]|l_sw[1]|l_sw[2]|l_sw[3]|l_sw[4]|l_sw[5]|l_sw[6]|l_sw[7]|l_sw[8]|l_sw[9]|vc|vdd|vss|z
+ in_l_sw[2]|x
+ BOTTOM|TOP|h_sw[0]|h_sw[10]|h_sw[1]|h_sw[2]|h_sw[3]|h_sw[4]|h_sw[5]|h_sw[6]|h_sw[7]|h_sw[8]|h_sw[9]|l_sw[0]|l_sw[10]|l_sw[1]|l_sw[2]|l_sw[3]|l_sw[4]|l_sw[5]|l_sw[6]|l_sw[7]|l_sw[8]|l_sw[9]|vc|vdd|vss|z
+ \$22 sg13_lv_pmos L=0.13u W=1u AS=0.19p AD=0.19p PS=1.38u PD=1.38u rfmode=0
M$330
+ BOTTOM|TOP|h_sw[0]|h_sw[10]|h_sw[1]|h_sw[2]|h_sw[3]|h_sw[4]|h_sw[5]|h_sw[6]|h_sw[7]|h_sw[8]|h_sw[9]|l_sw[0]|l_sw[10]|l_sw[1]|l_sw[2]|l_sw[3]|l_sw[4]|l_sw[5]|l_sw[6]|l_sw[7]|l_sw[8]|l_sw[9]|vc|vdd|vss|z
+ in_l_sw[2]|x
+ BOTTOM|TOP|h_sw[0]|h_sw[10]|h_sw[1]|h_sw[2]|h_sw[3]|h_sw[4]|h_sw[5]|h_sw[6]|h_sw[7]|h_sw[8]|h_sw[9]|l_sw[0]|l_sw[10]|l_sw[1]|l_sw[2]|l_sw[3]|l_sw[4]|l_sw[5]|l_sw[6]|l_sw[7]|l_sw[8]|l_sw[9]|vc|vdd|vss|z
+ \$22 sg13_lv_pmos L=0.13u W=1u AS=0.19p AD=0.19p PS=1.38u PD=1.38u rfmode=0
M$331
+ BOTTOM|TOP|h_sw[0]|h_sw[10]|h_sw[1]|h_sw[2]|h_sw[3]|h_sw[4]|h_sw[5]|h_sw[6]|h_sw[7]|h_sw[8]|h_sw[9]|l_sw[0]|l_sw[10]|l_sw[1]|l_sw[2]|l_sw[3]|l_sw[4]|l_sw[5]|l_sw[6]|l_sw[7]|l_sw[8]|l_sw[9]|vc|vdd|vss|z
+ in_l_sw[2]|x
+ BOTTOM|TOP|h_sw[0]|h_sw[10]|h_sw[1]|h_sw[2]|h_sw[3]|h_sw[4]|h_sw[5]|h_sw[6]|h_sw[7]|h_sw[8]|h_sw[9]|l_sw[0]|l_sw[10]|l_sw[1]|l_sw[2]|l_sw[3]|l_sw[4]|l_sw[5]|l_sw[6]|l_sw[7]|l_sw[8]|l_sw[9]|vc|vdd|vss|z
+ \$22 sg13_lv_pmos L=0.13u W=1u AS=0.19p AD=0.19p PS=1.38u PD=1.38u rfmode=0
M$332
+ BOTTOM|TOP|h_sw[0]|h_sw[10]|h_sw[1]|h_sw[2]|h_sw[3]|h_sw[4]|h_sw[5]|h_sw[6]|h_sw[7]|h_sw[8]|h_sw[9]|l_sw[0]|l_sw[10]|l_sw[1]|l_sw[2]|l_sw[3]|l_sw[4]|l_sw[5]|l_sw[6]|l_sw[7]|l_sw[8]|l_sw[9]|vc|vdd|vss|z
+ in_l_sw[2]|x
+ BOTTOM|TOP|h_sw[0]|h_sw[10]|h_sw[1]|h_sw[2]|h_sw[3]|h_sw[4]|h_sw[5]|h_sw[6]|h_sw[7]|h_sw[8]|h_sw[9]|l_sw[0]|l_sw[10]|l_sw[1]|l_sw[2]|l_sw[3]|l_sw[4]|l_sw[5]|l_sw[6]|l_sw[7]|l_sw[8]|l_sw[9]|vc|vdd|vss|z
+ \$22 sg13_lv_pmos L=0.13u W=1u AS=0.19p AD=0.19p PS=1.38u PD=1.38u rfmode=0
M$333
+ BOTTOM|TOP|h_sw[0]|h_sw[10]|h_sw[1]|h_sw[2]|h_sw[3]|h_sw[4]|h_sw[5]|h_sw[6]|h_sw[7]|h_sw[8]|h_sw[9]|l_sw[0]|l_sw[10]|l_sw[1]|l_sw[2]|l_sw[3]|l_sw[4]|l_sw[5]|l_sw[6]|l_sw[7]|l_sw[8]|l_sw[9]|vc|vdd|vss|z
+ in_l_sw[2]|x
+ BOTTOM|TOP|h_sw[0]|h_sw[10]|h_sw[1]|h_sw[2]|h_sw[3]|h_sw[4]|h_sw[5]|h_sw[6]|h_sw[7]|h_sw[8]|h_sw[9]|l_sw[0]|l_sw[10]|l_sw[1]|l_sw[2]|l_sw[3]|l_sw[4]|l_sw[5]|l_sw[6]|l_sw[7]|l_sw[8]|l_sw[9]|vc|vdd|vss|z
+ \$22 sg13_lv_pmos L=0.13u W=1u AS=0.19p AD=0.19p PS=1.38u PD=1.38u rfmode=0
M$334
+ BOTTOM|TOP|h_sw[0]|h_sw[10]|h_sw[1]|h_sw[2]|h_sw[3]|h_sw[4]|h_sw[5]|h_sw[6]|h_sw[7]|h_sw[8]|h_sw[9]|l_sw[0]|l_sw[10]|l_sw[1]|l_sw[2]|l_sw[3]|l_sw[4]|l_sw[5]|l_sw[6]|l_sw[7]|l_sw[8]|l_sw[9]|vc|vdd|vss|z
+ in_l_sw[2]|x
+ BOTTOM|TOP|h_sw[0]|h_sw[10]|h_sw[1]|h_sw[2]|h_sw[3]|h_sw[4]|h_sw[5]|h_sw[6]|h_sw[7]|h_sw[8]|h_sw[9]|l_sw[0]|l_sw[10]|l_sw[1]|l_sw[2]|l_sw[3]|l_sw[4]|l_sw[5]|l_sw[6]|l_sw[7]|l_sw[8]|l_sw[9]|vc|vdd|vss|z
+ \$22 sg13_lv_pmos L=0.13u W=1u AS=0.19p AD=0.19p PS=1.38u PD=1.38u rfmode=0
M$335
+ BOTTOM|TOP|h_sw[0]|h_sw[10]|h_sw[1]|h_sw[2]|h_sw[3]|h_sw[4]|h_sw[5]|h_sw[6]|h_sw[7]|h_sw[8]|h_sw[9]|l_sw[0]|l_sw[10]|l_sw[1]|l_sw[2]|l_sw[3]|l_sw[4]|l_sw[5]|l_sw[6]|l_sw[7]|l_sw[8]|l_sw[9]|vc|vdd|vss|z
+ in_l_sw[2]|x
+ BOTTOM|TOP|h_sw[0]|h_sw[10]|h_sw[1]|h_sw[2]|h_sw[3]|h_sw[4]|h_sw[5]|h_sw[6]|h_sw[7]|h_sw[8]|h_sw[9]|l_sw[0]|l_sw[10]|l_sw[1]|l_sw[2]|l_sw[3]|l_sw[4]|l_sw[5]|l_sw[6]|l_sw[7]|l_sw[8]|l_sw[9]|vc|vdd|vss|z
+ \$22 sg13_lv_pmos L=0.13u W=1u AS=0.19p AD=0.19p PS=1.38u PD=1.38u rfmode=0
M$336
+ BOTTOM|TOP|h_sw[0]|h_sw[10]|h_sw[1]|h_sw[2]|h_sw[3]|h_sw[4]|h_sw[5]|h_sw[6]|h_sw[7]|h_sw[8]|h_sw[9]|l_sw[0]|l_sw[10]|l_sw[1]|l_sw[2]|l_sw[3]|l_sw[4]|l_sw[5]|l_sw[6]|l_sw[7]|l_sw[8]|l_sw[9]|vc|vdd|vss|z
+ in_l_sw[2]|x
+ BOTTOM|TOP|h_sw[0]|h_sw[10]|h_sw[1]|h_sw[2]|h_sw[3]|h_sw[4]|h_sw[5]|h_sw[6]|h_sw[7]|h_sw[8]|h_sw[9]|l_sw[0]|l_sw[10]|l_sw[1]|l_sw[2]|l_sw[3]|l_sw[4]|l_sw[5]|l_sw[6]|l_sw[7]|l_sw[8]|l_sw[9]|vc|vdd|vss|z
+ \$22 sg13_lv_pmos L=0.13u W=1u AS=0.19p AD=0.19p PS=1.38u PD=1.38u rfmode=0
M$337
+ BOTTOM|TOP|h_sw[0]|h_sw[10]|h_sw[1]|h_sw[2]|h_sw[3]|h_sw[4]|h_sw[5]|h_sw[6]|h_sw[7]|h_sw[8]|h_sw[9]|l_sw[0]|l_sw[10]|l_sw[1]|l_sw[2]|l_sw[3]|l_sw[4]|l_sw[5]|l_sw[6]|l_sw[7]|l_sw[8]|l_sw[9]|vc|vdd|vss|z
+ in_l_sw[2]|x
+ BOTTOM|TOP|h_sw[0]|h_sw[10]|h_sw[1]|h_sw[2]|h_sw[3]|h_sw[4]|h_sw[5]|h_sw[6]|h_sw[7]|h_sw[8]|h_sw[9]|l_sw[0]|l_sw[10]|l_sw[1]|l_sw[2]|l_sw[3]|l_sw[4]|l_sw[5]|l_sw[6]|l_sw[7]|l_sw[8]|l_sw[9]|vc|vdd|vss|z
+ \$22 sg13_lv_pmos L=0.13u W=1u AS=0.19p AD=0.19p PS=1.38u PD=1.38u rfmode=0
M$338
+ BOTTOM|TOP|h_sw[0]|h_sw[10]|h_sw[1]|h_sw[2]|h_sw[3]|h_sw[4]|h_sw[5]|h_sw[6]|h_sw[7]|h_sw[8]|h_sw[9]|l_sw[0]|l_sw[10]|l_sw[1]|l_sw[2]|l_sw[3]|l_sw[4]|l_sw[5]|l_sw[6]|l_sw[7]|l_sw[8]|l_sw[9]|vc|vdd|vss|z
+ in_l_sw[2]|x
+ BOTTOM|TOP|h_sw[0]|h_sw[10]|h_sw[1]|h_sw[2]|h_sw[3]|h_sw[4]|h_sw[5]|h_sw[6]|h_sw[7]|h_sw[8]|h_sw[9]|l_sw[0]|l_sw[10]|l_sw[1]|l_sw[2]|l_sw[3]|l_sw[4]|l_sw[5]|l_sw[6]|l_sw[7]|l_sw[8]|l_sw[9]|vc|vdd|vss|z
+ \$22 sg13_lv_pmos L=0.13u W=1u AS=0.19p AD=0.34p PS=1.38u PD=2.68u rfmode=0
M$339
+ BOTTOM|TOP|h_sw[0]|h_sw[10]|h_sw[1]|h_sw[2]|h_sw[3]|h_sw[4]|h_sw[5]|h_sw[6]|h_sw[7]|h_sw[8]|h_sw[9]|l_sw[0]|l_sw[10]|l_sw[1]|l_sw[2]|l_sw[3]|l_sw[4]|l_sw[5]|l_sw[6]|l_sw[7]|l_sw[8]|l_sw[9]|vc|vdd|vss|z
+ in_h_sw[2]|x
+ BOTTOM|TOP|h_sw[0]|h_sw[10]|h_sw[1]|h_sw[2]|h_sw[3]|h_sw[4]|h_sw[5]|h_sw[6]|h_sw[7]|h_sw[8]|h_sw[9]|l_sw[0]|l_sw[10]|l_sw[1]|l_sw[2]|l_sw[3]|l_sw[4]|l_sw[5]|l_sw[6]|l_sw[7]|l_sw[8]|l_sw[9]|vc|vdd|vss|z
+ \$22 sg13_lv_pmos L=0.13u W=1u AS=0.34p AD=0.19p PS=2.68u PD=1.38u rfmode=0
M$340
+ BOTTOM|TOP|h_sw[0]|h_sw[10]|h_sw[1]|h_sw[2]|h_sw[3]|h_sw[4]|h_sw[5]|h_sw[6]|h_sw[7]|h_sw[8]|h_sw[9]|l_sw[0]|l_sw[10]|l_sw[1]|l_sw[2]|l_sw[3]|l_sw[4]|l_sw[5]|l_sw[6]|l_sw[7]|l_sw[8]|l_sw[9]|vc|vdd|vss|z
+ in_h_sw[2]|x
+ BOTTOM|TOP|h_sw[0]|h_sw[10]|h_sw[1]|h_sw[2]|h_sw[3]|h_sw[4]|h_sw[5]|h_sw[6]|h_sw[7]|h_sw[8]|h_sw[9]|l_sw[0]|l_sw[10]|l_sw[1]|l_sw[2]|l_sw[3]|l_sw[4]|l_sw[5]|l_sw[6]|l_sw[7]|l_sw[8]|l_sw[9]|vc|vdd|vss|z
+ \$22 sg13_lv_pmos L=0.13u W=1u AS=0.19p AD=0.19p PS=1.38u PD=1.38u rfmode=0
M$341
+ BOTTOM|TOP|h_sw[0]|h_sw[10]|h_sw[1]|h_sw[2]|h_sw[3]|h_sw[4]|h_sw[5]|h_sw[6]|h_sw[7]|h_sw[8]|h_sw[9]|l_sw[0]|l_sw[10]|l_sw[1]|l_sw[2]|l_sw[3]|l_sw[4]|l_sw[5]|l_sw[6]|l_sw[7]|l_sw[8]|l_sw[9]|vc|vdd|vss|z
+ in_h_sw[2]|x
+ BOTTOM|TOP|h_sw[0]|h_sw[10]|h_sw[1]|h_sw[2]|h_sw[3]|h_sw[4]|h_sw[5]|h_sw[6]|h_sw[7]|h_sw[8]|h_sw[9]|l_sw[0]|l_sw[10]|l_sw[1]|l_sw[2]|l_sw[3]|l_sw[4]|l_sw[5]|l_sw[6]|l_sw[7]|l_sw[8]|l_sw[9]|vc|vdd|vss|z
+ \$22 sg13_lv_pmos L=0.13u W=1u AS=0.19p AD=0.19p PS=1.38u PD=1.38u rfmode=0
M$342
+ BOTTOM|TOP|h_sw[0]|h_sw[10]|h_sw[1]|h_sw[2]|h_sw[3]|h_sw[4]|h_sw[5]|h_sw[6]|h_sw[7]|h_sw[8]|h_sw[9]|l_sw[0]|l_sw[10]|l_sw[1]|l_sw[2]|l_sw[3]|l_sw[4]|l_sw[5]|l_sw[6]|l_sw[7]|l_sw[8]|l_sw[9]|vc|vdd|vss|z
+ in_h_sw[2]|x
+ BOTTOM|TOP|h_sw[0]|h_sw[10]|h_sw[1]|h_sw[2]|h_sw[3]|h_sw[4]|h_sw[5]|h_sw[6]|h_sw[7]|h_sw[8]|h_sw[9]|l_sw[0]|l_sw[10]|l_sw[1]|l_sw[2]|l_sw[3]|l_sw[4]|l_sw[5]|l_sw[6]|l_sw[7]|l_sw[8]|l_sw[9]|vc|vdd|vss|z
+ \$22 sg13_lv_pmos L=0.13u W=1u AS=0.19p AD=0.19p PS=1.38u PD=1.38u rfmode=0
M$343
+ BOTTOM|TOP|h_sw[0]|h_sw[10]|h_sw[1]|h_sw[2]|h_sw[3]|h_sw[4]|h_sw[5]|h_sw[6]|h_sw[7]|h_sw[8]|h_sw[9]|l_sw[0]|l_sw[10]|l_sw[1]|l_sw[2]|l_sw[3]|l_sw[4]|l_sw[5]|l_sw[6]|l_sw[7]|l_sw[8]|l_sw[9]|vc|vdd|vss|z
+ in_h_sw[2]|x
+ BOTTOM|TOP|h_sw[0]|h_sw[10]|h_sw[1]|h_sw[2]|h_sw[3]|h_sw[4]|h_sw[5]|h_sw[6]|h_sw[7]|h_sw[8]|h_sw[9]|l_sw[0]|l_sw[10]|l_sw[1]|l_sw[2]|l_sw[3]|l_sw[4]|l_sw[5]|l_sw[6]|l_sw[7]|l_sw[8]|l_sw[9]|vc|vdd|vss|z
+ \$22 sg13_lv_pmos L=0.13u W=1u AS=0.19p AD=0.19p PS=1.38u PD=1.38u rfmode=0
M$344
+ BOTTOM|TOP|h_sw[0]|h_sw[10]|h_sw[1]|h_sw[2]|h_sw[3]|h_sw[4]|h_sw[5]|h_sw[6]|h_sw[7]|h_sw[8]|h_sw[9]|l_sw[0]|l_sw[10]|l_sw[1]|l_sw[2]|l_sw[3]|l_sw[4]|l_sw[5]|l_sw[6]|l_sw[7]|l_sw[8]|l_sw[9]|vc|vdd|vss|z
+ in_h_sw[2]|x
+ BOTTOM|TOP|h_sw[0]|h_sw[10]|h_sw[1]|h_sw[2]|h_sw[3]|h_sw[4]|h_sw[5]|h_sw[6]|h_sw[7]|h_sw[8]|h_sw[9]|l_sw[0]|l_sw[10]|l_sw[1]|l_sw[2]|l_sw[3]|l_sw[4]|l_sw[5]|l_sw[6]|l_sw[7]|l_sw[8]|l_sw[9]|vc|vdd|vss|z
+ \$22 sg13_lv_pmos L=0.13u W=1u AS=0.19p AD=0.19p PS=1.38u PD=1.38u rfmode=0
M$345
+ BOTTOM|TOP|h_sw[0]|h_sw[10]|h_sw[1]|h_sw[2]|h_sw[3]|h_sw[4]|h_sw[5]|h_sw[6]|h_sw[7]|h_sw[8]|h_sw[9]|l_sw[0]|l_sw[10]|l_sw[1]|l_sw[2]|l_sw[3]|l_sw[4]|l_sw[5]|l_sw[6]|l_sw[7]|l_sw[8]|l_sw[9]|vc|vdd|vss|z
+ in_h_sw[2]|x
+ BOTTOM|TOP|h_sw[0]|h_sw[10]|h_sw[1]|h_sw[2]|h_sw[3]|h_sw[4]|h_sw[5]|h_sw[6]|h_sw[7]|h_sw[8]|h_sw[9]|l_sw[0]|l_sw[10]|l_sw[1]|l_sw[2]|l_sw[3]|l_sw[4]|l_sw[5]|l_sw[6]|l_sw[7]|l_sw[8]|l_sw[9]|vc|vdd|vss|z
+ \$22 sg13_lv_pmos L=0.13u W=1u AS=0.19p AD=0.19p PS=1.38u PD=1.38u rfmode=0
M$346
+ BOTTOM|TOP|h_sw[0]|h_sw[10]|h_sw[1]|h_sw[2]|h_sw[3]|h_sw[4]|h_sw[5]|h_sw[6]|h_sw[7]|h_sw[8]|h_sw[9]|l_sw[0]|l_sw[10]|l_sw[1]|l_sw[2]|l_sw[3]|l_sw[4]|l_sw[5]|l_sw[6]|l_sw[7]|l_sw[8]|l_sw[9]|vc|vdd|vss|z
+ in_h_sw[2]|x
+ BOTTOM|TOP|h_sw[0]|h_sw[10]|h_sw[1]|h_sw[2]|h_sw[3]|h_sw[4]|h_sw[5]|h_sw[6]|h_sw[7]|h_sw[8]|h_sw[9]|l_sw[0]|l_sw[10]|l_sw[1]|l_sw[2]|l_sw[3]|l_sw[4]|l_sw[5]|l_sw[6]|l_sw[7]|l_sw[8]|l_sw[9]|vc|vdd|vss|z
+ \$22 sg13_lv_pmos L=0.13u W=1u AS=0.19p AD=0.19p PS=1.38u PD=1.38u rfmode=0
M$347
+ BOTTOM|TOP|h_sw[0]|h_sw[10]|h_sw[1]|h_sw[2]|h_sw[3]|h_sw[4]|h_sw[5]|h_sw[6]|h_sw[7]|h_sw[8]|h_sw[9]|l_sw[0]|l_sw[10]|l_sw[1]|l_sw[2]|l_sw[3]|l_sw[4]|l_sw[5]|l_sw[6]|l_sw[7]|l_sw[8]|l_sw[9]|vc|vdd|vss|z
+ in_h_sw[2]|x
+ BOTTOM|TOP|h_sw[0]|h_sw[10]|h_sw[1]|h_sw[2]|h_sw[3]|h_sw[4]|h_sw[5]|h_sw[6]|h_sw[7]|h_sw[8]|h_sw[9]|l_sw[0]|l_sw[10]|l_sw[1]|l_sw[2]|l_sw[3]|l_sw[4]|l_sw[5]|l_sw[6]|l_sw[7]|l_sw[8]|l_sw[9]|vc|vdd|vss|z
+ \$22 sg13_lv_pmos L=0.13u W=1u AS=0.19p AD=0.19p PS=1.38u PD=1.38u rfmode=0
M$348
+ BOTTOM|TOP|h_sw[0]|h_sw[10]|h_sw[1]|h_sw[2]|h_sw[3]|h_sw[4]|h_sw[5]|h_sw[6]|h_sw[7]|h_sw[8]|h_sw[9]|l_sw[0]|l_sw[10]|l_sw[1]|l_sw[2]|l_sw[3]|l_sw[4]|l_sw[5]|l_sw[6]|l_sw[7]|l_sw[8]|l_sw[9]|vc|vdd|vss|z
+ in_h_sw[2]|x
+ BOTTOM|TOP|h_sw[0]|h_sw[10]|h_sw[1]|h_sw[2]|h_sw[3]|h_sw[4]|h_sw[5]|h_sw[6]|h_sw[7]|h_sw[8]|h_sw[9]|l_sw[0]|l_sw[10]|l_sw[1]|l_sw[2]|l_sw[3]|l_sw[4]|l_sw[5]|l_sw[6]|l_sw[7]|l_sw[8]|l_sw[9]|vc|vdd|vss|z
+ \$22 sg13_lv_pmos L=0.13u W=1u AS=0.19p AD=0.19p PS=1.38u PD=1.38u rfmode=0
M$349
+ BOTTOM|TOP|h_sw[0]|h_sw[10]|h_sw[1]|h_sw[2]|h_sw[3]|h_sw[4]|h_sw[5]|h_sw[6]|h_sw[7]|h_sw[8]|h_sw[9]|l_sw[0]|l_sw[10]|l_sw[1]|l_sw[2]|l_sw[3]|l_sw[4]|l_sw[5]|l_sw[6]|l_sw[7]|l_sw[8]|l_sw[9]|vc|vdd|vss|z
+ in_h_sw[2]|x
+ BOTTOM|TOP|h_sw[0]|h_sw[10]|h_sw[1]|h_sw[2]|h_sw[3]|h_sw[4]|h_sw[5]|h_sw[6]|h_sw[7]|h_sw[8]|h_sw[9]|l_sw[0]|l_sw[10]|l_sw[1]|l_sw[2]|l_sw[3]|l_sw[4]|l_sw[5]|l_sw[6]|l_sw[7]|l_sw[8]|l_sw[9]|vc|vdd|vss|z
+ \$22 sg13_lv_pmos L=0.13u W=1u AS=0.19p AD=0.19p PS=1.38u PD=1.38u rfmode=0
M$350
+ BOTTOM|TOP|h_sw[0]|h_sw[10]|h_sw[1]|h_sw[2]|h_sw[3]|h_sw[4]|h_sw[5]|h_sw[6]|h_sw[7]|h_sw[8]|h_sw[9]|l_sw[0]|l_sw[10]|l_sw[1]|l_sw[2]|l_sw[3]|l_sw[4]|l_sw[5]|l_sw[6]|l_sw[7]|l_sw[8]|l_sw[9]|vc|vdd|vss|z
+ in_h_sw[2]|x
+ BOTTOM|TOP|h_sw[0]|h_sw[10]|h_sw[1]|h_sw[2]|h_sw[3]|h_sw[4]|h_sw[5]|h_sw[6]|h_sw[7]|h_sw[8]|h_sw[9]|l_sw[0]|l_sw[10]|l_sw[1]|l_sw[2]|l_sw[3]|l_sw[4]|l_sw[5]|l_sw[6]|l_sw[7]|l_sw[8]|l_sw[9]|vc|vdd|vss|z
+ \$22 sg13_lv_pmos L=0.13u W=1u AS=0.19p AD=0.19p PS=1.38u PD=1.38u rfmode=0
M$351
+ BOTTOM|TOP|h_sw[0]|h_sw[10]|h_sw[1]|h_sw[2]|h_sw[3]|h_sw[4]|h_sw[5]|h_sw[6]|h_sw[7]|h_sw[8]|h_sw[9]|l_sw[0]|l_sw[10]|l_sw[1]|l_sw[2]|l_sw[3]|l_sw[4]|l_sw[5]|l_sw[6]|l_sw[7]|l_sw[8]|l_sw[9]|vc|vdd|vss|z
+ in_h_sw[2]|x
+ BOTTOM|TOP|h_sw[0]|h_sw[10]|h_sw[1]|h_sw[2]|h_sw[3]|h_sw[4]|h_sw[5]|h_sw[6]|h_sw[7]|h_sw[8]|h_sw[9]|l_sw[0]|l_sw[10]|l_sw[1]|l_sw[2]|l_sw[3]|l_sw[4]|l_sw[5]|l_sw[6]|l_sw[7]|l_sw[8]|l_sw[9]|vc|vdd|vss|z
+ \$22 sg13_lv_pmos L=0.13u W=1u AS=0.19p AD=0.19p PS=1.38u PD=1.38u rfmode=0
M$352
+ BOTTOM|TOP|h_sw[0]|h_sw[10]|h_sw[1]|h_sw[2]|h_sw[3]|h_sw[4]|h_sw[5]|h_sw[6]|h_sw[7]|h_sw[8]|h_sw[9]|l_sw[0]|l_sw[10]|l_sw[1]|l_sw[2]|l_sw[3]|l_sw[4]|l_sw[5]|l_sw[6]|l_sw[7]|l_sw[8]|l_sw[9]|vc|vdd|vss|z
+ in_h_sw[2]|x
+ BOTTOM|TOP|h_sw[0]|h_sw[10]|h_sw[1]|h_sw[2]|h_sw[3]|h_sw[4]|h_sw[5]|h_sw[6]|h_sw[7]|h_sw[8]|h_sw[9]|l_sw[0]|l_sw[10]|l_sw[1]|l_sw[2]|l_sw[3]|l_sw[4]|l_sw[5]|l_sw[6]|l_sw[7]|l_sw[8]|l_sw[9]|vc|vdd|vss|z
+ \$22 sg13_lv_pmos L=0.13u W=1u AS=0.19p AD=0.19p PS=1.38u PD=1.38u rfmode=0
M$353
+ BOTTOM|TOP|h_sw[0]|h_sw[10]|h_sw[1]|h_sw[2]|h_sw[3]|h_sw[4]|h_sw[5]|h_sw[6]|h_sw[7]|h_sw[8]|h_sw[9]|l_sw[0]|l_sw[10]|l_sw[1]|l_sw[2]|l_sw[3]|l_sw[4]|l_sw[5]|l_sw[6]|l_sw[7]|l_sw[8]|l_sw[9]|vc|vdd|vss|z
+ in_h_sw[2]|x
+ BOTTOM|TOP|h_sw[0]|h_sw[10]|h_sw[1]|h_sw[2]|h_sw[3]|h_sw[4]|h_sw[5]|h_sw[6]|h_sw[7]|h_sw[8]|h_sw[9]|l_sw[0]|l_sw[10]|l_sw[1]|l_sw[2]|l_sw[3]|l_sw[4]|l_sw[5]|l_sw[6]|l_sw[7]|l_sw[8]|l_sw[9]|vc|vdd|vss|z
+ \$22 sg13_lv_pmos L=0.13u W=1u AS=0.19p AD=0.19p PS=1.38u PD=1.38u rfmode=0
M$354
+ BOTTOM|TOP|h_sw[0]|h_sw[10]|h_sw[1]|h_sw[2]|h_sw[3]|h_sw[4]|h_sw[5]|h_sw[6]|h_sw[7]|h_sw[8]|h_sw[9]|l_sw[0]|l_sw[10]|l_sw[1]|l_sw[2]|l_sw[3]|l_sw[4]|l_sw[5]|l_sw[6]|l_sw[7]|l_sw[8]|l_sw[9]|vc|vdd|vss|z
+ in_h_sw[2]|x
+ BOTTOM|TOP|h_sw[0]|h_sw[10]|h_sw[1]|h_sw[2]|h_sw[3]|h_sw[4]|h_sw[5]|h_sw[6]|h_sw[7]|h_sw[8]|h_sw[9]|l_sw[0]|l_sw[10]|l_sw[1]|l_sw[2]|l_sw[3]|l_sw[4]|l_sw[5]|l_sw[6]|l_sw[7]|l_sw[8]|l_sw[9]|vc|vdd|vss|z
+ \$22 sg13_lv_pmos L=0.13u W=1u AS=0.19p AD=0.34p PS=1.38u PD=2.68u rfmode=0
M$355
+ BOTTOM|TOP|h_sw[0]|h_sw[10]|h_sw[1]|h_sw[2]|h_sw[3]|h_sw[4]|h_sw[5]|h_sw[6]|h_sw[7]|h_sw[8]|h_sw[9]|l_sw[0]|l_sw[10]|l_sw[1]|l_sw[2]|l_sw[3]|l_sw[4]|l_sw[5]|l_sw[6]|l_sw[7]|l_sw[8]|l_sw[9]|vc|vdd|vss|z
+ in_h_sw[6]|x
+ BOTTOM|TOP|h_sw[0]|h_sw[10]|h_sw[1]|h_sw[2]|h_sw[3]|h_sw[4]|h_sw[5]|h_sw[6]|h_sw[7]|h_sw[8]|h_sw[9]|l_sw[0]|l_sw[10]|l_sw[1]|l_sw[2]|l_sw[3]|l_sw[4]|l_sw[5]|l_sw[6]|l_sw[7]|l_sw[8]|l_sw[9]|vc|vdd|vss|z
+ \$11 sg13_lv_pmos L=0.13u W=1u AS=0.34p AD=0.19p PS=2.68u PD=1.38u rfmode=0
M$356
+ BOTTOM|TOP|h_sw[0]|h_sw[10]|h_sw[1]|h_sw[2]|h_sw[3]|h_sw[4]|h_sw[5]|h_sw[6]|h_sw[7]|h_sw[8]|h_sw[9]|l_sw[0]|l_sw[10]|l_sw[1]|l_sw[2]|l_sw[3]|l_sw[4]|l_sw[5]|l_sw[6]|l_sw[7]|l_sw[8]|l_sw[9]|vc|vdd|vss|z
+ in_h_sw[6]|x
+ BOTTOM|TOP|h_sw[0]|h_sw[10]|h_sw[1]|h_sw[2]|h_sw[3]|h_sw[4]|h_sw[5]|h_sw[6]|h_sw[7]|h_sw[8]|h_sw[9]|l_sw[0]|l_sw[10]|l_sw[1]|l_sw[2]|l_sw[3]|l_sw[4]|l_sw[5]|l_sw[6]|l_sw[7]|l_sw[8]|l_sw[9]|vc|vdd|vss|z
+ \$11 sg13_lv_pmos L=0.13u W=1u AS=0.19p AD=0.19p PS=1.38u PD=1.38u rfmode=0
M$357
+ BOTTOM|TOP|h_sw[0]|h_sw[10]|h_sw[1]|h_sw[2]|h_sw[3]|h_sw[4]|h_sw[5]|h_sw[6]|h_sw[7]|h_sw[8]|h_sw[9]|l_sw[0]|l_sw[10]|l_sw[1]|l_sw[2]|l_sw[3]|l_sw[4]|l_sw[5]|l_sw[6]|l_sw[7]|l_sw[8]|l_sw[9]|vc|vdd|vss|z
+ in_h_sw[6]|x
+ BOTTOM|TOP|h_sw[0]|h_sw[10]|h_sw[1]|h_sw[2]|h_sw[3]|h_sw[4]|h_sw[5]|h_sw[6]|h_sw[7]|h_sw[8]|h_sw[9]|l_sw[0]|l_sw[10]|l_sw[1]|l_sw[2]|l_sw[3]|l_sw[4]|l_sw[5]|l_sw[6]|l_sw[7]|l_sw[8]|l_sw[9]|vc|vdd|vss|z
+ \$11 sg13_lv_pmos L=0.13u W=1u AS=0.19p AD=0.19p PS=1.38u PD=1.38u rfmode=0
M$358
+ BOTTOM|TOP|h_sw[0]|h_sw[10]|h_sw[1]|h_sw[2]|h_sw[3]|h_sw[4]|h_sw[5]|h_sw[6]|h_sw[7]|h_sw[8]|h_sw[9]|l_sw[0]|l_sw[10]|l_sw[1]|l_sw[2]|l_sw[3]|l_sw[4]|l_sw[5]|l_sw[6]|l_sw[7]|l_sw[8]|l_sw[9]|vc|vdd|vss|z
+ in_h_sw[6]|x
+ BOTTOM|TOP|h_sw[0]|h_sw[10]|h_sw[1]|h_sw[2]|h_sw[3]|h_sw[4]|h_sw[5]|h_sw[6]|h_sw[7]|h_sw[8]|h_sw[9]|l_sw[0]|l_sw[10]|l_sw[1]|l_sw[2]|l_sw[3]|l_sw[4]|l_sw[5]|l_sw[6]|l_sw[7]|l_sw[8]|l_sw[9]|vc|vdd|vss|z
+ \$11 sg13_lv_pmos L=0.13u W=1u AS=0.19p AD=0.34p PS=1.38u PD=2.68u rfmode=0
M$359
+ BOTTOM|TOP|h_sw[0]|h_sw[10]|h_sw[1]|h_sw[2]|h_sw[3]|h_sw[4]|h_sw[5]|h_sw[6]|h_sw[7]|h_sw[8]|h_sw[9]|l_sw[0]|l_sw[10]|l_sw[1]|l_sw[2]|l_sw[3]|l_sw[4]|l_sw[5]|l_sw[6]|l_sw[7]|l_sw[8]|l_sw[9]|vc|vdd|vss|z
+ in_h_sw[7]|x
+ BOTTOM|TOP|h_sw[0]|h_sw[10]|h_sw[1]|h_sw[2]|h_sw[3]|h_sw[4]|h_sw[5]|h_sw[6]|h_sw[7]|h_sw[8]|h_sw[9]|l_sw[0]|l_sw[10]|l_sw[1]|l_sw[2]|l_sw[3]|l_sw[4]|l_sw[5]|l_sw[6]|l_sw[7]|l_sw[8]|l_sw[9]|vc|vdd|vss|z
+ \$29 sg13_lv_pmos L=0.13u W=1u AS=0.34p AD=0.19p PS=2.68u PD=1.38u rfmode=0
M$360
+ BOTTOM|TOP|h_sw[0]|h_sw[10]|h_sw[1]|h_sw[2]|h_sw[3]|h_sw[4]|h_sw[5]|h_sw[6]|h_sw[7]|h_sw[8]|h_sw[9]|l_sw[0]|l_sw[10]|l_sw[1]|l_sw[2]|l_sw[3]|l_sw[4]|l_sw[5]|l_sw[6]|l_sw[7]|l_sw[8]|l_sw[9]|vc|vdd|vss|z
+ in_h_sw[7]|x
+ BOTTOM|TOP|h_sw[0]|h_sw[10]|h_sw[1]|h_sw[2]|h_sw[3]|h_sw[4]|h_sw[5]|h_sw[6]|h_sw[7]|h_sw[8]|h_sw[9]|l_sw[0]|l_sw[10]|l_sw[1]|l_sw[2]|l_sw[3]|l_sw[4]|l_sw[5]|l_sw[6]|l_sw[7]|l_sw[8]|l_sw[9]|vc|vdd|vss|z
+ \$29 sg13_lv_pmos L=0.13u W=1u AS=0.19p AD=0.19p PS=1.38u PD=1.38u rfmode=0
M$361
+ BOTTOM|TOP|h_sw[0]|h_sw[10]|h_sw[1]|h_sw[2]|h_sw[3]|h_sw[4]|h_sw[5]|h_sw[6]|h_sw[7]|h_sw[8]|h_sw[9]|l_sw[0]|l_sw[10]|l_sw[1]|l_sw[2]|l_sw[3]|l_sw[4]|l_sw[5]|l_sw[6]|l_sw[7]|l_sw[8]|l_sw[9]|vc|vdd|vss|z
+ in_h_sw[7]|x
+ BOTTOM|TOP|h_sw[0]|h_sw[10]|h_sw[1]|h_sw[2]|h_sw[3]|h_sw[4]|h_sw[5]|h_sw[6]|h_sw[7]|h_sw[8]|h_sw[9]|l_sw[0]|l_sw[10]|l_sw[1]|l_sw[2]|l_sw[3]|l_sw[4]|l_sw[5]|l_sw[6]|l_sw[7]|l_sw[8]|l_sw[9]|vc|vdd|vss|z
+ \$29 sg13_lv_pmos L=0.13u W=1u AS=0.19p AD=0.19p PS=1.38u PD=1.38u rfmode=0
M$362
+ BOTTOM|TOP|h_sw[0]|h_sw[10]|h_sw[1]|h_sw[2]|h_sw[3]|h_sw[4]|h_sw[5]|h_sw[6]|h_sw[7]|h_sw[8]|h_sw[9]|l_sw[0]|l_sw[10]|l_sw[1]|l_sw[2]|l_sw[3]|l_sw[4]|l_sw[5]|l_sw[6]|l_sw[7]|l_sw[8]|l_sw[9]|vc|vdd|vss|z
+ in_h_sw[7]|x
+ BOTTOM|TOP|h_sw[0]|h_sw[10]|h_sw[1]|h_sw[2]|h_sw[3]|h_sw[4]|h_sw[5]|h_sw[6]|h_sw[7]|h_sw[8]|h_sw[9]|l_sw[0]|l_sw[10]|l_sw[1]|l_sw[2]|l_sw[3]|l_sw[4]|l_sw[5]|l_sw[6]|l_sw[7]|l_sw[8]|l_sw[9]|vc|vdd|vss|z
+ \$29 sg13_lv_pmos L=0.13u W=1u AS=0.19p AD=0.34p PS=1.38u PD=2.68u rfmode=0
M$363
+ BOTTOM|TOP|h_sw[0]|h_sw[10]|h_sw[1]|h_sw[2]|h_sw[3]|h_sw[4]|h_sw[5]|h_sw[6]|h_sw[7]|h_sw[8]|h_sw[9]|l_sw[0]|l_sw[10]|l_sw[1]|l_sw[2]|l_sw[3]|l_sw[4]|l_sw[5]|l_sw[6]|l_sw[7]|l_sw[8]|l_sw[9]|vc|vdd|vss|z
+ in_h_sw[8]|x
+ BOTTOM|TOP|h_sw[0]|h_sw[10]|h_sw[1]|h_sw[2]|h_sw[3]|h_sw[4]|h_sw[5]|h_sw[6]|h_sw[7]|h_sw[8]|h_sw[9]|l_sw[0]|l_sw[10]|l_sw[1]|l_sw[2]|l_sw[3]|l_sw[4]|l_sw[5]|l_sw[6]|l_sw[7]|l_sw[8]|l_sw[9]|vc|vdd|vss|z
+ \$29 sg13_lv_pmos L=0.13u W=1u AS=0.34p AD=0.19p PS=2.68u PD=1.38u rfmode=0
M$364
+ BOTTOM|TOP|h_sw[0]|h_sw[10]|h_sw[1]|h_sw[2]|h_sw[3]|h_sw[4]|h_sw[5]|h_sw[6]|h_sw[7]|h_sw[8]|h_sw[9]|l_sw[0]|l_sw[10]|l_sw[1]|l_sw[2]|l_sw[3]|l_sw[4]|l_sw[5]|l_sw[6]|l_sw[7]|l_sw[8]|l_sw[9]|vc|vdd|vss|z
+ in_h_sw[8]|x
+ BOTTOM|TOP|h_sw[0]|h_sw[10]|h_sw[1]|h_sw[2]|h_sw[3]|h_sw[4]|h_sw[5]|h_sw[6]|h_sw[7]|h_sw[8]|h_sw[9]|l_sw[0]|l_sw[10]|l_sw[1]|l_sw[2]|l_sw[3]|l_sw[4]|l_sw[5]|l_sw[6]|l_sw[7]|l_sw[8]|l_sw[9]|vc|vdd|vss|z
+ \$29 sg13_lv_pmos L=0.13u W=1u AS=0.19p AD=0.34p PS=1.38u PD=2.68u rfmode=0
M$365
+ BOTTOM|TOP|h_sw[0]|h_sw[10]|h_sw[1]|h_sw[2]|h_sw[3]|h_sw[4]|h_sw[5]|h_sw[6]|h_sw[7]|h_sw[8]|h_sw[9]|l_sw[0]|l_sw[10]|l_sw[1]|l_sw[2]|l_sw[3]|l_sw[4]|l_sw[5]|l_sw[6]|l_sw[7]|l_sw[8]|l_sw[9]|vc|vdd|vss|z
+ in_h_sw[9]|x
+ BOTTOM|TOP|h_sw[0]|h_sw[10]|h_sw[1]|h_sw[2]|h_sw[3]|h_sw[4]|h_sw[5]|h_sw[6]|h_sw[7]|h_sw[8]|h_sw[9]|l_sw[0]|l_sw[10]|l_sw[1]|l_sw[2]|l_sw[3]|l_sw[4]|l_sw[5]|l_sw[6]|l_sw[7]|l_sw[8]|l_sw[9]|vc|vdd|vss|z
+ \$48 sg13_lv_pmos L=0.13u W=1u AS=0.34p AD=0.19p PS=2.68u PD=1.38u rfmode=0
M$366
+ BOTTOM|TOP|h_sw[0]|h_sw[10]|h_sw[1]|h_sw[2]|h_sw[3]|h_sw[4]|h_sw[5]|h_sw[6]|h_sw[7]|h_sw[8]|h_sw[9]|l_sw[0]|l_sw[10]|l_sw[1]|l_sw[2]|l_sw[3]|l_sw[4]|l_sw[5]|l_sw[6]|l_sw[7]|l_sw[8]|l_sw[9]|vc|vdd|vss|z
+ in_h_sw[9]|x
+ BOTTOM|TOP|h_sw[0]|h_sw[10]|h_sw[1]|h_sw[2]|h_sw[3]|h_sw[4]|h_sw[5]|h_sw[6]|h_sw[7]|h_sw[8]|h_sw[9]|l_sw[0]|l_sw[10]|l_sw[1]|l_sw[2]|l_sw[3]|l_sw[4]|l_sw[5]|l_sw[6]|l_sw[7]|l_sw[8]|l_sw[9]|vc|vdd|vss|z
+ \$48 sg13_lv_pmos L=0.13u W=1u AS=0.19p AD=0.34p PS=1.38u PD=2.68u rfmode=0
M$367
+ BOTTOM|TOP|h_sw[0]|h_sw[10]|h_sw[1]|h_sw[2]|h_sw[3]|h_sw[4]|h_sw[5]|h_sw[6]|h_sw[7]|h_sw[8]|h_sw[9]|l_sw[0]|l_sw[10]|l_sw[1]|l_sw[2]|l_sw[3]|l_sw[4]|l_sw[5]|l_sw[6]|l_sw[7]|l_sw[8]|l_sw[9]|vc|vdd|vss|z
+ in_l_sw[4]|x
+ BOTTOM|TOP|h_sw[0]|h_sw[10]|h_sw[1]|h_sw[2]|h_sw[3]|h_sw[4]|h_sw[5]|h_sw[6]|h_sw[7]|h_sw[8]|h_sw[9]|l_sw[0]|l_sw[10]|l_sw[1]|l_sw[2]|l_sw[3]|l_sw[4]|l_sw[5]|l_sw[6]|l_sw[7]|l_sw[8]|l_sw[9]|vc|vdd|vss|z
+ \$10 sg13_lv_pmos L=0.13u W=1u AS=0.34p AD=0.19p PS=2.68u PD=1.38u rfmode=0
M$368
+ BOTTOM|TOP|h_sw[0]|h_sw[10]|h_sw[1]|h_sw[2]|h_sw[3]|h_sw[4]|h_sw[5]|h_sw[6]|h_sw[7]|h_sw[8]|h_sw[9]|l_sw[0]|l_sw[10]|l_sw[1]|l_sw[2]|l_sw[3]|l_sw[4]|l_sw[5]|l_sw[6]|l_sw[7]|l_sw[8]|l_sw[9]|vc|vdd|vss|z
+ in_l_sw[4]|x
+ BOTTOM|TOP|h_sw[0]|h_sw[10]|h_sw[1]|h_sw[2]|h_sw[3]|h_sw[4]|h_sw[5]|h_sw[6]|h_sw[7]|h_sw[8]|h_sw[9]|l_sw[0]|l_sw[10]|l_sw[1]|l_sw[2]|l_sw[3]|l_sw[4]|l_sw[5]|l_sw[6]|l_sw[7]|l_sw[8]|l_sw[9]|vc|vdd|vss|z
+ \$10 sg13_lv_pmos L=0.13u W=1u AS=0.19p AD=0.19p PS=1.38u PD=1.38u rfmode=0
M$369
+ BOTTOM|TOP|h_sw[0]|h_sw[10]|h_sw[1]|h_sw[2]|h_sw[3]|h_sw[4]|h_sw[5]|h_sw[6]|h_sw[7]|h_sw[8]|h_sw[9]|l_sw[0]|l_sw[10]|l_sw[1]|l_sw[2]|l_sw[3]|l_sw[4]|l_sw[5]|l_sw[6]|l_sw[7]|l_sw[8]|l_sw[9]|vc|vdd|vss|z
+ in_l_sw[4]|x
+ BOTTOM|TOP|h_sw[0]|h_sw[10]|h_sw[1]|h_sw[2]|h_sw[3]|h_sw[4]|h_sw[5]|h_sw[6]|h_sw[7]|h_sw[8]|h_sw[9]|l_sw[0]|l_sw[10]|l_sw[1]|l_sw[2]|l_sw[3]|l_sw[4]|l_sw[5]|l_sw[6]|l_sw[7]|l_sw[8]|l_sw[9]|vc|vdd|vss|z
+ \$10 sg13_lv_pmos L=0.13u W=1u AS=0.19p AD=0.19p PS=1.38u PD=1.38u rfmode=0
M$370
+ BOTTOM|TOP|h_sw[0]|h_sw[10]|h_sw[1]|h_sw[2]|h_sw[3]|h_sw[4]|h_sw[5]|h_sw[6]|h_sw[7]|h_sw[8]|h_sw[9]|l_sw[0]|l_sw[10]|l_sw[1]|l_sw[2]|l_sw[3]|l_sw[4]|l_sw[5]|l_sw[6]|l_sw[7]|l_sw[8]|l_sw[9]|vc|vdd|vss|z
+ in_l_sw[4]|x
+ BOTTOM|TOP|h_sw[0]|h_sw[10]|h_sw[1]|h_sw[2]|h_sw[3]|h_sw[4]|h_sw[5]|h_sw[6]|h_sw[7]|h_sw[8]|h_sw[9]|l_sw[0]|l_sw[10]|l_sw[1]|l_sw[2]|l_sw[3]|l_sw[4]|l_sw[5]|l_sw[6]|l_sw[7]|l_sw[8]|l_sw[9]|vc|vdd|vss|z
+ \$10 sg13_lv_pmos L=0.13u W=1u AS=0.19p AD=0.19p PS=1.38u PD=1.38u rfmode=0
M$371
+ BOTTOM|TOP|h_sw[0]|h_sw[10]|h_sw[1]|h_sw[2]|h_sw[3]|h_sw[4]|h_sw[5]|h_sw[6]|h_sw[7]|h_sw[8]|h_sw[9]|l_sw[0]|l_sw[10]|l_sw[1]|l_sw[2]|l_sw[3]|l_sw[4]|l_sw[5]|l_sw[6]|l_sw[7]|l_sw[8]|l_sw[9]|vc|vdd|vss|z
+ in_l_sw[4]|x
+ BOTTOM|TOP|h_sw[0]|h_sw[10]|h_sw[1]|h_sw[2]|h_sw[3]|h_sw[4]|h_sw[5]|h_sw[6]|h_sw[7]|h_sw[8]|h_sw[9]|l_sw[0]|l_sw[10]|l_sw[1]|l_sw[2]|l_sw[3]|l_sw[4]|l_sw[5]|l_sw[6]|l_sw[7]|l_sw[8]|l_sw[9]|vc|vdd|vss|z
+ \$10 sg13_lv_pmos L=0.13u W=1u AS=0.19p AD=0.19p PS=1.38u PD=1.38u rfmode=0
M$372
+ BOTTOM|TOP|h_sw[0]|h_sw[10]|h_sw[1]|h_sw[2]|h_sw[3]|h_sw[4]|h_sw[5]|h_sw[6]|h_sw[7]|h_sw[8]|h_sw[9]|l_sw[0]|l_sw[10]|l_sw[1]|l_sw[2]|l_sw[3]|l_sw[4]|l_sw[5]|l_sw[6]|l_sw[7]|l_sw[8]|l_sw[9]|vc|vdd|vss|z
+ in_l_sw[4]|x
+ BOTTOM|TOP|h_sw[0]|h_sw[10]|h_sw[1]|h_sw[2]|h_sw[3]|h_sw[4]|h_sw[5]|h_sw[6]|h_sw[7]|h_sw[8]|h_sw[9]|l_sw[0]|l_sw[10]|l_sw[1]|l_sw[2]|l_sw[3]|l_sw[4]|l_sw[5]|l_sw[6]|l_sw[7]|l_sw[8]|l_sw[9]|vc|vdd|vss|z
+ \$10 sg13_lv_pmos L=0.13u W=1u AS=0.19p AD=0.19p PS=1.38u PD=1.38u rfmode=0
M$373
+ BOTTOM|TOP|h_sw[0]|h_sw[10]|h_sw[1]|h_sw[2]|h_sw[3]|h_sw[4]|h_sw[5]|h_sw[6]|h_sw[7]|h_sw[8]|h_sw[9]|l_sw[0]|l_sw[10]|l_sw[1]|l_sw[2]|l_sw[3]|l_sw[4]|l_sw[5]|l_sw[6]|l_sw[7]|l_sw[8]|l_sw[9]|vc|vdd|vss|z
+ in_l_sw[4]|x
+ BOTTOM|TOP|h_sw[0]|h_sw[10]|h_sw[1]|h_sw[2]|h_sw[3]|h_sw[4]|h_sw[5]|h_sw[6]|h_sw[7]|h_sw[8]|h_sw[9]|l_sw[0]|l_sw[10]|l_sw[1]|l_sw[2]|l_sw[3]|l_sw[4]|l_sw[5]|l_sw[6]|l_sw[7]|l_sw[8]|l_sw[9]|vc|vdd|vss|z
+ \$10 sg13_lv_pmos L=0.13u W=1u AS=0.19p AD=0.19p PS=1.38u PD=1.38u rfmode=0
M$374
+ BOTTOM|TOP|h_sw[0]|h_sw[10]|h_sw[1]|h_sw[2]|h_sw[3]|h_sw[4]|h_sw[5]|h_sw[6]|h_sw[7]|h_sw[8]|h_sw[9]|l_sw[0]|l_sw[10]|l_sw[1]|l_sw[2]|l_sw[3]|l_sw[4]|l_sw[5]|l_sw[6]|l_sw[7]|l_sw[8]|l_sw[9]|vc|vdd|vss|z
+ in_l_sw[4]|x
+ BOTTOM|TOP|h_sw[0]|h_sw[10]|h_sw[1]|h_sw[2]|h_sw[3]|h_sw[4]|h_sw[5]|h_sw[6]|h_sw[7]|h_sw[8]|h_sw[9]|l_sw[0]|l_sw[10]|l_sw[1]|l_sw[2]|l_sw[3]|l_sw[4]|l_sw[5]|l_sw[6]|l_sw[7]|l_sw[8]|l_sw[9]|vc|vdd|vss|z
+ \$10 sg13_lv_pmos L=0.13u W=1u AS=0.19p AD=0.34p PS=1.38u PD=2.68u rfmode=0
M$375
+ BOTTOM|TOP|h_sw[0]|h_sw[10]|h_sw[1]|h_sw[2]|h_sw[3]|h_sw[4]|h_sw[5]|h_sw[6]|h_sw[7]|h_sw[8]|h_sw[9]|l_sw[0]|l_sw[10]|l_sw[1]|l_sw[2]|l_sw[3]|l_sw[4]|l_sw[5]|l_sw[6]|l_sw[7]|l_sw[8]|l_sw[9]|vc|vdd|vss|z
+ in_l_sw[5]|x
+ BOTTOM|TOP|h_sw[0]|h_sw[10]|h_sw[1]|h_sw[2]|h_sw[3]|h_sw[4]|h_sw[5]|h_sw[6]|h_sw[7]|h_sw[8]|h_sw[9]|l_sw[0]|l_sw[10]|l_sw[1]|l_sw[2]|l_sw[3]|l_sw[4]|l_sw[5]|l_sw[6]|l_sw[7]|l_sw[8]|l_sw[9]|vc|vdd|vss|z
+ \$11 sg13_lv_pmos L=0.13u W=1u AS=0.34p AD=0.19p PS=2.68u PD=1.38u rfmode=0
M$376
+ BOTTOM|TOP|h_sw[0]|h_sw[10]|h_sw[1]|h_sw[2]|h_sw[3]|h_sw[4]|h_sw[5]|h_sw[6]|h_sw[7]|h_sw[8]|h_sw[9]|l_sw[0]|l_sw[10]|l_sw[1]|l_sw[2]|l_sw[3]|l_sw[4]|l_sw[5]|l_sw[6]|l_sw[7]|l_sw[8]|l_sw[9]|vc|vdd|vss|z
+ in_l_sw[5]|x
+ BOTTOM|TOP|h_sw[0]|h_sw[10]|h_sw[1]|h_sw[2]|h_sw[3]|h_sw[4]|h_sw[5]|h_sw[6]|h_sw[7]|h_sw[8]|h_sw[9]|l_sw[0]|l_sw[10]|l_sw[1]|l_sw[2]|l_sw[3]|l_sw[4]|l_sw[5]|l_sw[6]|l_sw[7]|l_sw[8]|l_sw[9]|vc|vdd|vss|z
+ \$11 sg13_lv_pmos L=0.13u W=1u AS=0.19p AD=0.19p PS=1.38u PD=1.38u rfmode=0
M$377
+ BOTTOM|TOP|h_sw[0]|h_sw[10]|h_sw[1]|h_sw[2]|h_sw[3]|h_sw[4]|h_sw[5]|h_sw[6]|h_sw[7]|h_sw[8]|h_sw[9]|l_sw[0]|l_sw[10]|l_sw[1]|l_sw[2]|l_sw[3]|l_sw[4]|l_sw[5]|l_sw[6]|l_sw[7]|l_sw[8]|l_sw[9]|vc|vdd|vss|z
+ in_l_sw[5]|x
+ BOTTOM|TOP|h_sw[0]|h_sw[10]|h_sw[1]|h_sw[2]|h_sw[3]|h_sw[4]|h_sw[5]|h_sw[6]|h_sw[7]|h_sw[8]|h_sw[9]|l_sw[0]|l_sw[10]|l_sw[1]|l_sw[2]|l_sw[3]|l_sw[4]|l_sw[5]|l_sw[6]|l_sw[7]|l_sw[8]|l_sw[9]|vc|vdd|vss|z
+ \$11 sg13_lv_pmos L=0.13u W=1u AS=0.19p AD=0.19p PS=1.38u PD=1.38u rfmode=0
M$378
+ BOTTOM|TOP|h_sw[0]|h_sw[10]|h_sw[1]|h_sw[2]|h_sw[3]|h_sw[4]|h_sw[5]|h_sw[6]|h_sw[7]|h_sw[8]|h_sw[9]|l_sw[0]|l_sw[10]|l_sw[1]|l_sw[2]|l_sw[3]|l_sw[4]|l_sw[5]|l_sw[6]|l_sw[7]|l_sw[8]|l_sw[9]|vc|vdd|vss|z
+ in_l_sw[5]|x
+ BOTTOM|TOP|h_sw[0]|h_sw[10]|h_sw[1]|h_sw[2]|h_sw[3]|h_sw[4]|h_sw[5]|h_sw[6]|h_sw[7]|h_sw[8]|h_sw[9]|l_sw[0]|l_sw[10]|l_sw[1]|l_sw[2]|l_sw[3]|l_sw[4]|l_sw[5]|l_sw[6]|l_sw[7]|l_sw[8]|l_sw[9]|vc|vdd|vss|z
+ \$11 sg13_lv_pmos L=0.13u W=1u AS=0.19p AD=0.19p PS=1.38u PD=1.38u rfmode=0
M$379
+ BOTTOM|TOP|h_sw[0]|h_sw[10]|h_sw[1]|h_sw[2]|h_sw[3]|h_sw[4]|h_sw[5]|h_sw[6]|h_sw[7]|h_sw[8]|h_sw[9]|l_sw[0]|l_sw[10]|l_sw[1]|l_sw[2]|l_sw[3]|l_sw[4]|l_sw[5]|l_sw[6]|l_sw[7]|l_sw[8]|l_sw[9]|vc|vdd|vss|z
+ in_l_sw[5]|x
+ BOTTOM|TOP|h_sw[0]|h_sw[10]|h_sw[1]|h_sw[2]|h_sw[3]|h_sw[4]|h_sw[5]|h_sw[6]|h_sw[7]|h_sw[8]|h_sw[9]|l_sw[0]|l_sw[10]|l_sw[1]|l_sw[2]|l_sw[3]|l_sw[4]|l_sw[5]|l_sw[6]|l_sw[7]|l_sw[8]|l_sw[9]|vc|vdd|vss|z
+ \$11 sg13_lv_pmos L=0.13u W=1u AS=0.19p AD=0.19p PS=1.38u PD=1.38u rfmode=0
M$380
+ BOTTOM|TOP|h_sw[0]|h_sw[10]|h_sw[1]|h_sw[2]|h_sw[3]|h_sw[4]|h_sw[5]|h_sw[6]|h_sw[7]|h_sw[8]|h_sw[9]|l_sw[0]|l_sw[10]|l_sw[1]|l_sw[2]|l_sw[3]|l_sw[4]|l_sw[5]|l_sw[6]|l_sw[7]|l_sw[8]|l_sw[9]|vc|vdd|vss|z
+ in_l_sw[5]|x
+ BOTTOM|TOP|h_sw[0]|h_sw[10]|h_sw[1]|h_sw[2]|h_sw[3]|h_sw[4]|h_sw[5]|h_sw[6]|h_sw[7]|h_sw[8]|h_sw[9]|l_sw[0]|l_sw[10]|l_sw[1]|l_sw[2]|l_sw[3]|l_sw[4]|l_sw[5]|l_sw[6]|l_sw[7]|l_sw[8]|l_sw[9]|vc|vdd|vss|z
+ \$11 sg13_lv_pmos L=0.13u W=1u AS=0.19p AD=0.19p PS=1.38u PD=1.38u rfmode=0
M$381
+ BOTTOM|TOP|h_sw[0]|h_sw[10]|h_sw[1]|h_sw[2]|h_sw[3]|h_sw[4]|h_sw[5]|h_sw[6]|h_sw[7]|h_sw[8]|h_sw[9]|l_sw[0]|l_sw[10]|l_sw[1]|l_sw[2]|l_sw[3]|l_sw[4]|l_sw[5]|l_sw[6]|l_sw[7]|l_sw[8]|l_sw[9]|vc|vdd|vss|z
+ in_l_sw[5]|x
+ BOTTOM|TOP|h_sw[0]|h_sw[10]|h_sw[1]|h_sw[2]|h_sw[3]|h_sw[4]|h_sw[5]|h_sw[6]|h_sw[7]|h_sw[8]|h_sw[9]|l_sw[0]|l_sw[10]|l_sw[1]|l_sw[2]|l_sw[3]|l_sw[4]|l_sw[5]|l_sw[6]|l_sw[7]|l_sw[8]|l_sw[9]|vc|vdd|vss|z
+ \$11 sg13_lv_pmos L=0.13u W=1u AS=0.19p AD=0.19p PS=1.38u PD=1.38u rfmode=0
M$382
+ BOTTOM|TOP|h_sw[0]|h_sw[10]|h_sw[1]|h_sw[2]|h_sw[3]|h_sw[4]|h_sw[5]|h_sw[6]|h_sw[7]|h_sw[8]|h_sw[9]|l_sw[0]|l_sw[10]|l_sw[1]|l_sw[2]|l_sw[3]|l_sw[4]|l_sw[5]|l_sw[6]|l_sw[7]|l_sw[8]|l_sw[9]|vc|vdd|vss|z
+ in_l_sw[5]|x
+ BOTTOM|TOP|h_sw[0]|h_sw[10]|h_sw[1]|h_sw[2]|h_sw[3]|h_sw[4]|h_sw[5]|h_sw[6]|h_sw[7]|h_sw[8]|h_sw[9]|l_sw[0]|l_sw[10]|l_sw[1]|l_sw[2]|l_sw[3]|l_sw[4]|l_sw[5]|l_sw[6]|l_sw[7]|l_sw[8]|l_sw[9]|vc|vdd|vss|z
+ \$11 sg13_lv_pmos L=0.13u W=1u AS=0.19p AD=0.34p PS=1.38u PD=2.68u rfmode=0
M$383
+ BOTTOM|TOP|h_sw[0]|h_sw[10]|h_sw[1]|h_sw[2]|h_sw[3]|h_sw[4]|h_sw[5]|h_sw[6]|h_sw[7]|h_sw[8]|h_sw[9]|l_sw[0]|l_sw[10]|l_sw[1]|l_sw[2]|l_sw[3]|l_sw[4]|l_sw[5]|l_sw[6]|l_sw[7]|l_sw[8]|l_sw[9]|vc|vdd|vss|z
+ in_h_sw[10]|x
+ BOTTOM|TOP|h_sw[0]|h_sw[10]|h_sw[1]|h_sw[2]|h_sw[3]|h_sw[4]|h_sw[5]|h_sw[6]|h_sw[7]|h_sw[8]|h_sw[9]|l_sw[0]|l_sw[10]|l_sw[1]|l_sw[2]|l_sw[3]|l_sw[4]|l_sw[5]|l_sw[6]|l_sw[7]|l_sw[8]|l_sw[9]|vc|vdd|vss|z
+ \$48 sg13_lv_pmos L=0.13u W=1u AS=0.34p AD=0.34p PS=2.68u PD=2.68u rfmode=0
M$384
+ BOTTOM|TOP|h_sw[0]|h_sw[10]|h_sw[1]|h_sw[2]|h_sw[3]|h_sw[4]|h_sw[5]|h_sw[6]|h_sw[7]|h_sw[8]|h_sw[9]|l_sw[0]|l_sw[10]|l_sw[1]|l_sw[2]|l_sw[3]|l_sw[4]|l_sw[5]|l_sw[6]|l_sw[7]|l_sw[8]|l_sw[9]|vc|vdd|vss|z
+ in_l_sw[3]|x
+ BOTTOM|TOP|h_sw[0]|h_sw[10]|h_sw[1]|h_sw[2]|h_sw[3]|h_sw[4]|h_sw[5]|h_sw[6]|h_sw[7]|h_sw[8]|h_sw[9]|l_sw[0]|l_sw[10]|l_sw[1]|l_sw[2]|l_sw[3]|l_sw[4]|l_sw[5]|l_sw[6]|l_sw[7]|l_sw[8]|l_sw[9]|vc|vdd|vss|z
+ \$10 sg13_lv_pmos L=0.13u W=1u AS=0.34p AD=0.19p PS=2.68u PD=1.38u rfmode=0
M$385
+ BOTTOM|TOP|h_sw[0]|h_sw[10]|h_sw[1]|h_sw[2]|h_sw[3]|h_sw[4]|h_sw[5]|h_sw[6]|h_sw[7]|h_sw[8]|h_sw[9]|l_sw[0]|l_sw[10]|l_sw[1]|l_sw[2]|l_sw[3]|l_sw[4]|l_sw[5]|l_sw[6]|l_sw[7]|l_sw[8]|l_sw[9]|vc|vdd|vss|z
+ in_l_sw[3]|x
+ BOTTOM|TOP|h_sw[0]|h_sw[10]|h_sw[1]|h_sw[2]|h_sw[3]|h_sw[4]|h_sw[5]|h_sw[6]|h_sw[7]|h_sw[8]|h_sw[9]|l_sw[0]|l_sw[10]|l_sw[1]|l_sw[2]|l_sw[3]|l_sw[4]|l_sw[5]|l_sw[6]|l_sw[7]|l_sw[8]|l_sw[9]|vc|vdd|vss|z
+ \$10 sg13_lv_pmos L=0.13u W=1u AS=0.19p AD=0.19p PS=1.38u PD=1.38u rfmode=0
M$386
+ BOTTOM|TOP|h_sw[0]|h_sw[10]|h_sw[1]|h_sw[2]|h_sw[3]|h_sw[4]|h_sw[5]|h_sw[6]|h_sw[7]|h_sw[8]|h_sw[9]|l_sw[0]|l_sw[10]|l_sw[1]|l_sw[2]|l_sw[3]|l_sw[4]|l_sw[5]|l_sw[6]|l_sw[7]|l_sw[8]|l_sw[9]|vc|vdd|vss|z
+ in_l_sw[3]|x
+ BOTTOM|TOP|h_sw[0]|h_sw[10]|h_sw[1]|h_sw[2]|h_sw[3]|h_sw[4]|h_sw[5]|h_sw[6]|h_sw[7]|h_sw[8]|h_sw[9]|l_sw[0]|l_sw[10]|l_sw[1]|l_sw[2]|l_sw[3]|l_sw[4]|l_sw[5]|l_sw[6]|l_sw[7]|l_sw[8]|l_sw[9]|vc|vdd|vss|z
+ \$10 sg13_lv_pmos L=0.13u W=1u AS=0.19p AD=0.19p PS=1.38u PD=1.38u rfmode=0
M$387
+ BOTTOM|TOP|h_sw[0]|h_sw[10]|h_sw[1]|h_sw[2]|h_sw[3]|h_sw[4]|h_sw[5]|h_sw[6]|h_sw[7]|h_sw[8]|h_sw[9]|l_sw[0]|l_sw[10]|l_sw[1]|l_sw[2]|l_sw[3]|l_sw[4]|l_sw[5]|l_sw[6]|l_sw[7]|l_sw[8]|l_sw[9]|vc|vdd|vss|z
+ in_l_sw[3]|x
+ BOTTOM|TOP|h_sw[0]|h_sw[10]|h_sw[1]|h_sw[2]|h_sw[3]|h_sw[4]|h_sw[5]|h_sw[6]|h_sw[7]|h_sw[8]|h_sw[9]|l_sw[0]|l_sw[10]|l_sw[1]|l_sw[2]|l_sw[3]|l_sw[4]|l_sw[5]|l_sw[6]|l_sw[7]|l_sw[8]|l_sw[9]|vc|vdd|vss|z
+ \$10 sg13_lv_pmos L=0.13u W=1u AS=0.19p AD=0.19p PS=1.38u PD=1.38u rfmode=0
M$388
+ BOTTOM|TOP|h_sw[0]|h_sw[10]|h_sw[1]|h_sw[2]|h_sw[3]|h_sw[4]|h_sw[5]|h_sw[6]|h_sw[7]|h_sw[8]|h_sw[9]|l_sw[0]|l_sw[10]|l_sw[1]|l_sw[2]|l_sw[3]|l_sw[4]|l_sw[5]|l_sw[6]|l_sw[7]|l_sw[8]|l_sw[9]|vc|vdd|vss|z
+ in_l_sw[3]|x
+ BOTTOM|TOP|h_sw[0]|h_sw[10]|h_sw[1]|h_sw[2]|h_sw[3]|h_sw[4]|h_sw[5]|h_sw[6]|h_sw[7]|h_sw[8]|h_sw[9]|l_sw[0]|l_sw[10]|l_sw[1]|l_sw[2]|l_sw[3]|l_sw[4]|l_sw[5]|l_sw[6]|l_sw[7]|l_sw[8]|l_sw[9]|vc|vdd|vss|z
+ \$10 sg13_lv_pmos L=0.13u W=1u AS=0.19p AD=0.19p PS=1.38u PD=1.38u rfmode=0
M$389
+ BOTTOM|TOP|h_sw[0]|h_sw[10]|h_sw[1]|h_sw[2]|h_sw[3]|h_sw[4]|h_sw[5]|h_sw[6]|h_sw[7]|h_sw[8]|h_sw[9]|l_sw[0]|l_sw[10]|l_sw[1]|l_sw[2]|l_sw[3]|l_sw[4]|l_sw[5]|l_sw[6]|l_sw[7]|l_sw[8]|l_sw[9]|vc|vdd|vss|z
+ in_l_sw[3]|x
+ BOTTOM|TOP|h_sw[0]|h_sw[10]|h_sw[1]|h_sw[2]|h_sw[3]|h_sw[4]|h_sw[5]|h_sw[6]|h_sw[7]|h_sw[8]|h_sw[9]|l_sw[0]|l_sw[10]|l_sw[1]|l_sw[2]|l_sw[3]|l_sw[4]|l_sw[5]|l_sw[6]|l_sw[7]|l_sw[8]|l_sw[9]|vc|vdd|vss|z
+ \$10 sg13_lv_pmos L=0.13u W=1u AS=0.19p AD=0.19p PS=1.38u PD=1.38u rfmode=0
M$390
+ BOTTOM|TOP|h_sw[0]|h_sw[10]|h_sw[1]|h_sw[2]|h_sw[3]|h_sw[4]|h_sw[5]|h_sw[6]|h_sw[7]|h_sw[8]|h_sw[9]|l_sw[0]|l_sw[10]|l_sw[1]|l_sw[2]|l_sw[3]|l_sw[4]|l_sw[5]|l_sw[6]|l_sw[7]|l_sw[8]|l_sw[9]|vc|vdd|vss|z
+ in_l_sw[3]|x
+ BOTTOM|TOP|h_sw[0]|h_sw[10]|h_sw[1]|h_sw[2]|h_sw[3]|h_sw[4]|h_sw[5]|h_sw[6]|h_sw[7]|h_sw[8]|h_sw[9]|l_sw[0]|l_sw[10]|l_sw[1]|l_sw[2]|l_sw[3]|l_sw[4]|l_sw[5]|l_sw[6]|l_sw[7]|l_sw[8]|l_sw[9]|vc|vdd|vss|z
+ \$10 sg13_lv_pmos L=0.13u W=1u AS=0.19p AD=0.19p PS=1.38u PD=1.38u rfmode=0
M$391
+ BOTTOM|TOP|h_sw[0]|h_sw[10]|h_sw[1]|h_sw[2]|h_sw[3]|h_sw[4]|h_sw[5]|h_sw[6]|h_sw[7]|h_sw[8]|h_sw[9]|l_sw[0]|l_sw[10]|l_sw[1]|l_sw[2]|l_sw[3]|l_sw[4]|l_sw[5]|l_sw[6]|l_sw[7]|l_sw[8]|l_sw[9]|vc|vdd|vss|z
+ in_l_sw[3]|x
+ BOTTOM|TOP|h_sw[0]|h_sw[10]|h_sw[1]|h_sw[2]|h_sw[3]|h_sw[4]|h_sw[5]|h_sw[6]|h_sw[7]|h_sw[8]|h_sw[9]|l_sw[0]|l_sw[10]|l_sw[1]|l_sw[2]|l_sw[3]|l_sw[4]|l_sw[5]|l_sw[6]|l_sw[7]|l_sw[8]|l_sw[9]|vc|vdd|vss|z
+ \$10 sg13_lv_pmos L=0.13u W=1u AS=0.19p AD=0.34p PS=1.38u PD=2.68u rfmode=0
M$392
+ BOTTOM|TOP|h_sw[0]|h_sw[10]|h_sw[1]|h_sw[2]|h_sw[3]|h_sw[4]|h_sw[5]|h_sw[6]|h_sw[7]|h_sw[8]|h_sw[9]|l_sw[0]|l_sw[10]|l_sw[1]|l_sw[2]|l_sw[3]|l_sw[4]|l_sw[5]|l_sw[6]|l_sw[7]|l_sw[8]|l_sw[9]|vc|vdd|vss|z
+ in_l_sw[6]|x
+ BOTTOM|TOP|h_sw[0]|h_sw[10]|h_sw[1]|h_sw[2]|h_sw[3]|h_sw[4]|h_sw[5]|h_sw[6]|h_sw[7]|h_sw[8]|h_sw[9]|l_sw[0]|l_sw[10]|l_sw[1]|l_sw[2]|l_sw[3]|l_sw[4]|l_sw[5]|l_sw[6]|l_sw[7]|l_sw[8]|l_sw[9]|vc|vdd|vss|z
+ \$11 sg13_lv_pmos L=0.13u W=1u AS=0.34p AD=0.19p PS=2.68u PD=1.38u rfmode=0
M$393
+ BOTTOM|TOP|h_sw[0]|h_sw[10]|h_sw[1]|h_sw[2]|h_sw[3]|h_sw[4]|h_sw[5]|h_sw[6]|h_sw[7]|h_sw[8]|h_sw[9]|l_sw[0]|l_sw[10]|l_sw[1]|l_sw[2]|l_sw[3]|l_sw[4]|l_sw[5]|l_sw[6]|l_sw[7]|l_sw[8]|l_sw[9]|vc|vdd|vss|z
+ in_l_sw[6]|x
+ BOTTOM|TOP|h_sw[0]|h_sw[10]|h_sw[1]|h_sw[2]|h_sw[3]|h_sw[4]|h_sw[5]|h_sw[6]|h_sw[7]|h_sw[8]|h_sw[9]|l_sw[0]|l_sw[10]|l_sw[1]|l_sw[2]|l_sw[3]|l_sw[4]|l_sw[5]|l_sw[6]|l_sw[7]|l_sw[8]|l_sw[9]|vc|vdd|vss|z
+ \$11 sg13_lv_pmos L=0.13u W=1u AS=0.19p AD=0.19p PS=1.38u PD=1.38u rfmode=0
M$394
+ BOTTOM|TOP|h_sw[0]|h_sw[10]|h_sw[1]|h_sw[2]|h_sw[3]|h_sw[4]|h_sw[5]|h_sw[6]|h_sw[7]|h_sw[8]|h_sw[9]|l_sw[0]|l_sw[10]|l_sw[1]|l_sw[2]|l_sw[3]|l_sw[4]|l_sw[5]|l_sw[6]|l_sw[7]|l_sw[8]|l_sw[9]|vc|vdd|vss|z
+ in_l_sw[6]|x
+ BOTTOM|TOP|h_sw[0]|h_sw[10]|h_sw[1]|h_sw[2]|h_sw[3]|h_sw[4]|h_sw[5]|h_sw[6]|h_sw[7]|h_sw[8]|h_sw[9]|l_sw[0]|l_sw[10]|l_sw[1]|l_sw[2]|l_sw[3]|l_sw[4]|l_sw[5]|l_sw[6]|l_sw[7]|l_sw[8]|l_sw[9]|vc|vdd|vss|z
+ \$11 sg13_lv_pmos L=0.13u W=1u AS=0.19p AD=0.19p PS=1.38u PD=1.38u rfmode=0
M$395
+ BOTTOM|TOP|h_sw[0]|h_sw[10]|h_sw[1]|h_sw[2]|h_sw[3]|h_sw[4]|h_sw[5]|h_sw[6]|h_sw[7]|h_sw[8]|h_sw[9]|l_sw[0]|l_sw[10]|l_sw[1]|l_sw[2]|l_sw[3]|l_sw[4]|l_sw[5]|l_sw[6]|l_sw[7]|l_sw[8]|l_sw[9]|vc|vdd|vss|z
+ in_l_sw[6]|x
+ BOTTOM|TOP|h_sw[0]|h_sw[10]|h_sw[1]|h_sw[2]|h_sw[3]|h_sw[4]|h_sw[5]|h_sw[6]|h_sw[7]|h_sw[8]|h_sw[9]|l_sw[0]|l_sw[10]|l_sw[1]|l_sw[2]|l_sw[3]|l_sw[4]|l_sw[5]|l_sw[6]|l_sw[7]|l_sw[8]|l_sw[9]|vc|vdd|vss|z
+ \$11 sg13_lv_pmos L=0.13u W=1u AS=0.19p AD=0.34p PS=1.38u PD=2.68u rfmode=0
M$396
+ BOTTOM|TOP|h_sw[0]|h_sw[10]|h_sw[1]|h_sw[2]|h_sw[3]|h_sw[4]|h_sw[5]|h_sw[6]|h_sw[7]|h_sw[8]|h_sw[9]|l_sw[0]|l_sw[10]|l_sw[1]|l_sw[2]|l_sw[3]|l_sw[4]|l_sw[5]|l_sw[6]|l_sw[7]|l_sw[8]|l_sw[9]|vc|vdd|vss|z
+ in_l_sw[7]|x
+ BOTTOM|TOP|h_sw[0]|h_sw[10]|h_sw[1]|h_sw[2]|h_sw[3]|h_sw[4]|h_sw[5]|h_sw[6]|h_sw[7]|h_sw[8]|h_sw[9]|l_sw[0]|l_sw[10]|l_sw[1]|l_sw[2]|l_sw[3]|l_sw[4]|l_sw[5]|l_sw[6]|l_sw[7]|l_sw[8]|l_sw[9]|vc|vdd|vss|z
+ \$29 sg13_lv_pmos L=0.13u W=1u AS=0.34p AD=0.19p PS=2.68u PD=1.38u rfmode=0
M$397
+ BOTTOM|TOP|h_sw[0]|h_sw[10]|h_sw[1]|h_sw[2]|h_sw[3]|h_sw[4]|h_sw[5]|h_sw[6]|h_sw[7]|h_sw[8]|h_sw[9]|l_sw[0]|l_sw[10]|l_sw[1]|l_sw[2]|l_sw[3]|l_sw[4]|l_sw[5]|l_sw[6]|l_sw[7]|l_sw[8]|l_sw[9]|vc|vdd|vss|z
+ in_l_sw[7]|x
+ BOTTOM|TOP|h_sw[0]|h_sw[10]|h_sw[1]|h_sw[2]|h_sw[3]|h_sw[4]|h_sw[5]|h_sw[6]|h_sw[7]|h_sw[8]|h_sw[9]|l_sw[0]|l_sw[10]|l_sw[1]|l_sw[2]|l_sw[3]|l_sw[4]|l_sw[5]|l_sw[6]|l_sw[7]|l_sw[8]|l_sw[9]|vc|vdd|vss|z
+ \$29 sg13_lv_pmos L=0.13u W=1u AS=0.19p AD=0.19p PS=1.38u PD=1.38u rfmode=0
M$398
+ BOTTOM|TOP|h_sw[0]|h_sw[10]|h_sw[1]|h_sw[2]|h_sw[3]|h_sw[4]|h_sw[5]|h_sw[6]|h_sw[7]|h_sw[8]|h_sw[9]|l_sw[0]|l_sw[10]|l_sw[1]|l_sw[2]|l_sw[3]|l_sw[4]|l_sw[5]|l_sw[6]|l_sw[7]|l_sw[8]|l_sw[9]|vc|vdd|vss|z
+ in_l_sw[7]|x
+ BOTTOM|TOP|h_sw[0]|h_sw[10]|h_sw[1]|h_sw[2]|h_sw[3]|h_sw[4]|h_sw[5]|h_sw[6]|h_sw[7]|h_sw[8]|h_sw[9]|l_sw[0]|l_sw[10]|l_sw[1]|l_sw[2]|l_sw[3]|l_sw[4]|l_sw[5]|l_sw[6]|l_sw[7]|l_sw[8]|l_sw[9]|vc|vdd|vss|z
+ \$29 sg13_lv_pmos L=0.13u W=1u AS=0.19p AD=0.19p PS=1.38u PD=1.38u rfmode=0
M$399
+ BOTTOM|TOP|h_sw[0]|h_sw[10]|h_sw[1]|h_sw[2]|h_sw[3]|h_sw[4]|h_sw[5]|h_sw[6]|h_sw[7]|h_sw[8]|h_sw[9]|l_sw[0]|l_sw[10]|l_sw[1]|l_sw[2]|l_sw[3]|l_sw[4]|l_sw[5]|l_sw[6]|l_sw[7]|l_sw[8]|l_sw[9]|vc|vdd|vss|z
+ in_l_sw[7]|x
+ BOTTOM|TOP|h_sw[0]|h_sw[10]|h_sw[1]|h_sw[2]|h_sw[3]|h_sw[4]|h_sw[5]|h_sw[6]|h_sw[7]|h_sw[8]|h_sw[9]|l_sw[0]|l_sw[10]|l_sw[1]|l_sw[2]|l_sw[3]|l_sw[4]|l_sw[5]|l_sw[6]|l_sw[7]|l_sw[8]|l_sw[9]|vc|vdd|vss|z
+ \$29 sg13_lv_pmos L=0.13u W=1u AS=0.19p AD=0.34p PS=1.38u PD=2.68u rfmode=0
M$400
+ BOTTOM|TOP|h_sw[0]|h_sw[10]|h_sw[1]|h_sw[2]|h_sw[3]|h_sw[4]|h_sw[5]|h_sw[6]|h_sw[7]|h_sw[8]|h_sw[9]|l_sw[0]|l_sw[10]|l_sw[1]|l_sw[2]|l_sw[3]|l_sw[4]|l_sw[5]|l_sw[6]|l_sw[7]|l_sw[8]|l_sw[9]|vc|vdd|vss|z
+ in_l_sw[8]|x
+ BOTTOM|TOP|h_sw[0]|h_sw[10]|h_sw[1]|h_sw[2]|h_sw[3]|h_sw[4]|h_sw[5]|h_sw[6]|h_sw[7]|h_sw[8]|h_sw[9]|l_sw[0]|l_sw[10]|l_sw[1]|l_sw[2]|l_sw[3]|l_sw[4]|l_sw[5]|l_sw[6]|l_sw[7]|l_sw[8]|l_sw[9]|vc|vdd|vss|z
+ \$29 sg13_lv_pmos L=0.13u W=1u AS=0.34p AD=0.19p PS=2.68u PD=1.38u rfmode=0
M$401
+ BOTTOM|TOP|h_sw[0]|h_sw[10]|h_sw[1]|h_sw[2]|h_sw[3]|h_sw[4]|h_sw[5]|h_sw[6]|h_sw[7]|h_sw[8]|h_sw[9]|l_sw[0]|l_sw[10]|l_sw[1]|l_sw[2]|l_sw[3]|l_sw[4]|l_sw[5]|l_sw[6]|l_sw[7]|l_sw[8]|l_sw[9]|vc|vdd|vss|z
+ in_l_sw[8]|x
+ BOTTOM|TOP|h_sw[0]|h_sw[10]|h_sw[1]|h_sw[2]|h_sw[3]|h_sw[4]|h_sw[5]|h_sw[6]|h_sw[7]|h_sw[8]|h_sw[9]|l_sw[0]|l_sw[10]|l_sw[1]|l_sw[2]|l_sw[3]|l_sw[4]|l_sw[5]|l_sw[6]|l_sw[7]|l_sw[8]|l_sw[9]|vc|vdd|vss|z
+ \$29 sg13_lv_pmos L=0.13u W=1u AS=0.19p AD=0.34p PS=1.38u PD=2.68u rfmode=0
M$402
+ BOTTOM|TOP|h_sw[0]|h_sw[10]|h_sw[1]|h_sw[2]|h_sw[3]|h_sw[4]|h_sw[5]|h_sw[6]|h_sw[7]|h_sw[8]|h_sw[9]|l_sw[0]|l_sw[10]|l_sw[1]|l_sw[2]|l_sw[3]|l_sw[4]|l_sw[5]|l_sw[6]|l_sw[7]|l_sw[8]|l_sw[9]|vc|vdd|vss|z
+ in_l_sw[9]|x
+ BOTTOM|TOP|h_sw[0]|h_sw[10]|h_sw[1]|h_sw[2]|h_sw[3]|h_sw[4]|h_sw[5]|h_sw[6]|h_sw[7]|h_sw[8]|h_sw[9]|l_sw[0]|l_sw[10]|l_sw[1]|l_sw[2]|l_sw[3]|l_sw[4]|l_sw[5]|l_sw[6]|l_sw[7]|l_sw[8]|l_sw[9]|vc|vdd|vss|z
+ \$48 sg13_lv_pmos L=0.13u W=1u AS=0.34p AD=0.19p PS=2.68u PD=1.38u rfmode=0
M$403
+ BOTTOM|TOP|h_sw[0]|h_sw[10]|h_sw[1]|h_sw[2]|h_sw[3]|h_sw[4]|h_sw[5]|h_sw[6]|h_sw[7]|h_sw[8]|h_sw[9]|l_sw[0]|l_sw[10]|l_sw[1]|l_sw[2]|l_sw[3]|l_sw[4]|l_sw[5]|l_sw[6]|l_sw[7]|l_sw[8]|l_sw[9]|vc|vdd|vss|z
+ in_l_sw[9]|x
+ BOTTOM|TOP|h_sw[0]|h_sw[10]|h_sw[1]|h_sw[2]|h_sw[3]|h_sw[4]|h_sw[5]|h_sw[6]|h_sw[7]|h_sw[8]|h_sw[9]|l_sw[0]|l_sw[10]|l_sw[1]|l_sw[2]|l_sw[3]|l_sw[4]|l_sw[5]|l_sw[6]|l_sw[7]|l_sw[8]|l_sw[9]|vc|vdd|vss|z
+ \$48 sg13_lv_pmos L=0.13u W=1u AS=0.19p AD=0.34p PS=1.38u PD=2.68u rfmode=0
M$404
+ BOTTOM|TOP|h_sw[0]|h_sw[10]|h_sw[1]|h_sw[2]|h_sw[3]|h_sw[4]|h_sw[5]|h_sw[6]|h_sw[7]|h_sw[8]|h_sw[9]|l_sw[0]|l_sw[10]|l_sw[1]|l_sw[2]|l_sw[3]|l_sw[4]|l_sw[5]|l_sw[6]|l_sw[7]|l_sw[8]|l_sw[9]|vc|vdd|vss|z
+ in_l_sw[10]|x
+ BOTTOM|TOP|h_sw[0]|h_sw[10]|h_sw[1]|h_sw[2]|h_sw[3]|h_sw[4]|h_sw[5]|h_sw[6]|h_sw[7]|h_sw[8]|h_sw[9]|l_sw[0]|l_sw[10]|l_sw[1]|l_sw[2]|l_sw[3]|l_sw[4]|l_sw[5]|l_sw[6]|l_sw[7]|l_sw[8]|l_sw[9]|vc|vdd|vss|z
+ \$48 sg13_lv_pmos L=0.13u W=1u AS=0.34p AD=0.34p PS=2.68u PD=2.68u rfmode=0
R$406
+ BOTTOM|TOP|h_sw[0]|h_sw[10]|h_sw[1]|h_sw[2]|h_sw[3]|h_sw[4]|h_sw[5]|h_sw[6]|h_sw[7]|h_sw[8]|h_sw[9]|l_sw[0]|l_sw[10]|l_sw[1]|l_sw[2]|l_sw[3]|l_sw[4]|l_sw[5]|l_sw[6]|l_sw[7]|l_sw[8]|l_sw[9]|vc|vdd|vss|z
+ \$2 ntap1 A=13.356p P=89.04u
R$407
+ BOTTOM|TOP|h_sw[0]|h_sw[10]|h_sw[1]|h_sw[2]|h_sw[3]|h_sw[4]|h_sw[5]|h_sw[6]|h_sw[7]|h_sw[8]|h_sw[9]|l_sw[0]|l_sw[10]|l_sw[1]|l_sw[2]|l_sw[3]|l_sw[4]|l_sw[5]|l_sw[6]|l_sw[7]|l_sw[8]|l_sw[9]|vc|vdd|vss|z
+ \$2 ntap1 A=13.356p P=89.04u
R$408
+ BOTTOM|TOP|h_sw[0]|h_sw[10]|h_sw[1]|h_sw[2]|h_sw[3]|h_sw[4]|h_sw[5]|h_sw[6]|h_sw[7]|h_sw[8]|h_sw[9]|l_sw[0]|l_sw[10]|l_sw[1]|l_sw[2]|l_sw[3]|l_sw[4]|l_sw[5]|l_sw[6]|l_sw[7]|l_sw[8]|l_sw[9]|vc|vdd|vss|z
+ \$10 ntap1 A=6.012p P=40.08u
R$409
+ BOTTOM|TOP|h_sw[0]|h_sw[10]|h_sw[1]|h_sw[2]|h_sw[3]|h_sw[4]|h_sw[5]|h_sw[6]|h_sw[7]|h_sw[8]|h_sw[9]|l_sw[0]|l_sw[10]|l_sw[1]|l_sw[2]|l_sw[3]|l_sw[4]|l_sw[5]|l_sw[6]|l_sw[7]|l_sw[8]|l_sw[9]|vc|vdd|vss|z
+ \$10 ntap1 A=6.012p P=40.08u
R$410
+ BOTTOM|TOP|h_sw[0]|h_sw[10]|h_sw[1]|h_sw[2]|h_sw[3]|h_sw[4]|h_sw[5]|h_sw[6]|h_sw[7]|h_sw[8]|h_sw[9]|l_sw[0]|l_sw[10]|l_sw[1]|l_sw[2]|l_sw[3]|l_sw[4]|l_sw[5]|l_sw[6]|l_sw[7]|l_sw[8]|l_sw[9]|vc|vdd|vss|z
+ \$10 ntap1 A=6.012p P=40.08u
R$411
+ BOTTOM|TOP|h_sw[0]|h_sw[10]|h_sw[1]|h_sw[2]|h_sw[3]|h_sw[4]|h_sw[5]|h_sw[6]|h_sw[7]|h_sw[8]|h_sw[9]|l_sw[0]|l_sw[10]|l_sw[1]|l_sw[2]|l_sw[3]|l_sw[4]|l_sw[5]|l_sw[6]|l_sw[7]|l_sw[8]|l_sw[9]|vc|vdd|vss|z
+ \$10 ntap1 A=6.012p P=40.08u
R$412
+ BOTTOM|TOP|h_sw[0]|h_sw[10]|h_sw[1]|h_sw[2]|h_sw[3]|h_sw[4]|h_sw[5]|h_sw[6]|h_sw[7]|h_sw[8]|h_sw[9]|l_sw[0]|l_sw[10]|l_sw[1]|l_sw[2]|l_sw[3]|l_sw[4]|l_sw[5]|l_sw[6]|l_sw[7]|l_sw[8]|l_sw[9]|vc|vdd|vss|z
+ \$11 ntap1 A=6.012p P=40.08u
R$413
+ BOTTOM|TOP|h_sw[0]|h_sw[10]|h_sw[1]|h_sw[2]|h_sw[3]|h_sw[4]|h_sw[5]|h_sw[6]|h_sw[7]|h_sw[8]|h_sw[9]|l_sw[0]|l_sw[10]|l_sw[1]|l_sw[2]|l_sw[3]|l_sw[4]|l_sw[5]|l_sw[6]|l_sw[7]|l_sw[8]|l_sw[9]|vc|vdd|vss|z
+ \$11 ntap1 A=4.788p P=31.92u
R$414
+ BOTTOM|TOP|h_sw[0]|h_sw[10]|h_sw[1]|h_sw[2]|h_sw[3]|h_sw[4]|h_sw[5]|h_sw[6]|h_sw[7]|h_sw[8]|h_sw[9]|l_sw[0]|l_sw[10]|l_sw[1]|l_sw[2]|l_sw[3]|l_sw[4]|l_sw[5]|l_sw[6]|l_sw[7]|l_sw[8]|l_sw[9]|vc|vdd|vss|z
+ \$11 ntap1 A=6.012p P=40.08u
R$415
+ BOTTOM|TOP|h_sw[0]|h_sw[10]|h_sw[1]|h_sw[2]|h_sw[3]|h_sw[4]|h_sw[5]|h_sw[6]|h_sw[7]|h_sw[8]|h_sw[9]|l_sw[0]|l_sw[10]|l_sw[1]|l_sw[2]|l_sw[3]|l_sw[4]|l_sw[5]|l_sw[6]|l_sw[7]|l_sw[8]|l_sw[9]|vc|vdd|vss|z
+ \$11 ntap1 A=4.788p P=31.92u
R$416
+ BOTTOM|TOP|h_sw[0]|h_sw[10]|h_sw[1]|h_sw[2]|h_sw[3]|h_sw[4]|h_sw[5]|h_sw[6]|h_sw[7]|h_sw[8]|h_sw[9]|l_sw[0]|l_sw[10]|l_sw[1]|l_sw[2]|l_sw[3]|l_sw[4]|l_sw[5]|l_sw[6]|l_sw[7]|l_sw[8]|l_sw[9]|vc|vdd|vss|z
+ \$21 ntap1 A=8.46p P=56.4u
R$417
+ BOTTOM|TOP|h_sw[0]|h_sw[10]|h_sw[1]|h_sw[2]|h_sw[3]|h_sw[4]|h_sw[5]|h_sw[6]|h_sw[7]|h_sw[8]|h_sw[9]|l_sw[0]|l_sw[10]|l_sw[1]|l_sw[2]|l_sw[3]|l_sw[4]|l_sw[5]|l_sw[6]|l_sw[7]|l_sw[8]|l_sw[9]|vc|vdd|vss|z
+ \$21 ntap1 A=8.46p P=56.4u
R$418
+ BOTTOM|TOP|h_sw[0]|h_sw[10]|h_sw[1]|h_sw[2]|h_sw[3]|h_sw[4]|h_sw[5]|h_sw[6]|h_sw[7]|h_sw[8]|h_sw[9]|l_sw[0]|l_sw[10]|l_sw[1]|l_sw[2]|l_sw[3]|l_sw[4]|l_sw[5]|l_sw[6]|l_sw[7]|l_sw[8]|l_sw[9]|vc|vdd|vss|z
+ \$22 ntap1 A=8.46p P=56.4u
R$419
+ BOTTOM|TOP|h_sw[0]|h_sw[10]|h_sw[1]|h_sw[2]|h_sw[3]|h_sw[4]|h_sw[5]|h_sw[6]|h_sw[7]|h_sw[8]|h_sw[9]|l_sw[0]|l_sw[10]|l_sw[1]|l_sw[2]|l_sw[3]|l_sw[4]|l_sw[5]|l_sw[6]|l_sw[7]|l_sw[8]|l_sw[9]|vc|vdd|vss|z
+ \$22 ntap1 A=8.46p P=56.4u
R$420
+ BOTTOM|TOP|h_sw[0]|h_sw[10]|h_sw[1]|h_sw[2]|h_sw[3]|h_sw[4]|h_sw[5]|h_sw[6]|h_sw[7]|h_sw[8]|h_sw[9]|l_sw[0]|l_sw[10]|l_sw[1]|l_sw[2]|l_sw[3]|l_sw[4]|l_sw[5]|l_sw[6]|l_sw[7]|l_sw[8]|l_sw[9]|vc|vdd|vss|z
+ \$29 ntap1 A=4.788p P=31.92u
R$421
+ BOTTOM|TOP|h_sw[0]|h_sw[10]|h_sw[1]|h_sw[2]|h_sw[3]|h_sw[4]|h_sw[5]|h_sw[6]|h_sw[7]|h_sw[8]|h_sw[9]|l_sw[0]|l_sw[10]|l_sw[1]|l_sw[2]|l_sw[3]|l_sw[4]|l_sw[5]|l_sw[6]|l_sw[7]|l_sw[8]|l_sw[9]|vc|vdd|vss|z
+ \$29 ntap1 A=4.176p P=27.84u
R$422
+ BOTTOM|TOP|h_sw[0]|h_sw[10]|h_sw[1]|h_sw[2]|h_sw[3]|h_sw[4]|h_sw[5]|h_sw[6]|h_sw[7]|h_sw[8]|h_sw[9]|l_sw[0]|l_sw[10]|l_sw[1]|l_sw[2]|l_sw[3]|l_sw[4]|l_sw[5]|l_sw[6]|l_sw[7]|l_sw[8]|l_sw[9]|vc|vdd|vss|z
+ \$29 ntap1 A=4.788p P=31.92u
R$423
+ BOTTOM|TOP|h_sw[0]|h_sw[10]|h_sw[1]|h_sw[2]|h_sw[3]|h_sw[4]|h_sw[5]|h_sw[6]|h_sw[7]|h_sw[8]|h_sw[9]|l_sw[0]|l_sw[10]|l_sw[1]|l_sw[2]|l_sw[3]|l_sw[4]|l_sw[5]|l_sw[6]|l_sw[7]|l_sw[8]|l_sw[9]|vc|vdd|vss|z
+ \$29 ntap1 A=4.176p P=27.84u
R$424
+ BOTTOM|TOP|h_sw[0]|h_sw[10]|h_sw[1]|h_sw[2]|h_sw[3]|h_sw[4]|h_sw[5]|h_sw[6]|h_sw[7]|h_sw[8]|h_sw[9]|l_sw[0]|l_sw[10]|l_sw[1]|l_sw[2]|l_sw[3]|l_sw[4]|l_sw[5]|l_sw[6]|l_sw[7]|l_sw[8]|l_sw[9]|vc|vdd|vss|z
+ \$48 ntap1 A=4.176p P=27.84u
R$425
+ BOTTOM|TOP|h_sw[0]|h_sw[10]|h_sw[1]|h_sw[2]|h_sw[3]|h_sw[4]|h_sw[5]|h_sw[6]|h_sw[7]|h_sw[8]|h_sw[9]|l_sw[0]|l_sw[10]|l_sw[1]|l_sw[2]|l_sw[3]|l_sw[4]|l_sw[5]|l_sw[6]|l_sw[7]|l_sw[8]|l_sw[9]|vc|vdd|vss|z
+ \$48 ntap1 A=3.87p P=25.8u
R$426
+ BOTTOM|TOP|h_sw[0]|h_sw[10]|h_sw[1]|h_sw[2]|h_sw[3]|h_sw[4]|h_sw[5]|h_sw[6]|h_sw[7]|h_sw[8]|h_sw[9]|l_sw[0]|l_sw[10]|l_sw[1]|l_sw[2]|l_sw[3]|l_sw[4]|l_sw[5]|l_sw[6]|l_sw[7]|l_sw[8]|l_sw[9]|vc|vdd|vss|z
+ \$48 ntap1 A=4.176p P=27.84u
R$427
+ BOTTOM|TOP|h_sw[0]|h_sw[10]|h_sw[1]|h_sw[2]|h_sw[3]|h_sw[4]|h_sw[5]|h_sw[6]|h_sw[7]|h_sw[8]|h_sw[9]|l_sw[0]|l_sw[10]|l_sw[1]|l_sw[2]|l_sw[3]|l_sw[4]|l_sw[5]|l_sw[6]|l_sw[7]|l_sw[8]|l_sw[9]|vc|vdd|vss|z
+ \$48 ntap1 A=3.87p P=25.8u
R$428
+ BOTTOM|TOP|h_sw[0]|h_sw[10]|h_sw[1]|h_sw[2]|h_sw[3]|h_sw[4]|h_sw[5]|h_sw[6]|h_sw[7]|h_sw[8]|h_sw[9]|l_sw[0]|l_sw[10]|l_sw[1]|l_sw[2]|l_sw[3]|l_sw[4]|l_sw[5]|l_sw[6]|l_sw[7]|l_sw[8]|l_sw[9]|vc|vdd|vss|z
+ \$1 ptap1 A=12.528p P=83.52u
R$429
+ BOTTOM|TOP|h_sw[0]|h_sw[10]|h_sw[1]|h_sw[2]|h_sw[3]|h_sw[4]|h_sw[5]|h_sw[6]|h_sw[7]|h_sw[8]|h_sw[9]|l_sw[0]|l_sw[10]|l_sw[1]|l_sw[2]|l_sw[3]|l_sw[4]|l_sw[5]|l_sw[6]|l_sw[7]|l_sw[8]|l_sw[9]|vc|vdd|vss|z
+ \$1 ptap1 A=12.528p P=83.52u
R$430
+ BOTTOM|TOP|h_sw[0]|h_sw[10]|h_sw[1]|h_sw[2]|h_sw[3]|h_sw[4]|h_sw[5]|h_sw[6]|h_sw[7]|h_sw[8]|h_sw[9]|l_sw[0]|l_sw[10]|l_sw[1]|l_sw[2]|l_sw[3]|l_sw[4]|l_sw[5]|l_sw[6]|l_sw[7]|l_sw[8]|l_sw[9]|vc|vdd|vss|z
+ \$1 ptap1 A=5.184p P=34.56u
R$431
+ BOTTOM|TOP|h_sw[0]|h_sw[10]|h_sw[1]|h_sw[2]|h_sw[3]|h_sw[4]|h_sw[5]|h_sw[6]|h_sw[7]|h_sw[8]|h_sw[9]|l_sw[0]|l_sw[10]|l_sw[1]|l_sw[2]|l_sw[3]|l_sw[4]|l_sw[5]|l_sw[6]|l_sw[7]|l_sw[8]|l_sw[9]|vc|vdd|vss|z
+ \$1 ptap1 A=5.184p P=34.56u
R$432
+ BOTTOM|TOP|h_sw[0]|h_sw[10]|h_sw[1]|h_sw[2]|h_sw[3]|h_sw[4]|h_sw[5]|h_sw[6]|h_sw[7]|h_sw[8]|h_sw[9]|l_sw[0]|l_sw[10]|l_sw[1]|l_sw[2]|l_sw[3]|l_sw[4]|l_sw[5]|l_sw[6]|l_sw[7]|l_sw[8]|l_sw[9]|vc|vdd|vss|z
+ \$1 ptap1 A=5.184p P=34.56u
R$433
+ BOTTOM|TOP|h_sw[0]|h_sw[10]|h_sw[1]|h_sw[2]|h_sw[3]|h_sw[4]|h_sw[5]|h_sw[6]|h_sw[7]|h_sw[8]|h_sw[9]|l_sw[0]|l_sw[10]|l_sw[1]|l_sw[2]|l_sw[3]|l_sw[4]|l_sw[5]|l_sw[6]|l_sw[7]|l_sw[8]|l_sw[9]|vc|vdd|vss|z
+ \$1 ptap1 A=7.632p P=50.88u
R$434
+ BOTTOM|TOP|h_sw[0]|h_sw[10]|h_sw[1]|h_sw[2]|h_sw[3]|h_sw[4]|h_sw[5]|h_sw[6]|h_sw[7]|h_sw[8]|h_sw[9]|l_sw[0]|l_sw[10]|l_sw[1]|l_sw[2]|l_sw[3]|l_sw[4]|l_sw[5]|l_sw[6]|l_sw[7]|l_sw[8]|l_sw[9]|vc|vdd|vss|z
+ \$1 ptap1 A=7.632p P=50.88u
R$435
+ BOTTOM|TOP|h_sw[0]|h_sw[10]|h_sw[1]|h_sw[2]|h_sw[3]|h_sw[4]|h_sw[5]|h_sw[6]|h_sw[7]|h_sw[8]|h_sw[9]|l_sw[0]|l_sw[10]|l_sw[1]|l_sw[2]|l_sw[3]|l_sw[4]|l_sw[5]|l_sw[6]|l_sw[7]|l_sw[8]|l_sw[9]|vc|vdd|vss|z
+ \$1 ptap1 A=7.632p P=50.88u
R$436
+ BOTTOM|TOP|h_sw[0]|h_sw[10]|h_sw[1]|h_sw[2]|h_sw[3]|h_sw[4]|h_sw[5]|h_sw[6]|h_sw[7]|h_sw[8]|h_sw[9]|l_sw[0]|l_sw[10]|l_sw[1]|l_sw[2]|l_sw[3]|l_sw[4]|l_sw[5]|l_sw[6]|l_sw[7]|l_sw[8]|l_sw[9]|vc|vdd|vss|z
+ \$1 ptap1 A=7.632p P=50.88u
R$437
+ BOTTOM|TOP|h_sw[0]|h_sw[10]|h_sw[1]|h_sw[2]|h_sw[3]|h_sw[4]|h_sw[5]|h_sw[6]|h_sw[7]|h_sw[8]|h_sw[9]|l_sw[0]|l_sw[10]|l_sw[1]|l_sw[2]|l_sw[3]|l_sw[4]|l_sw[5]|l_sw[6]|l_sw[7]|l_sw[8]|l_sw[9]|vc|vdd|vss|z
+ \$1 ptap1 A=3.96p P=26.4u
R$438
+ BOTTOM|TOP|h_sw[0]|h_sw[10]|h_sw[1]|h_sw[2]|h_sw[3]|h_sw[4]|h_sw[5]|h_sw[6]|h_sw[7]|h_sw[8]|h_sw[9]|l_sw[0]|l_sw[10]|l_sw[1]|l_sw[2]|l_sw[3]|l_sw[4]|l_sw[5]|l_sw[6]|l_sw[7]|l_sw[8]|l_sw[9]|vc|vdd|vss|z
+ \$1 ptap1 A=3.96p P=26.4u
R$439
+ BOTTOM|TOP|h_sw[0]|h_sw[10]|h_sw[1]|h_sw[2]|h_sw[3]|h_sw[4]|h_sw[5]|h_sw[6]|h_sw[7]|h_sw[8]|h_sw[9]|l_sw[0]|l_sw[10]|l_sw[1]|l_sw[2]|l_sw[3]|l_sw[4]|l_sw[5]|l_sw[6]|l_sw[7]|l_sw[8]|l_sw[9]|vc|vdd|vss|z
+ \$1 ptap1 A=5.184p P=34.56u
R$440
+ BOTTOM|TOP|h_sw[0]|h_sw[10]|h_sw[1]|h_sw[2]|h_sw[3]|h_sw[4]|h_sw[5]|h_sw[6]|h_sw[7]|h_sw[8]|h_sw[9]|l_sw[0]|l_sw[10]|l_sw[1]|l_sw[2]|l_sw[3]|l_sw[4]|l_sw[5]|l_sw[6]|l_sw[7]|l_sw[8]|l_sw[9]|vc|vdd|vss|z
+ \$1 ptap1 A=5.184p P=34.56u
R$441
+ BOTTOM|TOP|h_sw[0]|h_sw[10]|h_sw[1]|h_sw[2]|h_sw[3]|h_sw[4]|h_sw[5]|h_sw[6]|h_sw[7]|h_sw[8]|h_sw[9]|l_sw[0]|l_sw[10]|l_sw[1]|l_sw[2]|l_sw[3]|l_sw[4]|l_sw[5]|l_sw[6]|l_sw[7]|l_sw[8]|l_sw[9]|vc|vdd|vss|z
+ \$1 ptap1 A=5.184p P=34.56u
R$442
+ BOTTOM|TOP|h_sw[0]|h_sw[10]|h_sw[1]|h_sw[2]|h_sw[3]|h_sw[4]|h_sw[5]|h_sw[6]|h_sw[7]|h_sw[8]|h_sw[9]|l_sw[0]|l_sw[10]|l_sw[1]|l_sw[2]|l_sw[3]|l_sw[4]|l_sw[5]|l_sw[6]|l_sw[7]|l_sw[8]|l_sw[9]|vc|vdd|vss|z
+ \$1 ptap1 A=3.348p P=22.32u
R$443
+ BOTTOM|TOP|h_sw[0]|h_sw[10]|h_sw[1]|h_sw[2]|h_sw[3]|h_sw[4]|h_sw[5]|h_sw[6]|h_sw[7]|h_sw[8]|h_sw[9]|l_sw[0]|l_sw[10]|l_sw[1]|l_sw[2]|l_sw[3]|l_sw[4]|l_sw[5]|l_sw[6]|l_sw[7]|l_sw[8]|l_sw[9]|vc|vdd|vss|z
+ \$1 ptap1 A=3.348p P=22.32u
R$444
+ BOTTOM|TOP|h_sw[0]|h_sw[10]|h_sw[1]|h_sw[2]|h_sw[3]|h_sw[4]|h_sw[5]|h_sw[6]|h_sw[7]|h_sw[8]|h_sw[9]|l_sw[0]|l_sw[10]|l_sw[1]|l_sw[2]|l_sw[3]|l_sw[4]|l_sw[5]|l_sw[6]|l_sw[7]|l_sw[8]|l_sw[9]|vc|vdd|vss|z
+ \$1 ptap1 A=3.042p P=20.28u
R$445
+ BOTTOM|TOP|h_sw[0]|h_sw[10]|h_sw[1]|h_sw[2]|h_sw[3]|h_sw[4]|h_sw[5]|h_sw[6]|h_sw[7]|h_sw[8]|h_sw[9]|l_sw[0]|l_sw[10]|l_sw[1]|l_sw[2]|l_sw[3]|l_sw[4]|l_sw[5]|l_sw[6]|l_sw[7]|l_sw[8]|l_sw[9]|vc|vdd|vss|z
+ \$1 ptap1 A=3.96p P=26.4u
R$446
+ BOTTOM|TOP|h_sw[0]|h_sw[10]|h_sw[1]|h_sw[2]|h_sw[3]|h_sw[4]|h_sw[5]|h_sw[6]|h_sw[7]|h_sw[8]|h_sw[9]|l_sw[0]|l_sw[10]|l_sw[1]|l_sw[2]|l_sw[3]|l_sw[4]|l_sw[5]|l_sw[6]|l_sw[7]|l_sw[8]|l_sw[9]|vc|vdd|vss|z
+ \$1 ptap1 A=3.96p P=26.4u
R$447
+ BOTTOM|TOP|h_sw[0]|h_sw[10]|h_sw[1]|h_sw[2]|h_sw[3]|h_sw[4]|h_sw[5]|h_sw[6]|h_sw[7]|h_sw[8]|h_sw[9]|l_sw[0]|l_sw[10]|l_sw[1]|l_sw[2]|l_sw[3]|l_sw[4]|l_sw[5]|l_sw[6]|l_sw[7]|l_sw[8]|l_sw[9]|vc|vdd|vss|z
+ \$1 ptap1 A=3.348p P=22.32u
R$448
+ BOTTOM|TOP|h_sw[0]|h_sw[10]|h_sw[1]|h_sw[2]|h_sw[3]|h_sw[4]|h_sw[5]|h_sw[6]|h_sw[7]|h_sw[8]|h_sw[9]|l_sw[0]|l_sw[10]|l_sw[1]|l_sw[2]|l_sw[3]|l_sw[4]|l_sw[5]|l_sw[6]|l_sw[7]|l_sw[8]|l_sw[9]|vc|vdd|vss|z
+ \$1 ptap1 A=3.348p P=22.32u
R$449
+ BOTTOM|TOP|h_sw[0]|h_sw[10]|h_sw[1]|h_sw[2]|h_sw[3]|h_sw[4]|h_sw[5]|h_sw[6]|h_sw[7]|h_sw[8]|h_sw[9]|l_sw[0]|l_sw[10]|l_sw[1]|l_sw[2]|l_sw[3]|l_sw[4]|l_sw[5]|l_sw[6]|l_sw[7]|l_sw[8]|l_sw[9]|vc|vdd|vss|z
+ \$1 ptap1 A=3.042p P=20.28u
.ENDS side_cap8b
