* MSPHY9932 ref (per-instance iovss/iovdd)
.model sg13_lv_nmos nmos
.model sg13_lv_pmos pmos
.model sg13_hv_nmos nmos
.model sg13_hv_pmos pmos

.subckt MSPHY9932_ref vdd cks vip vin vddr data[0] data[1] data[2] cko frame
M0 SAR/a_15974_6162# SAR/sg13cmos5l_buf_1_57.X vdd vdd sg13_lv_pmos ad=79.8f pd=0.8u as=0.1428p ps=1.52u w=0.42u l=0.13u
M1 SAR/a_7440_1948# SAR/a_6889_1680# vdd vdd sg13_lv_pmos ad=0.105p pd=1.21u as=1.86162p ps=11.935u w=1u l=0.13u
M2 vdd SAR/sg13cmos5l_inv_1_27.Y SAR/a_14632_9224# vdd sg13_lv_pmos ad=0.2114p pd=1.54u as=0.2856p ps=2.36u w=0.84u l=0.13u
M3 vss SAR/a_7820_9150# SAR/sg13cmos5l_buf_1_73.X vss sg13_lv_nmos ad=0.14875p pd=1.16u as=0.2886p ps=2.26u w=0.74u l=0.13u
M4 vdd SAR/sg13cmos5l_dfrbp_1_6.RESET_B SAR/a_12490_6385# vdd sg13_lv_pmos ad=0.1563p pd=1.22u as=0.147p ps=1.54u w=0.42u l=0.13u
M5 vdd SAR/a_10473_9186# SAR/a_10406_9624# vdd sg13_lv_pmos ad=0.2387p pd=1.84u as=0.1008p ps=0.9u w=0.42u l=0.13u
M6 vss SAR/a_15429_7653# SAR/a_15531_7796# vss sg13_lv_nmos ad=1.49685p pd=9.6u as=0.2516p ps=2.16u w=0.74u l=0.13u
M7 vdd SAR/a_16940_3102# nh_sw[8] vdd sg13_lv_pmos ad=0.2114p pd=1.54u as=0.42p ps=2.99u w=1.12u l=0.13u
M8 vdd SAR/a_12976_2630# SAR/a_12921_2511# vdd sg13_lv_pmos ad=1.86162p pd=11.935u as=93.45f ps=0.865u w=0.42u l=0.13u
M9 SAR/sg13cmos5l_buf_1_44.A SAR/a_5673_3138# vss vss sg13_lv_nmos ad=0.2516p pd=2.16u as=0.1406p ps=1.12u w=0.74u l=0.13u
M10 SAR/a_13072_4142# SAR/a_12815_4261# SAR/a_13234_4338# vss sg13_lv_nmos ad=0.1428p pd=1.52u as=37.8f ps=0.6u w=0.42u l=0.13u
M11 vdd SAR/sg13cmos5l_inv_1_6.A SAR/sg13cmos5l_buf_1_0.A vdd sg13_lv_pmos ad=0.3808p pd=2.92u as=0.3808p ps=2.92u w=1.12u l=0.13u
M12 SAR/a_5104_4870# SAR/a_4847_4727# SAR/a_5266_4650# vss sg13_lv_nmos ad=0.1428p pd=1.52u as=37.8f ps=0.6u w=0.42u l=0.13u
M13 SAR/a_18615_5770# SAR/sg13cmos5l_dfrbp_1_8.D vss vss sg13_lv_nmos ad=0.2516p pd=2.16u as=0.15055p ps=1.17u w=0.74u l=0.13u
M14 SAR/a_11072_5347# SAR/sg13cmos5l_nor2_1_0.A vdd vdd sg13_lv_pmos ad=0.2856p pd=2.36u as=0.1596p ps=1.22u w=0.84u l=0.13u
M15 vdd SAR/sg13cmos5l_dfrbp_1_21.Q_N SAR/a_18793_6216# vdd sg13_lv_pmos ad=1.07253p pd=6.75u as=0.2856p ps=2.36u w=0.84u l=0.13u
M16 vdd SAR/a_14543_3215# SAR/a_15380_3436# vdd sg13_lv_pmos ad=0.2128p pd=1.5u as=0.3864p ps=2.93u w=1.12u l=0.13u
M17 pl_sw[5] SAR/a_7336_9224# vss vss sg13_lv_nmos ad=0.2886p pd=2.26u as=0.14875p ps=1.16u w=0.74u l=0.13u
M18 SAR/a_11973_1605# SAR/sg13cmos5l_dfrbp_1_0.CLK vss vss sg13_lv_nmos ad=0.2516p pd=2.16u as=5.84582p ps=38.34u w=0.74u l=0.13u
M19 vdd SAR/a_11973_3911# SAR/a_12075_3911# vdd sg13_lv_pmos ad=1.43437p pd=9.105u as=0.3864p ps=2.93u w=1.12u l=0.13u
M20 vss SAR/a_3407_8797# SAR/a_4244_8436# vss sg13_lv_nmos ad=0.1406p pd=1.12u as=0.2516p ps=2.16u w=0.74u l=0.13u
M21 vdd SAR/a_19209_5769# SAR/a_19734_5842# vdd sg13_lv_pmos ad=0.1974p pd=1.5u as=0.2856p ps=2.36u w=0.84u l=0.13u
M22 SAR/sg13cmos5l_dlhr_1_16.Q SAR/a_19209_5769# vss vss sg13_lv_nmos ad=0.2516p pd=2.16u as=0.1406p ps=1.12u w=0.74u l=0.13u
M23 vdd SAR/a_19340_8400# pl_sw[9] vdd sg13_lv_pmos ad=0.2114p pd=1.54u as=0.42p ps=2.99u w=1.12u l=0.13u
M24 SAR/sg13cmos5l_dlhr_1_2.D SAR/a_6479_2749# vss vss sg13_lv_nmos ad=0.2849p pd=2.25u as=0.2516p ps=2.16u w=0.74u l=0.13u
M25 SAR/a_13100_8400# SAR/sg13cmos5l_buf_1_90.X vss vss sg13_lv_nmos ad=0.187p pd=1.78u as=0.14875p ps=1.16u w=0.55u l=0.13u
M26 SAR/a_10071_7282# SAR/sg13cmos5l_dfrbp_1_18.Q vss vss sg13_lv_nmos ad=0.2516p pd=2.16u as=0.15055p ps=1.17u w=0.74u l=0.13u
M27 vdd SAR/a_10288_8678# SAR/a_10233_8559# vdd sg13_lv_pmos ad=1.15047p pd=7.175u as=93.45f ps=0.865u w=0.42u l=0.13u
M28 SAR/a_13701_3117# SAR/sg13cmos5l_dfrbp_1_0.CLK vss vss sg13_lv_nmos ad=0.2516p pd=2.16u as=2.43055p ps=15.415u w=0.74u l=0.13u
M29 SAR/a_1484_9150# SAR/sg13cmos5l_inv_1_19.A vss vss sg13_lv_nmos ad=0.187p pd=1.78u as=0.14875p ps=1.16u w=0.55u l=0.13u
M30 SAR/a_934_7349# SAR/sg13cmos5l_dfrbp_1_6.RESET_B vss vss sg13_lv_nmos ad=37.8f pd=0.6u as=0.1701p ps=1.65u w=0.42u l=0.13u
M31 vdd SAR/a_14889_7281# SAR/a_14822_6924# vdd sg13_lv_pmos ad=0.2387p pd=1.84u as=0.1008p ps=0.9u w=0.42u l=0.13u
M32 SAR/sg13cmos5l_buf_1_19.A SAR/a_18856_8436# vdd vdd sg13_lv_pmos ad=0.42p pd=2.99u as=0.2114p ps=1.54u w=1.12u l=0.13u
M33 SAR/a_16068_6928# SAR/a_16042_6892# vdd vdd sg13_lv_pmos ad=0.34p pd=2.68u as=0.36237p ps=2.605u w=1u l=0.13u
M34 vdd SAR/a_16748_9150# pl_sw[7] vdd sg13_lv_pmos ad=0.2114p pd=1.54u as=0.42p ps=2.99u w=1.12u l=0.13u
M35 SAR/sg13cmos5l_buf_1_96.A SAR/a_10665_7281# vss vss sg13_lv_nmos ad=0.2516p pd=2.16u as=0.1406p ps=1.12u w=0.74u l=0.13u
M36 SAR/a_14889_7281# SAR/a_14708_6924# vdd vdd sg13_lv_pmos ad=0.2128p pd=1.5u as=0.2387p ps=1.84u w=1.12u l=0.13u
M37 SAR/a_6898_2826# SAR/sg13cmos5l_dfrbp_1_6.RESET_B vss vss sg13_lv_nmos ad=37.8f pd=0.6u as=79.8f ps=0.8u w=0.42u l=0.13u
M38 SAR/a_11530_1849# SAR/a_11973_1605# SAR/a_11913_2017# vdd sg13_lv_pmos ad=79.8f pd=0.8u as=63f ps=0.72u w=0.42u l=0.13u
M39 vss SAR/sg13cmos5l_buf_1_111.A SAR/a_18376_9224# vss sg13_lv_nmos ad=0.14875p pd=1.16u as=0.187p ps=1.78u w=0.55u l=0.13u
M40 SAR/a_16677_6141# SAR/sg13cmos5l_dfrbp_1_8.D vdd vdd sg13_lv_pmos ad=0.4088p pd=2.97u as=1.04815p ps=6.595u w=1.12u l=0.13u
M41 SAR/a_13284_3456# SAR/a_13258_3361# vdd vdd sg13_lv_pmos ad=0.34p pd=2.68u as=0.36237p ps=2.605u w=1u l=0.13u
M42 SAR/a_16271_7751# SAR/a_15429_7653# SAR/a_16177_7751# vss sg13_lv_nmos ad=0.12665p pd=1.145u as=0.1428p ps=1.52u w=0.42u l=0.13u
M43 vdd SAR/a_7689_1626# SAR/a_7622_2064# vdd sg13_lv_pmos ad=0.2387p pd=1.84u as=0.1008p ps=0.9u w=0.42u l=0.13u
M44 vss SAR/a_9705_4650# SAR/a_9660_4686# vss sg13_lv_nmos ad=0.1428p pd=1.52u as=47.25f ps=0.645u w=0.42u l=0.13u
M45 SAR/sg13cmos5l_dfrbp_1_12.Q_N SAR/a_7055_4261# vss vss sg13_lv_nmos ad=0.2849p pd=2.25u as=0.2516p ps=2.16u w=0.74u l=0.13u
M46 SAR/sg13cmos5l_nor2_1_2.A SAR/sg13cmos5l_inv_1_9.Y vdd vdd sg13_lv_pmos ad=0.3808p pd=2.92u as=0.3808p ps=2.92u w=1.12u l=0.13u
M47 vss SAR/a_2565_8447# SAR/a_2667_8447# vss sg13_lv_nmos ad=2.92392p pd=18.89u as=0.2516p ps=2.16u w=0.74u l=0.13u
M48 SAR/a_1997_6126# SAR/a_2727_6380# SAR/a_2748_6126# vss sg13_lv_nmos ad=0.12665p pd=1.145u as=0.3473p ps=2.71u w=0.74u l=0.13u
M49 vss vdd vss vss sg13_lv_nmos ad=0.1428p pd=1.52u as=0.40368n ps=2.16158m w=0.42u l=1u
M50 SAR/a_15702_4187# SAR/a_15821_3864# vdd vdd sg13_lv_pmos ad=0.3864p pd=2.93u as=0.2128p ps=1.5u w=1.12u l=0.13u
M51 SAR/a_10031_8797# SAR/a_9189_8447# SAR/a_9937_8797# vss sg13_lv_nmos ad=0.12665p pd=1.145u as=0.1428p ps=1.52u w=0.42u l=0.13u
M52 SAR/a_5414_6162# SAR/sg13cmos5l_dfrbp_1_6.D vdd vdd sg13_lv_pmos ad=79.8f pd=0.8u as=0.1428p ps=1.52u w=0.42u l=0.13u
M53 vdd SAR/a_15429_7653# SAR/a_15531_7796# vdd sg13_lv_pmos ad=1.15047p pd=7.175u as=0.3864p ps=2.93u w=1.12u l=0.13u
M54 vdd SAR/a_1967_7285# SAR/a_2804_6924# vdd sg13_lv_pmos ad=0.2128p pd=1.5u as=0.3864p ps=2.93u w=1.12u l=0.13u
M55 nl_sw[3] SAR/a_4456_1664# vss vss sg13_lv_nmos ad=0.2886p pd=2.26u as=0.14875p ps=1.16u w=0.74u l=0.13u
M56 vss SAR/sg13cmos5l_nor2_1_0.A SAR/a_12814_4692# vss sg13_lv_nmos ad=0.17255p pd=1.25u as=0.187p ps=1.78u w=0.55u l=0.13u
M57 SAR/sg13cmos5l_buf_1_78.X SAR/a_6184_9224# vdd vdd sg13_lv_pmos ad=0.42p pd=2.99u as=0.2114p ps=1.54u w=1.12u l=0.13u
M58 SAR/a_12980_6924# SAR/a_12567_7282# SAR/a_12912_6924# vdd sg13_lv_pmos ad=0.191p pd=1.44u as=0.105p ps=1.21u w=1u l=0.13u
M59 vss SAR/a_1402_3864# SAR/a_1121_4166# vss sg13_lv_nmos ad=79.8f pd=0.8u as=0.1428p ps=1.52u w=0.42u l=0.5u
M60 SAR/a_9940_4636# SAR/a_9524_4972# SAR/a_9705_4650# vss sg13_lv_nmos ad=77.7f pd=0.95u as=0.2516p ps=2.16u w=0.74u l=0.13u
M61 SAR/a_2732_1590# SAR/sg13cmos5l_buf_1_37.A vss vss sg13_lv_nmos ad=0.187p pd=1.78u as=0.14875p ps=1.16u w=0.55u l=0.13u
M62 SAR/a_11556_1944# SAR/a_12075_1748# SAR/a_12815_1703# vss sg13_lv_nmos ad=0.3473p pd=2.71u as=0.12665p ps=1.145u w=0.74u l=0.13u
M63 SAR/a_2566_3151# SAR/sg13cmos5l_dfrbp_1_6.RESET_B vss vss sg13_lv_nmos ad=37.8f pd=0.6u as=0.1701p ps=1.65u w=0.42u l=0.13u
M64 vss SAR/sg13cmos5l_buf_1_5.A SAR/sg13cmos5l_inv_1_27.Y vss sg13_lv_nmos ad=0.2516p pd=2.16u as=0.2516p ps=2.16u w=0.74u l=0.13u
M65 SAR/a_11973_1605# SAR/sg13cmos5l_dfrbp_1_0.CLK vdd vdd sg13_lv_pmos ad=0.4088p pd=2.97u as=1.777p ps=11.395u w=1.12u l=0.13u
M66 SAR/a_3575_6553# SAR/a_2879_6432# SAR/a_3669_6320# vss sg13_lv_nmos ad=0.1296p pd=1.52u as=79.8f ps=0.8u w=0.42u l=0.13u
M67 SAR/a_4652_6126# SAR/sg13cmos5l_buf_1_59.A vss vss sg13_lv_nmos ad=0.187p pd=1.78u as=0.14875p ps=1.16u w=0.55u l=0.13u
M68 SAR/a_5673_3138# SAR/a_5492_3460# vdd vdd sg13_lv_pmos ad=0.2128p pd=1.5u as=0.2387p ps=1.84u w=1.12u l=0.13u
M69 SAR/a_10224_9508# SAR/a_9673_9240# vdd vdd sg13_lv_pmos ad=0.105p pd=1.21u as=4.11675p ps=27.17u w=1u l=0.13u
M70 SAR/sg13cmos5l_dlhr_1_1.Q SAR/a_2409_4650# vss vss sg13_lv_nmos ad=0.2516p pd=2.16u as=0.1406p ps=1.12u w=0.74u l=0.13u
M71 vdd SAR/sg13cmos5l_dlhr_1_0.D SAR/a_6889_1680# vdd sg13_lv_pmos ad=1.86162p pd=11.935u as=0.2856p ps=2.36u w=0.84u l=0.13u
M72 SAR/a_19090_1626# SAR/sg13cmos5l_dfrbp_1_0.RESET_B vss vss sg13_lv_nmos ad=37.8f pd=0.6u as=79.8f ps=0.8u w=0.42u l=0.13u
M73 SAR/a_17493_3947# SAR/a_16551_3987# SAR/a_17354_4180# vss sg13_lv_nmos ad=79.8f pd=0.8u as=0.2373p ps=1.97u w=0.42u l=0.13u
M74 SAR/a_5132_3864# SAR/sg13cmos5l_buf_1_44.A vss vss sg13_lv_nmos ad=0.187p pd=1.78u as=0.14875p ps=1.16u w=0.55u l=0.13u
M75 vss vdd vss vss sg13_lv_nmos ad=0.1428p pd=1.52u as=0 ps=0 w=0.42u l=1u
M76 vdd SAR/sg13cmos5l_dfrbp_1_6.RESET_B SAR/a_2314_3361# vdd sg13_lv_pmos ad=0.1563p pd=1.22u as=0.147p ps=1.54u w=0.42u l=0.13u
M77 SAR/sg13cmos5l_dlhr_1_16.Q SAR/a_19209_5769# vdd vdd sg13_lv_pmos ad=0.3808p pd=2.92u as=0.2128p ps=1.5u w=1.12u l=0.13u
M78 SAR/a_13701_3117# SAR/sg13cmos5l_dfrbp_1_0.CLK vdd vdd sg13_lv_pmos ad=0.4088p pd=2.97u as=1.38655p ps=8.8u w=1.12u l=0.13u
M79 SAR/a_1967_5773# SAR/a_1125_5423# SAR/a_1873_5773# vss sg13_lv_nmos ad=0.12665p pd=1.145u as=0.1428p ps=1.52u w=0.42u l=0.13u
M80 SAR/a_14295_7282# SAR/sg13cmos5l_dfrbp_1_23.CLK vdd vdd sg13_lv_pmos ad=0.3234p pd=2.45u as=1.04815p ps=6.595u w=0.84u l=0.13u
M81 SAR/sg13cmos5l_dlhr_1_12.D SAR/a_16271_7751# vdd vdd sg13_lv_pmos ad=0.4312p pd=3.01u as=0.2639p ps=1.81u w=1.12u l=0.13u
M82 vdd SAR/a_17327_7285# SAR/a_18164_6924# vdd sg13_lv_pmos ad=0.2128p pd=1.5u as=0.3864p ps=2.93u w=1.12u l=0.13u
M83 vdd SAR/a_15177_5769# SAR/a_15702_5842# vdd sg13_lv_pmos ad=0.1974p pd=1.5u as=0.2856p ps=2.36u w=0.84u l=0.13u
M84 SAR/a_16748_9150# SAR/sg13cmos5l_buf_1_93.X vdd vdd sg13_lv_pmos ad=0.2856p pd=2.36u as=0.2114p ps=1.54u w=0.84u l=0.13u
M85 vdd SAR/a_7689_1626# SAR/a_8214_1608# vdd sg13_lv_pmos ad=0.1974p pd=1.5u as=0.2856p ps=2.36u w=0.84u l=0.13u
M86 SAR/a_13460_7996# SAR/a_13178_7684# SAR/a_13393_7666# vss sg13_lv_nmos ad=0.141p pd=1.17u as=71.99999f ps=0.865u w=0.64u l=0.13u
M87 SAR/a_1402_3864# SAR/sg13cmos5l_dlygate4sd2_1_0.X vdd vdd sg13_lv_pmos ad=0.1428p pd=1.52u as=0.1523p ps=1.38u w=0.42u l=0.13u
M88 vdd SAR/a_12716_8400# ph_sw[5] vdd sg13_lv_pmos ad=0.2114p pd=1.54u as=0.42p ps=2.99u w=1.12u l=0.13u
M89 SAR/a_12324_6162# SAR/sg13cmos5l_buf_1_57.X SAR/a_12230_6162# vss sg13_lv_nmos ad=60.89999f pd=0.71u as=0.1428p ps=1.52u w=0.42u l=0.13u
M90 SAR/a_6117_6141# SAR/sg13cmos5l_dlhr_1_5.GATE vdd vdd sg13_lv_pmos ad=0.4088p pd=2.97u as=1.04815p ps=6.595u w=1.12u l=0.13u
M91 vdd SAR/sg13cmos5l_dfrbp_1_6.RESET_B SAR/a_8457_7281# vdd sg13_lv_pmos ad=0.2128p pd=1.5u as=0.2128p ps=1.5u w=1.12u l=0.13u
M92 vss SAR/a_12549_9165# SAR/a_12651_9308# vss sg13_lv_nmos ad=2.92392p pd=18.89u as=0.2516p ps=2.16u w=0.74u l=0.13u
M93 vdd SAR/a_18860_9150# ph_sw[8] vdd sg13_lv_pmos ad=0.2114p pd=1.54u as=0.42p ps=2.99u w=1.12u l=0.13u
M94 vdd SAR/sg13cmos5l_buf_1_96.A SAR/a_11464_8436# vdd sg13_lv_pmos ad=0.2114p pd=1.54u as=0.2856p ps=2.36u w=0.84u l=0.13u
M95 SAR/sg13cmos5l_dfrbp_1_1.D SAR/sg13cmos5l_a22oi_1_2.B2 SAR/a_9823_2780# vss sg13_lv_nmos ad=0.2664p pd=1.46u as=0.13875p ps=1.115u w=0.74u l=0.13u
M96 vdd SAR/a_16751_2749# SAR/a_17588_2388# vdd sg13_lv_pmos ad=0.2128p pd=1.5u as=0.3864p ps=2.93u w=1.12u l=0.13u
M97 SAR/sg13cmos5l_dlhr_1_0.D SAR/a_7316_2388# vss vss sg13_lv_nmos ad=0.2516p pd=2.16u as=0.1406p ps=1.12u w=0.74u l=0.13u
M98 SAR/a_2122_8404# SAR/a_2565_8447# SAR/a_1862_8874# vss sg13_lv_nmos ad=79.8f pd=0.8u as=0.1296p ps=1.52u w=0.42u l=0.13u
M99 SAR/a_17367_8794# SAR/sg13cmos5l_dfrbp_1_22.D vdd vdd sg13_lv_pmos ad=0.3234p pd=2.45u as=1.12242p ps=7u w=0.84u l=0.13u
M100 SAR/sg13cmos5l_buf_1_25.A SAR/sg13cmos5l_inv_1_14.A vss vss sg13_lv_nmos ad=0.2516p pd=2.16u as=0.2516p ps=2.16u w=0.74u l=0.13u
M101 SAR/a_20204_5376# SAR/sg13cmos5l_dlhr_1_16.Q vdd vdd sg13_lv_pmos ad=0.2856p pd=2.36u as=0.2114p ps=1.54u w=0.84u l=0.13u
M102 vdd rdy SAR/a_424_8436# vdd sg13_lv_pmos ad=0.2114p pd=1.54u as=0.2856p ps=2.36u w=0.84u l=0.13u
M103 SAR/sg13cmos5l_buf_1_87.A SAR/a_18376_9224# vdd vdd sg13_lv_pmos ad=0.42p pd=2.99u as=0.2114p ps=1.54u w=1.12u l=0.13u
M104 SAR/a_6479_2749# SAR/a_5637_2399# SAR/a_6385_2749# vss sg13_lv_nmos ad=0.12665p pd=1.145u as=0.1428p ps=1.52u w=0.42u l=0.13u
M105 SAR/a_7888_4870# SAR/a_7631_4727# SAR/a_8050_4650# vss sg13_lv_nmos ad=0.1428p pd=1.52u as=37.8f ps=0.6u w=0.42u l=0.13u
M106 vss SAR/a_2831_7630# SAR/a_2786_7666# vss sg13_lv_nmos ad=1.49685p pd=9.6u as=71.99999f ps=0.865u w=0.64u l=0.13u
M107 _frm SAR/a_20008_7712# vss vss sg13_lv_nmos ad=0.2886p pd=2.26u as=0.14875p ps=1.16u w=0.74u l=0.13u
M108 SAR/a_6598_4663# SAR/sg13cmos5l_dfrbp_1_8.RESET_B vss vss sg13_lv_nmos ad=37.8f pd=0.6u as=0.1701p ps=1.65u w=0.42u l=0.13u
M109 SAR/a_1125_6935# SAR/sg13cmos5l_dfrbp_1_15.D vss vss sg13_lv_nmos ad=0.2516p pd=2.16u as=1.49685p ps=9.6u w=0.74u l=0.13u
M110 SAR/a_20012_2352# SAR/sg13cmos5l_buf_1_0.X vdd vdd sg13_lv_pmos ad=0.2856p pd=2.36u as=0.2114p ps=1.54u w=0.84u l=0.13u
M111 SAR/a_8486_8874# SAR/a_9291_8447# SAR/a_8746_8404# vdd sg13_lv_pmos ad=0.1428p pd=1.52u as=79.8f ps=0.8u w=0.42u l=0.13u
M112 vdd SAR/a_15887_8797# SAR/a_16724_8436# vdd sg13_lv_pmos ad=0.2128p pd=1.5u as=0.3864p ps=2.93u w=1.12u l=0.13u
M113 vss comp_p SAR/a_424_1664# vss sg13_lv_nmos ad=0.14875p pd=1.16u as=0.187p ps=1.78u w=0.55u l=0.13u
M114 vdd SAR/a_3664_4142# SAR/a_3609_4023# vdd sg13_lv_pmos ad=1.43437p pd=9.105u as=93.45f ps=0.865u w=0.42u l=0.13u
M115 nh_sw[1] SAR/a_2824_2388# vss vss sg13_lv_nmos ad=0.2886p pd=2.26u as=0.14875p ps=1.16u w=0.74u l=0.13u
M116 vdd SAR/sg13cmos5l_dfrbp_1_0.RESET_B SAR/a_17414_3138# vdd sg13_lv_pmos ad=0.36237p pd=2.605u as=79.8f ps=0.8u w=0.42u l=0.13u
M117 SAR/a_2122_3868# SAR/a_2565_3911# SAR/a_2505_3947# vdd sg13_lv_pmos ad=79.8f pd=0.8u as=63f ps=0.72u w=0.42u l=0.13u
M118 vss SAR/a_4460_9150# SAR/sg13cmos5l_buf_1_60.X vss sg13_lv_nmos ad=0.14875p pd=1.16u as=0.2886p ps=2.26u w=0.74u l=0.13u
M119 SAR/a_11846_9186# SAR/sg13cmos5l_dlhr_1_11.GATE vdd vdd sg13_lv_pmos ad=79.8f pd=0.8u as=0.1428p ps=1.52u w=0.42u l=0.13u
M120 SAR/a_3801_3453# SAR/a_2859_3260# SAR/a_3599_3215# vdd sg13_lv_pmos ad=93.45f pd=0.865u as=0.2048p ps=1.63u w=0.42u l=0.13u
M121 SAR/a_13234_4338# SAR/sg13cmos5l_dfrbp_1_0.RESET_B vss vss sg13_lv_nmos ad=37.8f pd=0.6u as=79.8f ps=0.8u w=0.42u l=0.13u
M122 SAR/a_17751_7690# SAR/sg13cmos5l_dfrbp_1_22.D vss vss sg13_lv_nmos ad=0.2516p pd=2.16u as=0.15055p ps=1.17u w=0.74u l=0.13u
M123 SAR/a_7316_3460# SAR/a_7034_3148# SAR/a_7249_3130# vss sg13_lv_nmos ad=0.141p pd=1.17u as=71.99999f ps=0.865u w=0.64u l=0.13u
M124 SAR/sg13cmos5l_buf_1_116.A SAR/a_15177_5769# vdd vdd sg13_lv_pmos ad=0.3808p pd=2.92u as=0.2128p ps=1.5u w=1.12u l=0.13u
M125 vdd SAR/sg13cmos5l_dfrbp_1_15.D SAR/a_2621_7636# vdd sg13_lv_pmos ad=1.15047p pd=7.175u as=0.3234p ps=2.45u w=0.84u l=0.13u
M126 SAR/a_14928_5412# SAR/a_14377_5770# vdd vdd sg13_lv_pmos ad=0.105p pd=1.21u as=1.28962p ps=8.195u w=1u l=0.13u
M127 SAR/a_7247_8797# SAR/a_6405_8447# SAR/a_5988_8440# vdd sg13_lv_pmos ad=0.2048p pd=1.63u as=0.34p ps=2.68u w=1u l=0.13u
M128 ph_sw[2] SAR/a_3976_9224# vss vss sg13_lv_nmos ad=0.2886p pd=2.26u as=0.14875p ps=1.16u w=0.74u l=0.13u
M129 SAR/a_18196_8824# SAR/a_17780_8436# SAR/a_17961_8793# vss sg13_lv_nmos ad=77.7f pd=0.95u as=0.2516p ps=2.16u w=0.74u l=0.13u
M130 SAR/a_8204_2352# SAR/sg13cmos5l_dlhr_1_2.Q vss vss sg13_lv_nmos ad=0.187p pd=1.78u as=0.14875p ps=1.16u w=0.55u l=0.13u
M131 SAR/a_5104_4870# SAR/sg13cmos5l_dfrbp_1_8.RESET_B vdd vdd sg13_lv_pmos ad=79.8f pd=0.8u as=1.2517p ps=7.955u w=0.42u l=0.13u
M132 SAR/sg13cmos5l_buf_1_59.A SAR/a_4425_7281# vdd vdd sg13_lv_pmos ad=0.3808p pd=2.92u as=0.2128p ps=1.5u w=1.12u l=0.13u
M133 SAR/a_16485_6935# SAR/sg13cmos5l_inv_1_2.A vss vss sg13_lv_nmos ad=0.2516p pd=2.16u as=1.49685p ps=9.6u w=0.74u l=0.13u
M134 SAR/a_17392_4870# SAR/a_17135_4727# SAR/a_17554_4650# vss sg13_lv_nmos ad=0.1428p pd=1.52u as=37.8f ps=0.6u w=0.42u l=0.13u
M135 SAR/a_18860_9150# SAR/sg13cmos5l_buf_1_101.X vdd vdd sg13_lv_pmos ad=0.2856p pd=2.36u as=0.2114p ps=1.54u w=0.84u l=0.13u
M136 SAR/sg13cmos5l_dfrbp_1_7.Q_N SAR/a_14543_3215# vss vss sg13_lv_nmos ad=0.2849p pd=2.25u as=0.2516p ps=2.16u w=0.74u l=0.13u
M137 SAR/a_3575_6553# SAR/sg13cmos5l_dfrbp_1_15.D SAR/a_4322_6162# vss sg13_lv_nmos ad=0.1428p pd=1.52u as=60.89999f ps=0.71u w=0.42u l=0.13u
M138 vdd SAR/sg13cmos5l_buf_1_5.A SAR/sg13cmos5l_inv_1_27.Y vdd sg13_lv_pmos ad=0.3808p pd=2.92u as=0.3808p ps=2.92u w=1.12u l=0.13u
M139 SAR/a_7095_1642# SAR/sg13cmos5l_dlhr_1_0.GATE vss vss sg13_lv_nmos ad=0.2516p pd=2.16u as=0.15055p ps=1.17u w=0.74u l=0.13u
M140 SAR/a_2697_3529# SAR/a_2340_3456# vdd vdd sg13_lv_pmos ad=63f pd=0.72u as=0.1563p ps=1.22u w=0.42u l=0.13u
M141 vss SAR/a_5104_4870# SAR/a_4753_4727# vss sg13_lv_nmos ad=79.8f pd=0.8u as=0.1428p ps=1.52u w=0.42u l=0.13u
M142 SAR/sg13cmos5l_nor2_1_0.A SAR/a_13556_2388# vdd vdd sg13_lv_pmos ad=0.3808p pd=2.92u as=0.2128p ps=1.5u w=1.12u l=0.13u
M143 vss SAR/sg13cmos5l_dfrbp_1_21.Q SAR/a_18409_5770# vss sg13_lv_nmos ad=0.15055p pd=1.17u as=0.187p ps=1.78u w=0.55u l=0.13u
M144 SAR/a_13698_5412# SAR/sg13cmos5l_dfrbp_1_23.Q SAR/a_13486_5412# vdd sg13_lv_pmos ad=0.2128p pd=1.5u as=0.2128p ps=1.5u w=1.12u l=0.13u
M145 SAR/a_19526_6600# SAR/a_19130_6172# SAR/a_19412_6484# vdd sg13_lv_pmos ad=0.1008p pd=0.9u as=0.191p ps=1.44u w=0.42u l=0.13u
M146 vdd SAR/a_17776_6382# SAR/a_17721_6477# vdd sg13_lv_pmos ad=1.07253p pd=6.75u as=93.45f ps=0.865u w=0.42u l=0.13u
M147 vdd SAR/a_16268_3102# nl_sw[8] vdd sg13_lv_pmos ad=0.2114p pd=1.54u as=0.42p ps=2.99u w=1.12u l=0.13u
M148 vdd SAR/a_6213_3911# SAR/a_6315_3911# vdd sg13_lv_pmos ad=1.43437p pd=9.105u as=0.3864p ps=2.93u w=1.12u l=0.13u
M149 vss SAR/sg13cmos5l_dfrbp_1_0.RESET_B SAR/a_11268_2826# vss sg13_lv_nmos ad=0.1626p pd=1.415u as=60.89999f ps=0.71u w=0.42u l=0.13u
M150 vss SAR/a_17493_3947# SAR/a_16572_4261# vss sg13_lv_nmos ad=0.1626p pd=1.415u as=0.2516p ps=2.16u w=0.74u l=0.13u
M151 vss SAR/sg13cmos5l_buf_1_65.X SAR/a_8488_9224# vss sg13_lv_nmos ad=0.14875p pd=1.16u as=0.187p ps=1.78u w=0.55u l=0.13u
M152 SAR/a_708_6928# SAR/a_682_6892# vss vss sg13_lv_nmos ad=0.2516p pd=2.16u as=0.1626p ps=1.415u w=0.74u l=0.13u
M153 SAR/a_1948_7964# SAR/sg13cmos5l_dfrbp_1_6.RESET_B vdd vdd sg13_lv_pmos ad=0.2128p pd=1.5u as=0.2128p ps=1.5u w=1.12u l=0.13u
M154 SAR/a_19161_3453# SAR/a_18219_3260# SAR/a_18959_3215# vdd sg13_lv_pmos ad=93.45f pd=0.865u as=0.2048p ps=1.63u w=0.42u l=0.13u
M155 vdd SAR/a_4041_2745# SAR/a_3974_2388# vdd sg13_lv_pmos ad=0.2387p pd=1.84u as=0.1008p ps=0.9u w=0.42u l=0.13u
M156 SAR/a_16260_6480# SAR/a_16779_6284# SAR/a_17519_6239# vss sg13_lv_nmos ad=0.3473p pd=2.71u as=0.12665p ps=1.145u w=0.74u l=0.13u
M157 vss SAR/a_1484_6126# SAR/sg13cmos5l_buf_1_40.A vss sg13_lv_nmos ad=0.14875p pd=1.16u as=0.2886p ps=2.26u w=0.74u l=0.13u
M158 vss SAR/sg13cmos5l_inv_1_3.A SAR/a_15016_9224# vss sg13_lv_nmos ad=0.14875p pd=1.16u as=0.187p ps=1.78u w=0.55u l=0.13u
M159 vdd SAR/a_18671_1703# SAR/a_18928_1846# vdd sg13_lv_pmos ad=0.2639p pd=1.81u as=79.8f ps=0.8u w=0.42u l=0.13u
M160 vss SAR/sg13cmos5l_dfrbp_1_8.RESET_B SAR/a_11940_9186# vss sg13_lv_nmos ad=0.1626p pd=1.415u as=60.89999f ps=0.71u w=0.42u l=0.13u
M161 vdd SAR/a_9033_6162# SAR/a_8966_6600# vdd sg13_lv_pmos ad=0.2387p pd=1.84u as=0.1008p ps=0.9u w=0.42u l=0.13u
M162 SAR/a_12913_7326# SAR/a_12361_7282# vss vss sg13_lv_nmos ad=71.99999f pd=0.865u as=1.49685p ps=9.6u w=0.64u l=0.13u
M163 SAR/a_5508_2813# SAR/a_5220_2392# SAR/a_5446_2813# vss sg13_lv_nmos ad=0.1428p pd=1.52u as=37.8f ps=0.6u w=0.42u l=0.13u
M164 vss SAR/a_19593_6162# SAR/a_19548_6198# vss sg13_lv_nmos ad=0.1428p pd=1.52u as=47.25f ps=0.645u w=0.42u l=0.13u
M165 SAR/a_18057_3529# SAR/a_17700_3456# vdd vdd sg13_lv_pmos ad=63f pd=0.72u as=0.1563p ps=1.22u w=0.42u l=0.13u
M166 vss SAR/a_7631_4727# SAR/a_8468_4948# vss sg13_lv_nmos ad=0.1406p pd=1.12u as=0.2516p ps=2.16u w=0.74u l=0.13u
M167 vdd vss vdd vdd sg13_lv_pmos ad=0.34p pd=2.68u as=0.43217n ps=2.29179m w=1u l=1u
M168 vdd SAR/a_10473_9186# SAR/a_10998_9168# vdd sg13_lv_pmos ad=0.1974p pd=1.5u as=0.2856p ps=2.36u w=0.84u l=0.13u
M169 SAR/a_17220_1626# SAR/sg13cmos5l_dfrbp_1_0.D SAR/a_17126_1626# vss sg13_lv_nmos ad=60.89999f pd=0.71u as=0.1428p ps=1.52u w=0.42u l=0.13u
M170 vdd SAR/a_620_7638# pl_sw[0] vdd sg13_lv_pmos ad=0.2114p pd=1.54u as=0.42p ps=2.99u w=1.12u l=0.13u
M171 SAR/a_10665_8065# SAR/a_10308_7992# vdd vdd sg13_lv_pmos ad=63f pd=0.72u as=0.1563p ps=1.22u w=0.42u l=0.13u
M172 vdd SAR/a_14800_3358# SAR/a_14745_3453# vdd sg13_lv_pmos ad=1.43437p pd=9.105u as=93.45f ps=0.865u w=0.42u l=0.13u
M173 vss SAR/sg13cmos5l_nor2_1_1.A SAR/a_15439_1630# vss sg13_lv_nmos ad=0.14505p pd=1.15u as=0.1406p ps=1.12u w=0.74u l=0.13u
M174 SAR/a_2148_3138# SAR/sg13cmos5l_dfrbp_1_6.D SAR/a_2054_3138# vss sg13_lv_nmos ad=60.89999f pd=0.71u as=0.1428p ps=1.52u w=0.42u l=0.13u
M175 SAR/a_3860_2388# SAR/a_3578_2752# SAR/a_3793_2790# vss sg13_lv_nmos ad=0.141p pd=1.17u as=71.99999f ps=0.865u w=0.64u l=0.13u
M176 SAR/sg13cmos5l_dlygate4sd2_1_0.A SAR/sg13cmos5l_inv_1_8.Y vdd vdd sg13_lv_pmos ad=0.2128p pd=1.5u as=0.3808p ps=2.92u w=1.12u l=0.13u
M177 SAR/a_1065_5459# SAR/a_708_5416# vdd vdd sg13_lv_pmos ad=63f pd=0.72u as=0.1563p ps=1.22u w=0.42u l=0.13u
M178 vss SAR/a_5132_9150# SAR/sg13cmos5l_buf_1_64.A vss sg13_lv_nmos ad=0.14875p pd=1.16u as=0.2886p ps=2.26u w=0.74u l=0.13u
M179 SAR/a_1862_8874# SAR/a_2667_8447# SAR/a_2122_8404# vdd sg13_lv_pmos ad=0.1428p pd=1.52u as=79.8f ps=0.8u w=0.42u l=0.13u
M180 SAR/a_13392_7996# SAR/a_12841_7728# vdd vdd sg13_lv_pmos ad=0.105p pd=1.21u as=1.15047p ps=7.175u w=1u l=0.13u
M181 vss SAR/sg13cmos5l_dfrbp_1_6.RESET_B SAR/a_8692_7312# vss sg13_lv_nmos ad=0.1406p pd=1.12u as=77.7f ps=0.95u w=0.74u l=0.13u
M182 SAR/a_13284_3456# SAR/a_13803_3260# SAR/a_14543_3215# vss sg13_lv_nmos ad=0.3473p pd=2.71u as=0.12665p ps=1.145u w=0.74u l=0.13u
M183 SAR/sg13cmos5l_nand2_1_2.B SAR/sg13cmos5l_or2_1_0.A SAR/a_650_3900# vdd sg13_lv_pmos ad=0.3808p pd=2.92u as=0.1176p ps=1.33u w=1.12u l=0.13u
M184 vss SAR/a_4425_7281# SAR/a_4950_7354# vss sg13_lv_nmos ad=0.1491p pd=1.18u as=0.187p ps=1.78u w=0.55u l=0.13u
M185 vdd SAR/sg13cmos5l_dfrbp_1_0.RESET_B SAR/a_17386_1849# vdd sg13_lv_pmos ad=0.1563p pd=1.22u as=0.147p ps=1.54u w=0.42u l=0.13u
M186 SAR/a_14628_8440# SAR/a_14602_8404# vdd vdd sg13_lv_pmos ad=0.34p pd=2.68u as=0.36237p ps=2.605u w=1u l=0.13u
M187 SAR/a_20492_8400# SAR/sg13cmos5l_buf_1_104.X vss vss sg13_lv_nmos ad=0.187p pd=1.78u as=0.14875p ps=1.16u w=0.55u l=0.13u
M188 SAR/a_13486_5412# SAR/sg13cmos5l_nor2b_1_0.Y vdd vdd sg13_lv_pmos ad=0.2128p pd=1.5u as=0.3808p ps=2.92u w=1.12u l=0.13u
M189 SAR/sg13cmos5l_dfrbp_1_6.D SAR/a_1672_3176# vss vss sg13_lv_nmos ad=0.2886p pd=2.26u as=0.14875p ps=1.16u w=0.74u l=0.13u
M190 SAR/sg13cmos5l_buf_1_98.A SAR/a_13641_7674# vdd vdd sg13_lv_pmos ad=0.3808p pd=2.92u as=0.2128p ps=1.5u w=1.12u l=0.13u
M191 vdd SAR/a_1997_6126# SAR/sg13cmos5l_dfrbp_1_15.Q_N vdd sg13_lv_pmos ad=0.2639p pd=1.81u as=0.4312p ps=3.01u w=1.12u l=0.13u
M192 _d1 SAR/a_20008_3900# vdd vdd sg13_lv_pmos ad=0.42p pd=2.99u as=0.2114p ps=1.54u w=1.12u l=0.13u
M193 vdd SAR/a_4950_5699# SAR/sg13cmos5l_dlhr_1_5.GATE vdd sg13_lv_pmos ad=0.2128p pd=1.5u as=0.3808p ps=2.92u w=1.12u l=0.13u
M194 SAR/a_6572_1590# SAR/sg13cmos5l_buf_1_24.A vdd vdd sg13_lv_pmos ad=0.2856p pd=2.36u as=0.2114p ps=1.54u w=0.84u l=0.13u
M195 SAR/a_8966_6600# SAR/a_8570_6172# SAR/a_8852_6484# vdd sg13_lv_pmos ad=0.1008p pd=0.9u as=0.191p ps=1.44u w=0.42u l=0.13u
M196 SAR/sg13cmos5l_buf_1_97.A SAR/a_10473_9186# vss vss sg13_lv_nmos ad=0.2516p pd=2.16u as=0.1406p ps=1.12u w=0.74u l=0.13u
M197 SAR/a_10331_1924# SAR/sg13cmos5l_nand2_1_1.B SAR/sg13cmos5l_a22oi_1_2.B1 vdd sg13_lv_pmos ad=0.2128p pd=1.5u as=0.3808p ps=2.92u w=1.12u l=0.13u
M198 vss SAR/sg13cmos5l_dfrbp_1_6.RESET_B SAR/a_516_5850# vss sg13_lv_nmos ad=0.1626p pd=1.415u as=60.89999f ps=0.71u w=0.42u l=0.13u
M199 SAR/sg13cmos5l_a221oi_1_0.A2 SAR/a_7892_3900# vdd vdd sg13_lv_pmos ad=0.3808p pd=2.92u as=0.2128p ps=1.5u w=1.12u l=0.13u
M200 SAR/a_18300_7710# SAR/a_17751_7690# SAR/a_18164_7996# vss sg13_lv_nmos ad=47.25f pd=0.645u as=0.141p ps=1.17u w=0.42u l=0.13u
M201 vdd SAR/sg13cmos5l_dfrbp_1_8.RESET_B SAR/a_14602_8404# vdd sg13_lv_pmos ad=0.1563p pd=1.22u as=0.147p ps=1.54u w=0.42u l=0.13u
M202 SAR/sg13cmos5l_dfrbp_1_1.Q SAR/a_13652_1924# vss vss sg13_lv_nmos ad=0.2516p pd=2.16u as=0.1406p ps=1.12u w=0.74u l=0.13u
M203 SAR/sg13cmos5l_a221oi_1_0.C1 SAR/sg13cmos5l_inv_1_0.A vss vss sg13_lv_nmos ad=0.1406p pd=1.12u as=0.2516p ps=2.16u w=0.74u l=0.13u
M204 vdd SAR/a_8972_9150# SAR/sg13cmos5l_buf_1_77.X vdd sg13_lv_pmos ad=0.2114p pd=1.54u as=0.42p ps=2.99u w=1.12u l=0.13u
M205 vdd SAR/sg13cmos5l_dfrbp_1_6.RESET_B SAR/a_422_7362# vdd sg13_lv_pmos ad=0.36237p pd=2.605u as=79.8f ps=0.8u w=0.42u l=0.13u
M206 vss SAR/a_11372_3102# nh_sw[5] vss sg13_lv_nmos ad=0.14875p pd=1.16u as=0.2886p ps=2.26u w=0.74u l=0.13u
M207 SAR/a_11530_3868# SAR/a_11973_3911# SAR/a_11270_4338# vss sg13_lv_nmos ad=79.8f pd=0.8u as=0.1296p ps=1.52u w=0.42u l=0.13u
M208 SAR/a_2161_4642# SAR/a_1609_4704# vss vss sg13_lv_nmos ad=71.99999f pd=0.865u as=2.41737p ps=15.64u w=0.64u l=0.13u
M209 vdd SAR/sg13cmos5l_a22oi_1_1.A1 SAR/a_14814_3876# vdd sg13_lv_pmos ad=0.3808p pd=2.92u as=0.2716p ps=1.605u w=1.12u l=0.13u
M210 vdd SAR/a_10412_6126# SAR/sg13cmos5l_buf_1_29.A vdd sg13_lv_pmos ad=0.2114p pd=1.54u as=0.42p ps=2.99u w=1.12u l=0.13u
M211 vdd SAR/sg13cmos5l_dfrbp_1_0.RESET_B SAR/a_15466_2356# vdd sg13_lv_pmos ad=0.1563p pd=1.22u as=0.147p ps=1.54u w=0.42u l=0.13u
M212 vdd vss vdd vdd sg13_lv_pmos ad=0.34p pd=2.68u as=0 ps=0 w=1u l=1u
M213 SAR/a_6188_1590# SAR/sg13cmos5l_buf_1_25.A vss vss sg13_lv_nmos ad=0.187p pd=1.78u as=0.14875p ps=1.16u w=0.55u l=0.13u
M214 SAR/sg13cmos5l_dlhr_1_11.Q_N SAR/a_13686_7354# vdd vdd sg13_lv_pmos ad=0.3808p pd=2.92u as=0.1974p ps=1.5u w=1.12u l=0.13u
M215 SAR/a_16425_6971# SAR/a_16068_6928# vdd vdd sg13_lv_pmos ad=63f pd=0.72u as=0.1563p ps=1.22u w=0.42u l=0.13u
M216 SAR/sg13cmos5l_nand2_1_1.A SAR/a_15380_3436# vss vss sg13_lv_nmos ad=0.2516p pd=2.16u as=0.1406p ps=1.12u w=0.74u l=0.13u
M217 SAR/sg13cmos5l_inv_1_2.A SAR/a_8488_9224# vdd vdd sg13_lv_pmos ad=0.42p pd=2.99u as=0.2114p ps=1.54u w=1.12u l=0.13u
M218 SAR/a_9040_7894# SAR/a_8783_7751# SAR/a_9202_7674# vss sg13_lv_nmos ad=0.1428p pd=1.52u as=37.8f ps=0.6u w=0.42u l=0.13u
M219 vdd SAR/a_7631_4727# SAR/a_7888_4870# vdd sg13_lv_pmos ad=0.2639p pd=1.81u as=79.8f ps=0.8u w=0.42u l=0.13u
M220 SAR/a_2374_4325# SAR/sg13cmos5l_dfrbp_1_8.RESET_B vss vss sg13_lv_nmos ad=37.8f pd=0.6u as=0.1701p ps=1.65u w=0.42u l=0.13u
M221 SAR/a_3831_7282# SAR/sg13cmos5l_dfrbp_1_15.D vss vss sg13_lv_nmos ad=0.2516p pd=2.16u as=0.15055p ps=1.17u w=0.74u l=0.13u
M222 SAR/a_10598_6924# SAR/a_10202_7288# SAR/a_10484_6924# vdd sg13_lv_pmos ad=0.1008p pd=0.9u as=0.191p ps=1.44u w=0.42u l=0.13u
M223 SAR/a_7750_7687# SAR/sg13cmos5l_dfrbp_1_6.RESET_B vss vss sg13_lv_nmos ad=37.8f pd=0.6u as=0.1701p ps=1.65u w=0.42u l=0.13u
M224 _d0 SAR/a_20392_2388# vdd vdd sg13_lv_pmos ad=0.42p pd=2.99u as=0.2114p ps=1.54u w=1.12u l=0.13u
M225 vss SAR/sg13cmos5l_dfrbp_1_20.Q_N SAR/a_9673_9240# vss sg13_lv_nmos ad=0.15055p pd=1.17u as=0.187p ps=1.78u w=0.55u l=0.13u
M226 SAR/a_8412_7326# SAR/a_7863_7282# SAR/a_8276_6924# vss sg13_lv_nmos ad=47.25f pd=0.645u as=0.141p ps=1.17u w=0.42u l=0.13u
M227 SAR/sg13cmos5l_buf_1_94.X SAR/a_15016_9224# vdd vdd sg13_lv_pmos ad=0.42p pd=2.99u as=0.2114p ps=1.54u w=1.12u l=0.13u
M228 vdd SAR/a_6380_7638# pl_sw[3] vdd sg13_lv_pmos ad=0.2114p pd=1.54u as=0.42p ps=2.99u w=1.12u l=0.13u
M229 vdd SAR/a_17493_3947# SAR/a_16572_4261# vdd sg13_lv_pmos ad=0.36237p pd=2.605u as=0.34p ps=2.68u w=1u l=0.13u
M230 SAR/a_11364_4338# SAR/sg13cmos5l_dfrbp_1_2.D SAR/a_11270_4338# vss sg13_lv_nmos ad=60.89999f pd=0.71u as=0.1428p ps=1.52u w=0.42u l=0.13u
M231 vdd SAR/a_13484_8400# SAR/sg13cmos5l_buf_1_5.A vdd sg13_lv_pmos ad=0.2114p pd=1.54u as=0.42p ps=2.99u w=1.12u l=0.13u
M232 SAR/a_2638_6162# SAR/a_2380_6162# vss vss sg13_lv_nmos ad=0.1428p pd=1.52u as=79.8f ps=0.8u w=0.42u l=0.13u
M233 SAR/sg13cmos5l_dlhr_1_10.Q_N SAR/a_20118_6144# vdd vdd sg13_lv_pmos ad=0.3808p pd=2.92u as=0.1974p ps=1.5u w=1.12u l=0.13u
M234 SAR/a_11460_2392# SAR/a_11434_2356# vdd vdd sg13_lv_pmos ad=0.34p pd=2.68u as=0.36237p ps=2.605u w=1u l=0.13u
M235 SAR/sg13cmos5l_buf_1_59.A SAR/a_4425_7281# vss vss sg13_lv_nmos ad=0.2516p pd=2.16u as=0.1406p ps=1.12u w=0.74u l=0.13u
M236 vdd SAR/sg13cmos5l_inv_1_29.Y SAR/a_11771_5412# vdd sg13_lv_pmos ad=0.2128p pd=1.5u as=0.2128p ps=1.5u w=1.12u l=0.13u
M237 vdd SAR/a_18959_3215# SAR/a_19796_3436# vdd sg13_lv_pmos ad=0.2128p pd=1.5u as=0.3864p ps=2.93u w=1.12u l=0.13u
M238 vss SAR/sg13cmos5l_buf_1_24.X SAR/a_5704_1664# vss sg13_lv_nmos ad=0.14875p pd=1.16u as=0.187p ps=1.78u w=0.55u l=0.13u
M239 SAR/a_10433_4248# SAR/sg13cmos5l_dfrbp_1_10.Q SAR/sg13cmos5l_a22oi_1_1.B1 vss sg13_lv_nmos ad=0.1406p pd=1.12u as=0.1406p ps=1.12u w=0.74u l=0.13u
M240 SAR/a_2436_4325# SAR/a_2667_3911# SAR/a_2122_3868# vss sg13_lv_nmos ad=0.2373p pd=1.97u as=79.8f ps=0.8u w=0.42u l=0.13u
M241 vss SAR/sg13cmos5l_buf_1_34.X SAR/sg13cmos5l_buf_1_60.A vss sg13_lv_nmos ad=0.2516p pd=2.16u as=0.2516p ps=2.16u w=0.74u l=0.13u
M242 SAR/a_10484_6924# SAR/a_10202_7288# SAR/a_10417_7326# vss sg13_lv_nmos ad=0.141p pd=1.17u as=71.99999f ps=0.865u w=0.64u l=0.13u
M243 vss vdd vss vss sg13_lv_nmos ad=0.1428p pd=1.52u as=0 ps=0 w=0.42u l=1u
M244 SAR/a_4559_7630# SAR/sg13cmos5l_dlhr_1_9.D vdd vdd sg13_lv_pmos ad=0.2856p pd=2.36u as=1.15047p ps=7.175u w=0.84u l=0.13u
M245 vdd SAR/sg13cmos5l_dfrbp_1_6.RESET_B SAR/a_12230_6162# vdd sg13_lv_pmos ad=0.36237p pd=2.605u as=79.8f ps=0.8u w=0.42u l=0.13u
M246 SAR/a_18117_3117# SAR/sg13cmos5l_dfrbp_1_0.CLK vss vss sg13_lv_nmos ad=0.2516p pd=2.16u as=2.43055p ps=15.415u w=0.74u l=0.13u
M247 vss SAR/sg13cmos5l_dfrbp_1_6.RESET_B SAR/a_7732_3124# vss sg13_lv_nmos ad=0.1406p pd=1.12u as=77.7f ps=0.95u w=0.74u l=0.13u
M248 vdd SAR/a_2224_5654# SAR/a_2169_5535# vdd sg13_lv_pmos ad=1.28962p pd=8.195u as=93.45f ps=0.865u w=0.42u l=0.13u
M249 vss SAR/sg13cmos5l_buf_1_61.X SAR/a_1000_9224# vss sg13_lv_nmos ad=0.14875p pd=1.16u as=0.187p ps=1.78u w=0.55u l=0.13u
M250 SAR/a_13017_4023# SAR/a_12075_3911# SAR/a_12815_4261# vdd sg13_lv_pmos ad=93.45f pd=0.865u as=0.2048p ps=1.63u w=0.42u l=0.13u
M251 vdd SAR/a_17135_4727# SAR/a_17392_4870# vdd sg13_lv_pmos ad=0.2639p pd=1.81u as=79.8f ps=0.8u w=0.42u l=0.13u
M252 SAR/sg13cmos5l_buf_1_111.A SAR/a_19240_7712# vss vss sg13_lv_nmos ad=0.2886p pd=2.26u as=0.14875p ps=1.16u w=0.74u l=0.13u
M253 vdd SAR/sg13cmos5l_inv_1_6.A SAR/a_20008_8436# vdd sg13_lv_pmos ad=0.2114p pd=1.54u as=0.2856p ps=2.36u w=0.84u l=0.13u
M254 SAR/a_4172_1590# SAR/sg13cmos5l_buf_1_38.A vss vss sg13_lv_nmos ad=0.187p pd=1.78u as=0.14875p ps=1.16u w=0.55u l=0.13u
M255 vss SAR/a_9879_9202# SAR/a_10010_9196# vss sg13_lv_nmos ad=2.92392p pd=18.89u as=0.2775p ps=2.23u w=0.74u l=0.13u
M256 SAR/a_7474_4338# SAR/sg13cmos5l_dfrbp_1_6.RESET_B vss vss sg13_lv_nmos ad=37.8f pd=0.6u as=79.8f ps=0.8u w=0.42u l=0.13u
M257 SAR/sg13cmos5l_dlhr_1_5.D SAR/a_6959_6239# vss vss sg13_lv_nmos ad=0.2849p pd=2.25u as=0.2516p ps=2.16u w=0.74u l=0.13u
M258 SAR/a_8593_5814# SAR/a_8041_5770# vss vss sg13_lv_nmos ad=71.99999f pd=0.865u as=1.97045p ps=12.335u w=0.64u l=0.13u
M259 SAR/a_11877_2399# SAR/sg13cmos5l_dfrbp_1_0.CLK vss vss sg13_lv_nmos ad=0.2516p pd=2.16u as=2.43055p ps=15.415u w=0.74u l=0.13u
M260 SAR/a_17554_4650# SAR/sg13cmos5l_dfrbp_1_8.RESET_B vss vss sg13_lv_nmos ad=37.8f pd=0.6u as=79.8f ps=0.8u w=0.42u l=0.13u
M261 SAR/a_17132_9150# SAR/sg13cmos5l_buf_1_94.X vss vss sg13_lv_nmos ad=0.187p pd=1.78u as=0.14875p ps=1.16u w=0.55u l=0.13u
M262 vdd SAR/sg13cmos5l_buf_1_19.A SAR/a_18760_2388# vdd sg13_lv_pmos ad=0.2114p pd=1.54u as=0.2856p ps=2.36u w=0.84u l=0.13u
M263 SAR/a_5674_6385# SAR/a_6117_6141# SAR/a_6057_6553# vdd sg13_lv_pmos ad=79.8f pd=0.8u as=63f ps=0.72u w=0.42u l=0.13u
M264 vdd SAR/sg13cmos5l_buf_1_98.A SAR/a_13768_8436# vdd sg13_lv_pmos ad=0.2114p pd=1.54u as=0.2856p ps=2.36u w=0.84u l=0.13u
M265 SAR/sg13cmos5l_dlhr_1_5.Q_N SAR/a_8982_7354# vdd vdd sg13_lv_pmos ad=0.3808p pd=2.92u as=0.1974p ps=1.5u w=1.12u l=0.13u
M266 SAR/a_17700_3456# SAR/a_17674_3361# vdd vdd sg13_lv_pmos ad=0.34p pd=2.68u as=0.36237p ps=2.605u w=1u l=0.13u
M267 SAR/a_10220_3102# SAR/sg13cmos5l_buf_1_28.X vdd vdd sg13_lv_pmos ad=0.2856p pd=2.36u as=0.2114p ps=1.54u w=0.84u l=0.13u
M268 SAR/sg13cmos5l_a22oi_1_1.Y SAR/sg13cmos5l_a22oi_1_1.B2 SAR/a_14814_3876# vdd sg13_lv_pmos ad=0.2128p pd=1.5u as=0.2744p ps=1.61u w=1.12u l=0.13u
M269 SAR/a_8660_5412# SAR/a_8247_5770# SAR/a_8592_5412# vdd sg13_lv_pmos ad=0.191p pd=1.44u as=0.105p ps=1.21u w=1u l=0.13u
M270 SAR/a_8796_5814# SAR/a_8247_5770# SAR/a_8660_5412# vss sg13_lv_nmos ad=47.25f pd=0.645u as=0.141p ps=1.17u w=0.42u l=0.13u
M271 vss SAR/a_17961_8793# SAR/a_18486_8866# vss sg13_lv_nmos ad=0.1491p pd=1.18u as=0.187p ps=1.78u w=0.55u l=0.13u
M272 vdd SAR/sg13cmos5l_inv_1_29.A SAR/a_12841_7728# vdd sg13_lv_pmos ad=1.15047p pd=7.175u as=0.2856p ps=2.36u w=0.84u l=0.13u
M273 vdd SAR/a_13641_7674# SAR/a_13574_8112# vdd sg13_lv_pmos ad=0.2387p pd=1.84u as=0.1008p ps=0.9u w=0.42u l=0.13u
M274 vdd SAR/a_19593_6162# SAR/a_20118_6144# vdd sg13_lv_pmos ad=0.1974p pd=1.5u as=0.2856p ps=2.36u w=0.84u l=0.13u
M275 SAR/a_10028_6126# SAR/sg13cmos5l_buf_1_56.A vss vss sg13_lv_nmos ad=0.187p pd=1.78u as=0.14875p ps=1.16u w=0.55u l=0.13u
M276 vss SAR/sg13cmos5l_buf_1_33.A SAR/a_2248_1664# vss sg13_lv_nmos ad=0.14875p pd=1.16u as=0.187p ps=1.78u w=0.55u l=0.13u
M277 vss SAR/sg13cmos5l_buf_8_1.A SAR/a_18363_4270# vss sg13_lv_nmos ad=0.1406p pd=1.12u as=0.2553p ps=2.17u w=0.74u l=0.13u
M278 vss SAR/a_13076_5376# SAR/sg13cmos5l_or2_1_1.B vss sg13_lv_nmos ad=0.17255p pd=1.25u as=0.1406p ps=1.12u w=0.74u l=0.13u
M279 SAR/sg13cmos5l_dfrbp_1_21.Q SAR/a_18356_6460# vss vss sg13_lv_nmos ad=0.2516p pd=2.16u as=0.1406p ps=1.12u w=0.74u l=0.13u
M280 SAR/a_13161_7281# SAR/a_12980_6924# vdd vdd sg13_lv_pmos ad=0.2128p pd=1.5u as=0.2387p ps=1.84u w=1.12u l=0.13u
M281 SAR/a_7820_2352# SAR/sg13cmos5l_dlhr_1_0.Q vss vss sg13_lv_nmos ad=0.187p pd=1.78u as=0.14875p ps=1.16u w=0.55u l=0.13u
M282 vdd SAR/sg13cmos5l_dlhr_1_6.D SAR/a_8233_6216# vdd sg13_lv_pmos ad=1.07253p pd=6.75u as=0.2856p ps=2.36u w=0.84u l=0.13u
M283 SAR/a_3302_4650# SAR/sg13cmos5l_dfrbp_1_9.Q vdd vdd sg13_lv_pmos ad=79.8f pd=0.8u as=0.1428p ps=1.52u w=0.42u l=0.13u
M284 SAR/sg13cmos5l_o21ai_1_0.A2 SAR/sg13cmos5l_nand2_1_0.B vdd vdd sg13_lv_pmos ad=0.2128p pd=1.5u as=0.3808p ps=2.92u w=1.12u l=0.13u
M285 vdd SAR/a_15884_3102# nh_sw[7] vdd sg13_lv_pmos ad=0.2114p pd=1.54u as=0.42p ps=2.99u w=1.12u l=0.13u
M286 SAR/a_12106_9409# SAR/a_12549_9165# SAR/a_11846_9186# vss sg13_lv_nmos ad=79.8f pd=0.8u as=0.1296p ps=1.52u w=0.42u l=0.13u
M287 SAR/a_8985_7989# SAR/a_8043_7796# SAR/a_8783_7751# vdd sg13_lv_pmos ad=93.45f pd=0.865u as=0.2048p ps=1.63u w=0.42u l=0.13u
M288 SAR/a_4177_7326# SAR/a_3625_7282# vss vss sg13_lv_nmos ad=71.99999f pd=0.865u as=1.49685p ps=9.6u w=0.64u l=0.13u
M289 vdd SAR/a_12815_4261# SAR/a_13072_4142# vdd sg13_lv_pmos ad=0.2639p pd=1.81u as=79.8f ps=0.8u w=0.42u l=0.13u
M290 vss SAR/a_6903_3154# SAR/a_7034_3148# vss sg13_lv_nmos ad=2.59257p pd=16.445u as=0.2775p ps=2.23u w=0.74u l=0.13u
M291 SAR/a_18117_3117# SAR/sg13cmos5l_dfrbp_1_0.CLK vdd vdd sg13_lv_pmos ad=0.4088p pd=2.97u as=1.38655p ps=8.8u w=1.12u l=0.13u
M292 vdd SAR/sg13cmos5l_buf_1_28.A SAR/a_9448_1664# vdd sg13_lv_pmos ad=0.2114p pd=1.54u as=0.2856p ps=2.36u w=0.84u l=0.13u
M293 SAR/a_17584_7166# SAR/sg13cmos5l_dfrbp_1_8.RESET_B vdd vdd sg13_lv_pmos ad=79.8f pd=0.8u as=1.04815p ps=6.595u w=0.42u l=0.13u
M294 vdd SAR/sg13cmos5l_buf_1_86.A SAR/a_20392_6924# vdd sg13_lv_pmos ad=0.2114p pd=1.54u as=0.2856p ps=2.36u w=0.84u l=0.13u
M295 SAR/a_17519_6239# SAR/a_16677_6141# SAR/a_16260_6480# vdd sg13_lv_pmos ad=0.2048p pd=1.63u as=0.34p ps=2.68u w=1u l=0.13u
M296 SAR/a_996_5837# SAR/a_708_5416# SAR/a_934_5837# vss sg13_lv_nmos ad=0.1428p pd=1.52u as=37.8f ps=0.6u w=0.42u l=0.13u
M297 vdd vss vdd vdd sg13_lv_pmos ad=0.19p pd=1.38u as=0 ps=0 w=1u l=1u
M298 vdd SAR/sg13cmos5l_inv_1_8.A SAR/a_2879_6432# vdd sg13_lv_pmos ad=1.07253p pd=6.75u as=0.4088p ps=2.97u w=1.12u l=0.13u
M299 SAR/a_2054_3138# SAR/a_2859_3260# SAR/a_2314_3361# vdd sg13_lv_pmos ad=0.1428p pd=1.52u as=79.8f ps=0.8u w=0.42u l=0.13u
M300 vdd SAR/a_1484_9150# SAR/sg13cmos5l_buf_1_68.X vdd sg13_lv_pmos ad=0.2114p pd=1.54u as=0.42p ps=2.99u w=1.12u l=0.13u
M301 vdd SAR/sg13cmos5l_dfrbp_1_0.RESET_B SAR/a_17126_1626# vdd sg13_lv_pmos ad=0.36237p pd=2.605u as=79.8f ps=0.8u w=0.42u l=0.13u
M302 SAR/sg13cmos5l_dfrbp_1_0.D SAR/sg13cmos5l_nor2_1_1.A vss vss sg13_lv_nmos ad=0.1406p pd=1.12u as=0.2516p ps=2.16u w=0.74u l=0.13u
M303 vdd SAR/sg13cmos5l_buf_1_78.A SAR/a_6184_9224# vdd sg13_lv_pmos ad=0.2114p pd=1.54u as=0.2856p ps=2.36u w=0.84u l=0.13u
M304 SAR/a_5194_2356# SAR/a_5637_2399# SAR/a_5577_2435# vdd sg13_lv_pmos ad=79.8f pd=0.8u as=63f ps=0.72u w=0.42u l=0.13u
M305 SAR/a_14543_3215# SAR/a_13701_3117# SAR/a_14449_3215# vss sg13_lv_nmos ad=0.12665p pd=1.145u as=0.1428p ps=1.52u w=0.42u l=0.13u
M306 vss SAR/a_12719_2749# SAR/a_13556_2388# vss sg13_lv_nmos ad=0.1406p pd=1.12u as=0.2516p ps=2.16u w=0.74u l=0.13u
M307 vdd SAR/sg13cmos5l_dfrbp_1_6.RESET_B SAR/a_2054_3138# vdd sg13_lv_pmos ad=0.36237p pd=2.605u as=79.8f ps=0.8u w=0.42u l=0.13u
M308 SAR/sg13cmos5l_buf_8_0.X SAR/a_19227_4654# vss vss sg13_lv_nmos ad=0.1406p pd=1.12u as=0.1406p ps=1.12u w=0.74u l=0.13u
M309 SAR/a_3945_5041# SAR/a_3588_4968# vdd vdd sg13_lv_pmos ad=63f pd=0.72u as=0.1563p ps=1.22u w=0.42u l=0.13u
M310 pl_sw[1] SAR/a_1000_9224# vdd vdd sg13_lv_pmos ad=0.42p pd=2.99u as=0.2114p ps=1.54u w=1.12u l=0.13u
M311 SAR/a_3407_8797# SAR/a_2565_8447# SAR/a_2148_8440# vdd sg13_lv_pmos ad=0.2048p pd=1.63u as=0.34p ps=2.68u w=1u l=0.13u
M312 SAR/a_12815_1703# SAR/a_11973_1605# SAR/a_11556_1944# vdd sg13_lv_pmos ad=0.2048p pd=1.63u as=0.34p ps=2.68u w=1u l=0.13u
M313 vss SAR/sg13cmos5l_dlygate4sd3_1_0.X SAR/sg13cmos5l_buf_1_43.A vss sg13_lv_nmos ad=0.2516p pd=2.16u as=0.2516p ps=2.16u w=0.74u l=0.13u
M314 SAR/sg13cmos5l_buf_1_6.A SAR/a_12520_3176# vss vss sg13_lv_nmos ad=0.2886p pd=2.26u as=0.14875p ps=1.16u w=0.74u l=0.13u
M315 SAR/a_15876_4968# SAR/a_15850_4873# vss vss sg13_lv_nmos ad=0.2516p pd=2.16u as=0.1626p ps=1.415u w=0.74u l=0.13u
M316 ph_sw[0] SAR/a_616_9224# vss vss sg13_lv_nmos ad=0.2886p pd=2.26u as=0.14875p ps=1.16u w=0.74u l=0.13u
M317 SAR/a_11846_9186# SAR/a_12651_9308# SAR/a_12106_9409# vdd sg13_lv_pmos ad=0.1428p pd=1.52u as=79.8f ps=0.8u w=0.42u l=0.13u
M318 vdd SAR/a_4559_7630# SAR/a_4518_7996# vdd sg13_lv_pmos ad=1.15047p pd=7.175u as=0.105p ps=1.21u w=1u l=0.13u
M319 SAR/a_1948_7964# SAR/a_2348_7624# SAR/a_2306_7660# vss sg13_lv_nmos ad=0.2516p pd=2.16u as=77.7f ps=0.95u w=0.74u l=0.13u
M320 SAR/a_15124_7312# SAR/a_14708_6924# SAR/a_14889_7281# vss sg13_lv_nmos ad=77.7f pd=0.95u as=0.2516p ps=2.16u w=0.74u l=0.13u
M321 vss SAR/a_3308_9150# SAR/sg13cmos5l_inv_1_8.A vss sg13_lv_nmos ad=0.14875p pd=1.16u as=0.2886p ps=2.26u w=0.74u l=0.13u
M322 SAR/a_15821_3864# SAR/a_16551_3987# SAR/a_16572_4261# vss sg13_lv_nmos ad=0.12665p pd=1.145u as=0.3473p ps=2.71u w=0.74u l=0.13u
M323 SAR/a_12804_6175# SAR/a_12516_6480# SAR/a_12742_6175# vss sg13_lv_nmos ad=0.1428p pd=1.52u as=37.8f ps=0.6u w=0.42u l=0.13u
M324 SAR/a_8208_6924# SAR/a_7657_7282# vdd vdd sg13_lv_pmos ad=0.105p pd=1.21u as=1.07253p ps=6.75u w=1u l=0.13u
M325 vss SAR/sg13cmos5l_buf_1_5.A SAR/a_14440_1664# vss sg13_lv_nmos ad=0.14875p pd=1.16u as=0.187p ps=1.78u w=0.55u l=0.13u
M326 SAR/sg13cmos5l_a22oi_1_0.Y SAR/sg13cmos5l_a22oi_1_0.B1 SAR/a_10783_3876# vdd sg13_lv_pmos ad=0.2128p pd=1.5u as=0.2716p ps=1.605u w=1.12u l=0.13u
M327 SAR/a_13648_9406# SAR/a_13391_9263# SAR/a_13810_9186# vss sg13_lv_nmos ad=0.1428p pd=1.52u as=37.8f ps=0.6u w=0.42u l=0.13u
M328 SAR/sg13cmos5l_buf_1_103.A SAR/a_15784_9224# vss vss sg13_lv_nmos ad=0.2886p pd=2.26u as=0.14875p ps=1.16u w=0.74u l=0.13u
M329 SAR/a_17414_3138# SAR/a_18219_3260# SAR/a_17674_3361# vdd sg13_lv_pmos ad=0.1428p pd=1.52u as=79.8f ps=0.8u w=0.42u l=0.13u
M330 SAR/sg13cmos5l_dlhr_1_6.D SAR/a_7796_6460# vss vss sg13_lv_nmos ad=0.2516p pd=2.16u as=0.1406p ps=1.12u w=0.74u l=0.13u
M331 vss vdd vss vss sg13_lv_nmos ad=79.8f pd=0.8u as=0 ps=0 w=0.42u l=1u
M332 SAR/a_6959_6239# SAR/a_6117_6141# SAR/a_6865_6239# vss sg13_lv_nmos ad=0.12665p pd=1.145u as=0.1428p ps=1.52u w=0.42u l=0.13u
M333 vss SAR/a_1580_2352# nh_sw[0] vss sg13_lv_nmos ad=0.14875p pd=1.16u as=0.2886p ps=2.26u w=0.74u l=0.13u
M334 SAR/a_7238_7674# SAR/a_8043_7796# SAR/a_7498_7897# vdd sg13_lv_pmos ad=0.1428p pd=1.52u as=79.8f ps=0.8u w=0.42u l=0.13u
M335 SAR/a_14543_3215# SAR/a_13701_3117# SAR/a_13284_3456# vdd sg13_lv_pmos ad=0.2048p pd=1.63u as=0.34p ps=2.68u w=1u l=0.13u
M336 SAR/a_19412_6484# SAR/a_18999_6178# SAR/a_19344_6484# vdd sg13_lv_pmos ad=0.191p pd=1.44u as=0.105p ps=1.21u w=1u l=0.13u
M337 SAR/sg13cmos5l_dlhr_1_15.Q SAR/a_18345_7674# vss vss sg13_lv_nmos ad=0.2516p pd=2.16u as=0.1406p ps=1.12u w=0.74u l=0.13u
M338 vdd SAR/a_4652_6126# SAR/sg13cmos5l_inv_1_19.A vdd sg13_lv_pmos ad=0.2114p pd=1.54u as=0.42p ps=2.99u w=1.12u l=0.13u
M339 vss SAR/sg13cmos5l_dfrbp_1_6.RESET_B SAR/a_13396_7312# vss sg13_lv_nmos ad=0.1406p pd=1.12u as=77.7f ps=0.95u w=0.74u l=0.13u
M340 vdd SAR/a_8588_2352# nl_sw[4] vdd sg13_lv_pmos ad=0.2114p pd=1.54u as=0.42p ps=2.99u w=1.12u l=0.13u
M341 SAR/a_15466_2356# SAR/a_15909_2399# SAR/a_15206_2826# vss sg13_lv_nmos ad=79.8f pd=0.8u as=0.1296p ps=1.52u w=0.42u l=0.13u
M342 SAR/a_16102_4663# SAR/sg13cmos5l_dfrbp_1_8.RESET_B vss vss sg13_lv_nmos ad=37.8f pd=0.6u as=0.1701p ps=1.65u w=0.42u l=0.13u
M343 vdd vss vdd vdd sg13_lv_pmos ad=0.19p pd=1.38u as=0 ps=0 w=1u l=1u
M344 SAR/a_2409_4650# SAR/a_2228_4972# vdd vdd sg13_lv_pmos ad=0.2128p pd=1.5u as=0.2387p ps=1.84u w=1.12u l=0.13u
M345 SAR/a_13017_1941# SAR/a_12075_1748# SAR/a_12815_1703# vdd sg13_lv_pmos ad=93.45f pd=0.865u as=0.2048p ps=1.63u w=0.42u l=0.13u
M346 SAR/a_9040_7894# SAR/sg13cmos5l_dfrbp_1_6.RESET_B vdd vdd sg13_lv_pmos ad=79.8f pd=0.8u as=1.12242p ps=7u w=0.42u l=0.13u
M347 SAR/a_13047_7690# SAR/sg13cmos5l_dlhr_1_11.GATE vss vss sg13_lv_nmos ad=0.2516p pd=2.16u as=0.15055p ps=1.17u w=0.74u l=0.13u
M348 SAR/sg13cmos5l_buf_1_2.X SAR/a_15784_1664# vdd vdd sg13_lv_pmos ad=0.42p pd=2.99u as=0.2114p ps=1.54u w=1.12u l=0.13u
M349 SAR/a_9524_4972# SAR/a_9242_4660# SAR/a_9457_4642# vss sg13_lv_nmos ad=0.141p pd=1.17u as=71.99999f ps=0.865u w=0.64u l=0.13u
M350 vss vdd vss vss sg13_lv_nmos ad=79.8f pd=0.8u as=0 ps=0 w=0.42u l=1u
M351 vdd SAR/sg13cmos5l_dfrbp_1_0.RESET_B SAR/a_11270_4338# vdd sg13_lv_pmos ad=0.36237p pd=2.605u as=79.8f ps=0.8u w=0.42u l=0.13u
M352 vdd SAR/a_19227_4654# SAR/sg13cmos5l_buf_8_0.X vdd sg13_lv_pmos ad=0.3864p pd=2.93u as=0.2128p ps=1.5u w=1.12u l=0.13u
M353 vdd SAR/sg13cmos5l_buf_1_31.X SAR/a_9448_6924# vdd sg13_lv_pmos ad=0.2114p pd=1.54u as=0.2856p ps=2.36u w=0.84u l=0.13u
M354 SAR/a_18999_6178# SAR/sg13cmos5l_dfrbp_1_8.D vdd vdd sg13_lv_pmos ad=0.3234p pd=2.45u as=1.04815p ps=6.595u w=0.84u l=0.13u
M355 SAR/sg13cmos5l_dlhr_1_15.D SAR/a_17108_7972# vdd vdd sg13_lv_pmos ad=0.3808p pd=2.92u as=0.2128p ps=1.5u w=1.12u l=0.13u
M356 SAR/a_1484_9150# SAR/sg13cmos5l_inv_1_19.A vdd vdd sg13_lv_pmos ad=0.2856p pd=2.36u as=0.2114p ps=1.54u w=0.84u l=0.13u
M357 SAR/a_6959_6239# SAR/a_6117_6141# SAR/a_5700_6480# vdd sg13_lv_pmos ad=0.2048p pd=1.63u as=0.34p ps=2.68u w=1u l=0.13u
M358 SAR/sg13cmos5l_dlhr_1_0.Q SAR/a_7689_1626# vss vss sg13_lv_nmos ad=0.2516p pd=2.16u as=0.1406p ps=1.12u w=0.74u l=0.13u
M359 SAR/a_15782_7362# SAR/sg13cmos5l_dfrbp_1_22.D vdd vdd sg13_lv_pmos ad=79.8f pd=0.8u as=0.1428p ps=1.52u w=0.42u l=0.13u
M360 SAR/a_19593_6162# SAR/a_19412_6484# vdd vdd sg13_lv_pmos ad=0.2128p pd=1.5u as=0.2387p ps=1.84u w=1.12u l=0.13u
M361 SAR/a_1125_6935# SAR/sg13cmos5l_dfrbp_1_15.D vdd vdd sg13_lv_pmos ad=0.4088p pd=2.97u as=1.04815p ps=6.595u w=1.12u l=0.13u
M362 vss SAR/a_620_2352# nl_sw[0] vss sg13_lv_nmos ad=0.14875p pd=1.16u as=0.2886p ps=2.26u w=0.74u l=0.13u
M363 SAR/a_5604_4338# SAR/sg13cmos5l_dfrbp_1_6.D SAR/a_5510_4338# vss sg13_lv_nmos ad=60.89999f pd=0.71u as=0.1428p ps=1.52u w=0.42u l=0.13u
M364 SAR/a_5028_2826# SAR/sg13cmos5l_dfrbp_1_6.D SAR/a_4934_2826# vss sg13_lv_nmos ad=60.89999f pd=0.71u as=0.1428p ps=1.52u w=0.42u l=0.13u
M365 SAR/sg13cmos5l_buf_1_104.A SAR/sg13cmos5l_buf_1_3.A vdd vdd sg13_lv_pmos ad=0.3808p pd=2.92u as=0.3808p ps=2.92u w=1.12u l=0.13u
M366 SAR/a_15684_4650# SAR/sg13cmos5l_dfrbp_1_8.D SAR/a_15590_4650# vss sg13_lv_nmos ad=60.89999f pd=0.71u as=0.1428p ps=1.52u w=0.42u l=0.13u
M367 SAR/sg13cmos5l_o21ai_1_0.A1 SAR/sg13cmos5l_a221oi_1_0.C1 vss vss sg13_lv_nmos ad=0.2516p pd=2.16u as=0.1406p ps=1.12u w=0.74u l=0.13u
M368 SAR/a_2474_6162# SAR/a_1997_6126# SAR/a_2380_6162# vss sg13_lv_nmos ad=37.8f pd=0.6u as=0.1428p ps=1.52u w=0.42u l=0.13u
M369 vdd SAR/sg13cmos5l_buf_1_111.A SAR/a_18376_9224# vdd sg13_lv_pmos ad=0.2114p pd=1.54u as=0.2856p ps=2.36u w=0.84u l=0.13u
M370 SAR/a_18097_7666# SAR/a_17545_7728# vss vss sg13_lv_nmos ad=71.99999f pd=0.865u as=1.49685p ps=9.6u w=0.64u l=0.13u
M371 vss SAR/a_3447_2746# SAR/a_3578_2752# vss sg13_lv_nmos ad=2.59257p pd=16.445u as=0.2775p ps=2.23u w=0.74u l=0.13u
M372 vdd SAR/sg13cmos5l_dfrbp_1_6.RESET_B SAR/a_16234_6385# vdd sg13_lv_pmos ad=0.1563p pd=1.22u as=0.147p ps=1.54u w=0.42u l=0.13u
M373 SAR/a_10665_7281# SAR/a_10484_6924# vdd vdd sg13_lv_pmos ad=0.2128p pd=1.5u as=0.2387p ps=1.84u w=1.12u l=0.13u
M374 vdd SAR/sg13cmos5l_dfrbp_1_8.RESET_B SAR/a_6086_4650# vdd sg13_lv_pmos ad=0.36237p pd=2.605u as=79.8f ps=0.8u w=0.42u l=0.13u
M375 vss SAR/sg13cmos5l_buf_8_1.A SAR/a_16703_3871# vss sg13_lv_nmos ad=2.41737p pd=15.64u as=0.2516p ps=2.16u w=0.74u l=0.13u
M376 vdd SAR/sg13cmos5l_nor2_1_0.A SAR/a_13324_4696# vdd sg13_lv_pmos ad=0.1596p pd=1.22u as=0.2856p ps=2.36u w=0.84u l=0.13u
M377 SAR/a_996_5837# SAR/a_1227_5423# SAR/a_682_5380# vss sg13_lv_nmos ad=0.2373p pd=1.97u as=79.8f ps=0.8u w=0.42u l=0.13u
M378 SAR/a_10282_7897# SAR/a_10725_7653# SAR/a_10665_8065# vdd sg13_lv_pmos ad=79.8f pd=0.8u as=63f ps=0.72u w=0.42u l=0.13u
M379 SAR/a_5424_3460# SAR/a_4873_3192# vdd vdd sg13_lv_pmos ad=0.105p pd=1.21u as=1.43437p ps=9.105u w=1u l=0.13u
M380 SAR/a_1402_3864# SAR/sg13cmos5l_dlygate4sd2_1_0.X vss vss sg13_lv_nmos ad=0.1428p pd=1.52u as=79.8f ps=0.8u w=0.42u l=0.13u
M381 vss SAR/sg13cmos5l_inv_1_29.A SAR/a_12841_7728# vss sg13_lv_nmos ad=0.15055p pd=1.17u as=0.187p ps=1.78u w=0.55u l=0.13u
M382 vdd SAR/sg13cmos5l_dfrbp_1_21.Q SAR/a_18409_5770# vdd sg13_lv_pmos ad=1.28962p pd=8.195u as=0.2856p ps=2.36u w=0.84u l=0.13u
M383 vdd SAR/sg13cmos5l_dfrbp_1_10.Q_N SAR/a_3241_2746# vdd sg13_lv_pmos ad=1.86162p pd=11.935u as=0.2856p ps=2.36u w=0.84u l=0.13u
M384 vss SAR/a_19227_9190# SAR/sg13cmos5l_buf_8_2.X vss sg13_lv_nmos ad=0.2516p pd=2.16u as=0.1406p ps=1.12u w=0.74u l=0.13u
M385 vss SAR/a_10071_7282# SAR/a_10202_7288# vss sg13_lv_nmos ad=1.49685p pd=9.6u as=0.2775p ps=2.23u w=0.74u l=0.13u
M386 vdd SAR/a_7504_8678# SAR/a_7449_8559# vdd sg13_lv_pmos ad=1.15047p pd=7.175u as=93.45f ps=0.865u w=0.42u l=0.13u
M387 SAR/a_4282_8112# SAR/a_3676_7964# vdd vdd sg13_lv_pmos ad=0.1008p pd=0.9u as=0.2387p ps=1.84u w=0.42u l=0.13u
M388 SAR/a_682_5380# SAR/a_1125_5423# SAR/a_1065_5459# vdd sg13_lv_pmos ad=79.8f pd=0.8u as=63f ps=0.72u w=0.42u l=0.13u
M389 vdd SAR/a_11824_7894# SAR/a_11769_7989# vdd sg13_lv_pmos ad=1.15047p pd=7.175u as=93.45f ps=0.865u w=0.42u l=0.13u
M390 vdd SAR/a_4425_7281# SAR/a_4358_6924# vdd sg13_lv_pmos ad=0.2387p pd=1.84u as=0.1008p ps=0.9u w=0.42u l=0.13u
M391 SAR/a_2732_1590# SAR/sg13cmos5l_buf_1_37.A vdd vdd sg13_lv_pmos ad=0.2856p pd=2.36u as=0.2114p ps=1.54u w=0.84u l=0.13u
M392 SAR/a_16485_6935# SAR/sg13cmos5l_inv_1_2.A vdd vdd sg13_lv_pmos ad=0.4088p pd=2.97u as=1.07253p ps=6.75u w=1.12u l=0.13u
M393 SAR/a_13036_4948# SAR/a_12814_4692# vdd vdd sg13_lv_pmos ad=0.1176p pd=1.33u as=0.2618p ps=1.63u w=1.12u l=0.13u
M394 vss SAR/a_18615_5770# SAR/a_18746_5776# vss sg13_lv_nmos ad=1.97045p pd=12.335u as=0.2775p ps=2.23u w=0.74u l=0.13u
M395 vdd SAR/a_3574_7850# SAR/sg13cmos5l_dlhr_1_9.Q_N vdd sg13_lv_pmos ad=0.1974p pd=1.5u as=0.3808p ps=2.92u w=1.12u l=0.13u
M396 vdd SAR/a_16271_7751# SAR/a_16528_7894# vdd sg13_lv_pmos ad=0.2639p pd=1.81u as=79.8f ps=0.8u w=0.42u l=0.13u
M397 SAR/a_6084_4325# SAR/a_5796_3904# SAR/a_6022_4325# vss sg13_lv_nmos ad=0.1428p pd=1.52u as=37.8f ps=0.6u w=0.42u l=0.13u
M398 vdd SAR/a_12815_1703# SAR/a_13072_1846# vdd sg13_lv_pmos ad=0.2639p pd=1.81u as=79.8f ps=0.8u w=0.42u l=0.13u
M399 SAR/sg13cmos5l_a22oi_1_1.B2 SAR/sg13cmos5l_dlhr_1_6.D SAR/a_13486_5760# vss sg13_lv_nmos ad=0.2516p pd=2.16u as=0.1406p ps=1.12u w=0.74u l=0.13u
M400 SAR/a_11072_5347# SAR/sg13cmos5l_nor2_1_0.A SAR/a_11370_5760# vss sg13_lv_nmos ad=0.2176p pd=1.96u as=0.1216p ps=1.02u w=0.64u l=0.13u
M401 vss SAR/sg13cmos5l_buf_1_4.A SAR/a_16552_1664# vss sg13_lv_nmos ad=0.14875p pd=1.16u as=0.187p ps=1.78u w=0.55u l=0.13u
M402 vss SAR/a_16485_6935# SAR/a_16587_6935# vss sg13_lv_nmos ad=1.49685p pd=9.6u as=0.2516p ps=2.16u w=0.74u l=0.13u
M403 vss SAR/sg13cmos5l_inv_1_7.A SAR/a_12232_8436# vss sg13_lv_nmos ad=0.14875p pd=1.16u as=0.187p ps=1.78u w=0.55u l=0.13u
M404 vss SAR/a_8972_3864# SAR/sg13cmos5l_buf_1_45.X vss sg13_lv_nmos ad=0.14875p pd=1.16u as=0.2886p ps=2.26u w=0.74u l=0.13u
M405 SAR/a_10308_7992# SAR/a_10827_7796# SAR/a_11567_7751# vss sg13_lv_nmos ad=0.3473p pd=2.71u as=0.12665p ps=1.145u w=0.74u l=0.13u
M406 SAR/sg13cmos5l_dfrbp_1_22.Q_N SAR/a_17327_7285# vdd vdd sg13_lv_pmos ad=0.4312p pd=3.01u as=0.2639p ps=1.81u w=1.12u l=0.13u
M407 SAR/sg13cmos5l_dfrbp_1_17.Q_N SAR/a_3407_8797# vdd vdd sg13_lv_pmos ad=0.4312p pd=3.01u as=0.2639p ps=1.81u w=1.12u l=0.13u
M408 vdd SAR/a_15909_2399# SAR/a_16011_2399# vdd sg13_lv_pmos ad=1.86162p pd=11.935u as=0.3864p ps=2.93u w=1.12u l=0.13u
M409 SAR/a_16306_8874# SAR/sg13cmos5l_dfrbp_1_8.RESET_B vss vss sg13_lv_nmos ad=37.8f pd=0.6u as=79.8f ps=0.8u w=0.42u l=0.13u
M410 SAR/sg13cmos5l_dlhr_1_11.Q_N SAR/a_13686_7354# vss vss sg13_lv_nmos ad=0.2516p pd=2.16u as=0.1491p ps=1.18u w=0.74u l=0.13u
M411 SAR/sg13cmos5l_buf_1_31.X SAR/a_424_1664# vss vss sg13_lv_nmos ad=0.2886p pd=2.26u as=0.14875p ps=1.16u w=0.74u l=0.13u
M412 SAR/a_5069_5376# SAR/a_5799_5499# SAR/a_5710_5535# vdd sg13_lv_pmos ad=0.2048p pd=1.63u as=93.45f ps=0.865u w=0.42u l=0.13u
M413 SAR/a_3664_8678# SAR/a_3407_8797# SAR/a_3826_8874# vss sg13_lv_nmos ad=0.1428p pd=1.52u as=37.8f ps=0.6u w=0.42u l=0.13u
M414 SAR/a_11434_2356# SAR/a_11877_2399# SAR/a_11174_2826# vss sg13_lv_nmos ad=79.8f pd=0.8u as=0.1296p ps=1.52u w=0.42u l=0.13u
M415 vdd SAR/sg13cmos5l_dfrbp_1_8.RESET_B SAR/a_15590_4650# vdd sg13_lv_pmos ad=0.36237p pd=2.605u as=79.8f ps=0.8u w=0.42u l=0.13u
M416 SAR/sg13cmos5l_buf_1_3.A SAR/a_19528_6924# vss vss sg13_lv_nmos ad=0.2886p pd=2.26u as=0.14875p ps=1.16u w=0.74u l=0.13u
M417 vdd SAR/sg13cmos5l_dfrbp_1_6.D SAR/a_17399_3947# vdd sg13_lv_pmos ad=0.1428p pd=1.52u as=79.8f ps=0.8u w=0.42u l=0.13u
M418 vdd SAR/sg13cmos5l_buf_8_1.A SAR/a_18363_4270# vdd sg13_lv_pmos ad=0.2128p pd=1.5u as=0.3808p ps=2.92u w=1.12u l=0.13u
M419 SAR/a_1065_6971# SAR/a_708_6928# vdd vdd sg13_lv_pmos ad=63f pd=0.72u as=0.1563p ps=1.22u w=0.42u l=0.13u
M420 SAR/a_17700_1639# SAR/a_17412_1944# SAR/a_17638_1639# vss sg13_lv_nmos ad=0.1428p pd=1.52u as=37.8f ps=0.6u w=0.42u l=0.13u
M421 SAR/a_11986_7674# SAR/sg13cmos5l_dfrbp_1_6.RESET_B vss vss sg13_lv_nmos ad=37.8f pd=0.6u as=79.8f ps=0.8u w=0.42u l=0.13u
M422 SAR/a_7689_1626# SAR/a_7508_1948# vdd vdd sg13_lv_pmos ad=0.2128p pd=1.5u as=0.2387p ps=1.84u w=1.12u l=0.13u
M423 vdd SAR/sg13cmos5l_dfrbp_1_0.RESET_B SAR/a_11530_1849# vdd sg13_lv_pmos ad=0.1563p pd=1.22u as=0.147p ps=1.54u w=0.42u l=0.13u
M424 vdd SAR/a_3308_5376# SAR/sg13cmos5l_buf_1_41.A vdd sg13_lv_pmos ad=0.2114p pd=1.54u as=0.42p ps=2.99u w=1.12u l=0.13u
M425 SAR/a_16042_6892# SAR/a_16485_6935# SAR/a_16425_6971# vdd sg13_lv_pmos ad=79.8f pd=0.8u as=63f ps=0.72u w=0.42u l=0.13u
M426 SAR/a_12420_9199# SAR/a_12132_9504# SAR/a_12358_9199# vss sg13_lv_nmos ad=0.1428p pd=1.52u as=37.8f ps=0.6u w=0.42u l=0.13u
M427 vdd SAR/sg13cmos5l_dfrbp_1_6.RESET_B SAR/a_5674_6385# vdd sg13_lv_pmos ad=0.1563p pd=1.22u as=0.147p ps=1.54u w=0.42u l=0.13u
M428 vdd SAR/a_2565_8447# SAR/a_2667_8447# vdd sg13_lv_pmos ad=1.15047p pd=7.175u as=0.3864p ps=2.93u w=1.12u l=0.13u
M429 vdd SAR/a_18671_1703# SAR/a_19508_1924# vdd sg13_lv_pmos ad=0.2128p pd=1.5u as=0.3864p ps=2.93u w=1.12u l=0.13u
M430 SAR/sg13cmos5l_dlygate4sd2_1_0.X SAR/a_1290_3206# vdd vdd sg13_lv_pmos ad=0.3808p pd=2.92u as=0.2245p ps=1.53u w=1.12u l=0.13u
M431 vdd SAR/a_7055_4261# SAR/a_7312_4142# vdd sg13_lv_pmos ad=0.2639p pd=1.81u as=79.8f ps=0.8u w=0.42u l=0.13u
M432 SAR/a_4005_4629# SAR/sg13cmos5l_inv_1_8.A vdd vdd sg13_lv_pmos ad=0.4088p pd=2.97u as=1.2517p ps=7.955u w=1.12u l=0.13u
M433 SAR/a_934_5837# SAR/sg13cmos5l_dfrbp_1_6.RESET_B vss vss sg13_lv_nmos ad=37.8f pd=0.6u as=0.1701p ps=1.65u w=0.42u l=0.13u
M434 SAR/a_7378_6162# SAR/sg13cmos5l_dfrbp_1_6.RESET_B vss vss sg13_lv_nmos ad=37.8f pd=0.6u as=79.8f ps=0.8u w=0.42u l=0.13u
M435 vss SAR/sg13cmos5l_buf_1_35.A SAR/a_1864_1664# vss sg13_lv_nmos ad=0.14875p pd=1.16u as=0.187p ps=1.78u w=0.55u l=0.13u
M436 vss SAR/a_16528_7894# SAR/a_16177_7751# vss sg13_lv_nmos ad=79.8f pd=0.8u as=0.1428p ps=1.52u w=0.42u l=0.13u
M437 SAR/sg13cmos5l_buf_8_0.X SAR/a_19227_4654# vss vss sg13_lv_nmos ad=0.1406p pd=1.12u as=0.1406p ps=1.12u w=0.74u l=0.13u
M438 SAR/a_2596_7996# SAR/a_2621_7636# vdd vdd sg13_lv_pmos ad=0.2856p pd=2.36u as=1.15047p ps=7.175u w=0.84u l=0.13u
M439 SAR/sg13cmos5l_dfrbp_1_1.D SAR/sg13cmos5l_a22oi_1_2.B1 SAR/a_9823_2364# vdd sg13_lv_pmos ad=0.2128p pd=1.5u as=0.2716p ps=1.605u w=1.12u l=0.13u
M440 vdd SAR/a_13391_9263# SAR/a_14228_9484# vdd sg13_lv_pmos ad=0.2128p pd=1.5u as=0.3864p ps=2.93u w=1.12u l=0.13u
M441 vdd SAR/a_3599_3215# SAR/a_4436_3436# vdd sg13_lv_pmos ad=0.2128p pd=1.5u as=0.3864p ps=2.93u w=1.12u l=0.13u
M442 vss SAR/sg13cmos5l_or2_1_1.B SAR/a_11873_5760# vss sg13_lv_nmos ad=0.2516p pd=2.16u as=0.1406p ps=1.12u w=0.74u l=0.13u
M443 SAR/a_17337_4965# SAR/a_16395_4772# SAR/a_17135_4727# vdd sg13_lv_pmos ad=93.45f pd=0.865u as=0.2048p ps=1.63u w=0.42u l=0.13u
M444 vss SAR/sg13cmos5l_dfrbp_1_6.RESET_B SAR/a_9076_5800# vss sg13_lv_nmos ad=0.1406p pd=1.12u as=77.7f ps=0.95u w=0.74u l=0.13u
M445 SAR/sg13cmos5l_dlhr_1_17.Q_N SAR/a_9366_5842# vdd vdd sg13_lv_pmos ad=0.3808p pd=2.92u as=0.1974p ps=1.5u w=1.12u l=0.13u
M446 vss vdd vss vss sg13_lv_nmos ad=0.1428p pd=1.52u as=0 ps=0 w=0.42u l=1u
M447 vss vdd vss vss sg13_lv_nmos ad=79.8f pd=0.8u as=0 ps=0 w=0.42u l=1u
M448 SAR/a_6729_5041# SAR/a_6372_4968# vdd vdd sg13_lv_pmos ad=63f pd=0.72u as=0.1563p ps=1.22u w=0.42u l=0.13u
M449 SAR/a_16617_6553# SAR/a_16260_6480# vdd vdd sg13_lv_pmos ad=63f pd=0.72u as=0.1563p ps=1.22u w=0.42u l=0.13u
M450 vss SAR/a_9033_6162# SAR/a_8988_6198# vss sg13_lv_nmos ad=0.1428p pd=1.52u as=47.25f ps=0.645u w=0.42u l=0.13u
M451 SAR/sg13cmos5l_dlhr_1_1.Q_N SAR/a_2934_4632# vss vss sg13_lv_nmos ad=0.2516p pd=2.16u as=0.1491p ps=1.18u w=0.74u l=0.13u
M452 SAR/sg13cmos5l_dfrbp_1_4.D SAR/sg13cmos5l_nand2_1_1.B SAR/a_10707_2388# vdd sg13_lv_pmos ad=0.2408p pd=1.55u as=0.1428p ps=1.375u w=1.12u l=0.13u
M453 vdd comp_p SAR/a_424_1664# vdd sg13_lv_pmos ad=0.2114p pd=1.54u as=0.2856p ps=2.36u w=0.84u l=0.13u
M454 nh_sw[10] SAR/a_20392_3176# vss vss sg13_lv_nmos ad=0.2886p pd=2.26u as=0.14875p ps=1.16u w=0.74u l=0.13u
M455 SAR/sg13cmos5l_or2_1_0.A SAR/a_18363_4270# vss vss sg13_lv_nmos ad=0.1406p pd=1.12u as=0.1406p ps=1.12u w=0.74u l=0.13u
M456 SAR/a_17126_1626# SAR/a_17931_1748# SAR/a_17386_1849# vdd sg13_lv_pmos ad=0.1428p pd=1.52u as=79.8f ps=0.8u w=0.42u l=0.13u
M457 SAR/sg13cmos5l_dfrbp_1_18.Q SAR/a_8084_8436# vss vss sg13_lv_nmos ad=0.2516p pd=2.16u as=0.1406p ps=1.12u w=0.74u l=0.13u
M458 SAR/a_708_6928# SAR/a_1227_6935# SAR/a_1967_7285# vss sg13_lv_nmos ad=0.3473p pd=2.71u as=0.12665p ps=1.145u w=0.74u l=0.13u
M459 SAR/sg13cmos5l_dlhr_1_5.Q_N SAR/a_8982_7354# vss vss sg13_lv_nmos ad=0.2516p pd=2.16u as=0.1491p ps=1.18u w=0.74u l=0.13u
M460 SAR/a_2757_3117# SAR/sg13cmos5l_dfrbp_1_9.Q vss vss sg13_lv_nmos ad=0.2516p pd=2.16u as=2.59257p ps=16.445u w=0.74u l=0.13u
M461 SAR/a_9456_4972# SAR/a_8905_4704# vdd vdd sg13_lv_pmos ad=0.105p pd=1.21u as=1.28962p ps=8.195u w=1u l=0.13u
M462 vss SAR/sg13cmos5l_dfrbp_1_8.RESET_B SAR/a_1956_8874# vss sg13_lv_nmos ad=0.1626p pd=1.415u as=60.89999f ps=0.71u w=0.42u l=0.13u
M463 SAR/a_19028_5412# SAR/a_18746_5776# SAR/a_18961_5814# vss sg13_lv_nmos ad=0.141p pd=1.17u as=71.99999f ps=0.865u w=0.64u l=0.13u
M464 SAR/a_7524_7992# SAR/a_7498_7897# vss vss sg13_lv_nmos ad=0.2516p pd=2.16u as=0.1626p ps=1.415u w=0.74u l=0.13u
M465 SAR/a_17412_1944# SAR/a_17386_1849# vdd vdd sg13_lv_pmos ad=0.34p pd=2.68u as=0.36237p ps=2.605u w=1u l=0.13u
M466 SAR/a_9268_6148# SAR/a_8852_6484# SAR/a_9033_6162# vss sg13_lv_nmos ad=77.7f pd=0.95u as=0.2516p ps=2.16u w=0.74u l=0.13u
M467 vss SAR/a_18363_4270# SAR/sg13cmos5l_or2_1_0.A vss sg13_lv_nmos ad=0.1406p pd=1.12u as=0.1406p ps=1.12u w=0.74u l=0.13u
M468 SAR/a_11556_1944# SAR/a_11530_1849# vss vss sg13_lv_nmos ad=0.2516p pd=2.16u as=0.1626p ps=1.415u w=0.74u l=0.13u
M469 vdd SAR/a_19227_4654# SAR/sg13cmos5l_buf_8_0.X vdd sg13_lv_pmos ad=0.2128p pd=1.5u as=0.2128p ps=1.5u w=1.12u l=0.13u
M470 vss _cks SAR/sg13cmos5l_dfrbp_1_6.RESET_B vss sg13_lv_nmos ad=0.2516p pd=2.16u as=0.1443p ps=1.13u w=0.74u l=0.13u
M471 SAR/a_14708_6924# SAR/a_14295_7282# SAR/a_14640_6924# vdd sg13_lv_pmos ad=0.191p pd=1.44u as=0.105p ps=1.21u w=1u l=0.13u
M472 SAR/a_15718_2813# SAR/sg13cmos5l_dfrbp_1_0.RESET_B vss vss sg13_lv_nmos ad=37.8f pd=0.6u as=0.1701p ps=1.65u w=0.42u l=0.13u
M473 SAR/a_2340_3456# SAR/a_2314_3361# vdd vdd sg13_lv_pmos ad=0.34p pd=2.68u as=0.36237p ps=2.605u w=1u l=0.13u
M474 SAR/sg13cmos5l_buf_8_2.X SAR/a_19227_9190# vdd vdd sg13_lv_pmos ad=0.2128p pd=1.5u as=0.2128p ps=1.5u w=1.12u l=0.13u
M475 SAR/a_2386_7362# SAR/sg13cmos5l_dfrbp_1_6.RESET_B vss vss sg13_lv_nmos ad=37.8f pd=0.6u as=79.8f ps=0.8u w=0.42u l=0.13u
M476 vdd SAR/sg13cmos5l_buf_8_0.X SAR/a_20392_7712# vdd sg13_lv_pmos ad=0.2114p pd=1.54u as=0.2856p ps=2.36u w=0.84u l=0.13u
M477 SAR/a_2596_7996# SAR/a_2621_7636# vss vss sg13_lv_nmos ad=0.2775p pd=2.23u as=1.49685p ps=9.6u w=0.74u l=0.13u
M478 vss SAR/sg13cmos5l_buf_1_30.A SAR/a_8680_1664# vss sg13_lv_nmos ad=0.14875p pd=1.16u as=0.187p ps=1.78u w=0.55u l=0.13u
M479 SAR/a_17750_4325# SAR/a_16572_4261# SAR/a_17354_4180# vss sg13_lv_nmos ad=37.8f pd=0.6u as=0.1428p ps=1.52u w=0.42u l=0.13u
M480 SAR/a_16268_3102# SAR/sg13cmos5l_buf_1_2.X vss vss sg13_lv_nmos ad=0.187p pd=1.78u as=0.14875p ps=1.16u w=0.55u l=0.13u
M481 SAR/sg13cmos5l_dfrbp_1_23.Q_N SAR/a_13775_6239# vss vss sg13_lv_nmos ad=0.2849p pd=2.25u as=0.2516p ps=2.16u w=0.74u l=0.13u
M482 SAR/a_13284_3456# SAR/a_13258_3361# vss vss sg13_lv_nmos ad=0.2516p pd=2.16u as=0.1626p ps=1.415u w=0.74u l=0.13u
M483 vss SAR/sg13cmos5l_inv_1_29.A SAR/sg13cmos5l_inv_1_29.Y vss sg13_lv_nmos ad=0.2516p pd=2.16u as=0.2516p ps=2.16u w=0.74u l=0.13u
M484 SAR/a_2831_7630# SAR/sg13cmos5l_dfrbp_1_16.Q_N vdd vdd sg13_lv_pmos ad=0.2856p pd=2.36u as=1.15047p ps=7.175u w=0.84u l=0.13u
M485 vss SAR/sg13cmos5l_buf_1_3.A SAR/a_20296_1664# vss sg13_lv_nmos ad=0.14875p pd=1.16u as=0.187p ps=1.78u w=0.55u l=0.13u
M486 vdd SAR/sg13cmos5l_buf_1_41.X SAR/a_2824_2388# vdd sg13_lv_pmos ad=0.2114p pd=1.54u as=0.2856p ps=2.36u w=0.84u l=0.13u
M487 vss SAR/sg13cmos5l_buf_1_8.X SAR/a_11656_3176# vss sg13_lv_nmos ad=0.14875p pd=1.16u as=0.187p ps=1.78u w=0.55u l=0.13u
M488 SAR/a_19412_6484# SAR/a_19130_6172# SAR/a_19345_6154# vss sg13_lv_nmos ad=0.141p pd=1.17u as=71.99999f ps=0.865u w=0.64u l=0.13u
M489 SAR/a_16068_6162# SAR/sg13cmos5l_buf_1_57.X SAR/a_15974_6162# vss sg13_lv_nmos ad=60.89999f pd=0.71u as=0.1428p ps=1.52u w=0.42u l=0.13u
M490 vdd SAR/sg13cmos5l_buf_1_65.X SAR/a_8488_9224# vdd sg13_lv_pmos ad=0.2114p pd=1.54u as=0.2856p ps=2.36u w=0.84u l=0.13u
M491 vss SAR/sg13cmos5l_buf_1_76.X SAR/a_5416_9224# vss sg13_lv_nmos ad=0.14875p pd=1.16u as=0.187p ps=1.78u w=0.55u l=0.13u
M492 vdd SAR/sg13cmos5l_dfrbp_1_6.RESET_B SAR/a_9705_4650# vdd sg13_lv_pmos ad=0.2128p pd=1.5u as=0.2128p ps=1.5u w=1.12u l=0.13u
M493 vss SAR/a_15821_3864# SAR/sg13cmos5l_dfrbp_1_6.Q_N vss sg13_lv_nmos ad=0.2516p pd=2.16u as=0.2849p ps=2.25u w=0.74u l=0.13u
M494 SAR/a_9260_2352# SAR/sg13cmos5l_buf_1_30.X vss vss sg13_lv_nmos ad=0.187p pd=1.78u as=0.14875p ps=1.16u w=0.55u l=0.13u
M495 vdd SAR/sg13cmos5l_inv_1_19.A SAR/sg13cmos5l_buf_1_32.A vdd sg13_lv_pmos ad=0.3808p pd=2.92u as=0.3808p ps=2.92u w=1.12u l=0.13u
M496 vdd SAR/sg13cmos5l_dfrbp_1_6.RESET_B SAR/a_5510_4338# vdd sg13_lv_pmos ad=0.36237p pd=2.605u as=79.8f ps=0.8u w=0.42u l=0.13u
M497 vdd SAR/sg13cmos5l_buf_1_4.A SAR/sg13cmos5l_buf_1_110.A vdd sg13_lv_pmos ad=0.3808p pd=2.92u as=0.3808p ps=2.92u w=1.12u l=0.13u
M498 SAR/a_10292_9508# SAR/a_9879_9202# SAR/a_10224_9508# vdd sg13_lv_pmos ad=0.191p pd=1.44u as=0.105p ps=1.21u w=1u l=0.13u
M499 vss SAR/a_10031_8797# SAR/a_10868_8436# vss sg13_lv_nmos ad=0.1406p pd=1.12u as=0.2516p ps=2.16u w=0.74u l=0.13u
M500 vdd SAR/sg13cmos5l_buf_8_0.A SAR/a_19227_4654# vdd sg13_lv_pmos ad=0.2128p pd=1.5u as=0.3808p ps=2.92u w=1.12u l=0.13u
M501 vdd SAR/a_7631_4727# SAR/a_8468_4948# vdd sg13_lv_pmos ad=0.2128p pd=1.5u as=0.3864p ps=2.93u w=1.12u l=0.13u
M502 vdd SAR/sg13cmos5l_inv_1_3.A SAR/a_15016_9224# vdd sg13_lv_pmos ad=0.2114p pd=1.54u as=0.2856p ps=2.36u w=0.84u l=0.13u
M503 SAR/sg13cmos5l_dfrbp_1_8.RESET_B _cks vss vss sg13_lv_nmos ad=0.2516p pd=2.16u as=0.2516p ps=2.16u w=0.74u l=0.13u
M504 vss SAR/a_3212_1590# SAR/sg13cmos5l_buf_1_41.X vss sg13_lv_nmos ad=0.14875p pd=1.16u as=0.2886p ps=2.26u w=0.74u l=0.13u
M505 vss vdd vss vss sg13_lv_nmos ad=79.8f pd=0.8u as=0 ps=0 w=0.42u l=1u
M506 SAR/a_2148_3904# SAR/a_2122_3868# vdd vdd sg13_lv_pmos ad=0.34p pd=2.68u as=0.36237p ps=2.605u w=1u l=0.13u
M507 SAR/sg13cmos5l_buf_1_4.A SAR/a_15592_6200# vss vss sg13_lv_nmos ad=0.2886p pd=2.26u as=0.14875p ps=1.16u w=0.74u l=0.13u
M508 vss SAR/a_19227_9190# SAR/sg13cmos5l_buf_8_2.X vss sg13_lv_nmos ad=0.1406p pd=1.12u as=0.1406p ps=1.12u w=0.74u l=0.13u
M509 vdd vss vdd vdd sg13_lv_pmos ad=0.19p pd=1.38u as=0 ps=0 w=1u l=1u
M510 SAR/a_11460_2392# SAR/a_11434_2356# vss vss sg13_lv_nmos ad=0.2516p pd=2.16u as=0.1626p ps=1.415u w=0.74u l=0.13u
M511 SAR/a_2757_3117# SAR/sg13cmos5l_dfrbp_1_9.Q vdd vdd sg13_lv_pmos ad=0.4088p pd=2.97u as=1.38655p ps=8.8u w=1.12u l=0.13u
M512 SAR/a_14342_8874# SAR/sg13cmos5l_dfrbp_1_23.CLK vdd vdd sg13_lv_pmos ad=79.8f pd=0.8u as=0.1428p ps=1.52u w=0.42u l=0.13u
M513 SAR/sg13cmos5l_dlhr_1_17.Q_N SAR/a_9366_5842# vss vss sg13_lv_nmos ad=0.2516p pd=2.16u as=0.1491p ps=1.18u w=0.74u l=0.13u
M514 vdd SAR/a_5069_5376# SAR/sg13cmos5l_dfrbp_1_29.Q_N vdd sg13_lv_pmos ad=0.2639p pd=1.81u as=0.4312p ps=3.01u w=1.12u l=0.13u
M515 SAR/a_15238_7687# SAR/sg13cmos5l_dfrbp_1_6.RESET_B vss vss sg13_lv_nmos ad=37.8f pd=0.6u as=0.1701p ps=1.65u w=0.42u l=0.13u
M516 vss vdd vss vss sg13_lv_nmos ad=79.8f pd=0.8u as=0 ps=0 w=0.42u l=1u
M517 SAR/a_5820_5773# SAR/a_5951_5383# SAR/a_5069_5376# vdd sg13_lv_pmos ad=0.34p pd=2.68u as=0.2048p ps=1.63u w=1u l=0.13u
M518 SAR/a_8841_5769# SAR/a_8660_5412# vdd vdd sg13_lv_pmos ad=0.2128p pd=1.5u as=0.2387p ps=1.84u w=1.12u l=0.13u
M519 SAR/a_2732_9150# SAR/sg13cmos5l_inv_1_20.Y vss vss sg13_lv_nmos ad=0.187p pd=1.78u as=0.14875p ps=1.16u w=0.55u l=0.13u
M520 SAR/a_15206_2826# SAR/sg13cmos5l_nor2b_1_1.Y vdd vdd sg13_lv_pmos ad=79.8f pd=0.8u as=0.1428p ps=1.52u w=0.42u l=0.13u
M521 vdd SAR/sg13cmos5l_dfrbp_1_8.RESET_B SAR/a_2122_3868# vdd sg13_lv_pmos ad=0.1563p pd=1.22u as=0.147p ps=1.54u w=0.42u l=0.13u
M522 SAR/a_15012_7992# SAR/a_14986_7897# vss vss sg13_lv_nmos ad=0.2516p pd=2.16u as=0.1626p ps=1.415u w=0.74u l=0.13u
M523 vdd SAR/a_4041_2745# SAR/a_4566_2818# vdd sg13_lv_pmos ad=0.1974p pd=1.5u as=0.2856p ps=2.36u w=0.84u l=0.13u
M524 SAR/a_1125_5423# SAR/sg13cmos5l_dlhr_1_1.GATE vss vss sg13_lv_nmos ad=0.2516p pd=2.16u as=1.97045p ps=12.335u w=0.74u l=0.13u
M525 ph_sw[4] SAR/a_6568_9224# vss vss sg13_lv_nmos ad=0.2886p pd=2.26u as=0.14875p ps=1.16u w=0.74u l=0.13u
M526 vdd SAR/sg13cmos5l_nand2_1_1.B SAR/a_10464_2427# vdd sg13_lv_pmos ad=0.2891p pd=1.695u as=0.1596p ps=1.22u w=0.84u l=0.13u
M527 SAR/a_11913_3947# SAR/a_11556_3904# vdd vdd sg13_lv_pmos ad=63f pd=0.72u as=0.1563p ps=1.22u w=0.42u l=0.13u
M528 vdd SAR/a_3831_7282# SAR/a_3962_7288# vdd sg13_lv_pmos ad=1.07253p pd=6.75u as=0.2856p ps=2.36u w=0.84u l=0.13u
M529 SAR/a_13574_8112# SAR/a_13178_7684# SAR/a_13460_7996# vdd sg13_lv_pmos ad=0.1008p pd=0.9u as=0.191p ps=1.44u w=0.42u l=0.13u
M530 SAR/a_1878_6337# SAR/a_1997_6126# vdd vdd sg13_lv_pmos ad=0.3864p pd=2.93u as=0.2128p ps=1.5u w=1.12u l=0.13u
M531 SAR/a_13418_4696# SAR/sg13cmos5l_nor2_1_0.A SAR/a_13324_4696# vss sg13_lv_nmos ad=0.1216p pd=1.02u as=0.2176p ps=1.96u w=0.64u l=0.13u
M532 SAR/a_6372_4968# SAR/a_6346_4873# vdd vdd sg13_lv_pmos ad=0.34p pd=2.68u as=0.36237p ps=2.605u w=1u l=0.13u
M533 vss _cks SAR/sg13cmos5l_dfrbp_1_6.RESET_B vss sg13_lv_nmos ad=0.1406p pd=1.12u as=0.1406p ps=1.12u w=0.74u l=0.13u
M534 vss _cks SAR/a_19227_9190# vss sg13_lv_nmos ad=0.1406p pd=1.12u as=0.2553p ps=2.17u w=0.74u l=0.13u
M535 vdd SAR/sg13cmos5l_dfrbp_1_12.Q_N SAR/a_8905_4704# vdd sg13_lv_pmos ad=1.28962p pd=8.195u as=0.2856p ps=2.36u w=0.84u l=0.13u
M536 SAR/a_1484_6126# SAR/sg13cmos5l_buf_1_58.A vdd vdd sg13_lv_pmos ad=0.2856p pd=2.36u as=0.2114p ps=1.54u w=0.84u l=0.13u
M537 SAR/sg13cmos5l_dlhr_1_2.Q SAR/a_7497_3138# vdd vdd sg13_lv_pmos ad=0.3808p pd=2.92u as=0.2128p ps=1.5u w=1.12u l=0.13u
M538 SAR/sg13cmos5l_buf_8_2.X SAR/a_19227_9190# vdd vdd sg13_lv_pmos ad=0.2128p pd=1.5u as=0.2128p ps=1.5u w=1.12u l=0.13u
M539 vss SAR/a_2409_4650# SAR/a_2934_4632# vss sg13_lv_nmos ad=0.1491p pd=1.18u as=0.187p ps=1.78u w=0.55u l=0.13u
M540 SAR/a_18860_6888# SAR/sg13cmos5l_buf_1_87.A vss vss sg13_lv_nmos ad=0.187p pd=1.78u as=0.14875p ps=1.16u w=0.55u l=0.13u
M541 vss SAR/a_19244_2352# nl_sw[9] vss sg13_lv_nmos ad=0.14875p pd=1.16u as=0.2886p ps=2.26u w=0.74u l=0.13u
M542 vss vdd vss vss sg13_lv_nmos ad=0.1428p pd=1.52u as=0 ps=0 w=0.42u l=1u
M543 SAR/a_5508_6162# SAR/sg13cmos5l_dfrbp_1_6.D SAR/a_5414_6162# vss sg13_lv_nmos ad=60.89999f pd=0.71u as=0.1428p ps=1.52u w=0.42u l=0.13u
M544 SAR/sg13cmos5l_dfrbp_1_6.RESET_B _cks vdd vdd sg13_lv_pmos ad=0.2128p pd=1.5u as=0.2128p ps=1.5u w=1.12u l=0.13u
M545 vdd SAR/a_3407_4261# SAR/a_4244_3900# vdd sg13_lv_pmos ad=0.2128p pd=1.5u as=0.3864p ps=2.93u w=1.12u l=0.13u
M546 vss SAR/sg13cmos5l_or2_1_0.A SAR/a_18480_5028# vss sg13_lv_nmos ad=0.1469p pd=1.155u as=0.1045p ps=0.93u w=0.55u l=0.13u
M547 vss SAR/a_5637_2399# SAR/a_5739_2399# vss sg13_lv_nmos ad=2.59257p pd=16.445u as=0.2516p ps=2.16u w=0.74u l=0.13u
M548 SAR/a_7508_1948# SAR/a_7226_1636# SAR/a_7441_1618# vss sg13_lv_nmos ad=0.141p pd=1.17u as=71.99999f ps=0.865u w=0.64u l=0.13u
M549 vss SAR/a_3664_8678# SAR/a_3313_8797# vss sg13_lv_nmos ad=79.8f pd=0.8u as=0.1428p ps=1.52u w=0.42u l=0.13u
M550 vdd SAR/a_13076_5376# SAR/a_13034_5412# vdd sg13_lv_pmos ad=0.2618p pd=1.63u as=0.1176p ps=1.33u w=1.12u l=0.13u
M551 vdd SAR/a_16268_1590# nl_sw[7] vdd sg13_lv_pmos ad=0.2114p pd=1.54u as=0.42p ps=2.99u w=1.12u l=0.13u
M552 vdd SAR/sg13cmos5l_dfrbp_1_0.RESET_B SAR/a_11270_1626# vdd sg13_lv_pmos ad=0.36237p pd=2.605u as=79.8f ps=0.8u w=0.42u l=0.13u
M553 SAR/sg13cmos5l_dfrbp_1_10.Q_N SAR/a_3599_3215# vss vss sg13_lv_nmos ad=0.2849p pd=2.25u as=0.2516p ps=2.16u w=0.74u l=0.13u
M554 SAR/a_3588_4968# SAR/a_4107_4772# SAR/a_4847_4727# vss sg13_lv_nmos ad=0.3473p pd=2.71u as=0.12665p ps=1.145u w=0.74u l=0.13u
M555 SAR/a_14929_5814# SAR/a_14377_5770# vss vss sg13_lv_nmos ad=71.99999f pd=0.865u as=1.97045p ps=12.335u w=0.64u l=0.13u
M556 vdd SAR/a_10665_7281# SAR/a_11190_7354# vdd sg13_lv_pmos ad=0.1974p pd=1.5u as=0.2856p ps=2.36u w=0.84u l=0.13u
M557 SAR/a_3792_2388# SAR/a_3241_2746# vdd vdd sg13_lv_pmos ad=0.105p pd=1.21u as=1.86162p ps=11.935u w=1u l=0.13u
M558 vdd SAR/a_17132_9150# ph_sw[7] vdd sg13_lv_pmos ad=0.2114p pd=1.54u as=0.42p ps=2.99u w=1.12u l=0.13u
M559 vdd SAR/sg13cmos5l_inv_1_17.A SAR/sg13cmos5l_buf_1_37.A vdd sg13_lv_pmos ad=0.3808p pd=2.92u as=0.3808p ps=2.92u w=1.12u l=0.13u
M560 SAR/a_18959_3215# SAR/a_18117_3117# SAR/a_18865_3215# vss sg13_lv_nmos ad=0.12665p pd=1.145u as=0.1428p ps=1.52u w=0.42u l=0.13u
M561 SAR/a_6188_1590# SAR/sg13cmos5l_buf_1_25.A vdd vdd sg13_lv_pmos ad=0.2856p pd=2.36u as=0.2114p ps=1.54u w=0.84u l=0.13u
M562 nh_sw[2] SAR/a_3688_1664# vss vss sg13_lv_nmos ad=0.2886p pd=2.26u as=0.14875p ps=1.16u w=0.74u l=0.13u
M563 SAR/sg13cmos5l_dfrbp_1_2.Q_N SAR/a_12815_4261# vss vss sg13_lv_nmos ad=0.2849p pd=2.25u as=0.2516p ps=2.16u w=0.74u l=0.13u
M564 SAR/a_6789_4629# SAR/sg13cmos5l_inv_1_8.A vdd vdd sg13_lv_pmos ad=0.4088p pd=2.97u as=1.2517p ps=7.955u w=1.12u l=0.13u
M565 SAR/a_708_5416# SAR/a_682_5380# vss vss sg13_lv_nmos ad=0.2516p pd=2.16u as=0.1626p ps=1.415u w=0.74u l=0.13u
M566 vdd SAR/sg13cmos5l_buf_1_105.A SAR/a_18856_8436# vdd sg13_lv_pmos ad=0.2114p pd=1.54u as=0.2856p ps=2.36u w=0.84u l=0.13u
M567 SAR/a_15876_4968# SAR/a_15850_4873# vdd vdd sg13_lv_pmos ad=0.34p pd=2.68u as=0.36237p ps=2.605u w=1u l=0.13u
M568 ph_sw[3] SAR/a_5416_9224# vdd vdd sg13_lv_pmos ad=0.42p pd=2.99u as=0.2114p ps=1.54u w=1.12u l=0.13u
M569 SAR/a_19227_9190# _cks vdd vdd sg13_lv_pmos ad=0.2128p pd=1.5u as=0.2128p ps=1.5u w=1.12u l=0.13u
M570 vdd SAR/sg13cmos5l_dfrbp_1_0.RESET_B SAR/a_11174_2826# vdd sg13_lv_pmos ad=0.36237p pd=2.605u as=79.8f ps=0.8u w=0.42u l=0.13u
M571 SAR/a_16298_4338# SAR/a_15821_3864# SAR/a_16204_4338# vss sg13_lv_nmos ad=37.8f pd=0.6u as=0.1428p ps=1.52u w=0.42u l=0.13u
M572 SAR/sg13cmos5l_dfrbp_1_23.Q SAR/a_14612_6460# vss vss sg13_lv_nmos ad=0.2516p pd=2.16u as=0.1406p ps=1.12u w=0.74u l=0.13u
M573 SAR/a_14800_3358# SAR/a_14543_3215# SAR/a_14962_3138# vss sg13_lv_nmos ad=0.1428p pd=1.52u as=37.8f ps=0.6u w=0.42u l=0.13u
M574 SAR/sg13cmos5l_buf_1_8.A SAR/sg13cmos5l_inv_1_7.A vss vss sg13_lv_nmos ad=0.2516p pd=2.16u as=0.2516p ps=2.16u w=0.74u l=0.13u
M575 SAR/sg13cmos5l_dfrbp_1_0.Q_N SAR/a_18671_1703# vss vss sg13_lv_nmos ad=0.2849p pd=2.25u as=0.2516p ps=2.16u w=0.74u l=0.13u
M576 vss SAR/sg13cmos5l_inv_1_28.Y SAR/a_11464_9224# vss sg13_lv_nmos ad=0.14875p pd=1.16u as=0.187p ps=1.78u w=0.55u l=0.13u
M577 SAR/a_19142_5412# SAR/a_18746_5776# SAR/a_19028_5412# vdd sg13_lv_pmos ad=0.1008p pd=0.9u as=0.191p ps=1.44u w=0.42u l=0.13u
M578 vdd SAR/a_4076_5376# SAR/sg13cmos5l_inv_1_17.A vdd sg13_lv_pmos ad=0.2114p pd=1.54u as=0.42p ps=2.99u w=1.12u l=0.13u
M579 SAR/sg13cmos5l_dfrbp_1_24.Q_N SAR/a_13391_9263# vss vss sg13_lv_nmos ad=0.2849p pd=2.25u as=0.2516p ps=2.16u w=0.74u l=0.13u
M580 SAR/a_8580_8874# SAR/sg13cmos5l_dfrbp_1_18.Q SAR/a_8486_8874# vss sg13_lv_nmos ad=60.89999f pd=0.71u as=0.1428p ps=1.52u w=0.42u l=0.13u
M581 vss SAR/a_11567_7751# SAR/a_12404_7972# vss sg13_lv_nmos ad=0.1406p pd=1.12u as=0.2516p ps=2.16u w=0.74u l=0.13u
M582 vdd SAR/a_10028_6126# SAR/sg13cmos5l_inv_1_18.A vdd sg13_lv_pmos ad=0.2114p pd=1.54u as=0.42p ps=2.99u w=1.12u l=0.13u
M583 SAR/a_5770_3868# SAR/a_6213_3911# SAR/a_5510_4338# vss sg13_lv_nmos ad=79.8f pd=0.8u as=0.1296p ps=1.52u w=0.42u l=0.13u
M584 vdd SAR/sg13cmos5l_dfrbp_1_6.RESET_B SAR/a_16204_4338# vdd sg13_lv_pmos ad=1.38655p pd=8.8u as=79.8f ps=0.8u w=0.42u l=0.13u
M585 SAR/a_18959_3215# SAR/a_18117_3117# SAR/a_17700_3456# vdd sg13_lv_pmos ad=0.2048p pd=1.63u as=0.34p ps=2.68u w=1u l=0.13u
M586 SAR/a_2306_7660# SAR/sg13cmos5l_dfrbp_1_6.RESET_B vss vss sg13_lv_nmos ad=77.7f pd=0.95u as=0.1406p ps=1.12u w=0.74u l=0.13u
M587 SAR/sg13cmos5l_buf_1_98.A SAR/a_13641_7674# vss vss sg13_lv_nmos ad=0.2516p pd=2.16u as=0.1406p ps=1.12u w=0.74u l=0.13u
M588 SAR/a_16473_7989# SAR/a_15531_7796# SAR/a_16271_7751# vdd sg13_lv_pmos ad=93.45f pd=0.865u as=0.2048p ps=1.63u w=0.42u l=0.13u
M589 vdd SAR/sg13cmos5l_buf_1_24.X SAR/a_5704_1664# vdd sg13_lv_pmos ad=0.2114p pd=1.54u as=0.2856p ps=2.36u w=0.84u l=0.13u
M590 SAR/a_2348_7624# SAR/a_2621_7636# SAR/a_2583_7710# vss sg13_lv_nmos ad=0.141p pd=1.17u as=47.25f ps=0.645u w=0.42u l=0.13u
M591 SAR/sg13cmos5l_dlhr_1_6.Q_N SAR/a_9558_6144# vdd vdd sg13_lv_pmos ad=0.3808p pd=2.92u as=0.1974p ps=1.5u w=1.12u l=0.13u
M592 SAR/a_17493_3947# SAR/a_16551_3987# SAR/a_17399_3947# vdd sg13_lv_pmos ad=79.8f pd=0.8u as=0.1428p ps=1.52u w=0.42u l=0.13u
M593 vdd SAR/a_1967_5773# SAR/a_2804_5412# vdd sg13_lv_pmos ad=0.2128p pd=1.5u as=0.3864p ps=2.93u w=1.12u l=0.13u
M594 SAR/sg13cmos5l_or2_1_0.A SAR/a_18363_4270# vdd vdd sg13_lv_pmos ad=0.2128p pd=1.5u as=0.2128p ps=1.5u w=1.12u l=0.13u
M595 vss SAR/a_524_4614# ckc vss sg13_lv_nmos ad=0.14875p pd=1.16u as=0.2886p ps=2.26u w=0.74u l=0.13u
M596 vss SAR/a_13641_7674# SAR/a_13596_7710# vss sg13_lv_nmos ad=0.1428p pd=1.52u as=47.25f ps=0.645u w=0.42u l=0.13u
M597 vss SAR/sg13cmos5l_dfrbp_1_8.RESET_B SAR/a_15876_7362# vss sg13_lv_nmos ad=0.1626p pd=1.415u as=60.89999f ps=0.71u w=0.42u l=0.13u
M598 SAR/a_13396_7312# SAR/a_12980_6924# SAR/a_13161_7281# vss sg13_lv_nmos ad=77.7f pd=0.95u as=0.2516p ps=2.16u w=0.74u l=0.13u
M599 vdd SAR/a_17008_2630# SAR/a_16953_2511# vdd sg13_lv_pmos ad=1.86162p pd=11.935u as=93.45f ps=0.865u w=0.42u l=0.13u
M600 vdd vss vdd vdd sg13_lv_pmos ad=0.34p pd=2.68u as=0 ps=0 w=1u l=1u
M601 vdd SAR/sg13cmos5l_buf_1_61.X SAR/a_1000_9224# vdd sg13_lv_pmos ad=0.2114p pd=1.54u as=0.2856p ps=2.36u w=0.84u l=0.13u
M602 SAR/a_15887_8797# SAR/a_15045_8447# SAR/a_14628_8440# vdd sg13_lv_pmos ad=0.2048p pd=1.63u as=0.34p ps=2.68u w=1u l=0.13u
M603 SAR/a_6741_5459# SAR/sg13cmos5l_dfrbp_1_8.RESET_B vdd vdd sg13_lv_pmos ad=0.147p pd=1.54u as=0.1563p ps=1.22u w=0.42u l=0.13u
M604 vss SAR/a_7941_7653# SAR/a_8043_7796# vss sg13_lv_nmos ad=1.49685p pd=9.6u as=0.2516p ps=2.16u w=0.74u l=0.13u
M605 SAR/a_4172_1590# SAR/sg13cmos5l_buf_1_38.A vdd vdd sg13_lv_pmos ad=0.2856p pd=2.36u as=0.2114p ps=1.54u w=0.84u l=0.13u
M606 SAR/a_13076_5376# SAR/sg13cmos5l_inv_1_0.A vss vss sg13_lv_nmos ad=0.187p pd=1.78u as=0.17255p ps=1.25u w=0.55u l=0.13u
M607 SAR/a_9060_8861# SAR/a_8772_8440# SAR/a_8998_8861# vss sg13_lv_nmos ad=0.1428p pd=1.52u as=37.8f ps=0.6u w=0.42u l=0.13u
M608 vdd SAR/sg13cmos5l_dfrbp_1_6.RESET_B SAR/a_17961_8793# vdd sg13_lv_pmos ad=0.2128p pd=1.5u as=0.2128p ps=1.5u w=1.12u l=0.13u
M609 vdd SAR/a_18363_4270# SAR/sg13cmos5l_or2_1_0.A vdd sg13_lv_pmos ad=0.2128p pd=1.5u as=0.2128p ps=1.5u w=1.12u l=0.13u
M610 SAR/a_17132_9150# SAR/sg13cmos5l_buf_1_94.X vdd vdd sg13_lv_pmos ad=0.2856p pd=2.36u as=0.2114p ps=1.54u w=0.84u l=0.13u
M611 vdd SAR/a_18928_1846# SAR/a_18873_1941# vdd sg13_lv_pmos ad=1.86162p pd=11.935u as=93.45f ps=0.865u w=0.42u l=0.13u
M612 SAR/sg13cmos5l_dfrbp_1_16.Q_N SAR/a_1967_7285# vdd vdd sg13_lv_pmos ad=0.4312p pd=3.01u as=0.2639p ps=1.81u w=1.12u l=0.13u
M613 SAR/a_2565_3911# SAR/sg13cmos5l_inv_1_8.A vss vss sg13_lv_nmos ad=0.2516p pd=2.16u as=2.27517p ps=14.72u w=0.74u l=0.13u
M614 SAR/sg13cmos5l_buf_1_107.X SAR/a_17896_9224# vss vss sg13_lv_nmos ad=0.2886p pd=2.26u as=0.14875p ps=1.16u w=0.74u l=0.13u
M615 vdd SAR/a_17961_8793# SAR/a_17894_8436# vdd sg13_lv_pmos ad=0.2387p pd=1.84u as=0.1008p ps=0.9u w=0.42u l=0.13u
M616 vdd SAR/a_13100_8400# pl_sw[6] vdd sg13_lv_pmos ad=0.2114p pd=1.54u as=0.42p ps=2.99u w=1.12u l=0.13u
M617 vss SAR/sg13cmos5l_dfrbp_1_6.RESET_B SAR/a_19828_6148# vss sg13_lv_nmos ad=0.1406p pd=1.12u as=77.7f ps=0.95u w=0.74u l=0.13u
M618 SAR/a_12216_5728# SAR/sg13cmos5l_or2_1_1.B SAR/a_12358_5388# vdd sg13_lv_pmos ad=0.2856p pd=2.36u as=0.1596p ps=1.22u w=0.84u l=0.13u
M619 vdd SAR/sg13cmos5l_dfrbp_1_6.RESET_B SAR/a_422_5850# vdd sg13_lv_pmos ad=0.36237p pd=2.605u as=79.8f ps=0.8u w=0.42u l=0.13u
M620 SAR/a_13460_7996# SAR/a_13047_7690# SAR/a_13392_7996# vdd sg13_lv_pmos ad=0.191p pd=1.44u as=0.105p ps=1.21u w=1u l=0.13u
M621 vdd SAR/a_2409_4650# SAR/a_2342_5088# vdd sg13_lv_pmos ad=0.2387p pd=1.84u as=0.1008p ps=0.9u w=0.42u l=0.13u
M622 SAR/a_15974_6162# SAR/a_16779_6284# SAR/a_16234_6385# vdd sg13_lv_pmos ad=0.1428p pd=1.52u as=79.8f ps=0.8u w=0.42u l=0.13u
M623 SAR/a_7257_4023# SAR/a_6315_3911# SAR/a_7055_4261# vdd sg13_lv_pmos ad=93.45f pd=0.865u as=0.2048p ps=1.63u w=0.42u l=0.13u
M624 SAR/a_13648_9406# SAR/sg13cmos5l_dfrbp_1_8.RESET_B vdd vdd sg13_lv_pmos ad=79.8f pd=0.8u as=4.11675p ps=27.17u w=0.42u l=0.13u
M625 vdd SAR/a_11567_7751# SAR/a_11824_7894# vdd sg13_lv_pmos ad=0.2639p pd=1.81u as=79.8f ps=0.8u w=0.42u l=0.13u
M626 SAR/a_10071_7282# SAR/sg13cmos5l_dfrbp_1_18.Q vdd vdd sg13_lv_pmos ad=0.3234p pd=2.45u as=1.07253p ps=6.75u w=0.84u l=0.13u
M627 vdd SAR/sg13cmos5l_buf_1_33.A SAR/a_2248_1664# vdd sg13_lv_pmos ad=0.2114p pd=1.54u as=0.2856p ps=2.36u w=0.84u l=0.13u
M628 vss vdd vss vss sg13_lv_nmos ad=79.8f pd=0.8u as=0 ps=0 w=0.42u l=1u
M629 vdd SAR/a_14032_6382# SAR/a_13977_6477# vdd sg13_lv_pmos ad=1.07253p pd=6.75u as=93.45f ps=0.865u w=0.42u l=0.13u
M630 SAR/sg13cmos5l_buf_1_8.X SAR/a_10888_1664# vss vss sg13_lv_nmos ad=0.2886p pd=2.26u as=0.14875p ps=1.16u w=0.74u l=0.13u
M631 vdd SAR/a_9033_6162# SAR/a_9558_6144# vdd sg13_lv_pmos ad=0.1974p pd=1.5u as=0.2856p ps=2.36u w=0.84u l=0.13u
M632 SAR/a_682_6892# SAR/a_1125_6935# SAR/a_1065_6971# vdd sg13_lv_pmos ad=79.8f pd=0.8u as=63f ps=0.72u w=0.42u l=0.13u
M633 SAR/a_15884_3102# SAR/sg13cmos5l_buf_1_5.X vss vss sg13_lv_nmos ad=0.187p pd=1.78u as=0.14875p ps=1.16u w=0.55u l=0.13u
M634 SAR/a_15110_5412# SAR/a_14714_5776# SAR/a_14996_5412# vdd sg13_lv_pmos ad=0.1008p pd=0.9u as=0.191p ps=1.44u w=0.42u l=0.13u
M635 vdd SAR/sg13cmos5l_dfrbp_1_6.RESET_B SAR/a_15974_6162# vdd sg13_lv_pmos ad=0.36237p pd=2.605u as=79.8f ps=0.8u w=0.42u l=0.13u
M636 vss SAR/a_3692_9150# SAR/sg13cmos5l_buf_1_62.X vss sg13_lv_nmos ad=0.14875p pd=1.16u as=0.2886p ps=2.26u w=0.74u l=0.13u
M637 SAR/a_8772_8440# SAR/a_9291_8447# SAR/a_10031_8797# vss sg13_lv_nmos ad=0.3473p pd=2.71u as=0.12665p ps=1.145u w=0.74u l=0.13u
M638 SAR/a_7238_7674# SAR/sg13cmos5l_dfrbp_1_6.D vdd vdd sg13_lv_pmos ad=79.8f pd=0.8u as=0.1428p ps=1.52u w=0.42u l=0.13u
M639 SAR/a_6346_4873# SAR/a_6789_4629# SAR/a_6729_5041# vdd sg13_lv_pmos ad=79.8f pd=0.8u as=63f ps=0.72u w=0.42u l=0.13u
M640 vdd SAR/sg13cmos5l_buf_8_1.A SAR/a_16703_3871# vdd sg13_lv_pmos ad=1.43437p pd=9.105u as=0.4088p ps=2.97u w=1.12u l=0.13u
M641 vss SAR/a_5673_3138# SAR/a_5628_3174# vss sg13_lv_nmos ad=0.1428p pd=1.52u as=47.25f ps=0.645u w=0.42u l=0.13u
M642 SAR/sg13cmos5l_buf_1_90.X SAR/a_11464_9224# vdd vdd sg13_lv_pmos ad=0.42p pd=2.99u as=0.2114p ps=1.54u w=1.12u l=0.13u
M643 SAR/a_13641_7674# SAR/a_13460_7996# vdd vdd sg13_lv_pmos ad=0.2128p pd=1.5u as=0.2387p ps=1.84u w=1.12u l=0.13u
M644 SAR/sg13cmos5l_nor2b_1_1.Y SAR/a_14254_2444# vss vss sg13_lv_nmos ad=0.1406p pd=1.12u as=0.17255p ps=1.25u w=0.74u l=0.13u
M645 _d2 SAR/a_20392_3900# vss vss sg13_lv_nmos ad=0.2886p pd=2.26u as=0.14875p ps=1.16u w=0.74u l=0.13u
M646 SAR/a_12719_2749# SAR/a_11877_2399# SAR/a_11460_2392# vdd sg13_lv_pmos ad=0.2048p pd=1.63u as=0.34p ps=2.68u w=1u l=0.13u
M647 SAR/a_12976_2630# SAR/sg13cmos5l_dfrbp_1_0.RESET_B vdd vdd sg13_lv_pmos ad=79.8f pd=0.8u as=1.777p ps=11.395u w=0.42u l=0.13u
M648 SAR/a_10726_5760# SAR/sg13cmos5l_dfrbp_1_20.Q SAR/sg13cmos5l_a22oi_1_2.B2 vss sg13_lv_nmos ad=0.1406p pd=1.12u as=0.2516p ps=2.16u w=0.74u l=0.13u
M649 SAR/sg13cmos5l_buf_1_65.X SAR/a_424_8436# vdd vdd sg13_lv_pmos ad=0.42p pd=2.99u as=0.2114p ps=1.54u w=1.12u l=0.13u
M650 SAR/a_8439_6178# SAR/sg13cmos5l_dlhr_1_5.GATE vdd vdd sg13_lv_pmos ad=0.3234p pd=2.45u as=1.04815p ps=6.595u w=0.84u l=0.13u
M651 vss vdd vss vss sg13_lv_nmos ad=0.1428p pd=1.52u as=0 ps=0 w=0.42u l=1u
M652 vdd SAR/a_7941_7653# SAR/a_8043_7796# vdd sg13_lv_pmos ad=1.15047p pd=7.175u as=0.3864p ps=2.93u w=1.12u l=0.13u
M653 SAR/a_16293_4629# SAR/sg13cmos5l_inv_1_2.A vss vss sg13_lv_nmos ad=0.2516p pd=2.16u as=2.41737p ps=15.64u w=0.74u l=0.13u
M654 SAR/a_9638_5088# SAR/a_9242_4660# SAR/a_9524_4972# vdd sg13_lv_pmos ad=0.1008p pd=0.9u as=0.191p ps=1.44u w=0.42u l=0.13u
M655 vss SAR/sg13cmos5l_inv_1_1.A SAR/a_16264_9224# vss sg13_lv_nmos ad=0.14875p pd=1.16u as=0.187p ps=1.78u w=0.55u l=0.13u
M656 SAR/a_5908_3124# SAR/a_5492_3460# SAR/a_5673_3138# vss sg13_lv_nmos ad=77.7f pd=0.95u as=0.2516p ps=2.16u w=0.74u l=0.13u
M657 SAR/a_9033_6162# SAR/a_8852_6484# vdd vdd sg13_lv_pmos ad=0.2128p pd=1.5u as=0.2387p ps=1.84u w=1.12u l=0.13u
M658 SAR/sg13cmos5l_dfrbp_1_17.D SAR/a_1662_8374# vdd vdd sg13_lv_pmos ad=0.3927p pd=2.99u as=1.15047p ps=7.175u w=1.155u l=0.13u
M659 SAR/sg13cmos5l_dfrbp_1_15.D SAR/a_4244_8436# vss vss sg13_lv_nmos ad=0.2516p pd=2.16u as=0.1406p ps=1.12u w=0.74u l=0.13u
M660 vdd vss vdd vdd sg13_lv_pmos ad=0.34p pd=2.68u as=0 ps=0 w=1u l=1u
M661 SAR/a_6405_8447# SAR/sg13cmos5l_inv_1_8.A vss vss sg13_lv_nmos ad=0.2516p pd=2.16u as=2.71505p ps=17.54u w=0.74u l=0.13u
M662 vdd SAR/a_16485_6935# SAR/a_16587_6935# vdd sg13_lv_pmos ad=1.07253p pd=6.75u as=0.3864p ps=2.93u w=1.12u l=0.13u
M663 SAR/sg13cmos5l_dlhr_1_0.Q SAR/a_7689_1626# vdd vdd sg13_lv_pmos ad=0.3808p pd=2.92u as=0.2128p ps=1.5u w=1.12u l=0.13u
M664 SAR/a_8204_9150# SAR/sg13cmos5l_buf_1_45.X vss vss sg13_lv_nmos ad=0.187p pd=1.78u as=0.14875p ps=1.16u w=0.55u l=0.13u
M665 vdd SAR/a_20012_1590# SAR/sg13cmos5l_buf_1_0.X vdd sg13_lv_pmos ad=0.2114p pd=1.54u as=0.42p ps=2.99u w=1.12u l=0.13u
M666 SAR/a_10288_8678# SAR/sg13cmos5l_dfrbp_1_8.RESET_B vdd vdd sg13_lv_pmos ad=79.8f pd=0.8u as=1.12242p ps=7u w=0.42u l=0.13u
M667 vss SAR/sg13cmos5l_dlhr_1_12.D SAR/a_17161_8794# vss sg13_lv_nmos ad=0.15055p pd=1.17u as=0.187p ps=1.78u w=0.55u l=0.13u
M668 SAR/a_7316_3460# SAR/a_6903_3154# SAR/a_7248_3460# vdd sg13_lv_pmos ad=0.191p pd=1.44u as=0.105p ps=1.21u w=1u l=0.13u
M669 vdd SAR/a_7888_4870# SAR/a_7833_4965# vdd sg13_lv_pmos ad=1.28962p pd=8.195u as=93.45f ps=0.865u w=0.42u l=0.13u
M670 vss SAR/sg13cmos5l_a221oi_1_1.C1 SAR/sg13cmos5l_a22oi_1_2.B2 vss sg13_lv_nmos ad=0.1406p pd=1.12u as=0.2516p ps=2.16u w=0.74u l=0.13u
M671 SAR/a_9060_8861# SAR/a_9291_8447# SAR/a_8746_8404# vss sg13_lv_nmos ad=0.2373p pd=1.97u as=79.8f ps=0.8u w=0.42u l=0.13u
M672 vss SAR/sg13cmos5l_buf_1_34.A SAR/a_4840_1664# vss sg13_lv_nmos ad=0.14875p pd=1.16u as=0.187p ps=1.78u w=0.55u l=0.13u
M673 vdd SAR/a_12815_1703# SAR/a_13652_1924# vdd sg13_lv_pmos ad=0.2128p pd=1.5u as=0.3864p ps=2.93u w=1.12u l=0.13u
M674 vss SAR/a_1158_3142# SAR/a_1290_3206# vss sg13_lv_nmos ad=0.1405p pd=1.15u as=0.2163p ps=1.87u w=0.42u l=0.18u
M675 SAR/sg13cmos5l_dfrbp_1_20.Q_N SAR/a_8783_7751# vdd vdd sg13_lv_pmos ad=0.4312p pd=3.01u as=0.2639p ps=1.81u w=1.12u l=0.13u
M676 SAR/a_6903_3154# SAR/sg13cmos5l_dlhr_1_0.GATE vss vss sg13_lv_nmos ad=0.2516p pd=2.16u as=0.15055p ps=1.17u w=0.74u l=0.13u
M677 SAR/sg13cmos5l_dfrbp_1_25.Q_N SAR/a_15887_8797# vdd vdd sg13_lv_pmos ad=0.4312p pd=3.01u as=0.2639p ps=1.81u w=1.12u l=0.13u
M678 SAR/a_2638_6162# SAR/a_2879_6432# SAR/a_1997_6126# vss sg13_lv_nmos ad=0.1428p pd=1.52u as=0.12665p ps=1.145u w=0.42u l=0.13u
M679 vss SAR/a_4425_7281# SAR/a_4380_7326# vss sg13_lv_nmos ad=0.1428p pd=1.52u as=47.25f ps=0.645u w=0.42u l=0.13u
M680 SAR/a_6372_4968# SAR/a_6891_4772# SAR/a_7631_4727# vss sg13_lv_nmos ad=0.3473p pd=2.71u as=0.12665p ps=1.145u w=0.74u l=0.13u
M681 vss vdd vss vss sg13_lv_nmos ad=0.1428p pd=1.52u as=0 ps=0 w=0.42u l=1u
M682 vdd SAR/sg13cmos5l_buf_1_5.A SAR/a_14440_1664# vdd sg13_lv_pmos ad=0.2114p pd=1.54u as=0.2856p ps=2.36u w=0.84u l=0.13u
M683 vdd SAR/a_5132_3864# SAR/sg13cmos5l_buf_1_44.X vdd sg13_lv_pmos ad=0.2114p pd=1.54u as=0.42p ps=2.99u w=1.12u l=0.13u
M684 vdd vss vdd vdd sg13_lv_pmos ad=0.34p pd=2.68u as=0 ps=0 w=1u l=1u
M685 SAR/a_10900_7312# SAR/a_10484_6924# SAR/a_10665_7281# vss sg13_lv_nmos ad=77.7f pd=0.95u as=0.2516p ps=2.16u w=0.74u l=0.13u
M686 SAR/a_10331_3900# SAR/sg13cmos5l_nand2_1_1.B SAR/sg13cmos5l_a22oi_1_1.B1 vdd sg13_lv_pmos ad=0.2128p pd=1.5u as=0.3808p ps=2.92u w=1.12u l=0.13u
M687 vdd SAR/sg13cmos5l_dfrbp_1_6.RESET_B SAR/a_5414_6162# vdd sg13_lv_pmos ad=0.36237p pd=2.605u as=79.8f ps=0.8u w=0.42u l=0.13u
M688 SAR/sg13cmos5l_dfrbp_1_16.Q SAR/a_2804_6924# vdd vdd sg13_lv_pmos ad=0.3808p pd=2.92u as=0.2128p ps=1.5u w=1.12u l=0.13u
M689 SAR/a_9076_5800# SAR/a_8660_5412# SAR/a_8841_5769# vss sg13_lv_nmos ad=77.7f pd=0.95u as=0.2516p ps=2.16u w=0.74u l=0.13u
M690 SAR/a_14726_7674# SAR/sg13cmos5l_buf_1_57.X vdd vdd sg13_lv_pmos ad=79.8f pd=0.8u as=0.1428p ps=1.52u w=0.42u l=0.13u
M691 SAR/a_16233_5041# SAR/a_15876_4968# vdd vdd sg13_lv_pmos ad=63f pd=0.72u as=0.1563p ps=1.22u w=0.42u l=0.13u
M692 SAR/a_5220_2392# SAR/a_5739_2399# SAR/a_6479_2749# vss sg13_lv_nmos ad=0.3473p pd=2.71u as=0.12665p ps=1.145u w=0.74u l=0.13u
M693 SAR/a_14602_8404# SAR/a_15045_8447# SAR/a_14985_8483# vdd sg13_lv_pmos ad=79.8f pd=0.8u as=63f ps=0.72u w=0.42u l=0.13u
M694 SAR/a_11556_1944# SAR/a_11530_1849# vdd vdd sg13_lv_pmos ad=0.34p pd=2.68u as=0.36237p ps=2.605u w=1u l=0.13u
M695 vdd SAR/sg13cmos5l_dfrbp_1_6.RESET_B SAR/a_5673_3138# vdd sg13_lv_pmos ad=0.2128p pd=1.5u as=0.2128p ps=1.5u w=1.12u l=0.13u
M696 SAR/a_19628_2352# SAR/sg13cmos5l_buf_1_19.X vss vss sg13_lv_nmos ad=0.187p pd=1.78u as=0.14875p ps=1.16u w=0.55u l=0.13u
M697 vdd SAR/sg13cmos5l_inv_1_29.A SAR/sg13cmos5l_inv_1_29.Y vdd sg13_lv_pmos ad=0.3808p pd=2.92u as=0.3808p ps=2.92u w=1.12u l=0.13u
M698 SAR/sg13cmos5l_buf_1_40.X SAR/a_1192_1664# vdd vdd sg13_lv_pmos ad=0.42p pd=2.99u as=0.2114p ps=1.54u w=1.12u l=0.13u
M699 vdd SAR/sg13cmos5l_buf_1_104.A SAR/a_19624_8436# vdd sg13_lv_pmos ad=0.2114p pd=1.54u as=0.2856p ps=2.36u w=0.84u l=0.13u
M700 SAR/sg13cmos5l_buf_1_18.X SAR/a_18376_2388# vss vss sg13_lv_nmos ad=0.2886p pd=2.26u as=0.14875p ps=1.16u w=0.74u l=0.13u
M701 SAR/a_17399_3947# SAR/a_16703_3871# SAR/a_17493_3947# vss sg13_lv_nmos ad=0.1296p pd=1.52u as=79.8f ps=0.8u w=0.42u l=0.13u
M702 SAR/sg13cmos5l_nand2_1_0.A SAR/sg13cmos5l_dfrbp_1_0.Q vss vss sg13_lv_nmos ad=0.1406p pd=1.12u as=0.2516p ps=2.16u w=0.74u l=0.13u
M703 vss SAR/sg13cmos5l_o21ai_1_0.A1 SAR/a_12022_3134# vss sg13_lv_nmos ad=0.1406p pd=1.12u as=0.2516p ps=2.16u w=0.74u l=0.15u
M704 SAR/sg13cmos5l_dfrbp_1_8.D SAR/a_18164_6924# vdd vdd sg13_lv_pmos ad=0.3808p pd=2.92u as=0.2128p ps=1.5u w=1.12u l=0.13u
M705 vdd SAR/sg13cmos5l_dfrbp_1_6.RESET_B SAR/a_5194_2356# vdd sg13_lv_pmos ad=0.1563p pd=1.22u as=0.147p ps=1.54u w=0.42u l=0.13u
M706 SAR/a_17700_3456# SAR/a_17674_3361# vss vss sg13_lv_nmos ad=0.2516p pd=2.16u as=0.1626p ps=1.415u w=0.74u l=0.13u
M707 SAR/sg13cmos5l_dlhr_1_19.Q_N SAR/a_15702_5842# vdd vdd sg13_lv_pmos ad=0.3808p pd=2.92u as=0.1974p ps=1.5u w=1.12u l=0.13u
M708 SAR/sg13cmos5l_dfrbp_1_4.Q_N SAR/a_12719_2749# vdd vdd sg13_lv_pmos ad=0.4312p pd=3.01u as=0.2639p ps=1.81u w=1.12u l=0.13u
M709 SAR/a_1580_2352# SAR/sg13cmos5l_buf_1_40.X vdd vdd sg13_lv_pmos ad=0.2856p pd=2.36u as=0.2114p ps=1.54u w=0.84u l=0.13u
M710 vss SAR/sg13cmos5l_dfrbp_1_6.RESET_B SAR/a_7332_7674# vss sg13_lv_nmos ad=0.1626p pd=1.415u as=60.89999f ps=0.71u w=0.42u l=0.13u
M711 SAR/sg13cmos5l_buf_1_101.X SAR/a_16264_9224# vdd vdd sg13_lv_pmos ad=0.42p pd=2.99u as=0.2114p ps=1.54u w=1.12u l=0.13u
M712 vss vdd vss vss sg13_lv_nmos ad=0.1428p pd=1.52u as=0 ps=0 w=0.42u l=1u
M713 SAR/a_19209_5769# SAR/a_19028_5412# vdd vdd sg13_lv_pmos ad=0.2128p pd=1.5u as=0.2387p ps=1.84u w=1.12u l=0.13u
M714 SAR/a_7452_3174# SAR/a_6903_3154# SAR/a_7316_3460# vss sg13_lv_nmos ad=47.25f pd=0.645u as=0.141p ps=1.17u w=0.42u l=0.13u
M715 vss SAR/a_4847_4727# SAR/a_5684_4948# vss sg13_lv_nmos ad=0.1406p pd=1.12u as=0.2516p ps=2.16u w=0.74u l=0.13u
M716 vss SAR/a_14800_3358# SAR/a_14449_3215# vss sg13_lv_nmos ad=79.8f pd=0.8u as=0.1428p ps=1.52u w=0.42u l=0.13u
M717 vdd SAR/a_12216_5728# SAR/sg13cmos5l_a221oi_1_0.B1 vdd sg13_lv_pmos ad=0.2226p pd=1.535u as=0.3976p ps=2.95u w=1.12u l=0.13u
M718 SAR/a_11844_1639# SAR/a_12075_1748# SAR/a_11530_1849# vss sg13_lv_nmos ad=0.2373p pd=1.97u as=79.8f ps=0.8u w=0.42u l=0.13u
M719 SAR/a_2148_3904# SAR/a_2667_3911# SAR/a_3407_4261# vss sg13_lv_nmos ad=0.3473p pd=2.71u as=0.12665p ps=1.145u w=0.74u l=0.13u
M720 SAR/a_18960_5412# SAR/a_18409_5770# vdd vdd sg13_lv_pmos ad=0.105p pd=1.21u as=1.28962p ps=8.195u w=1u l=0.13u
M721 SAR/a_19345_6154# SAR/a_18793_6216# vss vss sg13_lv_nmos ad=71.99999f pd=0.865u as=1.97045p ps=12.335u w=0.64u l=0.13u
M722 vss vdd vss vss sg13_lv_nmos ad=0.1428p pd=1.52u as=0 ps=0 w=0.42u l=1u
M723 SAR/a_11530_3868# SAR/a_11973_3911# SAR/a_11913_3947# vdd sg13_lv_pmos ad=79.8f pd=0.8u as=63f ps=0.72u w=0.42u l=0.13u
M724 vdd SAR/a_8204_2352# SAR/sg13cmos5l_buf_1_24.A vdd sg13_lv_pmos ad=0.2114p pd=1.54u as=0.42p ps=2.99u w=1.12u l=0.13u
M725 SAR/a_6057_6553# SAR/a_5700_6480# vdd vdd sg13_lv_pmos ad=63f pd=0.72u as=0.1563p ps=1.22u w=0.42u l=0.13u
M726 vss SAR/a_13161_7281# SAR/a_13686_7354# vss sg13_lv_nmos ad=0.1491p pd=1.18u as=0.187p ps=1.78u w=0.55u l=0.13u
M727 SAR/sg13cmos5l_nor2_1_1.A SAR/a_17588_2388# vdd vdd sg13_lv_pmos ad=0.3808p pd=2.92u as=0.2128p ps=1.5u w=1.12u l=0.13u
M728 vdd SAR/a_9705_4650# SAR/a_10230_4632# vdd sg13_lv_pmos ad=0.1974p pd=1.5u as=0.2856p ps=2.36u w=0.84u l=0.13u
M729 SAR/a_16548_6175# SAR/a_16260_6480# SAR/a_16486_6175# vss sg13_lv_nmos ad=0.1428p pd=1.52u as=37.8f ps=0.6u w=0.42u l=0.13u
M730 vss SAR/sg13cmos5l_dfrbp_1_0.RESET_B SAR/a_15300_2826# vss sg13_lv_nmos ad=0.1626p pd=1.415u as=60.89999f ps=0.71u w=0.42u l=0.13u
M731 SAR/a_3447_2746# SAR/sg13cmos5l_dfrbp_1_9.Q vdd vdd sg13_lv_pmos ad=0.3234p pd=2.45u as=1.86162p ps=11.935u w=0.84u l=0.13u
M732 SAR/a_2436_8861# SAR/a_2667_8447# SAR/a_2122_8404# vss sg13_lv_nmos ad=0.2373p pd=1.97u as=79.8f ps=0.8u w=0.42u l=0.13u
M733 vdd SAR/sg13cmos5l_buf_1_4.A SAR/a_16552_1664# vdd sg13_lv_pmos ad=0.2114p pd=1.54u as=0.2856p ps=2.36u w=0.84u l=0.13u
M734 vdd SAR/a_17367_8794# SAR/a_17498_8800# vdd sg13_lv_pmos ad=1.15047p pd=7.175u as=0.2856p ps=2.36u w=0.84u l=0.13u
M735 SAR/a_620_2352# SAR/sg13cmos5l_buf_1_32.X vdd vdd sg13_lv_pmos ad=0.2856p pd=2.36u as=0.2114p ps=1.54u w=0.84u l=0.13u
M736 SAR/a_18146_4338# SAR/sg13cmos5l_dfrbp_1_6.RESET_B vss vss sg13_lv_nmos ad=60.89999f pd=0.71u as=0.1626p ps=1.415u w=0.42u l=0.13u
M737 SAR/a_3669_6320# SAR/a_2727_6380# SAR/a_3575_6553# vdd sg13_lv_pmos ad=79.8f pd=0.8u as=0.1428p ps=1.52u w=0.42u l=0.13u
M738 SAR/a_12815_4261# SAR/a_11973_3911# SAR/a_12721_4261# vss sg13_lv_nmos ad=0.12665p pd=1.145u as=0.1428p ps=1.52u w=0.42u l=0.13u
M739 vss SAR/sg13cmos5l_buf_1_60.X SAR/a_2248_9224# vss sg13_lv_nmos ad=0.14875p pd=1.16u as=0.187p ps=1.78u w=0.55u l=0.13u
M740 vdd vss vdd vdd sg13_lv_pmos ad=0.19p pd=1.38u as=0 ps=0 w=1u l=1u
M741 SAR/a_10308_7992# SAR/a_10282_7897# vss vss sg13_lv_nmos ad=0.2516p pd=2.16u as=0.1626p ps=1.415u w=0.74u l=0.13u
M742 ph_sw[1] SAR/a_1864_9224# vss vss sg13_lv_nmos ad=0.2886p pd=2.26u as=0.14875p ps=1.16u w=0.74u l=0.13u
M743 SAR/a_18671_1703# SAR/a_17829_1605# SAR/a_18577_1703# vss sg13_lv_nmos ad=0.12665p pd=1.145u as=0.1428p ps=1.52u w=0.42u l=0.13u
M744 SAR/a_6741_5459# SAR/a_5799_5499# SAR/a_6602_5692# vss sg13_lv_nmos ad=79.8f pd=0.8u as=0.2373p ps=1.97u w=0.42u l=0.13u
M745 vdd SAR/a_17519_6239# SAR/a_18356_6460# vdd sg13_lv_pmos ad=0.2128p pd=1.5u as=0.3864p ps=2.93u w=1.12u l=0.13u
M746 vdd SAR/a_1196_8400# SAR/sg13cmos5l_buf_1_63.X vdd sg13_lv_pmos ad=0.2114p pd=1.54u as=0.42p ps=2.99u w=1.12u l=0.13u
M747 SAR/a_17780_8436# SAR/a_17498_8800# SAR/a_17713_8838# vss sg13_lv_nmos ad=0.141p pd=1.17u as=71.99999f ps=0.865u w=0.64u l=0.13u
M748 vss SAR/a_3676_7964# SAR/sg13cmos5l_dlhr_1_9.Q vss sg13_lv_nmos ad=0.1406p pd=1.12u as=0.2516p ps=2.16u w=0.74u l=0.13u
M749 SAR/sg13cmos5l_dfrbp_1_20.Q SAR/a_9620_7972# vdd vdd sg13_lv_pmos ad=0.3808p pd=2.92u as=0.2128p ps=1.5u w=1.12u l=0.13u
M750 SAR/sg13cmos5l_dfrbp_1_22.D SAR/a_16724_8436# vdd vdd sg13_lv_pmos ad=0.3808p pd=2.92u as=0.2128p ps=1.5u w=1.12u l=0.13u
M751 SAR/a_3676_7964# SAR/a_4076_7624# SAR/a_4034_7660# vss sg13_lv_nmos ad=0.2516p pd=2.16u as=77.7f ps=0.95u w=0.74u l=0.13u
M752 SAR/a_13391_9263# SAR/a_12549_9165# SAR/a_13297_9263# vss sg13_lv_nmos ad=0.12665p pd=1.145u as=0.1428p ps=1.52u w=0.42u l=0.13u
M753 vss SAR/sg13cmos5l_inv_1_26.Y SAR/a_17896_9224# vss sg13_lv_nmos ad=0.14875p pd=1.16u as=0.187p ps=1.78u w=0.55u l=0.13u
M754 SAR/a_18615_5770# SAR/sg13cmos5l_dfrbp_1_8.D vdd vdd sg13_lv_pmos ad=0.3234p pd=2.45u as=1.28962p ps=8.195u w=0.84u l=0.13u
M755 SAR/a_1862_4338# SAR/a_2667_3911# SAR/a_2122_3868# vdd sg13_lv_pmos ad=0.1428p pd=1.52u as=79.8f ps=0.8u w=0.42u l=0.13u
M756 vss SAR/a_8588_3864# SAR/sg13cmos5l_buf_1_30.A vss sg13_lv_nmos ad=0.14875p pd=1.16u as=0.2886p ps=2.26u w=0.74u l=0.13u
M757 SAR/a_16677_6141# SAR/sg13cmos5l_dfrbp_1_8.D vss vss sg13_lv_nmos ad=0.2516p pd=2.16u as=1.97045p ps=12.335u w=0.74u l=0.13u
M758 vdd SAR/a_12549_9165# SAR/a_12651_9308# vdd sg13_lv_pmos ad=4.11675p pd=27.17u as=0.3864p ps=2.93u w=1.12u l=0.13u
M759 vss SAR/a_17961_8793# SAR/a_17916_8838# vss sg13_lv_nmos ad=0.1428p pd=1.52u as=47.25f ps=0.645u w=0.42u l=0.13u
M760 nl_sw[1] SAR/a_1864_1664# vdd vdd sg13_lv_pmos ad=0.42p pd=2.99u as=0.2114p ps=1.54u w=1.12u l=0.13u
M761 vss SAR/sg13cmos5l_dfrbp_1_6.RESET_B SAR/a_15124_7312# vss sg13_lv_nmos ad=0.1406p pd=1.12u as=77.7f ps=0.95u w=0.74u l=0.13u
M762 SAR/a_18671_1703# SAR/a_17829_1605# SAR/a_17412_1944# vdd sg13_lv_pmos ad=0.2048p pd=1.63u as=0.34p ps=2.68u w=1u l=0.13u
M763 SAR/a_10783_4292# SAR/sg13cmos5l_a22oi_1_0.B1 vss vss sg13_lv_nmos ad=0.13875p pd=1.115u as=0.2553p ps=2.17u w=0.74u l=0.13u
M764 SAR/a_8276_6924# SAR/a_7863_7282# SAR/a_8208_6924# vdd sg13_lv_pmos ad=0.191p pd=1.44u as=0.105p ps=1.21u w=1u l=0.13u
M765 SAR/a_13572_3151# SAR/a_13284_3456# SAR/a_13510_3151# vss sg13_lv_nmos ad=0.1428p pd=1.52u as=37.8f ps=0.6u w=0.42u l=0.13u
M766 SAR/a_20204_5376# SAR/sg13cmos5l_dlhr_1_16.Q vss vss sg13_lv_nmos ad=0.187p pd=1.78u as=0.14875p ps=1.16u w=0.55u l=0.13u
M767 SAR/a_3609_8559# SAR/a_2667_8447# SAR/a_3407_8797# vdd sg13_lv_pmos ad=93.45f pd=0.865u as=0.2048p ps=1.63u w=0.42u l=0.13u
M768 vdd SAR/a_4847_4727# SAR/a_5104_4870# vdd sg13_lv_pmos ad=0.2639p pd=1.81u as=79.8f ps=0.8u w=0.42u l=0.13u
M769 SAR/sg13cmos5l_dfrbp_1_6.RESET_B _cks vdd vdd sg13_lv_pmos ad=0.2128p pd=1.5u as=0.2128p ps=1.5u w=1.12u l=0.13u
M770 vdd SAR/sg13cmos5l_buf_1_35.A SAR/a_1864_1664# vdd sg13_lv_pmos ad=0.2114p pd=1.54u as=0.2856p ps=2.36u w=0.84u l=0.13u
M771 SAR/a_3664_4142# SAR/sg13cmos5l_dfrbp_1_8.RESET_B vdd vdd sg13_lv_pmos ad=79.8f pd=0.8u as=1.43437p ps=9.105u w=0.42u l=0.13u
M772 SAR/sg13cmos5l_dlhr_1_19.Q_N SAR/a_15702_5842# vss vss sg13_lv_nmos ad=0.2516p pd=2.16u as=0.1491p ps=1.18u w=0.74u l=0.13u
M773 SAR/a_15132_5814# SAR/a_14583_5770# SAR/a_14996_5412# vss sg13_lv_nmos ad=47.25f pd=0.645u as=0.141p ps=1.17u w=0.42u l=0.13u
M774 SAR/sg13cmos5l_buf_1_95.X SAR/a_12232_8436# vdd vdd sg13_lv_pmos ad=0.42p pd=2.99u as=0.2114p ps=1.54u w=1.12u l=0.13u
M775 SAR/a_16260_6480# SAR/a_16234_6385# vdd vdd sg13_lv_pmos ad=0.34p pd=2.68u as=0.36237p ps=2.605u w=1u l=0.13u
M776 SAR/a_9189_8447# SAR/sg13cmos5l_inv_1_2.A vss vss sg13_lv_nmos ad=0.2516p pd=2.16u as=2.71505p ps=17.54u w=0.74u l=0.13u
M777 SAR/a_3599_3215# SAR/a_2757_3117# SAR/a_2340_3456# vdd sg13_lv_pmos ad=0.2048p pd=1.63u as=0.34p ps=2.68u w=1u l=0.13u
M778 SAR/a_8785_6154# SAR/a_8233_6216# vss vss sg13_lv_nmos ad=71.99999f pd=0.865u as=1.97045p ps=12.335u w=0.64u l=0.13u
M779 vss SAR/sg13cmos5l_buf_8_0.X SAR/a_20392_7712# vss sg13_lv_nmos ad=0.14875p pd=1.16u as=0.187p ps=1.78u w=0.55u l=0.13u
M780 SAR/sg13cmos5l_dfrbp_1_1.Q_N SAR/a_12815_1703# vss vss sg13_lv_nmos ad=0.2849p pd=2.25u as=0.2516p ps=2.16u w=0.74u l=0.13u
M781 SAR/a_15177_5769# SAR/a_14996_5412# vdd vdd sg13_lv_pmos ad=0.2128p pd=1.5u as=0.2387p ps=1.84u w=1.12u l=0.13u
M782 SAR/a_17776_6382# SAR/sg13cmos5l_dfrbp_1_6.RESET_B vdd vdd sg13_lv_pmos ad=79.8f pd=0.8u as=1.04815p ps=6.595u w=0.42u l=0.13u
M783 vdd SAR/a_12933_6141# SAR/a_13035_6284# vdd sg13_lv_pmos ad=1.07253p pd=6.75u as=0.3864p ps=2.93u w=1.12u l=0.13u
M784 SAR/a_5577_2435# SAR/a_5220_2392# vdd vdd sg13_lv_pmos ad=63f pd=0.72u as=0.1563p ps=1.22u w=0.42u l=0.13u
M785 vdd SAR/a_3669_6320# SAR/a_2748_6126# vdd sg13_lv_pmos ad=0.36237p pd=2.605u as=0.34p ps=2.68u w=1u l=0.13u
M786 SAR/a_3692_9150# SAR/sg13cmos5l_inv_1_17.A vss vss sg13_lv_nmos ad=0.187p pd=1.78u as=0.14875p ps=1.16u w=0.55u l=0.13u
M787 vss SAR/sg13cmos5l_dfrbp_1_21.Q_N SAR/a_18793_6216# vss sg13_lv_nmos ad=0.15055p pd=1.17u as=0.187p ps=1.78u w=0.55u l=0.13u
M788 vdd SAR/a_2348_7624# SAR/a_1948_7964# vdd sg13_lv_pmos ad=0.2387p pd=1.84u as=0.2128p ps=1.5u w=1.12u l=0.13u
M789 SAR/a_1210_4654# SAR/sg13cmos5l_inv_1_8.Y SAR/sg13cmos5l_dlygate4sd2_1_0.A vss sg13_lv_nmos ad=0.1406p pd=1.12u as=0.2516p ps=2.16u w=0.74u l=0.13u
M790 SAR/a_5988_6175# SAR/a_5700_6480# SAR/a_5926_6175# vss sg13_lv_nmos ad=0.1428p pd=1.52u as=37.8f ps=0.6u w=0.42u l=0.13u
M791 vdd SAR/a_9164_1590# SAR/sg13cmos5l_buf_1_26.X vdd sg13_lv_pmos ad=0.2114p pd=1.54u as=0.42p ps=2.99u w=1.12u l=0.13u
M792 SAR/sg13cmos5l_dfrbp_1_3.Q_N SAR/a_18959_3215# vdd vdd sg13_lv_pmos ad=0.4312p pd=3.01u as=0.2639p ps=1.81u w=1.12u l=0.13u
M793 SAR/a_8972_9150# SAR/sg13cmos5l_buf_1_77.A vss vss sg13_lv_nmos ad=0.187p pd=1.78u as=0.14875p ps=1.16u w=0.55u l=0.13u
M794 SAR/a_5799_5499# SAR/a_5951_5383# vss vss sg13_lv_nmos ad=0.2516p pd=2.16u as=1.97045p ps=12.335u w=0.74u l=0.13u
M795 vdd SAR/a_6959_6239# SAR/a_7796_6460# vdd sg13_lv_pmos ad=0.2128p pd=1.5u as=0.3864p ps=2.93u w=1.12u l=0.13u
M796 vdd SAR/a_2732_9150# SAR/sg13cmos5l_buf_1_61.X vdd sg13_lv_pmos ad=0.2114p pd=1.54u as=0.42p ps=2.99u w=1.12u l=0.13u
M797 SAR/sg13cmos5l_nor2b_1_0.Y SAR/sg13cmos5l_inv_1_0.A SAR/a_13036_4948# vdd sg13_lv_pmos ad=0.3808p pd=2.92u as=0.1176p ps=1.33u w=1.12u l=0.13u
M798 SAR/a_7820_9150# SAR/sg13cmos5l_buf_1_73.A vss vss sg13_lv_nmos ad=0.187p pd=1.78u as=0.14875p ps=1.16u w=0.55u l=0.13u
M799 vdd vss vdd vdd sg13_lv_pmos ad=0.19p pd=1.38u as=0 ps=0 w=1u l=1u
M800 SAR/a_10707_2388# SAR/sg13cmos5l_nor2_1_0.A vdd vdd sg13_lv_pmos ad=0.1428p pd=1.375u as=0.2891p ps=1.695u w=1.12u l=0.13u
M801 SAR/sg13cmos5l_dfrbp_1_11.Q SAR/a_8468_4948# vss vss sg13_lv_nmos ad=0.2516p pd=2.16u as=0.1406p ps=1.12u w=0.74u l=0.13u
M802 SAR/a_7631_4727# SAR/a_6789_4629# SAR/a_7537_4727# vss sg13_lv_nmos ad=0.12665p pd=1.145u as=0.1428p ps=1.52u w=0.42u l=0.13u
M803 SAR/a_3407_4261# SAR/a_2565_3911# SAR/a_3313_4261# vss sg13_lv_nmos ad=0.12665p pd=1.145u as=0.1428p ps=1.52u w=0.42u l=0.13u
M804 vdd SAR/sg13cmos5l_buf_1_30.A SAR/a_8680_1664# vdd sg13_lv_pmos ad=0.2114p pd=1.54u as=0.2856p ps=2.36u w=0.84u l=0.13u
M805 SAR/a_5492_3460# SAR/a_5079_3154# SAR/a_5424_3460# vdd sg13_lv_pmos ad=0.191p pd=1.44u as=0.105p ps=1.21u w=1u l=0.13u
M806 SAR/a_7863_7282# SAR/sg13cmos5l_dlhr_1_5.GATE vss vss sg13_lv_nmos ad=0.2516p pd=2.16u as=0.15055p ps=1.17u w=0.74u l=0.13u
M807 SAR/a_14800_3358# SAR/sg13cmos5l_dfrbp_1_0.RESET_B vdd vdd sg13_lv_pmos ad=79.8f pd=0.8u as=1.38655p ps=8.8u w=0.42u l=0.13u
M808 pl_sw[2] SAR/a_2248_9224# vdd vdd sg13_lv_pmos ad=0.42p pd=2.99u as=0.2114p ps=1.54u w=1.12u l=0.13u
M809 SAR/a_2148_8440# SAR/a_2122_8404# vss vss sg13_lv_nmos ad=0.2516p pd=2.16u as=0.1626p ps=1.415u w=0.74u l=0.13u
M810 SAR/a_6117_6141# SAR/sg13cmos5l_dlhr_1_5.GATE vss vss sg13_lv_nmos ad=0.2516p pd=2.16u as=1.97045p ps=12.335u w=0.74u l=0.13u
M811 SAR/a_16268_3102# SAR/sg13cmos5l_buf_1_2.X vdd vdd sg13_lv_pmos ad=0.2856p pd=2.36u as=0.2114p ps=1.54u w=0.84u l=0.13u
M812 SAR/sg13cmos5l_buf_1_1.A SAR/a_14056_1664# vdd vdd sg13_lv_pmos ad=0.42p pd=2.99u as=0.2114p ps=1.54u w=1.12u l=0.13u
M813 vdd SAR/sg13cmos5l_dfrbp_1_8.RESET_B SAR/a_16042_6892# vdd sg13_lv_pmos ad=0.1563p pd=1.22u as=0.147p ps=1.54u w=0.42u l=0.13u
M814 SAR/a_14583_5770# SAR/sg13cmos5l_dfrbp_1_23.CLK vdd vdd sg13_lv_pmos ad=0.3234p pd=2.45u as=1.28962p ps=8.195u w=0.84u l=0.13u
M815 vdd SAR/a_3599_3215# SAR/a_3856_3358# vdd sg13_lv_pmos ad=0.2639p pd=1.81u as=79.8f ps=0.8u w=0.42u l=0.13u
M816 vdd SAR/sg13cmos5l_buf_1_3.A SAR/a_20296_1664# vdd sg13_lv_pmos ad=0.2114p pd=1.54u as=0.2856p ps=2.36u w=0.84u l=0.13u
M817 vdd SAR/sg13cmos5l_buf_1_8.X SAR/a_11656_3176# vdd sg13_lv_pmos ad=0.2114p pd=1.54u as=0.2856p ps=2.36u w=0.84u l=0.13u
M818 vdd SAR/a_1815_4666# SAR/a_1946_4660# vdd sg13_lv_pmos ad=1.28962p pd=8.195u as=0.2856p ps=2.36u w=0.84u l=0.13u
M819 vdd SAR/sg13cmos5l_nand2_1_2.B SAR/sg13cmos5l_dlygate4sd2_1_0.A vdd sg13_lv_pmos ad=0.3808p pd=2.92u as=0.2128p ps=1.5u w=1.12u l=0.13u
M820 vdd SAR/a_908_1590# SAR/sg13cmos5l_buf_1_32.X vdd sg13_lv_pmos ad=0.2114p pd=1.54u as=0.42p ps=2.99u w=1.12u l=0.13u
M821 SAR/a_15492_2392# SAR/a_15466_2356# vdd vdd sg13_lv_pmos ad=0.34p pd=2.68u as=0.36237p ps=2.605u w=1u l=0.13u
M822 vdd SAR/sg13cmos5l_buf_1_76.X SAR/a_5416_9224# vdd sg13_lv_pmos ad=0.2114p pd=1.54u as=0.2856p ps=2.36u w=0.84u l=0.13u
M823 SAR/sg13cmos5l_dlhr_1_5.Q SAR/a_8457_7281# vss vss sg13_lv_nmos ad=0.2516p pd=2.16u as=0.1406p ps=1.12u w=0.74u l=0.13u
M824 SAR/a_3831_7282# SAR/sg13cmos5l_dfrbp_1_15.D vdd vdd sg13_lv_pmos ad=0.3234p pd=2.45u as=1.04815p ps=6.595u w=0.84u l=0.13u
M825 vss SAR/a_8841_5769# SAR/a_9366_5842# vss sg13_lv_nmos ad=0.1491p pd=1.18u as=0.187p ps=1.78u w=0.55u l=0.13u
M826 SAR/sg13cmos5l_dlhr_1_13.Q_N SAR/a_15414_7354# vss vss sg13_lv_nmos ad=0.2516p pd=2.16u as=0.1491p ps=1.18u w=0.74u l=0.13u
M827 SAR/a_11782_4325# SAR/sg13cmos5l_dfrbp_1_0.RESET_B vss vss sg13_lv_nmos ad=37.8f pd=0.6u as=0.1701p ps=1.65u w=0.42u l=0.13u
M828 vdd SAR/sg13cmos5l_dlhr_1_6.D SAR/a_13486_5412# vdd sg13_lv_pmos ad=0.3808p pd=2.92u as=0.2128p ps=1.5u w=1.12u l=0.13u
M829 SAR/a_5700_6480# SAR/a_5674_6385# vdd vdd sg13_lv_pmos ad=0.34p pd=2.68u as=0.36237p ps=2.605u w=1u l=0.13u
M830 vdd SAR/sg13cmos5l_buf_8_2.X SAR/a_20008_7712# vdd sg13_lv_pmos ad=0.2114p pd=1.54u as=0.2856p ps=2.36u w=0.84u l=0.13u
M831 vdd SAR/a_14295_7282# SAR/a_14426_7288# vdd sg13_lv_pmos ad=1.07253p pd=6.75u as=0.2856p ps=2.36u w=0.84u l=0.13u
M832 SAR/a_7631_4727# SAR/a_6789_4629# SAR/a_6372_4968# vdd sg13_lv_pmos ad=0.2048p pd=1.63u as=0.34p ps=2.68u w=1u l=0.13u
M833 SAR/a_12815_4261# SAR/a_11973_3911# SAR/a_11556_3904# vdd sg13_lv_pmos ad=0.2048p pd=1.63u as=0.34p ps=2.68u w=1u l=0.13u
M834 SAR/a_1862_4338# SAR/sg13cmos5l_dlhr_1_1.GATE vdd vdd sg13_lv_pmos ad=79.8f pd=0.8u as=0.1428p ps=1.52u w=0.42u l=0.13u
M835 vss SAR/a_19340_8400# pl_sw[9] vss sg13_lv_nmos ad=0.14875p pd=1.16u as=0.2886p ps=2.26u w=0.74u l=0.13u
M836 vdd SAR/sg13cmos5l_dlhr_1_0.D SAR/a_10331_1924# vdd sg13_lv_pmos ad=0.2128p pd=1.5u as=0.2128p ps=1.5u w=1.12u l=0.13u
M837 vdd SAR/a_7497_3138# SAR/a_8022_3120# vdd sg13_lv_pmos ad=0.1974p pd=1.5u as=0.2856p ps=2.36u w=0.84u l=0.13u
M838 SAR/a_15702_4187# SAR/a_15821_3864# vss vss sg13_lv_nmos ad=0.2516p pd=2.16u as=0.1406p ps=1.12u w=0.74u l=0.13u
M839 vss SAR/sg13cmos5l_dfrbp_1_0.RESET_B SAR/a_17508_3138# vss sg13_lv_nmos ad=0.1626p pd=1.415u as=60.89999f ps=0.71u w=0.42u l=0.13u
M840 vss SAR/a_1967_7285# SAR/a_2804_6924# vss sg13_lv_nmos ad=0.1406p pd=1.12u as=0.2516p ps=2.16u w=0.74u l=0.13u
M841 SAR/sg13cmos5l_buf_1_19.A SAR/a_18856_8436# vss vss sg13_lv_nmos ad=0.2886p pd=2.26u as=0.14875p ps=1.16u w=0.74u l=0.13u
M842 _cko SAR/a_20392_7712# vdd vdd sg13_lv_pmos ad=0.42p pd=2.99u as=0.2114p ps=1.54u w=1.12u l=0.13u
M843 SAR/a_17493_3947# SAR/sg13cmos5l_dfrbp_1_6.RESET_B vdd vdd sg13_lv_pmos ad=0.147p pd=1.54u as=0.1563p ps=1.22u w=0.42u l=0.13u
M844 SAR/a_2732_9150# SAR/sg13cmos5l_inv_1_20.Y vdd vdd sg13_lv_pmos ad=0.2856p pd=2.36u as=0.2114p ps=1.54u w=0.84u l=0.13u
M845 SAR/a_15909_2399# SAR/sg13cmos5l_dfrbp_1_0.CLK vss vss sg13_lv_nmos ad=0.2516p pd=2.16u as=2.43055p ps=15.415u w=0.74u l=0.13u
M846 SAR/a_17894_8436# SAR/a_17498_8800# SAR/a_17780_8436# vdd sg13_lv_pmos ad=0.1008p pd=0.9u as=0.191p ps=1.44u w=0.42u l=0.13u
M847 SAR/a_4324_7996# SAR/a_4349_7636# vdd vdd sg13_lv_pmos ad=0.2856p pd=2.36u as=1.15047p ps=7.175u w=0.84u l=0.13u
M848 SAR/sg13cmos5l_inv_1_1.A SAR/a_15208_6200# vss vss sg13_lv_nmos ad=0.2886p pd=2.26u as=0.14875p ps=1.16u w=0.74u l=0.13u
M849 vdd SAR/a_6736_2630# SAR/a_6681_2511# vdd sg13_lv_pmos ad=1.86162p pd=11.935u as=93.45f ps=0.865u w=0.42u l=0.13u
M850 SAR/sg13cmos5l_dfrbp_1_21.Q_N SAR/a_17519_6239# vss vss sg13_lv_nmos ad=0.2849p pd=2.25u as=0.2516p ps=2.16u w=0.74u l=0.13u
M851 SAR/a_2565_3911# SAR/sg13cmos5l_inv_1_8.A vdd vdd sg13_lv_pmos ad=0.4088p pd=2.97u as=1.43437p ps=9.105u w=1.12u l=0.13u
M852 vss vdd vss vss sg13_lv_nmos ad=0.1428p pd=1.52u as=0 ps=0 w=0.42u l=1u
M853 SAR/a_708_5416# SAR/a_1227_5423# SAR/a_1967_5773# vss sg13_lv_nmos ad=0.3473p pd=2.71u as=0.12665p ps=1.145u w=0.74u l=0.13u
M854 vss SAR/a_4950_5699# SAR/sg13cmos5l_dlhr_1_5.GATE vss sg13_lv_nmos ad=0.1406p pd=1.12u as=0.2516p ps=2.16u w=0.74u l=0.13u
M855 vdd vss vdd vdd sg13_lv_pmos ad=0.34p pd=2.68u as=0 ps=0 w=1u l=1u
M856 SAR/a_9524_4972# SAR/a_9111_4666# SAR/a_9456_4972# vdd sg13_lv_pmos ad=0.191p pd=1.44u as=0.105p ps=1.21u w=1u l=0.13u
M857 vss SAR/a_17327_7285# SAR/a_18164_6924# vss sg13_lv_nmos ad=0.1406p pd=1.12u as=0.2516p ps=2.16u w=0.74u l=0.13u
M858 vdd SAR/sg13cmos5l_dfrbp_1_8.RESET_B SAR/a_1862_8874# vdd sg13_lv_pmos ad=0.36237p pd=2.605u as=79.8f ps=0.8u w=0.42u l=0.13u
M859 SAR/sg13cmos5l_dlhr_1_4.Q_N SAR/a_6198_3120# vdd vdd sg13_lv_pmos ad=0.3808p pd=2.92u as=0.1974p ps=1.5u w=1.12u l=0.13u
M860 SAR/a_11771_5412# SAR/sg13cmos5l_or2_1_1.B vdd vdd sg13_lv_pmos ad=0.3808p pd=2.92u as=0.2128p ps=1.5u w=1.12u l=0.13u
M861 vdd SAR/sg13cmos5l_dfrbp_1_8.RESET_B SAR/a_2380_6162# vdd sg13_lv_pmos ad=1.04815p pd=6.595u as=79.8f ps=0.8u w=0.42u l=0.13u
M862 vdd SAR/a_7820_2352# SAR/sg13cmos5l_inv_1_14.A vdd sg13_lv_pmos ad=0.2114p pd=1.54u as=0.42p ps=2.99u w=1.12u l=0.13u
M863 SAR/sg13cmos5l_inv_1_5.A SAR/a_19796_3436# vdd vdd sg13_lv_pmos ad=0.3808p pd=2.92u as=0.2128p ps=1.5u w=1.12u l=0.13u
M864 vss SAR/sg13cmos5l_a221oi_1_0.C1 SAR/a_10433_4248# vss sg13_lv_nmos ad=0.2516p pd=2.16u as=0.1406p ps=1.12u w=0.74u l=0.13u
M865 SAR/a_2386_5850# SAR/sg13cmos5l_dfrbp_1_6.RESET_B vss vss sg13_lv_nmos ad=37.8f pd=0.6u as=79.8f ps=0.8u w=0.42u l=0.13u
M866 SAR/a_12490_6385# SAR/a_12933_6141# SAR/a_12230_6162# vss sg13_lv_nmos ad=79.8f pd=0.8u as=0.1296p ps=1.52u w=0.42u l=0.13u
M867 SAR/a_6153_3947# SAR/a_5796_3904# vdd vdd sg13_lv_pmos ad=63f pd=0.72u as=0.1563p ps=1.22u w=0.42u l=0.13u
M868 SAR/a_16268_1590# SAR/sg13cmos5l_buf_1_1.A vss vss sg13_lv_nmos ad=0.187p pd=1.78u as=0.14875p ps=1.16u w=0.55u l=0.13u
M869 SAR/a_8209_7326# SAR/a_7657_7282# vss vss sg13_lv_nmos ad=71.99999f pd=0.865u as=1.49685p ps=9.6u w=0.64u l=0.13u
M870 SAR/a_19444_5800# SAR/a_19028_5412# SAR/a_19209_5769# vss sg13_lv_nmos ad=77.7f pd=0.95u as=0.2516p ps=2.16u w=0.74u l=0.13u
M871 vdd SAR/sg13cmos5l_inv_1_3.A SAR/sg13cmos5l_buf_1_7.A vdd sg13_lv_pmos ad=0.3808p pd=2.92u as=0.3808p ps=2.92u w=1.12u l=0.13u
M872 SAR/a_4324_7996# SAR/a_4349_7636# vss vss sg13_lv_nmos ad=0.2775p pd=2.23u as=1.49685p ps=9.6u w=0.74u l=0.13u
M873 SAR/a_15300_7687# SAR/a_15531_7796# SAR/a_14986_7897# vss sg13_lv_nmos ad=0.2373p pd=1.97u as=79.8f ps=0.8u w=0.42u l=0.13u
M874 SAR/sg13cmos5l_dlhr_1_2.Q SAR/a_7497_3138# vss vss sg13_lv_nmos ad=0.2516p pd=2.16u as=0.1406p ps=1.12u w=0.74u l=0.13u
M875 vss SAR/sg13cmos5l_buf_1_62.X SAR/a_1864_9224# vss sg13_lv_nmos ad=0.14875p pd=1.16u as=0.187p ps=1.78u w=0.55u l=0.13u
M876 vss SAR/sg13cmos5l_dfrbp_1_6.RESET_B SAR/a_9268_6148# vss sg13_lv_nmos ad=0.1406p pd=1.12u as=77.7f ps=0.95u w=0.74u l=0.13u
M877 SAR/a_8772_8440# SAR/a_8746_8404# vdd vdd sg13_lv_pmos ad=0.34p pd=2.68u as=0.36237p ps=2.605u w=1u l=0.13u
M878 SAR/a_11002_3142# SAR/sg13cmos5l_nand2_1_0.B vss vss sg13_lv_nmos ad=0.1406p pd=1.12u as=0.2516p ps=2.16u w=0.74u l=0.13u
M879 vss SAR/sg13cmos5l_dlygate4sd2_1_0.A SAR/a_902_3142# vss sg13_lv_nmos ad=0.1323p pd=1.05u as=0.1428p ps=1.52u w=0.42u l=0.13u
M880 SAR/a_5414_6162# SAR/a_6219_6284# SAR/a_5674_6385# vdd sg13_lv_pmos ad=0.1428p pd=1.52u as=79.8f ps=0.8u w=0.42u l=0.13u
M881 SAR/a_3407_4261# SAR/a_2565_3911# SAR/a_2148_3904# vdd sg13_lv_pmos ad=0.2048p pd=1.63u as=0.34p ps=2.68u w=1u l=0.13u
M882 SAR/a_8050_4650# SAR/sg13cmos5l_dfrbp_1_8.RESET_B vss vss sg13_lv_nmos ad=37.8f pd=0.6u as=79.8f ps=0.8u w=0.42u l=0.13u
M883 SAR/a_1125_5423# SAR/sg13cmos5l_dlhr_1_1.GATE vdd vdd sg13_lv_pmos ad=0.4088p pd=2.97u as=1.2517p ps=7.955u w=1.12u l=0.13u
M884 vdd SAR/sg13cmos5l_inv_1_28.Y SAR/a_11464_9224# vdd sg13_lv_pmos ad=0.2114p pd=1.54u as=0.2856p ps=2.36u w=0.84u l=0.13u
M885 vss SAR/a_12716_8400# ph_sw[5] vss sg13_lv_nmos ad=0.14875p pd=1.16u as=0.2886p ps=2.26u w=0.74u l=0.13u
M886 vss SAR/a_17584_7166# SAR/a_17233_7285# vss sg13_lv_nmos ad=79.8f pd=0.8u as=0.1428p ps=1.52u w=0.42u l=0.13u
M887 SAR/a_17412_1944# SAR/a_17386_1849# vss vss sg13_lv_nmos ad=0.2516p pd=2.16u as=0.1626p ps=1.415u w=0.74u l=0.13u
M888 vdd SAR/a_17392_4870# SAR/a_17337_4965# vdd sg13_lv_pmos ad=1.28962p pd=8.195u as=93.45f ps=0.865u w=0.42u l=0.13u
M889 vss SAR/sg13cmos5l_buf_1_2.A SAR/a_15784_1664# vss sg13_lv_nmos ad=0.14875p pd=1.16u as=0.187p ps=1.78u w=0.55u l=0.13u
M890 vss SAR/a_18363_4270# SAR/sg13cmos5l_or2_1_0.A vss sg13_lv_nmos ad=0.1406p pd=1.12u as=0.1406p ps=1.12u w=0.74u l=0.13u
M891 vss SAR/sg13cmos5l_buf_1_96.A SAR/a_11464_8436# vss sg13_lv_nmos ad=0.14875p pd=1.16u as=0.187p ps=1.78u w=0.55u l=0.13u
M892 vss SAR/a_16751_2749# SAR/a_17588_2388# vss sg13_lv_nmos ad=0.1406p pd=1.12u as=0.2516p ps=2.16u w=0.74u l=0.13u
M893 SAR/sg13cmos5l_buf_1_28.X SAR/a_9448_1664# vss vss sg13_lv_nmos ad=0.2886p pd=2.26u as=0.14875p ps=1.16u w=0.74u l=0.13u
M894 vdd SAR/sg13cmos5l_dfrbp_1_8.RESET_B SAR/a_8746_8404# vdd sg13_lv_pmos ad=0.1563p pd=1.22u as=0.147p ps=1.54u w=0.42u l=0.13u
M895 SAR/a_19244_2352# SAR/sg13cmos5l_buf_1_18.X vdd vdd sg13_lv_pmos ad=0.2856p pd=2.36u as=0.2114p ps=1.54u w=0.84u l=0.13u
M896 vss SAR/a_4041_2745# SAR/a_4566_2818# vss sg13_lv_nmos ad=0.1491p pd=1.18u as=0.187p ps=1.78u w=0.55u l=0.13u
M897 vdd SAR/a_524_4614# ckc vdd sg13_lv_pmos ad=0.2114p pd=1.54u as=0.42p ps=2.99u w=1.12u l=0.13u
M898 SAR/a_10022_7674# SAR/sg13cmos5l_buf_1_57.X vdd vdd sg13_lv_pmos ad=79.8f pd=0.8u as=0.1428p ps=1.52u w=0.42u l=0.13u
M899 SAR/a_17008_2630# SAR/a_16751_2749# SAR/a_17170_2826# vss sg13_lv_nmos ad=0.1428p pd=1.52u as=37.8f ps=0.6u w=0.42u l=0.13u
M900 SAR/a_17386_1849# SAR/a_17829_1605# SAR/a_17126_1626# vss sg13_lv_nmos ad=79.8f pd=0.8u as=0.1296p ps=1.52u w=0.42u l=0.13u
M901 SAR/a_2340_3456# SAR/a_2314_3361# vss vss sg13_lv_nmos ad=0.2516p pd=2.16u as=0.1626p ps=1.415u w=0.74u l=0.13u
M902 SAR/a_15876_4968# SAR/a_16395_4772# SAR/a_17135_4727# vss sg13_lv_nmos ad=0.3473p pd=2.71u as=0.12665p ps=1.145u w=0.74u l=0.13u
M903 SAR/a_11182_4948# SAR/sg13cmos5l_a221oi_1_0.B1 SAR/a_11394_4948# vdd sg13_lv_pmos ad=0.2128p pd=1.5u as=0.3808p ps=2.92u w=1.12u l=0.13u
M904 vss SAR/a_1815_4666# SAR/a_1946_4660# vss sg13_lv_nmos ad=2.41737p pd=15.64u as=0.2775p ps=2.23u w=0.74u l=0.13u
M905 vss rdy SAR/a_424_8436# vss sg13_lv_nmos ad=0.14875p pd=1.16u as=0.187p ps=1.78u w=0.55u l=0.13u
M906 SAR/a_16462_4338# SAR/a_16703_3871# SAR/a_15821_3864# vss sg13_lv_nmos ad=0.1428p pd=1.52u as=0.12665p ps=1.145u w=0.42u l=0.13u
M907 SAR/a_18363_4270# SAR/sg13cmos5l_buf_8_1.A vss vss sg13_lv_nmos ad=0.1406p pd=1.12u as=0.1406p ps=1.12u w=0.74u l=0.13u
M908 vdd SAR/sg13cmos5l_dfrbp_1_6.RESET_B SAR/a_13161_7281# vdd sg13_lv_pmos ad=0.2128p pd=1.5u as=0.2128p ps=1.5u w=1.12u l=0.13u
M909 SAR/sg13cmos5l_buf_1_104.A SAR/sg13cmos5l_buf_1_3.A vss vss sg13_lv_nmos ad=0.2516p pd=2.16u as=0.2516p ps=2.16u w=0.74u l=0.13u
M910 vss SAR/a_2409_4650# SAR/a_2364_4686# vss sg13_lv_nmos ad=0.1428p pd=1.52u as=47.25f ps=0.645u w=0.42u l=0.13u
M911 SAR/a_20012_2352# SAR/sg13cmos5l_buf_1_0.X vss vss sg13_lv_nmos ad=0.187p pd=1.78u as=0.14875p ps=1.16u w=0.55u l=0.13u
M912 vdd SAR/sg13cmos5l_dfrbp_1_8.RESET_B SAR/a_3302_4650# vdd sg13_lv_pmos ad=0.36237p pd=2.605u as=79.8f ps=0.8u w=0.42u l=0.13u
M913 vdd SAR/sg13cmos5l_dlhr_1_15.D SAR/a_17545_7728# vdd sg13_lv_pmos ad=1.15047p pd=7.175u as=0.2856p ps=2.36u w=0.84u l=0.13u
M914 SAR/a_4460_9150# SAR/sg13cmos5l_buf_1_60.A vss vss sg13_lv_nmos ad=0.187p pd=1.78u as=0.14875p ps=1.16u w=0.55u l=0.13u
M915 vdd SAR/a_18345_7674# SAR/a_18278_8112# vdd sg13_lv_pmos ad=0.2387p pd=1.84u as=0.1008p ps=0.9u w=0.42u l=0.13u
M916 SAR/a_11182_4948# SAR/sg13cmos5l_a221oi_1_0.A2 vdd vdd sg13_lv_pmos ad=0.2128p pd=1.5u as=0.3808p ps=2.92u w=1.12u l=0.13u
M917 vss SAR/a_15887_8797# SAR/a_16724_8436# vss sg13_lv_nmos ad=0.1406p pd=1.12u as=0.2516p ps=2.16u w=0.74u l=0.13u
M918 SAR/a_3575_6553# SAR/sg13cmos5l_dfrbp_1_8.RESET_B vdd vdd sg13_lv_pmos ad=79.8f pd=0.8u as=0.36237p ps=2.605u w=0.42u l=0.13u
M919 SAR/a_5079_3154# SAR/sg13cmos5l_dfrbp_1_9.Q vdd vdd sg13_lv_pmos ad=0.3234p pd=2.45u as=1.38655p ps=8.8u w=0.84u l=0.13u
M920 vss SAR/a_8783_7751# SAR/a_9620_7972# vss sg13_lv_nmos ad=0.1406p pd=1.12u as=0.2516p ps=2.16u w=0.74u l=0.13u
M921 SAR/a_2644_4636# SAR/a_2228_4972# SAR/a_2409_4650# vss sg13_lv_nmos ad=77.7f pd=0.95u as=0.2516p ps=2.16u w=0.74u l=0.13u
M922 SAR/a_17519_6239# SAR/a_16677_6141# SAR/a_17425_6239# vss sg13_lv_nmos ad=0.12665p pd=1.145u as=0.1428p ps=1.52u w=0.42u l=0.13u
M923 vdd vss vdd vdd sg13_lv_pmos ad=0.34p pd=2.68u as=0 ps=0 w=1u l=1u
M924 vss vdd vss vss sg13_lv_nmos ad=0.1428p pd=1.52u as=0 ps=0 w=0.42u l=1u
M925 SAR/a_1967_5773# SAR/a_1125_5423# SAR/a_708_5416# vdd sg13_lv_pmos ad=0.2048p pd=1.63u as=0.34p ps=2.68u w=1u l=0.13u
M926 vdd SAR/a_17327_7285# SAR/a_17584_7166# vdd sg13_lv_pmos ad=0.2639p pd=1.81u as=79.8f ps=0.8u w=0.42u l=0.13u
M927 SAR/sg13cmos5l_buf_1_9.A SAR/a_9832_1664# vss vss sg13_lv_nmos ad=0.2886p pd=2.26u as=0.14875p ps=1.16u w=0.74u l=0.13u
M928 vdd SAR/a_8204_9150# SAR/sg13cmos5l_buf_1_74.X vdd sg13_lv_pmos ad=0.2114p pd=1.54u as=0.42p ps=2.99u w=1.12u l=0.13u
M929 SAR/a_8783_7751# SAR/a_7941_7653# SAR/a_7524_7992# vdd sg13_lv_pmos ad=0.2048p pd=1.63u as=0.34p ps=2.68u w=1u l=0.13u
M930 vdd SAR/a_13072_4142# SAR/a_13017_4023# vdd sg13_lv_pmos ad=1.43437p pd=9.105u as=93.45f ps=0.865u w=0.42u l=0.13u
M931 vss SAR/sg13cmos5l_dfrbp_1_0.Q SAR/sg13cmos5l_dfrbp_1_0.D vss sg13_lv_nmos ad=0.2516p pd=2.16u as=0.1406p ps=1.12u w=0.74u l=0.13u
M932 SAR/a_708_6928# SAR/a_682_6892# vdd vdd sg13_lv_pmos ad=0.34p pd=2.68u as=0.36237p ps=2.605u w=1u l=0.13u
M933 vss SAR/sg13cmos5l_dlhr_1_5.D SAR/a_7657_7282# vss sg13_lv_nmos ad=0.15055p pd=1.17u as=0.187p ps=1.78u w=0.55u l=0.13u
M934 SAR/a_15412_5800# SAR/a_14996_5412# SAR/a_15177_5769# vss sg13_lv_nmos ad=77.7f pd=0.95u as=0.2516p ps=2.16u w=0.74u l=0.13u
M935 SAR/a_5492_3460# SAR/a_5210_3148# SAR/a_5425_3130# vss sg13_lv_nmos ad=0.141p pd=1.17u as=71.99999f ps=0.865u w=0.64u l=0.13u
M936 SAR/a_4934_2826# SAR/a_5739_2399# SAR/a_5194_2356# vdd sg13_lv_pmos ad=0.1428p pd=1.52u as=79.8f ps=0.8u w=0.42u l=0.13u
M937 vss SAR/sg13cmos5l_inv_1_3.A SAR/sg13cmos5l_buf_1_7.A vss sg13_lv_nmos ad=0.2516p pd=2.16u as=0.2516p ps=2.16u w=0.74u l=0.13u
M938 SAR/a_5049_4965# SAR/a_4107_4772# SAR/a_4847_4727# vdd sg13_lv_pmos ad=93.45f pd=0.865u as=0.2048p ps=1.63u w=0.42u l=0.13u
M939 SAR/sg13cmos5l_nor2_1_0.A SAR/a_13556_2388# vss vss sg13_lv_nmos ad=0.2516p pd=2.16u as=0.1406p ps=1.12u w=0.74u l=0.13u
M940 SAR/a_12815_1703# SAR/a_11973_1605# SAR/a_12721_1703# vss sg13_lv_nmos ad=0.12665p pd=1.145u as=0.1428p ps=1.52u w=0.42u l=0.13u
M941 vss SAR/a_14889_7281# SAR/a_14844_7326# vss sg13_lv_nmos ad=0.1428p pd=1.52u as=47.25f ps=0.645u w=0.42u l=0.13u
M942 vss SAR/a_19227_4654# SAR/sg13cmos5l_buf_8_0.X vss sg13_lv_nmos ad=0.2516p pd=2.16u as=0.1406p ps=1.12u w=0.74u l=0.13u
M943 SAR/a_6022_4325# SAR/sg13cmos5l_dfrbp_1_6.RESET_B vss vss sg13_lv_nmos ad=37.8f pd=0.6u as=0.1701p ps=1.65u w=0.42u l=0.13u
M944 SAR/a_1484_6126# SAR/sg13cmos5l_buf_1_58.A vss vss sg13_lv_nmos ad=0.187p pd=1.78u as=0.14875p ps=1.16u w=0.55u l=0.13u
M945 SAR/a_5446_2813# SAR/sg13cmos5l_dfrbp_1_6.RESET_B vss vss sg13_lv_nmos ad=37.8f pd=0.6u as=0.1701p ps=1.65u w=0.42u l=0.13u
M946 SAR/a_15884_3102# SAR/sg13cmos5l_buf_1_5.X vdd vdd sg13_lv_pmos ad=0.2856p pd=2.36u as=0.2114p ps=1.54u w=0.84u l=0.13u
M947 SAR/a_4559_7630# SAR/sg13cmos5l_dlhr_1_9.D vss vss sg13_lv_nmos ad=0.187p pd=1.78u as=0.15055p ps=1.17u w=0.55u l=0.13u
M948 SAR/a_6372_4968# SAR/a_6346_4873# vss vss sg13_lv_nmos ad=0.2516p pd=2.16u as=0.1626p ps=1.415u w=0.74u l=0.13u
M949 SAR/sg13cmos5l_a22oi_1_2.B1 SAR/sg13cmos5l_nand2_1_1.B vss vss sg13_lv_nmos ad=0.1406p pd=1.12u as=0.2516p ps=2.16u w=0.74u l=0.13u
M950 SAR/a_10783_3876# SAR/sg13cmos5l_inv_1_0.A SAR/sg13cmos5l_a22oi_1_0.Y vdd sg13_lv_pmos ad=0.2744p pd=1.61u as=0.2128p ps=1.5u w=1.12u l=0.13u
M951 SAR/a_12976_2630# SAR/a_12719_2749# SAR/a_13138_2826# vss sg13_lv_nmos ad=0.1428p pd=1.52u as=37.8f ps=0.6u w=0.42u l=0.13u
M952 SAR/sg13cmos5l_dfrbp_1_6.RESET_B _cks vss vss sg13_lv_nmos ad=0.1406p pd=1.12u as=0.2516p ps=2.16u w=0.74u l=0.13u
M953 vdd SAR/sg13cmos5l_dlhr_1_15.Q SAR/a_19240_7712# vdd sg13_lv_pmos ad=0.2114p pd=1.54u as=0.2856p ps=2.36u w=0.84u l=0.13u
M954 vdd SAR/a_8457_7281# SAR/a_8390_6924# vdd sg13_lv_pmos ad=0.2387p pd=1.84u as=0.1008p ps=0.9u w=0.42u l=0.13u
M955 vss SAR/sg13cmos5l_dfrbp_1_6.RESET_B SAR/a_13876_7660# vss sg13_lv_nmos ad=0.1406p pd=1.12u as=77.7f ps=0.95u w=0.74u l=0.13u
M956 vdd SAR/a_5324_1590# SAR/sg13cmos5l_buf_1_39.A vdd sg13_lv_pmos ad=0.2114p pd=1.54u as=0.42p ps=2.99u w=1.12u l=0.13u
M957 vdd SAR/sg13cmos5l_inv_1_1.A SAR/a_16264_9224# vdd sg13_lv_pmos ad=0.2114p pd=1.54u as=0.2856p ps=2.36u w=0.84u l=0.13u
M958 SAR/a_3669_6320# SAR/sg13cmos5l_dfrbp_1_8.RESET_B vdd vdd sg13_lv_pmos ad=0.147p pd=1.54u as=0.1563p ps=1.22u w=0.42u l=0.13u
M959 SAR/a_3860_2388# SAR/a_3447_2746# SAR/a_3792_2388# vdd sg13_lv_pmos ad=0.191p pd=1.44u as=0.105p ps=1.21u w=1u l=0.13u
M960 vdd SAR/a_10464_2427# SAR/sg13cmos5l_dfrbp_1_4.D vdd sg13_lv_pmos ad=0.3808p pd=2.92u as=0.2408p ps=1.55u w=1.12u l=0.13u
M961 SAR/a_14924_1590# SAR/sg13cmos5l_buf_1_6.A vss vss sg13_lv_nmos ad=0.187p pd=1.78u as=0.14875p ps=1.16u w=0.55u l=0.13u
M962 SAR/a_20012_1590# SAR/sg13cmos5l_buf_1_0.A vss vss sg13_lv_nmos ad=0.187p pd=1.78u as=0.14875p ps=1.16u w=0.55u l=0.13u
M963 vdd SAR/a_8783_7751# SAR/a_9040_7894# vdd sg13_lv_pmos ad=0.2639p pd=1.81u as=79.8f ps=0.8u w=0.42u l=0.13u
M964 SAR/a_5132_9150# SAR/sg13cmos5l_buf_1_44.X vss vss sg13_lv_nmos ad=0.187p pd=1.78u as=0.14875p ps=1.16u w=0.55u l=0.13u
M965 SAR/a_8204_9150# SAR/sg13cmos5l_buf_1_45.X vdd vdd sg13_lv_pmos ad=0.2856p pd=2.36u as=0.2114p ps=1.54u w=0.84u l=0.13u
M966 _d1 SAR/a_20008_3900# vss vss sg13_lv_nmos ad=0.2886p pd=2.26u as=0.14875p ps=1.16u w=0.74u l=0.13u
M967 SAR/sg13cmos5l_buf_1_34.X SAR/a_4840_1664# vdd vdd sg13_lv_pmos ad=0.42p pd=2.99u as=0.2114p ps=1.54u w=1.12u l=0.13u
M968 SAR/sg13cmos5l_dlhr_1_20.Q_N SAR/a_10230_4632# vss vss sg13_lv_nmos ad=0.2516p pd=2.16u as=0.1491p ps=1.18u w=0.74u l=0.13u
M969 SAR/a_5988_8440# SAR/a_6507_8447# SAR/a_7247_8797# vss sg13_lv_nmos ad=0.3473p pd=2.71u as=0.12665p ps=1.145u w=0.74u l=0.13u
M970 SAR/sg13cmos5l_nor2b_1_0.Y SAR/a_12814_4692# vss vss sg13_lv_nmos ad=0.1406p pd=1.12u as=0.17255p ps=1.25u w=0.74u l=0.13u
M971 SAR/a_4076_7624# SAR/a_4349_7636# SAR/a_4311_7710# vss sg13_lv_nmos ad=0.141p pd=1.17u as=47.25f ps=0.645u w=0.42u l=0.13u
M972 vss SAR/a_7689_1626# SAR/a_7644_1662# vss sg13_lv_nmos ad=0.1428p pd=1.52u as=47.25f ps=0.645u w=0.42u l=0.13u
M973 SAR/sg13cmos5l_a221oi_1_0.A2 SAR/a_7892_3900# vss vss sg13_lv_nmos ad=0.2516p pd=2.16u as=0.1406p ps=1.12u w=0.74u l=0.13u
M974 SAR/a_17988_3151# SAR/a_17700_3456# SAR/a_17926_3151# vss sg13_lv_nmos ad=0.1428p pd=1.52u as=37.8f ps=0.6u w=0.42u l=0.13u
M975 vdd SAR/sg13cmos5l_dfrbp_1_8.RESET_B SAR/a_15782_7362# vdd sg13_lv_pmos ad=0.36237p pd=2.605u as=79.8f ps=0.8u w=0.42u l=0.13u
M976 vdd SAR/sg13cmos5l_dfrbp_1_6.RESET_B SAR/a_19593_6162# vdd sg13_lv_pmos ad=0.2128p pd=1.5u as=0.2128p ps=1.5u w=1.12u l=0.13u
M977 vdd SAR/sg13cmos5l_buf_1_34.A SAR/a_4840_1664# vdd sg13_lv_pmos ad=0.2114p pd=1.54u as=0.2856p ps=2.36u w=0.84u l=0.13u
M978 SAR/a_6346_4873# SAR/a_6789_4629# SAR/a_6086_4650# vss sg13_lv_nmos ad=79.8f pd=0.8u as=0.1296p ps=1.52u w=0.42u l=0.13u
M979 SAR/a_4934_2826# SAR/sg13cmos5l_dfrbp_1_6.D vdd vdd sg13_lv_pmos ad=79.8f pd=0.8u as=0.1428p ps=1.52u w=0.42u l=0.13u
M980 SAR/a_6180_4650# SAR/sg13cmos5l_dlhr_1_0.GATE SAR/a_6086_4650# vss sg13_lv_nmos ad=60.89999f pd=0.71u as=0.1428p ps=1.52u w=0.42u l=0.13u
M981 SAR/a_10725_7653# SAR/sg13cmos5l_dlhr_1_11.GATE vss vss sg13_lv_nmos ad=0.2516p pd=2.16u as=1.49685p ps=9.6u w=0.74u l=0.13u
M982 SAR/a_7924_1612# SAR/a_7508_1948# SAR/a_7689_1626# vss sg13_lv_nmos ad=77.7f pd=0.95u as=0.2516p ps=2.16u w=0.74u l=0.13u
M983 SAR/a_7666_8874# SAR/sg13cmos5l_dfrbp_1_8.RESET_B vss vss sg13_lv_nmos ad=37.8f pd=0.6u as=79.8f ps=0.8u w=0.42u l=0.13u
M984 vdd SAR/sg13cmos5l_dfrbp_1_6.RESET_B SAR/a_10665_7281# vdd sg13_lv_pmos ad=0.2128p pd=1.5u as=0.2128p ps=1.5u w=1.12u l=0.13u
M985 vss SAR/sg13cmos5l_dfrbp_1_16.Q SAR/a_3625_7282# vss sg13_lv_nmos ad=0.15055p pd=1.17u as=0.187p ps=1.78u w=0.55u l=0.13u
M986 SAR/a_13324_4696# SAR/sg13cmos5l_inv_1_0.A vdd vdd sg13_lv_pmos ad=0.1596p pd=1.22u as=0.1596p ps=1.22u w=0.84u l=0.13u
M987 SAR/a_10022_7674# SAR/a_10827_7796# SAR/a_10282_7897# vdd sg13_lv_pmos ad=0.1428p pd=1.52u as=79.8f ps=0.8u w=0.42u l=0.13u
M988 SAR/sg13cmos5l_dlhr_1_6.Q_N SAR/a_9558_6144# vss vss sg13_lv_nmos ad=0.2516p pd=2.16u as=0.1491p ps=1.18u w=0.74u l=0.13u
M989 SAR/a_10484_6924# SAR/a_10071_7282# SAR/a_10416_6924# vdd sg13_lv_pmos ad=0.191p pd=1.44u as=0.105p ps=1.21u w=1u l=0.13u
M990 SAR/a_19216_3358# SAR/a_18959_3215# SAR/a_19378_3138# vss sg13_lv_nmos ad=0.1428p pd=1.52u as=37.8f ps=0.6u w=0.42u l=0.13u
M991 SAR/sg13cmos5l_a22oi_1_1.B2 SAR/sg13cmos5l_and3_1_0.X vss vss sg13_lv_nmos ad=0.2516p pd=2.16u as=0.1406p ps=1.12u w=0.74u l=0.13u
M992 vss SAR/a_17516_9150# pl_sw[8] vss sg13_lv_nmos ad=0.14875p pd=1.16u as=0.2886p ps=2.26u w=0.74u l=0.13u
M993 vdd SAR/a_13775_6239# SAR/a_14612_6460# vdd sg13_lv_pmos ad=0.2128p pd=1.5u as=0.3864p ps=2.93u w=1.12u l=0.13u
M994 vss SAR/a_6572_1590# SAR/sg13cmos5l_buf_1_24.X vss sg13_lv_nmos ad=0.14875p pd=1.16u as=0.2886p ps=2.26u w=0.74u l=0.13u
M995 vdd SAR/sg13cmos5l_dfrbp_1_8.RESET_B SAR/a_6346_4873# vdd sg13_lv_pmos ad=0.1563p pd=1.22u as=0.147p ps=1.54u w=0.42u l=0.13u
M996 pl_sw[4] SAR/a_5800_9224# vss vss sg13_lv_nmos ad=0.2886p pd=2.26u as=0.14875p ps=1.16u w=0.74u l=0.13u
M997 SAR/a_422_5850# SAR/a_1227_5423# SAR/a_682_5380# vdd sg13_lv_pmos ad=0.1428p pd=1.52u as=79.8f ps=0.8u w=0.42u l=0.13u
M998 SAR/a_18999_6178# SAR/sg13cmos5l_dfrbp_1_8.D vss vss sg13_lv_nmos ad=0.2516p pd=2.16u as=0.15055p ps=1.17u w=0.74u l=0.13u
M999 SAR/a_11748_2813# SAR/a_11460_2392# SAR/a_11686_2813# vss sg13_lv_nmos ad=0.1428p pd=1.52u as=37.8f ps=0.6u w=0.42u l=0.13u
M1000 SAR/a_15062_4292# SAR/sg13cmos5l_a22oi_1_1.B2 SAR/sg13cmos5l_a22oi_1_1.Y vss sg13_lv_nmos ad=0.13875p pd=1.115u as=0.2664p ps=1.46u w=0.74u l=0.13u
M1001 vdd SAR/sg13cmos5l_or2_1_0.A SAR/a_18574_5028# vdd sg13_lv_pmos ad=0.2226p pd=1.535u as=0.1596p ps=1.22u w=0.84u l=0.13u
M1002 vss SAR/a_9040_7894# SAR/a_8689_7751# vss sg13_lv_nmos ad=79.8f pd=0.8u as=0.1428p ps=1.52u w=0.42u l=0.13u
M1003 SAR/a_14986_7897# SAR/a_15429_7653# SAR/a_15369_8065# vdd sg13_lv_pmos ad=79.8f pd=0.8u as=63f ps=0.72u w=0.42u l=0.13u
M1004 vss SAR/sg13cmos5l_dfrbp_1_0.RESET_B SAR/a_17220_1626# vss sg13_lv_nmos ad=0.1626p pd=1.415u as=60.89999f ps=0.71u w=0.42u l=0.13u
M1005 vss SAR/sg13cmos5l_buf_1_77.X SAR/a_7336_9224# vss sg13_lv_nmos ad=0.14875p pd=1.16u as=0.187p ps=1.78u w=0.55u l=0.13u
M1006 SAR/a_6405_8447# SAR/sg13cmos5l_inv_1_8.A vdd vdd sg13_lv_pmos ad=0.4088p pd=2.97u as=1.12242p ps=7u w=1.12u l=0.13u
M1007 SAR/a_7249_3130# SAR/a_6697_3192# vss vss sg13_lv_nmos ad=71.99999f pd=0.865u as=2.59257p ps=16.445u w=0.64u l=0.13u
M1008 SAR/sg13cmos5l_dlygate4sd2_1_0.X SAR/a_1290_3206# vss vss sg13_lv_nmos ad=0.2516p pd=2.16u as=0.1405p ps=1.15u w=0.74u l=0.13u
M1009 vss SAR/sg13cmos5l_inv_1_8.A SAR/a_2879_6432# vss sg13_lv_nmos ad=1.88087p pd=11.775u as=0.2516p ps=2.16u w=0.74u l=0.13u
M1010 _d0 SAR/a_20392_2388# vss vss sg13_lv_nmos ad=0.2886p pd=2.26u as=0.14875p ps=1.16u w=0.74u l=0.13u
M1011 vdd SAR/a_18363_4270# SAR/sg13cmos5l_or2_1_0.A vdd sg13_lv_pmos ad=0.2128p pd=1.5u as=0.2128p ps=1.5u w=1.12u l=0.13u
M1012 vss SAR/sg13cmos5l_dfrbp_1_6.RESET_B SAR/a_2148_3138# vss sg13_lv_nmos ad=0.1626p pd=1.415u as=60.89999f ps=0.71u w=0.42u l=0.13u
M1013 SAR/sg13cmos5l_buf_8_0.X SAR/a_19227_4654# vdd vdd sg13_lv_pmos ad=0.2128p pd=1.5u as=0.2128p ps=1.5u w=1.12u l=0.13u
M1014 vdd SAR/a_13072_1846# SAR/a_13017_1941# vdd sg13_lv_pmos ad=1.86162p pd=11.935u as=93.45f ps=0.865u w=0.42u l=0.13u
M1015 vdd vss vdd vdd sg13_lv_pmos ad=0.34p pd=2.68u as=0 ps=0 w=1u l=1u
M1016 vdd SAR/a_4847_4727# SAR/a_5684_4948# vdd sg13_lv_pmos ad=0.2128p pd=1.5u as=0.3864p ps=2.93u w=1.12u l=0.13u
M1017 SAR/a_10613_2758# SAR/sg13cmos5l_nand2_1_1.B vss vss sg13_lv_nmos ad=0.1406p pd=1.12u as=0.1898p ps=1.36u w=0.74u l=0.13u
M1018 SAR/a_11748_2813# SAR/a_11979_2399# SAR/a_11434_2356# vss sg13_lv_nmos ad=0.2373p pd=1.97u as=79.8f ps=0.8u w=0.42u l=0.13u
M1019 vss SAR/a_13484_8400# SAR/sg13cmos5l_buf_1_5.A vss sg13_lv_nmos ad=0.14875p pd=1.16u as=0.2886p ps=2.26u w=0.74u l=0.13u
M1020 SAR/a_17135_4727# SAR/a_16293_4629# SAR/a_17041_4727# vss sg13_lv_nmos ad=0.12665p pd=1.145u as=0.1428p ps=1.52u w=0.42u l=0.13u
M1021 vss vdd vss vss sg13_lv_nmos ad=0.1428p pd=1.52u as=0 ps=0 w=0.42u l=1u
M1022 SAR/a_12516_6480# SAR/a_12490_6385# vdd vdd sg13_lv_pmos ad=0.34p pd=2.68u as=0.36237p ps=2.605u w=1u l=0.13u
M1023 vss SAR/sg13cmos5l_buf_1_4.A SAR/sg13cmos5l_buf_1_110.A vss sg13_lv_nmos ad=0.2516p pd=2.16u as=0.2516p ps=2.16u w=0.74u l=0.13u
M1024 vss SAR/sg13cmos5l_dlhr_1_2.D SAR/a_6697_3192# vss sg13_lv_nmos ad=0.15055p pd=1.17u as=0.187p ps=1.78u w=0.55u l=0.13u
M1025 SAR/a_18363_4270# SAR/sg13cmos5l_buf_8_1.A vdd vdd sg13_lv_pmos ad=0.2128p pd=1.5u as=0.2128p ps=1.5u w=1.12u l=0.13u
M1026 SAR/a_10725_7653# SAR/sg13cmos5l_dlhr_1_11.GATE vdd vdd sg13_lv_pmos ad=0.4088p pd=2.97u as=1.12242p ps=7u w=1.12u l=0.13u
M1027 vdd SAR/a_16293_4629# SAR/a_16395_4772# vdd sg13_lv_pmos ad=1.28962p pd=8.195u as=0.3864p ps=2.93u w=1.12u l=0.13u
M1028 SAR/a_13116_7326# SAR/a_12567_7282# SAR/a_12980_6924# vss sg13_lv_nmos ad=47.25f pd=0.645u as=0.141p ps=1.17u w=0.42u l=0.13u
M1029 vss SAR/a_15500_9150# ph_sw[6] vss sg13_lv_nmos ad=0.14875p pd=1.16u as=0.2886p ps=2.26u w=0.74u l=0.13u
M1030 vdd SAR/a_12567_7282# SAR/a_12698_7288# vdd sg13_lv_pmos ad=1.07253p pd=6.75u as=0.2856p ps=2.36u w=0.84u l=0.13u
M1031 SAR/a_15782_7362# SAR/a_16587_6935# SAR/a_16042_6892# vdd sg13_lv_pmos ad=0.1428p pd=1.52u as=79.8f ps=0.8u w=0.42u l=0.13u
M1032 vdd SAR/sg13cmos5l_dlhr_1_5.D SAR/a_7657_7282# vdd sg13_lv_pmos ad=1.07253p pd=6.75u as=0.2856p ps=2.36u w=0.84u l=0.13u
M1033 SAR/a_10464_2427# SAR/sg13cmos5l_nand2_1_1.B SAR/a_10427_2736# vss sg13_lv_nmos ad=0.2176p pd=1.96u as=78.39999f ps=0.885u w=0.64u l=0.13u
M1034 vss SAR/sg13cmos5l_dlhr_1_6.D SAR/a_8233_6216# vss sg13_lv_nmos ad=0.15055p pd=1.17u as=0.187p ps=1.78u w=0.55u l=0.13u
M1035 SAR/sg13cmos5l_dfrbp_1_0.Q SAR/a_19508_1924# vdd vdd sg13_lv_pmos ad=0.3808p pd=2.92u as=0.2128p ps=1.5u w=1.12u l=0.13u
M1036 SAR/a_17135_4727# SAR/a_16293_4629# SAR/a_15876_4968# vdd sg13_lv_pmos ad=0.2048p pd=1.63u as=0.34p ps=2.68u w=1u l=0.13u
M1037 SAR/a_10420_5412# SAR/sg13cmos5l_dfrbp_1_20.Q vdd vdd sg13_lv_pmos ad=0.2128p pd=1.5u as=0.3808p ps=2.92u w=1.12u l=0.13u
M1038 vss SAR/a_19227_4654# SAR/sg13cmos5l_buf_8_0.X vss sg13_lv_nmos ad=0.1406p pd=1.12u as=0.1406p ps=1.12u w=0.74u l=0.13u
M1039 SAR/a_16690_7674# SAR/sg13cmos5l_dfrbp_1_6.RESET_B vss vss sg13_lv_nmos ad=37.8f pd=0.6u as=79.8f ps=0.8u w=0.42u l=0.13u
M1040 SAR/a_1158_3142# SAR/a_902_3142# vdd vdd sg13_lv_pmos ad=0.34p pd=2.68u as=0.2481p ps=1.56u w=1u l=0.25u
M1041 SAR/a_3588_4968# SAR/a_3562_4873# vdd vdd sg13_lv_pmos ad=0.34p pd=2.68u as=0.36237p ps=2.605u w=1u l=0.13u
M1042 SAR/sg13cmos5l_buf_8_2.X SAR/a_19227_9190# vss vss sg13_lv_nmos ad=0.1406p pd=1.12u as=0.1406p ps=1.12u w=0.74u l=0.13u
M1043 vss SAR/sg13cmos5l_inv_1_6.A SAR/a_20008_8436# vss sg13_lv_nmos ad=0.14875p pd=1.16u as=0.187p ps=1.78u w=0.55u l=0.13u
M1044 SAR/sg13cmos5l_dfrbp_1_23.CLK SAR/a_14228_9484# vdd vdd sg13_lv_pmos ad=0.3808p pd=2.92u as=0.2128p ps=1.5u w=1.12u l=0.13u
M1045 vss SAR/sg13cmos5l_buf_1_24.A SAR/sg13cmos5l_buf_1_78.A vss sg13_lv_nmos ad=0.2516p pd=2.16u as=0.2516p ps=2.16u w=0.74u l=0.13u
M1046 SAR/a_7508_1948# SAR/a_7095_1642# SAR/a_7440_1948# vdd sg13_lv_pmos ad=0.191p pd=1.44u as=0.105p ps=1.21u w=1u l=0.13u
M1047 vdd SAR/a_7216_6382# SAR/a_7161_6477# vdd sg13_lv_pmos ad=1.07253p pd=6.75u as=93.45f ps=0.865u w=0.42u l=0.13u
M1048 vss SAR/sg13cmos5l_nor2b_1_0.Y SAR/a_11054_4292# vss sg13_lv_nmos ad=0.2516p pd=2.16u as=96.2f ps=1u w=0.74u l=0.13u
M1049 SAR/a_19548_6198# SAR/a_18999_6178# SAR/a_19412_6484# vss sg13_lv_nmos ad=47.25f pd=0.645u as=0.141p ps=1.17u w=0.42u l=0.13u
M1050 vss SAR/a_4041_2745# SAR/a_3996_2790# vss sg13_lv_nmos ad=0.1428p pd=1.52u as=47.25f ps=0.645u w=0.42u l=0.13u
M1051 SAR/sg13cmos5l_dfrbp_1_10.Q SAR/a_4436_3436# vdd vdd sg13_lv_pmos ad=0.3808p pd=2.92u as=0.2128p ps=1.5u w=1.12u l=0.13u
M1052 vss SAR/a_1006_4167# SAR/sg13cmos5l_dlygate4sd3_1_0.X vss sg13_lv_nmos ad=0.1426p pd=1.16u as=0.2516p ps=2.16u w=0.74u l=0.13u
M1053 vss SAR/sg13cmos5l_buf_1_19.A SAR/a_18760_2388# vss sg13_lv_nmos ad=0.14875p pd=1.16u as=0.187p ps=1.78u w=0.55u l=0.13u
M1054 vss SAR/sg13cmos5l_dfrbp_1_6.RESET_B SAR/a_5908_3124# vss sg13_lv_nmos ad=0.1406p pd=1.12u as=77.7f ps=0.95u w=0.74u l=0.13u
M1055 vdd SAR/sg13cmos5l_buf_1_60.X SAR/a_2248_9224# vdd sg13_lv_pmos ad=0.2114p pd=1.54u as=0.2856p ps=2.36u w=0.84u l=0.13u
M1056 vss SAR/sg13cmos5l_buf_1_98.A SAR/a_13768_8436# vss sg13_lv_nmos ad=0.14875p pd=1.16u as=0.187p ps=1.78u w=0.55u l=0.13u
M1057 vss SAR/a_11072_5347# SAR/sg13cmos5l_a221oi_1_1.C1 vss sg13_lv_nmos ad=0.1371p pd=1.12u as=0.2516p ps=2.16u w=0.74u l=0.13u
M1058 SAR/a_14628_8440# SAR/a_14602_8404# vss vss sg13_lv_nmos ad=0.2516p pd=2.16u as=0.1626p ps=1.415u w=0.74u l=0.13u
M1059 vdd SAR/a_9260_2352# nh_sw[4] vdd sg13_lv_pmos ad=0.2114p pd=1.54u as=0.42p ps=2.99u w=1.12u l=0.13u
M1060 vdd SAR/a_7312_4142# SAR/a_7257_4023# vdd sg13_lv_pmos ad=1.43437p pd=9.105u as=93.45f ps=0.865u w=0.42u l=0.13u
M1061 vss SAR/a_17135_4727# SAR/a_17972_4948# vss sg13_lv_nmos ad=0.1406p pd=1.12u as=0.2516p ps=2.16u w=0.74u l=0.13u
M1062 SAR/a_908_1590# SAR/sg13cmos5l_buf_1_32.A vss vss sg13_lv_nmos ad=0.187p pd=1.78u as=0.14875p ps=1.16u w=0.55u l=0.13u
M1063 SAR/a_7247_8797# SAR/a_6405_8447# SAR/a_7153_8797# vss sg13_lv_nmos ad=0.12665p pd=1.145u as=0.1428p ps=1.52u w=0.42u l=0.13u
M1064 SAR/a_5700_6480# SAR/a_6219_6284# SAR/a_6959_6239# vss sg13_lv_nmos ad=0.3473p pd=2.71u as=0.12665p ps=1.145u w=0.74u l=0.13u
M1065 vdd SAR/sg13cmos5l_dfrbp_1_1.Q SAR/sg13cmos5l_inv_1_11.Y vdd sg13_lv_pmos ad=0.3808p pd=2.92u as=0.3808p ps=2.92u w=1.12u l=0.13u
M1066 SAR/a_5770_3868# SAR/a_6213_3911# SAR/a_6153_3947# vdd sg13_lv_pmos ad=79.8f pd=0.8u as=63f ps=0.72u w=0.42u l=0.13u
M1067 vss SAR/a_10473_9186# SAR/a_10428_9222# vss sg13_lv_nmos ad=0.1428p pd=1.52u as=47.25f ps=0.645u w=0.42u l=0.13u
M1068 SAR/a_524_4614# SAR/sg13cmos5l_buf_1_43.A vdd vdd sg13_lv_pmos ad=0.2856p pd=2.36u as=0.2114p ps=1.54u w=0.84u l=0.13u
M1069 vdd SAR/sg13cmos5l_buf_1_116.A SAR/a_15592_6200# vdd sg13_lv_pmos ad=0.2114p pd=1.54u as=0.2856p ps=2.36u w=0.84u l=0.13u
M1070 SAR/a_15492_2392# SAR/a_15466_2356# vss vss sg13_lv_nmos ad=0.2516p pd=2.16u as=0.1626p ps=1.415u w=0.74u l=0.13u
M1071 vss SAR/a_18363_4270# SAR/sg13cmos5l_or2_1_0.A vss sg13_lv_nmos ad=0.2516p pd=2.16u as=0.1406p ps=1.12u w=0.74u l=0.13u
M1072 vss SAR/a_3308_5376# SAR/sg13cmos5l_buf_1_41.A vss sg13_lv_nmos ad=0.14875p pd=1.16u as=0.2886p ps=2.26u w=0.74u l=0.13u
M1073 vdd SAR/sg13cmos5l_inv_1_26.Y SAR/a_17896_9224# vdd sg13_lv_pmos ad=0.2114p pd=1.54u as=0.2856p ps=2.36u w=0.84u l=0.13u
M1074 SAR/a_6345_8483# SAR/a_5988_8440# vdd vdd sg13_lv_pmos ad=63f pd=0.72u as=0.1563p ps=1.22u w=0.42u l=0.13u
M1075 vss SAR/a_10220_3102# nl_sw[5] vss sg13_lv_nmos ad=0.14875p pd=1.16u as=0.2886p ps=2.26u w=0.74u l=0.13u
M1076 vdd SAR/a_7820_9150# SAR/sg13cmos5l_buf_1_73.X vdd sg13_lv_pmos ad=0.2114p pd=1.54u as=0.42p ps=2.99u w=1.12u l=0.13u
M1077 SAR/a_16144_8678# SAR/sg13cmos5l_dfrbp_1_8.RESET_B vdd vdd sg13_lv_pmos ad=79.8f pd=0.8u as=1.12242p ps=7u w=0.42u l=0.13u
M1078 vss SAR/sg13cmos5l_inv_1_0.A SAR/sg13cmos5l_inv_1_0.Y vss sg13_lv_nmos ad=0.2516p pd=2.16u as=0.2516p ps=2.16u w=0.74u l=0.13u
M1079 SAR/a_10318_5412# SAR/sg13cmos5l_a221oi_1_1.C1 SAR/sg13cmos5l_a22oi_1_2.B2 vdd sg13_lv_pmos ad=0.2128p pd=1.5u as=0.3808p ps=2.92u w=1.12u l=0.13u
M1080 vss SAR/a_9033_6162# SAR/a_9558_6144# vss sg13_lv_nmos ad=0.1491p pd=1.18u as=0.187p ps=1.78u w=0.55u l=0.13u
M1081 vss SAR/sg13cmos5l_buf_8_0.A SAR/a_19227_4654# vss sg13_lv_nmos ad=0.1406p pd=1.12u as=0.2553p ps=2.17u w=0.74u l=0.13u
M1082 SAR/a_11556_3904# SAR/a_11530_3868# vdd vdd sg13_lv_pmos ad=0.34p pd=2.68u as=0.36237p ps=2.605u w=1u l=0.13u
M1083 vss SAR/sg13cmos5l_buf_1_86.A SAR/a_20392_6924# vss sg13_lv_nmos ad=0.14875p pd=1.16u as=0.187p ps=1.78u w=0.55u l=0.13u
M1084 SAR/sg13cmos5l_or2_1_0.A SAR/a_18363_4270# vss vss sg13_lv_nmos ad=0.1406p pd=1.12u as=0.1406p ps=1.12u w=0.74u l=0.13u
M1085 SAR/a_7055_4261# SAR/a_6213_3911# SAR/a_6961_4261# vss sg13_lv_nmos ad=0.12665p pd=1.145u as=0.1428p ps=1.52u w=0.42u l=0.13u
M1086 SAR/sg13cmos5l_buf_8_0.X SAR/a_19227_4654# vdd vdd sg13_lv_pmos ad=0.2128p pd=1.5u as=0.2128p ps=1.5u w=1.12u l=0.13u
M1087 vdd SAR/a_19227_9190# SAR/sg13cmos5l_buf_8_2.X vdd sg13_lv_pmos ad=0.2128p pd=1.5u as=0.2128p ps=1.5u w=1.12u l=0.13u
M1088 pl_sw[5] SAR/a_7336_9224# vdd vdd sg13_lv_pmos ad=0.42p pd=2.99u as=0.2114p ps=1.54u w=1.12u l=0.13u
M1089 SAR/a_16042_6892# SAR/a_16485_6935# SAR/a_15782_7362# vss sg13_lv_nmos ad=79.8f pd=0.8u as=0.1296p ps=1.52u w=0.42u l=0.13u
M1090 vss SAR/sg13cmos5l_dfrbp_1_6.RESET_B SAR/a_10900_7312# vss sg13_lv_nmos ad=0.1406p pd=1.12u as=77.7f ps=0.95u w=0.74u l=0.13u
M1091 SAR/a_6647_5459# SAR/sg13cmos5l_dfrbp_1_11.Q SAR/a_7394_5850# vss sg13_lv_nmos ad=0.1428p pd=1.52u as=60.89999f ps=0.71u w=0.42u l=0.13u
M1092 SAR/a_6647_5459# SAR/sg13cmos5l_dfrbp_1_8.RESET_B vdd vdd sg13_lv_pmos ad=79.8f pd=0.8u as=0.36237p ps=2.605u w=0.42u l=0.13u
M1093 SAR/a_5606_3576# SAR/a_5210_3148# SAR/a_5492_3460# vdd sg13_lv_pmos ad=0.1008p pd=0.9u as=0.191p ps=1.44u w=0.42u l=0.13u
M1094 SAR/a_3664_4142# SAR/a_3407_4261# SAR/a_3826_4338# vss sg13_lv_nmos ad=0.1428p pd=1.52u as=37.8f ps=0.6u w=0.42u l=0.13u
M1095 vss SAR/sg13cmos5l_dlhr_1_11.D SAR/a_12361_7282# vss sg13_lv_nmos ad=0.15055p pd=1.17u as=0.187p ps=1.78u w=0.55u l=0.13u
M1096 SAR/a_2727_6380# SAR/a_2879_6432# vdd vdd sg13_lv_pmos ad=0.3864p pd=2.93u as=1.07253p ps=6.75u w=1.12u l=0.13u
M1097 vdd SAR/sg13cmos5l_dfrbp_1_0.RESET_B SAR/a_11530_3868# vdd sg13_lv_pmos ad=0.1563p pd=1.22u as=0.147p ps=1.54u w=0.42u l=0.13u
M1098 vdd SAR/sg13cmos5l_nor2_1_0.A SAR/a_11980_4948# vdd sg13_lv_pmos ad=0.4032p pd=2.96u as=0.1176p ps=1.33u w=1.12u l=0.13u
M1099 SAR/a_5796_8874# SAR/sg13cmos5l_dlhr_1_5.GATE SAR/a_5702_8874# vss sg13_lv_nmos ad=60.89999f pd=0.71u as=0.1428p ps=1.52u w=0.42u l=0.13u
M1100 SAR/a_9164_1590# SAR/sg13cmos5l_buf_1_26.A vss vss sg13_lv_nmos ad=0.187p pd=1.78u as=0.14875p ps=1.16u w=0.55u l=0.13u
M1101 SAR/a_12230_6162# SAR/a_13035_6284# SAR/a_12490_6385# vdd sg13_lv_pmos ad=0.1428p pd=1.52u as=79.8f ps=0.8u w=0.42u l=0.13u
M1102 SAR/a_3692_9150# SAR/sg13cmos5l_inv_1_17.A vdd vdd sg13_lv_pmos ad=0.2856p pd=2.36u as=0.2114p ps=1.54u w=0.84u l=0.13u
M1103 SAR/a_7332_7674# SAR/sg13cmos5l_dfrbp_1_6.D SAR/a_7238_7674# vss sg13_lv_nmos ad=60.89999f pd=0.71u as=0.1428p ps=1.52u w=0.42u l=0.13u
M1104 SAR/sg13cmos5l_buf_1_46.A SAR/a_9705_4650# vdd vdd sg13_lv_pmos ad=0.3808p pd=2.92u as=0.2128p ps=1.5u w=1.12u l=0.13u
M1105 vdd SAR/sg13cmos5l_dfrbp_1_16.Q SAR/a_3625_7282# vdd sg13_lv_pmos ad=1.07253p pd=6.75u as=0.2856p ps=2.36u w=0.84u l=0.13u
M1106 SAR/sg13cmos5l_dlhr_1_11.D SAR/a_11567_7751# vss vss sg13_lv_nmos ad=0.2849p pd=2.25u as=0.2516p ps=2.16u w=0.74u l=0.13u
M1107 SAR/a_17529_7047# SAR/a_16587_6935# SAR/a_17327_7285# vdd sg13_lv_pmos ad=93.45f pd=0.865u as=0.2048p ps=1.63u w=0.42u l=0.13u
M1108 SAR/a_8988_6198# SAR/a_8439_6178# SAR/a_8852_6484# vss sg13_lv_nmos ad=47.25f pd=0.645u as=0.141p ps=1.17u w=0.42u l=0.13u
M1109 SAR/sg13cmos5l_buf_1_10.A SAR/a_11848_8436# vdd vdd sg13_lv_pmos ad=0.42p pd=2.99u as=0.2114p ps=1.54u w=1.12u l=0.13u
M1110 SAR/a_19227_4654# SAR/sg13cmos5l_buf_8_0.A vdd vdd sg13_lv_pmos ad=0.2128p pd=1.5u as=0.2128p ps=1.5u w=1.12u l=0.13u
M1111 SAR/sg13cmos5l_dfrbp_1_11.Q SAR/a_8468_4948# vdd vdd sg13_lv_pmos ad=0.3808p pd=2.92u as=0.2128p ps=1.5u w=1.12u l=0.13u
M1112 vss SAR/sg13cmos5l_dfrbp_1_6.RESET_B SAR/a_9940_4636# vss sg13_lv_nmos ad=0.1406p pd=1.12u as=77.7f ps=0.95u w=0.74u l=0.13u
M1113 SAR/a_12742_6175# SAR/sg13cmos5l_dfrbp_1_6.RESET_B vss vss sg13_lv_nmos ad=37.8f pd=0.6u as=0.1701p ps=1.65u w=0.42u l=0.13u
M1114 vss SAR/sg13cmos5l_buf_8_2.X SAR/a_20008_7712# vss sg13_lv_nmos ad=0.14875p pd=1.16u as=0.187p ps=1.78u w=0.55u l=0.13u
M1115 SAR/a_8972_9150# SAR/sg13cmos5l_buf_1_77.A vdd vdd sg13_lv_pmos ad=0.2856p pd=2.36u as=0.2114p ps=1.54u w=0.84u l=0.13u
M1116 SAR/sg13cmos5l_buf_8_2.X SAR/a_19227_9190# vss vss sg13_lv_nmos ad=0.1406p pd=1.12u as=0.1406p ps=1.12u w=0.74u l=0.13u
M1117 vss SAR/a_12976_2630# SAR/a_12625_2749# vss sg13_lv_nmos ad=79.8f pd=0.8u as=0.1428p ps=1.52u w=0.42u l=0.13u
M1118 SAR/a_10473_9186# SAR/a_10292_9508# vdd vdd sg13_lv_pmos ad=0.2128p pd=1.5u as=0.2387p ps=1.84u w=1.12u l=0.13u
M1119 SAR/sg13cmos5l_dlhr_1_1.D SAR/a_1967_5773# vdd vdd sg13_lv_pmos ad=0.4312p pd=3.01u as=0.2639p ps=1.81u w=1.12u l=0.13u
M1120 vdd SAR/sg13cmos5l_dfrbp_1_8.RESET_B SAR/a_14342_8874# vdd sg13_lv_pmos ad=0.36237p pd=2.605u as=79.8f ps=0.8u w=0.42u l=0.13u
M1121 SAR/a_18961_5814# SAR/a_18409_5770# vss vss sg13_lv_nmos ad=71.99999f pd=0.865u as=1.97045p ps=12.335u w=0.64u l=0.13u
M1122 vdd SAR/sg13cmos5l_dfrbp_1_6.RESET_B SAR/a_7498_7897# vdd sg13_lv_pmos ad=0.1563p pd=1.22u as=0.147p ps=1.54u w=0.42u l=0.13u
M1123 SAR/a_7820_9150# SAR/sg13cmos5l_buf_1_73.A vdd vdd sg13_lv_pmos ad=0.2856p pd=2.36u as=0.2114p ps=1.54u w=0.84u l=0.13u
M1124 SAR/a_3308_9150# SAR/sg13cmos5l_buf_1_65.X vss vss sg13_lv_nmos ad=0.187p pd=1.78u as=0.14875p ps=1.16u w=0.55u l=0.13u
M1125 vdd SAR/a_18860_6888# ph_sw[9] vdd sg13_lv_pmos ad=0.2114p pd=1.54u as=0.42p ps=2.99u w=1.12u l=0.13u
M1126 vss SAR/a_18928_1846# SAR/a_18577_1703# vss sg13_lv_nmos ad=79.8f pd=0.8u as=0.1428p ps=1.52u w=0.42u l=0.13u
M1127 SAR/a_12120_3456# SAR/sg13cmos5l_o21ai_1_0.A1 vdd vdd sg13_lv_pmos ad=0.2128p pd=1.5u as=0.3808p ps=2.92u w=1.12u l=0.15u
M1128 nl_sw[3] SAR/a_4456_1664# vdd vdd sg13_lv_pmos ad=0.42p pd=2.99u as=0.2114p ps=1.54u w=1.12u l=0.13u
M1129 vdd SAR/a_12815_4261# SAR/a_13652_3900# vdd sg13_lv_pmos ad=0.2128p pd=1.5u as=0.3864p ps=2.93u w=1.12u l=0.13u
M1130 SAR/a_6276_8861# SAR/a_5988_8440# SAR/a_6214_8861# vss sg13_lv_nmos ad=0.1428p pd=1.52u as=37.8f ps=0.6u w=0.42u l=0.13u
M1131 vss SAR/sg13cmos5l_inv_1_18.A SAR/sg13cmos5l_buf_1_28.A vss sg13_lv_nmos ad=0.2516p pd=2.16u as=0.2516p ps=2.16u w=0.74u l=0.13u
M1132 vdd SAR/sg13cmos5l_dfrbp_1_6.RESET_B SAR/a_8841_5769# vdd sg13_lv_pmos ad=0.2128p pd=1.5u as=0.2128p ps=1.5u w=1.12u l=0.13u
M1133 vss SAR/a_14889_7281# SAR/a_15414_7354# vss sg13_lv_nmos ad=0.1491p pd=1.18u as=0.187p ps=1.78u w=0.55u l=0.13u
M1134 vdd SAR/sg13cmos5l_dfrbp_1_0.RESET_B SAR/a_15206_2826# vdd sg13_lv_pmos ad=0.36237p pd=2.605u as=79.8f ps=0.8u w=0.42u l=0.13u
M1135 vss SAR/a_13648_9406# SAR/a_13297_9263# vss sg13_lv_nmos ad=79.8f pd=0.8u as=0.1428p ps=1.52u w=0.42u l=0.13u
M1136 SAR/a_10620_7326# SAR/a_10071_7282# SAR/a_10484_6924# vss sg13_lv_nmos ad=47.25f pd=0.645u as=0.141p ps=1.17u w=0.42u l=0.13u
M1137 SAR/a_8588_3864# SAR/sg13cmos5l_buf_1_46.A vdd vdd sg13_lv_pmos ad=0.2856p pd=2.36u as=0.2114p ps=1.54u w=0.84u l=0.13u
M1138 vss SAR/a_11973_1605# SAR/a_12075_1748# vss sg13_lv_nmos ad=7.01497p pd=46.005u as=0.2516p ps=2.16u w=0.74u l=0.13u
M1139 vss SAR/sg13cmos5l_dfrbp_1_6.RESET_B SAR/a_4276_2776# vss sg13_lv_nmos ad=0.1406p pd=1.12u as=77.7f ps=0.95u w=0.74u l=0.13u
M1140 SAR/sg13cmos5l_dlhr_1_3.Q_N SAR/a_4566_2818# vdd vdd sg13_lv_pmos ad=0.3808p pd=2.92u as=0.1974p ps=1.5u w=1.12u l=0.13u
M1141 vss SAR/sg13cmos5l_buf_1_31.X SAR/a_9448_6924# vss sg13_lv_nmos ad=0.14875p pd=1.16u as=0.187p ps=1.78u w=0.55u l=0.13u
M1142 SAR/a_2224_7166# SAR/sg13cmos5l_dfrbp_1_6.RESET_B vdd vdd sg13_lv_pmos ad=79.8f pd=0.8u as=1.04815p ps=6.595u w=0.42u l=0.13u
M1143 vdd SAR/a_8841_5769# SAR/a_8774_5412# vdd sg13_lv_pmos ad=0.2387p pd=1.84u as=0.1008p ps=0.9u w=0.42u l=0.13u
M1144 SAR/a_9189_8447# SAR/sg13cmos5l_inv_1_2.A vdd vdd sg13_lv_pmos ad=0.4088p pd=2.97u as=1.12242p ps=7u w=1.12u l=0.13u
M1145 SAR/a_13520_4696# SAR/sg13cmos5l_inv_1_0.A SAR/a_13418_4696# vss sg13_lv_nmos ad=0.1216p pd=1.02u as=0.1216p ps=1.02u w=0.64u l=0.13u
M1146 SAR/a_4005_4629# SAR/sg13cmos5l_inv_1_8.A vss vss sg13_lv_nmos ad=0.2516p pd=2.16u as=2.27517p ps=14.72u w=0.74u l=0.13u
M1147 SAR/sg13cmos5l_dfrbp_1_6.RESET_B _cks vss vss sg13_lv_nmos ad=0.1443p pd=1.13u as=0.1406p ps=1.12u w=0.74u l=0.13u
M1148 vss SAR/sg13cmos5l_buf_1_64.A SAR/a_3976_9224# vss sg13_lv_nmos ad=0.14875p pd=1.16u as=0.187p ps=1.78u w=0.55u l=0.13u
M1149 vss SAR/sg13cmos5l_dfrbp_1_8.RESET_B SAR/a_1956_4338# vss sg13_lv_nmos ad=0.1626p pd=1.415u as=60.89999f ps=0.71u w=0.42u l=0.13u
M1150 SAR/a_19227_9190# _cks vss vss sg13_lv_nmos ad=0.1406p pd=1.12u as=0.1406p ps=1.12u w=0.74u l=0.13u
M1151 SAR/a_13258_3361# SAR/a_13701_3117# SAR/a_12998_3138# vss sg13_lv_nmos ad=79.8f pd=0.8u as=0.1296p ps=1.52u w=0.42u l=0.13u
M1152 vss SAR/a_8588_2352# nl_sw[4] vss sg13_lv_nmos ad=0.14875p pd=1.16u as=0.2886p ps=2.26u w=0.74u l=0.13u
M1153 vss SAR/a_13701_3117# SAR/a_13803_3260# vss sg13_lv_nmos ad=2.59257p pd=16.445u as=0.2516p ps=2.16u w=0.74u l=0.13u
M1154 SAR/a_8998_8861# SAR/sg13cmos5l_dfrbp_1_8.RESET_B vss vss sg13_lv_nmos ad=37.8f pd=0.6u as=0.1701p ps=1.65u w=0.42u l=0.13u
M1155 vdd SAR/sg13cmos5l_dlygate4sd3_1_0.X SAR/sg13cmos5l_buf_1_43.A vdd sg13_lv_pmos ad=0.3808p pd=2.92u as=0.3808p ps=2.92u w=1.12u l=0.13u
M1156 vdd SAR/a_19227_9190# SAR/sg13cmos5l_buf_8_2.X vdd sg13_lv_pmos ad=0.2128p pd=1.5u as=0.2128p ps=1.5u w=1.12u l=0.13u
M1157 SAR/a_16953_2511# SAR/a_16011_2399# SAR/a_16751_2749# vdd sg13_lv_pmos ad=93.45f pd=0.865u as=0.2048p ps=1.63u w=0.42u l=0.13u
M1158 vss SAR/a_5069_5376# SAR/sg13cmos5l_dfrbp_1_29.Q_N vss sg13_lv_nmos ad=0.2516p pd=2.16u as=0.2849p ps=2.25u w=0.74u l=0.13u
M1159 vss _cks SAR/sg13cmos5l_dfrbp_1_6.RESET_B vss sg13_lv_nmos ad=0.1406p pd=1.12u as=0.1406p ps=1.12u w=0.74u l=0.13u
M1160 vdd SAR/a_16677_6141# SAR/a_16779_6284# vdd sg13_lv_pmos ad=1.07253p pd=6.75u as=0.3864p ps=2.93u w=1.12u l=0.13u
M1161 SAR/a_1967_7285# SAR/a_1125_6935# SAR/a_708_6928# vdd sg13_lv_pmos ad=0.2048p pd=1.63u as=0.34p ps=2.68u w=1u l=0.13u
M1162 SAR/sg13cmos5l_dfrbp_1_9.Q SAR/a_4244_3900# vdd vdd sg13_lv_pmos ad=0.3808p pd=2.92u as=0.2128p ps=1.5u w=1.12u l=0.13u
M1163 SAR/a_14820_7674# SAR/sg13cmos5l_buf_1_57.X SAR/a_14726_7674# vss sg13_lv_nmos ad=60.89999f pd=0.71u as=0.1428p ps=1.52u w=0.42u l=0.13u
M1164 SAR/a_6736_2630# SAR/a_6479_2749# SAR/a_6898_2826# vss sg13_lv_nmos ad=0.1428p pd=1.52u as=37.8f ps=0.6u w=0.42u l=0.13u
M1165 SAR/a_5799_5499# SAR/a_5951_5383# vdd vdd sg13_lv_pmos ad=0.3864p pd=2.93u as=1.28962p ps=8.195u w=1.12u l=0.13u
M1166 SAR/sg13cmos5l_inv_1_20.Y SAR/sg13cmos5l_buf_1_41.A vss vss sg13_lv_nmos ad=0.2516p pd=2.16u as=0.2516p ps=2.16u w=0.74u l=0.13u
M1167 vdd vss vdd vdd sg13_lv_pmos ad=0.19p pd=1.38u as=0 ps=0 w=1u l=1u
M1168 nh_sw[3] SAR/a_5704_1664# vss vss sg13_lv_nmos ad=0.2886p pd=2.26u as=0.14875p ps=1.16u w=0.74u l=0.13u
M1169 SAR/sg13cmos5l_dlhr_1_18.Q_N SAR/a_11190_7354# vdd vdd sg13_lv_pmos ad=0.3808p pd=2.92u as=0.1974p ps=1.5u w=1.12u l=0.13u
M1170 vss SAR/a_15045_8447# SAR/a_15147_8447# vss sg13_lv_nmos ad=2.92392p pd=18.89u as=0.2516p ps=2.16u w=0.74u l=0.13u
M1171 SAR/a_17367_8794# SAR/sg13cmos5l_dfrbp_1_22.D vss vss sg13_lv_nmos ad=0.2516p pd=2.16u as=0.15055p ps=1.17u w=0.74u l=0.13u
M1172 SAR/sg13cmos5l_nand2_1_0.B SAR/sg13cmos5l_a221oi_1_0.C1 vdd vdd sg13_lv_pmos ad=0.2128p pd=1.5u as=0.2198p ps=1.53u w=1.12u l=0.13u
M1173 SAR/sg13cmos5l_dlhr_1_11.GATE SAR/a_10868_8436# vdd vdd sg13_lv_pmos ad=0.3808p pd=2.92u as=0.2128p ps=1.5u w=1.12u l=0.13u
M1174 vdd SAR/a_11973_1605# SAR/a_12075_1748# vdd sg13_lv_pmos ad=1.86162p pd=11.935u as=0.3864p ps=2.93u w=1.12u l=0.13u
M1175 SAR/sg13cmos5l_dfrbp_1_22.Q_N SAR/a_17327_7285# vss vss sg13_lv_nmos ad=0.2849p pd=2.25u as=0.2516p ps=2.16u w=0.74u l=0.13u
M1176 vdd SAR/a_1463_8741# SAR/a_1463_8511# vdd sg13_lv_pmos ad=1.15047p pd=7.175u as=0.2442p ps=2.06u w=0.66u l=0.13u
M1177 SAR/a_2831_7630# SAR/sg13cmos5l_dfrbp_1_16.Q_N vss vss sg13_lv_nmos ad=0.187p pd=1.78u as=0.15055p ps=1.17u w=0.55u l=0.13u
M1178 SAR/a_12980_6924# SAR/a_12698_7288# SAR/a_12913_7326# vss sg13_lv_nmos ad=0.141p pd=1.17u as=71.99999f ps=0.865u w=0.64u l=0.13u
M1179 SAR/a_18122_2388# SAR/sg13cmos5l_nor2_1_1.A vdd vdd sg13_lv_pmos ad=0.1176p pd=1.33u as=0.4032p ps=2.96u w=1.12u l=0.13u
M1180 SAR/a_2628_3151# SAR/a_2340_3456# SAR/a_2566_3151# vss sg13_lv_nmos ad=0.1428p pd=1.52u as=37.8f ps=0.6u w=0.42u l=0.13u
M1181 SAR/a_4322_6162# SAR/sg13cmos5l_dfrbp_1_8.RESET_B vss vss sg13_lv_nmos ad=60.89999f pd=0.71u as=0.1626p ps=1.415u w=0.42u l=0.13u
M1182 SAR/sg13cmos5l_buf_1_105.A SAR/a_17961_8793# vss vss sg13_lv_nmos ad=0.2516p pd=2.16u as=0.1406p ps=1.12u w=0.74u l=0.13u
M1183 SAR/a_17327_7285# SAR/a_16485_6935# SAR/a_16068_6928# vdd sg13_lv_pmos ad=0.2048p pd=1.63u as=0.34p ps=2.68u w=1u l=0.13u
M1184 SAR/a_3826_8874# SAR/sg13cmos5l_dfrbp_1_8.RESET_B vss vss sg13_lv_nmos ad=37.8f pd=0.6u as=79.8f ps=0.8u w=0.42u l=0.13u
M1185 SAR/a_19340_8400# SAR/sg13cmos5l_buf_1_107.X vdd vdd sg13_lv_pmos ad=0.2856p pd=2.36u as=0.2114p ps=1.54u w=0.84u l=0.13u
M1186 vdd SAR/a_4076_7624# SAR/a_3676_7964# vdd sg13_lv_pmos ad=0.2387p pd=1.84u as=0.2128p ps=1.5u w=1.12u l=0.13u
M1187 _frm SAR/a_20008_7712# vdd vdd sg13_lv_pmos ad=0.42p pd=2.99u as=0.2114p ps=1.54u w=1.12u l=0.13u
M1188 SAR/sg13cmos5l_inv_1_29.A SAR/a_12404_7972# vss vss sg13_lv_nmos ad=0.2516p pd=2.16u as=0.1406p ps=1.12u w=0.74u l=0.13u
M1189 vss SAR/sg13cmos5l_nand2_1_1.B SAR/a_10094_2780# vss sg13_lv_nmos ad=0.2516p pd=2.16u as=96.2f ps=1u w=0.74u l=0.13u
M1190 vss SAR/sg13cmos5l_a221oi_1_0.A2 SAR/a_8041_5770# vss sg13_lv_nmos ad=0.15055p pd=1.17u as=0.187p ps=1.78u w=0.55u l=0.13u
M1191 SAR/a_8486_8874# SAR/sg13cmos5l_dfrbp_1_18.Q vdd vdd sg13_lv_pmos ad=79.8f pd=0.8u as=0.1428p ps=1.52u w=0.42u l=0.13u
M1192 SAR/a_16462_4023# SAR/a_16204_4338# vdd vdd sg13_lv_pmos ad=93.45f pd=0.865u as=1.43437p ps=9.105u w=0.42u l=0.13u
M1193 SAR/a_6084_4325# SAR/a_6315_3911# SAR/a_5770_3868# vss sg13_lv_nmos ad=0.2373p pd=1.97u as=79.8f ps=0.8u w=0.42u l=0.13u
M1194 SAR/a_11973_3911# SAR/sg13cmos5l_dfrbp_1_0.CLK vss vss sg13_lv_nmos ad=0.2516p pd=2.16u as=2.41737p ps=15.64u w=0.74u l=0.13u
M1195 SAR/sg13cmos5l_buf_1_79.X SAR/a_9256_9224# vss vss sg13_lv_nmos ad=0.2886p pd=2.26u as=0.14875p ps=1.16u w=0.74u l=0.13u
M1196 vdd vss vdd vdd sg13_lv_pmos ad=0.19p pd=1.38u as=0 ps=0 w=1u l=1u
M1197 vdd SAR/a_13701_3117# SAR/a_13803_3260# vdd sg13_lv_pmos ad=1.43437p pd=9.105u as=0.3864p ps=2.93u w=1.12u l=0.13u
M1198 SAR/a_18928_1846# SAR/a_18671_1703# SAR/a_19090_1626# vss sg13_lv_nmos ad=0.1428p pd=1.52u as=37.8f ps=0.6u w=0.42u l=0.13u
M1199 SAR/a_16940_3102# SAR/sg13cmos5l_buf_1_4.X vss vss sg13_lv_nmos ad=0.187p pd=1.78u as=0.14875p ps=1.16u w=0.55u l=0.13u
M1200 SAR/a_9129_8483# SAR/a_8772_8440# vdd vdd sg13_lv_pmos ad=63f pd=0.72u as=0.1563p ps=1.22u w=0.42u l=0.13u
M1201 SAR/a_7881_8065# SAR/a_7524_7992# vdd vdd sg13_lv_pmos ad=63f pd=0.72u as=0.1563p ps=1.22u w=0.42u l=0.13u
M1202 vdd _cks SAR/a_19227_9190# vdd sg13_lv_pmos ad=0.2128p pd=1.5u as=0.2128p ps=1.5u w=1.12u l=0.13u
M1203 SAR/a_17638_1639# SAR/sg13cmos5l_dfrbp_1_0.RESET_B vss vss sg13_lv_nmos ad=37.8f pd=0.6u as=0.1701p ps=1.65u w=0.42u l=0.13u
M1204 SAR/a_14996_5412# SAR/a_14583_5770# SAR/a_14928_5412# vdd sg13_lv_pmos ad=0.191p pd=1.44u as=0.105p ps=1.21u w=1u l=0.13u
M1205 vss SAR/sg13cmos5l_dfrbp_1_8.RESET_B SAR/a_5546_5850# vss sg13_lv_nmos ad=79.8f pd=0.8u as=37.8f ps=0.6u w=0.42u l=0.13u
M1206 vss SAR/a_2732_1590# SAR/sg13cmos5l_buf_1_35.A vss sg13_lv_nmos ad=0.14875p pd=1.16u as=0.2886p ps=2.26u w=0.74u l=0.13u
M1207 SAR/a_17595_3947# SAR/a_16703_3871# SAR/a_17493_3947# vdd sg13_lv_pmos ad=63f pd=0.72u as=79.8f ps=0.8u w=0.42u l=0.13u
M1208 SAR/sg13cmos5l_dlhr_1_9.D SAR/a_2804_5412# vdd vdd sg13_lv_pmos ad=0.3808p pd=2.92u as=0.2128p ps=1.5u w=1.12u l=0.13u
M1209 vdd SAR/a_4460_9150# SAR/sg13cmos5l_buf_1_60.X vdd sg13_lv_pmos ad=0.2114p pd=1.54u as=0.42p ps=2.99u w=1.12u l=0.13u
M1210 SAR/sg13cmos5l_dfrbp_1_17.Q_N SAR/a_3407_8797# vss vss sg13_lv_nmos ad=0.2849p pd=2.25u as=0.2516p ps=2.16u w=0.74u l=0.13u
M1211 SAR/a_16268_1590# SAR/sg13cmos5l_buf_1_1.A vdd vdd sg13_lv_pmos ad=0.2856p pd=2.36u as=0.2114p ps=1.54u w=0.84u l=0.13u
M1212 vss SAR/a_16271_7751# SAR/a_17108_7972# vss sg13_lv_nmos ad=0.1406p pd=1.12u as=0.2516p ps=2.16u w=0.74u l=0.13u
M1213 SAR/a_4041_2745# SAR/a_3860_2388# vdd vdd sg13_lv_pmos ad=0.2128p pd=1.5u as=0.2387p ps=1.84u w=1.12u l=0.13u
M1214 SAR/a_12358_9199# SAR/sg13cmos5l_dfrbp_1_8.RESET_B vss vss sg13_lv_nmos ad=37.8f pd=0.6u as=0.1701p ps=1.65u w=0.42u l=0.13u
M1215 SAR/a_13876_7660# SAR/a_13460_7996# SAR/a_13641_7674# vss sg13_lv_nmos ad=77.7f pd=0.95u as=0.2516p ps=2.16u w=0.74u l=0.13u
M1216 vdd SAR/a_18363_4270# SAR/sg13cmos5l_or2_1_0.A vdd sg13_lv_pmos ad=0.3864p pd=2.93u as=0.2128p ps=1.5u w=1.12u l=0.13u
M1217 SAR/sg13cmos5l_buf_1_93.X SAR/a_14632_9224# vss vss sg13_lv_nmos ad=0.2886p pd=2.26u as=0.14875p ps=1.16u w=0.74u l=0.13u
M1218 SAR/a_16751_2749# SAR/a_15909_2399# SAR/a_15492_2392# vdd sg13_lv_pmos ad=0.2048p pd=1.63u as=0.34p ps=2.68u w=1u l=0.13u
M1219 SAR/a_17008_2630# SAR/sg13cmos5l_dfrbp_1_0.RESET_B vdd vdd sg13_lv_pmos ad=79.8f pd=0.8u as=1.777p ps=11.395u w=0.42u l=0.13u
M1220 nl_sw[2] SAR/a_2248_1664# vss vss sg13_lv_nmos ad=0.2886p pd=2.26u as=0.14875p ps=1.16u w=0.74u l=0.13u
M1221 SAR/a_14458_4270# SAR/sg13cmos5l_nand2_1_1.B vss vss sg13_lv_nmos ad=0.1406p pd=1.12u as=0.2516p ps=2.16u w=0.74u l=0.13u
M1222 SAR/a_11567_7751# SAR/a_10725_7653# SAR/a_10308_7992# vdd sg13_lv_pmos ad=0.2048p pd=1.63u as=0.34p ps=2.68u w=1u l=0.13u
M1223 vdd SAR/a_6117_6141# SAR/a_6219_6284# vdd sg13_lv_pmos ad=1.07253p pd=6.75u as=0.3864p ps=2.93u w=1.12u l=0.13u
M1224 vdd SAR/sg13cmos5l_buf_1_62.X SAR/a_1864_9224# vdd sg13_lv_pmos ad=0.2114p pd=1.54u as=0.2856p ps=2.36u w=0.84u l=0.13u
M1225 SAR/a_12921_2511# SAR/a_11979_2399# SAR/a_12719_2749# vdd sg13_lv_pmos ad=93.45f pd=0.865u as=0.2048p ps=1.63u w=0.42u l=0.13u
M1226 ph_sw[2] SAR/a_3976_9224# vdd vdd sg13_lv_pmos ad=0.42p pd=2.99u as=0.2114p ps=1.54u w=1.12u l=0.13u
M1227 vdd SAR/a_3664_8678# SAR/a_3609_8559# vdd sg13_lv_pmos ad=1.15047p pd=7.175u as=93.45f ps=0.865u w=0.42u l=0.13u
M1228 SAR/sg13cmos5l_buf_1_105.A SAR/a_17961_8793# vdd vdd sg13_lv_pmos ad=0.3808p pd=2.92u as=0.2128p ps=1.5u w=1.12u l=0.13u
M1229 vss SAR/a_4076_5376# SAR/sg13cmos5l_inv_1_17.A vss sg13_lv_nmos ad=0.14875p pd=1.16u as=0.2886p ps=2.26u w=0.74u l=0.13u
M1230 SAR/sg13cmos5l_or2_1_0.A SAR/a_18363_4270# vdd vdd sg13_lv_pmos ad=0.2128p pd=1.5u as=0.2128p ps=1.5u w=1.12u l=0.13u
M1231 SAR/a_5796_3904# SAR/a_5770_3868# vdd vdd sg13_lv_pmos ad=0.34p pd=2.68u as=0.36237p ps=2.605u w=1u l=0.13u
M1232 vss SAR/sg13cmos5l_dfrbp_1_8.RESET_B SAR/a_6998_5837# vss sg13_lv_nmos ad=0.1701p pd=1.65u as=37.8f ps=0.6u w=0.42u l=0.13u
M1233 SAR/sg13cmos5l_buf_1_104.X SAR/a_19624_8436# vdd vdd sg13_lv_pmos ad=0.42p pd=2.99u as=0.2114p ps=1.54u w=1.12u l=0.13u
M1234 SAR/sg13cmos5l_dfrbp_1_7.Q_N SAR/a_14543_3215# vdd vdd sg13_lv_pmos ad=0.4312p pd=3.01u as=0.2639p ps=1.81u w=1.12u l=0.13u
M1235 vss SAR/a_18345_7674# SAR/a_18300_7710# vss sg13_lv_nmos ad=0.1428p pd=1.52u as=47.25f ps=0.645u w=0.42u l=0.13u
M1236 vdd vss vdd vdd sg13_lv_pmos ad=0.19p pd=1.38u as=0 ps=0 w=1u l=1u
M1237 vdd SAR/a_6479_2749# SAR/a_7316_2388# vdd sg13_lv_pmos ad=0.2128p pd=1.5u as=0.3864p ps=2.93u w=1.12u l=0.13u
M1238 SAR/a_11940_9186# SAR/sg13cmos5l_dlhr_1_11.GATE SAR/a_11846_9186# vss sg13_lv_nmos ad=60.89999f pd=0.71u as=0.1428p ps=1.52u w=0.42u l=0.13u
M1239 SAR/a_2228_4972# SAR/a_1946_4660# SAR/a_2161_4642# vss sg13_lv_nmos ad=0.141p pd=1.17u as=71.99999f ps=0.865u w=0.64u l=0.13u
M1240 vdd SAR/sg13cmos5l_buf_1_2.A SAR/a_15784_1664# vdd sg13_lv_pmos ad=0.2114p pd=1.54u as=0.2856p ps=2.36u w=0.84u l=0.13u
M1241 SAR/a_10783_3876# SAR/sg13cmos5l_nand2_1_0.A vdd vdd sg13_lv_pmos ad=0.2716p pd=1.605u as=0.3808p ps=2.92u w=1.12u l=0.13u
M1242 SAR/a_524_4614# SAR/sg13cmos5l_buf_1_43.A vss vss sg13_lv_nmos ad=0.187p pd=1.78u as=0.14875p ps=1.16u w=0.55u l=0.13u
M1243 vdd SAR/sg13cmos5l_inv_1_5.A SAR/a_20392_3900# vdd sg13_lv_pmos ad=0.2114p pd=1.54u as=0.2856p ps=2.36u w=0.84u l=0.13u
M1244 SAR/a_14602_8404# SAR/a_15045_8447# SAR/a_14342_8874# vss sg13_lv_nmos ad=79.8f pd=0.8u as=0.1296p ps=1.52u w=0.42u l=0.13u
M1245 SAR/sg13cmos5l_dlhr_1_10.Q SAR/a_19593_6162# vss vss sg13_lv_nmos ad=0.2516p pd=2.16u as=0.1406p ps=1.12u w=0.74u l=0.13u
M1246 vss SAR/a_1967_5773# SAR/a_2804_5412# vss sg13_lv_nmos ad=0.1406p pd=1.12u as=0.2516p ps=2.16u w=0.74u l=0.13u
M1247 vss SAR/a_3664_4142# SAR/a_3313_4261# vss sg13_lv_nmos ad=79.8f pd=0.8u as=0.1428p ps=1.52u w=0.42u l=0.13u
M1248 vss SAR/sg13cmos5l_buf_1_40.A SAR/a_1192_1664# vss sg13_lv_nmos ad=0.14875p pd=1.16u as=0.187p ps=1.78u w=0.55u l=0.13u
M1249 vdd SAR/sg13cmos5l_dfrbp_1_6.RESET_B SAR/a_5770_3868# vdd sg13_lv_pmos ad=0.1563p pd=1.22u as=0.147p ps=1.54u w=0.42u l=0.13u
M1250 vss SAR/a_1125_6935# SAR/a_1227_6935# vss sg13_lv_nmos ad=1.49685p pd=9.6u as=0.2516p ps=2.16u w=0.74u l=0.13u
M1251 vdd SAR/a_1484_6126# SAR/sg13cmos5l_buf_1_40.A vdd sg13_lv_pmos ad=0.2114p pd=1.54u as=0.42p ps=2.99u w=1.12u l=0.13u
M1252 SAR/a_6660_4663# SAR/a_6372_4968# SAR/a_6598_4663# vss sg13_lv_nmos ad=0.1428p pd=1.52u as=37.8f ps=0.6u w=0.42u l=0.13u
M1253 SAR/a_16234_6385# SAR/a_16677_6141# SAR/a_15974_6162# vss sg13_lv_nmos ad=79.8f pd=0.8u as=0.1296p ps=1.52u w=0.42u l=0.13u
M1254 vdd SAR/a_13391_9263# SAR/a_13648_9406# vdd sg13_lv_pmos ad=0.2639p pd=1.81u as=79.8f ps=0.8u w=0.42u l=0.13u
M1255 SAR/sg13cmos5l_dlhr_1_0.Q_N SAR/a_8214_1608# vdd vdd sg13_lv_pmos ad=0.3808p pd=2.92u as=0.1974p ps=1.5u w=1.12u l=0.13u
M1256 SAR/a_10292_9508# SAR/a_10010_9196# SAR/a_10225_9178# vss sg13_lv_nmos ad=0.141p pd=1.17u as=71.99999f ps=0.865u w=0.64u l=0.13u
M1257 SAR/sg13cmos5l_dlhr_1_2.Q_N SAR/a_8022_3120# vss vss sg13_lv_nmos ad=0.2516p pd=2.16u as=0.1491p ps=1.18u w=0.74u l=0.13u
M1258 SAR/a_10416_6924# SAR/a_9865_7282# vdd vdd sg13_lv_pmos ad=0.105p pd=1.21u as=1.07253p ps=6.75u w=1u l=0.13u
M1259 SAR/a_14032_6382# SAR/sg13cmos5l_dfrbp_1_6.RESET_B vdd vdd sg13_lv_pmos ad=79.8f pd=0.8u as=1.04815p ps=6.595u w=0.42u l=0.13u
M1260 vss SAR/sg13cmos5l_dfrbp_1_8.RESET_B SAR/a_3926_6175# vss sg13_lv_nmos ad=0.1701p pd=1.65u as=37.8f ps=0.6u w=0.42u l=0.13u
M1261 vdd SAR/a_3856_3358# SAR/a_3801_3453# vdd sg13_lv_pmos ad=1.43437p pd=9.105u as=93.45f ps=0.865u w=0.42u l=0.13u
M1262 vss SAR/a_8457_7281# SAR/a_8412_7326# vss sg13_lv_nmos ad=0.1428p pd=1.52u as=47.25f ps=0.645u w=0.42u l=0.13u
M1263 SAR/a_422_7362# SAR/a_1227_6935# SAR/a_682_6892# vdd sg13_lv_pmos ad=0.1428p pd=1.52u as=79.8f ps=0.8u w=0.42u l=0.13u
M1264 vdd SAR/sg13cmos5l_dfrbp_1_6.RESET_B SAR/a_7238_7674# vdd sg13_lv_pmos ad=0.36237p pd=2.605u as=79.8f ps=0.8u w=0.42u l=0.13u
M1265 SAR/a_18164_7996# SAR/a_17751_7690# SAR/a_18096_7996# vdd sg13_lv_pmos ad=0.191p pd=1.44u as=0.105p ps=1.21u w=1u l=0.13u
M1266 vdd SAR/sg13cmos5l_buf_1_29.A SAR/sg13cmos5l_buf_1_77.A vdd sg13_lv_pmos ad=0.3808p pd=2.92u as=0.3808p ps=2.92u w=1.12u l=0.13u
M1267 vdd vss vdd vdd sg13_lv_pmos ad=0.34p pd=2.68u as=0 ps=0 w=1u l=1u
M1268 SAR/a_5452_5850# SAR/a_5069_5376# vdd vdd sg13_lv_pmos ad=79.8f pd=0.8u as=0.2639p ps=1.81u w=0.42u l=0.13u
M1269 SAR/a_4460_9150# SAR/sg13cmos5l_buf_1_60.A vdd vdd sg13_lv_pmos ad=0.2856p pd=2.36u as=0.2114p ps=1.54u w=0.84u l=0.13u
M1270 SAR/sg13cmos5l_inv_1_20.Y SAR/sg13cmos5l_buf_1_41.A vdd vdd sg13_lv_pmos ad=0.3808p pd=2.92u as=0.3808p ps=2.92u w=1.12u l=0.13u
M1271 vdd SAR/sg13cmos5l_dfrbp_1_20.Q_N SAR/a_9673_9240# vdd sg13_lv_pmos ad=4.11675p pd=27.17u as=0.2856p ps=2.36u w=0.84u l=0.13u
M1272 SAR/a_11877_2399# SAR/sg13cmos5l_dfrbp_1_0.CLK vdd vdd sg13_lv_pmos ad=0.4088p pd=2.97u as=1.777p ps=11.395u w=1.12u l=0.13u
M1273 vss SAR/sg13cmos5l_dfrbp_1_0.RESET_B SAR/a_11364_1626# vss sg13_lv_nmos ad=0.1626p pd=1.415u as=60.89999f ps=0.71u w=0.42u l=0.13u
M1274 vdd SAR/sg13cmos5l_dfrbp_1_6.RESET_B SAR/a_13641_7674# vdd sg13_lv_pmos ad=0.2128p pd=1.5u as=0.2128p ps=1.5u w=1.12u l=0.13u
M1275 vss SAR/a_14924_1590# nh_sw[6] vss sg13_lv_nmos ad=0.14875p pd=1.16u as=0.2886p ps=2.26u w=0.74u l=0.13u
M1276 SAR/a_2340_3456# SAR/a_2859_3260# SAR/a_3599_3215# vss sg13_lv_nmos ad=0.3473p pd=2.71u as=0.12665p ps=1.145u w=0.74u l=0.13u
M1277 vdd SAR/sg13cmos5l_dlhr_1_9.D SAR/a_10587_4692# vdd sg13_lv_pmos ad=0.2198p pd=1.53u as=0.2856p ps=2.36u w=0.84u l=0.13u
M1278 vdd vss vdd vdd sg13_lv_pmos ad=0.19p pd=1.38u as=0 ps=0 w=1u l=1u
M1279 vss SAR/sg13cmos5l_nor2_1_1.A SAR/sg13cmos5l_nor2b_1_1.Y vss sg13_lv_nmos ad=0.2516p pd=2.16u as=0.1406p ps=1.12u w=0.74u l=0.13u
M1280 vdd SAR/a_12719_2749# SAR/a_12976_2630# vdd sg13_lv_pmos ad=0.2639p pd=1.81u as=79.8f ps=0.8u w=0.42u l=0.13u
M1281 SAR/sg13cmos5l_dfrbp_1_18.Q_N SAR/a_7247_8797# vdd vdd sg13_lv_pmos ad=0.4312p pd=3.01u as=0.2639p ps=1.81u w=1.12u l=0.13u
M1282 vss SAR/sg13cmos5l_or2_1_1.B SAR/a_10726_5760# vss sg13_lv_nmos ad=0.2516p pd=2.16u as=0.1406p ps=1.12u w=0.74u l=0.13u
M1283 SAR/sg13cmos5l_dfrbp_1_14.Q_N SAR/a_4847_4727# vss vss sg13_lv_nmos ad=0.2849p pd=2.25u as=0.2516p ps=2.16u w=0.74u l=0.13u
M1284 SAR/a_12716_8400# SAR/sg13cmos5l_buf_1_79.X vdd vdd sg13_lv_pmos ad=0.2856p pd=2.36u as=0.2114p ps=1.54u w=0.84u l=0.13u
M1285 SAR/a_17751_7690# SAR/sg13cmos5l_dfrbp_1_22.D vdd vdd sg13_lv_pmos ad=0.3234p pd=2.45u as=1.12242p ps=7u w=0.84u l=0.13u
M1286 SAR/sg13cmos5l_nor2b_1_1.Y SAR/sg13cmos5l_nor2_1_1.A SAR/a_14476_2388# vdd sg13_lv_pmos ad=0.3808p pd=2.92u as=0.1176p ps=1.33u w=1.12u l=0.13u
M1287 vdd SAR/a_7055_4261# SAR/a_7892_3900# vdd sg13_lv_pmos ad=0.2128p pd=1.5u as=0.3864p ps=2.93u w=1.12u l=0.13u
M1288 vdd SAR/a_5132_9150# SAR/sg13cmos5l_buf_1_64.A vdd sg13_lv_pmos ad=0.2114p pd=1.54u as=0.42p ps=2.99u w=1.12u l=0.13u
M1289 SAR/sg13cmos5l_inv_1_7.A SAR/a_11464_8436# vdd vdd sg13_lv_pmos ad=0.42p pd=2.99u as=0.2114p ps=1.54u w=1.12u l=0.13u
M1290 SAR/a_6789_4629# SAR/sg13cmos5l_inv_1_8.A vss vss sg13_lv_nmos ad=0.2516p pd=2.16u as=2.27517p ps=14.72u w=0.74u l=0.13u
M1291 vss SAR/sg13cmos5l_dlhr_1_15.Q SAR/a_19240_7712# vss sg13_lv_nmos ad=0.14875p pd=1.16u as=0.187p ps=1.78u w=0.55u l=0.13u
M1292 SAR/sg13cmos5l_buf_1_5.X SAR/a_14440_1664# vss vss sg13_lv_nmos ad=0.2886p pd=2.26u as=0.14875p ps=1.16u w=0.74u l=0.13u
M1293 vss SAR/sg13cmos5l_dfrbp_1_0.RESET_B SAR/a_13092_3138# vss sg13_lv_nmos ad=0.1626p pd=1.415u as=60.89999f ps=0.71u w=0.42u l=0.13u
M1294 SAR/a_1196_8400# SAR/sg13cmos5l_buf_1_63.A vdd vdd sg13_lv_pmos ad=0.2856p pd=2.36u as=0.2114p ps=1.54u w=0.84u l=0.13u
M1295 vdd SAR/sg13cmos5l_dfrbp_1_6.RESET_B SAR/a_9033_6162# vdd sg13_lv_pmos ad=0.2128p pd=1.5u as=0.2128p ps=1.5u w=1.12u l=0.13u
M1296 SAR/a_12022_3134# SAR/sg13cmos5l_o21ai_1_0.A2 vss vss sg13_lv_nmos ad=0.1406p pd=1.12u as=0.1406p ps=1.12u w=0.74u l=0.15u
M1297 SAR/a_18345_7674# SAR/a_18164_7996# vdd vdd sg13_lv_pmos ad=0.2128p pd=1.5u as=0.2387p ps=1.84u w=1.12u l=0.13u
M1298 vdd SAR/a_8247_5770# SAR/a_8378_5776# vdd sg13_lv_pmos ad=1.28962p pd=8.195u as=0.2856p ps=2.36u w=0.84u l=0.13u
M1299 vdd SAR/a_19628_2352# nh_sw[9] vdd sg13_lv_pmos ad=0.2114p pd=1.54u as=0.42p ps=2.99u w=1.12u l=0.13u
M1300 vdd SAR/a_19216_3358# SAR/a_19161_3453# vdd sg13_lv_pmos ad=1.43437p pd=9.105u as=93.45f ps=0.865u w=0.42u l=0.13u
M1301 SAR/sg13cmos5l_dfrbp_1_6.D SAR/a_1672_3176# vdd vdd sg13_lv_pmos ad=0.42p pd=2.99u as=0.2114p ps=1.54u w=1.12u l=0.13u
M1302 vdd SAR/sg13cmos5l_buf_1_24.A SAR/sg13cmos5l_buf_1_78.A vdd sg13_lv_pmos ad=0.3808p pd=2.92u as=0.3808p ps=2.92u w=1.12u l=0.13u
M1303 vdd SAR/sg13cmos5l_buf_1_18.A SAR/a_18376_2388# vdd sg13_lv_pmos ad=0.2114p pd=1.54u as=0.2856p ps=2.36u w=0.84u l=0.13u
M1304 vss SAR/sg13cmos5l_dfrbp_1_10.Q_N SAR/a_3241_2746# vss sg13_lv_nmos ad=0.15055p pd=1.17u as=0.187p ps=1.78u w=0.55u l=0.13u
M1305 vdd SAR/a_10031_8797# SAR/a_10288_8678# vdd sg13_lv_pmos ad=0.2639p pd=1.81u as=79.8f ps=0.8u w=0.42u l=0.13u
M1306 SAR/a_8660_5412# SAR/a_8378_5776# SAR/a_8593_5814# vss sg13_lv_nmos ad=0.141p pd=1.17u as=71.99999f ps=0.865u w=0.64u l=0.13u
M1307 SAR/a_5962_8404# SAR/a_6405_8447# SAR/a_6345_8483# vdd sg13_lv_pmos ad=79.8f pd=0.8u as=63f ps=0.72u w=0.42u l=0.13u
M1308 SAR/a_17700_3456# SAR/a_18219_3260# SAR/a_18959_3215# vss sg13_lv_nmos ad=0.3473p pd=2.71u as=0.12665p ps=1.145u w=0.74u l=0.13u
M1309 SAR/a_17776_6382# SAR/a_17519_6239# SAR/a_17938_6162# vss sg13_lv_nmos ad=0.1428p pd=1.52u as=37.8f ps=0.6u w=0.42u l=0.13u
M1310 vss SAR/sg13cmos5l_buf_1_41.X SAR/a_2824_2388# vss sg13_lv_nmos ad=0.14875p pd=1.16u as=0.187p ps=1.78u w=0.55u l=0.13u
M1311 SAR/a_10420_5760# SAR/sg13cmos5l_dfrbp_1_16.Q vss vss sg13_lv_nmos ad=0.1406p pd=1.12u as=0.1406p ps=1.12u w=0.74u l=0.13u
M1312 SAR/sg13cmos5l_dfrbp_1_1.Q SAR/a_13652_1924# vdd vdd sg13_lv_pmos ad=0.3808p pd=2.92u as=0.2128p ps=1.5u w=1.12u l=0.13u
M1313 vdd SAR/a_11372_3102# nh_sw[5] vdd sg13_lv_pmos ad=0.2114p pd=1.54u as=0.42p ps=2.99u w=1.12u l=0.13u
M1314 SAR/a_4358_6924# SAR/a_3962_7288# SAR/a_4244_6924# vdd sg13_lv_pmos ad=0.1008p pd=0.9u as=0.191p ps=1.44u w=0.42u l=0.13u
M1315 vss vdd vss vss sg13_lv_nmos ad=0.1428p pd=1.52u as=0 ps=0 w=0.42u l=1u
M1316 vss SAR/sg13cmos5l_dfrbp_1_12.Q_N SAR/a_8905_4704# vss sg13_lv_nmos ad=0.15055p pd=1.17u as=0.187p ps=1.78u w=0.55u l=0.13u
M1317 SAR/a_8439_6178# SAR/sg13cmos5l_dlhr_1_5.GATE vss vss sg13_lv_nmos ad=0.2516p pd=2.16u as=0.15055p ps=1.17u w=0.74u l=0.13u
M1318 SAR/a_682_6892# SAR/a_1125_6935# SAR/a_422_7362# vss sg13_lv_nmos ad=79.8f pd=0.8u as=0.1296p ps=1.52u w=0.42u l=0.13u
M1319 vss SAR/a_8841_5769# SAR/a_8796_5814# vss sg13_lv_nmos ad=0.1428p pd=1.52u as=47.25f ps=0.645u w=0.42u l=0.13u
M1320 SAR/a_1956_8874# SAR/sg13cmos5l_dfrbp_1_17.D SAR/a_1862_8874# vss sg13_lv_nmos ad=60.89999f pd=0.71u as=0.1428p ps=1.52u w=0.42u l=0.13u
M1321 SAR/a_5324_1590# SAR/sg13cmos5l_buf_1_34.X vss vss sg13_lv_nmos ad=0.187p pd=1.78u as=0.14875p ps=1.16u w=0.55u l=0.13u
M1322 vdd SAR/a_7497_3138# SAR/a_7430_3576# vdd sg13_lv_pmos ad=0.2387p pd=1.84u as=0.1008p ps=0.9u w=0.42u l=0.13u
M1323 vdd SAR/sg13cmos5l_dfrbp_1_10.Q SAR/a_10331_3900# vdd sg13_lv_pmos ad=0.2128p pd=1.5u as=0.2128p ps=1.5u w=1.12u l=0.13u
M1324 vss vdd vss vss sg13_lv_nmos ad=79.8f pd=0.8u as=0 ps=0 w=0.42u l=1u
M1325 vdd SAR/sg13cmos5l_inv_1_0.A SAR/sg13cmos5l_inv_1_0.Y vdd sg13_lv_pmos ad=0.3808p pd=2.92u as=0.3808p ps=2.92u w=1.12u l=0.13u
M1326 SAR/sg13cmos5l_nand2_1_1.A SAR/a_15380_3436# vdd vdd sg13_lv_pmos ad=0.3808p pd=2.92u as=0.2128p ps=1.5u w=1.12u l=0.13u
M1327 vdd SAR/sg13cmos5l_dfrbp_1_6.RESET_B SAR/a_14726_7674# vdd sg13_lv_pmos ad=0.36237p pd=2.605u as=79.8f ps=0.8u w=0.42u l=0.13u
M1328 SAR/sg13cmos5l_a22oi_1_0.B1 SAR/sg13cmos5l_nand2_1_0.A vdd vdd sg13_lv_pmos ad=0.2128p pd=1.5u as=0.3808p ps=2.92u w=1.12u l=0.13u
M1329 SAR/sg13cmos5l_dlhr_1_16.Q_N SAR/a_19734_5842# vdd vdd sg13_lv_pmos ad=0.3808p pd=2.92u as=0.1974p ps=1.5u w=1.12u l=0.13u
M1330 SAR/sg13cmos5l_dlhr_1_10.Q_N SAR/a_20118_6144# vss vss sg13_lv_nmos ad=0.2516p pd=2.16u as=0.1491p ps=1.18u w=0.74u l=0.13u
M1331 SAR/a_2748_6126# SAR/a_2879_6432# SAR/a_1997_6126# vdd sg13_lv_pmos ad=0.34p pd=2.68u as=0.2048p ps=1.63u w=1u l=0.13u
M1332 SAR/sg13cmos5l_dfrbp_1_5.Q_N SAR/a_16751_2749# vdd vdd sg13_lv_pmos ad=0.4312p pd=3.01u as=0.2639p ps=1.81u w=1.12u l=0.13u
M1333 SAR/a_20012_1590# SAR/sg13cmos5l_buf_1_0.A vdd vdd sg13_lv_pmos ad=0.2856p pd=2.36u as=0.2114p ps=1.54u w=0.84u l=0.13u
M1334 SAR/a_14924_1590# SAR/sg13cmos5l_buf_1_6.A vdd vdd sg13_lv_pmos ad=0.2856p pd=2.36u as=0.2114p ps=1.54u w=0.84u l=0.13u
M1335 SAR/a_11556_3904# SAR/a_12075_3911# SAR/a_12815_4261# vss sg13_lv_nmos ad=0.3473p pd=2.71u as=0.12665p ps=1.145u w=0.74u l=0.13u
M1336 SAR/a_11072_5347# SAR/sg13cmos5l_dlhr_1_15.D vdd vdd sg13_lv_pmos ad=0.1596p pd=1.22u as=0.36195p ps=1.84u w=0.84u l=0.13u
M1337 vdd SAR/a_15702_4187# SAR/sg13cmos5l_and3_1_0.C vdd sg13_lv_pmos ad=0.2128p pd=1.5u as=0.3808p ps=2.92u w=1.12u l=0.13u
M1338 SAR/a_5132_9150# SAR/sg13cmos5l_buf_1_44.X vdd vdd sg13_lv_pmos ad=0.2856p pd=2.36u as=0.2114p ps=1.54u w=0.84u l=0.13u
M1339 SAR/a_14342_8874# SAR/a_15147_8447# SAR/a_14602_8404# vdd sg13_lv_pmos ad=0.1428p pd=1.52u as=79.8f ps=0.8u w=0.42u l=0.13u
M1340 SAR/a_4244_6924# SAR/a_3962_7288# SAR/a_4177_7326# vss sg13_lv_nmos ad=0.141p pd=1.17u as=71.99999f ps=0.865u w=0.64u l=0.13u
M1341 vdd SAR/a_18999_6178# SAR/a_19130_6172# vdd sg13_lv_pmos ad=1.07253p pd=6.75u as=0.2856p ps=2.36u w=0.84u l=0.13u
M1342 SAR/sg13cmos5l_dfrbp_1_8.RESET_B _cks vdd vdd sg13_lv_pmos ad=0.3808p pd=2.92u as=0.3808p ps=2.92u w=1.12u l=0.13u
M1343 vss SAR/a_3407_4261# SAR/a_4244_3900# vss sg13_lv_nmos ad=0.1406p pd=1.12u as=0.2516p ps=2.16u w=0.74u l=0.13u
M1344 SAR/a_2436_8861# SAR/a_2148_8440# SAR/a_2374_8861# vss sg13_lv_nmos ad=0.1428p pd=1.52u as=37.8f ps=0.6u w=0.42u l=0.13u
M1345 vdd SAR/sg13cmos5l_dfrbp_1_6.RESET_B SAR/a_14889_7281# vdd sg13_lv_pmos ad=0.2128p pd=1.5u as=0.2128p ps=1.5u w=1.12u l=0.13u
M1346 SAR/sg13cmos5l_buf_1_4.X SAR/a_16552_1664# vss vss sg13_lv_nmos ad=0.2886p pd=2.26u as=0.14875p ps=1.16u w=0.74u l=0.13u
M1347 SAR/a_6213_3911# SAR/sg13cmos5l_dfrbp_1_11.Q vss vss sg13_lv_nmos ad=0.2516p pd=2.16u as=2.41737p ps=15.64u w=0.74u l=0.13u
M1348 SAR/a_2160_4972# SAR/a_1609_4704# vdd vdd sg13_lv_pmos ad=0.105p pd=1.21u as=1.28962p ps=8.195u w=1u l=0.13u
M1349 SAR/a_5637_2399# SAR/sg13cmos5l_dlhr_1_0.GATE vss vss sg13_lv_nmos ad=0.2516p pd=2.16u as=2.59257p ps=16.445u w=0.74u l=0.13u
M1350 vss SAR/sg13cmos5l_dfrbp_1_6.RESET_B SAR/a_16068_6162# vss sg13_lv_nmos ad=0.1626p pd=1.415u as=60.89999f ps=0.71u w=0.42u l=0.13u
M1351 SAR/sg13cmos5l_buf_1_111.A SAR/a_19240_7712# vdd vdd sg13_lv_pmos ad=0.42p pd=2.99u as=0.2114p ps=1.54u w=1.12u l=0.13u
M1352 vdd _cks SAR/sg13cmos5l_dfrbp_1_6.RESET_B vdd sg13_lv_pmos ad=0.3808p pd=2.92u as=0.2184p ps=1.51u w=1.12u l=0.13u
M1353 SAR/sg13cmos5l_dlhr_1_0.GATE SAR/a_5684_4948# vss vss sg13_lv_nmos ad=0.2516p pd=2.16u as=0.1406p ps=1.12u w=0.74u l=0.13u
M1354 vss SAR/sg13cmos5l_buf_1_68.X SAR/a_616_9224# vss sg13_lv_nmos ad=0.14875p pd=1.16u as=0.187p ps=1.78u w=0.55u l=0.13u
M1355 SAR/a_14962_3138# SAR/sg13cmos5l_dfrbp_1_0.RESET_B vss vss sg13_lv_nmos ad=37.8f pd=0.6u as=79.8f ps=0.8u w=0.42u l=0.13u
M1356 SAR/sg13cmos5l_dlhr_1_5.D SAR/a_6959_6239# vdd vdd sg13_lv_pmos ad=0.4312p pd=3.01u as=0.2639p ps=1.81u w=1.12u l=0.13u
M1357 SAR/a_4847_4727# SAR/a_4005_4629# SAR/a_4753_4727# vss sg13_lv_nmos ad=0.12665p pd=1.145u as=0.1428p ps=1.52u w=0.42u l=0.13u
M1358 SAR/a_15206_2826# SAR/a_16011_2399# SAR/a_15466_2356# vdd sg13_lv_pmos ad=0.1428p pd=1.52u as=79.8f ps=0.8u w=0.42u l=0.13u
M1359 SAR/sg13cmos5l_o21ai_1_0.B1 SAR/sg13cmos5l_nand2_1_1.B vdd vdd sg13_lv_pmos ad=0.2128p pd=1.5u as=0.3808p ps=2.92u w=1.12u l=0.13u
M1360 SAR/a_19164_5814# SAR/a_18615_5770# SAR/a_19028_5412# vss sg13_lv_nmos ad=47.25f pd=0.645u as=0.141p ps=1.17u w=0.42u l=0.13u
M1361 SAR/sg13cmos5l_or2_1_1.B SAR/sg13cmos5l_nor2_1_0.A vss vss sg13_lv_nmos ad=0.1406p pd=1.12u as=0.2516p ps=2.16u w=0.74u l=0.13u
M1362 vss SAR/sg13cmos5l_buf_1_110.A SAR/a_15784_9224# vss sg13_lv_nmos ad=0.14875p pd=1.16u as=0.187p ps=1.78u w=0.55u l=0.13u
M1363 vss SAR/a_14900_2352# SAR/sg13cmos5l_nand2_1_0.A vss sg13_lv_nmos ad=0.17255p pd=1.25u as=0.1406p ps=1.12u w=0.74u l=0.13u
M1364 vss SAR/sg13cmos5l_buf_1_7.A SAR/a_14056_1664# vss sg13_lv_nmos ad=0.14875p pd=1.16u as=0.187p ps=1.78u w=0.55u l=0.13u
M1365 vss SAR/sg13cmos5l_buf_1_105.A SAR/a_18856_8436# vss sg13_lv_nmos ad=0.14875p pd=1.16u as=0.187p ps=1.78u w=0.55u l=0.13u
M1366 vdd SAR/sg13cmos5l_buf_1_77.X SAR/a_7336_9224# vdd sg13_lv_pmos ad=0.2114p pd=1.54u as=0.2856p ps=2.36u w=0.84u l=0.13u
M1367 SAR/a_1846_7850# SAR/a_1948_7964# vss vss sg13_lv_nmos ad=0.187p pd=1.78u as=0.1491p ps=1.18u w=0.55u l=0.13u
M1368 SAR/a_3771_6553# SAR/a_2879_6432# SAR/a_3669_6320# vdd sg13_lv_pmos ad=63f pd=0.72u as=79.8f ps=0.8u w=0.42u l=0.13u
M1369 vss SAR/sg13cmos5l_dfrbp_1_8.RESET_B SAR/a_14436_8874# vss sg13_lv_nmos ad=0.1626p pd=1.415u as=60.89999f ps=0.71u w=0.42u l=0.13u
M1370 SAR/sg13cmos5l_dlhr_1_18.Q_N SAR/a_11190_7354# vss vss sg13_lv_nmos ad=0.2516p pd=2.16u as=0.1491p ps=1.18u w=0.74u l=0.13u
M1371 SAR/a_4847_4727# SAR/a_4005_4629# SAR/a_3588_4968# vdd sg13_lv_pmos ad=0.2048p pd=1.63u as=0.34p ps=2.68u w=1u l=0.13u
M1372 vss SAR/a_6188_1590# SAR/sg13cmos5l_buf_1_25.X vss sg13_lv_nmos ad=0.14875p pd=1.16u as=0.2886p ps=2.26u w=0.74u l=0.13u
M1373 vss SAR/sg13cmos5l_dlhr_1_1.GATE SAR/a_4349_7636# vss sg13_lv_nmos ad=0.15055p pd=1.17u as=0.2516p ps=2.16u w=0.74u l=0.13u
M1374 SAR/sg13cmos5l_dlhr_1_16.Q_N SAR/a_19734_5842# vss vss sg13_lv_nmos ad=0.2516p pd=2.16u as=0.1491p ps=1.18u w=0.74u l=0.13u
M1375 SAR/sg13cmos5l_dfrbp_1_21.Q SAR/a_18356_6460# vdd vdd sg13_lv_pmos ad=0.3808p pd=2.92u as=0.2128p ps=1.5u w=1.12u l=0.13u
M1376 vss SAR/sg13cmos5l_dfrbp_1_6.RESET_B SAR/a_15412_5800# vss sg13_lv_nmos ad=0.1406p pd=1.12u as=77.7f ps=0.95u w=0.74u l=0.13u
M1377 SAR/a_6647_5459# SAR/a_5951_5383# SAR/a_6741_5459# vss sg13_lv_nmos ad=0.1296p pd=1.52u as=79.8f ps=0.8u w=0.42u l=0.13u
M1378 vss SAR/a_7052_9150# SAR/sg13cmos5l_buf_1_76.X vss sg13_lv_nmos ad=0.14875p pd=1.16u as=0.2886p ps=2.26u w=0.74u l=0.13u
M1379 vss SAR/a_1878_6337# SAR/sg13cmos5l_dlhr_1_1.GATE vss sg13_lv_nmos ad=0.1406p pd=1.12u as=0.2516p ps=2.16u w=0.74u l=0.13u
M1380 vdd SAR/a_8439_6178# SAR/a_8570_6172# vdd sg13_lv_pmos ad=1.07253p pd=6.75u as=0.2856p ps=2.36u w=0.84u l=0.13u
M1381 SAR/a_9823_2780# SAR/sg13cmos5l_a22oi_1_2.B1 vss vss sg13_lv_nmos ad=0.13875p pd=1.115u as=0.2553p ps=2.17u w=0.74u l=0.13u
M1382 SAR/a_14295_7282# SAR/sg13cmos5l_dfrbp_1_23.CLK vss vss sg13_lv_nmos ad=0.2516p pd=2.16u as=0.15055p ps=1.17u w=0.74u l=0.13u
M1383 SAR/a_6741_5459# SAR/a_5799_5499# SAR/a_6647_5459# vdd sg13_lv_pmos ad=79.8f pd=0.8u as=0.1428p ps=1.52u w=0.42u l=0.13u
M1384 SAR/a_4276_2776# SAR/a_3860_2388# SAR/a_4041_2745# vss sg13_lv_nmos ad=77.7f pd=0.95u as=0.2516p ps=2.16u w=0.74u l=0.13u
M1385 vdd SAR/a_18345_7674# SAR/a_18870_7656# vdd sg13_lv_pmos ad=0.1974p pd=1.5u as=0.2856p ps=2.36u w=0.84u l=0.13u
M1386 vss SAR/a_18117_3117# SAR/a_18219_3260# vss sg13_lv_nmos ad=2.59257p pd=16.445u as=0.2516p ps=2.16u w=0.74u l=0.13u
M1387 vss SAR/sg13cmos5l_buf_1_8.A SAR/a_10888_1664# vss sg13_lv_nmos ad=0.14875p pd=1.16u as=0.187p ps=1.78u w=0.55u l=0.13u
M1388 SAR/sg13cmos5l_buf_8_0.A SAR/a_18480_5028# vdd vdd sg13_lv_pmos ad=0.3976p pd=2.95u as=0.2226p ps=1.535u w=1.12u l=0.13u
M1389 SAR/a_7941_7653# SAR/sg13cmos5l_dfrbp_1_18.Q vss vss sg13_lv_nmos ad=0.2516p pd=2.16u as=1.49685p ps=9.6u w=0.74u l=0.13u
M1390 SAR/a_8746_8404# SAR/a_9189_8447# SAR/a_9129_8483# vdd sg13_lv_pmos ad=79.8f pd=0.8u as=63f ps=0.72u w=0.42u l=0.13u
M1391 SAR/sg13cmos5l_dfrbp_1_16.Q_N SAR/a_1967_7285# vss vss sg13_lv_nmos ad=0.2849p pd=2.25u as=0.2516p ps=2.16u w=0.74u l=0.13u
M1392 SAR/sg13cmos5l_dlhr_1_5.Q SAR/a_8457_7281# vdd vdd sg13_lv_pmos ad=0.3808p pd=2.92u as=0.2128p ps=1.5u w=1.12u l=0.13u
M1393 SAR/sg13cmos5l_buf_1_8.A SAR/sg13cmos5l_inv_1_7.A vdd vdd sg13_lv_pmos ad=0.3808p pd=2.92u as=0.3808p ps=2.92u w=1.12u l=0.13u
M1394 SAR/a_8774_5412# SAR/a_8378_5776# SAR/a_8660_5412# vdd sg13_lv_pmos ad=0.1008p pd=0.9u as=0.191p ps=1.44u w=0.42u l=0.13u
M1395 SAR/sg13cmos5l_buf_1_89.A SAR/a_14889_7281# vss vss sg13_lv_nmos ad=0.2516p pd=2.16u as=0.1406p ps=1.12u w=0.74u l=0.13u
M1396 vss SAR/a_19593_6162# SAR/a_20118_6144# vss sg13_lv_nmos ad=0.1491p pd=1.18u as=0.187p ps=1.78u w=0.55u l=0.13u
M1397 vss SAR/sg13cmos5l_dfrbp_1_6.RESET_B SAR/a_5508_6162# vss sg13_lv_nmos ad=0.1626p pd=1.415u as=60.89999f ps=0.71u w=0.42u l=0.13u
M1398 vss SAR/a_11877_2399# SAR/a_11979_2399# vss sg13_lv_nmos ad=2.59257p pd=16.445u as=0.2516p ps=2.16u w=0.74u l=0.13u
M1399 SAR/a_3599_3215# SAR/a_2757_3117# SAR/a_3505_3215# vss sg13_lv_nmos ad=0.12665p pd=1.145u as=0.1428p ps=1.52u w=0.42u l=0.13u
M1400 SAR/a_18164_7996# SAR/a_17882_7684# SAR/a_18097_7666# vss sg13_lv_nmos ad=0.141p pd=1.17u as=71.99999f ps=0.865u w=0.64u l=0.13u
M1401 vdd vss vdd vdd sg13_lv_pmos ad=0.34p pd=2.68u as=0 ps=0 w=1u l=1u
M1402 SAR/a_10116_7674# SAR/sg13cmos5l_buf_1_57.X SAR/a_10022_7674# vss sg13_lv_nmos ad=60.89999f pd=0.71u as=0.1428p ps=1.52u w=0.42u l=0.13u
M1403 vdd SAR/a_17135_4727# SAR/a_17972_4948# vdd sg13_lv_pmos ad=0.2128p pd=1.5u as=0.3864p ps=2.93u w=1.12u l=0.13u
M1404 vdd _cks SAR/sg13cmos5l_dfrbp_1_6.RESET_B vdd sg13_lv_pmos ad=0.2128p pd=1.5u as=0.2128p ps=1.5u w=1.12u l=0.13u
M1405 vdd SAR/a_3407_4261# SAR/a_3664_4142# vdd sg13_lv_pmos ad=0.2639p pd=1.81u as=79.8f ps=0.8u w=0.42u l=0.13u
M1406 SAR/a_3562_4873# SAR/a_4005_4629# SAR/a_3945_5041# vdd sg13_lv_pmos ad=79.8f pd=0.8u as=63f ps=0.72u w=0.42u l=0.13u
M1407 SAR/a_4514_7666# SAR/a_4324_7996# SAR/a_4076_7624# vss sg13_lv_nmos ad=71.99999f pd=0.865u as=0.141p ps=1.17u w=0.64u l=0.13u
M1408 SAR/sg13cmos5l_dfrbp_1_8.Q_N SAR/a_17135_4727# vss vss sg13_lv_nmos ad=0.2849p pd=2.25u as=0.2516p ps=2.16u w=0.74u l=0.13u
M1409 vss SAR/sg13cmos5l_inv_1_1.A SAR/sg13cmos5l_buf_1_2.A vss sg13_lv_nmos ad=0.2516p pd=2.16u as=0.2516p ps=2.16u w=0.74u l=0.13u
M1410 vdd SAR/sg13cmos5l_dlhr_1_1.D SAR/a_1609_4704# vdd sg13_lv_pmos ad=1.28962p pd=8.195u as=0.2856p ps=2.36u w=0.84u l=0.13u
M1411 vdd SAR/sg13cmos5l_dfrbp_1_6.RESET_B SAR/a_15177_5769# vdd sg13_lv_pmos ad=0.2128p pd=1.5u as=0.2128p ps=1.5u w=1.12u l=0.13u
M1412 SAR/a_17584_7166# SAR/a_17327_7285# SAR/a_17746_7362# vss sg13_lv_nmos ad=0.1428p pd=1.52u as=37.8f ps=0.6u w=0.42u l=0.13u
M1413 vss SAR/a_1463_8741# SAR/a_1463_8741# vss sg13_lv_nmos ad=2.92392p pd=18.89u as=0.111p ps=1.34u w=0.3u l=0.13u
M1414 SAR/sg13cmos5l_buf_1_30.X SAR/a_8680_1664# vss vss sg13_lv_nmos ad=0.2886p pd=2.26u as=0.14875p ps=1.16u w=0.74u l=0.13u
M1415 SAR/a_13484_8400# SAR/sg13cmos5l_dlhr_1_11.Q vdd vdd sg13_lv_pmos ad=0.2856p pd=2.36u as=0.2114p ps=1.54u w=0.84u l=0.13u
M1416 vdd SAR/a_5104_4870# SAR/a_5049_4965# vdd sg13_lv_pmos ad=1.28962p pd=8.195u as=93.45f ps=0.865u w=0.42u l=0.13u
M1417 SAR/a_7498_7897# SAR/a_7941_7653# SAR/a_7881_8065# vdd sg13_lv_pmos ad=79.8f pd=0.8u as=63f ps=0.72u w=0.42u l=0.13u
M1418 SAR/a_908_1590# SAR/sg13cmos5l_buf_1_32.A vdd vdd sg13_lv_pmos ad=0.2856p pd=2.36u as=0.2114p ps=1.54u w=0.84u l=0.13u
M1419 SAR/a_11054_4292# SAR/sg13cmos5l_nand2_1_0.A SAR/sg13cmos5l_a22oi_1_0.Y vss sg13_lv_nmos ad=96.2f pd=1u as=0.2664p ps=1.46u w=0.74u l=0.13u
M1420 vss SAR/a_4172_1590# SAR/sg13cmos5l_buf_1_33.A vss sg13_lv_nmos ad=0.14875p pd=1.16u as=0.2886p ps=2.26u w=0.74u l=0.13u
M1421 SAR/a_1846_7850# SAR/a_1948_7964# vdd vdd sg13_lv_pmos ad=0.2856p pd=2.36u as=0.1974p ps=1.5u w=0.84u l=0.13u
M1422 vdd SAR/sg13cmos5l_dfrbp_1_6.RESET_B SAR/a_10282_7897# vdd sg13_lv_pmos ad=0.1563p pd=1.22u as=0.147p ps=1.54u w=0.42u l=0.13u
M1423 vdd SAR/a_16572_4261# SAR/a_17595_3947# vdd sg13_lv_pmos ad=0.1563p pd=1.22u as=63f ps=0.72u w=0.42u l=0.13u
M1424 vss SAR/sg13cmos5l_nand2_1_2.B SAR/a_1210_4654# vss sg13_lv_nmos ad=0.2516p pd=2.16u as=0.1406p ps=1.12u w=0.74u l=0.13u
M1425 vss SAR/a_13100_8400# pl_sw[6] vss sg13_lv_nmos ad=0.14875p pd=1.16u as=0.2886p ps=2.26u w=0.74u l=0.13u
M1426 SAR/sg13cmos5l_buf_1_6.A SAR/a_12520_3176# vdd vdd sg13_lv_pmos ad=0.42p pd=2.99u as=0.2114p ps=1.54u w=1.12u l=0.13u
M1427 ph_sw[0] SAR/a_616_9224# vdd vdd sg13_lv_pmos ad=0.42p pd=2.99u as=0.2114p ps=1.54u w=1.12u l=0.13u
M1428 SAR/sg13cmos5l_buf_1_3.X SAR/a_20296_1664# vss vss sg13_lv_nmos ad=0.2886p pd=2.26u as=0.14875p ps=1.16u w=0.74u l=0.13u
M1429 nl_sw[6] SAR/a_11656_3176# vss vss sg13_lv_nmos ad=0.2886p pd=2.26u as=0.14875p ps=1.16u w=0.74u l=0.13u
M1430 SAR/a_11782_1639# SAR/sg13cmos5l_dfrbp_1_0.RESET_B vss vss sg13_lv_nmos ad=37.8f pd=0.6u as=0.1701p ps=1.65u w=0.42u l=0.13u
M1431 SAR/sg13cmos5l_and3_1_0.X SAR/a_13324_4696# vss vss sg13_lv_nmos ad=0.2516p pd=2.16u as=0.1371p ps=1.12u w=0.74u l=0.13u
M1432 vss SAR/a_18999_6178# SAR/a_19130_6172# vss sg13_lv_nmos ad=1.97045p pd=12.335u as=0.2775p ps=2.23u w=0.74u l=0.13u
M1433 vss SAR/sg13cmos5l_dfrbp_1_8.RESET_B SAR/a_8580_8874# vss sg13_lv_nmos ad=0.1626p pd=1.415u as=60.89999f ps=0.71u w=0.42u l=0.13u
M1434 vdd SAR/sg13cmos5l_buf_1_44.X SAR/sg13cmos5l_buf_1_38.A vdd sg13_lv_pmos ad=0.3808p pd=2.92u as=0.3808p ps=2.92u w=1.12u l=0.13u
M1435 vdd SAR/a_3308_9150# SAR/sg13cmos5l_inv_1_8.A vdd sg13_lv_pmos ad=0.2114p pd=1.54u as=0.42p ps=2.99u w=1.12u l=0.13u
M1436 vdd SAR/a_20492_8400# pl_sw[10] vdd sg13_lv_pmos ad=0.2114p pd=1.54u as=0.42p ps=2.99u w=1.12u l=0.13u
M1437 SAR/sg13cmos5l_buf_1_103.A SAR/a_15784_9224# vdd vdd sg13_lv_pmos ad=0.42p pd=2.99u as=0.2114p ps=1.54u w=1.12u l=0.13u
M1438 SAR/sg13cmos5l_dlhr_1_6.D SAR/a_7796_6460# vdd vdd sg13_lv_pmos ad=0.3808p pd=2.92u as=0.2128p ps=1.5u w=1.12u l=0.13u
M1439 vdd SAR/a_18117_3117# SAR/a_18219_3260# vdd sg13_lv_pmos ad=1.43437p pd=9.105u as=0.3864p ps=2.93u w=1.12u l=0.13u
M1440 SAR/a_13593_9501# SAR/a_12651_9308# SAR/a_13391_9263# vdd sg13_lv_pmos ad=93.45f pd=0.865u as=0.2048p ps=1.63u w=0.42u l=0.13u
M1441 SAR/a_7524_7992# SAR/a_8043_7796# SAR/a_8783_7751# vss sg13_lv_nmos ad=0.3473p pd=2.71u as=0.12665p ps=1.145u w=0.74u l=0.13u
M1442 vss SAR/sg13cmos5l_dfrbp_1_6.RESET_B SAR/a_7924_1612# vss sg13_lv_nmos ad=0.1406p pd=1.12u as=77.7f ps=0.95u w=0.74u l=0.13u
M1443 SAR/a_5988_8440# SAR/a_5962_8404# vdd vdd sg13_lv_pmos ad=0.34p pd=2.68u as=0.36237p ps=2.605u w=1u l=0.13u
M1444 SAR/sg13cmos5l_buf_1_86.A SAR/a_20008_8436# vdd vdd sg13_lv_pmos ad=0.42p pd=2.99u as=0.2114p ps=1.54u w=1.12u l=0.13u
M1445 SAR/a_7941_7653# SAR/sg13cmos5l_dfrbp_1_18.Q vdd vdd sg13_lv_pmos ad=0.4088p pd=2.97u as=1.15047p ps=7.175u w=1.12u l=0.13u
M1446 vdd SAR/sg13cmos5l_buf_1_89.A SAR/a_15208_6200# vdd sg13_lv_pmos ad=0.2114p pd=1.54u as=0.2856p ps=2.36u w=0.84u l=0.13u
M1447 SAR/sg13cmos5l_dlhr_1_14.Q_N SAR/a_14166_7656# vdd vdd sg13_lv_pmos ad=0.3808p pd=2.92u as=0.1974p ps=1.5u w=1.12u l=0.13u
M1448 vss vdd vss vss sg13_lv_nmos ad=0.1428p pd=1.52u as=0 ps=0 w=0.42u l=1u
M1449 SAR/a_11556_3904# SAR/a_11530_3868# vss vss sg13_lv_nmos ad=0.2516p pd=2.16u as=0.1626p ps=1.415u w=0.74u l=0.13u
M1450 vss SAR/a_8457_7281# SAR/a_8982_7354# vss sg13_lv_nmos ad=0.1491p pd=1.18u as=0.187p ps=1.78u w=0.55u l=0.13u
M1451 SAR/a_5266_4650# SAR/sg13cmos5l_dfrbp_1_8.RESET_B vss vss sg13_lv_nmos ad=37.8f pd=0.6u as=79.8f ps=0.8u w=0.42u l=0.13u
M1452 SAR/sg13cmos5l_inv_1_3.A SAR/a_13768_8436# vdd vdd sg13_lv_pmos ad=0.42p pd=2.99u as=0.2114p ps=1.54u w=1.12u l=0.13u
M1453 SAR/sg13cmos5l_buf_1_19.X SAR/a_18760_2388# vdd vdd sg13_lv_pmos ad=0.42p pd=2.99u as=0.2114p ps=1.54u w=1.12u l=0.13u
M1454 SAR/sg13cmos5l_a22oi_1_1.B2 SAR/sg13cmos5l_and3_1_0.X SAR/a_13698_5412# vdd sg13_lv_pmos ad=0.3808p pd=2.92u as=0.2128p ps=1.5u w=1.12u l=0.13u
M1455 SAR/a_7441_1618# SAR/a_6889_1680# vss vss sg13_lv_nmos ad=71.99999f pd=0.865u as=7.01497p ps=46.005u w=0.64u l=0.13u
M1456 SAR/sg13cmos5l_buf_1_65.X SAR/a_424_8436# vss vss sg13_lv_nmos ad=0.2886p pd=2.26u as=0.14875p ps=1.16u w=0.74u l=0.13u
M1457 vss SAR/a_1846_7850# SAR/sg13cmos5l_dlhr_1_8.Q_N vss sg13_lv_nmos ad=0.1491p pd=1.18u as=0.2516p ps=2.16u w=0.74u l=0.13u
M1458 vss vdd vss vss sg13_lv_nmos ad=0.1428p pd=1.52u as=0 ps=0 w=0.42u l=1u
M1459 vss SAR/a_17776_6382# SAR/a_17425_6239# vss sg13_lv_nmos ad=79.8f pd=0.8u as=0.1428p ps=1.52u w=0.42u l=0.13u
M1460 SAR/a_4425_7281# SAR/a_4244_6924# vdd vdd sg13_lv_pmos ad=0.2128p pd=1.5u as=0.2387p ps=1.84u w=1.12u l=0.13u
M1461 SAR/a_9164_1590# SAR/sg13cmos5l_buf_1_26.A vdd vdd sg13_lv_pmos ad=0.2856p pd=2.36u as=0.2114p ps=1.54u w=0.84u l=0.13u
M1462 SAR/a_9823_2364# SAR/sg13cmos5l_a22oi_1_2.B2 SAR/sg13cmos5l_dfrbp_1_1.D vdd sg13_lv_pmos ad=0.2744p pd=1.61u as=0.2128p ps=1.5u w=1.12u l=0.13u
M1463 SAR/a_11973_3911# SAR/sg13cmos5l_dfrbp_1_0.CLK vdd vdd sg13_lv_pmos ad=0.4088p pd=2.97u as=1.38655p ps=8.8u w=1.12u l=0.13u
M1464 SAR/a_15012_7992# SAR/a_14986_7897# vdd vdd sg13_lv_pmos ad=0.34p pd=2.68u as=0.36237p ps=2.605u w=1u l=0.13u
M1465 vss SAR/a_3831_7282# SAR/a_3962_7288# vss sg13_lv_nmos ad=1.49685p pd=9.6u as=0.2775p ps=2.23u w=0.74u l=0.13u
M1466 vdd SAR/sg13cmos5l_dlhr_1_2.D SAR/a_6697_3192# vdd sg13_lv_pmos ad=1.43437p pd=9.105u as=0.2856p ps=2.36u w=0.84u l=0.13u
M1467 SAR/a_10331_1924# SAR/sg13cmos5l_nor2b_1_0.Y vdd vdd sg13_lv_pmos ad=0.3808p pd=2.92u as=0.2128p ps=1.5u w=1.12u l=0.13u
M1468 vss SAR/a_5132_3864# SAR/sg13cmos5l_buf_1_44.X vss sg13_lv_nmos ad=0.14875p pd=1.16u as=0.2886p ps=2.26u w=0.74u l=0.13u
M1469 SAR/a_3308_9150# SAR/sg13cmos5l_buf_1_65.X vdd vdd sg13_lv_pmos ad=0.2856p pd=2.36u as=0.2114p ps=1.54u w=0.84u l=0.13u
M1470 SAR/a_10233_8559# SAR/a_9291_8447# SAR/a_10031_8797# vdd sg13_lv_pmos ad=93.45f pd=0.865u as=0.2048p ps=1.63u w=0.42u l=0.13u
M1471 SAR/sg13cmos5l_dfrbp_1_16.Q SAR/a_2804_6924# vss vss sg13_lv_nmos ad=0.2516p pd=2.16u as=0.1406p ps=1.12u w=0.74u l=0.13u
M1472 vss SAR/a_8439_6178# SAR/a_8570_6172# vss sg13_lv_nmos ad=1.97045p pd=12.335u as=0.2775p ps=2.23u w=0.74u l=0.13u
M1473 SAR/sg13cmos5l_dfrbp_1_25.Q_N SAR/a_15887_8797# vss vss sg13_lv_nmos ad=0.2849p pd=2.25u as=0.2516p ps=2.16u w=0.74u l=0.13u
M1474 SAR/a_708_5416# SAR/a_682_5380# vdd vdd sg13_lv_pmos ad=0.34p pd=2.68u as=0.36237p ps=2.605u w=1u l=0.13u
M1475 SAR/a_7812_7687# SAR/a_8043_7796# SAR/a_7498_7897# vss sg13_lv_nmos ad=0.2373p pd=1.97u as=79.8f ps=0.8u w=0.42u l=0.13u
M1476 SAR/a_6736_2630# SAR/sg13cmos5l_dfrbp_1_6.RESET_B vdd vdd sg13_lv_pmos ad=79.8f pd=0.8u as=1.86162p ps=11.935u w=0.42u l=0.13u
M1477 ph_sw[10] SAR/a_20392_6924# vdd vdd sg13_lv_pmos ad=0.42p pd=2.99u as=0.2114p ps=1.54u w=1.12u l=0.13u
M1478 SAR/a_5194_2356# SAR/a_5637_2399# SAR/a_4934_2826# vss sg13_lv_nmos ad=79.8f pd=0.8u as=0.1296p ps=1.52u w=0.42u l=0.13u
M1479 vss SAR/sg13cmos5l_buf_1_44.X SAR/sg13cmos5l_buf_1_38.A vss sg13_lv_nmos ad=0.2516p pd=2.16u as=0.2516p ps=2.16u w=0.74u l=0.13u
M1480 SAR/a_16164_4663# SAR/a_15876_4968# SAR/a_16102_4663# vss sg13_lv_nmos ad=0.1428p pd=1.52u as=37.8f ps=0.6u w=0.42u l=0.13u
M1481 vss SAR/a_16940_3102# nh_sw[8] vss sg13_lv_nmos ad=0.14875p pd=1.16u as=0.2886p ps=2.26u w=0.74u l=0.13u
M1482 vdd SAR/sg13cmos5l_buf_1_64.A SAR/a_3976_9224# vdd sg13_lv_pmos ad=0.2114p pd=1.54u as=0.2856p ps=2.36u w=0.84u l=0.13u
M1483 SAR/a_15369_8065# SAR/a_15012_7992# vdd vdd sg13_lv_pmos ad=63f pd=0.72u as=0.1563p ps=1.22u w=0.42u l=0.13u
M1484 vdd SAR/sg13cmos5l_dfrbp_1_6.RESET_B SAR/a_682_5380# vdd sg13_lv_pmos ad=0.1563p pd=1.22u as=0.147p ps=1.54u w=0.42u l=0.13u
M1485 vss SAR/a_12933_6141# SAR/a_13035_6284# vss sg13_lv_nmos ad=1.97045p pd=12.335u as=0.2516p ps=2.16u w=0.74u l=0.13u
M1486 vss SAR/a_14543_3215# SAR/a_15380_3436# vss sg13_lv_nmos ad=0.1406p pd=1.12u as=0.2516p ps=2.16u w=0.74u l=0.13u
M1487 vdd SAR/a_1125_6935# SAR/a_1227_6935# vdd sg13_lv_pmos ad=1.07253p pd=6.75u as=0.3864p ps=2.93u w=1.12u l=0.13u
M1488 SAR/sg13cmos5l_buf_1_31.X SAR/a_424_1664# vdd vdd sg13_lv_pmos ad=0.42p pd=2.99u as=0.2114p ps=1.54u w=1.12u l=0.13u
M1489 SAR/a_13047_7690# SAR/sg13cmos5l_dlhr_1_11.GATE vdd vdd sg13_lv_pmos ad=0.3234p pd=2.45u as=1.12242p ps=7u w=0.84u l=0.13u
M1490 SAR/a_18096_7996# SAR/a_17545_7728# vdd vdd sg13_lv_pmos ad=0.105p pd=1.21u as=1.15047p ps=7.175u w=1u l=0.13u
M1491 SAR/sg13cmos5l_dfrbp_1_8.D SAR/a_18164_6924# vss vss sg13_lv_nmos ad=0.2516p pd=2.16u as=0.1406p ps=1.12u w=0.74u l=0.13u
M1492 vdd SAR/a_20204_5376# SAR/sg13cmos5l_inv_1_6.A vdd sg13_lv_pmos ad=0.2114p pd=1.54u as=0.42p ps=2.99u w=1.12u l=0.13u
M1493 SAR/a_2638_6477# SAR/a_2380_6162# vdd vdd sg13_lv_pmos ad=93.45f pd=0.865u as=1.07253p ps=6.75u w=0.42u l=0.13u
M1494 vss SAR/sg13cmos5l_buf_1_104.A SAR/a_19624_8436# vss sg13_lv_nmos ad=0.14875p pd=1.16u as=0.187p ps=1.78u w=0.55u l=0.13u
M1495 vdd SAR/a_20012_2352# nl_sw[10] vdd sg13_lv_pmos ad=0.2114p pd=1.54u as=0.42p ps=2.99u w=1.12u l=0.13u
M1496 SAR/a_2148_3904# SAR/a_2122_3868# vss vss sg13_lv_nmos ad=0.2516p pd=2.16u as=0.1626p ps=1.415u w=0.74u l=0.13u
M1497 SAR/a_3588_4968# SAR/a_3562_4873# vss vss sg13_lv_nmos ad=0.2516p pd=2.16u as=0.1626p ps=1.415u w=0.74u l=0.13u
M1498 vss SAR/a_2565_3911# SAR/a_2667_3911# vss sg13_lv_nmos ad=2.41737p pd=15.64u as=0.2516p ps=2.16u w=0.74u l=0.13u
M1499 SAR/a_14476_2388# SAR/a_14254_2444# vdd vdd sg13_lv_pmos ad=0.1176p pd=1.33u as=0.2618p ps=1.63u w=1.12u l=0.13u
M1500 vss SAR/sg13cmos5l_buf_1_116.A SAR/a_15592_6200# vss sg13_lv_nmos ad=0.14875p pd=1.16u as=0.187p ps=1.78u w=0.55u l=0.13u
M1501 SAR/a_10282_7897# SAR/a_10725_7653# SAR/a_10022_7674# vss sg13_lv_nmos ad=79.8f pd=0.8u as=0.1296p ps=1.52u w=0.42u l=0.13u
M1502 vss SAR/a_16748_9150# pl_sw[7] vss sg13_lv_nmos ad=0.14875p pd=1.16u as=0.2886p ps=2.26u w=0.74u l=0.13u
M1503 SAR/a_516_7362# SAR/sg13cmos5l_dfrbp_1_6.D SAR/a_422_7362# vss sg13_lv_nmos ad=60.89999f pd=0.71u as=0.1428p ps=1.52u w=0.42u l=0.13u
M1504 SAR/sg13cmos5l_dfrbp_1_4.Q_N SAR/a_12719_2749# vss vss sg13_lv_nmos ad=0.2849p pd=2.25u as=0.2516p ps=2.16u w=0.74u l=0.13u
M1505 SAR/a_1580_2352# SAR/sg13cmos5l_buf_1_40.X vss vss sg13_lv_nmos ad=0.187p pd=1.78u as=0.14875p ps=1.16u w=0.55u l=0.13u
M1506 SAR/sg13cmos5l_buf_1_56.A SAR/a_9033_6162# vss vss sg13_lv_nmos ad=0.2516p pd=2.16u as=0.1406p ps=1.12u w=0.74u l=0.13u
M1507 vss SAR/sg13cmos5l_dfrbp_1_23.Q SAR/a_14089_7282# vss sg13_lv_nmos ad=0.15055p pd=1.17u as=0.187p ps=1.78u w=0.55u l=0.13u
M1508 SAR/a_2342_5088# SAR/a_1946_4660# SAR/a_2228_4972# vdd sg13_lv_pmos ad=0.1008p pd=0.9u as=0.191p ps=1.44u w=0.42u l=0.13u
M1509 vdd SAR/a_11072_5347# SAR/sg13cmos5l_a221oi_1_1.C1 vdd sg13_lv_pmos ad=0.36195p pd=1.84u as=0.3808p ps=2.92u w=1.12u l=0.13u
M1510 SAR/a_8588_2352# SAR/sg13cmos5l_buf_1_26.X vdd vdd sg13_lv_pmos ad=0.2856p pd=2.36u as=0.2114p ps=1.54u w=0.84u l=0.13u
M1511 SAR/sg13cmos5l_nand2_1_1.B SAR/a_15357_1816# vdd vdd sg13_lv_pmos ad=0.2128p pd=1.5u as=0.3808p ps=2.92u w=1.12u l=0.13u
M1512 SAR/a_5674_6385# SAR/a_6117_6141# SAR/a_5414_6162# vss sg13_lv_nmos ad=79.8f pd=0.8u as=0.1296p ps=1.52u w=0.42u l=0.13u
M1513 vdd vss vdd vdd sg13_lv_pmos ad=0.19p pd=1.38u as=0 ps=0 w=1u l=1u
M1514 SAR/a_17392_4870# SAR/sg13cmos5l_dfrbp_1_8.RESET_B vdd vdd sg13_lv_pmos ad=79.8f pd=0.8u as=1.2517p ps=7.955u w=0.42u l=0.13u
M1515 vss SAR/a_8204_2352# SAR/sg13cmos5l_buf_1_24.A vss sg13_lv_nmos ad=0.14875p pd=1.16u as=0.2886p ps=2.26u w=0.74u l=0.13u
M1516 vss SAR/sg13cmos5l_buf_1_74.X SAR/a_6568_9224# vss sg13_lv_nmos ad=0.14875p pd=1.16u as=0.187p ps=1.78u w=0.55u l=0.13u
M1517 SAR/a_5628_3174# SAR/a_5079_3154# SAR/a_5492_3460# vss sg13_lv_nmos ad=47.25f pd=0.645u as=0.141p ps=1.17u w=0.42u l=0.13u
M1518 vdd SAR/sg13cmos5l_a22oi_1_0.Y SAR/sg13cmos5l_dfrbp_1_2.D vdd sg13_lv_pmos ad=0.3808p pd=2.92u as=0.3808p ps=2.92u w=1.12u l=0.13u
M1519 SAR/sg13cmos5l_or2_1_0.A SAR/a_18363_4270# vss vss sg13_lv_nmos ad=0.1406p pd=1.12u as=0.1406p ps=1.12u w=0.74u l=0.13u
M1520 SAR/a_15850_4873# SAR/a_16293_4629# SAR/a_16233_5041# vdd sg13_lv_pmos ad=79.8f pd=0.8u as=63f ps=0.72u w=0.42u l=0.13u
M1521 SAR/sg13cmos5l_buf_1_57.X SAR/a_9448_6924# vdd vdd sg13_lv_pmos ad=0.42p pd=2.99u as=0.2114p ps=1.54u w=1.12u l=0.13u
M1522 SAR/sg13cmos5l_buf_1_78.X SAR/a_6184_9224# vss vss sg13_lv_nmos ad=0.2886p pd=2.26u as=0.14875p ps=1.16u w=0.74u l=0.13u
M1523 SAR/sg13cmos5l_nor2_1_1.A SAR/a_17588_2388# vss vss sg13_lv_nmos ad=0.2516p pd=2.16u as=0.1406p ps=1.12u w=0.74u l=0.13u
M1524 SAR/a_11270_1626# SAR/a_12075_1748# SAR/a_11530_1849# vdd sg13_lv_pmos ad=0.1428p pd=1.52u as=79.8f ps=0.8u w=0.42u l=0.13u
M1525 vdd SAR/sg13cmos5l_dfrbp_1_6.RESET_B SAR/a_10022_7674# vdd sg13_lv_pmos ad=0.36237p pd=2.605u as=79.8f ps=0.8u w=0.42u l=0.13u
M1526 vdd SAR/a_5637_2399# SAR/a_5739_2399# vdd sg13_lv_pmos ad=1.86162p pd=11.935u as=0.3864p ps=2.93u w=1.12u l=0.13u
M1527 SAR/a_11460_2392# SAR/a_11979_2399# SAR/a_12719_2749# vss sg13_lv_nmos ad=0.3473p pd=2.71u as=0.12665p ps=1.145u w=0.74u l=0.13u
M1528 nh_sw[10] SAR/a_20392_3176# vdd vdd sg13_lv_pmos ad=0.42p pd=2.99u as=0.2114p ps=1.54u w=1.12u l=0.13u
M1529 SAR/a_16940_3102# SAR/sg13cmos5l_buf_1_4.X vdd vdd sg13_lv_pmos ad=0.2856p pd=2.36u as=0.2114p ps=1.54u w=0.84u l=0.13u
M1530 SAR/a_10094_2780# SAR/sg13cmos5l_inv_1_11.Y SAR/sg13cmos5l_dfrbp_1_1.D vss sg13_lv_nmos ad=96.2f pd=1u as=0.2664p ps=1.46u w=0.74u l=0.13u
M1531 vdd SAR/sg13cmos5l_nor2b_1_0.Y SAR/a_10783_3876# vdd sg13_lv_pmos ad=0.3808p pd=2.92u as=0.2744p ps=1.61u w=1.12u l=0.13u
M1532 SAR/a_11394_4948# SAR/sg13cmos5l_a221oi_1_0.B2 SAR/a_11182_4948# vdd sg13_lv_pmos ad=0.2128p pd=1.5u as=0.2128p ps=1.5u w=1.12u l=0.13u
M1533 SAR/a_16751_2749# SAR/a_15909_2399# SAR/a_16657_2749# vss sg13_lv_nmos ad=0.12665p pd=1.145u as=0.1428p ps=1.52u w=0.42u l=0.13u
M1534 SAR/a_620_2352# SAR/sg13cmos5l_buf_1_32.X vss vss sg13_lv_nmos ad=0.187p pd=1.78u as=0.14875p ps=1.16u w=0.55u l=0.13u
M1535 SAR/a_16144_8678# SAR/a_15887_8797# SAR/a_16306_8874# vss sg13_lv_nmos ad=0.1428p pd=1.52u as=37.8f ps=0.6u w=0.42u l=0.13u
M1536 vss SAR/sg13cmos5l_buf_8_1.A SAR/a_18363_4270# vss sg13_lv_nmos ad=0.1406p pd=1.12u as=0.1406p ps=1.12u w=0.74u l=0.13u
M1537 SAR/sg13cmos5l_dfrbp_1_27.Q_N SAR/a_10031_8797# vdd vdd sg13_lv_pmos ad=0.4312p pd=3.01u as=0.2639p ps=1.81u w=1.12u l=0.13u
M1538 SAR/a_3396_4650# SAR/sg13cmos5l_dfrbp_1_9.Q SAR/a_3302_4650# vss sg13_lv_nmos ad=60.89999f pd=0.71u as=0.1428p ps=1.52u w=0.42u l=0.13u
M1539 vss SAR/sg13cmos5l_buf_1_10.A SAR/sg13cmos5l_inv_1_28.Y vss sg13_lv_nmos ad=0.2516p pd=2.16u as=0.2516p ps=2.16u w=0.74u l=0.13u
M1540 SAR/sg13cmos5l_dlhr_1_11.Q SAR/a_13161_7281# vdd vdd sg13_lv_pmos ad=0.3808p pd=2.92u as=0.2128p ps=1.5u w=1.12u l=0.13u
M1541 vss SAR/a_1196_8400# SAR/sg13cmos5l_buf_1_63.X vss sg13_lv_nmos ad=0.14875p pd=1.16u as=0.2886p ps=2.26u w=0.74u l=0.13u
M1542 SAR/a_2224_5654# SAR/sg13cmos5l_dfrbp_1_6.RESET_B vdd vdd sg13_lv_pmos ad=79.8f pd=0.8u as=1.28962p ps=8.195u w=0.42u l=0.13u
M1543 SAR/sg13cmos5l_nand2_1_2.B SAR/sg13cmos5l_nor2_1_2.A vss vss sg13_lv_nmos ad=0.1406p pd=1.12u as=0.2516p ps=2.16u w=0.74u l=0.13u
M1544 vdd SAR/sg13cmos5l_inv_1_0.Y SAR/a_11182_4948# vdd sg13_lv_pmos ad=0.3808p pd=2.92u as=0.2128p ps=1.5u w=1.12u l=0.13u
M1545 SAR/a_10406_9624# SAR/a_10010_9196# SAR/a_10292_9508# vdd sg13_lv_pmos ad=0.1008p pd=0.9u as=0.191p ps=1.44u w=0.42u l=0.13u
M1546 SAR/sg13cmos5l_dfrbp_1_22.D SAR/a_16724_8436# vss vss sg13_lv_nmos ad=0.2516p pd=2.16u as=0.1406p ps=1.12u w=0.74u l=0.13u
M1547 SAR/sg13cmos5l_dlhr_1_12.D SAR/a_16271_7751# vss vss sg13_lv_nmos ad=0.2849p pd=2.25u as=0.2516p ps=2.16u w=0.74u l=0.13u
M1548 SAR/a_2314_3361# SAR/a_2757_3117# SAR/a_2054_3138# vss sg13_lv_nmos ad=79.8f pd=0.8u as=0.1296p ps=1.52u w=0.42u l=0.13u
M1549 vdd SAR/sg13cmos5l_dfrbp_1_8.RESET_B SAR/a_3562_4873# vdd sg13_lv_pmos ad=0.1563p pd=1.22u as=0.147p ps=1.54u w=0.42u l=0.13u
M1550 vdd SAR/a_15045_8447# SAR/a_15147_8447# vdd sg13_lv_pmos ad=1.15047p pd=7.175u as=0.3864p ps=2.93u w=1.12u l=0.13u
M1551 vdd SAR/a_4005_4629# SAR/a_4107_4772# vdd sg13_lv_pmos ad=1.28962p pd=8.195u as=0.3864p ps=2.93u w=1.12u l=0.13u
M1552 SAR/a_16356_7349# SAR/a_16068_6928# SAR/a_16294_7349# vss sg13_lv_nmos ad=0.1428p pd=1.52u as=37.8f ps=0.6u w=0.42u l=0.13u
M1553 SAR/sg13cmos5l_dfrbp_1_23.Q_N SAR/a_13775_6239# vdd vdd sg13_lv_pmos ad=0.4312p pd=3.01u as=0.2639p ps=1.81u w=1.12u l=0.13u
M1554 SAR/a_12933_6141# SAR/sg13cmos5l_dfrbp_1_23.CLK vdd vdd sg13_lv_pmos ad=0.4088p pd=2.97u as=1.04815p ps=6.595u w=1.12u l=0.13u
M1555 SAR/a_7216_6382# SAR/a_6959_6239# SAR/a_7378_6162# vss sg13_lv_nmos ad=0.1428p pd=1.52u as=37.8f ps=0.6u w=0.42u l=0.13u
M1556 vdd SAR/a_2748_6126# SAR/a_3771_6553# vdd sg13_lv_pmos ad=0.1563p pd=1.22u as=63f ps=0.72u w=0.42u l=0.13u
M1557 SAR/a_5796_3904# SAR/a_5770_3868# vss vss sg13_lv_nmos ad=0.2516p pd=2.16u as=0.1626p ps=1.415u w=0.74u l=0.13u
M1558 SAR/a_5926_6175# SAR/sg13cmos5l_dfrbp_1_6.RESET_B vss vss sg13_lv_nmos ad=37.8f pd=0.6u as=0.1701p ps=1.65u w=0.42u l=0.13u
M1559 SAR/a_5220_2392# SAR/a_5194_2356# vss vss sg13_lv_nmos ad=0.2516p pd=2.16u as=0.1626p ps=1.415u w=0.74u l=0.13u
M1560 SAR/a_13072_4142# SAR/sg13cmos5l_dfrbp_1_0.RESET_B vdd vdd sg13_lv_pmos ad=79.8f pd=0.8u as=1.38655p ps=8.8u w=0.42u l=0.13u
M1561 SAR/a_12216_5728# SAR/sg13cmos5l_dfrbp_1_21.Q vss vss sg13_lv_nmos ad=0.1045p pd=0.93u as=0.1469p ps=1.155u w=0.55u l=0.13u
M1562 vss SAR/a_17829_1605# SAR/a_17931_1748# vss sg13_lv_nmos ad=7.01497p pd=46.005u as=0.2516p ps=2.16u w=0.74u l=0.13u
M1563 vss SAR/a_13072_1846# SAR/a_12721_1703# vss sg13_lv_nmos ad=79.8f pd=0.8u as=0.1428p ps=1.52u w=0.42u l=0.13u
M1564 vss SAR/a_18860_9150# ph_sw[8] vss sg13_lv_nmos ad=0.14875p pd=1.16u as=0.2886p ps=2.26u w=0.74u l=0.13u
M1565 SAR/sg13cmos5l_buf_1_95.X SAR/a_12232_8436# vss vss sg13_lv_nmos ad=0.2886p pd=2.26u as=0.14875p ps=1.16u w=0.74u l=0.13u
M1566 vdd SAR/sg13cmos5l_buf_1_40.A SAR/a_1192_1664# vdd sg13_lv_pmos ad=0.2114p pd=1.54u as=0.2856p ps=2.36u w=0.84u l=0.13u
M1567 vdd SAR/a_17584_7166# SAR/a_17529_7047# vdd sg13_lv_pmos ad=1.07253p pd=6.75u as=93.45f ps=0.865u w=0.42u l=0.13u
M1568 vdd SAR/a_3212_1590# SAR/sg13cmos5l_buf_1_41.X vdd sg13_lv_pmos ad=0.2114p pd=1.54u as=0.42p ps=2.99u w=1.12u l=0.13u
M1569 SAR/a_14822_6924# SAR/a_14426_7288# SAR/a_14708_6924# vdd sg13_lv_pmos ad=0.1008p pd=0.9u as=0.191p ps=1.44u w=0.42u l=0.13u
M1570 SAR/sg13cmos5l_buf_1_4.A SAR/a_15592_6200# vdd vdd sg13_lv_pmos ad=0.42p pd=2.99u as=0.2114p ps=1.54u w=1.12u l=0.13u
M1571 vdd SAR/a_7247_8797# SAR/a_8084_8436# vdd sg13_lv_pmos ad=0.2128p pd=1.5u as=0.3864p ps=2.93u w=1.12u l=0.13u
M1572 SAR/a_9660_4686# SAR/a_9111_4666# SAR/a_9524_4972# vss sg13_lv_nmos ad=47.25f pd=0.645u as=0.141p ps=1.17u w=0.42u l=0.13u
M1573 SAR/a_6213_3911# SAR/sg13cmos5l_dfrbp_1_11.Q vdd vdd sg13_lv_pmos ad=0.4088p pd=2.97u as=1.43437p ps=9.105u w=1.12u l=0.13u
M1574 vdd vss vdd vdd sg13_lv_pmos ad=0.34p pd=2.68u as=0 ps=0 w=1u l=1u
M1575 SAR/a_17399_3947# SAR/sg13cmos5l_dfrbp_1_6.D SAR/a_18146_4338# vss sg13_lv_nmos ad=0.1428p pd=1.52u as=60.89999f ps=0.71u w=0.42u l=0.13u
M1576 SAR/a_17674_3361# SAR/a_18117_3117# SAR/a_17414_3138# vss sg13_lv_nmos ad=79.8f pd=0.8u as=0.1296p ps=1.52u w=0.42u l=0.13u
M1577 SAR/sg13cmos5l_dfrbp_1_14.Q_N SAR/a_4847_4727# vdd vdd sg13_lv_pmos ad=0.4312p pd=3.01u as=0.2639p ps=1.81u w=1.12u l=0.13u
M1578 SAR/sg13cmos5l_buf_1_87.A SAR/a_18376_9224# vss vss sg13_lv_nmos ad=0.2886p pd=2.26u as=0.14875p ps=1.16u w=0.74u l=0.13u
M1579 vdd SAR/sg13cmos5l_nand2_1_1.A SAR/a_20008_3900# vdd sg13_lv_pmos ad=0.2114p pd=1.54u as=0.2856p ps=2.36u w=0.84u l=0.13u
M1580 SAR/a_7622_2064# SAR/a_7226_1636# SAR/a_7508_1948# vdd sg13_lv_pmos ad=0.1008p pd=0.9u as=0.191p ps=1.44u w=0.42u l=0.13u
M1581 SAR/a_12420_9199# SAR/a_12651_9308# SAR/a_12106_9409# vss sg13_lv_nmos ad=0.2373p pd=1.97u as=79.8f ps=0.8u w=0.42u l=0.13u
M1582 vdd SAR/sg13cmos5l_inv_1_5.A SAR/sg13cmos5l_a22oi_1_1.A1 vdd sg13_lv_pmos ad=0.3808p pd=2.92u as=0.3808p ps=2.92u w=1.12u l=0.13u
M1583 vss SAR/sg13cmos5l_a22oi_1_0.Y SAR/sg13cmos5l_dfrbp_1_2.D vss sg13_lv_nmos ad=0.2516p pd=2.16u as=0.2516p ps=2.16u w=0.74u l=0.13u
M1584 SAR/a_10433_1652# SAR/sg13cmos5l_dlhr_1_0.D SAR/sg13cmos5l_a22oi_1_2.B1 vss sg13_lv_nmos ad=0.1406p pd=1.12u as=0.1406p ps=1.12u w=0.74u l=0.13u
M1585 SAR/a_3308_5376# SAR/sg13cmos5l_dlhr_1_1.Q vdd vdd sg13_lv_pmos ad=0.2856p pd=2.36u as=0.2114p ps=1.54u w=0.84u l=0.13u
M1586 ph_sw[4] SAR/a_6568_9224# vdd vdd sg13_lv_pmos ad=0.42p pd=2.99u as=0.2114p ps=1.54u w=1.12u l=0.13u
M1587 vss _cks SAR/sg13cmos5l_dfrbp_1_6.RESET_B vss sg13_lv_nmos ad=0.1406p pd=1.12u as=0.1406p ps=1.12u w=0.74u l=0.13u
M1588 SAR/a_12106_9409# SAR/a_12549_9165# SAR/a_12489_9577# vdd sg13_lv_pmos ad=79.8f pd=0.8u as=63f ps=0.72u w=0.42u l=0.13u
M1589 SAR/a_12719_2749# SAR/a_11877_2399# SAR/a_12625_2749# vss sg13_lv_nmos ad=0.12665p pd=1.145u as=0.1428p ps=1.52u w=0.42u l=0.13u
M1590 SAR/a_15780_2813# SAR/a_15492_2392# SAR/a_15718_2813# vss sg13_lv_nmos ad=0.1428p pd=1.52u as=37.8f ps=0.6u w=0.42u l=0.13u
M1591 SAR/a_2224_7166# SAR/a_1967_7285# SAR/a_2386_7362# vss sg13_lv_nmos ad=0.1428p pd=1.52u as=37.8f ps=0.6u w=0.42u l=0.13u
M1592 SAR/a_14708_6924# SAR/a_14426_7288# SAR/a_14641_7326# vss sg13_lv_nmos ad=0.141p pd=1.17u as=71.99999f ps=0.865u w=0.64u l=0.13u
M1593 SAR/a_9879_9202# SAR/sg13cmos5l_dfrbp_1_18.Q vdd vdd sg13_lv_pmos ad=0.3234p pd=2.45u as=4.11675p ps=27.17u w=0.84u l=0.13u
M1594 vss SAR/sg13cmos5l_dfrbp_1_6.RESET_B SAR/a_12324_6162# vss sg13_lv_nmos ad=0.1626p pd=1.415u as=60.89999f ps=0.71u w=0.42u l=0.13u
M1595 vdd SAR/a_13641_7674# SAR/a_14166_7656# vdd sg13_lv_pmos ad=0.1974p pd=1.5u as=0.2856p ps=2.36u w=0.84u l=0.13u
M1596 vdd SAR/sg13cmos5l_inv_1_1.A SAR/sg13cmos5l_buf_1_2.A vdd sg13_lv_pmos ad=0.3808p pd=2.92u as=0.3808p ps=2.92u w=1.12u l=0.13u
M1597 vdd SAR/sg13cmos5l_dfrbp_1_1.Q SAR/a_20392_2388# vdd sg13_lv_pmos ad=0.2114p pd=1.54u as=0.2856p ps=2.36u w=0.84u l=0.13u
M1598 SAR/sg13cmos5l_dfrbp_1_0.D SAR/sg13cmos5l_dfrbp_1_0.Q SAR/a_18122_2388# vdd sg13_lv_pmos ad=0.3808p pd=2.92u as=0.1176p ps=1.33u w=1.12u l=0.13u
M1599 vss SAR/sg13cmos5l_inv_1_0.A SAR/sg13cmos5l_nor2b_1_0.Y vss sg13_lv_nmos ad=0.2516p pd=2.16u as=0.1406p ps=1.12u w=0.74u l=0.13u
M1600 vdd SAR/a_17829_1605# SAR/a_17931_1748# vdd sg13_lv_pmos ad=1.86162p pd=11.935u as=0.3864p ps=2.93u w=1.12u l=0.13u
M1601 vdd SAR/a_4425_7281# SAR/a_4950_7354# vdd sg13_lv_pmos ad=0.1974p pd=1.5u as=0.2856p ps=2.36u w=0.84u l=0.13u
M1602 SAR/a_14745_3453# SAR/a_13803_3260# SAR/a_14543_3215# vdd sg13_lv_pmos ad=93.45f pd=0.865u as=0.2048p ps=1.63u w=0.42u l=0.13u
M1603 SAR/sg13cmos5l_inv_1_26.Y SAR/sg13cmos5l_buf_1_19.A vss vss sg13_lv_nmos ad=0.2516p pd=2.16u as=0.2516p ps=2.16u w=0.74u l=0.13u
M1604 vss vdd vss vss sg13_lv_nmos ad=0.1428p pd=1.52u as=0 ps=0 w=0.42u l=1u
M1605 SAR/sg13cmos5l_dlhr_1_10.Q SAR/a_19593_6162# vdd vdd sg13_lv_pmos ad=0.3808p pd=2.92u as=0.2128p ps=1.5u w=1.12u l=0.13u
M1606 SAR/a_11372_3102# SAR/sg13cmos5l_buf_1_9.A vss vss sg13_lv_nmos ad=0.187p pd=1.78u as=0.14875p ps=1.16u w=0.55u l=0.13u
M1607 vdd SAR/sg13cmos5l_dfrbp_1_8.RESET_B SAR/a_11846_9186# vdd sg13_lv_pmos ad=0.36237p pd=2.605u as=79.8f ps=0.8u w=0.42u l=0.13u
M1608 SAR/a_16572_4261# SAR/a_16703_3871# SAR/a_15821_3864# vdd sg13_lv_pmos ad=0.34p pd=2.68u as=0.2048p ps=1.63u w=1u l=0.13u
M1609 vdd SAR/sg13cmos5l_dfrbp_1_23.Q SAR/a_14089_7282# vdd sg13_lv_pmos ad=1.07253p pd=6.75u as=0.2856p ps=2.36u w=0.84u l=0.13u
M1610 vss SAR/a_16268_3102# nl_sw[8] vss sg13_lv_nmos ad=0.14875p pd=1.16u as=0.2886p ps=2.26u w=0.74u l=0.13u
M1611 vdd SAR/sg13cmos5l_dfrbp_1_6.RESET_B SAR/a_4934_2826# vdd sg13_lv_pmos ad=0.36237p pd=2.605u as=79.8f ps=0.8u w=0.42u l=0.13u
M1612 SAR/a_11270_4338# SAR/sg13cmos5l_dfrbp_1_2.D vdd vdd sg13_lv_pmos ad=79.8f pd=0.8u as=0.1428p ps=1.52u w=0.42u l=0.13u
M1613 SAR/a_13393_7666# SAR/a_12841_7728# vss vss sg13_lv_nmos ad=71.99999f pd=0.865u as=1.49685p ps=9.6u w=0.64u l=0.13u
M1614 vdd SAR/sg13cmos5l_buf_1_10.A SAR/sg13cmos5l_inv_1_28.Y vdd sg13_lv_pmos ad=0.3808p pd=2.92u as=0.3808p ps=2.92u w=1.12u l=0.13u
M1615 vss SAR/sg13cmos5l_dfrbp_1_1.Q SAR/sg13cmos5l_inv_1_11.Y vss sg13_lv_nmos ad=0.2516p pd=2.16u as=0.2516p ps=2.16u w=0.74u l=0.13u
M1616 SAR/a_12567_7282# SAR/sg13cmos5l_dlhr_1_11.GATE vss vss sg13_lv_nmos ad=0.2516p pd=2.16u as=0.15055p ps=1.17u w=0.74u l=0.13u
M1617 SAR/sg13cmos5l_buf_8_0.X SAR/a_19227_4654# vss vss sg13_lv_nmos ad=0.1406p pd=1.12u as=0.1406p ps=1.12u w=0.74u l=0.13u
M1618 vdd SAR/a_3676_7964# SAR/sg13cmos5l_dlhr_1_9.Q vdd sg13_lv_pmos ad=0.2128p pd=1.5u as=0.3808p ps=2.92u w=1.12u l=0.13u
M1619 SAR/sg13cmos5l_dfrbp_1_10.Q_N SAR/a_3599_3215# vdd vdd sg13_lv_pmos ad=0.4312p pd=3.01u as=0.2639p ps=1.81u w=1.12u l=0.13u
M1620 vdd SAR/a_6903_3154# SAR/a_7034_3148# vdd sg13_lv_pmos ad=1.43437p pd=9.105u as=0.2856p ps=2.36u w=0.84u l=0.13u
M1621 vdd SAR/sg13cmos5l_and3_1_0.C SAR/a_13324_4696# vdd sg13_lv_pmos ad=0.36195p pd=1.84u as=0.1596p ps=1.22u w=0.84u l=0.13u
M1622 nh_sw[2] SAR/a_3688_1664# vdd vdd sg13_lv_pmos ad=0.42p pd=2.99u as=0.2114p ps=1.54u w=1.12u l=0.13u
M1623 SAR/a_5324_1590# SAR/sg13cmos5l_buf_1_34.X vdd vdd sg13_lv_pmos ad=0.2856p pd=2.36u as=0.2114p ps=1.54u w=0.84u l=0.13u
M1624 SAR/a_13641_3529# SAR/a_13284_3456# vdd vdd sg13_lv_pmos ad=63f pd=0.72u as=0.1563p ps=1.22u w=0.42u l=0.13u
M1625 vdd SAR/a_15177_5769# SAR/a_15110_5412# vdd sg13_lv_pmos ad=0.2387p pd=1.84u as=0.1008p ps=0.9u w=0.42u l=0.13u
M1626 SAR/a_10596_7687# SAR/a_10308_7992# SAR/a_10534_7687# vss sg13_lv_nmos ad=0.1428p pd=1.52u as=37.8f ps=0.6u w=0.42u l=0.13u
M1627 SAR/sg13cmos5l_dlhr_1_11.Q SAR/a_13161_7281# vss vss sg13_lv_nmos ad=0.2516p pd=2.16u as=0.1406p ps=1.12u w=0.74u l=0.13u
M1628 vss SAR/a_1125_5423# SAR/a_1227_5423# vss sg13_lv_nmos ad=1.97045p pd=12.335u as=0.2516p ps=2.16u w=0.74u l=0.13u
M1629 vdd SAR/sg13cmos5l_buf_1_97.A SAR/a_11848_8436# vdd sg13_lv_pmos ad=0.2114p pd=1.54u as=0.2856p ps=2.36u w=0.84u l=0.13u
M1630 SAR/sg13cmos5l_dfrbp_1_23.Q SAR/a_14612_6460# vdd vdd sg13_lv_pmos ad=0.3808p pd=2.92u as=0.2128p ps=1.5u w=1.12u l=0.13u
M1631 vdd SAR/sg13cmos5l_dfrbp_1_6.RESET_B SAR/a_2409_4650# vdd sg13_lv_pmos ad=0.2128p pd=1.5u as=0.2128p ps=1.5u w=1.12u l=0.13u
M1632 SAR/sg13cmos5l_dfrbp_1_0.Q_N SAR/a_18671_1703# vdd vdd sg13_lv_pmos ad=0.4312p pd=3.01u as=0.2639p ps=1.81u w=1.12u l=0.13u
M1633 SAR/a_2786_7666# SAR/a_2596_7996# SAR/a_2348_7624# vss sg13_lv_nmos ad=71.99999f pd=0.865u as=0.141p ps=1.17u w=0.64u l=0.13u
M1634 SAR/sg13cmos5l_dfrbp_1_24.Q_N SAR/a_13391_9263# vdd vdd sg13_lv_pmos ad=0.4312p pd=3.01u as=0.2639p ps=1.81u w=1.12u l=0.13u
M1635 SAR/a_5069_5376# SAR/a_5799_5499# SAR/a_5820_5773# vss sg13_lv_nmos ad=0.12665p pd=1.145u as=0.3473p ps=2.71u w=0.74u l=0.13u
M1636 SAR/a_9202_7674# SAR/sg13cmos5l_dfrbp_1_6.RESET_B vss vss sg13_lv_nmos ad=37.8f pd=0.6u as=79.8f ps=0.8u w=0.42u l=0.13u
M1637 vdd SAR/a_11567_7751# SAR/a_12404_7972# vdd sg13_lv_pmos ad=0.2128p pd=1.5u as=0.3864p ps=2.93u w=1.12u l=0.13u
M1638 SAR/a_13792_5760# SAR/sg13cmos5l_or2_1_1.B SAR/sg13cmos5l_a22oi_1_1.B2 vss sg13_lv_nmos ad=0.1406p pd=1.12u as=0.2516p ps=2.16u w=0.74u l=0.13u
M1639 vss SAR/a_620_7638# pl_sw[0] vss sg13_lv_nmos ad=0.14875p pd=1.16u as=0.2886p ps=2.26u w=0.74u l=0.13u
M1640 SAR/a_8972_3864# SAR/sg13cmos5l_buf_1_45.A vdd vdd sg13_lv_pmos ad=0.2856p pd=2.36u as=0.2114p ps=1.54u w=0.84u l=0.13u
M1641 vss SAR/sg13cmos5l_inv_1_5.A SAR/sg13cmos5l_a22oi_1_1.A1 vss sg13_lv_nmos ad=0.2516p pd=2.16u as=0.2516p ps=2.16u w=0.74u l=0.13u
M1642 vdd SAR/sg13cmos5l_dlhr_1_10.Q SAR/a_19528_6924# vdd sg13_lv_pmos ad=0.2114p pd=1.54u as=0.2856p ps=2.36u w=0.84u l=0.13u
M1643 SAR/sg13cmos5l_a22oi_1_1.Y SAR/sg13cmos5l_a22oi_1_1.A1 SAR/a_14814_4292# vss sg13_lv_nmos ad=0.2664p pd=1.46u as=96.2f ps=1u w=0.74u l=0.13u
M1644 SAR/sg13cmos5l_or2_1_0.A SAR/a_18363_4270# vdd vdd sg13_lv_pmos ad=0.2128p pd=1.5u as=0.2128p ps=1.5u w=1.12u l=0.13u
M1645 vdd SAR/a_19227_4654# SAR/sg13cmos5l_buf_8_0.X vdd sg13_lv_pmos ad=0.2128p pd=1.5u as=0.2128p ps=1.5u w=1.12u l=0.13u
M1646 SAR/a_13072_1846# SAR/sg13cmos5l_dfrbp_1_0.RESET_B vdd vdd sg13_lv_pmos ad=79.8f pd=0.8u as=1.777p ps=11.395u w=0.42u l=0.13u
M1647 SAR/sg13cmos5l_dlhr_1_0.GATE SAR/a_5684_4948# vdd vdd sg13_lv_pmos ad=0.3808p pd=2.92u as=0.2128p ps=1.5u w=1.12u l=0.13u
M1648 SAR/a_15429_7653# SAR/sg13cmos5l_dfrbp_1_22.D vss vss sg13_lv_nmos ad=0.2516p pd=2.16u as=1.49685p ps=9.6u w=0.74u l=0.13u
M1649 SAR/sg13cmos5l_dfrbp_1_4.D SAR/a_10464_2427# SAR/a_10613_2758# vss sg13_lv_nmos ad=0.2516p pd=2.16u as=0.1406p ps=1.12u w=0.74u l=0.13u
M1650 SAR/a_10031_8797# SAR/a_9189_8447# SAR/a_8772_8440# vdd sg13_lv_pmos ad=0.2048p pd=1.63u as=0.34p ps=2.68u w=1u l=0.13u
M1651 vdd SAR/sg13cmos5l_buf_8_1.A SAR/a_18363_4270# vdd sg13_lv_pmos ad=0.2128p pd=1.5u as=0.2128p ps=1.5u w=1.12u l=0.13u
M1652 SAR/a_5796_3904# SAR/a_6315_3911# SAR/a_7055_4261# vss sg13_lv_nmos ad=0.3473p pd=2.71u as=0.12665p ps=1.145u w=0.74u l=0.13u
M1653 SAR/a_11488_4676# SAR/sg13cmos5l_a221oi_1_0.B1 SAR/sg13cmos5l_o21ai_1_0.A1 vss sg13_lv_nmos ad=0.1406p pd=1.12u as=0.2516p ps=2.16u w=0.74u l=0.13u
M1654 vss SAR/a_1997_6126# SAR/sg13cmos5l_dfrbp_1_15.Q_N vss sg13_lv_nmos ad=0.2516p pd=2.16u as=0.2849p ps=2.25u w=0.74u l=0.13u
M1655 vss SAR/a_7820_2352# SAR/sg13cmos5l_inv_1_14.A vss sg13_lv_nmos ad=0.14875p pd=1.16u as=0.2886p ps=2.26u w=0.74u l=0.13u
M1656 vdd SAR/a_6741_5459# SAR/a_5820_5773# vdd sg13_lv_pmos ad=0.36237p pd=2.605u as=0.34p ps=2.68u w=1u l=0.13u
M1657 vdd SAR/sg13cmos5l_buf_1_68.X SAR/a_616_9224# vdd sg13_lv_pmos ad=0.2114p pd=1.54u as=0.2856p ps=2.36u w=0.84u l=0.13u
M1658 vss SAR/a_16144_8678# SAR/a_15793_8797# vss sg13_lv_nmos ad=79.8f pd=0.8u as=0.1428p ps=1.52u w=0.42u l=0.13u
M1659 SAR/a_10308_7992# SAR/a_10282_7897# vdd vdd sg13_lv_pmos ad=0.34p pd=2.68u as=0.36237p ps=2.605u w=1u l=0.13u
M1660 vss SAR/sg13cmos5l_buf_1_25.X SAR/a_4456_1664# vss sg13_lv_nmos ad=0.14875p pd=1.16u as=0.187p ps=1.78u w=0.55u l=0.13u
M1661 SAR/a_15590_4650# SAR/sg13cmos5l_dfrbp_1_8.D vdd vdd sg13_lv_pmos ad=79.8f pd=0.8u as=0.1428p ps=1.52u w=0.42u l=0.13u
M1662 vdd SAR/a_6789_4629# SAR/a_6891_4772# vdd sg13_lv_pmos ad=1.28962p pd=8.195u as=0.3864p ps=2.93u w=1.12u l=0.13u
M1663 SAR/a_7504_8678# SAR/sg13cmos5l_dfrbp_1_8.RESET_B vdd vdd sg13_lv_pmos ad=79.8f pd=0.8u as=1.12242p ps=7u w=0.42u l=0.13u
M1664 SAR/a_650_3900# SAR/sg13cmos5l_nor2_1_2.A vdd vdd sg13_lv_pmos ad=0.1176p pd=1.33u as=0.4032p ps=2.96u w=1.12u l=0.13u
M1665 vss SAR/a_10665_7281# SAR/a_11190_7354# vss sg13_lv_nmos ad=0.1491p pd=1.18u as=0.187p ps=1.78u w=0.55u l=0.13u
M1666 SAR/a_11824_7894# SAR/sg13cmos5l_dfrbp_1_6.RESET_B vdd vdd sg13_lv_pmos ad=79.8f pd=0.8u as=1.12242p ps=7u w=0.42u l=0.13u
M1667 vdd SAR/sg13cmos5l_buf_1_110.A SAR/a_15784_9224# vdd sg13_lv_pmos ad=0.2114p pd=1.54u as=0.2856p ps=2.36u w=0.84u l=0.13u
M1668 SAR/a_11182_4676# SAR/sg13cmos5l_a221oi_1_0.A2 vss vss sg13_lv_nmos ad=0.1406p pd=1.12u as=0.2516p ps=2.16u w=0.74u l=0.13u
M1669 vss SAR/a_19209_5769# SAR/a_19734_5842# vss sg13_lv_nmos ad=0.1491p pd=1.18u as=0.187p ps=1.78u w=0.55u l=0.13u
M1670 SAR/sg13cmos5l_buf_1_107.X SAR/a_17896_9224# vdd vdd sg13_lv_pmos ad=0.42p pd=2.99u as=0.2114p ps=1.54u w=1.12u l=0.13u
M1671 vss SAR/a_8972_9150# SAR/sg13cmos5l_buf_1_77.X vss sg13_lv_nmos ad=0.14875p pd=1.16u as=0.2886p ps=2.26u w=0.74u l=0.13u
M1672 vdd SAR/sg13cmos5l_buf_1_7.A SAR/a_14056_1664# vdd sg13_lv_pmos ad=0.2114p pd=1.54u as=0.2856p ps=2.36u w=0.84u l=0.13u
M1673 vss SAR/a_11824_7894# SAR/a_11473_7751# vss sg13_lv_nmos ad=79.8f pd=0.8u as=0.1428p ps=1.52u w=0.42u l=0.13u
M1674 vss SAR/sg13cmos5l_dlhr_1_15.D SAR/a_17545_7728# vss sg13_lv_nmos ad=0.15055p pd=1.17u as=0.187p ps=1.78u w=0.55u l=0.13u
M1675 vss SAR/sg13cmos5l_dfrbp_1_6.RESET_B SAR/a_16298_4338# vss sg13_lv_nmos ad=79.8f pd=0.8u as=37.8f ps=0.6u w=0.42u l=0.13u
M1676 vdd SAR/sg13cmos5l_or2_1_1.B SAR/a_10420_5412# vdd sg13_lv_pmos ad=0.3808p pd=2.92u as=0.2128p ps=1.5u w=1.12u l=0.13u
M1677 SAR/sg13cmos5l_buf_8_0.X SAR/a_19227_4654# vss vss sg13_lv_nmos ad=0.1406p pd=1.12u as=0.1406p ps=1.12u w=0.74u l=0.13u
M1678 vss SAR/a_19227_9190# SAR/sg13cmos5l_buf_8_2.X vss sg13_lv_nmos ad=0.1406p pd=1.12u as=0.1406p ps=1.12u w=0.74u l=0.13u
M1679 vss SAR/a_17367_8794# SAR/a_17498_8800# vss sg13_lv_nmos ad=2.92392p pd=18.89u as=0.2775p ps=2.23u w=0.74u l=0.13u
M1680 vss SAR/a_10412_6126# SAR/sg13cmos5l_buf_1_29.A vss sg13_lv_nmos ad=0.14875p pd=1.16u as=0.2886p ps=2.26u w=0.74u l=0.13u
M1681 SAR/a_4950_5699# SAR/a_5069_5376# vdd vdd sg13_lv_pmos ad=0.3864p pd=2.93u as=0.2128p ps=1.5u w=1.12u l=0.13u
M1682 SAR/a_7216_6382# SAR/sg13cmos5l_dfrbp_1_6.RESET_B vdd vdd sg13_lv_pmos ad=79.8f pd=0.8u as=1.04815p ps=6.595u w=0.42u l=0.13u
M1683 vdd SAR/a_16528_7894# SAR/a_16473_7989# vdd sg13_lv_pmos ad=1.15047p pd=7.175u as=93.45f ps=0.865u w=0.42u l=0.13u
M1684 vdd vss vdd vdd sg13_lv_pmos ad=0.19p pd=1.38u as=0 ps=0 w=1u l=1u
M1685 SAR/a_11268_5760# SAR/sg13cmos5l_dlhr_1_15.D vss vss sg13_lv_nmos ad=0.1216p pd=1.02u as=0.1371p ps=1.12u w=0.64u l=0.13u
M1686 SAR/sg13cmos5l_inv_1_2.A SAR/a_8488_9224# vss vss sg13_lv_nmos ad=0.2886p pd=2.26u as=0.14875p ps=1.16u w=0.74u l=0.13u
M1687 SAR/a_7312_4142# SAR/sg13cmos5l_dfrbp_1_6.RESET_B vdd vdd sg13_lv_pmos ad=79.8f pd=0.8u as=1.38655p ps=8.8u w=0.42u l=0.13u
M1688 SAR/sg13cmos5l_o21ai_1_0.Y SAR/sg13cmos5l_o21ai_1_0.A2 SAR/a_12120_3456# vdd sg13_lv_pmos ad=0.2128p pd=1.5u as=0.2128p ps=1.5u w=1.12u l=0.15u
M1689 SAR/sg13cmos5l_buf_8_1.A SAR/a_17972_4948# vss vss sg13_lv_nmos ad=0.2516p pd=2.16u as=0.1406p ps=1.12u w=0.74u l=0.13u
M1690 SAR/sg13cmos5l_inv_1_26.Y SAR/sg13cmos5l_buf_1_19.A vdd vdd sg13_lv_pmos ad=0.3808p pd=2.92u as=0.3808p ps=2.92u w=1.12u l=0.13u
M1691 SAR/a_6479_2749# SAR/a_5637_2399# SAR/a_5220_2392# vdd sg13_lv_pmos ad=0.2048p pd=1.63u as=0.34p ps=2.68u w=1u l=0.13u
M1692 SAR/sg13cmos5l_buf_8_0.A SAR/a_18480_5028# vss vss sg13_lv_nmos ad=0.2516p pd=2.16u as=0.1469p ps=1.155u w=0.74u l=0.13u
M1693 vss SAR/sg13cmos5l_nor2_1_0.A SAR/sg13cmos5l_a221oi_1_0.C1 vss sg13_lv_nmos ad=0.2516p pd=2.16u as=0.1406p ps=1.12u w=0.74u l=0.13u
M1694 vss SAR/a_17008_2630# SAR/a_16657_2749# vss sg13_lv_nmos ad=79.8f pd=0.8u as=0.1428p ps=1.52u w=0.42u l=0.13u
M1695 SAR/sg13cmos5l_buf_1_8.X SAR/a_10888_1664# vdd vdd sg13_lv_pmos ad=0.42p pd=2.99u as=0.2114p ps=1.54u w=1.12u l=0.13u
M1696 SAR/a_11844_4325# SAR/a_12075_3911# SAR/a_11530_3868# vss sg13_lv_nmos ad=0.2373p pd=1.97u as=79.8f ps=0.8u w=0.42u l=0.13u
M1697 SAR/a_5510_4338# SAR/a_6315_3911# SAR/a_5770_3868# vdd sg13_lv_pmos ad=0.1428p pd=1.52u as=79.8f ps=0.8u w=0.42u l=0.13u
M1698 SAR/a_10708_9172# SAR/a_10292_9508# SAR/a_10473_9186# vss sg13_lv_nmos ad=77.7f pd=0.95u as=0.2516p ps=2.16u w=0.74u l=0.13u
M1699 SAR/a_2565_8447# SAR/sg13cmos5l_inv_1_8.A vss vss sg13_lv_nmos ad=0.2516p pd=2.16u as=2.71505p ps=17.54u w=0.74u l=0.13u
M1700 SAR/a_15012_7992# SAR/a_15531_7796# SAR/a_16271_7751# vss sg13_lv_nmos ad=0.3473p pd=2.71u as=0.12665p ps=1.145u w=0.74u l=0.13u
M1701 vdd SAR/sg13cmos5l_inv_1_8.A SAR/sg13cmos5l_inv_1_8.Y vdd sg13_lv_pmos ad=0.3808p pd=2.92u as=0.3808p ps=2.92u w=1.12u l=0.13u
M1702 vss SAR/a_9705_4650# SAR/a_10230_4632# vss sg13_lv_nmos ad=0.1491p pd=1.18u as=0.187p ps=1.78u w=0.55u l=0.13u
M1703 SAR/sg13cmos5l_buf_1_94.X SAR/a_15016_9224# vss vss sg13_lv_nmos ad=0.2886p pd=2.26u as=0.14875p ps=1.16u w=0.74u l=0.13u
M1704 vdd SAR/a_3692_9150# SAR/sg13cmos5l_buf_1_62.X vdd sg13_lv_pmos ad=0.2114p pd=1.54u as=0.42p ps=2.99u w=1.12u l=0.13u
M1705 vss SAR/a_6380_7638# pl_sw[3] vss sg13_lv_nmos ad=0.14875p pd=1.16u as=0.2886p ps=2.26u w=0.74u l=0.13u
M1706 SAR/a_19244_2352# SAR/sg13cmos5l_buf_1_18.X vss vss sg13_lv_nmos ad=0.187p pd=1.78u as=0.14875p ps=1.16u w=0.55u l=0.13u
M1707 SAR/a_15429_7653# SAR/sg13cmos5l_dfrbp_1_22.D vdd vdd sg13_lv_pmos ad=0.4088p pd=2.97u as=1.12242p ps=7u w=1.12u l=0.13u
M1708 vdd SAR/a_15887_8797# SAR/a_16144_8678# vdd sg13_lv_pmos ad=0.2639p pd=1.81u as=79.8f ps=0.8u w=0.42u l=0.13u
M1709 vdd SAR/sg13cmos5l_dfrbp_1_6.RESET_B SAR/a_7689_1626# vdd sg13_lv_pmos ad=0.2128p pd=1.5u as=0.2128p ps=1.5u w=1.12u l=0.13u
M1710 vdd SAR/sg13cmos5l_buf_1_8.A SAR/a_10888_1664# vdd sg13_lv_pmos ad=0.2114p pd=1.54u as=0.2856p ps=2.36u w=0.84u l=0.13u
M1711 SAR/a_10420_5412# SAR/sg13cmos5l_dfrbp_1_16.Q SAR/a_10318_5412# vdd sg13_lv_pmos ad=0.2128p pd=1.5u as=0.2128p ps=1.5u w=1.12u l=0.13u
M1712 SAR/a_1006_4167# SAR/a_1121_4166# vdd vdd sg13_lv_pmos ad=0.34p pd=2.68u as=0.2254p ps=1.53u w=1u l=0.5u
M1713 SAR/a_19227_4654# SAR/sg13cmos5l_buf_8_0.A vss vss sg13_lv_nmos ad=0.1406p pd=1.12u as=0.1406p ps=1.12u w=0.74u l=0.13u
M1714 vss SAR/a_18345_7674# SAR/a_18870_7656# vss sg13_lv_nmos ad=0.1491p pd=1.18u as=0.187p ps=1.78u w=0.55u l=0.13u
M1715 vss SAR/a_18959_3215# SAR/a_19796_3436# vss sg13_lv_nmos ad=0.1406p pd=1.12u as=0.2516p ps=2.16u w=0.74u l=0.13u
M1716 SAR/sg13cmos5l_dfrbp_1_8.Q_N SAR/a_17135_4727# vdd vdd sg13_lv_pmos ad=0.4312p pd=3.01u as=0.2639p ps=1.81u w=1.12u l=0.13u
M1717 vss SAR/a_18363_4270# SAR/sg13cmos5l_or2_1_0.A vss sg13_lv_nmos ad=0.1406p pd=1.12u as=0.1406p ps=1.12u w=0.74u l=0.13u
M1718 SAR/a_17386_1849# SAR/a_17829_1605# SAR/a_17769_2017# vdd sg13_lv_pmos ad=79.8f pd=0.8u as=63f ps=0.72u w=0.42u l=0.13u
M1719 vdd SAR/a_19227_4654# SAR/sg13cmos5l_buf_8_0.X vdd sg13_lv_pmos ad=0.2128p pd=1.5u as=0.2128p ps=1.5u w=1.12u l=0.13u
M1720 SAR/a_8247_5770# SAR/sg13cmos5l_dfrbp_1_11.Q vss vss sg13_lv_nmos ad=0.2516p pd=2.16u as=0.15055p ps=1.17u w=0.74u l=0.13u
M1721 SAR/sg13cmos5l_buf_8_2.X SAR/a_19227_9190# vdd vdd sg13_lv_pmos ad=0.2128p pd=1.5u as=0.2128p ps=1.5u w=1.12u l=0.13u
M1722 vdd SAR/sg13cmos5l_dfrbp_1_6.RESET_B SAR/a_682_6892# vdd sg13_lv_pmos ad=0.1563p pd=1.22u as=0.147p ps=1.54u w=0.42u l=0.13u
M1723 SAR/a_3793_2790# SAR/a_3241_2746# vss vss sg13_lv_nmos ad=71.99999f pd=0.865u as=2.59257p ps=16.445u w=0.64u l=0.13u
M1724 SAR/a_16356_7349# SAR/a_16587_6935# SAR/a_16042_6892# vss sg13_lv_nmos ad=0.2373p pd=1.97u as=79.8f ps=0.8u w=0.42u l=0.13u
M1725 vdd SAR/sg13cmos5l_dfrbp_1_11.Q SAR/a_6647_5459# vdd sg13_lv_pmos ad=0.1428p pd=1.52u as=79.8f ps=0.8u w=0.42u l=0.13u
M1726 SAR/sg13cmos5l_dfrbp_1_9.Q_N SAR/a_3407_4261# vdd vdd sg13_lv_pmos ad=0.4312p pd=3.01u as=0.2639p ps=1.81u w=1.12u l=0.13u
M1727 SAR/sg13cmos5l_buf_1_45.A SAR/a_8841_5769# vss vss sg13_lv_nmos ad=0.2516p pd=2.16u as=0.1406p ps=1.12u w=0.74u l=0.13u
M1728 SAR/a_4076_5376# SAR/sg13cmos5l_dlhr_1_9.Q vdd vdd sg13_lv_pmos ad=0.2856p pd=2.36u as=0.2114p ps=1.54u w=0.84u l=0.13u
M1729 vss SAR/a_2224_7166# SAR/a_1873_7285# vss sg13_lv_nmos ad=79.8f pd=0.8u as=0.1428p ps=1.52u w=0.42u l=0.13u
M1730 vdd vss vdd vdd sg13_lv_pmos ad=0.34p pd=2.68u as=0 ps=0 w=1u l=1u
M1731 SAR/a_5702_8874# SAR/sg13cmos5l_dlhr_1_5.GATE vdd vdd sg13_lv_pmos ad=79.8f pd=0.8u as=0.1428p ps=1.52u w=0.42u l=0.13u
M1732 SAR/a_3996_2790# SAR/a_3447_2746# SAR/a_3860_2388# vss sg13_lv_nmos ad=47.25f pd=0.645u as=0.141p ps=1.17u w=0.42u l=0.13u
M1733 SAR/a_9111_4666# SAR/sg13cmos5l_dfrbp_1_11.Q vdd vdd sg13_lv_pmos ad=0.3234p pd=2.45u as=1.2517p ps=7.955u w=0.84u l=0.13u
M1734 SAR/a_4660_7312# SAR/a_4244_6924# SAR/a_4425_7281# vss sg13_lv_nmos ad=77.7f pd=0.95u as=0.2516p ps=2.16u w=0.74u l=0.13u
M1735 SAR/sg13cmos5l_a221oi_1_0.B2 SAR/sg13cmos5l_nor2b_1_0.Y vss vss sg13_lv_nmos ad=0.1406p pd=1.12u as=0.2516p ps=2.16u w=0.74u l=0.13u
M1736 vss SAR/sg13cmos5l_dfrbp_1_0.RESET_B SAR/a_11364_4338# vss sg13_lv_nmos ad=0.1626p pd=1.415u as=60.89999f ps=0.71u w=0.42u l=0.13u
M1737 SAR/a_15466_2356# SAR/a_15909_2399# SAR/a_15849_2435# vdd sg13_lv_pmos ad=79.8f pd=0.8u as=63f ps=0.72u w=0.42u l=0.13u
M1738 SAR/a_7732_3124# SAR/a_7316_3460# SAR/a_7497_3138# vss sg13_lv_nmos ad=77.7f pd=0.95u as=0.2516p ps=2.16u w=0.74u l=0.13u
M1739 vss SAR/a_15177_5769# SAR/a_15702_5842# vss sg13_lv_nmos ad=0.1491p pd=1.18u as=0.187p ps=1.78u w=0.55u l=0.13u
M1740 SAR/a_10288_8678# SAR/a_10031_8797# SAR/a_10450_8874# vss sg13_lv_nmos ad=0.1428p pd=1.52u as=37.8f ps=0.6u w=0.42u l=0.13u
M1741 vss SAR/a_19227_9190# SAR/sg13cmos5l_buf_8_2.X vss sg13_lv_nmos ad=0.1406p pd=1.12u as=0.1406p ps=1.12u w=0.74u l=0.13u
M1742 SAR/a_13138_2826# SAR/sg13cmos5l_dfrbp_1_0.RESET_B vss vss sg13_lv_nmos ad=37.8f pd=0.6u as=79.8f ps=0.8u w=0.42u l=0.13u
M1743 vdd SAR/a_2565_3911# SAR/a_2667_3911# vdd sg13_lv_pmos ad=1.43437p pd=9.105u as=0.3864p ps=2.93u w=1.12u l=0.13u
M1744 SAR/a_12549_9165# SAR/sg13cmos5l_inv_1_2.A vss vss sg13_lv_nmos ad=0.2516p pd=2.16u as=2.71505p ps=17.54u w=0.74u l=0.13u
M1745 vdd SAR/sg13cmos5l_dfrbp_1_6.RESET_B SAR/a_10473_9186# vdd sg13_lv_pmos ad=0.2128p pd=1.5u as=0.2128p ps=1.5u w=1.12u l=0.13u
M1746 vss SAR/a_5079_3154# SAR/a_5210_3148# vss sg13_lv_nmos ad=2.59257p pd=16.445u as=0.2775p ps=2.23u w=0.74u l=0.13u
M1747 SAR/a_2228_4972# SAR/a_1815_4666# SAR/a_2160_4972# vdd sg13_lv_pmos ad=0.191p pd=1.44u as=0.105p ps=1.21u w=1u l=0.13u
M1748 SAR/a_5510_4338# SAR/sg13cmos5l_dfrbp_1_6.D vdd vdd sg13_lv_pmos ad=79.8f pd=0.8u as=0.1428p ps=1.52u w=0.42u l=0.13u
M1749 SAR/a_10534_7687# SAR/sg13cmos5l_dfrbp_1_6.RESET_B vss vss sg13_lv_nmos ad=37.8f pd=0.6u as=0.1701p ps=1.65u w=0.42u l=0.13u
M1750 vss SAR/a_14295_7282# SAR/a_14426_7288# vss sg13_lv_nmos ad=1.49685p pd=9.6u as=0.2775p ps=2.23u w=0.74u l=0.13u
M1751 vdd SAR/a_7863_7282# SAR/a_7994_7288# vdd sg13_lv_pmos ad=1.07253p pd=6.75u as=0.2856p ps=2.36u w=0.84u l=0.13u
M1752 SAR/sg13cmos5l_inv_1_0.A SAR/a_13652_3900# vdd vdd sg13_lv_pmos ad=0.3808p pd=2.92u as=0.2128p ps=1.5u w=1.12u l=0.13u
M1753 SAR/a_3562_4873# SAR/a_4005_4629# SAR/a_3302_4650# vss sg13_lv_nmos ad=79.8f pd=0.8u as=0.1296p ps=1.52u w=0.42u l=0.13u
M1754 SAR/sg13cmos5l_buf_1_45.A SAR/a_8841_5769# vdd vdd sg13_lv_pmos ad=0.3808p pd=2.92u as=0.2128p ps=1.5u w=1.12u l=0.13u
M1755 vss SAR/a_16293_4629# SAR/a_16395_4772# vss sg13_lv_nmos ad=2.41737p pd=15.64u as=0.2516p ps=2.16u w=0.74u l=0.13u
M1756 SAR/a_8772_8440# SAR/a_8746_8404# vss vss sg13_lv_nmos ad=0.2516p pd=2.16u as=0.1626p ps=1.415u w=0.74u l=0.13u
M1757 SAR/a_12132_9504# SAR/a_12106_9409# vdd vdd sg13_lv_pmos ad=0.34p pd=2.68u as=0.36237p ps=2.605u w=1u l=0.13u
M1758 SAR/a_13810_9186# SAR/sg13cmos5l_dfrbp_1_8.RESET_B vss vss sg13_lv_nmos ad=37.8f pd=0.6u as=79.8f ps=0.8u w=0.42u l=0.13u
M1759 vdd SAR/sg13cmos5l_buf_8_0.A SAR/a_19227_4654# vdd sg13_lv_pmos ad=0.2128p pd=1.5u as=0.2128p ps=1.5u w=1.12u l=0.13u
M1760 SAR/a_1815_4666# SAR/sg13cmos5l_dlhr_1_1.GATE vdd vdd sg13_lv_pmos ad=0.3234p pd=2.45u as=1.2517p ps=7.955u w=0.84u l=0.13u
M1761 vdd SAR/a_3407_8797# SAR/a_4244_8436# vdd sg13_lv_pmos ad=0.2128p pd=1.5u as=0.3864p ps=2.93u w=1.12u l=0.13u
M1762 SAR/a_14814_3876# SAR/sg13cmos5l_a22oi_1_1.B1 SAR/sg13cmos5l_a22oi_1_1.Y vdd sg13_lv_pmos ad=0.2716p pd=1.605u as=0.2128p ps=1.5u w=1.12u l=0.13u
M1763 vss SAR/a_15884_3102# nh_sw[7] vss sg13_lv_nmos ad=0.14875p pd=1.16u as=0.2886p ps=2.26u w=0.74u l=0.13u
M1764 vss SAR/a_6405_8447# SAR/a_6507_8447# vss sg13_lv_nmos ad=2.92392p pd=18.89u as=0.2516p ps=2.16u w=0.74u l=0.13u
M1765 SAR/a_3574_7850# SAR/a_3676_7964# vss vss sg13_lv_nmos ad=0.187p pd=1.78u as=0.1491p ps=1.18u w=0.55u l=0.13u
M1766 vdd SAR/a_1967_7285# SAR/a_2224_7166# vdd sg13_lv_pmos ad=0.2639p pd=1.81u as=79.8f ps=0.8u w=0.42u l=0.13u
M1767 vdd SAR/sg13cmos5l_nor2_1_0.A SAR/a_12814_4692# vdd sg13_lv_pmos ad=0.2618p pd=1.63u as=0.2856p ps=2.36u w=0.84u l=0.13u
M1768 SAR/a_17926_3151# SAR/sg13cmos5l_dfrbp_1_0.RESET_B vss vss sg13_lv_nmos ad=37.8f pd=0.6u as=0.1701p ps=1.65u w=0.42u l=0.13u
M1769 vss SAR/sg13cmos5l_and3_1_0.C SAR/a_13520_4696# vss sg13_lv_nmos ad=0.1371p pd=1.12u as=0.1216p ps=1.02u w=0.64u l=0.13u
M1770 SAR/a_10789_4654# SAR/sg13cmos5l_a221oi_1_0.C1 vss vss sg13_lv_nmos ad=0.1406p pd=1.12u as=0.14505p ps=1.15u w=0.74u l=0.13u
M1771 SAR/sg13cmos5l_dlhr_1_2.D SAR/a_6479_2749# vdd vdd sg13_lv_pmos ad=0.4312p pd=3.01u as=0.2639p ps=1.81u w=1.12u l=0.13u
M1772 SAR/a_13100_8400# SAR/sg13cmos5l_buf_1_90.X vdd vdd sg13_lv_pmos ad=0.2856p pd=2.36u as=0.2114p ps=1.54u w=0.84u l=0.13u
M1773 SAR/sg13cmos5l_nor2_1_2.A SAR/sg13cmos5l_inv_1_9.Y vss vss sg13_lv_nmos ad=0.2516p pd=2.16u as=0.2516p ps=2.16u w=0.74u l=0.13u
M1774 SAR/a_13572_3151# SAR/a_13803_3260# SAR/a_13258_3361# vss sg13_lv_nmos ad=0.2373p pd=1.97u as=79.8f ps=0.8u w=0.42u l=0.13u
M1775 SAR/a_11530_1849# SAR/a_11973_1605# SAR/a_11270_1626# vss sg13_lv_nmos ad=79.8f pd=0.8u as=0.1296p ps=1.52u w=0.42u l=0.13u
M1776 SAR/a_14032_6382# SAR/a_13775_6239# SAR/a_14194_6162# vss sg13_lv_nmos ad=0.1428p pd=1.52u as=37.8f ps=0.6u w=0.42u l=0.13u
M1777 SAR/a_10464_2427# SAR/sg13cmos5l_nor2_1_0.A vdd vdd sg13_lv_pmos ad=0.1596p pd=1.22u as=0.4536p ps=2.76u w=0.84u l=0.13u
M1778 vss SAR/a_3856_3358# SAR/a_3505_3215# vss sg13_lv_nmos ad=79.8f pd=0.8u as=0.1428p ps=1.52u w=0.42u l=0.13u
M1779 SAR/a_3876_4663# SAR/a_3588_4968# SAR/a_3814_4663# vss sg13_lv_nmos ad=0.1428p pd=1.52u as=37.8f ps=0.6u w=0.42u l=0.13u
M1780 SAR/a_6998_5837# SAR/a_5820_5773# SAR/a_6602_5692# vss sg13_lv_nmos ad=37.8f pd=0.6u as=0.1428p ps=1.52u w=0.42u l=0.13u
M1781 SAR/sg13cmos5l_dlhr_1_1.D SAR/a_1967_5773# vss vss sg13_lv_nmos ad=0.2849p pd=2.25u as=0.2516p ps=2.16u w=0.74u l=0.13u
M1782 vss vdd vss vss sg13_lv_nmos ad=0.1428p pd=1.52u as=0 ps=0 w=0.42u l=1u
M1783 SAR/a_10417_7326# SAR/a_9865_7282# vss vss sg13_lv_nmos ad=71.99999f pd=0.865u as=1.49685p ps=9.6u w=0.64u l=0.13u
M1784 vdd SAR/sg13cmos5l_nand2_1_0.A SAR/sg13cmos5l_o21ai_1_0.A2 vdd sg13_lv_pmos ad=0.3808p pd=2.92u as=0.2128p ps=1.5u w=1.12u l=0.13u
M1785 vss SAR/a_1484_9150# SAR/sg13cmos5l_buf_1_68.X vss sg13_lv_nmos ad=0.14875p pd=1.16u as=0.2886p ps=2.26u w=0.74u l=0.13u
M1786 vss SAR/sg13cmos5l_buf_1_40.A SAR/sg13cmos5l_buf_1_63.A vss sg13_lv_nmos ad=0.2516p pd=2.16u as=0.2516p ps=2.16u w=0.74u l=0.13u
M1787 vdd SAR/a_13161_7281# SAR/a_13094_6924# vdd sg13_lv_pmos ad=0.2387p pd=1.84u as=0.1008p ps=0.9u w=0.42u l=0.13u
M1788 vdd SAR/sg13cmos5l_nand2_1_1.B SAR/a_9823_2364# vdd sg13_lv_pmos ad=0.3808p pd=2.92u as=0.2744p ps=1.61u w=1.12u l=0.13u
M1789 SAR/a_14858_2388# SAR/sg13cmos5l_dfrbp_1_0.Q SAR/sg13cmos5l_nand2_1_0.A vdd sg13_lv_pmos ad=0.1176p pd=1.33u as=0.3808p ps=2.92u w=1.12u l=0.13u
M1790 vss _cks SAR/a_19227_9190# vss sg13_lv_nmos ad=0.1406p pd=1.12u as=0.1406p ps=1.12u w=0.74u l=0.13u
M1791 SAR/a_16068_6928# SAR/a_16042_6892# vss vss sg13_lv_nmos ad=0.2516p pd=2.16u as=0.1626p ps=1.415u w=0.74u l=0.13u
M1792 vdd SAR/a_19593_6162# SAR/a_19526_6600# vdd sg13_lv_pmos ad=0.2387p pd=1.84u as=0.1008p ps=0.9u w=0.42u l=0.13u
M1793 pl_sw[1] SAR/a_1000_9224# vss vss sg13_lv_nmos ad=0.2886p pd=2.26u as=0.14875p ps=1.16u w=0.74u l=0.13u
M1794 vss SAR/sg13cmos5l_buf_1_29.A SAR/sg13cmos5l_buf_1_77.A vss sg13_lv_nmos ad=0.2516p pd=2.16u as=0.2516p ps=2.16u w=0.74u l=0.13u
M1795 SAR/a_3447_2746# SAR/sg13cmos5l_dfrbp_1_9.Q vss vss sg13_lv_nmos ad=0.2516p pd=2.16u as=0.15055p ps=1.17u w=0.74u l=0.13u
M1796 SAR/a_18480_5028# SAR/sg13cmos5l_dfrbp_1_0.D vss vss sg13_lv_nmos ad=0.1045p pd=0.93u as=0.187p ps=1.78u w=0.55u l=0.13u
M1797 SAR/a_17516_9150# SAR/sg13cmos5l_buf_1_103.A vss vss sg13_lv_nmos ad=0.187p pd=1.78u as=0.14875p ps=1.16u w=0.55u l=0.13u
M1798 SAR/a_11434_2356# SAR/a_11877_2399# SAR/a_11817_2435# vdd sg13_lv_pmos ad=79.8f pd=0.8u as=63f ps=0.72u w=0.42u l=0.13u
M1799 vdd SAR/a_10587_4692# SAR/sg13cmos5l_nand2_1_0.B vdd sg13_lv_pmos ad=0.3808p pd=2.92u as=0.2128p ps=1.5u w=1.12u l=0.13u
M1800 vss SAR/a_19216_3358# SAR/a_18865_3215# vss sg13_lv_nmos ad=79.8f pd=0.8u as=0.1428p ps=1.52u w=0.42u l=0.13u
M1801 SAR/a_7497_3138# SAR/a_7316_3460# vdd vdd sg13_lv_pmos ad=0.2128p pd=1.5u as=0.2387p ps=1.84u w=1.12u l=0.13u
M1802 SAR/a_11270_1626# SAR/sg13cmos5l_dfrbp_1_1.D vdd vdd sg13_lv_pmos ad=79.8f pd=0.8u as=0.1428p ps=1.52u w=0.42u l=0.13u
M1803 SAR/sg13cmos5l_dlhr_1_1.Q_N SAR/a_2934_4632# vdd vdd sg13_lv_pmos ad=0.3808p pd=2.92u as=0.1974p ps=1.5u w=1.12u l=0.13u
M1804 SAR/sg13cmos5l_dfrbp_1_12.Q_N SAR/a_7055_4261# vdd vdd sg13_lv_pmos ad=0.4312p pd=3.01u as=0.2639p ps=1.81u w=1.12u l=0.13u
M1805 SAR/a_2727_6380# SAR/a_2879_6432# vss vss sg13_lv_nmos ad=0.2516p pd=2.16u as=1.97045p ps=12.335u w=0.74u l=0.13u
M1806 SAR/a_5425_3130# SAR/a_4873_3192# vss vss sg13_lv_nmos ad=71.99999f pd=0.865u as=2.59257p ps=16.445u w=0.64u l=0.13u
M1807 SAR/a_2148_8440# SAR/a_2667_8447# SAR/a_3407_8797# vss sg13_lv_nmos ad=0.3473p pd=2.71u as=0.12665p ps=1.145u w=0.74u l=0.13u
M1808 SAR/a_3574_7850# SAR/a_3676_7964# vdd vdd sg13_lv_pmos ad=0.2856p pd=2.36u as=0.1974p ps=1.5u w=0.84u l=0.13u
M1809 vss SAR/sg13cmos5l_buf_1_31.X SAR/a_1672_3176# vss sg13_lv_nmos ad=0.14875p pd=1.16u as=0.187p ps=1.78u w=0.55u l=0.13u
M1810 ph_sw[1] SAR/a_1864_9224# vdd vdd sg13_lv_pmos ad=0.42p pd=2.99u as=0.2114p ps=1.54u w=1.12u l=0.13u
M1811 vdd SAR/sg13cmos5l_dfrbp_1_8.RESET_B SAR/a_8486_8874# vdd sg13_lv_pmos ad=0.36237p pd=2.605u as=79.8f ps=0.8u w=0.42u l=0.13u
M1812 vss SAR/a_4652_6126# SAR/sg13cmos5l_inv_1_19.A vss sg13_lv_nmos ad=0.14875p pd=1.16u as=0.2886p ps=2.26u w=0.74u l=0.13u
M1813 SAR/a_18278_8112# SAR/a_17882_7684# SAR/a_18164_7996# vdd sg13_lv_pmos ad=0.1008p pd=0.9u as=0.191p ps=1.44u w=0.42u l=0.13u
M1814 SAR/a_7055_4261# SAR/a_6213_3911# SAR/a_5796_3904# vdd sg13_lv_pmos ad=0.2048p pd=1.63u as=0.34p ps=2.68u w=1u l=0.13u
M1815 SAR/a_12998_3138# SAR/sg13cmos5l_o21ai_1_0.Y vdd vdd sg13_lv_pmos ad=79.8f pd=0.8u as=0.1428p ps=1.52u w=0.42u l=0.13u
M1816 SAR/a_5962_8404# SAR/a_6405_8447# SAR/a_5702_8874# vss sg13_lv_nmos ad=79.8f pd=0.8u as=0.1296p ps=1.52u w=0.42u l=0.13u
M1817 SAR/sg13cmos5l_buf_1_2.X SAR/a_15784_1664# vss vss sg13_lv_nmos ad=0.2886p pd=2.26u as=0.14875p ps=1.16u w=0.74u l=0.13u
M1818 SAR/sg13cmos5l_buf_8_2.X SAR/a_19227_9190# vdd vdd sg13_lv_pmos ad=0.2128p pd=1.5u as=0.2128p ps=1.5u w=1.12u l=0.13u
M1819 vdd SAR/a_17961_8793# SAR/a_18486_8866# vdd sg13_lv_pmos ad=0.1974p pd=1.5u as=0.2856p ps=2.36u w=0.84u l=0.13u
M1820 SAR/a_5710_5850# SAR/a_5452_5850# vss vss sg13_lv_nmos ad=0.1428p pd=1.52u as=79.8f ps=0.8u w=0.42u l=0.13u
M1821 vdd SAR/a_9111_4666# SAR/a_9242_4660# vdd sg13_lv_pmos ad=1.28962p pd=8.195u as=0.2856p ps=2.36u w=0.84u l=0.13u
M1822 SAR/sg13cmos5l_dlhr_1_15.D SAR/a_17108_7972# vss vss sg13_lv_nmos ad=0.2516p pd=2.16u as=0.1406p ps=1.12u w=0.74u l=0.13u
M1823 vdd SAR/sg13cmos5l_dfrbp_1_6.RESET_B SAR/a_4041_2745# vdd sg13_lv_pmos ad=0.2128p pd=1.5u as=0.2128p ps=1.5u w=1.12u l=0.13u
M1824 SAR/a_19344_6484# SAR/a_18793_6216# vdd vdd sg13_lv_pmos ad=0.105p pd=1.21u as=1.07253p ps=6.75u w=1u l=0.13u
M1825 SAR/a_15909_2399# SAR/sg13cmos5l_dfrbp_1_0.CLK vdd vdd sg13_lv_pmos ad=0.4088p pd=2.97u as=1.777p ps=11.395u w=1.12u l=0.13u
M1826 vss SAR/a_1948_7964# SAR/sg13cmos5l_buf_1_58.A vss sg13_lv_nmos ad=0.1406p pd=1.12u as=0.2516p ps=2.16u w=0.74u l=0.13u
M1827 SAR/a_13258_3361# SAR/a_13701_3117# SAR/a_13641_3529# vdd sg13_lv_pmos ad=79.8f pd=0.8u as=63f ps=0.72u w=0.42u l=0.13u
M1828 vdd vss vdd vdd sg13_lv_pmos ad=0.34p pd=2.68u as=0 ps=0 w=1u l=1u
M1829 vdd SAR/a_16751_2749# SAR/a_17008_2630# vdd sg13_lv_pmos ad=0.2639p pd=1.81u as=79.8f ps=0.8u w=0.42u l=0.13u
M1830 SAR/sg13cmos5l_dfrbp_1_6.RESET_B _cks vdd vdd sg13_lv_pmos ad=0.2128p pd=1.5u as=0.3808p ps=2.92u w=1.12u l=0.13u
M1831 SAR/sg13cmos5l_o21ai_1_0.B1 SAR/sg13cmos5l_nand2_1_1.A SAR/a_14458_4270# vss sg13_lv_nmos ad=0.2516p pd=2.16u as=0.1406p ps=1.12u w=0.74u l=0.13u
M1832 SAR/a_5132_3864# SAR/sg13cmos5l_buf_1_44.A vdd vdd sg13_lv_pmos ad=0.2856p pd=2.36u as=0.2114p ps=1.54u w=0.84u l=0.13u
M1833 vss SAR/sg13cmos5l_dfrbp_1_8.RESET_B SAR/a_6180_4650# vss sg13_lv_nmos ad=0.1626p pd=1.415u as=60.89999f ps=0.71u w=0.42u l=0.13u
M1834 SAR/a_15500_9150# SAR/sg13cmos5l_buf_1_95.X vss vss sg13_lv_nmos ad=0.187p pd=1.78u as=0.14875p ps=1.16u w=0.55u l=0.13u
M1835 SAR/a_14844_7326# SAR/a_14295_7282# SAR/a_14708_6924# vss sg13_lv_nmos ad=47.25f pd=0.645u as=0.141p ps=1.17u w=0.42u l=0.13u
M1836 SAR/a_3856_3358# SAR/a_3599_3215# SAR/a_4018_3138# vss sg13_lv_nmos ad=0.1428p pd=1.52u as=37.8f ps=0.6u w=0.42u l=0.13u
M1837 vdd SAR/a_18363_4270# SAR/sg13cmos5l_or2_1_0.A vdd sg13_lv_pmos ad=0.2128p pd=1.5u as=0.2128p ps=1.5u w=1.12u l=0.13u
M1838 vss SAR/a_3574_7850# SAR/sg13cmos5l_dlhr_1_9.Q_N vss sg13_lv_nmos ad=0.1491p pd=1.18u as=0.2516p ps=2.16u w=0.74u l=0.13u
M1839 SAR/a_18580_7660# SAR/a_18164_7996# SAR/a_18345_7674# vss sg13_lv_nmos ad=77.7f pd=0.95u as=0.2516p ps=2.16u w=0.74u l=0.13u
M1840 SAR/sg13cmos5l_dfrbp_1_1.Q_N SAR/a_12815_1703# vdd vdd sg13_lv_pmos ad=0.4312p pd=3.01u as=0.2639p ps=1.81u w=1.12u l=0.13u
M1841 vss SAR/sg13cmos5l_dfrbp_1_10.Q SAR/a_4873_3192# vss sg13_lv_nmos ad=0.15055p pd=1.17u as=0.187p ps=1.78u w=0.55u l=0.13u
M1842 SAR/a_13977_6477# SAR/a_13035_6284# SAR/a_13775_6239# vdd sg13_lv_pmos ad=93.45f pd=0.865u as=0.2048p ps=1.63u w=0.42u l=0.13u
M1843 SAR/sg13cmos5l_dlhr_1_0.D SAR/a_7316_2388# vdd vdd sg13_lv_pmos ad=0.3808p pd=2.92u as=0.2128p ps=1.5u w=1.12u l=0.13u
M1844 vdd _cks SAR/sg13cmos5l_dfrbp_1_0.RESET_B vdd sg13_lv_pmos ad=0.3808p pd=2.92u as=0.3808p ps=2.92u w=1.12u l=0.13u
M1845 SAR/a_11268_2826# SAR/sg13cmos5l_dfrbp_1_4.D SAR/a_11174_2826# vss sg13_lv_nmos ad=60.89999f pd=0.71u as=0.1428p ps=1.52u w=0.42u l=0.13u
M1846 SAR/a_16271_7751# SAR/a_15429_7653# SAR/a_15012_7992# vdd sg13_lv_pmos ad=0.2048p pd=1.63u as=0.34p ps=2.68u w=1u l=0.13u
M1847 vss SAR/sg13cmos5l_dfrbp_1_6.RESET_B SAR/a_5028_2826# vss sg13_lv_nmos ad=0.1626p pd=1.415u as=60.89999f ps=0.71u w=0.42u l=0.13u
M1848 vss SAR/sg13cmos5l_buf_1_89.A SAR/a_15208_6200# vss sg13_lv_nmos ad=0.14875p pd=1.16u as=0.187p ps=1.78u w=0.55u l=0.13u
M1849 vdd SAR/sg13cmos5l_buf_1_74.X SAR/a_6568_9224# vdd sg13_lv_pmos ad=0.2114p pd=1.54u as=0.2856p ps=2.36u w=0.84u l=0.13u
M1850 SAR/sg13cmos5l_o21ai_1_0.Y SAR/sg13cmos5l_o21ai_1_0.B1 SAR/a_12022_3134# vss sg13_lv_nmos ad=0.2516p pd=2.16u as=0.1406p ps=1.12u w=0.74u l=0.15u
M1851 SAR/a_14916_8861# SAR/a_15147_8447# SAR/a_14602_8404# vss sg13_lv_nmos ad=0.2373p pd=1.97u as=79.8f ps=0.8u w=0.42u l=0.13u
M1852 vss vdd vss vss sg13_lv_nmos ad=0.1428p pd=1.52u as=0 ps=0 w=0.42u l=1u
M1853 SAR/sg13cmos5l_dlhr_1_9.D SAR/a_2804_5412# vss vss sg13_lv_nmos ad=0.2516p pd=2.16u as=0.1406p ps=1.12u w=0.74u l=0.13u
M1854 SAR/sg13cmos5l_dlhr_1_14.Q_N SAR/a_14166_7656# vss vss sg13_lv_nmos ad=0.2516p pd=2.16u as=0.1491p ps=1.18u w=0.74u l=0.13u
M1855 SAR/a_17712_8436# SAR/a_17161_8794# vdd vdd sg13_lv_pmos ad=0.105p pd=1.21u as=1.15047p ps=7.175u w=1u l=0.13u
M1856 SAR/a_3664_8678# SAR/sg13cmos5l_dfrbp_1_8.RESET_B vdd vdd sg13_lv_pmos ad=79.8f pd=0.8u as=1.12242p ps=7u w=0.42u l=0.13u
M1857 SAR/a_16548_6175# SAR/a_16779_6284# SAR/a_16234_6385# vss sg13_lv_nmos ad=0.2373p pd=1.97u as=79.8f ps=0.8u w=0.42u l=0.13u
M1858 SAR/a_8390_6924# SAR/a_7994_7288# SAR/a_8276_6924# vdd sg13_lv_pmos ad=0.1008p pd=0.9u as=0.191p ps=1.44u w=0.42u l=0.13u
M1859 vdd SAR/sg13cmos5l_dlhr_1_11.D SAR/a_12361_7282# vdd sg13_lv_pmos ad=1.07253p pd=6.75u as=0.2856p ps=2.36u w=0.84u l=0.13u
M1860 SAR/a_3856_3358# SAR/sg13cmos5l_dfrbp_1_6.RESET_B vdd vdd sg13_lv_pmos ad=79.8f pd=0.8u as=1.38655p ps=8.8u w=0.42u l=0.13u
M1861 vss SAR/a_9260_2352# nh_sw[4] vss sg13_lv_nmos ad=0.14875p pd=1.16u as=0.2886p ps=2.26u w=0.74u l=0.13u
M1862 nh_sw[1] SAR/a_2824_2388# vdd vdd sg13_lv_pmos ad=0.42p pd=2.99u as=0.2114p ps=1.54u w=1.12u l=0.13u
M1863 vss SAR/sg13cmos5l_dfrbp_1_6.RESET_B SAR/a_5604_4338# vss sg13_lv_nmos ad=0.1626p pd=1.415u as=60.89999f ps=0.71u w=0.42u l=0.13u
M1864 vss SAR/a_16677_6141# SAR/a_16779_6284# vss sg13_lv_nmos ad=1.97045p pd=12.335u as=0.2516p ps=2.16u w=0.74u l=0.13u
M1865 vdd SAR/a_10665_7281# SAR/a_10598_6924# vdd sg13_lv_pmos ad=0.2387p pd=1.84u as=0.1008p ps=0.9u w=0.42u l=0.13u
M1866 vss SAR/sg13cmos5l_dfrbp_1_8.RESET_B SAR/a_15684_4650# vss sg13_lv_nmos ad=0.1626p pd=1.415u as=60.89999f ps=0.71u w=0.42u l=0.13u
M1867 vdd SAR/sg13cmos5l_dfrbp_1_8.RESET_B SAR/a_5452_5850# vdd sg13_lv_pmos ad=1.2517p pd=7.955u as=79.8f ps=0.8u w=0.42u l=0.13u
M1868 SAR/a_7644_1662# SAR/a_7095_1642# SAR/a_7508_1948# vss sg13_lv_nmos ad=47.25f pd=0.645u as=0.141p ps=1.17u w=0.42u l=0.13u
M1869 SAR/a_3826_4338# SAR/sg13cmos5l_dfrbp_1_8.RESET_B vss vss sg13_lv_nmos ad=37.8f pd=0.6u as=79.8f ps=0.8u w=0.42u l=0.13u
M1870 SAR/a_8784_6484# SAR/a_8233_6216# vdd vdd sg13_lv_pmos ad=0.105p pd=1.21u as=1.07253p ps=6.75u w=1u l=0.13u
M1871 SAR/sg13cmos5l_inv_1_9.Y _cks vss vss sg13_lv_nmos ad=0.2516p pd=2.16u as=0.2516p ps=2.16u w=0.74u l=0.13u
M1872 SAR/a_8204_2352# SAR/sg13cmos5l_dlhr_1_2.Q vdd vdd sg13_lv_pmos ad=0.2856p pd=2.36u as=0.2114p ps=1.54u w=0.84u l=0.13u
M1873 vss SAR/a_9189_8447# SAR/a_9291_8447# vss sg13_lv_nmos ad=2.92392p pd=18.89u as=0.2516p ps=2.16u w=0.74u l=0.13u
M1874 SAR/a_9457_4642# SAR/a_8905_4704# vss vss sg13_lv_nmos ad=71.99999f pd=0.865u as=2.41737p ps=15.64u w=0.64u l=0.13u
M1875 SAR/a_16089_8559# SAR/a_15147_8447# SAR/a_15887_8797# vdd sg13_lv_pmos ad=93.45f pd=0.865u as=0.2048p ps=1.63u w=0.42u l=0.13u
M1876 SAR/a_15850_4873# SAR/a_16293_4629# SAR/a_15590_4650# vss sg13_lv_nmos ad=79.8f pd=0.8u as=0.1296p ps=1.52u w=0.42u l=0.13u
M1877 SAR/a_8276_6924# SAR/a_7994_7288# SAR/a_8209_7326# vss sg13_lv_nmos ad=0.141p pd=1.17u as=71.99999f ps=0.865u w=0.64u l=0.13u
M1878 SAR/sg13cmos5l_buf_1_56.A SAR/a_9033_6162# vdd vdd sg13_lv_pmos ad=0.3808p pd=2.92u as=0.2128p ps=1.5u w=1.12u l=0.13u
M1879 SAR/a_6214_8861# SAR/sg13cmos5l_dfrbp_1_8.RESET_B vss vss sg13_lv_nmos ad=37.8f pd=0.6u as=0.1701p ps=1.65u w=0.42u l=0.13u
M1880 vdd SAR/sg13cmos5l_dfrbp_1_6.RESET_B SAR/a_18345_7674# vdd sg13_lv_pmos ad=0.2128p pd=1.5u as=0.2128p ps=1.5u w=1.12u l=0.13u
M1881 vdd SAR/a_14889_7281# SAR/a_15414_7354# vdd sg13_lv_pmos ad=0.1974p pd=1.5u as=0.2856p ps=2.36u w=0.84u l=0.13u
M1882 SAR/a_19216_3358# SAR/sg13cmos5l_dfrbp_1_0.RESET_B vdd vdd sg13_lv_pmos ad=79.8f pd=0.8u as=1.38655p ps=8.8u w=0.42u l=0.13u
M1883 SAR/a_3212_1590# SAR/sg13cmos5l_buf_1_41.A vss vss sg13_lv_nmos ad=0.187p pd=1.78u as=0.14875p ps=1.16u w=0.55u l=0.13u
M1884 SAR/a_10618_3142# SAR/sg13cmos5l_nand2_1_0.A vss vss sg13_lv_nmos ad=0.1406p pd=1.12u as=0.2516p ps=2.16u w=0.74u l=0.13u
M1885 SAR/sg13cmos5l_buf_1_26.A SAR/sg13cmos5l_buf_1_45.X vdd vdd sg13_lv_pmos ad=0.3808p pd=2.92u as=0.3808p ps=2.92u w=1.12u l=0.13u
M1886 SAR/a_3407_8797# SAR/a_2565_8447# SAR/a_3313_8797# vss sg13_lv_nmos ad=0.12665p pd=1.145u as=0.1428p ps=1.52u w=0.42u l=0.13u
M1887 vss SAR/a_18671_1703# SAR/a_19508_1924# vss sg13_lv_nmos ad=0.1406p pd=1.12u as=0.2516p ps=2.16u w=0.74u l=0.13u
M1888 vss SAR/a_10288_8678# SAR/a_9937_8797# vss sg13_lv_nmos ad=79.8f pd=0.8u as=0.1428p ps=1.52u w=0.42u l=0.13u
M1889 SAR/a_5702_8874# SAR/a_6507_8447# SAR/a_5962_8404# vdd sg13_lv_pmos ad=0.1428p pd=1.52u as=79.8f ps=0.8u w=0.42u l=0.13u
M1890 SAR/a_516_5850# SAR/sg13cmos5l_dfrbp_1_6.D SAR/a_422_5850# vss sg13_lv_nmos ad=60.89999f pd=0.71u as=0.1428p ps=1.52u w=0.42u l=0.13u
M1891 vss SAR/a_13391_9263# SAR/a_14228_9484# vss sg13_lv_nmos ad=0.1406p pd=1.12u as=0.2516p ps=2.16u w=0.74u l=0.13u
M1892 SAR/a_2505_8483# SAR/a_2148_8440# vdd vdd sg13_lv_pmos ad=63f pd=0.72u as=0.1563p ps=1.22u w=0.42u l=0.13u
M1893 vss SAR/a_3599_3215# SAR/a_4436_3436# vss sg13_lv_nmos ad=0.1406p pd=1.12u as=0.2516p ps=2.16u w=0.74u l=0.13u
M1894 vdd SAR/sg13cmos5l_dfrbp_1_8.RESET_B SAR/a_15850_4873# vdd sg13_lv_pmos ad=0.1563p pd=1.22u as=0.147p ps=1.54u w=0.42u l=0.13u
M1895 SAR/sg13cmos5l_a22oi_1_2.B2 SAR/sg13cmos5l_a221oi_1_0.C1 SAR/a_10420_5760# vss sg13_lv_nmos ad=0.2516p pd=2.16u as=0.1406p ps=1.12u w=0.74u l=0.13u
M1896 vss SAR/sg13cmos5l_inv_1_8.A SAR/a_5951_5383# vss sg13_lv_nmos ad=1.88087p pd=11.775u as=0.2516p ps=2.16u w=0.74u l=0.13u
M1897 vss SAR/a_18860_6888# ph_sw[9] vss sg13_lv_nmos ad=0.14875p pd=1.16u as=0.2886p ps=2.26u w=0.74u l=0.13u
M1898 vss SAR/a_14032_6382# SAR/a_13681_6239# vss sg13_lv_nmos ad=79.8f pd=0.8u as=0.1428p ps=1.52u w=0.42u l=0.13u
M1899 SAR/a_6086_4650# SAR/a_6891_4772# SAR/a_6346_4873# vdd sg13_lv_pmos ad=0.1428p pd=1.52u as=79.8f ps=0.8u w=0.42u l=0.13u
M1900 vss SAR/a_12815_4261# SAR/a_13652_3900# vss sg13_lv_nmos ad=0.1406p pd=1.12u as=0.2516p ps=2.16u w=0.74u l=0.13u
M1901 SAR/a_996_7349# SAR/a_1227_6935# SAR/a_682_6892# vss sg13_lv_nmos ad=0.2373p pd=1.97u as=79.8f ps=0.8u w=0.42u l=0.13u
M1902 SAR/a_8588_3864# SAR/sg13cmos5l_buf_1_46.A vss vss sg13_lv_nmos ad=0.187p pd=1.78u as=0.14875p ps=1.16u w=0.55u l=0.13u
M1903 SAR/sg13cmos5l_buf_1_10.A SAR/a_11848_8436# vss vss sg13_lv_nmos ad=0.2886p pd=2.26u as=0.14875p ps=1.16u w=0.74u l=0.13u
M1904 SAR/sg13cmos5l_dlhr_1_21.Q_N SAR/a_10998_9168# vdd vdd sg13_lv_pmos ad=0.3808p pd=2.92u as=0.1974p ps=1.5u w=1.12u l=0.13u
M1905 SAR/sg13cmos5l_buf_1_18.A SAR/sg13cmos5l_buf_1_111.A vss vss sg13_lv_nmos ad=0.2516p pd=2.16u as=0.2516p ps=2.16u w=0.74u l=0.13u
M1906 vss SAR/a_9111_4666# SAR/a_9242_4660# vss sg13_lv_nmos ad=2.41737p pd=15.64u as=0.2775p ps=2.23u w=0.74u l=0.13u
M1907 SAR/a_1862_8874# SAR/sg13cmos5l_dfrbp_1_17.D vdd vdd sg13_lv_pmos ad=79.8f pd=0.8u as=0.1428p ps=1.52u w=0.42u l=0.13u
M1908 SAR/a_8746_8404# SAR/a_9189_8447# SAR/a_8486_8874# vss sg13_lv_nmos ad=79.8f pd=0.8u as=0.1296p ps=1.52u w=0.42u l=0.13u
M1909 SAR/a_10331_3900# SAR/sg13cmos5l_a221oi_1_0.C1 vdd vdd sg13_lv_pmos ad=0.3808p pd=2.92u as=0.2128p ps=1.5u w=1.12u l=0.13u
M1910 SAR/sg13cmos5l_inv_1_1.A SAR/a_15208_6200# vdd vdd sg13_lv_pmos ad=0.42p pd=2.99u as=0.2114p ps=1.54u w=1.12u l=0.13u
M1911 SAR/sg13cmos5l_dfrbp_1_21.Q_N SAR/a_17519_6239# vdd vdd sg13_lv_pmos ad=0.4312p pd=3.01u as=0.2639p ps=1.81u w=1.12u l=0.13u
M1912 vss SAR/a_6117_6141# SAR/a_6219_6284# vss sg13_lv_nmos ad=1.97045p pd=12.335u as=0.2516p ps=2.16u w=0.74u l=0.13u
M1913 vdd SAR/sg13cmos5l_nor2_1_0.A SAR/sg13cmos5l_a22oi_1_0.B1 vdd sg13_lv_pmos ad=0.3808p pd=2.92u as=0.2128p ps=1.5u w=1.12u l=0.13u
M1914 vdd SAR/sg13cmos5l_inv_1_0.A SAR/a_11072_5347# vdd sg13_lv_pmos ad=0.1596p pd=1.22u as=0.1596p ps=1.22u w=0.84u l=0.13u
M1915 vss SAR/a_13641_7674# SAR/a_14166_7656# vss sg13_lv_nmos ad=0.1491p pd=1.18u as=0.187p ps=1.78u w=0.55u l=0.13u
M1916 SAR/a_5220_2392# SAR/a_5194_2356# vdd vdd sg13_lv_pmos ad=0.34p pd=2.68u as=0.36237p ps=2.605u w=1u l=0.13u
M1917 SAR/a_7095_1642# SAR/sg13cmos5l_dlhr_1_0.GATE vdd vdd sg13_lv_pmos ad=0.3234p pd=2.45u as=1.777p ps=11.395u w=0.84u l=0.13u
M1918 SAR/a_20492_8400# SAR/sg13cmos5l_buf_1_104.X vdd vdd sg13_lv_pmos ad=0.2856p pd=2.36u as=0.2114p ps=1.54u w=0.84u l=0.13u
M1919 vss SAR/sg13cmos5l_dfrbp_1_6.RESET_B SAR/a_19444_5800# vss sg13_lv_nmos ad=0.1406p pd=1.12u as=77.7f ps=0.95u w=0.74u l=0.13u
M1920 SAR/a_1997_6126# SAR/a_2727_6380# SAR/a_2638_6477# vdd sg13_lv_pmos ad=0.2048p pd=1.63u as=93.45f ps=0.865u w=0.42u l=0.13u
M1921 SAR/a_11844_4325# SAR/a_11556_3904# SAR/a_11782_4325# vss sg13_lv_nmos ad=0.1428p pd=1.52u as=37.8f ps=0.6u w=0.42u l=0.13u
M1922 SAR/sg13cmos5l_dfrbp_1_9.Q SAR/a_4244_3900# vss vss sg13_lv_nmos ad=0.2516p pd=2.16u as=0.1406p ps=1.12u w=0.74u l=0.13u
M1923 SAR/sg13cmos5l_buf_1_89.A SAR/a_14889_7281# vdd vdd sg13_lv_pmos ad=0.3808p pd=2.92u as=0.2128p ps=1.5u w=1.12u l=0.13u
M1924 SAR/a_11372_3102# SAR/sg13cmos5l_buf_1_9.A vdd vdd sg13_lv_pmos ad=0.2856p pd=2.36u as=0.2114p ps=1.54u w=0.84u l=0.13u
M1925 vss SAR/sg13cmos5l_buf_1_10.A SAR/a_12520_3176# vss sg13_lv_nmos ad=0.14875p pd=1.16u as=0.187p ps=1.78u w=0.55u l=0.13u
M1926 vss SAR/a_7888_4870# SAR/a_7537_4727# vss sg13_lv_nmos ad=79.8f pd=0.8u as=0.1428p ps=1.52u w=0.42u l=0.13u
M1927 SAR/a_2169_7047# SAR/a_1227_6935# SAR/a_1967_7285# vdd sg13_lv_pmos ad=93.45f pd=0.865u as=0.2048p ps=1.63u w=0.42u l=0.13u
M1928 SAR/a_14640_6924# SAR/a_14089_7282# vdd vdd sg13_lv_pmos ad=0.105p pd=1.21u as=1.07253p ps=6.75u w=1u l=0.13u
M1929 vss SAR/sg13cmos5l_dfrbp_1_8.RESET_B SAR/a_5796_8874# vss sg13_lv_nmos ad=0.1626p pd=1.415u as=60.89999f ps=0.71u w=0.42u l=0.13u
M1930 SAR/a_11567_7751# SAR/a_10725_7653# SAR/a_11473_7751# vss sg13_lv_nmos ad=0.12665p pd=1.145u as=0.1428p ps=1.52u w=0.42u l=0.13u
M1931 vdd SAR/sg13cmos5l_inv_1_18.A SAR/sg13cmos5l_buf_1_28.A vdd sg13_lv_pmos ad=0.3808p pd=2.92u as=0.3808p ps=2.92u w=1.12u l=0.13u
M1932 SAR/sg13cmos5l_dlhr_1_3.Q_N SAR/a_4566_2818# vss vss sg13_lv_nmos ad=0.2516p pd=2.16u as=0.1491p ps=1.18u w=0.74u l=0.13u
M1933 vss SAR/a_6736_2630# SAR/a_6385_2749# vss sg13_lv_nmos ad=79.8f pd=0.8u as=0.1428p ps=1.52u w=0.42u l=0.13u
M1934 SAR/sg13cmos5l_dlhr_1_2.Q_N SAR/a_8022_3120# vdd vdd sg13_lv_pmos ad=0.3808p pd=2.92u as=0.1974p ps=1.5u w=1.12u l=0.13u
M1935 SAR/a_15045_8447# SAR/sg13cmos5l_inv_1_2.A vss vss sg13_lv_nmos ad=0.2516p pd=2.16u as=2.71505p ps=17.54u w=0.74u l=0.13u
M1936 vss SAR/a_15909_2399# SAR/a_16011_2399# vss sg13_lv_nmos ad=2.59257p pd=16.445u as=0.2516p ps=2.16u w=0.74u l=0.13u
M1937 SAR/a_12873_6553# SAR/a_12516_6480# vdd vdd sg13_lv_pmos ad=63f pd=0.72u as=0.1563p ps=1.22u w=0.42u l=0.13u
M1938 vdd vss vdd vdd sg13_lv_pmos ad=0.34p pd=2.68u as=0 ps=0 w=1u l=1u
M1939 SAR/a_9823_2364# SAR/sg13cmos5l_inv_1_11.Y vdd vdd sg13_lv_pmos ad=0.2716p pd=1.605u as=0.3808p ps=2.92u w=1.12u l=0.13u
M1940 SAR/a_10428_9222# SAR/a_9879_9202# SAR/a_10292_9508# vss sg13_lv_nmos ad=47.25f pd=0.645u as=0.141p ps=1.17u w=0.42u l=0.13u
M1941 vdd SAR/sg13cmos5l_nand2_1_1.A SAR/sg13cmos5l_o21ai_1_0.B1 vdd sg13_lv_pmos ad=0.3808p pd=2.92u as=0.2128p ps=1.5u w=1.12u l=0.13u
M1942 vss SAR/a_3669_6320# SAR/a_2748_6126# vss sg13_lv_nmos ad=0.1626p pd=1.415u as=0.2516p ps=2.16u w=0.74u l=0.13u
M1943 vdd vss vdd vdd sg13_lv_pmos ad=0.19p pd=1.38u as=0 ps=0 w=1u l=1u
M1944 vdd vss vdd vdd sg13_lv_pmos ad=0.19p pd=1.38u as=0 ps=0 w=1u l=1u
M1945 SAR/sg13cmos5l_buf_1_28.X SAR/a_9448_1664# vdd vdd sg13_lv_pmos ad=0.42p pd=2.99u as=0.2114p ps=1.54u w=1.12u l=0.13u
M1946 vdd SAR/sg13cmos5l_dfrbp_1_8.RESET_B SAR/a_12106_9409# vdd sg13_lv_pmos ad=0.1563p pd=1.22u as=0.147p ps=1.54u w=0.42u l=0.13u
M1947 SAR/a_14583_5770# SAR/sg13cmos5l_dfrbp_1_23.CLK vss vss sg13_lv_nmos ad=0.2516p pd=2.16u as=0.15055p ps=1.17u w=0.74u l=0.13u
M1948 SAR/sg13cmos5l_dlhr_1_11.GATE SAR/a_10868_8436# vss vss sg13_lv_nmos ad=0.2516p pd=2.16u as=0.1406p ps=1.12u w=0.74u l=0.13u
M1949 vss SAR/a_7497_3138# SAR/a_8022_3120# vss sg13_lv_nmos ad=0.1491p pd=1.18u as=0.187p ps=1.78u w=0.55u l=0.13u
M1950 SAR/a_5546_5850# SAR/a_5069_5376# SAR/a_5452_5850# vss sg13_lv_nmos ad=37.8f pd=0.6u as=0.1428p ps=1.52u w=0.42u l=0.13u
M1951 vss SAR/a_12567_7282# SAR/a_12698_7288# vss sg13_lv_nmos ad=1.49685p pd=9.6u as=0.2775p ps=2.23u w=0.74u l=0.13u
M1952 SAR/a_3669_6320# SAR/a_2727_6380# SAR/a_3530_6320# vss sg13_lv_nmos ad=79.8f pd=0.8u as=0.2373p ps=1.97u w=0.42u l=0.13u
M1953 vdd SAR/sg13cmos5l_dfrbp_1_0.Q SAR/a_14254_2444# vdd sg13_lv_pmos ad=0.2618p pd=1.63u as=0.2856p ps=2.36u w=0.84u l=0.13u
M1954 SAR/a_1956_4338# SAR/sg13cmos5l_dlhr_1_1.GATE SAR/a_1862_4338# vss sg13_lv_nmos ad=60.89999f pd=0.71u as=0.1428p ps=1.52u w=0.42u l=0.13u
M1955 SAR/a_1878_6337# SAR/a_1997_6126# vss vss sg13_lv_nmos ad=0.2516p pd=2.16u as=0.1406p ps=1.12u w=0.74u l=0.13u
M1956 SAR/a_14814_4292# SAR/sg13cmos5l_nand2_1_1.B vss vss sg13_lv_nmos ad=96.2f pd=1u as=0.2516p ps=2.16u w=0.74u l=0.13u
M1957 SAR/sg13cmos5l_buf_1_116.A SAR/a_15177_5769# vss vss sg13_lv_nmos ad=0.2516p pd=2.16u as=0.1406p ps=1.12u w=0.74u l=0.13u
M1958 SAR/a_12516_6480# SAR/a_12490_6385# vss vss sg13_lv_nmos ad=0.2516p pd=2.16u as=0.1626p ps=1.415u w=0.74u l=0.13u
M1959 SAR/a_19340_8400# SAR/sg13cmos5l_buf_1_107.X vss vss sg13_lv_nmos ad=0.187p pd=1.78u as=0.14875p ps=1.16u w=0.55u l=0.13u
M1960 vss SAR/sg13cmos5l_dfrbp_1_6.RESET_B SAR/a_2644_4636# vss sg13_lv_nmos ad=0.1406p pd=1.12u as=77.7f ps=0.95u w=0.74u l=0.13u
M1961 SAR/a_7812_7687# SAR/a_7524_7992# SAR/a_7750_7687# vss sg13_lv_nmos ad=0.1428p pd=1.52u as=37.8f ps=0.6u w=0.42u l=0.13u
M1962 SAR/a_2224_5654# SAR/a_1967_5773# SAR/a_2386_5850# vss sg13_lv_nmos ad=0.1428p pd=1.52u as=37.8f ps=0.6u w=0.42u l=0.13u
M1963 vdd SAR/a_17751_7690# SAR/a_17882_7684# vdd sg13_lv_pmos ad=1.15047p pd=7.175u as=0.2856p ps=2.36u w=0.84u l=0.13u
M1964 vdd SAR/sg13cmos5l_dfrbp_1_6.RESET_B SAR/a_19209_5769# vdd sg13_lv_pmos ad=0.2128p pd=1.5u as=0.2128p ps=1.5u w=1.12u l=0.13u
M1965 SAR/a_6843_5459# SAR/a_5951_5383# SAR/a_6741_5459# vdd sg13_lv_pmos ad=63f pd=0.72u as=79.8f ps=0.8u w=0.42u l=0.13u
M1966 vdd SAR/sg13cmos5l_buf_1_40.A SAR/sg13cmos5l_buf_1_63.A vdd sg13_lv_pmos ad=0.3808p pd=2.92u as=0.3808p ps=2.92u w=1.12u l=0.13u
M1967 vdd SAR/sg13cmos5l_inv_1_2.A SAR/sg13cmos5l_dfrbp_1_0.CLK vdd sg13_lv_pmos ad=0.3808p pd=2.92u as=0.3808p ps=2.92u w=1.12u l=0.13u
M1968 SAR/sg13cmos5l_and3_1_0.X SAR/a_13324_4696# vdd vdd sg13_lv_pmos ad=0.3808p pd=2.92u as=0.36195p ps=1.84u w=1.12u l=0.13u
M1969 vdd SAR/a_10071_7282# SAR/a_10202_7288# vdd sg13_lv_pmos ad=1.07253p pd=6.75u as=0.2856p ps=2.36u w=0.84u l=0.13u
M1970 SAR/a_19028_5412# SAR/a_18615_5770# SAR/a_18960_5412# vdd sg13_lv_pmos ad=0.191p pd=1.44u as=0.105p ps=1.21u w=1u l=0.13u
M1971 SAR/a_10427_2736# SAR/sg13cmos5l_nor2_1_0.A vss vss sg13_lv_nmos ad=78.39999f pd=0.885u as=0.2272p ps=1.99u w=0.64u l=0.13u
M1972 vdd SAR/sg13cmos5l_buf_1_25.X SAR/a_4456_1664# vdd sg13_lv_pmos ad=0.2114p pd=1.54u as=0.2856p ps=2.36u w=0.84u l=0.13u
M1973 vdd SAR/a_8783_7751# SAR/a_9620_7972# vdd sg13_lv_pmos ad=0.2128p pd=1.5u as=0.3864p ps=2.93u w=1.12u l=0.13u
M1974 SAR/sg13cmos5l_buf_1_9.A SAR/a_9832_1664# vdd vdd sg13_lv_pmos ad=0.42p pd=2.99u as=0.2114p ps=1.54u w=1.12u l=0.13u
M1975 vss SAR/sg13cmos5l_dfrbp_1_6.RESET_B SAR/a_14820_7674# vss sg13_lv_nmos ad=0.1626p pd=1.415u as=60.89999f ps=0.71u w=0.42u l=0.13u
M1976 vss SAR/sg13cmos5l_inv_1_5.A SAR/a_20392_3900# vss sg13_lv_nmos ad=0.14875p pd=1.16u as=0.187p ps=1.78u w=0.55u l=0.13u
M1977 vdd SAR/a_1125_5423# SAR/a_1227_5423# vdd sg13_lv_pmos ad=1.28962p pd=8.195u as=0.3864p ps=2.93u w=1.12u l=0.13u
M1978 SAR/a_2436_4325# SAR/a_2148_3904# SAR/a_2374_4325# vss sg13_lv_nmos ad=0.1428p pd=1.52u as=37.8f ps=0.6u w=0.42u l=0.13u
M1979 SAR/sg13cmos5l_buf_8_1.A SAR/a_17972_4948# vdd vdd sg13_lv_pmos ad=0.3808p pd=2.92u as=0.2128p ps=1.5u w=1.12u l=0.13u
M1980 SAR/sg13cmos5l_dfrbp_1_6.RESET_B _cks vdd vdd sg13_lv_pmos ad=0.2184p pd=1.51u as=0.2128p ps=1.5u w=1.12u l=0.13u
M1981 SAR/a_3302_4650# SAR/a_4107_4772# SAR/a_3562_4873# vdd sg13_lv_pmos ad=0.1428p pd=1.52u as=79.8f ps=0.8u w=0.42u l=0.13u
M1982 vss SAR/a_16268_1590# nl_sw[7] vss sg13_lv_nmos ad=0.14875p pd=1.16u as=0.2886p ps=2.26u w=0.74u l=0.13u
M1983 SAR/a_8457_7281# SAR/a_8276_6924# vdd vdd sg13_lv_pmos ad=0.2128p pd=1.5u as=0.2387p ps=1.84u w=1.12u l=0.13u
M1984 SAR/sg13cmos5l_dfrbp_1_11.Q_N SAR/a_7631_4727# vss vss sg13_lv_nmos ad=0.2849p pd=2.25u as=0.2516p ps=2.16u w=0.74u l=0.13u
M1985 vss SAR/a_17132_9150# ph_sw[7] vss sg13_lv_nmos ad=0.14875p pd=1.16u as=0.2886p ps=2.26u w=0.74u l=0.13u
M1986 vss SAR/sg13cmos5l_buf_1_73.X SAR/a_5800_9224# vss sg13_lv_nmos ad=0.14875p pd=1.16u as=0.187p ps=1.78u w=0.55u l=0.13u
M1987 SAR/sg13cmos5l_buf_1_104.X SAR/a_19624_8436# vss vss sg13_lv_nmos ad=0.2886p pd=2.26u as=0.14875p ps=1.16u w=0.74u l=0.13u
M1988 ph_sw[3] SAR/a_5416_9224# vss vss sg13_lv_nmos ad=0.2886p pd=2.26u as=0.14875p ps=1.16u w=0.74u l=0.13u
M1989 SAR/a_3926_6175# SAR/a_2748_6126# SAR/a_3530_6320# vss sg13_lv_nmos ad=37.8f pd=0.6u as=0.1428p ps=1.52u w=0.42u l=0.13u
M1990 SAR/a_13094_6924# SAR/a_12698_7288# SAR/a_12980_6924# vdd sg13_lv_pmos ad=0.1008p pd=0.9u as=0.191p ps=1.44u w=0.42u l=0.13u
M1991 vss SAR/a_6479_2749# SAR/a_7316_2388# vss sg13_lv_nmos ad=0.1406p pd=1.12u as=0.2516p ps=2.16u w=0.74u l=0.13u
M1992 SAR/a_9705_4650# SAR/a_9524_4972# vdd vdd sg13_lv_pmos ad=0.2128p pd=1.5u as=0.2387p ps=1.84u w=1.12u l=0.13u
M1993 vdd _cks SAR/sg13cmos5l_dfrbp_1_6.RESET_B vdd sg13_lv_pmos ad=0.2128p pd=1.5u as=0.2128p ps=1.5u w=1.12u l=0.13u
M1994 SAR/a_18873_1941# SAR/a_17931_1748# SAR/a_18671_1703# vdd sg13_lv_pmos ad=93.45f pd=0.865u as=0.2048p ps=1.63u w=0.42u l=0.13u
M1995 vdd SAR/a_1402_3864# SAR/a_1121_4166# vdd sg13_lv_pmos ad=0.1523p pd=1.38u as=0.34p ps=2.68u w=1u l=0.5u
M1996 SAR/a_13034_5412# SAR/sg13cmos5l_nor2_1_0.A SAR/sg13cmos5l_or2_1_1.B vdd sg13_lv_pmos ad=0.1176p pd=1.33u as=0.3808p ps=2.92u w=1.12u l=0.13u
M1997 vss SAR/a_7863_7282# SAR/a_7994_7288# vss sg13_lv_nmos ad=1.49685p pd=9.6u as=0.2775p ps=2.23u w=0.74u l=0.13u
M1998 SAR/a_16551_3987# SAR/a_16703_3871# vss vss sg13_lv_nmos ad=0.2516p pd=2.16u as=2.41737p ps=15.64u w=0.74u l=0.13u
M1999 SAR/a_7524_7992# SAR/a_7498_7897# vdd vdd sg13_lv_pmos ad=0.34p pd=2.68u as=0.36237p ps=2.605u w=1u l=0.13u
M2000 vdd SAR/a_7095_1642# SAR/a_7226_1636# vdd sg13_lv_pmos ad=1.86162p pd=11.935u as=0.2856p ps=2.36u w=0.84u l=0.13u
M2001 SAR/a_7820_2352# SAR/sg13cmos5l_dlhr_1_0.Q vdd vdd sg13_lv_pmos ad=0.2856p pd=2.36u as=0.2114p ps=1.54u w=0.84u l=0.13u
M2002 vss SAR/a_10028_6126# SAR/sg13cmos5l_inv_1_18.A vss sg13_lv_nmos ad=0.14875p pd=1.16u as=0.2886p ps=2.26u w=0.74u l=0.13u
M2003 SAR/a_4076_7624# SAR/a_4324_7996# SAR/a_4282_8112# vdd sg13_lv_pmos ad=0.191p pd=1.44u as=0.1008p ps=0.9u w=0.42u l=0.13u
M2004 SAR/sg13cmos5l_a22oi_1_0.Y SAR/sg13cmos5l_inv_1_0.A SAR/a_10783_4292# vss sg13_lv_nmos ad=0.2664p pd=1.46u as=0.13875p ps=1.115u w=0.74u l=0.13u
M2005 vss vdd vss vss sg13_lv_nmos ad=0.1428p pd=1.52u as=0 ps=0 w=0.42u l=1u
M2006 vdd SAR/sg13cmos5l_dfrbp_1_6.RESET_B SAR/a_14986_7897# vdd sg13_lv_pmos ad=0.1563p pd=1.22u as=0.147p ps=1.54u w=0.42u l=0.13u
M2007 SAR/a_2790_7996# SAR/a_2621_7636# SAR/a_2348_7624# vdd sg13_lv_pmos ad=0.105p pd=1.21u as=0.191p ps=1.44u w=1u l=0.13u
M2008 vss SAR/a_7055_4261# SAR/a_7892_3900# vss sg13_lv_nmos ad=0.1406p pd=1.12u as=0.2516p ps=2.16u w=0.74u l=0.13u
M2009 SAR/a_7312_4142# SAR/a_7055_4261# SAR/a_7474_4338# vss sg13_lv_nmos ad=0.1428p pd=1.52u as=37.8f ps=0.6u w=0.42u l=0.13u
M2010 SAR/a_17414_3138# SAR/sg13cmos5l_a22oi_1_1.Y vdd vdd sg13_lv_pmos ad=79.8f pd=0.8u as=0.1428p ps=1.52u w=0.42u l=0.13u
M2011 SAR/a_12489_9577# SAR/a_12132_9504# vdd vdd sg13_lv_pmos ad=63f pd=0.72u as=0.1563p ps=1.22u w=0.42u l=0.13u
M2012 vss SAR/a_13072_4142# SAR/a_12721_4261# vss sg13_lv_nmos ad=79.8f pd=0.8u as=0.1428p ps=1.52u w=0.42u l=0.13u
M2013 SAR/a_10412_6126# SAR/sg13cmos5l_dlhr_1_5.Q vdd vdd sg13_lv_pmos ad=0.2856p pd=2.36u as=0.2114p ps=1.54u w=0.84u l=0.13u
M2014 SAR/sg13cmos5l_dlhr_1_4.Q_N SAR/a_6198_3120# vss vss sg13_lv_nmos ad=0.2516p pd=2.16u as=0.1491p ps=1.18u w=0.74u l=0.13u
M2015 vss SAR/a_12216_5728# SAR/sg13cmos5l_a221oi_1_0.B1 vss sg13_lv_nmos ad=0.1469p pd=1.155u as=0.2516p ps=2.16u w=0.74u l=0.13u
M2016 SAR/a_7863_7282# SAR/sg13cmos5l_dlhr_1_5.GATE vdd vdd sg13_lv_pmos ad=0.3234p pd=2.45u as=1.04815p ps=6.595u w=0.84u l=0.13u
M2017 SAR/sg13cmos5l_dfrbp_1_18.Q_N SAR/a_7247_8797# vss vss sg13_lv_nmos ad=0.2849p pd=2.25u as=0.2516p ps=2.16u w=0.74u l=0.13u
M2018 SAR/a_13391_9263# SAR/a_12549_9165# SAR/a_12132_9504# vdd sg13_lv_pmos ad=0.2048p pd=1.63u as=0.34p ps=2.68u w=1u l=0.13u
M2019 SAR/a_12716_8400# SAR/sg13cmos5l_buf_1_79.X vss vss sg13_lv_nmos ad=0.187p pd=1.78u as=0.14875p ps=1.16u w=0.55u l=0.13u
M2020 SAR/a_15357_1816# SAR/sg13cmos5l_dfrbp_1_0.Q vdd vdd sg13_lv_pmos ad=0.2856p pd=2.36u as=0.2198p ps=1.53u w=0.84u l=0.13u
M2021 vss SAR/sg13cmos5l_inv_1_2.A SAR/sg13cmos5l_dfrbp_1_0.CLK vss sg13_lv_nmos ad=0.2516p pd=2.16u as=0.2516p ps=2.16u w=0.74u l=0.13u
M2022 SAR/a_17938_6162# SAR/sg13cmos5l_dfrbp_1_6.RESET_B vss vss sg13_lv_nmos ad=37.8f pd=0.6u as=79.8f ps=0.8u w=0.42u l=0.13u
M2023 vss SAR/a_13161_7281# SAR/a_13116_7326# vss sg13_lv_nmos ad=0.1428p pd=1.52u as=47.25f ps=0.645u w=0.42u l=0.13u
M2024 vdd SAR/sg13cmos5l_dfrbp_1_6.RESET_B SAR/a_4425_7281# vdd sg13_lv_pmos ad=0.2128p pd=1.5u as=0.2128p ps=1.5u w=1.12u l=0.13u
M2025 SAR/sg13cmos5l_inv_1_7.A SAR/a_11464_8436# vss vss sg13_lv_nmos ad=0.2886p pd=2.26u as=0.14875p ps=1.16u w=0.74u l=0.13u
M2026 SAR/sg13cmos5l_dlhr_1_15.Q_N SAR/a_18870_7656# vdd vdd sg13_lv_pmos ad=0.3808p pd=2.92u as=0.1974p ps=1.5u w=1.12u l=0.13u
M2027 SAR/a_1196_8400# SAR/sg13cmos5l_buf_1_63.A vss vss sg13_lv_nmos ad=0.187p pd=1.78u as=0.14875p ps=1.16u w=0.55u l=0.13u
M2028 SAR/a_13072_1846# SAR/a_12815_1703# SAR/a_13234_1626# vss sg13_lv_nmos ad=0.1428p pd=1.52u as=37.8f ps=0.6u w=0.42u l=0.13u
M2029 SAR/a_13486_5412# SAR/sg13cmos5l_or2_1_1.B SAR/a_13698_5412# vdd sg13_lv_pmos ad=0.2128p pd=1.5u as=0.3808p ps=2.92u w=1.12u l=0.13u
M2030 vdd SAR/a_12719_2749# SAR/a_13556_2388# vdd sg13_lv_pmos ad=0.2128p pd=1.5u as=0.3864p ps=2.93u w=1.12u l=0.13u
M2031 SAR/a_4244_6924# SAR/a_3831_7282# SAR/a_4176_6924# vdd sg13_lv_pmos ad=0.191p pd=1.44u as=0.105p ps=1.21u w=1u l=0.13u
M2032 vss SAR/sg13cmos5l_buf_1_3.X SAR/a_20392_3176# vss sg13_lv_nmos ad=0.14875p pd=1.16u as=0.187p ps=1.78u w=0.55u l=0.13u
M2033 vss SAR/a_19628_2352# nh_sw[9] vss sg13_lv_nmos ad=0.14875p pd=1.16u as=0.2886p ps=2.26u w=0.74u l=0.13u
M2034 vdd SAR/a_1158_3142# SAR/a_1290_3206# vdd sg13_lv_pmos ad=0.2245p pd=1.53u as=0.445p ps=2.89u w=1u l=0.25u
M2035 SAR/a_2565_8447# SAR/sg13cmos5l_inv_1_8.A vdd vdd sg13_lv_pmos ad=0.4088p pd=2.97u as=1.12242p ps=7u w=1.12u l=0.13u
M2036 SAR/a_14628_8440# SAR/a_15147_8447# SAR/a_15887_8797# vss sg13_lv_nmos ad=0.3473p pd=2.71u as=0.12665p ps=1.145u w=0.74u l=0.13u
M2037 vdd SAR/a_1948_7964# SAR/sg13cmos5l_buf_1_58.A vdd sg13_lv_pmos ad=0.2128p pd=1.5u as=0.3808p ps=2.92u w=1.12u l=0.13u
M2038 vss SAR/sg13cmos5l_buf_1_18.A SAR/a_18376_2388# vss sg13_lv_nmos ad=0.14875p pd=1.16u as=0.187p ps=1.78u w=0.55u l=0.13u
M2039 vss SAR/a_8247_5770# SAR/a_8378_5776# vss sg13_lv_nmos ad=1.97045p pd=12.335u as=0.2775p ps=2.23u w=0.74u l=0.13u
M2040 SAR/a_3974_2388# SAR/a_3578_2752# SAR/a_3860_2388# vdd sg13_lv_pmos ad=0.1008p pd=0.9u as=0.191p ps=1.44u w=0.42u l=0.13u
M2041 vdd SAR/a_2409_4650# SAR/a_2934_4632# vdd sg13_lv_pmos ad=0.1974p pd=1.5u as=0.2856p ps=2.36u w=0.84u l=0.13u
M2042 SAR/a_2374_8861# SAR/sg13cmos5l_dfrbp_1_8.RESET_B vss vss sg13_lv_nmos ad=37.8f pd=0.6u as=0.1701p ps=1.65u w=0.42u l=0.13u
M2043 SAR/a_18928_1846# SAR/sg13cmos5l_dfrbp_1_0.RESET_B vdd vdd sg13_lv_pmos ad=79.8f pd=0.8u as=1.777p ps=11.395u w=0.42u l=0.13u
M2044 vdd SAR/a_17516_9150# pl_sw[8] vdd sg13_lv_pmos ad=0.2114p pd=1.54u as=0.42p ps=2.99u w=1.12u l=0.13u
M2045 vss SAR/sg13cmos5l_dlhr_1_9.D SAR/a_10587_4692# vss sg13_lv_nmos ad=0.14505p pd=1.15u as=0.187p ps=1.78u w=0.55u l=0.13u
M2046 SAR/a_1158_3142# SAR/a_902_3142# vss vss sg13_lv_nmos ad=0.1428p pd=1.52u as=0.1323p ps=1.05u w=0.42u l=0.18u
M2047 vdd SAR/a_6572_1590# SAR/sg13cmos5l_buf_1_24.X vdd sg13_lv_pmos ad=0.2114p pd=1.54u as=0.42p ps=2.99u w=1.12u l=0.13u
M2048 vdd SAR/a_1580_2352# nh_sw[0] vdd sg13_lv_pmos ad=0.2114p pd=1.54u as=0.42p ps=2.99u w=1.12u l=0.13u
M2049 vdd SAR/sg13cmos5l_a221oi_1_0.A2 SAR/a_8041_5770# vdd sg13_lv_pmos ad=1.28962p pd=8.195u as=0.2856p ps=2.36u w=0.84u l=0.13u
M2050 SAR/a_7833_4965# SAR/a_6891_4772# SAR/a_7631_4727# vdd sg13_lv_pmos ad=93.45f pd=0.865u as=0.2048p ps=1.63u w=0.42u l=0.13u
M2051 pl_sw[4] SAR/a_5800_9224# vdd vdd sg13_lv_pmos ad=0.42p pd=2.99u as=0.2114p ps=1.54u w=1.12u l=0.13u
M2052 vss SAR/a_17751_7690# SAR/a_17882_7684# vss sg13_lv_nmos ad=1.49685p pd=9.6u as=0.2775p ps=2.23u w=0.74u l=0.13u
M2053 SAR/a_19828_6148# SAR/a_19412_6484# SAR/a_19593_6162# vss sg13_lv_nmos ad=77.7f pd=0.95u as=0.2516p ps=2.16u w=0.74u l=0.13u
M2054 vss SAR/a_15702_4187# SAR/sg13cmos5l_and3_1_0.C vss sg13_lv_nmos ad=0.1406p pd=1.12u as=0.2516p ps=2.16u w=0.74u l=0.13u
M2055 vdd SAR/a_6479_2749# SAR/a_6736_2630# vdd sg13_lv_pmos ad=0.2639p pd=1.81u as=79.8f ps=0.8u w=0.42u l=0.13u
M2056 SAR/sg13cmos5l_inv_1_9.Y _cks vdd vdd sg13_lv_pmos ad=0.3808p pd=2.92u as=0.3808p ps=2.92u w=1.12u l=0.13u
M2057 SAR/a_5508_2813# SAR/a_5739_2399# SAR/a_5194_2356# vss sg13_lv_nmos ad=0.2373p pd=1.97u as=79.8f ps=0.8u w=0.42u l=0.13u
M2058 vdd SAR/a_9879_9202# SAR/a_10010_9196# vdd sg13_lv_pmos ad=4.11675p pd=27.17u as=0.2856p ps=2.36u w=0.84u l=0.13u
M2059 SAR/sg13cmos5l_buf_1_90.X SAR/a_11464_9224# vss vss sg13_lv_nmos ad=0.2886p pd=2.26u as=0.14875p ps=1.16u w=0.74u l=0.13u
M2060 vdd vss vdd vdd sg13_lv_pmos ad=0.34p pd=2.68u as=0 ps=0 w=1u l=1u
M2061 SAR/a_15492_2392# SAR/a_16011_2399# SAR/a_16751_2749# vss sg13_lv_nmos ad=0.3473p pd=2.71u as=0.12665p ps=1.145u w=0.74u l=0.13u
M2062 SAR/a_2583_7710# SAR/a_1948_7964# vss vss sg13_lv_nmos ad=47.25f pd=0.645u as=0.1428p ps=1.52u w=0.42u l=0.13u
M2063 vdd SAR/a_5673_3138# SAR/a_5606_3576# vdd sg13_lv_pmos ad=0.2387p pd=1.84u as=0.1008p ps=0.9u w=0.42u l=0.13u
M2064 SAR/sg13cmos5l_dfrbp_1_5.Q_N SAR/a_16751_2749# vss vss sg13_lv_nmos ad=0.2849p pd=2.25u as=0.2516p ps=2.16u w=0.74u l=0.13u
M2065 SAR/a_15439_1630# SAR/a_15357_1816# SAR/sg13cmos5l_nand2_1_1.B vss sg13_lv_nmos ad=0.1406p pd=1.12u as=0.333p ps=2.38u w=0.74u l=0.13u
M2066 SAR/sg13cmos5l_buf_1_25.A SAR/sg13cmos5l_inv_1_14.A vdd vdd sg13_lv_pmos ad=0.3808p pd=2.92u as=0.3808p ps=2.92u w=1.12u l=0.13u
M2067 vdd vss vdd vdd sg13_lv_pmos ad=0.34p pd=2.68u as=0 ps=0 w=1u l=1u
M2068 SAR/a_2122_8404# SAR/a_2565_8447# SAR/a_2505_8483# vdd sg13_lv_pmos ad=79.8f pd=0.8u as=63f ps=0.72u w=0.42u l=0.13u
M2069 SAR/a_10225_9178# SAR/a_9673_9240# vss vss sg13_lv_nmos ad=71.99999f pd=0.865u as=2.92392p ps=18.89u w=0.64u l=0.13u
M2070 vdd SAR/a_3447_2746# SAR/a_3578_2752# vdd sg13_lv_pmos ad=1.86162p pd=11.935u as=0.2856p ps=2.36u w=0.84u l=0.13u
M2071 vdd SAR/a_620_2352# nl_sw[0] vdd sg13_lv_pmos ad=0.2114p pd=1.54u as=0.42p ps=2.99u w=1.12u l=0.13u
M2072 SAR/a_13596_7710# SAR/a_13047_7690# SAR/a_13460_7996# vss sg13_lv_nmos ad=47.25f pd=0.645u as=0.141p ps=1.17u w=0.42u l=0.13u
M2073 vss SAR/sg13cmos5l_dfrbp_1_23.Q_N SAR/a_14377_5770# vss sg13_lv_nmos ad=0.15055p pd=1.17u as=0.187p ps=1.78u w=0.55u l=0.13u
M2074 vss SAR/a_10725_7653# SAR/a_10827_7796# vss sg13_lv_nmos ad=1.49685p pd=9.6u as=0.2516p ps=2.16u w=0.74u l=0.13u
M2075 vss SAR/a_20012_1590# SAR/sg13cmos5l_buf_1_0.X vss sg13_lv_nmos ad=0.14875p pd=1.16u as=0.2886p ps=2.26u w=0.74u l=0.13u
M2076 vss SAR/sg13cmos5l_dfrbp_1_6.RESET_B SAR/a_10708_9172# vss sg13_lv_nmos ad=0.1406p pd=1.12u as=77.7f ps=0.95u w=0.74u l=0.13u
M2077 SAR/sg13cmos5l_buf_1_46.A SAR/a_9705_4650# vss vss sg13_lv_nmos ad=0.2516p pd=2.16u as=0.1406p ps=1.12u w=0.74u l=0.13u
M2078 SAR/a_7504_8678# SAR/a_7247_8797# SAR/a_7666_8874# vss sg13_lv_nmos ad=0.1428p pd=1.52u as=37.8f ps=0.6u w=0.42u l=0.13u
M2079 vdd SAR/a_15500_9150# ph_sw[6] vdd sg13_lv_pmos ad=0.2114p pd=1.54u as=0.42p ps=2.99u w=1.12u l=0.13u
M2080 SAR/a_2380_6162# SAR/a_1997_6126# vdd vdd sg13_lv_pmos ad=79.8f pd=0.8u as=0.2639p ps=1.81u w=0.42u l=0.13u
M2081 vss SAR/a_7095_1642# SAR/a_7226_1636# vss sg13_lv_nmos ad=7.01497p pd=46.005u as=0.2775p ps=2.23u w=0.74u l=0.13u
M2082 SAR/a_10596_7687# SAR/a_10827_7796# SAR/a_10282_7897# vss sg13_lv_nmos ad=0.2373p pd=1.97u as=79.8f ps=0.8u w=0.42u l=0.13u
M2083 vdd vss vdd vdd sg13_lv_pmos ad=0.34p pd=2.68u as=0 ps=0 w=1u l=1u
M2084 vss SAR/a_5673_3138# SAR/a_6198_3120# vss sg13_lv_nmos ad=0.1491p pd=1.18u as=0.187p ps=1.78u w=0.55u l=0.13u
M2085 vss SAR/a_2224_5654# SAR/a_1873_5773# vss sg13_lv_nmos ad=79.8f pd=0.8u as=0.1428p ps=1.52u w=0.42u l=0.13u
M2086 vss SAR/a_12815_1703# SAR/a_13652_1924# vss sg13_lv_nmos ad=0.1406p pd=1.12u as=0.2516p ps=2.16u w=0.74u l=0.13u
M2087 SAR/a_13076_5376# SAR/sg13cmos5l_inv_1_0.A vdd vdd sg13_lv_pmos ad=0.2856p pd=2.36u as=0.2618p ps=1.63u w=0.84u l=0.13u
M2088 SAR/a_17516_9150# SAR/sg13cmos5l_buf_1_103.A vdd vdd sg13_lv_pmos ad=0.2856p pd=2.36u as=0.2114p ps=1.54u w=0.84u l=0.13u
M2089 SAR/sg13cmos5l_buf_1_18.A SAR/sg13cmos5l_buf_1_111.A vdd vdd sg13_lv_pmos ad=0.3808p pd=2.92u as=0.3808p ps=2.92u w=1.12u l=0.13u
M2090 vdd SAR/a_18615_5770# SAR/a_18746_5776# vdd sg13_lv_pmos ad=1.28962p pd=8.195u as=0.2856p ps=2.36u w=0.84u l=0.13u
M2091 vss SAR/sg13cmos5l_buf_1_30.A SAR/sg13cmos5l_buf_1_73.A vss sg13_lv_nmos ad=0.2516p pd=2.16u as=0.2516p ps=2.16u w=0.74u l=0.13u
M2092 SAR/sg13cmos5l_dfrbp_1_20.Q_N SAR/a_8783_7751# vss vss sg13_lv_nmos ad=0.2849p pd=2.25u as=0.2516p ps=2.16u w=0.74u l=0.13u
M2093 SAR/a_422_7362# SAR/sg13cmos5l_dfrbp_1_6.D vdd vdd sg13_lv_pmos ad=79.8f pd=0.8u as=0.1428p ps=1.52u w=0.42u l=0.13u
M2094 SAR/a_15357_1816# SAR/sg13cmos5l_dfrbp_1_0.Q vss vss sg13_lv_nmos ad=0.187p pd=1.78u as=0.14505p ps=1.15u w=0.55u l=0.13u
M2095 SAR/a_7394_5850# SAR/sg13cmos5l_dfrbp_1_8.RESET_B vss vss sg13_lv_nmos ad=60.89999f pd=0.71u as=0.1626p ps=1.415u w=0.42u l=0.13u
M2096 vdd SAR/sg13cmos5l_nor2_1_1.A SAR/sg13cmos5l_nand2_1_1.B vdd sg13_lv_pmos ad=0.2198p pd=1.53u as=0.2128p ps=1.5u w=1.12u l=0.13u
M2097 SAR/a_7248_3460# SAR/a_6697_3192# vdd vdd sg13_lv_pmos ad=0.105p pd=1.21u as=1.43437p ps=9.105u w=1u l=0.13u
M2098 SAR/a_620_7638# SAR/sg13cmos5l_buf_1_63.X vdd vdd sg13_lv_pmos ad=0.2856p pd=2.36u as=0.2114p ps=1.54u w=0.84u l=0.13u
M2099 SAR/a_5988_6175# SAR/a_6219_6284# SAR/a_5674_6385# vss sg13_lv_nmos ad=0.2373p pd=1.97u as=79.8f ps=0.8u w=0.42u l=0.13u
M2100 vss SAR/a_20204_5376# SAR/sg13cmos5l_inv_1_6.A vss sg13_lv_nmos ad=0.14875p pd=1.16u as=0.2886p ps=2.26u w=0.74u l=0.13u
M2101 vdd SAR/a_6405_8447# SAR/a_6507_8447# vdd sg13_lv_pmos ad=1.15047p pd=7.175u as=0.3864p ps=2.93u w=1.12u l=0.13u
M2102 SAR/a_14986_7897# SAR/a_15429_7653# SAR/a_14726_7674# vss sg13_lv_nmos ad=79.8f pd=0.8u as=0.1296p ps=1.52u w=0.42u l=0.13u
M2103 vdd SAR/a_13161_7281# SAR/a_13686_7354# vdd sg13_lv_pmos ad=0.1974p pd=1.5u as=0.2856p ps=2.36u w=0.84u l=0.13u
M2104 vss vdd vss vss sg13_lv_nmos ad=0.1428p pd=1.52u as=0 ps=0 w=0.42u l=1u
M2105 vdd SAR/sg13cmos5l_inv_1_7.A SAR/a_12232_8436# vdd sg13_lv_pmos ad=0.2114p pd=1.54u as=0.2856p ps=2.36u w=0.84u l=0.13u
M2106 vdd SAR/sg13cmos5l_buf_1_31.X SAR/a_1672_3176# vdd sg13_lv_pmos ad=0.2114p pd=1.54u as=0.2856p ps=2.36u w=0.84u l=0.13u
M2107 SAR/a_7888_4870# SAR/sg13cmos5l_dfrbp_1_8.RESET_B vdd vdd sg13_lv_pmos ad=79.8f pd=0.8u as=1.2517p ps=7.955u w=0.42u l=0.13u
M2108 SAR/a_16486_6175# SAR/sg13cmos5l_dfrbp_1_6.RESET_B vss vss sg13_lv_nmos ad=37.8f pd=0.6u as=0.1701p ps=1.65u w=0.42u l=0.13u
M2109 SAR/a_15590_4650# SAR/a_16395_4772# SAR/a_15850_4873# vdd sg13_lv_pmos ad=0.1428p pd=1.52u as=79.8f ps=0.8u w=0.42u l=0.13u
M2110 vss SAR/a_10665_7281# SAR/a_10620_7326# vss sg13_lv_nmos ad=0.1428p pd=1.52u as=47.25f ps=0.645u w=0.42u l=0.13u
M2111 SAR/a_12230_6162# SAR/sg13cmos5l_buf_1_57.X vdd vdd sg13_lv_pmos ad=79.8f pd=0.8u as=0.1428p ps=1.52u w=0.42u l=0.13u
M2112 vss SAR/sg13cmos5l_dfrbp_1_8.RESET_B SAR/a_2474_6162# vss sg13_lv_nmos ad=79.8f pd=0.8u as=37.8f ps=0.6u w=0.42u l=0.13u
M2113 SAR/sg13cmos5l_o21ai_1_0.A1 SAR/sg13cmos5l_a221oi_1_0.C1 SAR/a_11394_4948# vdd sg13_lv_pmos ad=0.3808p pd=2.92u as=0.2128p ps=1.5u w=1.12u l=0.13u
M2114 SAR/a_7052_9150# SAR/sg13cmos5l_inv_1_14.A vss vss sg13_lv_nmos ad=0.187p pd=1.78u as=0.14875p ps=1.16u w=0.55u l=0.13u
M2115 vdd SAR/a_10220_3102# nl_sw[5] vdd sg13_lv_pmos ad=0.2114p pd=1.54u as=0.42p ps=2.99u w=1.12u l=0.13u
M2116 vss SAR/sg13cmos5l_dfrbp_1_6.RESET_B SAR/a_4660_7312# vss sg13_lv_nmos ad=0.1406p pd=1.12u as=77.7f ps=0.95u w=0.74u l=0.13u
M2117 SAR/sg13cmos5l_or2_1_0.A SAR/a_18363_4270# vss vss sg13_lv_nmos ad=0.1406p pd=1.12u as=0.1406p ps=1.12u w=0.74u l=0.13u
M2118 SAR/a_11771_5412# SAR/sg13cmos5l_nor2b_1_0.Y SAR/sg13cmos5l_a221oi_1_0.B2 vdd sg13_lv_pmos ad=0.2128p pd=1.5u as=0.3808p ps=2.92u w=1.12u l=0.13u
M2119 vss SAR/sg13cmos5l_dlhr_1_1.D SAR/a_1609_4704# vss sg13_lv_nmos ad=0.15055p pd=1.17u as=0.187p ps=1.78u w=0.55u l=0.13u
M2120 SAR/a_15887_8797# SAR/a_15045_8447# SAR/a_15793_8797# vss sg13_lv_nmos ad=0.12665p pd=1.145u as=0.1428p ps=1.52u w=0.42u l=0.13u
M2121 SAR/sg13cmos5l_buf_1_40.X SAR/a_1192_1664# vss vss sg13_lv_nmos ad=0.2886p pd=2.26u as=0.14875p ps=1.16u w=0.74u l=0.13u
M2122 vdd SAR/a_10725_7653# SAR/a_10827_7796# vdd sg13_lv_pmos ad=1.15047p pd=7.175u as=0.3864p ps=2.93u w=1.12u l=0.13u
M2123 SAR/a_16068_6928# SAR/a_16587_6935# SAR/a_17327_7285# vss sg13_lv_nmos ad=0.3473p pd=2.71u as=0.12665p ps=1.145u w=0.74u l=0.13u
M2124 SAR/sg13cmos5l_a22oi_1_1.B1 SAR/sg13cmos5l_nand2_1_1.B vss vss sg13_lv_nmos ad=0.1406p pd=1.12u as=0.2516p ps=2.16u w=0.74u l=0.13u
M2125 vdd SAR/a_8972_3864# SAR/sg13cmos5l_buf_1_45.X vdd sg13_lv_pmos ad=0.2114p pd=1.54u as=0.42p ps=2.99u w=1.12u l=0.13u
M2126 SAR/a_2122_3868# SAR/a_2565_3911# SAR/a_1862_4338# vss sg13_lv_nmos ad=79.8f pd=0.8u as=0.1296p ps=1.52u w=0.42u l=0.13u
M2127 SAR/a_12490_6385# SAR/a_12933_6141# SAR/a_12873_6553# vdd sg13_lv_pmos ad=79.8f pd=0.8u as=63f ps=0.72u w=0.42u l=0.13u
M2128 vdd SAR/a_1967_5773# SAR/a_2224_5654# vdd sg13_lv_pmos ad=0.2639p pd=1.81u as=79.8f ps=0.8u w=0.42u l=0.13u
M2129 SAR/a_14985_8483# SAR/a_14628_8440# vdd vdd sg13_lv_pmos ad=63f pd=0.72u as=0.1563p ps=1.22u w=0.42u l=0.13u
M2130 vss SAR/sg13cmos5l_buf_1_29.A SAR/a_9832_1664# vss sg13_lv_nmos ad=0.14875p pd=1.16u as=0.187p ps=1.78u w=0.55u l=0.13u
M2131 vss SAR/sg13cmos5l_or2_1_0.A SAR/sg13cmos5l_nand2_1_2.B vss sg13_lv_nmos ad=0.2516p pd=2.16u as=0.1406p ps=1.12u w=0.74u l=0.13u
M2132 vss SAR/sg13cmos5l_buf_1_39.A SAR/a_3688_1664# vss sg13_lv_nmos ad=0.14875p pd=1.16u as=0.187p ps=1.78u w=0.55u l=0.13u
M2133 SAR/a_17769_2017# SAR/a_17412_1944# vdd vdd sg13_lv_pmos ad=63f pd=0.72u as=0.1563p ps=1.22u w=0.42u l=0.13u
M2134 SAR/a_15500_9150# SAR/sg13cmos5l_buf_1_95.X vdd vdd sg13_lv_pmos ad=0.2856p pd=2.36u as=0.2114p ps=1.54u w=0.84u l=0.13u
M2135 SAR/a_2628_3151# SAR/a_2859_3260# SAR/a_2314_3361# vss sg13_lv_nmos ad=0.2373p pd=1.97u as=79.8f ps=0.8u w=0.42u l=0.13u
M2136 SAR/a_12912_6924# SAR/a_12361_7282# vdd vdd sg13_lv_pmos ad=0.105p pd=1.21u as=1.07253p ps=6.75u w=1u l=0.13u
M2137 SAR/a_17746_7362# SAR/sg13cmos5l_dfrbp_1_8.RESET_B vss vss sg13_lv_nmos ad=37.8f pd=0.6u as=79.8f ps=0.8u w=0.42u l=0.13u
M2138 SAR/sg13cmos5l_buf_1_3.A SAR/a_19528_6924# vdd vdd sg13_lv_pmos ad=0.42p pd=2.99u as=0.2114p ps=1.54u w=1.12u l=0.13u
M2139 SAR/sg13cmos5l_buf_1_44.A SAR/a_5673_3138# vdd vdd sg13_lv_pmos ad=0.3808p pd=2.92u as=0.2128p ps=1.5u w=1.12u l=0.13u
M2140 SAR/sg13cmos5l_buf_1_101.X SAR/a_16264_9224# vss vss sg13_lv_nmos ad=0.2886p pd=2.26u as=0.14875p ps=1.16u w=0.74u l=0.13u
M2141 SAR/a_13510_3151# SAR/sg13cmos5l_dfrbp_1_0.RESET_B vss vss sg13_lv_nmos ad=37.8f pd=0.6u as=0.1701p ps=1.65u w=0.42u l=0.13u
M2142 SAR/a_4652_6126# SAR/sg13cmos5l_buf_1_59.A vdd vdd sg13_lv_pmos ad=0.2856p pd=2.36u as=0.2114p ps=1.54u w=0.84u l=0.13u
M2143 vss SAR/a_7312_4142# SAR/a_6961_4261# vss sg13_lv_nmos ad=79.8f pd=0.8u as=0.1428p ps=1.52u w=0.42u l=0.13u
M2144 SAR/a_16528_7894# SAR/a_16271_7751# SAR/a_16690_7674# vss sg13_lv_nmos ad=0.1428p pd=1.52u as=37.8f ps=0.6u w=0.42u l=0.13u
M2145 vss SAR/a_17392_4870# SAR/a_17041_4727# vss sg13_lv_nmos ad=79.8f pd=0.8u as=0.1428p ps=1.52u w=0.42u l=0.13u
M2146 vdd SAR/sg13cmos5l_dfrbp_1_0.RESET_B SAR/a_11434_2356# vdd sg13_lv_pmos ad=0.1563p pd=1.22u as=0.147p ps=1.54u w=0.42u l=0.13u
M2147 vss SAR/sg13cmos5l_or2_1_1.B SAR/a_12216_5728# vss sg13_lv_nmos ad=0.187p pd=1.78u as=0.1045p ps=0.93u w=0.55u l=0.13u
M2148 SAR/a_17700_1639# SAR/a_17931_1748# SAR/a_17386_1849# vss sg13_lv_nmos ad=0.2373p pd=1.97u as=79.8f ps=0.8u w=0.42u l=0.13u
M2149 SAR/a_13234_1626# SAR/sg13cmos5l_dfrbp_1_0.RESET_B vss vss sg13_lv_nmos ad=37.8f pd=0.6u as=79.8f ps=0.8u w=0.42u l=0.13u
M2150 SAR/sg13cmos5l_dlhr_1_11.D SAR/a_11567_7751# vdd vdd sg13_lv_pmos ad=0.4312p pd=3.01u as=0.2639p ps=1.81u w=1.12u l=0.13u
M2151 vdd vss vdd vdd sg13_lv_pmos ad=0.34p pd=2.68u as=0 ps=0 w=1u l=1u
M2152 vdd SAR/a_8457_7281# SAR/a_8982_7354# vdd sg13_lv_pmos ad=0.1974p pd=1.5u as=0.2856p ps=2.36u w=0.84u l=0.13u
M2153 vdd SAR/a_14583_5770# SAR/a_14714_5776# vdd sg13_lv_pmos ad=1.28962p pd=8.195u as=0.2856p ps=2.36u w=0.84u l=0.13u
M2154 vdd SAR/sg13cmos5l_dfrbp_1_0.RESET_B SAR/a_13258_3361# vdd sg13_lv_pmos ad=0.1563p pd=1.22u as=0.147p ps=1.54u w=0.42u l=0.13u
M2155 SAR/a_12132_9504# SAR/a_12106_9409# vss vss sg13_lv_nmos ad=0.2516p pd=2.16u as=0.1626p ps=1.415u w=0.74u l=0.13u
M2156 SAR/a_6380_7638# SAR/sg13cmos5l_buf_1_78.X vdd vdd sg13_lv_pmos ad=0.2856p pd=2.36u as=0.2114p ps=1.54u w=0.84u l=0.13u
M2157 SAR/a_7430_3576# SAR/a_7034_3148# SAR/a_7316_3460# vdd sg13_lv_pmos ad=0.1008p pd=0.9u as=0.191p ps=1.44u w=0.42u l=0.13u
M2158 SAR/a_15849_2435# SAR/a_15492_2392# vdd vdd sg13_lv_pmos ad=63f pd=0.72u as=0.1563p ps=1.22u w=0.42u l=0.13u
M2159 SAR/sg13cmos5l_dfrbp_1_18.Q SAR/a_8084_8436# vdd vdd sg13_lv_pmos ad=0.3808p pd=2.92u as=0.2128p ps=1.5u w=1.12u l=0.13u
M2160 SAR/a_4380_7326# SAR/a_3831_7282# SAR/a_4244_6924# vss sg13_lv_nmos ad=47.25f pd=0.645u as=0.141p ps=1.17u w=0.42u l=0.13u
M2161 SAR/a_13484_8400# SAR/sg13cmos5l_dlhr_1_11.Q vss vss sg13_lv_nmos ad=0.187p pd=1.78u as=0.14875p ps=1.16u w=0.55u l=0.13u
M2162 vdd SAR/a_5820_5773# SAR/a_6843_5459# vdd sg13_lv_pmos ad=0.1563p pd=1.22u as=63f ps=0.72u w=0.42u l=0.13u
M2163 vss SAR/sg13cmos5l_inv_1_18.A SAR/a_9256_9224# vss sg13_lv_nmos ad=0.14875p pd=1.16u as=0.187p ps=1.78u w=0.55u l=0.13u
M2164 SAR/a_17988_3151# SAR/a_18219_3260# SAR/a_17674_3361# vss sg13_lv_nmos ad=0.2373p pd=1.97u as=79.8f ps=0.8u w=0.42u l=0.13u
M2165 SAR/a_14996_5412# SAR/a_14714_5776# SAR/a_14929_5814# vss sg13_lv_nmos ad=0.141p pd=1.17u as=71.99999f ps=0.865u w=0.64u l=0.13u
M2166 vdd SAR/sg13cmos5l_dfrbp_1_15.D SAR/a_3575_6553# vdd sg13_lv_pmos ad=0.1428p pd=1.52u as=79.8f ps=0.8u w=0.42u l=0.13u
M2167 vss SAR/sg13cmos5l_dlhr_1_0.D SAR/a_6889_1680# vss sg13_lv_nmos ad=0.15055p pd=1.17u as=0.187p ps=1.78u w=0.55u l=0.13u
M2168 SAR/a_11270_4338# SAR/a_12075_3911# SAR/a_11530_3868# vdd sg13_lv_pmos ad=0.1428p pd=1.52u as=79.8f ps=0.8u w=0.42u l=0.13u
M2169 vdd SAR/a_19209_5769# SAR/a_19142_5412# vdd sg13_lv_pmos ad=0.2387p pd=1.84u as=0.1008p ps=0.9u w=0.42u l=0.13u
M2170 vss SAR/a_17519_6239# SAR/a_18356_6460# vss sg13_lv_nmos ad=0.1406p pd=1.12u as=0.2516p ps=2.16u w=0.74u l=0.13u
M2171 SAR/a_3609_4023# SAR/a_2667_3911# SAR/a_3407_4261# vdd sg13_lv_pmos ad=93.45f pd=0.865u as=0.2048p ps=1.63u w=0.42u l=0.13u
M2172 SAR/sg13cmos5l_dfrbp_1_20.Q SAR/a_9620_7972# vss vss sg13_lv_nmos ad=0.2516p pd=2.16u as=0.1406p ps=1.12u w=0.74u l=0.13u
M2173 SAR/a_12567_7282# SAR/sg13cmos5l_dlhr_1_11.GATE vdd vdd sg13_lv_pmos ad=0.3234p pd=2.45u as=1.07253p ps=6.75u w=0.84u l=0.13u
M2174 vss SAR/sg13cmos5l_nor2b_1_0.Y SAR/a_10433_1652# vss sg13_lv_nmos ad=0.2516p pd=2.16u as=0.1406p ps=1.12u w=0.74u l=0.13u
M2175 vss SAR/a_2757_3117# SAR/a_2859_3260# vss sg13_lv_nmos ad=2.59257p pd=16.445u as=0.2516p ps=2.16u w=0.74u l=0.13u
M2176 vss SAR/sg13cmos5l_inv_1_19.A SAR/sg13cmos5l_buf_1_32.A vss sg13_lv_nmos ad=0.2516p pd=2.16u as=0.2516p ps=2.16u w=0.74u l=0.13u
M2177 vss SAR/a_20492_8400# pl_sw[10] vss sg13_lv_nmos ad=0.14875p pd=1.16u as=0.2886p ps=2.26u w=0.74u l=0.13u
M2178 SAR/sg13cmos5l_dfrbp_1_6.RESET_B _cks vss vss sg13_lv_nmos ad=0.1406p pd=1.12u as=0.1406p ps=1.12u w=0.74u l=0.13u
M2179 vdd SAR/a_14900_2352# SAR/a_14858_2388# vdd sg13_lv_pmos ad=0.2618p pd=1.63u as=0.1176p ps=1.33u w=1.12u l=0.13u
M2180 vss SAR/sg13cmos5l_inv_1_27.Y SAR/a_14632_9224# vss sg13_lv_nmos ad=0.14875p pd=1.16u as=0.187p ps=1.78u w=0.55u l=0.13u
M2181 SAR/a_17721_6477# SAR/a_16779_6284# SAR/a_17519_6239# vdd sg13_lv_pmos ad=93.45f pd=0.865u as=0.2048p ps=1.63u w=0.42u l=0.13u
M2182 vss SAR/a_6741_5459# SAR/a_5820_5773# vss sg13_lv_nmos ad=0.1626p pd=1.415u as=0.2516p ps=2.16u w=0.74u l=0.13u
M2183 vdd SAR/a_13047_7690# SAR/a_13178_7684# vdd sg13_lv_pmos ad=1.15047p pd=7.175u as=0.2856p ps=2.36u w=0.84u l=0.13u
M2184 SAR/a_14916_8861# SAR/a_14628_8440# SAR/a_14854_8861# vss sg13_lv_nmos ad=0.1428p pd=1.52u as=37.8f ps=0.6u w=0.42u l=0.13u
M2185 SAR/a_1967_7285# SAR/a_1125_6935# SAR/a_1873_7285# vss sg13_lv_nmos ad=0.12665p pd=1.145u as=0.1428p ps=1.52u w=0.42u l=0.13u
M2186 nl_sw[1] SAR/a_1864_1664# vss vss sg13_lv_nmos ad=0.2886p pd=2.26u as=0.14875p ps=1.16u w=0.74u l=0.13u
M2187 vss vdd vss vss sg13_lv_nmos ad=79.8f pd=0.8u as=0 ps=0 w=0.42u l=1u
M2188 SAR/sg13cmos5l_buf_1_86.A SAR/a_20008_8436# vss vss sg13_lv_nmos ad=0.2886p pd=2.26u as=0.14875p ps=1.16u w=0.74u l=0.13u
M2189 SAR/a_4034_7660# SAR/sg13cmos5l_dfrbp_1_6.RESET_B vss vss sg13_lv_nmos ad=77.7f pd=0.95u as=0.1406p ps=1.12u w=0.74u l=0.13u
M2190 vdd SAR/sg13cmos5l_dlhr_1_1.GATE SAR/a_4349_7636# vdd sg13_lv_pmos ad=1.15047p pd=7.175u as=0.3234p ps=2.45u w=0.84u l=0.13u
M2191 SAR/a_3212_1590# SAR/sg13cmos5l_buf_1_41.A vdd vdd sg13_lv_pmos ad=0.2856p pd=2.36u as=0.2114p ps=1.54u w=0.84u l=0.13u
M2192 SAR/a_1006_4167# SAR/a_1121_4166# vss vss sg13_lv_nmos ad=0.1428p pd=1.52u as=0.1426p ps=1.16u w=0.42u l=0.5u
M2193 SAR/sg13cmos5l_inv_1_3.A SAR/a_13768_8436# vss vss sg13_lv_nmos ad=0.2886p pd=2.26u as=0.14875p ps=1.16u w=0.74u l=0.13u
M2194 vss SAR/sg13cmos5l_dfrbp_1_0.Q SAR/a_14254_2444# vss sg13_lv_nmos ad=0.17255p pd=1.25u as=0.187p ps=1.78u w=0.55u l=0.13u
M2195 SAR/sg13cmos5l_buf_1_19.X SAR/a_18760_2388# vss vss sg13_lv_nmos ad=0.2886p pd=2.26u as=0.14875p ps=1.16u w=0.74u l=0.13u
M2196 vss SAR/sg13cmos5l_dfrbp_1_6.RESET_B SAR/a_10116_7674# vss sg13_lv_nmos ad=0.1626p pd=1.415u as=60.89999f ps=0.71u w=0.42u l=0.13u
M2197 SAR/a_9260_2352# SAR/sg13cmos5l_buf_1_30.X vdd vdd sg13_lv_pmos ad=0.2856p pd=2.36u as=0.2114p ps=1.54u w=0.84u l=0.13u
M2198 SAR/a_2314_3361# SAR/a_2757_3117# SAR/a_2697_3529# vdd sg13_lv_pmos ad=79.8f pd=0.8u as=63f ps=0.72u w=0.42u l=0.13u
M2199 vss SAR/sg13cmos5l_dfrbp_1_6.RESET_B SAR/a_17750_4325# vss sg13_lv_nmos ad=0.1701p pd=1.65u as=37.8f ps=0.6u w=0.42u l=0.13u
M2200 vdd SAR/a_10031_8797# SAR/a_10868_8436# vdd sg13_lv_pmos ad=0.2128p pd=1.5u as=0.3864p ps=2.93u w=1.12u l=0.13u
M2201 SAR/sg13cmos5l_dlhr_1_7.Q_N SAR/a_4950_7354# vdd vdd sg13_lv_pmos ad=0.3808p pd=2.92u as=0.1974p ps=1.5u w=1.12u l=0.13u
M2202 SAR/a_17126_1626# SAR/sg13cmos5l_dfrbp_1_0.D vdd vdd sg13_lv_pmos ad=79.8f pd=0.8u as=0.1428p ps=1.52u w=0.42u l=0.13u
M2203 SAR/a_3308_5376# SAR/sg13cmos5l_dlhr_1_1.Q vss vss sg13_lv_nmos ad=0.187p pd=1.78u as=0.14875p ps=1.16u w=0.55u l=0.13u
M2204 SAR/a_14900_2352# SAR/sg13cmos5l_nor2_1_1.A vdd vdd sg13_lv_pmos ad=0.2856p pd=2.36u as=0.2618p ps=1.63u w=0.84u l=0.13u
M2205 vdd SAR/sg13cmos5l_buf_1_34.X SAR/sg13cmos5l_buf_1_60.A vdd sg13_lv_pmos ad=0.3808p pd=2.92u as=0.3808p ps=2.92u w=1.12u l=0.13u
M2206 vss SAR/sg13cmos5l_inv_1_8.A SAR/sg13cmos5l_inv_1_8.Y vss sg13_lv_nmos ad=0.2516p pd=2.16u as=0.2516p ps=2.16u w=0.74u l=0.13u
M2207 SAR/a_2054_3138# SAR/sg13cmos5l_dfrbp_1_6.D vdd vdd sg13_lv_pmos ad=79.8f pd=0.8u as=0.1428p ps=1.52u w=0.42u l=0.13u
M2208 vss SAR/a_19227_4654# SAR/sg13cmos5l_buf_8_0.X vss sg13_lv_nmos ad=0.1406p pd=1.12u as=0.1406p ps=1.12u w=0.74u l=0.13u
M2209 SAR/a_3676_7964# SAR/sg13cmos5l_dfrbp_1_6.RESET_B vdd vdd sg13_lv_pmos ad=0.2128p pd=1.5u as=0.2128p ps=1.5u w=1.12u l=0.13u
M2210 nh_sw[3] SAR/a_5704_1664# vdd vdd sg13_lv_pmos ad=0.42p pd=2.99u as=0.2114p ps=1.54u w=1.12u l=0.13u
M2211 vss SAR/a_9164_1590# SAR/sg13cmos5l_buf_1_26.X vss sg13_lv_nmos ad=0.14875p pd=1.16u as=0.2886p ps=2.26u w=0.74u l=0.13u
M2212 SAR/a_17327_7285# SAR/a_16485_6935# SAR/a_17233_7285# vss sg13_lv_nmos ad=0.12665p pd=1.145u as=0.1428p ps=1.52u w=0.42u l=0.13u
M2213 vdd SAR/a_15821_3864# SAR/sg13cmos5l_dfrbp_1_6.Q_N vdd sg13_lv_pmos ad=0.2639p pd=1.81u as=0.4312p ps=3.01u w=1.12u l=0.13u
M2214 ph_sw[10] SAR/a_20392_6924# vss vss sg13_lv_nmos ad=0.2886p pd=2.26u as=0.14875p ps=1.16u w=0.74u l=0.13u
M2215 SAR/sg13cmos5l_dfrbp_1_3.Q_N SAR/a_18959_3215# vss vss sg13_lv_nmos ad=0.2849p pd=2.25u as=0.2516p ps=2.16u w=0.74u l=0.13u
M2216 vdd SAR/a_2757_3117# SAR/a_2859_3260# vdd sg13_lv_pmos ad=1.43437p pd=9.105u as=0.3864p ps=2.93u w=1.12u l=0.13u
M2217 SAR/a_11817_2435# SAR/a_11460_2392# vdd vdd sg13_lv_pmos ad=63f pd=0.72u as=0.1563p ps=1.22u w=0.42u l=0.13u
M2218 vdd SAR/a_17519_6239# SAR/a_17776_6382# vdd sg13_lv_pmos ad=0.2639p pd=1.81u as=79.8f ps=0.8u w=0.42u l=0.13u
M2219 vdd SAR/sg13cmos5l_dfrbp_1_10.Q SAR/a_4873_3192# vdd sg13_lv_pmos ad=1.43437p pd=9.105u as=0.2856p ps=2.36u w=0.84u l=0.13u
M2220 SAR/sg13cmos5l_dlhr_1_1.Q SAR/a_2409_4650# vdd vdd sg13_lv_pmos ad=0.3808p pd=2.92u as=0.2128p ps=1.5u w=1.12u l=0.13u
M2221 vss SAR/a_6959_6239# SAR/a_7796_6460# vss sg13_lv_nmos ad=0.1406p pd=1.12u as=0.2516p ps=2.16u w=0.74u l=0.13u
M2222 vss SAR/a_7504_8678# SAR/a_7153_8797# vss sg13_lv_nmos ad=79.8f pd=0.8u as=0.1428p ps=1.52u w=0.42u l=0.13u
M2223 SAR/a_17674_3361# SAR/a_18117_3117# SAR/a_18057_3529# vdd sg13_lv_pmos ad=79.8f pd=0.8u as=63f ps=0.72u w=0.42u l=0.13u
M2224 vss SAR/a_2732_9150# SAR/sg13cmos5l_buf_1_61.X vss sg13_lv_nmos ad=0.14875p pd=1.16u as=0.2886p ps=2.26u w=0.74u l=0.13u
M2225 vdd SAR/a_9189_8447# SAR/a_9291_8447# vdd sg13_lv_pmos ad=1.15047p pd=7.175u as=0.3864p ps=2.93u w=1.12u l=0.13u
M2226 vss SAR/a_4005_4629# SAR/a_4107_4772# vss sg13_lv_nmos ad=2.41737p pd=15.64u as=0.2516p ps=2.16u w=0.74u l=0.13u
M2227 vdd vss vdd vdd sg13_lv_pmos ad=0.34p pd=2.68u as=0 ps=0 w=1u l=1u
M2228 SAR/sg13cmos5l_inv_1_29.A SAR/a_12404_7972# vdd vdd sg13_lv_pmos ad=0.3808p pd=2.92u as=0.2128p ps=1.5u w=1.12u l=0.13u
M2229 vss SAR/sg13cmos5l_dfrbp_1_23.Q SAR/a_13792_5760# vss sg13_lv_nmos ad=0.1406p pd=1.12u as=0.1406p ps=1.12u w=0.74u l=0.13u
M2230 vss SAR/sg13cmos5l_dfrbp_1_6.RESET_B SAR/a_18580_7660# vss sg13_lv_nmos ad=0.1406p pd=1.12u as=77.7f ps=0.95u w=0.74u l=0.13u
M2231 SAR/a_17713_8838# SAR/a_17161_8794# vss vss sg13_lv_nmos ad=71.99999f pd=0.865u as=2.92392p ps=18.89u w=0.64u l=0.13u
M2232 SAR/a_15300_7687# SAR/a_15012_7992# SAR/a_15238_7687# vss sg13_lv_nmos ad=0.1428p pd=1.52u as=37.8f ps=0.6u w=0.42u l=0.13u
M2233 SAR/a_12933_6141# SAR/sg13cmos5l_dfrbp_1_23.CLK vss vss sg13_lv_nmos ad=0.2516p pd=2.16u as=1.97045p ps=12.335u w=0.74u l=0.13u
M2234 SAR/sg13cmos5l_buf_1_79.X SAR/a_9256_9224# vdd vdd sg13_lv_pmos ad=0.42p pd=2.99u as=0.2114p ps=1.54u w=1.12u l=0.13u
M2235 vss SAR/sg13cmos5l_inv_1_17.A SAR/sg13cmos5l_buf_1_37.A vss sg13_lv_nmos ad=0.2516p pd=2.16u as=0.2516p ps=2.16u w=0.74u l=0.13u
M2236 pl_sw[2] SAR/a_2248_9224# vss vss sg13_lv_nmos ad=0.2886p pd=2.26u as=0.14875p ps=1.16u w=0.74u l=0.13u
M2237 vdd SAR/a_9040_7894# SAR/a_8985_7989# vdd sg13_lv_pmos ad=1.15047p pd=7.175u as=93.45f ps=0.865u w=0.42u l=0.13u
M2238 SAR/sg13cmos5l_buf_1_1.A SAR/a_14056_1664# vss vss sg13_lv_nmos ad=0.2886p pd=2.26u as=0.14875p ps=1.16u w=0.74u l=0.13u
M2239 vdd SAR/a_5673_3138# SAR/a_6198_3120# vdd sg13_lv_pmos ad=0.1974p pd=1.5u as=0.2856p ps=2.36u w=0.84u l=0.13u
M2240 SAR/a_6660_4663# SAR/a_6891_4772# SAR/a_6346_4873# vss sg13_lv_nmos ad=0.2373p pd=1.97u as=79.8f ps=0.8u w=0.42u l=0.13u
M2241 SAR/a_6681_2511# SAR/a_5739_2399# SAR/a_6479_2749# vdd sg13_lv_pmos ad=93.45f pd=0.865u as=0.2048p ps=1.63u w=0.42u l=0.13u
M2242 vdd SAR/a_2732_1590# SAR/sg13cmos5l_buf_1_35.A vdd sg13_lv_pmos ad=0.2114p pd=1.54u as=0.42p ps=2.99u w=1.12u l=0.13u
M2243 SAR/sg13cmos5l_buf_8_0.X SAR/a_19227_4654# vdd vdd sg13_lv_pmos ad=0.2128p pd=1.5u as=0.2128p ps=1.5u w=1.12u l=0.13u
M2244 SAR/a_18574_5028# SAR/sg13cmos5l_dfrbp_1_0.D SAR/a_18480_5028# vdd sg13_lv_pmos ad=0.1596p pd=1.22u as=0.2856p ps=2.36u w=0.84u l=0.13u
M2245 SAR/a_16551_3987# SAR/a_16703_3871# vdd vdd sg13_lv_pmos ad=0.3864p pd=2.93u as=1.43437p ps=9.105u w=1.12u l=0.13u
M2246 vdd SAR/sg13cmos5l_buf_1_10.A SAR/a_12520_3176# vdd sg13_lv_pmos ad=0.2114p pd=1.54u as=0.2856p ps=2.36u w=0.84u l=0.13u
M2247 vdd SAR/sg13cmos5l_o21ai_1_0.B1 SAR/sg13cmos5l_o21ai_1_0.Y vdd sg13_lv_pmos ad=0.3808p pd=2.92u as=0.2128p ps=1.5u w=1.12u l=0.15u
M2248 vdd SAR/a_16271_7751# SAR/a_17108_7972# vdd sg13_lv_pmos ad=0.2128p pd=1.5u as=0.3864p ps=2.93u w=1.12u l=0.13u
M2249 vdd SAR/a_19244_2352# nl_sw[9] vdd sg13_lv_pmos ad=0.2114p pd=1.54u as=0.42p ps=2.99u w=1.12u l=0.13u
M2250 vss SAR/a_908_1590# SAR/sg13cmos5l_buf_1_32.X vss sg13_lv_nmos ad=0.14875p pd=1.16u as=0.2886p ps=2.26u w=0.74u l=0.13u
M2251 vss vdd vss vss sg13_lv_nmos ad=79.8f pd=0.8u as=0 ps=0 w=0.42u l=1u
M2252 SAR/a_17780_8436# SAR/a_17367_8794# SAR/a_17712_8436# vdd sg13_lv_pmos ad=0.191p pd=1.44u as=0.105p ps=1.21u w=1u l=0.13u
M2253 SAR/a_15876_7362# SAR/sg13cmos5l_dfrbp_1_22.D SAR/a_15782_7362# vss sg13_lv_nmos ad=60.89999f pd=0.71u as=0.1428p ps=1.52u w=0.42u l=0.13u
M2254 SAR/a_17916_8838# SAR/a_17367_8794# SAR/a_17780_8436# vss sg13_lv_nmos ad=47.25f pd=0.645u as=0.141p ps=1.17u w=0.42u l=0.13u
M2255 SAR/sg13cmos5l_buf_1_93.X SAR/a_14632_9224# vdd vdd sg13_lv_pmos ad=0.42p pd=2.99u as=0.2114p ps=1.54u w=1.12u l=0.13u
M2256 SAR/a_2348_7624# SAR/a_2596_7996# SAR/a_2554_8112# vdd sg13_lv_pmos ad=0.191p pd=1.44u as=0.1008p ps=0.9u w=0.42u l=0.13u
M2257 vdd SAR/a_9705_4650# SAR/a_9638_5088# vdd sg13_lv_pmos ad=0.2387p pd=1.84u as=0.1008p ps=0.9u w=0.42u l=0.13u
M2258 vdd SAR/sg13cmos5l_inv_1_8.A SAR/a_5951_5383# vdd sg13_lv_pmos ad=1.2517p pd=7.955u as=0.4088p ps=2.97u w=1.12u l=0.13u
M2259 nl_sw[2] SAR/a_2248_1664# vdd vdd sg13_lv_pmos ad=0.42p pd=2.99u as=0.2114p ps=1.54u w=1.12u l=0.13u
M2260 SAR/sg13cmos5l_or2_1_0.A SAR/a_18363_4270# vdd vdd sg13_lv_pmos ad=0.2128p pd=1.5u as=0.2128p ps=1.5u w=1.12u l=0.13u
M2261 vss SAR/sg13cmos5l_a221oi_1_0.B2 SAR/a_11488_4676# vss sg13_lv_nmos ad=0.1406p pd=1.12u as=0.1406p ps=1.12u w=0.74u l=0.13u
M2262 vss SAR/sg13cmos5l_a22oi_1_1.B1 SAR/a_15062_4292# vss sg13_lv_nmos ad=0.2553p pd=2.17u as=0.13875p ps=1.115u w=0.74u l=0.13u
M2263 vdd SAR/a_14543_3215# SAR/a_14800_3358# vdd sg13_lv_pmos ad=0.2639p pd=1.81u as=79.8f ps=0.8u w=0.42u l=0.13u
M2264 SAR/a_18860_6888# SAR/sg13cmos5l_buf_1_87.A vdd vdd sg13_lv_pmos ad=0.2856p pd=2.36u as=0.2114p ps=1.54u w=0.84u l=0.13u
M2265 SAR/a_11364_1626# SAR/sg13cmos5l_dfrbp_1_1.D SAR/a_11270_1626# vss sg13_lv_nmos ad=60.89999f pd=0.71u as=0.1428p ps=1.52u w=0.42u l=0.13u
M2266 vss SAR/a_20012_2352# nl_sw[10] vss sg13_lv_nmos ad=0.14875p pd=1.16u as=0.2886p ps=2.26u w=0.74u l=0.13u
M2267 SAR/a_6086_4650# SAR/sg13cmos5l_dlhr_1_0.GATE vdd vdd sg13_lv_pmos ad=79.8f pd=0.8u as=0.1428p ps=1.52u w=0.42u l=0.13u
M2268 SAR/a_16748_9150# SAR/sg13cmos5l_buf_1_93.X vss vss sg13_lv_nmos ad=0.187p pd=1.78u as=0.14875p ps=1.16u w=0.55u l=0.13u
M2269 SAR/a_5988_8440# SAR/a_5962_8404# vss vss sg13_lv_nmos ad=0.2516p pd=2.16u as=0.1626p ps=1.415u w=0.74u l=0.13u
M2270 vdd SAR/a_7247_8797# SAR/a_7504_8678# vdd sg13_lv_pmos ad=0.2639p pd=1.81u as=79.8f ps=0.8u w=0.42u l=0.13u
M2271 SAR/a_682_5380# SAR/a_1125_5423# SAR/a_422_5850# vss sg13_lv_nmos ad=79.8f pd=0.8u as=0.1296p ps=1.52u w=0.42u l=0.13u
M2272 SAR/sg13cmos5l_o21ai_1_0.A1 SAR/sg13cmos5l_inv_1_0.Y SAR/a_11182_4676# vss sg13_lv_nmos ad=0.2516p pd=2.16u as=0.1406p ps=1.12u w=0.74u l=0.13u
M2273 vdd SAR/sg13cmos5l_dfrbp_1_8.RESET_B SAR/a_5962_8404# vdd sg13_lv_pmos ad=0.1563p pd=1.22u as=0.147p ps=1.54u w=0.42u l=0.13u
M2274 SAR/a_14726_7674# SAR/a_15531_7796# SAR/a_14986_7897# vdd sg13_lv_pmos ad=0.1428p pd=1.52u as=79.8f ps=0.8u w=0.42u l=0.13u
M2275 SAR/sg13cmos5l_buf_1_57.X SAR/a_9448_6924# vss vss sg13_lv_nmos ad=0.2886p pd=2.26u as=0.14875p ps=1.16u w=0.74u l=0.13u
M2276 SAR/a_8852_6484# SAR/a_8439_6178# SAR/a_8784_6484# vdd sg13_lv_pmos ad=0.191p pd=1.44u as=0.105p ps=1.21u w=1u l=0.13u
M2277 SAR/a_4176_6924# SAR/a_3625_7282# vdd vdd sg13_lv_pmos ad=0.105p pd=1.21u as=1.07253p ps=6.75u w=1u l=0.13u
M2278 SAR/a_13092_3138# SAR/sg13cmos5l_o21ai_1_0.Y SAR/a_12998_3138# vss sg13_lv_nmos ad=60.89999f pd=0.71u as=0.1428p ps=1.52u w=0.42u l=0.13u
M2279 SAR/a_16462_4338# SAR/a_16204_4338# vss vss sg13_lv_nmos ad=0.1428p pd=1.52u as=79.8f ps=0.8u w=0.42u l=0.13u
M2280 vdd SAR/sg13cmos5l_dlhr_1_12.D SAR/a_17161_8794# vdd sg13_lv_pmos ad=1.15047p pd=7.175u as=0.2856p ps=2.36u w=0.84u l=0.13u
M2281 _cko SAR/a_20392_7712# vss vss sg13_lv_nmos ad=0.2886p pd=2.26u as=0.14875p ps=1.16u w=0.74u l=0.13u
M2282 SAR/a_15821_3864# SAR/a_16551_3987# SAR/a_16462_4023# vdd sg13_lv_pmos ad=0.2048p pd=1.63u as=93.45f ps=0.865u w=0.42u l=0.13u
M2283 vss SAR/a_19227_4654# SAR/sg13cmos5l_buf_8_0.X vss sg13_lv_nmos ad=0.1406p pd=1.12u as=0.1406p ps=1.12u w=0.74u l=0.13u
M2284 SAR/sg13cmos5l_buf_8_2.X SAR/a_19227_9190# vss vss sg13_lv_nmos ad=0.1406p pd=1.12u as=0.1406p ps=1.12u w=0.74u l=0.13u
M2285 SAR/sg13cmos5l_dlhr_1_0.Q_N SAR/a_8214_1608# vss vss sg13_lv_nmos ad=0.2516p pd=2.16u as=0.1491p ps=1.18u w=0.74u l=0.13u
M2286 SAR/a_8783_7751# SAR/a_7941_7653# SAR/a_8689_7751# vss sg13_lv_nmos ad=0.12665p pd=1.145u as=0.1428p ps=1.52u w=0.42u l=0.13u
M2287 vdd SAR/sg13cmos5l_dfrbp_1_8.RESET_B SAR/a_1862_4338# vdd sg13_lv_pmos ad=0.36237p pd=2.605u as=79.8f ps=0.8u w=0.42u l=0.13u
M2288 vdd SAR/a_6959_6239# SAR/a_7216_6382# vdd sg13_lv_pmos ad=0.2639p pd=1.81u as=79.8f ps=0.8u w=0.42u l=0.13u
M2289 SAR/a_16294_7349# SAR/sg13cmos5l_dfrbp_1_8.RESET_B vss vss sg13_lv_nmos ad=37.8f pd=0.6u as=0.1701p ps=1.65u w=0.42u l=0.13u
M2290 SAR/a_12516_6480# SAR/a_13035_6284# SAR/a_13775_6239# vss sg13_lv_nmos ad=0.3473p pd=2.71u as=0.12665p ps=1.145u w=0.74u l=0.13u
M2291 SAR/a_16528_7894# SAR/sg13cmos5l_dfrbp_1_6.RESET_B vdd vdd sg13_lv_pmos ad=79.8f pd=0.8u as=1.12242p ps=7u w=0.42u l=0.13u
M2292 SAR/a_8692_7312# SAR/a_8276_6924# SAR/a_8457_7281# vss sg13_lv_nmos ad=77.7f pd=0.95u as=0.2516p ps=2.16u w=0.74u l=0.13u
M2293 SAR/a_8588_2352# SAR/sg13cmos5l_buf_1_26.X vss vss sg13_lv_nmos ad=0.187p pd=1.78u as=0.14875p ps=1.16u w=0.55u l=0.13u
M2294 vss SAR/a_11973_3911# SAR/a_12075_3911# vss sg13_lv_nmos ad=2.41737p pd=15.64u as=0.2516p ps=2.16u w=0.74u l=0.13u
M2295 vss SAR/a_13047_7690# SAR/a_13178_7684# vss sg13_lv_nmos ad=1.49685p pd=9.6u as=0.2775p ps=2.23u w=0.74u l=0.13u
M2296 SAR/a_11370_5760# SAR/sg13cmos5l_inv_1_0.A SAR/a_11268_5760# vss sg13_lv_nmos ad=0.1216p pd=1.02u as=0.1216p ps=1.02u w=0.64u l=0.13u
M2297 SAR/a_5637_2399# SAR/sg13cmos5l_dlhr_1_0.GATE vdd vdd sg13_lv_pmos ad=0.4088p pd=2.97u as=1.777p ps=11.395u w=1.12u l=0.13u
M2298 SAR/sg13cmos5l_dfrbp_1_2.Q_N SAR/a_12815_4261# vdd vdd sg13_lv_pmos ad=0.4312p pd=3.01u as=0.2639p ps=1.81u w=1.12u l=0.13u
M2299 SAR/a_13486_5760# SAR/sg13cmos5l_nor2b_1_0.Y vss vss sg13_lv_nmos ad=0.1406p pd=1.12u as=0.2516p ps=2.16u w=0.74u l=0.13u
M2300 SAR/a_17170_2826# SAR/sg13cmos5l_dfrbp_1_0.RESET_B vss vss sg13_lv_nmos ad=37.8f pd=0.6u as=79.8f ps=0.8u w=0.42u l=0.13u
M2301 vss SAR/sg13cmos5l_dfrbp_1_20.Q SAR/a_9865_7282# vss sg13_lv_nmos ad=0.15055p pd=1.17u as=0.187p ps=1.78u w=0.55u l=0.13u
M2302 vdd SAR/a_14924_1590# nh_sw[6] vdd sg13_lv_pmos ad=0.2114p pd=1.54u as=0.42p ps=2.99u w=1.12u l=0.13u
M2303 SAR/a_10318_5412# SAR/sg13cmos5l_a221oi_1_0.C1 SAR/a_10420_5412# vdd sg13_lv_pmos ad=0.3808p pd=2.92u as=0.2128p ps=1.5u w=1.12u l=0.13u
M2304 SAR/sg13cmos5l_inv_1_5.A SAR/a_19796_3436# vss vss sg13_lv_nmos ad=0.2516p pd=2.16u as=0.1406p ps=1.12u w=0.74u l=0.13u
M2305 SAR/sg13cmos5l_dfrbp_1_27.Q_N SAR/a_10031_8797# vss vss sg13_lv_nmos ad=0.2849p pd=2.25u as=0.2516p ps=2.16u w=0.74u l=0.13u
M2306 SAR/a_5079_3154# SAR/sg13cmos5l_dfrbp_1_9.Q vss vss sg13_lv_nmos ad=0.2516p pd=2.16u as=0.15055p ps=1.17u w=0.74u l=0.13u
M2307 SAR/a_17399_3947# SAR/sg13cmos5l_dfrbp_1_6.RESET_B vdd vdd sg13_lv_pmos ad=79.8f pd=0.8u as=0.36237p ps=2.605u w=0.42u l=0.13u
M2308 SAR/sg13cmos5l_dfrbp_1_11.Q_N SAR/a_7631_4727# vdd vdd sg13_lv_pmos ad=0.4312p pd=3.01u as=0.2639p ps=1.81u w=1.12u l=0.13u
M2309 SAR/a_15045_8447# SAR/sg13cmos5l_inv_1_2.A vdd vdd sg13_lv_pmos ad=0.4088p pd=2.97u as=1.12242p ps=7u w=1.12u l=0.13u
M2310 vss SAR/a_14583_5770# SAR/a_14714_5776# vss sg13_lv_nmos ad=1.97045p pd=12.335u as=0.2775p ps=2.23u w=0.74u l=0.13u
M2311 SAR/a_4950_5699# SAR/a_5069_5376# vss vss sg13_lv_nmos ad=0.2516p pd=2.16u as=0.1406p ps=1.12u w=0.74u l=0.13u
M2312 vdd SAR/a_19227_9190# SAR/sg13cmos5l_buf_8_2.X vdd sg13_lv_pmos ad=0.3864p pd=2.93u as=0.2128p ps=1.5u w=1.12u l=0.13u
M2313 SAR/sg13cmos5l_dlhr_1_20.Q_N SAR/a_10230_4632# vdd vdd sg13_lv_pmos ad=0.3808p pd=2.92u as=0.1974p ps=1.5u w=1.12u l=0.13u
M2314 vss SAR/sg13cmos5l_inv_1_6.A SAR/sg13cmos5l_buf_1_0.A vss sg13_lv_nmos ad=0.2516p pd=2.16u as=0.2516p ps=2.16u w=0.74u l=0.13u
M2315 vdd SAR/a_16144_8678# SAR/a_16089_8559# vdd sg13_lv_pmos ad=1.15047p pd=7.175u as=93.45f ps=0.865u w=0.42u l=0.13u
M2316 SAR/sg13cmos5l_buf_1_5.X SAR/a_14440_1664# vdd vdd sg13_lv_pmos ad=0.42p pd=2.99u as=0.2114p ps=1.54u w=1.12u l=0.13u
M2317 SAR/a_14854_8861# SAR/sg13cmos5l_dfrbp_1_8.RESET_B vss vss sg13_lv_nmos ad=37.8f pd=0.6u as=0.1701p ps=1.65u w=0.42u l=0.13u
M2318 vdd SAR/sg13cmos5l_buf_1_30.A SAR/sg13cmos5l_buf_1_73.A vdd sg13_lv_pmos ad=0.3808p pd=2.92u as=0.3808p ps=2.92u w=1.12u l=0.13u
M2319 SAR/a_2169_5535# SAR/a_1227_5423# SAR/a_1967_5773# vdd sg13_lv_pmos ad=93.45f pd=0.865u as=0.2048p ps=1.63u w=0.42u l=0.13u
M2320 SAR/sg13cmos5l_dlhr_1_21.Q_N SAR/a_10998_9168# vss vss sg13_lv_nmos ad=0.2516p pd=2.16u as=0.1491p ps=1.18u w=0.74u l=0.13u
M2321 vdd SAR/sg13cmos5l_buf_1_73.X SAR/a_5800_9224# vdd sg13_lv_pmos ad=0.2114p pd=1.54u as=0.2856p ps=2.36u w=0.84u l=0.13u
M2322 vdd SAR/sg13cmos5l_dfrbp_1_23.Q_N SAR/a_14377_5770# vdd sg13_lv_pmos ad=1.28962p pd=8.195u as=0.2856p ps=2.36u w=0.84u l=0.13u
M2323 vss SAR/sg13cmos5l_dfrbp_1_6.RESET_B SAR/a_516_7362# vss sg13_lv_nmos ad=0.1626p pd=1.415u as=60.89999f ps=0.71u w=0.42u l=0.13u
M2324 SAR/a_17829_1605# SAR/sg13cmos5l_dfrbp_1_0.CLK vss vss sg13_lv_nmos ad=0.2516p pd=2.16u as=5.84582p ps=38.34u w=0.74u l=0.13u
M2325 vss SAR/a_7216_6382# SAR/a_6865_6239# vss sg13_lv_nmos ad=79.8f pd=0.8u as=0.1428p ps=1.52u w=0.42u l=0.13u
M2326 vss SAR/sg13cmos5l_buf_8_0.A SAR/a_19227_4654# vss sg13_lv_nmos ad=0.1406p pd=1.12u as=0.1406p ps=1.12u w=0.74u l=0.13u
M2327 vdd SAR/sg13cmos5l_dfrbp_1_8.RESET_B SAR/a_5702_8874# vdd sg13_lv_pmos ad=0.36237p pd=2.605u as=79.8f ps=0.8u w=0.42u l=0.13u
M2328 SAR/a_12804_6175# SAR/a_13035_6284# SAR/a_12490_6385# vss sg13_lv_nmos ad=0.2373p pd=1.97u as=79.8f ps=0.8u w=0.42u l=0.13u
M2329 SAR/a_18860_9150# SAR/sg13cmos5l_buf_1_101.X vss vss sg13_lv_nmos ad=0.187p pd=1.78u as=0.14875p ps=1.16u w=0.55u l=0.13u
M2330 vss SAR/a_19209_5769# SAR/a_19164_5814# vss sg13_lv_nmos ad=0.1428p pd=1.52u as=47.25f ps=0.645u w=0.42u l=0.13u
M2331 SAR/a_11873_5760# SAR/sg13cmos5l_inv_1_29.Y SAR/sg13cmos5l_a221oi_1_0.B2 vss sg13_lv_nmos ad=0.1406p pd=1.12u as=0.1406p ps=1.12u w=0.74u l=0.13u
M2332 vss SAR/sg13cmos5l_nand2_1_1.A SAR/a_20008_3900# vss sg13_lv_nmos ad=0.14875p pd=1.16u as=0.187p ps=1.78u w=0.55u l=0.13u
M2333 SAR/a_11980_4948# SAR/sg13cmos5l_inv_1_0.A SAR/sg13cmos5l_a221oi_1_0.C1 vdd sg13_lv_pmos ad=0.1176p pd=1.33u as=0.3808p ps=2.92u w=1.12u l=0.13u
M2334 vdd SAR/a_8841_5769# SAR/a_9366_5842# vdd sg13_lv_pmos ad=0.1974p pd=1.5u as=0.2856p ps=2.36u w=0.84u l=0.13u
M2335 vss SAR/a_7497_3138# SAR/a_7452_3174# vss sg13_lv_nmos ad=0.1428p pd=1.52u as=47.25f ps=0.645u w=0.42u l=0.13u
M2336 vss vdd vss vss sg13_lv_nmos ad=79.8f pd=0.8u as=0 ps=0 w=0.42u l=1u
M2337 SAR/sg13cmos5l_buf_1_97.A SAR/a_10473_9186# vdd vdd sg13_lv_pmos ad=0.3808p pd=2.92u as=0.2128p ps=1.5u w=1.12u l=0.13u
M2338 vdd SAR/a_11877_2399# SAR/a_11979_2399# vdd sg13_lv_pmos ad=1.86162p pd=11.935u as=0.3864p ps=2.93u w=1.12u l=0.13u
M2339 vdd SAR/sg13cmos5l_dlygate4sd2_1_0.A SAR/a_902_3142# vdd sg13_lv_pmos ad=0.2481p pd=1.56u as=0.1428p ps=1.52u w=0.42u l=0.13u
M2340 vss SAR/a_7247_8797# SAR/a_8084_8436# vss sg13_lv_nmos ad=0.1406p pd=1.12u as=0.2516p ps=2.16u w=0.74u l=0.13u
M2341 SAR/sg13cmos5l_o21ai_1_0.A2 SAR/sg13cmos5l_nand2_1_0.A SAR/a_11002_3142# vss sg13_lv_nmos ad=0.2516p pd=2.16u as=0.1406p ps=1.12u w=0.74u l=0.13u
M2342 SAR/a_16260_6480# SAR/a_16234_6385# vss vss sg13_lv_nmos ad=0.2516p pd=2.16u as=0.1626p ps=1.415u w=0.74u l=0.13u
M2343 SAR/a_3876_4663# SAR/a_4107_4772# SAR/a_3562_4873# vss sg13_lv_nmos ad=0.2373p pd=1.97u as=79.8f ps=0.8u w=0.42u l=0.13u
M2344 vss SAR/sg13cmos5l_dfrbp_1_8.RESET_B SAR/a_3396_4650# vss sg13_lv_nmos ad=0.1626p pd=1.415u as=60.89999f ps=0.71u w=0.42u l=0.13u
M2345 SAR/a_11913_2017# SAR/a_11556_1944# vdd vdd sg13_lv_pmos ad=63f pd=0.72u as=0.1563p ps=1.22u w=0.42u l=0.13u
M2346 SAR/a_4076_5376# SAR/sg13cmos5l_dlhr_1_9.Q vss vss sg13_lv_nmos ad=0.187p pd=1.78u as=0.14875p ps=1.16u w=0.55u l=0.13u
M2347 vss SAR/a_6789_4629# SAR/a_6891_4772# vss sg13_lv_nmos ad=2.41737p pd=15.64u as=0.2516p ps=2.16u w=0.74u l=0.13u
M2348 vss SAR/a_7689_1626# SAR/a_8214_1608# vss sg13_lv_nmos ad=0.1491p pd=1.18u as=0.187p ps=1.78u w=0.55u l=0.13u
M2349 SAR/sg13cmos5l_buf_8_0.X SAR/a_19227_4654# vdd vdd sg13_lv_pmos ad=0.2128p pd=1.5u as=0.2128p ps=1.5u w=1.12u l=0.13u
M2350 SAR/a_9111_4666# SAR/sg13cmos5l_dfrbp_1_11.Q vss vss sg13_lv_nmos ad=0.2516p pd=2.16u as=0.15055p ps=1.17u w=0.74u l=0.13u
M2351 SAR/sg13cmos5l_dfrbp_1_15.D SAR/a_4244_8436# vdd vdd sg13_lv_pmos ad=0.3808p pd=2.92u as=0.2128p ps=1.5u w=1.12u l=0.13u
M2352 SAR/a_17412_1944# SAR/a_17931_1748# SAR/a_18671_1703# vss sg13_lv_nmos ad=0.3473p pd=2.71u as=0.12665p ps=1.145u w=0.74u l=0.13u
M2353 _d2 SAR/a_20392_3900# vdd vdd sg13_lv_pmos ad=0.42p pd=2.99u as=0.2114p ps=1.54u w=1.12u l=0.13u
M2354 SAR/sg13cmos5l_nand2_1_0.B SAR/a_10587_4692# SAR/a_10789_4654# vss sg13_lv_nmos ad=0.333p pd=2.38u as=0.1406p ps=1.12u w=0.74u l=0.13u
M2355 vss _cks SAR/sg13cmos5l_dfrbp_1_0.RESET_B vss sg13_lv_nmos ad=0.2516p pd=2.16u as=0.2516p ps=2.16u w=0.74u l=0.13u
M2356 SAR/a_1815_4666# SAR/sg13cmos5l_dlhr_1_1.GATE vss vss sg13_lv_nmos ad=0.2516p pd=2.16u as=0.15055p ps=1.17u w=0.74u l=0.13u
M2357 SAR/a_17829_1605# SAR/sg13cmos5l_dfrbp_1_0.CLK vdd vdd sg13_lv_pmos ad=0.4088p pd=2.97u as=1.777p ps=11.395u w=1.12u l=0.13u
M2358 SAR/a_8592_5412# SAR/a_8041_5770# vdd vdd sg13_lv_pmos ad=0.105p pd=1.21u as=1.28962p ps=8.195u w=1u l=0.13u
M2359 SAR/a_9879_9202# SAR/sg13cmos5l_dfrbp_1_18.Q vss vss sg13_lv_nmos ad=0.2516p pd=2.16u as=0.15055p ps=1.17u w=0.74u l=0.13u
M2360 SAR/a_12132_9504# SAR/a_12651_9308# SAR/a_13391_9263# vss sg13_lv_nmos ad=0.3473p pd=2.71u as=0.12665p ps=1.145u w=0.74u l=0.13u
M2361 vdd SAR/sg13cmos5l_buf_1_3.X SAR/a_20392_3176# vdd sg13_lv_pmos ad=0.2114p pd=1.54u as=0.2856p ps=2.36u w=0.84u l=0.13u
M2362 SAR/a_10028_6126# SAR/sg13cmos5l_buf_1_56.A vdd vdd sg13_lv_pmos ad=0.2856p pd=2.36u as=0.2114p ps=1.54u w=0.84u l=0.13u
M2363 vss vdd vss vss sg13_lv_nmos ad=0.1428p pd=1.52u as=0 ps=0 w=0.42u l=1u
M2364 SAR/a_4018_3138# SAR/sg13cmos5l_dfrbp_1_6.RESET_B vss vss sg13_lv_nmos ad=37.8f pd=0.6u as=79.8f ps=0.8u w=0.42u l=0.13u
M2365 vss SAR/a_8204_9150# SAR/sg13cmos5l_buf_1_74.X vss sg13_lv_nmos ad=0.14875p pd=1.16u as=0.2886p ps=2.26u w=0.74u l=0.13u
M2366 SAR/a_1662_8374# SAR/a_1463_8511# vss vss sg13_lv_nmos ad=0.27427p pd=2.28u as=2.92392p ps=18.89u w=0.795u l=0.13u
M2367 SAR/sg13cmos5l_buf_1_4.X SAR/a_16552_1664# vdd vdd sg13_lv_pmos ad=0.42p pd=2.99u as=0.2114p ps=1.54u w=1.12u l=0.13u
M2368 vss vdd vss vss sg13_lv_nmos ad=79.8f pd=0.8u as=0 ps=0 w=0.42u l=1u
M2369 SAR/a_12549_9165# SAR/sg13cmos5l_inv_1_2.A vdd vdd sg13_lv_pmos ad=0.4088p pd=2.97u as=4.11675p ps=27.17u w=1.12u l=0.13u
M2370 vdd SAR/a_2224_7166# SAR/a_2169_7047# vdd sg13_lv_pmos ad=1.07253p pd=6.75u as=93.45f ps=0.865u w=0.42u l=0.13u
M2371 vss SAR/a_4559_7630# SAR/a_4514_7666# vss sg13_lv_nmos ad=1.49685p pd=9.6u as=71.99999f ps=0.865u w=0.64u l=0.13u
M2372 vss SAR/sg13cmos5l_dfrbp_1_1.Q SAR/a_20392_2388# vss sg13_lv_nmos ad=0.14875p pd=1.16u as=0.187p ps=1.78u w=0.55u l=0.13u
M2373 SAR/a_11824_7894# SAR/a_11567_7751# SAR/a_11986_7674# vss sg13_lv_nmos ad=0.1428p pd=1.52u as=37.8f ps=0.6u w=0.42u l=0.13u
M2374 vdd SAR/a_5079_3154# SAR/a_5210_3148# vdd sg13_lv_pmos ad=1.43437p pd=9.105u as=0.2856p ps=2.36u w=0.84u l=0.13u
M2375 SAR/a_6572_1590# SAR/sg13cmos5l_buf_1_24.A vss vss sg13_lv_nmos ad=0.187p pd=1.78u as=0.14875p ps=1.16u w=0.55u l=0.13u
M2376 SAR/sg13cmos5l_buf_8_2.X SAR/a_19227_9190# vss vss sg13_lv_nmos ad=0.1406p pd=1.12u as=0.1406p ps=1.12u w=0.74u l=0.13u
M2377 vss SAR/a_15177_5769# SAR/a_15132_5814# vss sg13_lv_nmos ad=0.1428p pd=1.52u as=47.25f ps=0.645u w=0.42u l=0.13u
M2378 SAR/a_14436_8874# SAR/sg13cmos5l_dfrbp_1_23.CLK SAR/a_14342_8874# vss sg13_lv_nmos ad=60.89999f pd=0.71u as=0.1428p ps=1.52u w=0.42u l=0.13u
M2379 vdd vss vdd vdd sg13_lv_pmos ad=0.34p pd=2.68u as=0 ps=0 w=1u l=1u
M2380 SAR/sg13cmos5l_dlhr_1_7.Q_N SAR/a_4950_7354# vss vss sg13_lv_nmos ad=0.2516p pd=2.16u as=0.1491p ps=1.18u w=0.74u l=0.13u
M2381 SAR/sg13cmos5l_buf_1_34.A SAR/a_4041_2745# vss vss sg13_lv_nmos ad=0.2516p pd=2.16u as=0.1406p ps=1.12u w=0.74u l=0.13u
M2382 vdd SAR/sg13cmos5l_dfrbp_1_0.RESET_B SAR/a_17674_3361# vdd sg13_lv_pmos ad=0.1563p pd=1.22u as=0.147p ps=1.54u w=0.42u l=0.13u
M2383 SAR/a_11174_2826# SAR/a_11979_2399# SAR/a_11434_2356# vdd sg13_lv_pmos ad=0.1428p pd=1.52u as=79.8f ps=0.8u w=0.42u l=0.13u
M2384 vdd SAR/sg13cmos5l_dfrbp_1_6.RESET_B SAR/a_7497_3138# vdd sg13_lv_pmos ad=0.2128p pd=1.5u as=0.2128p ps=1.5u w=1.12u l=0.13u
M2385 vss SAR/a_10473_9186# SAR/a_10998_9168# vss sg13_lv_nmos ad=0.1491p pd=1.18u as=0.187p ps=1.78u w=0.55u l=0.13u
M2386 SAR/a_15300_2826# SAR/sg13cmos5l_nor2b_1_1.Y SAR/a_15206_2826# vss sg13_lv_nmos ad=60.89999f pd=0.71u as=0.1428p ps=1.52u w=0.42u l=0.13u
M2387 SAR/a_19378_3138# SAR/sg13cmos5l_dfrbp_1_0.RESET_B vss vss sg13_lv_nmos ad=37.8f pd=0.6u as=79.8f ps=0.8u w=0.42u l=0.13u
M2388 SAR/a_8972_3864# SAR/sg13cmos5l_buf_1_45.A vss vss sg13_lv_nmos ad=0.187p pd=1.78u as=0.14875p ps=1.16u w=0.55u l=0.13u
M2389 SAR/a_8247_5770# SAR/sg13cmos5l_dfrbp_1_11.Q vdd vdd sg13_lv_pmos ad=0.3234p pd=2.45u as=1.2517p ps=7.955u w=0.84u l=0.13u
M2390 SAR/a_5700_6480# SAR/a_5674_6385# vss vss sg13_lv_nmos ad=0.2516p pd=2.16u as=0.1626p ps=1.415u w=0.74u l=0.13u
M2391 vss SAR/sg13cmos5l_dlhr_1_10.Q SAR/a_19528_6924# vss sg13_lv_nmos ad=0.14875p pd=1.16u as=0.187p ps=1.78u w=0.55u l=0.13u
M2392 vss SAR/sg13cmos5l_buf_1_97.A SAR/a_11848_8436# vss sg13_lv_nmos ad=0.14875p pd=1.16u as=0.187p ps=1.78u w=0.55u l=0.13u
M2393 SAR/a_11686_2813# SAR/sg13cmos5l_dfrbp_1_0.RESET_B vss vss sg13_lv_nmos ad=37.8f pd=0.6u as=0.1701p ps=1.65u w=0.42u l=0.13u
M2394 vdd SAR/sg13cmos5l_dfrbp_1_20.Q SAR/a_9865_7282# vdd sg13_lv_pmos ad=1.07253p pd=6.75u as=0.2856p ps=2.36u w=0.84u l=0.13u
M2395 SAR/a_19628_2352# SAR/sg13cmos5l_buf_1_19.X vdd vdd sg13_lv_pmos ad=0.2856p pd=2.36u as=0.2114p ps=1.54u w=0.84u l=0.13u
M2396 vdd SAR/a_6188_1590# SAR/sg13cmos5l_buf_1_25.X vdd sg13_lv_pmos ad=0.2114p pd=1.54u as=0.42p ps=2.99u w=1.12u l=0.13u
M2397 vdd SAR/a_1006_4167# SAR/sg13cmos5l_dlygate4sd3_1_0.X vdd sg13_lv_pmos ad=0.2254p pd=1.53u as=0.4256p ps=3u w=1.12u l=0.13u
M2398 SAR/a_620_7638# SAR/sg13cmos5l_buf_1_63.X vss vss sg13_lv_nmos ad=0.187p pd=1.78u as=0.14875p ps=1.16u w=0.55u l=0.13u
M2399 vss SAR/a_5324_1590# SAR/sg13cmos5l_buf_1_39.A vss sg13_lv_nmos ad=0.14875p pd=1.16u as=0.2886p ps=2.26u w=0.74u l=0.13u
M2400 SAR/a_5710_5850# SAR/a_5951_5383# SAR/a_5069_5376# vss sg13_lv_nmos ad=0.1428p pd=1.52u as=0.12665p ps=1.145u w=0.42u l=0.13u
M2401 SAR/sg13cmos5l_dfrbp_1_6.RESET_B _cks vss vss sg13_lv_nmos ad=0.1406p pd=1.12u as=0.1406p ps=1.12u w=0.74u l=0.13u
M2402 vdd SAR/a_1878_6337# SAR/sg13cmos5l_dlhr_1_1.GATE vdd sg13_lv_pmos ad=0.2128p pd=1.5u as=0.3808p ps=2.92u w=1.12u l=0.13u
M2403 SAR/sg13cmos5l_buf_1_18.X SAR/a_18376_2388# vdd vdd sg13_lv_pmos ad=0.42p pd=2.99u as=0.2114p ps=1.54u w=1.12u l=0.13u
M2404 vdd SAR/a_7052_9150# SAR/sg13cmos5l_buf_1_76.X vdd sg13_lv_pmos ad=0.2114p pd=1.54u as=0.42p ps=2.99u w=1.12u l=0.13u
M2405 SAR/a_8852_6484# SAR/a_8570_6172# SAR/a_8785_6154# vss sg13_lv_nmos ad=0.141p pd=1.17u as=71.99999f ps=0.865u w=0.64u l=0.13u
M2406 SAR/sg13cmos5l_buf_1_26.A SAR/sg13cmos5l_buf_1_45.X vss vss sg13_lv_nmos ad=0.2516p pd=2.16u as=0.2516p ps=2.16u w=0.74u l=0.13u
M2407 SAR/a_13775_6239# SAR/a_12933_6141# SAR/a_13681_6239# vss sg13_lv_nmos ad=0.12665p pd=1.145u as=0.1428p ps=1.52u w=0.42u l=0.13u
M2408 vdd SAR/sg13cmos5l_dfrbp_1_0.RESET_B SAR/a_12998_3138# vdd sg13_lv_pmos ad=0.36237p pd=2.605u as=79.8f ps=0.8u w=0.42u l=0.13u
M2409 vss SAR/a_6213_3911# SAR/a_6315_3911# vss sg13_lv_nmos ad=2.41737p pd=15.64u as=0.2516p ps=2.16u w=0.74u l=0.13u
M2410 SAR/a_2364_4686# SAR/a_1815_4666# SAR/a_2228_4972# vss sg13_lv_nmos ad=47.25f pd=0.645u as=0.141p ps=1.17u w=0.42u l=0.13u
M2411 SAR/a_6276_8861# SAR/a_6507_8447# SAR/a_5962_8404# vss sg13_lv_nmos ad=0.2373p pd=1.97u as=79.8f ps=0.8u w=0.42u l=0.13u
M2412 vss SAR/sg13cmos5l_dfrbp_1_6.RESET_B SAR/a_18196_8824# vss sg13_lv_nmos ad=0.1406p pd=1.12u as=77.7f ps=0.95u w=0.74u l=0.13u
M2413 vdd SAR/a_19227_9190# SAR/sg13cmos5l_buf_8_2.X vdd sg13_lv_pmos ad=0.2128p pd=1.5u as=0.2128p ps=1.5u w=1.12u l=0.13u
M2414 SAR/sg13cmos5l_dlhr_1_12.Q_N SAR/a_18486_8866# vdd vdd sg13_lv_pmos ad=0.3808p pd=2.92u as=0.1974p ps=1.5u w=1.12u l=0.13u
M2415 SAR/sg13cmos5l_buf_1_34.X SAR/a_4840_1664# vss vss sg13_lv_nmos ad=0.2886p pd=2.26u as=0.14875p ps=1.16u w=0.74u l=0.13u
M2416 SAR/sg13cmos5l_buf_1_34.A SAR/a_4041_2745# vdd vdd sg13_lv_pmos ad=0.3808p pd=2.92u as=0.2128p ps=1.5u w=1.12u l=0.13u
M2417 vdd vss vdd vdd sg13_lv_pmos ad=0.34p pd=2.68u as=0 ps=0 w=1u l=1u
M2418 SAR/a_4518_7996# SAR/a_4349_7636# SAR/a_4076_7624# vdd sg13_lv_pmos ad=0.105p pd=1.21u as=0.191p ps=1.44u w=1u l=0.13u
M2419 vss SAR/sg13cmos5l_dfrbp_1_15.D SAR/a_2621_7636# vss sg13_lv_nmos ad=0.15055p pd=1.17u as=0.2516p ps=2.16u w=0.74u l=0.13u
M2420 SAR/a_12998_3138# SAR/a_13803_3260# SAR/a_13258_3361# vdd sg13_lv_pmos ad=0.1428p pd=1.52u as=79.8f ps=0.8u w=0.42u l=0.13u
M2421 SAR/a_6903_3154# SAR/sg13cmos5l_dlhr_1_0.GATE vdd vdd sg13_lv_pmos ad=0.3234p pd=2.45u as=1.43437p ps=9.105u w=0.84u l=0.13u
M2422 SAR/a_14814_3876# SAR/sg13cmos5l_nand2_1_1.B vdd vdd sg13_lv_pmos ad=0.2744p pd=1.61u as=0.3808p ps=2.92u w=1.12u l=0.13u
M2423 SAR/a_996_7349# SAR/a_708_6928# SAR/a_934_7349# vss sg13_lv_nmos ad=0.1428p pd=1.52u as=37.8f ps=0.6u w=0.42u l=0.13u
M2424 vdd _cks SAR/sg13cmos5l_dfrbp_1_6.RESET_B vdd sg13_lv_pmos ad=0.2128p pd=1.5u as=0.2128p ps=1.5u w=1.12u l=0.13u
M2425 vss vdd vss vss sg13_lv_nmos ad=79.8f pd=0.8u as=0 ps=0 w=0.42u l=1u
M2426 SAR/a_13775_6239# SAR/a_12933_6141# SAR/a_12516_6480# vdd sg13_lv_pmos ad=0.2048p pd=1.63u as=0.34p ps=2.68u w=1u l=0.13u
M2427 vdd SAR/a_2831_7630# SAR/a_2790_7996# vdd sg13_lv_pmos ad=1.15047p pd=7.175u as=0.105p ps=1.21u w=1u l=0.13u
M2428 SAR/a_2505_3947# SAR/a_2148_3904# vdd vdd sg13_lv_pmos ad=63f pd=0.72u as=0.1563p ps=1.22u w=0.42u l=0.13u
M2429 SAR/a_16293_4629# SAR/sg13cmos5l_inv_1_2.A vdd vdd sg13_lv_pmos ad=0.4088p pd=2.97u as=1.28962p ps=8.195u w=1.12u l=0.13u
M2430 vss SAR/sg13cmos5l_nor2_1_0.A SAR/a_10613_2758# vss sg13_lv_nmos ad=0.1898p pd=1.36u as=0.2516p ps=2.16u w=0.74u l=0.13u
M2431 SAR/sg13cmos5l_buf_1_30.X SAR/a_8680_1664# vdd vdd sg13_lv_pmos ad=0.42p pd=2.99u as=0.2114p ps=1.54u w=1.12u l=0.13u
M2432 vdd _cks SAR/a_19227_9190# vdd sg13_lv_pmos ad=0.2128p pd=1.5u as=0.3808p ps=2.92u w=1.12u l=0.13u
M2433 SAR/a_10412_6126# SAR/sg13cmos5l_dlhr_1_5.Q vss vss sg13_lv_nmos ad=0.187p pd=1.78u as=0.14875p ps=1.16u w=0.55u l=0.13u
M2434 SAR/a_11174_2826# SAR/sg13cmos5l_dfrbp_1_4.D vdd vdd sg13_lv_pmos ad=79.8f pd=0.8u as=0.1428p ps=1.52u w=0.42u l=0.13u
M2435 vss SAR/a_13775_6239# SAR/a_14612_6460# vss sg13_lv_nmos ad=0.1406p pd=1.12u as=0.2516p ps=2.16u w=0.74u l=0.13u
M2436 SAR/a_2148_8440# SAR/a_2122_8404# vdd vdd sg13_lv_pmos ad=0.34p pd=2.68u as=0.36237p ps=2.605u w=1u l=0.13u
M2437 vdd SAR/a_4172_1590# SAR/sg13cmos5l_buf_1_33.A vdd sg13_lv_pmos ad=0.2114p pd=1.54u as=0.42p ps=2.99u w=1.12u l=0.13u
M2438 SAR/a_7449_8559# SAR/a_6507_8447# SAR/a_7247_8797# vdd sg13_lv_pmos ad=93.45f pd=0.865u as=0.2048p ps=1.63u w=0.42u l=0.13u
M2439 SAR/a_11769_7989# SAR/a_10827_7796# SAR/a_11567_7751# vdd sg13_lv_pmos ad=93.45f pd=0.865u as=0.2048p ps=1.63u w=0.42u l=0.13u
M2440 SAR/sg13cmos5l_buf_1_3.X SAR/a_20296_1664# vdd vdd sg13_lv_pmos ad=0.42p pd=2.99u as=0.2114p ps=1.54u w=1.12u l=0.13u
M2441 SAR/a_10220_3102# SAR/sg13cmos5l_buf_1_28.X vss vss sg13_lv_nmos ad=0.187p pd=1.78u as=0.14875p ps=1.16u w=0.55u l=0.13u
M2442 nl_sw[6] SAR/a_11656_3176# vdd vdd sg13_lv_pmos ad=0.42p pd=2.99u as=0.2114p ps=1.54u w=1.12u l=0.13u
M2443 SAR/sg13cmos5l_buf_1_96.A SAR/a_10665_7281# vdd vdd sg13_lv_pmos ad=0.3808p pd=2.92u as=0.2128p ps=1.5u w=1.12u l=0.13u
M2444 SAR/a_14641_7326# SAR/a_14089_7282# vss vss sg13_lv_nmos ad=71.99999f pd=0.865u as=1.49685p ps=9.6u w=0.64u l=0.13u
M2445 SAR/a_7052_9150# SAR/sg13cmos5l_inv_1_14.A vdd vdd sg13_lv_pmos ad=0.2856p pd=2.36u as=0.2114p ps=1.54u w=0.84u l=0.13u
M2446 vdd SAR/a_3407_8797# SAR/a_3664_8678# vdd sg13_lv_pmos ad=0.2639p pd=1.81u as=79.8f ps=0.8u w=0.42u l=0.13u
M2447 SAR/a_16204_4338# SAR/a_15821_3864# vdd vdd sg13_lv_pmos ad=79.8f pd=0.8u as=0.2639p ps=1.81u w=0.42u l=0.13u
M2448 vdd SAR/sg13cmos5l_dfrbp_1_8.RESET_B SAR/a_2122_8404# vdd sg13_lv_pmos ad=0.1563p pd=1.22u as=0.147p ps=1.54u w=0.42u l=0.13u
M2449 SAR/a_6380_7638# SAR/sg13cmos5l_buf_1_78.X vss vss sg13_lv_nmos ad=0.187p pd=1.78u as=0.14875p ps=1.16u w=0.55u l=0.13u
M2450 SAR/a_14900_2352# SAR/sg13cmos5l_nor2_1_1.A vss vss sg13_lv_nmos ad=0.187p pd=1.78u as=0.17255p ps=1.25u w=0.55u l=0.13u
M2451 SAR/a_7161_6477# SAR/a_6219_6284# SAR/a_6959_6239# vdd sg13_lv_pmos ad=93.45f pd=0.865u as=0.2048p ps=1.63u w=0.42u l=0.13u
M2452 SAR/sg13cmos5l_dlhr_1_15.Q_N SAR/a_18870_7656# vss vss sg13_lv_nmos ad=0.2516p pd=2.16u as=0.1491p ps=1.18u w=0.74u l=0.13u
M2453 SAR/a_15780_2813# SAR/a_16011_2399# SAR/a_15466_2356# vss sg13_lv_nmos ad=0.2373p pd=1.97u as=79.8f ps=0.8u w=0.42u l=0.13u
M2454 SAR/a_5710_5535# SAR/a_5452_5850# vdd vdd sg13_lv_pmos ad=93.45f pd=0.865u as=1.28962p ps=8.195u w=0.42u l=0.13u
M2455 vdd SAR/sg13cmos5l_buf_1_29.A SAR/a_9832_1664# vdd sg13_lv_pmos ad=0.2114p pd=1.54u as=0.2856p ps=2.36u w=0.84u l=0.13u
M2456 vdd SAR/sg13cmos5l_buf_1_39.A SAR/a_3688_1664# vdd sg13_lv_pmos ad=0.2114p pd=1.54u as=0.2856p ps=2.36u w=0.84u l=0.13u
M2457 SAR/sg13cmos5l_dfrbp_1_9.Q_N SAR/a_3407_4261# vss vss sg13_lv_nmos ad=0.2849p pd=2.25u as=0.2516p ps=2.16u w=0.74u l=0.13u
M2458 SAR/sg13cmos5l_dlhr_1_12.Q_N SAR/a_18486_8866# vss vss sg13_lv_nmos ad=0.2516p pd=2.16u as=0.1491p ps=1.18u w=0.74u l=0.13u
M2459 SAR/a_16164_4663# SAR/a_16395_4772# SAR/a_15850_4873# vss sg13_lv_nmos ad=0.2373p pd=1.97u as=79.8f ps=0.8u w=0.42u l=0.13u
M2460 SAR/a_17961_8793# SAR/a_17780_8436# vdd vdd sg13_lv_pmos ad=0.2128p pd=1.5u as=0.2387p ps=1.84u w=1.12u l=0.13u
M2461 vdd SAR/a_8588_3864# SAR/sg13cmos5l_buf_1_30.A vdd sg13_lv_pmos ad=0.2114p pd=1.54u as=0.42p ps=2.99u w=1.12u l=0.13u
M2462 SAR/a_4311_7710# SAR/a_3676_7964# vss vss sg13_lv_nmos ad=47.25f pd=0.645u as=0.1428p ps=1.52u w=0.42u l=0.13u
M2463 SAR/sg13cmos5l_dlhr_1_15.Q SAR/a_18345_7674# vdd vdd sg13_lv_pmos ad=0.3808p pd=2.92u as=0.2128p ps=1.5u w=1.12u l=0.13u
M2464 vss SAR/sg13cmos5l_buf_1_28.A SAR/a_9448_1664# vss sg13_lv_nmos ad=0.14875p pd=1.16u as=0.187p ps=1.78u w=0.55u l=0.13u
M2465 vdd SAR/a_18959_3215# SAR/a_19216_3358# vdd sg13_lv_pmos ad=0.2639p pd=1.81u as=79.8f ps=0.8u w=0.42u l=0.13u
M2466 SAR/sg13cmos5l_a22oi_1_0.B1 SAR/sg13cmos5l_nor2_1_0.A SAR/a_10618_3142# vss sg13_lv_nmos ad=0.2516p pd=2.16u as=0.1406p ps=1.12u w=0.74u l=0.13u
M2467 SAR/sg13cmos5l_dfrbp_1_0.Q SAR/a_19508_1924# vss vss sg13_lv_nmos ad=0.2516p pd=2.16u as=0.1406p ps=1.12u w=0.74u l=0.13u
M2468 SAR/a_10450_8874# SAR/sg13cmos5l_dfrbp_1_8.RESET_B vss vss sg13_lv_nmos ad=37.8f pd=0.6u as=79.8f ps=0.8u w=0.42u l=0.13u
M2469 SAR/a_2554_8112# SAR/a_1948_7964# vdd vdd sg13_lv_pmos ad=0.1008p pd=0.9u as=0.2387p ps=1.84u w=0.42u l=0.13u
M2470 SAR/a_7498_7897# SAR/a_7941_7653# SAR/a_7238_7674# vss sg13_lv_nmos ad=79.8f pd=0.8u as=0.1296p ps=1.52u w=0.42u l=0.13u
M2471 vss vdd vss vss sg13_lv_nmos ad=79.8f pd=0.8u as=0 ps=0 w=0.42u l=1u
M2472 vdd SAR/a_1846_7850# SAR/sg13cmos5l_dlhr_1_8.Q_N vdd sg13_lv_pmos ad=0.1974p pd=1.5u as=0.3808p ps=2.92u w=1.12u l=0.13u
M2473 vdd SAR/a_13775_6239# SAR/a_14032_6382# vdd sg13_lv_pmos ad=0.2639p pd=1.81u as=79.8f ps=0.8u w=0.42u l=0.13u
M2474 SAR/sg13cmos5l_dfrbp_1_23.CLK SAR/a_14228_9484# vss vss sg13_lv_nmos ad=0.2516p pd=2.16u as=0.1406p ps=1.12u w=0.74u l=0.13u
M2475 SAR/a_12358_5388# SAR/sg13cmos5l_dfrbp_1_21.Q vdd vdd sg13_lv_pmos ad=0.1596p pd=1.22u as=0.2226p ps=1.535u w=0.84u l=0.13u
M2476 SAR/a_422_5850# SAR/sg13cmos5l_dfrbp_1_6.D vdd vdd sg13_lv_pmos ad=79.8f pd=0.8u as=0.1428p ps=1.52u w=0.42u l=0.13u
M2477 vdd SAR/sg13cmos5l_inv_1_18.A SAR/a_9256_9224# vdd sg13_lv_pmos ad=0.2114p pd=1.54u as=0.2856p ps=2.36u w=0.84u l=0.13u
M2478 vss SAR/sg13cmos5l_buf_1_78.A SAR/a_6184_9224# vss sg13_lv_nmos ad=0.14875p pd=1.16u as=0.187p ps=1.78u w=0.55u l=0.13u
M2479 SAR/sg13cmos5l_dfrbp_1_10.Q SAR/a_4436_3436# vss vss sg13_lv_nmos ad=0.2516p pd=2.16u as=0.1406p ps=1.12u w=0.74u l=0.13u
M2480 SAR/a_17508_3138# SAR/sg13cmos5l_a22oi_1_1.Y SAR/a_17414_3138# vss sg13_lv_nmos ad=60.89999f pd=0.71u as=0.1428p ps=1.52u w=0.42u l=0.13u
M2481 SAR/a_16234_6385# SAR/a_16677_6141# SAR/a_16617_6553# vdd sg13_lv_pmos ad=79.8f pd=0.8u as=63f ps=0.72u w=0.42u l=0.13u
M2482 SAR/a_14194_6162# SAR/sg13cmos5l_dfrbp_1_6.RESET_B vss vss sg13_lv_nmos ad=37.8f pd=0.6u as=79.8f ps=0.8u w=0.42u l=0.13u
M2483 SAR/a_11844_1639# SAR/a_11556_1944# SAR/a_11782_1639# vss sg13_lv_nmos ad=0.1428p pd=1.52u as=37.8f ps=0.6u w=0.42u l=0.13u
M2484 vdd SAR/a_13648_9406# SAR/a_13593_9501# vdd sg13_lv_pmos ad=4.11675p pd=27.17u as=93.45f ps=0.865u w=0.42u l=0.13u
M2485 SAR/sg13cmos5l_inv_1_0.A SAR/a_13652_3900# vss vss sg13_lv_nmos ad=0.2516p pd=2.16u as=0.1406p ps=1.12u w=0.74u l=0.13u
M2486 SAR/a_3814_4663# SAR/sg13cmos5l_dfrbp_1_8.RESET_B vss vss sg13_lv_nmos ad=37.8f pd=0.6u as=0.1701p ps=1.65u w=0.42u l=0.13u
M2487 SAR/sg13cmos5l_dlhr_1_13.Q_N SAR/a_15414_7354# vdd vdd sg13_lv_pmos ad=0.3808p pd=2.92u as=0.1974p ps=1.5u w=1.12u l=0.13u
M0 vddr ph_sw[1] SC0/buf_16_3.z vddr sg13_lv_pmos ad=0.19p pd=1.38u as=0.19p ps=1.38u w=1u l=0.13u
M1 SC0/vss ph_sw[0] SC0/buf_32_1.z SC0/vss sg13_lv_nmos ad=95f pd=0.88u as=95f ps=0.88u w=0.5u l=0.13u
M2 vddr pl_sw[4] SC0/buf_8_0.z vddr sg13_lv_pmos ad=0.19p pd=1.38u as=0.19p ps=1.38u w=1u l=0.13u
M3 vddr pl_sw[0] SC0/buf_32_0.z vddr sg13_lv_pmos ad=0.19p pd=1.38u as=0.19p ps=1.38u w=1u l=0.13u
M4 SC0/buf_16_1.z pl_sw[2] SC0/vss SC0/vss sg13_lv_nmos ad=95f pd=0.88u as=95f ps=0.88u w=0.5u l=0.13u
M5 SC0/vss ph_sw[2] SC0/buf_16_0.z SC0/vss sg13_lv_nmos ad=95f pd=0.88u as=95f ps=0.88u w=0.5u l=0.13u
M6 SC0/buf_32_0.z pl_sw[0] SC0/vss SC0/vss sg13_lv_nmos ad=95f pd=0.88u as=95f ps=0.88u w=0.5u l=0.13u
M7 SC0/vss ph_sw[2] SC0/buf_16_0.z SC0/vss sg13_lv_nmos ad=95f pd=0.88u as=95f ps=0.88u w=0.5u l=0.13u
M8 vddr ph_sw[5] SC0/buf_8_5.z vddr sg13_lv_pmos ad=0.19p pd=1.38u as=0.34p ps=2.68u w=1u l=0.13u
M9 SC0/buf_16_1.z pl_sw[2] SC0/vss SC0/vss sg13_lv_nmos ad=95f pd=0.88u as=95f ps=0.88u w=0.5u l=0.13u
M10 SC0/buf_32_1.z ph_sw[0] SC0/vss SC0/vss sg13_lv_nmos ad=95f pd=0.88u as=95f ps=0.88u w=0.5u l=0.13u
M11 vddr pl_sw[0] SC0/buf_32_0.z vddr sg13_lv_pmos ad=0.19p pd=1.38u as=0.19p ps=1.38u w=1u l=0.13u
M12 SC0/buf_32_0.z pl_sw[0] vddr vddr sg13_lv_pmos ad=0.19p pd=1.38u as=0.19p ps=1.38u w=1u l=0.13u
M13 SC0/buf_2_2.z pl_sw[9] SC0/vss SC0/vss sg13_lv_nmos ad=0.17p pd=1.68u as=95f ps=0.88u w=0.5u l=0.13u
M14 vddr ph_sw[0] SC0/buf_32_1.z vddr sg13_lv_pmos ad=0.19p pd=1.38u as=0.19p ps=1.38u w=1u l=0.13u
M15 SC0/vss pl_sw[0] SC0/buf_32_0.z SC0/vss sg13_lv_nmos ad=95f pd=0.88u as=95f ps=0.88u w=0.5u l=0.13u
M16 SC0/buf_8_2.z ph_sw[4] SC0/vss SC0/vss sg13_lv_nmos ad=0.17p pd=1.68u as=95f ps=0.88u w=0.5u l=0.13u
M17 SC0/buf_16_0.z ph_sw[2] vddr vddr sg13_lv_pmos ad=0.34p pd=2.68u as=0.19p ps=1.38u w=1u l=0.13u
M18 SC0/vss ph_sw[0] SC0/buf_32_1.z SC0/vss sg13_lv_nmos ad=95f pd=0.88u as=95f ps=0.88u w=0.5u l=0.13u
M19 SC0/buf_16_3.z ph_sw[1] vddr vddr sg13_lv_pmos ad=0.19p pd=1.38u as=0.19p ps=1.38u w=1u l=0.13u
M20 SC0/buf_32_1.z ph_sw[0] vddr vddr sg13_lv_pmos ad=0.19p pd=1.38u as=0.19p ps=1.38u w=1u l=0.13u
M21 SC0/vss ph_sw[1] SC0/buf_16_3.z SC0/vss sg13_lv_nmos ad=95f pd=0.88u as=0.17p ps=1.68u w=0.5u l=0.13u
M22 SC0/buf_32_0.z pl_sw[0] SC0/vss SC0/vss sg13_lv_nmos ad=95f pd=0.88u as=95f ps=0.88u w=0.5u l=0.13u
M23 vddr ph_sw[3] SC0/buf_8_3.z vddr sg13_lv_pmos ad=0.19p pd=1.38u as=0.19p ps=1.38u w=1u l=0.13u
M24 SC0/buf_2_1.z pl_sw[8] vddr vddr sg13_lv_pmos ad=0.34p pd=2.68u as=0.19p ps=1.38u w=1u l=0.13u
M25 SC0/buf_32_1.z ph_sw[0] SC0/vss SC0/vss sg13_lv_nmos ad=95f pd=0.88u as=95f ps=0.88u w=0.5u l=0.13u
M26 vddr ph_sw[2] SC0/buf_16_0.z vddr sg13_lv_pmos ad=0.19p pd=1.38u as=0.34p ps=2.68u w=1u l=0.13u
M27 SC0/buf_8_1.z pl_sw[3] SC0/vss SC0/vss sg13_lv_nmos ad=95f pd=0.88u as=95f ps=0.88u w=0.5u l=0.13u
M28 vddr pl_sw[3] SC0/buf_8_1.z vddr sg13_lv_pmos ad=0.19p pd=1.38u as=0.19p ps=1.38u w=1u l=0.13u
M29 vddr ph_sw[0] SC0/buf_32_1.z vddr sg13_lv_pmos ad=0.19p pd=1.38u as=0.19p ps=1.38u w=1u l=0.13u
M30 SC0/buf_16_3.z ph_sw[1] SC0/vss SC0/vss sg13_lv_nmos ad=95f pd=0.88u as=95f ps=0.88u w=0.5u l=0.13u
M31 SC0/buf_8_2.z ph_sw[4] SC0/vss SC0/vss sg13_lv_nmos ad=95f pd=0.88u as=95f ps=0.88u w=0.5u l=0.13u
M32 SC0/vss ph_sw[0] SC0/buf_32_1.z SC0/vss sg13_lv_nmos ad=95f pd=0.88u as=95f ps=0.88u w=0.5u l=0.13u
M33 vddr ph_sw[0] SC0/buf_32_1.z vddr sg13_lv_pmos ad=0.19p pd=1.38u as=0.19p ps=1.38u w=1u l=0.13u
M34 SC0/buf_16_0.z ph_sw[2] vddr vddr sg13_lv_pmos ad=0.19p pd=1.38u as=0.19p ps=1.38u w=1u l=0.13u
M35 vddr ph_sw[6] SC0/buf_4_1.z vddr sg13_lv_pmos ad=0.19p pd=1.38u as=0.34p ps=2.68u w=1u l=0.13u
M36 SC0/buf_16_2.z pl_sw[1] SC0/vss SC0/vss sg13_lv_nmos ad=95f pd=0.88u as=95f ps=0.88u w=0.5u l=0.13u
M37 SC0/vss pl_sw[1] SC0/buf_16_2.z SC0/vss sg13_lv_nmos ad=95f pd=0.88u as=95f ps=0.88u w=0.5u l=0.13u
M38 SC0/buf_8_3.z ph_sw[3] SC0/vss SC0/vss sg13_lv_nmos ad=95f pd=0.88u as=95f ps=0.88u w=0.5u l=0.13u
M39 vddr pl_sw[2] SC0/buf_16_1.z vddr sg13_lv_pmos ad=0.19p pd=1.38u as=0.19p ps=1.38u w=1u l=0.13u
M40 SC0/buf_8_4.z pl_sw[5] SC0/vss SC0/vss sg13_lv_nmos ad=95f pd=0.88u as=95f ps=0.88u w=0.5u l=0.13u
M41 SC0/buf_32_0.z pl_sw[0] SC0/vss SC0/vss sg13_lv_nmos ad=95f pd=0.88u as=95f ps=0.88u w=0.5u l=0.13u
M42 vddr ph_sw[3] SC0/buf_8_3.z vddr sg13_lv_pmos ad=0.19p pd=1.38u as=0.19p ps=1.38u w=1u l=0.13u
M43 SC0/buf_16_1.z pl_sw[2] vddr vddr sg13_lv_pmos ad=0.19p pd=1.38u as=0.19p ps=1.38u w=1u l=0.13u
M44 SC0/buf_16_2.z pl_sw[1] vddr vddr sg13_lv_pmos ad=0.19p pd=1.38u as=0.19p ps=1.38u w=1u l=0.13u
M45 vddr pl_sw[0] SC0/buf_32_0.z vddr sg13_lv_pmos ad=0.19p pd=1.38u as=0.19p ps=1.38u w=1u l=0.13u
M46 SC0/vss ph_sw[7] SC0/buf_4_2.z SC0/vss sg13_lv_nmos ad=95f pd=0.88u as=95f ps=0.88u w=0.5u l=0.13u
M47 SC0/buf_2_2.z pl_sw[9] vddr vddr sg13_lv_pmos ad=0.34p pd=2.68u as=0.19p ps=1.38u w=1u l=0.13u
M48 SC0/buf_16_3.z ph_sw[1] vddr vddr sg13_lv_pmos ad=0.19p pd=1.38u as=0.19p ps=1.38u w=1u l=0.13u
M49 SC0/buf_4_0.z pl_sw[7] vddr vddr sg13_lv_pmos ad=0.19p pd=1.38u as=0.19p ps=1.38u w=1u l=0.13u
M50 SC0/vss pl_sw[0] SC0/buf_32_0.z SC0/vss sg13_lv_nmos ad=95f pd=0.88u as=95f ps=0.88u w=0.5u l=0.13u
M51 SC0/buf_8_5.z ph_sw[5] SC0/vss SC0/vss sg13_lv_nmos ad=0.17p pd=1.68u as=95f ps=0.88u w=0.5u l=0.13u
M52 vddr ph_sw[8] SC0/buf_2_0.z vddr sg13_lv_pmos ad=0.19p pd=1.38u as=0.34p ps=2.68u w=1u l=0.13u
M53 SC0/buf_8_0.z pl_sw[4] vddr vddr sg13_lv_pmos ad=0.19p pd=1.38u as=0.19p ps=1.38u w=1u l=0.13u
M54 SC0/buf_32_0.z pl_sw[0] vddr vddr sg13_lv_pmos ad=0.19p pd=1.38u as=0.19p ps=1.38u w=1u l=0.13u
M55 SC0/vss pl_sw[2] SC0/buf_16_1.z SC0/vss sg13_lv_nmos ad=95f pd=0.88u as=95f ps=0.88u w=0.5u l=0.13u
M56 SC0/vss pl_sw[0] SC0/buf_32_0.z SC0/vss sg13_lv_nmos ad=95f pd=0.88u as=95f ps=0.88u w=0.5u l=0.13u
M57 vddr pl_sw[2] SC0/buf_16_1.z vddr sg13_lv_pmos ad=0.19p pd=1.38u as=0.19p ps=1.38u w=1u l=0.13u
M58 vddr pl_sw[1] SC0/buf_16_2.z vddr sg13_lv_pmos ad=0.19p pd=1.38u as=0.19p ps=1.38u w=1u l=0.13u
M59 SC0/vss pl_sw[3] SC0/buf_8_1.z SC0/vss sg13_lv_nmos ad=95f pd=0.88u as=95f ps=0.88u w=0.5u l=0.13u
M60 vddr pl_sw[0] SC0/buf_32_0.z vddr sg13_lv_pmos ad=0.19p pd=1.38u as=0.19p ps=1.38u w=1u l=0.13u
M61 SC0/buf_32_1.z ph_sw[0] vddr vddr sg13_lv_pmos ad=0.19p pd=1.38u as=0.19p ps=1.38u w=1u l=0.13u
M62 vddr pl_sw[5] SC0/buf_8_4.z vddr sg13_lv_pmos ad=0.19p pd=1.38u as=0.19p ps=1.38u w=1u l=0.13u
M63 vddr ph_sw[2] SC0/buf_16_0.z vddr sg13_lv_pmos ad=0.19p pd=1.38u as=0.19p ps=1.38u w=1u l=0.13u
M64 SC0/buf_8_5.z ph_sw[5] SC0/vss SC0/vss sg13_lv_nmos ad=95f pd=0.88u as=95f ps=0.88u w=0.5u l=0.13u
M65 SC0/buf_32_0.z pl_sw[0] vddr vddr sg13_lv_pmos ad=0.19p pd=1.38u as=0.19p ps=1.38u w=1u l=0.13u
M66 SC0/vss pl_sw[4] SC0/buf_8_0.z SC0/vss sg13_lv_nmos ad=95f pd=0.88u as=0.17p ps=1.68u w=0.5u l=0.13u
M67 SC0/buf_16_3.z ph_sw[1] SC0/vss SC0/vss sg13_lv_nmos ad=95f pd=0.88u as=95f ps=0.88u w=0.5u l=0.13u
M68 vddr ph_sw[0] SC0/buf_32_1.z vddr sg13_lv_pmos ad=0.19p pd=1.38u as=0.19p ps=1.38u w=1u l=0.13u
M69 SC0/vss pl_sw[0] SC0/buf_32_0.z SC0/vss sg13_lv_nmos ad=95f pd=0.88u as=0.17p ps=1.68u w=0.5u l=0.13u
M70 SC0/buf_16_0.z ph_sw[2] SC0/vss SC0/vss sg13_lv_nmos ad=95f pd=0.88u as=95f ps=0.88u w=0.5u l=0.13u
M71 SC0/vss ph_sw[0] SC0/buf_32_1.z SC0/vss sg13_lv_nmos ad=95f pd=0.88u as=95f ps=0.88u w=0.5u l=0.13u
M72 SC0/buf_2_1.z pl_sw[8] SC0/vss SC0/vss sg13_lv_nmos ad=0.17p pd=1.68u as=95f ps=0.88u w=0.5u l=0.13u
M73 vddr pl_sw[0] SC0/buf_32_0.z vddr sg13_lv_pmos ad=0.19p pd=1.38u as=0.19p ps=1.38u w=1u l=0.13u
M74 SC0/buf_4_3.z pl_sw[6] SC0/vss SC0/vss sg13_lv_nmos ad=95f pd=0.88u as=95f ps=0.88u w=0.5u l=0.13u
M75 SC0/buf_8_1.z pl_sw[3] vddr vddr sg13_lv_pmos ad=0.34p pd=2.68u as=0.19p ps=1.38u w=1u l=0.13u
M76 SC0/buf_32_1.z ph_sw[0] vddr vddr sg13_lv_pmos ad=0.19p pd=1.38u as=0.19p ps=1.38u w=1u l=0.13u
M77 SC0/buf_4_2.z ph_sw[7] vddr vddr sg13_lv_pmos ad=0.19p pd=1.38u as=0.19p ps=1.38u w=1u l=0.13u
M78 SC0/vss ph_sw[1] SC0/buf_16_3.z SC0/vss sg13_lv_nmos ad=95f pd=0.88u as=95f ps=0.88u w=0.5u l=0.13u
M79 SC0/buf_32_0.z pl_sw[0] SC0/vss SC0/vss sg13_lv_nmos ad=95f pd=0.88u as=95f ps=0.88u w=0.5u l=0.13u
M80 SC0/vss ph_sw[4] SC0/buf_8_2.z SC0/vss sg13_lv_nmos ad=95f pd=0.88u as=95f ps=0.88u w=0.5u l=0.13u
M81 SC0/buf_32_1.z ph_sw[0] SC0/vss SC0/vss sg13_lv_nmos ad=95f pd=0.88u as=95f ps=0.88u w=0.5u l=0.13u
M82 SC0/buf_32_1.z ph_sw[0] vddr vddr sg13_lv_pmos ad=0.19p pd=1.38u as=0.19p ps=1.38u w=1u l=0.13u
M83 vddr ph_sw[2] SC0/buf_16_0.z vddr sg13_lv_pmos ad=0.19p pd=1.38u as=0.19p ps=1.38u w=1u l=0.13u
M84 SC0/vss ph_sw[0] SC0/buf_32_1.z SC0/vss sg13_lv_nmos ad=95f pd=0.88u as=95f ps=0.88u w=0.5u l=0.13u
M85 vddr ph_sw[5] SC0/buf_8_5.z vddr sg13_lv_pmos ad=0.19p pd=1.38u as=0.19p ps=1.38u w=1u l=0.13u
M86 SC0/buf_16_2.z pl_sw[1] SC0/vss SC0/vss sg13_lv_nmos ad=95f pd=0.88u as=95f ps=0.88u w=0.5u l=0.13u
M87 vddr ph_sw[0] SC0/buf_32_1.z vddr sg13_lv_pmos ad=0.19p pd=1.38u as=0.19p ps=1.38u w=1u l=0.13u
M88 vddr pl_sw[1] SC0/buf_16_2.z vddr sg13_lv_pmos ad=0.19p pd=1.38u as=0.19p ps=1.38u w=1u l=0.13u
M89 SC0/vss pl_sw[0] SC0/buf_32_0.z SC0/vss sg13_lv_nmos ad=95f pd=0.88u as=95f ps=0.88u w=0.5u l=0.13u
M90 SC0/buf_8_3.z ph_sw[3] vddr vddr sg13_lv_pmos ad=0.19p pd=1.38u as=0.19p ps=1.38u w=1u l=0.13u
M91 SC0/buf_4_0.z pl_sw[7] SC0/vss SC0/vss sg13_lv_nmos ad=0.17p pd=1.68u as=95f ps=0.88u w=0.5u l=0.13u
M92 vddr pl_sw[5] SC0/buf_8_4.z vddr sg13_lv_pmos ad=0.19p pd=1.38u as=0.19p ps=1.38u w=1u l=0.13u
M93 vddr ph_sw[1] SC0/buf_16_3.z vddr sg13_lv_pmos ad=0.19p pd=1.38u as=0.19p ps=1.38u w=1u l=0.13u
M94 SC0/buf_32_1.z ph_sw[0] vddr vddr sg13_lv_pmos ad=0.19p pd=1.38u as=0.19p ps=1.38u w=1u l=0.13u
M95 SC0/vss ph_sw[1] SC0/buf_16_3.z SC0/vss sg13_lv_nmos ad=95f pd=0.88u as=95f ps=0.88u w=0.5u l=0.13u
M96 SC0/vss ph_sw[4] SC0/buf_8_2.z SC0/vss sg13_lv_nmos ad=95f pd=0.88u as=0.17p ps=1.68u w=0.5u l=0.13u
M97 SC0/buf_8_0.z pl_sw[4] vddr vddr sg13_lv_pmos ad=0.19p pd=1.38u as=0.19p ps=1.38u w=1u l=0.13u
M98 SC0/buf_32_0.z pl_sw[0] SC0/vss SC0/vss sg13_lv_nmos ad=95f pd=0.88u as=95f ps=0.88u w=0.5u l=0.13u
M99 vddr ph_sw[2] SC0/buf_16_0.z vddr sg13_lv_pmos ad=0.19p pd=1.38u as=0.19p ps=1.38u w=1u l=0.13u
M100 SC0/buf_16_1.z pl_sw[2] SC0/vss SC0/vss sg13_lv_nmos ad=95f pd=0.88u as=95f ps=0.88u w=0.5u l=0.13u
M101 SC0/buf_16_2.z pl_sw[1] SC0/vss SC0/vss sg13_lv_nmos ad=95f pd=0.88u as=95f ps=0.88u w=0.5u l=0.13u
M102 vddr ph_sw[5] SC0/buf_8_5.z vddr sg13_lv_pmos ad=0.19p pd=1.38u as=0.19p ps=1.38u w=1u l=0.13u
M103 SC0/buf_16_1.z pl_sw[2] vddr vddr sg13_lv_pmos ad=0.19p pd=1.38u as=0.19p ps=1.38u w=1u l=0.13u
M104 SC0/buf_16_2.z pl_sw[1] vddr vddr sg13_lv_pmos ad=0.19p pd=1.38u as=0.19p ps=1.38u w=1u l=0.13u
M105 SC0/buf_8_0.z pl_sw[4] SC0/vss SC0/vss sg13_lv_nmos ad=95f pd=0.88u as=95f ps=0.88u w=0.5u l=0.13u
M106 SC0/vss pl_sw[5] SC0/buf_8_4.z SC0/vss sg13_lv_nmos ad=95f pd=0.88u as=0.17p ps=1.68u w=0.5u l=0.13u
M107 SC0/buf_8_1.z pl_sw[3] SC0/vss SC0/vss sg13_lv_nmos ad=95f pd=0.88u as=95f ps=0.88u w=0.5u l=0.13u
M108 SC0/buf_8_2.z ph_sw[4] vddr vddr sg13_lv_pmos ad=0.19p pd=1.38u as=0.19p ps=1.38u w=1u l=0.13u
M109 vddr ph_sw[9] SC0/buf_2_3.z vddr sg13_lv_pmos ad=0.19p pd=1.38u as=0.34p ps=2.68u w=1u l=0.13u
M110 SC0/buf_8_4.z pl_sw[5] vddr vddr sg13_lv_pmos ad=0.19p pd=1.38u as=0.19p ps=1.38u w=1u l=0.13u
M111 SC0/vss ph_sw[0] SC0/buf_32_1.z SC0/vss sg13_lv_nmos ad=95f pd=0.88u as=95f ps=0.88u w=0.5u l=0.13u
M112 SC0/vss ph_sw[5] SC0/buf_8_5.z SC0/vss sg13_lv_nmos ad=95f pd=0.88u as=95f ps=0.88u w=0.5u l=0.13u
M113 vddr pl_sw[0] SC0/buf_32_0.z vddr sg13_lv_pmos ad=0.19p pd=1.38u as=0.19p ps=1.38u w=1u l=0.13u
M114 SC0/buf_16_1.z pl_sw[2] SC0/vss SC0/vss sg13_lv_nmos ad=95f pd=0.88u as=95f ps=0.88u w=0.5u l=0.13u
M115 SC0/vss ph_sw[2] SC0/buf_16_0.z SC0/vss sg13_lv_nmos ad=95f pd=0.88u as=95f ps=0.88u w=0.5u l=0.13u
M116 SC0/vss ph_sw[2] SC0/buf_16_0.z SC0/vss sg13_lv_nmos ad=95f pd=0.88u as=95f ps=0.88u w=0.5u l=0.13u
M117 SC0/buf_32_1.z ph_sw[0] SC0/vss SC0/vss sg13_lv_nmos ad=95f pd=0.88u as=95f ps=0.88u w=0.5u l=0.13u
M118 SC0/buf_4_1.z ph_sw[6] SC0/vss SC0/vss sg13_lv_nmos ad=95f pd=0.88u as=95f ps=0.88u w=0.5u l=0.13u
M119 SC0/buf_16_1.z pl_sw[2] SC0/vss SC0/vss sg13_lv_nmos ad=0.17p pd=1.68u as=95f ps=0.88u w=0.5u l=0.13u
M120 vddr pl_sw[0] SC0/buf_32_0.z vddr sg13_lv_pmos ad=0.19p pd=1.38u as=0.19p ps=1.38u w=1u l=0.13u
M121 vddr pl_sw[3] SC0/buf_8_1.z vddr sg13_lv_pmos ad=0.19p pd=1.38u as=0.19p ps=1.38u w=1u l=0.13u
M122 SC0/buf_32_0.z pl_sw[0] vddr vddr sg13_lv_pmos ad=0.19p pd=1.38u as=0.19p ps=1.38u w=1u l=0.13u
M123 SC0/vss pl_sw[0] SC0/buf_32_0.z SC0/vss sg13_lv_nmos ad=95f pd=0.88u as=95f ps=0.88u w=0.5u l=0.13u
M124 SC0/vss ph_sw[0] SC0/buf_32_1.z SC0/vss sg13_lv_nmos ad=95f pd=0.88u as=95f ps=0.88u w=0.5u l=0.13u
M125 SC0/buf_16_3.z ph_sw[1] vddr vddr sg13_lv_pmos ad=0.34p pd=2.68u as=0.19p ps=1.38u w=1u l=0.13u
M126 SC0/vss ph_sw[5] SC0/buf_8_5.z SC0/vss sg13_lv_nmos ad=95f pd=0.88u as=0.17p ps=1.68u w=0.5u l=0.13u
M127 SC0/buf_32_1.z ph_sw[0] SC0/vss SC0/vss sg13_lv_nmos ad=95f pd=0.88u as=95f ps=0.88u w=0.5u l=0.13u
M128 SC0/buf_8_3.z ph_sw[3] SC0/vss SC0/vss sg13_lv_nmos ad=0.17p pd=1.68u as=95f ps=0.88u w=0.5u l=0.13u
M129 SC0/buf_32_0.z pl_sw[0] SC0/vss SC0/vss sg13_lv_nmos ad=95f pd=0.88u as=95f ps=0.88u w=0.5u l=0.13u
M130 SC0/buf_4_3.z pl_sw[6] vddr vddr sg13_lv_pmos ad=0.19p pd=1.38u as=0.19p ps=1.38u w=1u l=0.13u
M131 SC0/buf_32_1.z ph_sw[0] vddr vddr sg13_lv_pmos ad=0.19p pd=1.38u as=0.19p ps=1.38u w=1u l=0.13u
M132 SC0/vss pl_sw[7] SC0/buf_4_0.z SC0/vss sg13_lv_nmos ad=95f pd=0.88u as=0.17p ps=1.68u w=0.5u l=0.13u
M133 vddr ph_sw[0] SC0/buf_32_1.z vddr sg13_lv_pmos ad=0.19p pd=1.38u as=0.19p ps=1.38u w=1u l=0.13u
M134 SC0/buf_16_3.z ph_sw[1] SC0/vss SC0/vss sg13_lv_nmos ad=95f pd=0.88u as=95f ps=0.88u w=0.5u l=0.13u
M135 vddr ph_sw[6] SC0/buf_4_1.z vddr sg13_lv_pmos ad=0.19p pd=1.38u as=0.19p ps=1.38u w=1u l=0.13u
M136 SC0/buf_16_0.z ph_sw[2] vddr vddr sg13_lv_pmos ad=0.19p pd=1.38u as=0.19p ps=1.38u w=1u l=0.13u
M137 SC0/vss ph_sw[8] SC0/buf_2_0.z SC0/vss sg13_lv_nmos ad=95f pd=0.88u as=0.17p ps=1.68u w=0.5u l=0.13u
M138 SC0/buf_16_2.z pl_sw[1] SC0/vss SC0/vss sg13_lv_nmos ad=0.17p pd=1.68u as=95f ps=0.88u w=0.5u l=0.13u
M139 SC0/buf_8_3.z ph_sw[3] SC0/vss SC0/vss sg13_lv_nmos ad=95f pd=0.88u as=95f ps=0.88u w=0.5u l=0.13u
M140 vddr pl_sw[2] SC0/buf_16_1.z vddr sg13_lv_pmos ad=0.19p pd=1.38u as=0.19p ps=1.38u w=1u l=0.13u
M141 SC0/buf_8_5.z ph_sw[5] vddr vddr sg13_lv_pmos ad=0.19p pd=1.38u as=0.19p ps=1.38u w=1u l=0.13u
M142 SC0/buf_8_4.z pl_sw[5] SC0/vss SC0/vss sg13_lv_nmos ad=95f pd=0.88u as=95f ps=0.88u w=0.5u l=0.13u
M143 SC0/vss pl_sw[1] SC0/buf_16_2.z SC0/vss sg13_lv_nmos ad=95f pd=0.88u as=95f ps=0.88u w=0.5u l=0.13u
M144 SC0/buf_16_2.z pl_sw[1] vddr vddr sg13_lv_pmos ad=0.19p pd=1.38u as=0.19p ps=1.38u w=1u l=0.13u
M145 SC0/buf_16_1.z pl_sw[2] vddr vddr sg13_lv_pmos ad=0.34p pd=2.68u as=0.19p ps=1.38u w=1u l=0.13u
M146 vddr pl_sw[0] SC0/buf_32_0.z vddr sg13_lv_pmos ad=0.19p pd=1.38u as=0.19p ps=1.38u w=1u l=0.13u
M147 SC0/buf_16_3.z ph_sw[1] vddr vddr sg13_lv_pmos ad=0.19p pd=1.38u as=0.19p ps=1.38u w=1u l=0.13u
M148 SC0/buf_32_1.z ph_sw[0] SC0/vss SC0/vss sg13_lv_nmos ad=95f pd=0.88u as=95f ps=0.88u w=0.5u l=0.13u
M149 SC0/buf_4_0.z pl_sw[7] vddr vddr sg13_lv_pmos ad=0.34p pd=2.68u as=0.19p ps=1.38u w=1u l=0.13u
M150 SC0/buf_8_0.z pl_sw[4] vddr vddr sg13_lv_pmos ad=0.19p pd=1.38u as=0.19p ps=1.38u w=1u l=0.13u
M151 SC0/buf_32_0.z pl_sw[0] vddr vddr sg13_lv_pmos ad=0.19p pd=1.38u as=0.19p ps=1.38u w=1u l=0.13u
M152 SC0/vss pl_sw[2] SC0/buf_16_1.z SC0/vss sg13_lv_nmos ad=95f pd=0.88u as=95f ps=0.88u w=0.5u l=0.13u
M153 SC0/vss pl_sw[0] SC0/buf_32_0.z SC0/vss sg13_lv_nmos ad=95f pd=0.88u as=95f ps=0.88u w=0.5u l=0.13u
M154 SC0/buf_4_2.z ph_sw[7] vddr vddr sg13_lv_pmos ad=0.34p pd=2.68u as=0.19p ps=1.38u w=1u l=0.13u
M155 SC0/buf_16_0.z ph_sw[2] SC0/vss SC0/vss sg13_lv_nmos ad=95f pd=0.88u as=95f ps=0.88u w=0.5u l=0.13u
M156 SC0/buf_16_0.z ph_sw[2] SC0/vss SC0/vss sg13_lv_nmos ad=95f pd=0.88u as=95f ps=0.88u w=0.5u l=0.13u
M157 SC0/vss ph_sw[0] SC0/buf_32_1.z SC0/vss sg13_lv_nmos ad=95f pd=0.88u as=95f ps=0.88u w=0.5u l=0.13u
M158 SC0/vss pl_sw[2] SC0/buf_16_1.z SC0/vss sg13_lv_nmos ad=95f pd=0.88u as=95f ps=0.88u w=0.5u l=0.13u
M159 SC0/buf_2_3.z ph_sw[9] SC0/vss SC0/vss sg13_lv_nmos ad=0.17p pd=1.68u as=95f ps=0.88u w=0.5u l=0.13u
M160 SC0/buf_32_0.z pl_sw[0] vddr vddr sg13_lv_pmos ad=0.19p pd=1.38u as=0.19p ps=1.38u w=1u l=0.13u
M161 vddr pl_sw[0] SC0/buf_32_0.z vddr sg13_lv_pmos ad=0.19p pd=1.38u as=0.19p ps=1.38u w=1u l=0.13u
M162 SC0/vss pl_sw[9] SC0/buf_2_2.z SC0/vss sg13_lv_nmos ad=95f pd=0.88u as=0.17p ps=1.68u w=0.5u l=0.13u
M163 SC0/buf_32_1.z ph_sw[0] vddr vddr sg13_lv_pmos ad=0.19p pd=1.38u as=0.19p ps=1.38u w=1u l=0.13u
M164 SC0/buf_32_0.z pl_sw[0] SC0/vss SC0/vss sg13_lv_nmos ad=95f pd=0.88u as=95f ps=0.88u w=0.5u l=0.13u
M165 SC0/vss ph_sw[4] SC0/buf_8_2.z SC0/vss sg13_lv_nmos ad=95f pd=0.88u as=95f ps=0.88u w=0.5u l=0.13u
M166 SC0/buf_32_1.z ph_sw[0] SC0/vss SC0/vss sg13_lv_nmos ad=95f pd=0.88u as=95f ps=0.88u w=0.5u l=0.13u
M167 vddr ph_sw[2] SC0/buf_16_0.z vddr sg13_lv_pmos ad=0.19p pd=1.38u as=0.19p ps=1.38u w=1u l=0.13u
M168 vddr ph_sw[1] SC0/buf_16_3.z vddr sg13_lv_pmos ad=0.19p pd=1.38u as=0.19p ps=1.38u w=1u l=0.13u
M169 SC0/buf_16_3.z ph_sw[1] SC0/vss SC0/vss sg13_lv_nmos ad=0.17p pd=1.68u as=95f ps=0.88u w=0.5u l=0.13u
M170 SC0/vss pl_sw[4] SC0/buf_8_0.z SC0/vss sg13_lv_nmos ad=95f pd=0.88u as=95f ps=0.88u w=0.5u l=0.13u
M171 vddr ph_sw[0] SC0/buf_32_1.z vddr sg13_lv_pmos ad=0.19p pd=1.38u as=0.19p ps=1.38u w=1u l=0.13u
M172 SC0/vss pl_sw[0] SC0/buf_32_0.z SC0/vss sg13_lv_nmos ad=95f pd=0.88u as=95f ps=0.88u w=0.5u l=0.13u
M173 vddr pl_sw[8] SC0/buf_2_1.z vddr sg13_lv_pmos ad=0.19p pd=1.38u as=0.34p ps=2.68u w=1u l=0.13u
M174 SC0/buf_16_0.z ph_sw[2] SC0/vss SC0/vss sg13_lv_nmos ad=95f pd=0.88u as=95f ps=0.88u w=0.5u l=0.13u
M175 SC0/vss ph_sw[0] SC0/buf_32_1.z SC0/vss sg13_lv_nmos ad=95f pd=0.88u as=95f ps=0.88u w=0.5u l=0.13u
M176 SC0/vss pl_sw[3] SC0/buf_8_1.z SC0/vss sg13_lv_nmos ad=95f pd=0.88u as=0.17p ps=1.68u w=0.5u l=0.13u
M177 SC0/buf_4_3.z pl_sw[6] SC0/vss SC0/vss sg13_lv_nmos ad=0.17p pd=1.68u as=95f ps=0.88u w=0.5u l=0.13u
M178 SC0/buf_8_1.z pl_sw[3] vddr vddr sg13_lv_pmos ad=0.19p pd=1.38u as=0.19p ps=1.38u w=1u l=0.13u
M179 SC0/vss pl_sw[1] SC0/buf_16_2.z SC0/vss sg13_lv_nmos ad=95f pd=0.88u as=0.17p ps=1.68u w=0.5u l=0.13u
M180 SC0/buf_32_1.z ph_sw[0] vddr vddr sg13_lv_pmos ad=0.19p pd=1.38u as=0.19p ps=1.38u w=1u l=0.13u
M181 SC0/vss ph_sw[1] SC0/buf_16_3.z SC0/vss sg13_lv_nmos ad=95f pd=0.88u as=95f ps=0.88u w=0.5u l=0.13u
M182 SC0/buf_32_0.z pl_sw[0] SC0/vss SC0/vss sg13_lv_nmos ad=95f pd=0.88u as=95f ps=0.88u w=0.5u l=0.13u
M183 SC0/vss ph_sw[4] SC0/buf_8_2.z SC0/vss sg13_lv_nmos ad=95f pd=0.88u as=95f ps=0.88u w=0.5u l=0.13u
M184 SC0/buf_32_1.z ph_sw[0] SC0/vss SC0/vss sg13_lv_nmos ad=95f pd=0.88u as=95f ps=0.88u w=0.5u l=0.13u
M185 SC0/buf_32_1.z ph_sw[0] vddr vddr sg13_lv_pmos ad=0.19p pd=1.38u as=0.19p ps=1.38u w=1u l=0.13u
M186 vddr ph_sw[2] SC0/buf_16_0.z vddr sg13_lv_pmos ad=0.19p pd=1.38u as=0.19p ps=1.38u w=1u l=0.13u
M187 SC0/vss pl_sw[1] SC0/buf_16_2.z SC0/vss sg13_lv_nmos ad=95f pd=0.88u as=95f ps=0.88u w=0.5u l=0.13u
M188 SC0/buf_16_2.z pl_sw[1] SC0/vss SC0/vss sg13_lv_nmos ad=95f pd=0.88u as=95f ps=0.88u w=0.5u l=0.13u
M189 SC0/vss ph_sw[3] SC0/buf_8_3.z SC0/vss sg13_lv_nmos ad=95f pd=0.88u as=95f ps=0.88u w=0.5u l=0.13u
M190 SC0/vss pl_sw[0] SC0/buf_32_0.z SC0/vss sg13_lv_nmos ad=95f pd=0.88u as=95f ps=0.88u w=0.5u l=0.13u
M191 vddr pl_sw[1] SC0/buf_16_2.z vddr sg13_lv_pmos ad=0.19p pd=1.38u as=0.19p ps=1.38u w=1u l=0.13u
M192 SC0/buf_8_3.z ph_sw[3] vddr vddr sg13_lv_pmos ad=0.19p pd=1.38u as=0.19p ps=1.38u w=1u l=0.13u
M193 vddr pl_sw[2] SC0/buf_16_1.z vddr sg13_lv_pmos ad=0.19p pd=1.38u as=0.19p ps=1.38u w=1u l=0.13u
M194 SC0/buf_32_0.z pl_sw[0] vddr vddr sg13_lv_pmos ad=0.19p pd=1.38u as=0.19p ps=1.38u w=1u l=0.13u
M195 SC0/buf_8_2.z ph_sw[4] vddr vddr sg13_lv_pmos ad=0.34p pd=2.68u as=0.19p ps=1.38u w=1u l=0.13u
M196 SC0/buf_4_2.z ph_sw[7] SC0/vss SC0/vss sg13_lv_nmos ad=95f pd=0.88u as=95f ps=0.88u w=0.5u l=0.13u
M197 SC0/vss pl_sw[2] SC0/buf_16_1.z SC0/vss sg13_lv_nmos ad=95f pd=0.88u as=0.17p ps=1.68u w=0.5u l=0.13u
M198 vddr ph_sw[1] SC0/buf_16_3.z vddr sg13_lv_pmos ad=0.19p pd=1.38u as=0.19p ps=1.38u w=1u l=0.13u
M199 vddr pl_sw[9] SC0/buf_2_2.z vddr sg13_lv_pmos ad=0.19p pd=1.38u as=0.34p ps=2.68u w=1u l=0.13u
M200 SC0/buf_4_1.z ph_sw[6] SC0/vss SC0/vss sg13_lv_nmos ad=0.17p pd=1.68u as=95f ps=0.88u w=0.5u l=0.13u
M201 SC0/buf_32_1.z ph_sw[0] vddr vddr sg13_lv_pmos ad=0.19p pd=1.38u as=0.19p ps=1.38u w=1u l=0.13u
M202 vddr pl_sw[7] SC0/buf_4_0.z vddr sg13_lv_pmos ad=0.19p pd=1.38u as=0.34p ps=2.68u w=1u l=0.13u
M203 SC0/buf_32_0.z pl_sw[0] SC0/vss SC0/vss sg13_lv_nmos ad=95f pd=0.88u as=95f ps=0.88u w=0.5u l=0.13u
M204 SC0/vss ph_sw[5] SC0/buf_8_5.z SC0/vss sg13_lv_nmos ad=95f pd=0.88u as=95f ps=0.88u w=0.5u l=0.13u
M205 vddr pl_sw[0] SC0/buf_32_0.z vddr sg13_lv_pmos ad=0.19p pd=1.38u as=0.19p ps=1.38u w=1u l=0.13u
M206 SC0/buf_16_1.z pl_sw[2] SC0/vss SC0/vss sg13_lv_nmos ad=95f pd=0.88u as=95f ps=0.88u w=0.5u l=0.13u
M207 SC0/vss ph_sw[3] SC0/buf_8_3.z SC0/vss sg13_lv_nmos ad=95f pd=0.88u as=0.17p ps=1.68u w=0.5u l=0.13u
M208 SC0/buf_16_1.z pl_sw[2] vddr vddr sg13_lv_pmos ad=0.19p pd=1.38u as=0.19p ps=1.38u w=1u l=0.13u
M209 SC0/buf_16_2.z pl_sw[1] vddr vddr sg13_lv_pmos ad=0.19p pd=1.38u as=0.19p ps=1.38u w=1u l=0.13u
M210 SC0/vss pl_sw[5] SC0/buf_8_4.z SC0/vss sg13_lv_nmos ad=95f pd=0.88u as=95f ps=0.88u w=0.5u l=0.13u
M211 SC0/buf_8_0.z pl_sw[4] SC0/vss SC0/vss sg13_lv_nmos ad=0.17p pd=1.68u as=95f ps=0.88u w=0.5u l=0.13u
M212 SC0/buf_8_1.z pl_sw[3] SC0/vss SC0/vss sg13_lv_nmos ad=95f pd=0.88u as=95f ps=0.88u w=0.5u l=0.13u
M213 SC0/buf_32_0.z pl_sw[0] vddr vddr sg13_lv_pmos ad=0.19p pd=1.38u as=0.19p ps=1.38u w=1u l=0.13u
M214 SC0/buf_8_2.z ph_sw[4] vddr vddr sg13_lv_pmos ad=0.19p pd=1.38u as=0.19p ps=1.38u w=1u l=0.13u
M215 vddr ph_sw[0] SC0/buf_32_1.z vddr sg13_lv_pmos ad=0.19p pd=1.38u as=0.19p ps=1.38u w=1u l=0.13u
M216 SC0/buf_8_4.z pl_sw[5] vddr vddr sg13_lv_pmos ad=0.19p pd=1.38u as=0.19p ps=1.38u w=1u l=0.13u
M217 vddr ph_sw[10] SC0/buf_1_1.z vddr sg13_lv_pmos ad=0.34p pd=2.68u as=0.34p ps=2.68u w=1u l=0.13u
M218 SC0/buf_16_0.z ph_sw[2] vddr vddr sg13_lv_pmos ad=0.19p pd=1.38u as=0.19p ps=1.38u w=1u l=0.13u
M219 SC0/vss ph_sw[5] SC0/buf_8_5.z SC0/vss sg13_lv_nmos ad=95f pd=0.88u as=95f ps=0.88u w=0.5u l=0.13u
M220 vddr pl_sw[0] SC0/buf_32_0.z vddr sg13_lv_pmos ad=0.19p pd=1.38u as=0.19p ps=1.38u w=1u l=0.13u
M221 SC0/vss ph_sw[1] SC0/buf_16_3.z SC0/vss sg13_lv_nmos ad=95f pd=0.88u as=95f ps=0.88u w=0.5u l=0.13u
M222 SC0/vss ph_sw[2] SC0/buf_16_0.z SC0/vss sg13_lv_nmos ad=95f pd=0.88u as=95f ps=0.88u w=0.5u l=0.13u
M223 SC0/buf_32_1.z ph_sw[0] SC0/vss SC0/vss sg13_lv_nmos ad=95f pd=0.88u as=95f ps=0.88u w=0.5u l=0.13u
M224 SC0/vss pl_sw[8] SC0/buf_2_1.z SC0/vss sg13_lv_nmos ad=95f pd=0.88u as=0.17p ps=1.68u w=0.5u l=0.13u
M225 SC0/buf_32_0.z pl_sw[0] vddr vddr sg13_lv_pmos ad=0.19p pd=1.38u as=0.19p ps=1.38u w=1u l=0.13u
M226 SC0/vss pl_sw[6] SC0/buf_4_3.z SC0/vss sg13_lv_nmos ad=95f pd=0.88u as=0.17p ps=1.68u w=0.5u l=0.13u
M227 vddr pl_sw[3] SC0/buf_8_1.z vddr sg13_lv_pmos ad=0.19p pd=1.38u as=0.19p ps=1.38u w=1u l=0.13u
M228 vddr ph_sw[0] SC0/buf_32_1.z vddr sg13_lv_pmos ad=0.19p pd=1.38u as=0.34p ps=2.68u w=1u l=0.13u
M229 vddr ph_sw[7] SC0/buf_4_2.z vddr sg13_lv_pmos ad=0.19p pd=1.38u as=0.34p ps=2.68u w=1u l=0.13u
M230 SC0/vss pl_sw[0] SC0/buf_32_0.z SC0/vss sg13_lv_nmos ad=95f pd=0.88u as=95f ps=0.88u w=0.5u l=0.13u
M231 SC0/vss ph_sw[0] SC0/buf_32_1.z SC0/vss sg13_lv_nmos ad=95f pd=0.88u as=95f ps=0.88u w=0.5u l=0.13u
M232 SC0/buf_8_2.z ph_sw[4] SC0/vss SC0/vss sg13_lv_nmos ad=95f pd=0.88u as=95f ps=0.88u w=0.5u l=0.13u
M233 SC0/buf_32_1.z ph_sw[0] SC0/vss SC0/vss sg13_lv_nmos ad=95f pd=0.88u as=95f ps=0.88u w=0.5u l=0.13u
M234 SC0/buf_4_3.z pl_sw[6] vddr vddr sg13_lv_pmos ad=0.34p pd=2.68u as=0.19p ps=1.38u w=1u l=0.13u
M235 SC0/vss pl_sw[1] SC0/buf_16_2.z SC0/vss sg13_lv_nmos ad=95f pd=0.88u as=95f ps=0.88u w=0.5u l=0.13u
M236 SC0/buf_32_1.z ph_sw[0] vddr vddr sg13_lv_pmos ad=0.19p pd=1.38u as=0.19p ps=1.38u w=1u l=0.13u
M237 SC0/buf_16_2.z pl_sw[1] vddr vddr sg13_lv_pmos ad=0.19p pd=1.38u as=0.19p ps=1.38u w=1u l=0.13u
M238 SC0/buf_32_0.z pl_sw[0] SC0/vss SC0/vss sg13_lv_nmos ad=95f pd=0.88u as=95f ps=0.88u w=0.5u l=0.13u
M239 SC0/vss pl_sw[7] SC0/buf_4_0.z SC0/vss sg13_lv_nmos ad=95f pd=0.88u as=95f ps=0.88u w=0.5u l=0.13u
M240 SC0/buf_8_4.z pl_sw[5] vddr vddr sg13_lv_pmos ad=0.19p pd=1.38u as=0.19p ps=1.38u w=1u l=0.13u
M241 SC0/buf_16_3.z ph_sw[1] vddr vddr sg13_lv_pmos ad=0.19p pd=1.38u as=0.19p ps=1.38u w=1u l=0.13u
M242 vddr ph_sw[0] SC0/buf_32_1.z vddr sg13_lv_pmos ad=0.19p pd=1.38u as=0.19p ps=1.38u w=1u l=0.13u
M243 SC0/buf_16_3.z ph_sw[1] SC0/vss SC0/vss sg13_lv_nmos ad=95f pd=0.88u as=95f ps=0.88u w=0.5u l=0.13u
M244 vddr pl_sw[4] SC0/buf_8_0.z vddr sg13_lv_pmos ad=0.19p pd=1.38u as=0.34p ps=2.68u w=1u l=0.13u
M245 SC0/buf_16_0.z ph_sw[2] vddr vddr sg13_lv_pmos ad=0.19p pd=1.38u as=0.19p ps=1.38u w=1u l=0.13u
M246 SC0/vss pl_sw[2] SC0/buf_16_1.z SC0/vss sg13_lv_nmos ad=95f pd=0.88u as=95f ps=0.88u w=0.5u l=0.13u
M247 SC0/buf_8_5.z ph_sw[5] vddr vddr sg13_lv_pmos ad=0.19p pd=1.38u as=0.19p ps=1.38u w=1u l=0.13u
M248 SC0/buf_8_4.z pl_sw[5] SC0/vss SC0/vss sg13_lv_nmos ad=0.17p pd=1.68u as=95f ps=0.88u w=0.5u l=0.13u
M249 vddr pl_sw[2] SC0/buf_16_1.z vddr sg13_lv_pmos ad=0.19p pd=1.38u as=0.19p ps=1.38u w=1u l=0.13u
M250 SC0/vss pl_sw[1] SC0/buf_16_2.z SC0/vss sg13_lv_nmos ad=95f pd=0.88u as=95f ps=0.88u w=0.5u l=0.13u
M251 SC0/vss pl_sw[4] SC0/buf_8_0.z SC0/vss sg13_lv_nmos ad=95f pd=0.88u as=95f ps=0.88u w=0.5u l=0.13u
M252 SC0/buf_16_2.z pl_sw[1] vddr vddr sg13_lv_pmos ad=0.19p pd=1.38u as=0.19p ps=1.38u w=1u l=0.13u
M253 vddr ph_sw[4] SC0/buf_8_2.z vddr sg13_lv_pmos ad=0.19p pd=1.38u as=0.19p ps=1.38u w=1u l=0.13u
M254 SC0/buf_16_3.z ph_sw[1] vddr vddr sg13_lv_pmos ad=0.19p pd=1.38u as=0.19p ps=1.38u w=1u l=0.13u
M255 SC0/vss ph_sw[2] SC0/buf_16_0.z SC0/vss sg13_lv_nmos ad=95f pd=0.88u as=0.17p ps=1.68u w=0.5u l=0.13u
M256 SC0/buf_32_1.z ph_sw[0] SC0/vss SC0/vss sg13_lv_nmos ad=95f pd=0.88u as=95f ps=0.88u w=0.5u l=0.13u
M257 SC0/buf_8_0.z pl_sw[4] vddr vddr sg13_lv_pmos ad=0.34p pd=2.68u as=0.19p ps=1.38u w=1u l=0.13u
M258 SC0/buf_8_5.z ph_sw[5] SC0/vss SC0/vss sg13_lv_nmos ad=95f pd=0.88u as=95f ps=0.88u w=0.5u l=0.13u
M259 SC0/buf_32_0.z pl_sw[0] vddr vddr sg13_lv_pmos ad=0.19p pd=1.38u as=0.19p ps=1.38u w=1u l=0.13u
M260 SC0/vss pl_sw[2] SC0/buf_16_1.z SC0/vss sg13_lv_nmos ad=95f pd=0.88u as=95f ps=0.88u w=0.5u l=0.13u
M261 SC0/vss pl_sw[0] SC0/buf_32_0.z SC0/vss sg13_lv_nmos ad=95f pd=0.88u as=95f ps=0.88u w=0.5u l=0.13u
M262 SC0/buf_16_0.z ph_sw[2] SC0/vss SC0/vss sg13_lv_nmos ad=95f pd=0.88u as=95f ps=0.88u w=0.5u l=0.13u
M263 SC0/buf_16_0.z ph_sw[2] SC0/vss SC0/vss sg13_lv_nmos ad=95f pd=0.88u as=95f ps=0.88u w=0.5u l=0.13u
M264 SC0/vss ph_sw[0] SC0/buf_32_1.z SC0/vss sg13_lv_nmos ad=95f pd=0.88u as=95f ps=0.88u w=0.5u l=0.13u
M265 vddr pl_sw[10] SC0/buf_1_0.z vddr sg13_lv_pmos ad=0.34p pd=2.68u as=0.34p ps=2.68u w=1u l=0.13u
M266 SC0/vss ph_sw[6] SC0/buf_4_1.z SC0/vss sg13_lv_nmos ad=95f pd=0.88u as=0.17p ps=1.68u w=0.5u l=0.13u
M267 SC0/vss pl_sw[2] SC0/buf_16_1.z SC0/vss sg13_lv_nmos ad=95f pd=0.88u as=95f ps=0.88u w=0.5u l=0.13u
M268 SC0/buf_32_0.z pl_sw[0] vddr vddr sg13_lv_pmos ad=0.19p pd=1.38u as=0.19p ps=1.38u w=1u l=0.13u
M269 vddr pl_sw[0] SC0/buf_32_0.z vddr sg13_lv_pmos ad=0.19p pd=1.38u as=0.19p ps=1.38u w=1u l=0.13u
M270 vddr ph_sw[4] SC0/buf_8_2.z vddr sg13_lv_pmos ad=0.19p pd=1.38u as=0.34p ps=2.68u w=1u l=0.13u
M271 SC0/buf_8_1.z pl_sw[3] vddr vddr sg13_lv_pmos ad=0.19p pd=1.38u as=0.19p ps=1.38u w=1u l=0.13u
M272 SC0/buf_32_0.z pl_sw[0] SC0/vss SC0/vss sg13_lv_nmos ad=95f pd=0.88u as=95f ps=0.88u w=0.5u l=0.13u
M273 SC0/buf_32_1.z ph_sw[0] SC0/vss SC0/vss sg13_lv_nmos ad=95f pd=0.88u as=95f ps=0.88u w=0.5u l=0.13u
M274 SC0/buf_4_2.z ph_sw[7] SC0/vss SC0/vss sg13_lv_nmos ad=0.17p pd=1.68u as=95f ps=0.88u w=0.5u l=0.13u
M275 vddr ph_sw[1] SC0/buf_16_3.z vddr sg13_lv_pmos ad=0.19p pd=1.38u as=0.19p ps=1.38u w=1u l=0.13u
M276 vddr ph_sw[0] SC0/buf_32_1.z vddr sg13_lv_pmos ad=0.19p pd=1.38u as=0.19p ps=1.38u w=1u l=0.13u
M277 SC0/vss ph_sw[3] SC0/buf_8_3.z SC0/vss sg13_lv_nmos ad=95f pd=0.88u as=95f ps=0.88u w=0.5u l=0.13u
M278 vddr pl_sw[6] SC0/buf_4_3.z vddr sg13_lv_pmos ad=0.19p pd=1.38u as=0.34p ps=2.68u w=1u l=0.13u
M279 SC0/vss pl_sw[0] SC0/buf_32_0.z SC0/vss sg13_lv_nmos ad=95f pd=0.88u as=95f ps=0.88u w=0.5u l=0.13u
M280 SC0/buf_8_3.z ph_sw[3] vddr vddr sg13_lv_pmos ad=0.34p pd=2.68u as=0.19p ps=1.38u w=1u l=0.13u
M281 SC0/vss pl_sw[3] SC0/buf_8_1.z SC0/vss sg13_lv_nmos ad=95f pd=0.88u as=95f ps=0.88u w=0.5u l=0.13u
M282 SC0/buf_32_1.z ph_sw[0] vddr vddr sg13_lv_pmos ad=0.19p pd=1.38u as=0.19p ps=1.38u w=1u l=0.13u
M283 SC0/vss ph_sw[1] SC0/buf_16_3.z SC0/vss sg13_lv_nmos ad=95f pd=0.88u as=95f ps=0.88u w=0.5u l=0.13u
M284 SC0/buf_32_1.z ph_sw[0] SC0/vss SC0/vss sg13_lv_nmos ad=95f pd=0.88u as=95f ps=0.88u w=0.5u l=0.13u
M285 SC0/buf_32_1.z ph_sw[0] vddr vddr sg13_lv_pmos ad=0.34p pd=2.68u as=0.19p ps=1.38u w=1u l=0.13u
M286 vddr ph_sw[2] SC0/buf_16_0.z vddr sg13_lv_pmos ad=0.19p pd=1.38u as=0.19p ps=1.38u w=1u l=0.13u
M287 SC0/buf_4_1.z ph_sw[6] vddr vddr sg13_lv_pmos ad=0.19p pd=1.38u as=0.19p ps=1.38u w=1u l=0.13u
M288 SC0/vss pl_sw[1] SC0/buf_16_2.z SC0/vss sg13_lv_nmos ad=95f pd=0.88u as=95f ps=0.88u w=0.5u l=0.13u
M289 SC0/vss ph_sw[3] SC0/buf_8_3.z SC0/vss sg13_lv_nmos ad=95f pd=0.88u as=95f ps=0.88u w=0.5u l=0.13u
M290 SC0/buf_16_1.z pl_sw[2] vddr vddr sg13_lv_pmos ad=0.19p pd=1.38u as=0.19p ps=1.38u w=1u l=0.13u
M291 SC0/buf_16_2.z pl_sw[1] SC0/vss SC0/vss sg13_lv_nmos ad=95f pd=0.88u as=95f ps=0.88u w=0.5u l=0.13u
M292 SC0/buf_8_3.z ph_sw[3] vddr vddr sg13_lv_pmos ad=0.19p pd=1.38u as=0.19p ps=1.38u w=1u l=0.13u
M293 SC0/vss pl_sw[5] SC0/buf_8_4.z SC0/vss sg13_lv_nmos ad=95f pd=0.88u as=95f ps=0.88u w=0.5u l=0.13u
M294 vddr pl_sw[1] SC0/buf_16_2.z vddr sg13_lv_pmos ad=0.19p pd=1.38u as=0.19p ps=1.38u w=1u l=0.13u
M295 vddr pl_sw[2] SC0/buf_16_1.z vddr sg13_lv_pmos ad=0.19p pd=1.38u as=0.19p ps=1.38u w=1u l=0.13u
M296 SC0/buf_32_0.z pl_sw[0] vddr vddr sg13_lv_pmos ad=0.19p pd=1.38u as=0.19p ps=1.38u w=1u l=0.13u
M297 vddr ph_sw[1] SC0/buf_16_3.z vddr sg13_lv_pmos ad=0.19p pd=1.38u as=0.19p ps=1.38u w=1u l=0.13u
M298 SC0/vss ph_sw[0] SC0/buf_32_1.z SC0/vss sg13_lv_nmos ad=95f pd=0.88u as=95f ps=0.88u w=0.5u l=0.13u
M299 vddr pl_sw[7] SC0/buf_4_0.z vddr sg13_lv_pmos ad=0.19p pd=1.38u as=0.19p ps=1.38u w=1u l=0.13u
M300 SC0/buf_32_0.z pl_sw[0] SC0/vss SC0/vss sg13_lv_nmos ad=0.17p pd=1.68u as=95f ps=0.88u w=0.5u l=0.13u
M301 SC0/buf_2_0.z ph_sw[8] vddr vddr sg13_lv_pmos ad=0.34p pd=2.68u as=0.19p ps=1.38u w=1u l=0.13u
M302 vddr pl_sw[4] SC0/buf_8_0.z vddr sg13_lv_pmos ad=0.19p pd=1.38u as=0.19p ps=1.38u w=1u l=0.13u
M303 vddr pl_sw[0] SC0/buf_32_0.z vddr sg13_lv_pmos ad=0.19p pd=1.38u as=0.19p ps=1.38u w=1u l=0.13u
M304 SC0/vss ph_sw[10] SC0/buf_1_1.z SC0/vss sg13_lv_nmos ad=0.17p pd=1.68u as=0.17p ps=1.68u w=0.5u l=0.13u
M305 SC0/buf_16_1.z pl_sw[2] SC0/vss SC0/vss sg13_lv_nmos ad=95f pd=0.88u as=95f ps=0.88u w=0.5u l=0.13u
M306 SC0/buf_32_0.z pl_sw[0] SC0/vss SC0/vss sg13_lv_nmos ad=95f pd=0.88u as=95f ps=0.88u w=0.5u l=0.13u
M307 SC0/vss ph_sw[2] SC0/buf_16_0.z SC0/vss sg13_lv_nmos ad=95f pd=0.88u as=95f ps=0.88u w=0.5u l=0.13u
M308 SC0/buf_16_1.z pl_sw[2] vddr vddr sg13_lv_pmos ad=0.19p pd=1.38u as=0.19p ps=1.38u w=1u l=0.13u
M309 SC0/buf_16_2.z pl_sw[1] vddr vddr sg13_lv_pmos ad=0.34p pd=2.68u as=0.19p ps=1.38u w=1u l=0.13u
M310 SC0/buf_16_1.z pl_sw[2] SC0/vss SC0/vss sg13_lv_nmos ad=95f pd=0.88u as=95f ps=0.88u w=0.5u l=0.13u
M311 SC0/vss ph_sw[9] SC0/buf_2_3.z SC0/vss sg13_lv_nmos ad=95f pd=0.88u as=0.17p ps=1.68u w=0.5u l=0.13u
M312 SC0/buf_8_1.z pl_sw[3] SC0/vss SC0/vss sg13_lv_nmos ad=0.17p pd=1.68u as=95f ps=0.88u w=0.5u l=0.13u
M313 SC0/vss pl_sw[10] SC0/buf_1_0.z SC0/vss sg13_lv_nmos ad=0.17p pd=1.68u as=0.17p ps=1.68u w=0.5u l=0.13u
M314 SC0/buf_32_0.z pl_sw[0] vddr vddr sg13_lv_pmos ad=0.19p pd=1.38u as=0.19p ps=1.38u w=1u l=0.13u
M315 vddr ph_sw[0] SC0/buf_32_1.z vddr sg13_lv_pmos ad=0.19p pd=1.38u as=0.19p ps=1.38u w=1u l=0.13u
M316 SC0/buf_8_4.z pl_sw[5] vddr vddr sg13_lv_pmos ad=0.34p pd=2.68u as=0.19p ps=1.38u w=1u l=0.13u
M317 SC0/vss pl_sw[0] SC0/buf_32_0.z SC0/vss sg13_lv_nmos ad=95f pd=0.88u as=95f ps=0.88u w=0.5u l=0.13u
M318 SC0/vss ph_sw[0] SC0/buf_32_1.z SC0/vss sg13_lv_nmos ad=95f pd=0.88u as=0.17p ps=1.68u w=0.5u l=0.13u
M319 SC0/buf_16_0.z ph_sw[2] vddr vddr sg13_lv_pmos ad=0.19p pd=1.38u as=0.19p ps=1.38u w=1u l=0.13u
M320 SC0/buf_16_3.z ph_sw[1] vddr vddr sg13_lv_pmos ad=0.19p pd=1.38u as=0.19p ps=1.38u w=1u l=0.13u
M321 SC0/vss ph_sw[1] SC0/buf_16_3.z SC0/vss sg13_lv_nmos ad=95f pd=0.88u as=95f ps=0.88u w=0.5u l=0.13u
M322 SC0/buf_32_1.z ph_sw[0] vddr vddr sg13_lv_pmos ad=0.19p pd=1.38u as=0.19p ps=1.38u w=1u l=0.13u
M323 SC0/buf_8_0.z pl_sw[4] SC0/vss SC0/vss sg13_lv_nmos ad=95f pd=0.88u as=95f ps=0.88u w=0.5u l=0.13u
M324 SC0/buf_32_0.z pl_sw[0] SC0/vss SC0/vss sg13_lv_nmos ad=95f pd=0.88u as=95f ps=0.88u w=0.5u l=0.13u
M325 SC0/vss ph_sw[2] SC0/buf_16_0.z SC0/vss sg13_lv_nmos ad=95f pd=0.88u as=95f ps=0.88u w=0.5u l=0.13u
M326 SC0/buf_32_1.z ph_sw[0] SC0/vss SC0/vss sg13_lv_nmos ad=95f pd=0.88u as=95f ps=0.88u w=0.5u l=0.13u
M327 SC0/vss pl_sw[6] SC0/buf_4_3.z SC0/vss sg13_lv_nmos ad=95f pd=0.88u as=95f ps=0.88u w=0.5u l=0.13u
M328 SC0/buf_32_0.z pl_sw[0] vddr vddr sg13_lv_pmos ad=0.19p pd=1.38u as=0.19p ps=1.38u w=1u l=0.13u
M329 vddr pl_sw[3] SC0/buf_8_1.z vddr sg13_lv_pmos ad=0.19p pd=1.38u as=0.34p ps=2.68u w=1u l=0.13u
M330 vddr ph_sw[0] SC0/buf_32_1.z vddr sg13_lv_pmos ad=0.19p pd=1.38u as=0.19p ps=1.38u w=1u l=0.13u
M331 vddr pl_sw[1] SC0/buf_16_2.z vddr sg13_lv_pmos ad=0.19p pd=1.38u as=0.34p ps=2.68u w=1u l=0.13u
M332 vddr ph_sw[7] SC0/buf_4_2.z vddr sg13_lv_pmos ad=0.19p pd=1.38u as=0.19p ps=1.38u w=1u l=0.13u
M333 SC0/buf_16_3.z ph_sw[1] SC0/vss SC0/vss sg13_lv_nmos ad=95f pd=0.88u as=95f ps=0.88u w=0.5u l=0.13u
M334 SC0/vss pl_sw[0] SC0/buf_32_0.z SC0/vss sg13_lv_nmos ad=95f pd=0.88u as=95f ps=0.88u w=0.5u l=0.13u
M335 SC0/buf_8_2.z ph_sw[4] SC0/vss SC0/vss sg13_lv_nmos ad=95f pd=0.88u as=95f ps=0.88u w=0.5u l=0.13u
M336 SC0/vss ph_sw[0] SC0/buf_32_1.z SC0/vss sg13_lv_nmos ad=95f pd=0.88u as=95f ps=0.88u w=0.5u l=0.13u
M337 vddr ph_sw[0] SC0/buf_32_1.z vddr sg13_lv_pmos ad=0.19p pd=1.38u as=0.19p ps=1.38u w=1u l=0.13u
M338 SC0/buf_16_0.z ph_sw[2] vddr vddr sg13_lv_pmos ad=0.19p pd=1.38u as=0.19p ps=1.38u w=1u l=0.13u
M339 SC0/buf_32_1.z ph_sw[0] SC0/vss SC0/vss sg13_lv_nmos ad=0.17p pd=1.68u as=95f ps=0.88u w=0.5u l=0.13u
M340 vddr ph_sw[1] SC0/buf_16_3.z vddr sg13_lv_pmos ad=0.19p pd=1.38u as=0.34p ps=2.68u w=1u l=0.13u
M341 SC0/buf_16_2.z pl_sw[1] SC0/vss SC0/vss sg13_lv_nmos ad=95f pd=0.88u as=95f ps=0.88u w=0.5u l=0.13u
M342 SC0/buf_8_5.z ph_sw[5] vddr vddr sg13_lv_pmos ad=0.34p pd=2.68u as=0.19p ps=1.38u w=1u l=0.13u
M343 SC0/vss pl_sw[1] SC0/buf_16_2.z SC0/vss sg13_lv_nmos ad=95f pd=0.88u as=95f ps=0.88u w=0.5u l=0.13u
M344 SC0/buf_32_1.z ph_sw[0] vddr vddr sg13_lv_pmos ad=0.19p pd=1.38u as=0.19p ps=1.38u w=1u l=0.13u
M345 SC0/buf_8_3.z ph_sw[3] SC0/vss SC0/vss sg13_lv_nmos ad=95f pd=0.88u as=95f ps=0.88u w=0.5u l=0.13u
M346 SC0/buf_32_0.z pl_sw[0] SC0/vss SC0/vss sg13_lv_nmos ad=95f pd=0.88u as=95f ps=0.88u w=0.5u l=0.13u
M347 vddr ph_sw[3] SC0/buf_8_3.z vddr sg13_lv_pmos ad=0.19p pd=1.38u as=0.19p ps=1.38u w=1u l=0.13u
M348 SC0/buf_16_2.z pl_sw[1] vddr vddr sg13_lv_pmos ad=0.19p pd=1.38u as=0.19p ps=1.38u w=1u l=0.13u
M349 SC0/buf_16_1.z pl_sw[2] vddr vddr sg13_lv_pmos ad=0.19p pd=1.38u as=0.19p ps=1.38u w=1u l=0.13u
M350 vddr pl_sw[0] SC0/buf_32_0.z vddr sg13_lv_pmos ad=0.19p pd=1.38u as=0.19p ps=1.38u w=1u l=0.13u
M351 vddr ph_sw[4] SC0/buf_8_2.z vddr sg13_lv_pmos ad=0.19p pd=1.38u as=0.19p ps=1.38u w=1u l=0.13u
M352 SC0/vss ph_sw[7] SC0/buf_4_2.z SC0/vss sg13_lv_nmos ad=95f pd=0.88u as=0.17p ps=1.68u w=0.5u l=0.13u
M353 SC0/buf_16_3.z ph_sw[1] vddr vddr sg13_lv_pmos ad=0.19p pd=1.38u as=0.19p ps=1.38u w=1u l=0.13u
M354 vddr ph_sw[0] SC0/buf_32_1.z vddr sg13_lv_pmos ad=0.19p pd=1.38u as=0.19p ps=1.38u w=1u l=0.13u
M355 SC0/buf_16_3.z ph_sw[1] SC0/vss SC0/vss sg13_lv_nmos ad=95f pd=0.88u as=95f ps=0.88u w=0.5u l=0.13u
M356 vddr pl_sw[4] SC0/buf_8_0.z vddr sg13_lv_pmos ad=0.19p pd=1.38u as=0.19p ps=1.38u w=1u l=0.13u
M357 SC0/vss pl_sw[0] SC0/buf_32_0.z SC0/vss sg13_lv_nmos ad=95f pd=0.88u as=95f ps=0.88u w=0.5u l=0.13u
M358 SC0/buf_16_0.z ph_sw[2] vddr vddr sg13_lv_pmos ad=0.19p pd=1.38u as=0.19p ps=1.38u w=1u l=0.13u
M359 SC0/vss pl_sw[2] SC0/buf_16_1.z SC0/vss sg13_lv_nmos ad=95f pd=0.88u as=95f ps=0.88u w=0.5u l=0.13u
M360 SC0/buf_8_5.z ph_sw[5] vddr vddr sg13_lv_pmos ad=0.19p pd=1.38u as=0.19p ps=1.38u w=1u l=0.13u
M361 SC0/vss pl_sw[4] SC0/buf_8_0.z SC0/vss sg13_lv_nmos ad=95f pd=0.88u as=95f ps=0.88u w=0.5u l=0.13u
M362 vddr pl_sw[2] SC0/buf_16_1.z vddr sg13_lv_pmos ad=0.19p pd=1.38u as=0.19p ps=1.38u w=1u l=0.13u
M363 vddr pl_sw[1] SC0/buf_16_2.z vddr sg13_lv_pmos ad=0.19p pd=1.38u as=0.19p ps=1.38u w=1u l=0.13u
M364 vddr ph_sw[3] SC0/buf_8_3.z vddr sg13_lv_pmos ad=0.19p pd=1.38u as=0.34p ps=2.68u w=1u l=0.13u
M365 SC0/buf_8_4.z pl_sw[5] SC0/vss SC0/vss sg13_lv_nmos ad=95f pd=0.88u as=95f ps=0.88u w=0.5u l=0.13u
M366 SC0/vss pl_sw[3] SC0/buf_8_1.z SC0/vss sg13_lv_nmos ad=95f pd=0.88u as=95f ps=0.88u w=0.5u l=0.13u
M367 vddr pl_sw[0] SC0/buf_32_0.z vddr sg13_lv_pmos ad=0.19p pd=1.38u as=0.34p ps=2.68u w=1u l=0.13u
M368 vddr ph_sw[4] SC0/buf_8_2.z vddr sg13_lv_pmos ad=0.19p pd=1.38u as=0.19p ps=1.38u w=1u l=0.13u
M369 SC0/buf_2_3.z ph_sw[9] vddr vddr sg13_lv_pmos ad=0.34p pd=2.68u as=0.19p ps=1.38u w=1u l=0.13u
M370 vddr pl_sw[5] SC0/buf_8_4.z vddr sg13_lv_pmos ad=0.19p pd=1.38u as=0.19p ps=1.38u w=1u l=0.13u
M371 SC0/buf_8_5.z ph_sw[5] SC0/vss SC0/vss sg13_lv_nmos ad=95f pd=0.88u as=95f ps=0.88u w=0.5u l=0.13u
M372 SC0/buf_32_0.z pl_sw[0] vddr vddr sg13_lv_pmos ad=0.19p pd=1.38u as=0.19p ps=1.38u w=1u l=0.13u
M373 SC0/buf_16_3.z ph_sw[1] SC0/vss SC0/vss sg13_lv_nmos ad=95f pd=0.88u as=95f ps=0.88u w=0.5u l=0.13u
M374 SC0/buf_16_0.z ph_sw[2] SC0/vss SC0/vss sg13_lv_nmos ad=0.17p pd=1.68u as=95f ps=0.88u w=0.5u l=0.13u
M375 SC0/buf_16_0.z ph_sw[2] SC0/vss SC0/vss sg13_lv_nmos ad=95f pd=0.88u as=95f ps=0.88u w=0.5u l=0.13u
M376 SC0/vss ph_sw[6] SC0/buf_4_1.z SC0/vss sg13_lv_nmos ad=95f pd=0.88u as=95f ps=0.88u w=0.5u l=0.13u
M377 SC0/vss ph_sw[0] SC0/buf_32_1.z SC0/vss sg13_lv_nmos ad=95f pd=0.88u as=95f ps=0.88u w=0.5u l=0.13u
M378 SC0/buf_32_0.z pl_sw[0] vddr vddr sg13_lv_pmos ad=0.34p pd=2.68u as=0.19p ps=1.38u w=1u l=0.13u
M379 SC0/buf_4_1.z ph_sw[6] vddr vddr sg13_lv_pmos ad=0.34p pd=2.68u as=0.19p ps=1.38u w=1u l=0.13u
M380 SC0/buf_8_1.z pl_sw[3] vddr vddr sg13_lv_pmos ad=0.19p pd=1.38u as=0.19p ps=1.38u w=1u l=0.13u
M381 vddr pl_sw[0] SC0/buf_32_0.z vddr sg13_lv_pmos ad=0.19p pd=1.38u as=0.19p ps=1.38u w=1u l=0.13u
M382 SC0/buf_32_0.z pl_sw[0] SC0/vss SC0/vss sg13_lv_nmos ad=95f pd=0.88u as=95f ps=0.88u w=0.5u l=0.13u
M383 SC0/buf_32_1.z ph_sw[0] SC0/vss SC0/vss sg13_lv_nmos ad=95f pd=0.88u as=95f ps=0.88u w=0.5u l=0.13u
M384 SC0/vss ph_sw[0] SC0/buf_32_1.z SC0/vss sg13_lv_nmos ad=95f pd=0.88u as=95f ps=0.88u w=0.5u l=0.13u
M385 vddr pl_sw[6] SC0/buf_4_3.z vddr sg13_lv_pmos ad=0.19p pd=1.38u as=0.19p ps=1.38u w=1u l=0.13u
M386 vddr ph_sw[0] SC0/buf_32_1.z vddr sg13_lv_pmos ad=0.19p pd=1.38u as=0.19p ps=1.38u w=1u l=0.13u
M387 SC0/vss pl_sw[0] SC0/buf_32_0.z SC0/vss sg13_lv_nmos ad=95f pd=0.88u as=95f ps=0.88u w=0.5u l=0.13u
M388 vddr pl_sw[1] SC0/buf_16_2.z vddr sg13_lv_pmos ad=0.19p pd=1.38u as=0.19p ps=1.38u w=1u l=0.13u
M389 SC0/buf_4_0.z pl_sw[7] SC0/vss SC0/vss sg13_lv_nmos ad=95f pd=0.88u as=95f ps=0.88u w=0.5u l=0.13u
M390 vddr pl_sw[5] SC0/buf_8_4.z vddr sg13_lv_pmos ad=0.19p pd=1.38u as=0.34p ps=2.68u w=1u l=0.13u
M391 vddr ph_sw[1] SC0/buf_16_3.z vddr sg13_lv_pmos ad=0.19p pd=1.38u as=0.19p ps=1.38u w=1u l=0.13u
M392 vddr pl_sw[2] SC0/buf_16_1.z vddr sg13_lv_pmos ad=0.19p pd=1.38u as=0.34p ps=2.68u w=1u l=0.13u
M393 SC0/buf_32_1.z ph_sw[0] vddr vddr sg13_lv_pmos ad=0.19p pd=1.38u as=0.19p ps=1.38u w=1u l=0.13u
M394 SC0/vss ph_sw[1] SC0/buf_16_3.z SC0/vss sg13_lv_nmos ad=95f pd=0.88u as=95f ps=0.88u w=0.5u l=0.13u
M395 vddr ph_sw[2] SC0/buf_16_0.z vddr sg13_lv_pmos ad=0.19p pd=1.38u as=0.19p ps=1.38u w=1u l=0.13u
M396 SC0/buf_2_0.z ph_sw[8] SC0/vss SC0/vss sg13_lv_nmos ad=0.17p pd=1.68u as=95f ps=0.88u w=0.5u l=0.13u
M397 SC0/buf_16_1.z pl_sw[2] vddr vddr sg13_lv_pmos ad=0.19p pd=1.38u as=0.19p ps=1.38u w=1u l=0.13u
M398 vddr ph_sw[5] SC0/buf_8_5.z vddr sg13_lv_pmos ad=0.19p pd=1.38u as=0.19p ps=1.38u w=1u l=0.13u
M399 SC0/vss pl_sw[5] SC0/buf_8_4.z SC0/vss sg13_lv_nmos ad=95f pd=0.88u as=95f ps=0.88u w=0.5u l=0.13u
M400 SC0/buf_16_2.z pl_sw[1] SC0/vss SC0/vss sg13_lv_nmos ad=95f pd=0.88u as=95f ps=0.88u w=0.5u l=0.13u
M401 SC0/buf_8_0.z pl_sw[4] SC0/vss SC0/vss sg13_lv_nmos ad=95f pd=0.88u as=95f ps=0.88u w=0.5u l=0.13u
M402 vddr pl_sw[1] SC0/buf_16_2.z vddr sg13_lv_pmos ad=0.19p pd=1.38u as=0.19p ps=1.38u w=1u l=0.13u
M403 SC0/buf_8_2.z ph_sw[4] vddr vddr sg13_lv_pmos ad=0.19p pd=1.38u as=0.19p ps=1.38u w=1u l=0.13u
M0 vdd nh_sw[1] SC1/buf_16_3.z vdd sg13_lv_pmos ad=0.19p pd=1.38u as=0.19p ps=1.38u w=1u l=0.13u
M1 SC1/vss nh_sw[0] SC1/buf_32_1.z SC1/vss sg13_lv_nmos ad=95f pd=0.88u as=95f ps=0.88u w=0.5u l=0.13u
M2 vdd nl_sw[4] SC1/buf_8_0.z vdd sg13_lv_pmos ad=0.19p pd=1.38u as=0.19p ps=1.38u w=1u l=0.13u
M3 vdd nl_sw[0] SC1/buf_32_0.z vdd sg13_lv_pmos ad=0.19p pd=1.38u as=0.19p ps=1.38u w=1u l=0.13u
M4 SC1/buf_16_1.z nl_sw[2] SC1/vss SC1/vss sg13_lv_nmos ad=95f pd=0.88u as=95f ps=0.88u w=0.5u l=0.13u
M5 SC1/vss nh_sw[2] SC1/buf_16_0.z SC1/vss sg13_lv_nmos ad=95f pd=0.88u as=95f ps=0.88u w=0.5u l=0.13u
M6 SC1/buf_32_0.z nl_sw[0] SC1/vss SC1/vss sg13_lv_nmos ad=95f pd=0.88u as=95f ps=0.88u w=0.5u l=0.13u
M7 SC1/vss nh_sw[2] SC1/buf_16_0.z SC1/vss sg13_lv_nmos ad=95f pd=0.88u as=95f ps=0.88u w=0.5u l=0.13u
M8 vdd nh_sw[5] SC1/buf_8_5.z vdd sg13_lv_pmos ad=0.19p pd=1.38u as=0.34p ps=2.68u w=1u l=0.13u
M9 SC1/buf_16_1.z nl_sw[2] SC1/vss SC1/vss sg13_lv_nmos ad=95f pd=0.88u as=95f ps=0.88u w=0.5u l=0.13u
M10 SC1/buf_32_1.z nh_sw[0] SC1/vss SC1/vss sg13_lv_nmos ad=95f pd=0.88u as=95f ps=0.88u w=0.5u l=0.13u
M11 vdd nl_sw[0] SC1/buf_32_0.z vdd sg13_lv_pmos ad=0.19p pd=1.38u as=0.19p ps=1.38u w=1u l=0.13u
M12 SC1/buf_32_0.z nl_sw[0] vdd vdd sg13_lv_pmos ad=0.19p pd=1.38u as=0.19p ps=1.38u w=1u l=0.13u
M13 SC1/buf_2_2.z nl_sw[9] SC1/vss SC1/vss sg13_lv_nmos ad=0.17p pd=1.68u as=95f ps=0.88u w=0.5u l=0.13u
M14 vdd nh_sw[0] SC1/buf_32_1.z vdd sg13_lv_pmos ad=0.19p pd=1.38u as=0.19p ps=1.38u w=1u l=0.13u
M15 SC1/vss nl_sw[0] SC1/buf_32_0.z SC1/vss sg13_lv_nmos ad=95f pd=0.88u as=95f ps=0.88u w=0.5u l=0.13u
M16 SC1/buf_8_2.z nh_sw[4] SC1/vss SC1/vss sg13_lv_nmos ad=0.17p pd=1.68u as=95f ps=0.88u w=0.5u l=0.13u
M17 SC1/buf_16_0.z nh_sw[2] vdd vdd sg13_lv_pmos ad=0.34p pd=2.68u as=0.19p ps=1.38u w=1u l=0.13u
M18 SC1/vss nh_sw[0] SC1/buf_32_1.z SC1/vss sg13_lv_nmos ad=95f pd=0.88u as=95f ps=0.88u w=0.5u l=0.13u
M19 SC1/buf_16_3.z nh_sw[1] vdd vdd sg13_lv_pmos ad=0.19p pd=1.38u as=0.19p ps=1.38u w=1u l=0.13u
M20 SC1/buf_32_1.z nh_sw[0] vdd vdd sg13_lv_pmos ad=0.19p pd=1.38u as=0.19p ps=1.38u w=1u l=0.13u
M21 SC1/vss nh_sw[1] SC1/buf_16_3.z SC1/vss sg13_lv_nmos ad=95f pd=0.88u as=0.17p ps=1.68u w=0.5u l=0.13u
M22 SC1/buf_32_0.z nl_sw[0] SC1/vss SC1/vss sg13_lv_nmos ad=95f pd=0.88u as=95f ps=0.88u w=0.5u l=0.13u
M23 vdd nh_sw[3] SC1/buf_8_3.z vdd sg13_lv_pmos ad=0.19p pd=1.38u as=0.19p ps=1.38u w=1u l=0.13u
M24 SC1/buf_2_1.z nl_sw[8] vdd vdd sg13_lv_pmos ad=0.34p pd=2.68u as=0.19p ps=1.38u w=1u l=0.13u
M25 SC1/buf_32_1.z nh_sw[0] SC1/vss SC1/vss sg13_lv_nmos ad=95f pd=0.88u as=95f ps=0.88u w=0.5u l=0.13u
M26 vdd nh_sw[2] SC1/buf_16_0.z vdd sg13_lv_pmos ad=0.19p pd=1.38u as=0.34p ps=2.68u w=1u l=0.13u
M27 SC1/buf_8_1.z nl_sw[3] SC1/vss SC1/vss sg13_lv_nmos ad=95f pd=0.88u as=95f ps=0.88u w=0.5u l=0.13u
M28 vdd nl_sw[3] SC1/buf_8_1.z vdd sg13_lv_pmos ad=0.19p pd=1.38u as=0.19p ps=1.38u w=1u l=0.13u
M29 vdd nh_sw[0] SC1/buf_32_1.z vdd sg13_lv_pmos ad=0.19p pd=1.38u as=0.19p ps=1.38u w=1u l=0.13u
M30 SC1/buf_16_3.z nh_sw[1] SC1/vss SC1/vss sg13_lv_nmos ad=95f pd=0.88u as=95f ps=0.88u w=0.5u l=0.13u
M31 SC1/buf_8_2.z nh_sw[4] SC1/vss SC1/vss sg13_lv_nmos ad=95f pd=0.88u as=95f ps=0.88u w=0.5u l=0.13u
M32 SC1/vss nh_sw[0] SC1/buf_32_1.z SC1/vss sg13_lv_nmos ad=95f pd=0.88u as=95f ps=0.88u w=0.5u l=0.13u
M33 vdd nh_sw[0] SC1/buf_32_1.z vdd sg13_lv_pmos ad=0.19p pd=1.38u as=0.19p ps=1.38u w=1u l=0.13u
M34 SC1/buf_16_0.z nh_sw[2] vdd vdd sg13_lv_pmos ad=0.19p pd=1.38u as=0.19p ps=1.38u w=1u l=0.13u
M35 vdd nh_sw[6] SC1/buf_4_1.z vdd sg13_lv_pmos ad=0.19p pd=1.38u as=0.34p ps=2.68u w=1u l=0.13u
M36 SC1/buf_16_2.z nl_sw[1] SC1/vss SC1/vss sg13_lv_nmos ad=95f pd=0.88u as=95f ps=0.88u w=0.5u l=0.13u
M37 SC1/vss nl_sw[1] SC1/buf_16_2.z SC1/vss sg13_lv_nmos ad=95f pd=0.88u as=95f ps=0.88u w=0.5u l=0.13u
M38 SC1/buf_8_3.z nh_sw[3] SC1/vss SC1/vss sg13_lv_nmos ad=95f pd=0.88u as=95f ps=0.88u w=0.5u l=0.13u
M39 vdd nl_sw[2] SC1/buf_16_1.z vdd sg13_lv_pmos ad=0.19p pd=1.38u as=0.19p ps=1.38u w=1u l=0.13u
M40 SC1/buf_8_4.z nl_sw[5] SC1/vss SC1/vss sg13_lv_nmos ad=95f pd=0.88u as=95f ps=0.88u w=0.5u l=0.13u
M41 SC1/buf_32_0.z nl_sw[0] SC1/vss SC1/vss sg13_lv_nmos ad=95f pd=0.88u as=95f ps=0.88u w=0.5u l=0.13u
M42 vdd nh_sw[3] SC1/buf_8_3.z vdd sg13_lv_pmos ad=0.19p pd=1.38u as=0.19p ps=1.38u w=1u l=0.13u
M43 SC1/buf_16_1.z nl_sw[2] vdd vdd sg13_lv_pmos ad=0.19p pd=1.38u as=0.19p ps=1.38u w=1u l=0.13u
M44 SC1/buf_16_2.z nl_sw[1] vdd vdd sg13_lv_pmos ad=0.19p pd=1.38u as=0.19p ps=1.38u w=1u l=0.13u
M45 vdd nl_sw[0] SC1/buf_32_0.z vdd sg13_lv_pmos ad=0.19p pd=1.38u as=0.19p ps=1.38u w=1u l=0.13u
M46 SC1/vss nh_sw[7] SC1/buf_4_2.z SC1/vss sg13_lv_nmos ad=95f pd=0.88u as=95f ps=0.88u w=0.5u l=0.13u
M47 SC1/buf_2_2.z nl_sw[9] vdd vdd sg13_lv_pmos ad=0.34p pd=2.68u as=0.19p ps=1.38u w=1u l=0.13u
M48 SC1/buf_16_3.z nh_sw[1] vdd vdd sg13_lv_pmos ad=0.19p pd=1.38u as=0.19p ps=1.38u w=1u l=0.13u
M49 SC1/buf_4_0.z nl_sw[7] vdd vdd sg13_lv_pmos ad=0.19p pd=1.38u as=0.19p ps=1.38u w=1u l=0.13u
M50 SC1/vss nl_sw[0] SC1/buf_32_0.z SC1/vss sg13_lv_nmos ad=95f pd=0.88u as=95f ps=0.88u w=0.5u l=0.13u
M51 SC1/buf_8_5.z nh_sw[5] SC1/vss SC1/vss sg13_lv_nmos ad=0.17p pd=1.68u as=95f ps=0.88u w=0.5u l=0.13u
M52 vdd nh_sw[8] SC1/buf_2_0.z vdd sg13_lv_pmos ad=0.19p pd=1.38u as=0.34p ps=2.68u w=1u l=0.13u
M53 SC1/buf_8_0.z nl_sw[4] vdd vdd sg13_lv_pmos ad=0.19p pd=1.38u as=0.19p ps=1.38u w=1u l=0.13u
M54 SC1/buf_32_0.z nl_sw[0] vdd vdd sg13_lv_pmos ad=0.19p pd=1.38u as=0.19p ps=1.38u w=1u l=0.13u
M55 SC1/vss nl_sw[2] SC1/buf_16_1.z SC1/vss sg13_lv_nmos ad=95f pd=0.88u as=95f ps=0.88u w=0.5u l=0.13u
M56 SC1/vss nl_sw[0] SC1/buf_32_0.z SC1/vss sg13_lv_nmos ad=95f pd=0.88u as=95f ps=0.88u w=0.5u l=0.13u
M57 vdd nl_sw[2] SC1/buf_16_1.z vdd sg13_lv_pmos ad=0.19p pd=1.38u as=0.19p ps=1.38u w=1u l=0.13u
M58 vdd nl_sw[1] SC1/buf_16_2.z vdd sg13_lv_pmos ad=0.19p pd=1.38u as=0.19p ps=1.38u w=1u l=0.13u
M59 SC1/vss nl_sw[3] SC1/buf_8_1.z SC1/vss sg13_lv_nmos ad=95f pd=0.88u as=95f ps=0.88u w=0.5u l=0.13u
M60 vdd nl_sw[0] SC1/buf_32_0.z vdd sg13_lv_pmos ad=0.19p pd=1.38u as=0.19p ps=1.38u w=1u l=0.13u
M61 SC1/buf_32_1.z nh_sw[0] vdd vdd sg13_lv_pmos ad=0.19p pd=1.38u as=0.19p ps=1.38u w=1u l=0.13u
M62 vdd nl_sw[5] SC1/buf_8_4.z vdd sg13_lv_pmos ad=0.19p pd=1.38u as=0.19p ps=1.38u w=1u l=0.13u
M63 vdd nh_sw[2] SC1/buf_16_0.z vdd sg13_lv_pmos ad=0.19p pd=1.38u as=0.19p ps=1.38u w=1u l=0.13u
M64 SC1/buf_8_5.z nh_sw[5] SC1/vss SC1/vss sg13_lv_nmos ad=95f pd=0.88u as=95f ps=0.88u w=0.5u l=0.13u
M65 SC1/buf_32_0.z nl_sw[0] vdd vdd sg13_lv_pmos ad=0.19p pd=1.38u as=0.19p ps=1.38u w=1u l=0.13u
M66 SC1/vss nl_sw[4] SC1/buf_8_0.z SC1/vss sg13_lv_nmos ad=95f pd=0.88u as=0.17p ps=1.68u w=0.5u l=0.13u
M67 SC1/buf_16_3.z nh_sw[1] SC1/vss SC1/vss sg13_lv_nmos ad=95f pd=0.88u as=95f ps=0.88u w=0.5u l=0.13u
M68 vdd nh_sw[0] SC1/buf_32_1.z vdd sg13_lv_pmos ad=0.19p pd=1.38u as=0.19p ps=1.38u w=1u l=0.13u
M69 SC1/vss nl_sw[0] SC1/buf_32_0.z SC1/vss sg13_lv_nmos ad=95f pd=0.88u as=0.17p ps=1.68u w=0.5u l=0.13u
M70 SC1/buf_16_0.z nh_sw[2] SC1/vss SC1/vss sg13_lv_nmos ad=95f pd=0.88u as=95f ps=0.88u w=0.5u l=0.13u
M71 SC1/vss nh_sw[0] SC1/buf_32_1.z SC1/vss sg13_lv_nmos ad=95f pd=0.88u as=95f ps=0.88u w=0.5u l=0.13u
M72 SC1/buf_2_1.z nl_sw[8] SC1/vss SC1/vss sg13_lv_nmos ad=0.17p pd=1.68u as=95f ps=0.88u w=0.5u l=0.13u
M73 vdd nl_sw[0] SC1/buf_32_0.z vdd sg13_lv_pmos ad=0.19p pd=1.38u as=0.19p ps=1.38u w=1u l=0.13u
M74 SC1/buf_4_3.z nl_sw[6] SC1/vss SC1/vss sg13_lv_nmos ad=95f pd=0.88u as=95f ps=0.88u w=0.5u l=0.13u
M75 SC1/buf_8_1.z nl_sw[3] vdd vdd sg13_lv_pmos ad=0.34p pd=2.68u as=0.19p ps=1.38u w=1u l=0.13u
M76 SC1/buf_32_1.z nh_sw[0] vdd vdd sg13_lv_pmos ad=0.19p pd=1.38u as=0.19p ps=1.38u w=1u l=0.13u
M77 SC1/buf_4_2.z nh_sw[7] vdd vdd sg13_lv_pmos ad=0.19p pd=1.38u as=0.19p ps=1.38u w=1u l=0.13u
M78 SC1/vss nh_sw[1] SC1/buf_16_3.z SC1/vss sg13_lv_nmos ad=95f pd=0.88u as=95f ps=0.88u w=0.5u l=0.13u
M79 SC1/buf_32_0.z nl_sw[0] SC1/vss SC1/vss sg13_lv_nmos ad=95f pd=0.88u as=95f ps=0.88u w=0.5u l=0.13u
M80 SC1/vss nh_sw[4] SC1/buf_8_2.z SC1/vss sg13_lv_nmos ad=95f pd=0.88u as=95f ps=0.88u w=0.5u l=0.13u
M81 SC1/buf_32_1.z nh_sw[0] SC1/vss SC1/vss sg13_lv_nmos ad=95f pd=0.88u as=95f ps=0.88u w=0.5u l=0.13u
M82 SC1/buf_32_1.z nh_sw[0] vdd vdd sg13_lv_pmos ad=0.19p pd=1.38u as=0.19p ps=1.38u w=1u l=0.13u
M83 vdd nh_sw[2] SC1/buf_16_0.z vdd sg13_lv_pmos ad=0.19p pd=1.38u as=0.19p ps=1.38u w=1u l=0.13u
M84 SC1/vss nh_sw[0] SC1/buf_32_1.z SC1/vss sg13_lv_nmos ad=95f pd=0.88u as=95f ps=0.88u w=0.5u l=0.13u
M85 vdd nh_sw[5] SC1/buf_8_5.z vdd sg13_lv_pmos ad=0.19p pd=1.38u as=0.19p ps=1.38u w=1u l=0.13u
M86 SC1/buf_16_2.z nl_sw[1] SC1/vss SC1/vss sg13_lv_nmos ad=95f pd=0.88u as=95f ps=0.88u w=0.5u l=0.13u
M87 vdd nh_sw[0] SC1/buf_32_1.z vdd sg13_lv_pmos ad=0.19p pd=1.38u as=0.19p ps=1.38u w=1u l=0.13u
M88 vdd nl_sw[1] SC1/buf_16_2.z vdd sg13_lv_pmos ad=0.19p pd=1.38u as=0.19p ps=1.38u w=1u l=0.13u
M89 SC1/vss nl_sw[0] SC1/buf_32_0.z SC1/vss sg13_lv_nmos ad=95f pd=0.88u as=95f ps=0.88u w=0.5u l=0.13u
M90 SC1/buf_8_3.z nh_sw[3] vdd vdd sg13_lv_pmos ad=0.19p pd=1.38u as=0.19p ps=1.38u w=1u l=0.13u
M91 SC1/buf_4_0.z nl_sw[7] SC1/vss SC1/vss sg13_lv_nmos ad=0.17p pd=1.68u as=95f ps=0.88u w=0.5u l=0.13u
M92 vdd nl_sw[5] SC1/buf_8_4.z vdd sg13_lv_pmos ad=0.19p pd=1.38u as=0.19p ps=1.38u w=1u l=0.13u
M93 vdd nh_sw[1] SC1/buf_16_3.z vdd sg13_lv_pmos ad=0.19p pd=1.38u as=0.19p ps=1.38u w=1u l=0.13u
M94 SC1/buf_32_1.z nh_sw[0] vdd vdd sg13_lv_pmos ad=0.19p pd=1.38u as=0.19p ps=1.38u w=1u l=0.13u
M95 SC1/vss nh_sw[1] SC1/buf_16_3.z SC1/vss sg13_lv_nmos ad=95f pd=0.88u as=95f ps=0.88u w=0.5u l=0.13u
M96 SC1/vss nh_sw[4] SC1/buf_8_2.z SC1/vss sg13_lv_nmos ad=95f pd=0.88u as=0.17p ps=1.68u w=0.5u l=0.13u
M97 SC1/buf_8_0.z nl_sw[4] vdd vdd sg13_lv_pmos ad=0.19p pd=1.38u as=0.19p ps=1.38u w=1u l=0.13u
M98 SC1/buf_32_0.z nl_sw[0] SC1/vss SC1/vss sg13_lv_nmos ad=95f pd=0.88u as=95f ps=0.88u w=0.5u l=0.13u
M99 vdd nh_sw[2] SC1/buf_16_0.z vdd sg13_lv_pmos ad=0.19p pd=1.38u as=0.19p ps=1.38u w=1u l=0.13u
M100 SC1/buf_16_1.z nl_sw[2] SC1/vss SC1/vss sg13_lv_nmos ad=95f pd=0.88u as=95f ps=0.88u w=0.5u l=0.13u
M101 SC1/buf_16_2.z nl_sw[1] SC1/vss SC1/vss sg13_lv_nmos ad=95f pd=0.88u as=95f ps=0.88u w=0.5u l=0.13u
M102 vdd nh_sw[5] SC1/buf_8_5.z vdd sg13_lv_pmos ad=0.19p pd=1.38u as=0.19p ps=1.38u w=1u l=0.13u
M103 SC1/buf_16_1.z nl_sw[2] vdd vdd sg13_lv_pmos ad=0.19p pd=1.38u as=0.19p ps=1.38u w=1u l=0.13u
M104 SC1/buf_16_2.z nl_sw[1] vdd vdd sg13_lv_pmos ad=0.19p pd=1.38u as=0.19p ps=1.38u w=1u l=0.13u
M105 SC1/buf_8_0.z nl_sw[4] SC1/vss SC1/vss sg13_lv_nmos ad=95f pd=0.88u as=95f ps=0.88u w=0.5u l=0.13u
M106 SC1/vss nl_sw[5] SC1/buf_8_4.z SC1/vss sg13_lv_nmos ad=95f pd=0.88u as=0.17p ps=1.68u w=0.5u l=0.13u
M107 SC1/buf_8_1.z nl_sw[3] SC1/vss SC1/vss sg13_lv_nmos ad=95f pd=0.88u as=95f ps=0.88u w=0.5u l=0.13u
M108 SC1/buf_8_2.z nh_sw[4] vdd vdd sg13_lv_pmos ad=0.19p pd=1.38u as=0.19p ps=1.38u w=1u l=0.13u
M109 vdd nh_sw[9] SC1/buf_2_3.z vdd sg13_lv_pmos ad=0.19p pd=1.38u as=0.34p ps=2.68u w=1u l=0.13u
M110 SC1/buf_8_4.z nl_sw[5] vdd vdd sg13_lv_pmos ad=0.19p pd=1.38u as=0.19p ps=1.38u w=1u l=0.13u
M111 SC1/vss nh_sw[0] SC1/buf_32_1.z SC1/vss sg13_lv_nmos ad=95f pd=0.88u as=95f ps=0.88u w=0.5u l=0.13u
M112 SC1/vss nh_sw[5] SC1/buf_8_5.z SC1/vss sg13_lv_nmos ad=95f pd=0.88u as=95f ps=0.88u w=0.5u l=0.13u
M113 vdd nl_sw[0] SC1/buf_32_0.z vdd sg13_lv_pmos ad=0.19p pd=1.38u as=0.19p ps=1.38u w=1u l=0.13u
M114 SC1/buf_16_1.z nl_sw[2] SC1/vss SC1/vss sg13_lv_nmos ad=95f pd=0.88u as=95f ps=0.88u w=0.5u l=0.13u
M115 SC1/vss nh_sw[2] SC1/buf_16_0.z SC1/vss sg13_lv_nmos ad=95f pd=0.88u as=95f ps=0.88u w=0.5u l=0.13u
M116 SC1/vss nh_sw[2] SC1/buf_16_0.z SC1/vss sg13_lv_nmos ad=95f pd=0.88u as=95f ps=0.88u w=0.5u l=0.13u
M117 SC1/buf_32_1.z nh_sw[0] SC1/vss SC1/vss sg13_lv_nmos ad=95f pd=0.88u as=95f ps=0.88u w=0.5u l=0.13u
M118 SC1/buf_4_1.z nh_sw[6] SC1/vss SC1/vss sg13_lv_nmos ad=95f pd=0.88u as=95f ps=0.88u w=0.5u l=0.13u
M119 SC1/buf_16_1.z nl_sw[2] SC1/vss SC1/vss sg13_lv_nmos ad=0.17p pd=1.68u as=95f ps=0.88u w=0.5u l=0.13u
M120 vdd nl_sw[0] SC1/buf_32_0.z vdd sg13_lv_pmos ad=0.19p pd=1.38u as=0.19p ps=1.38u w=1u l=0.13u
M121 vdd nl_sw[3] SC1/buf_8_1.z vdd sg13_lv_pmos ad=0.19p pd=1.38u as=0.19p ps=1.38u w=1u l=0.13u
M122 SC1/buf_32_0.z nl_sw[0] vdd vdd sg13_lv_pmos ad=0.19p pd=1.38u as=0.19p ps=1.38u w=1u l=0.13u
M123 SC1/vss nl_sw[0] SC1/buf_32_0.z SC1/vss sg13_lv_nmos ad=95f pd=0.88u as=95f ps=0.88u w=0.5u l=0.13u
M124 SC1/vss nh_sw[0] SC1/buf_32_1.z SC1/vss sg13_lv_nmos ad=95f pd=0.88u as=95f ps=0.88u w=0.5u l=0.13u
M125 SC1/buf_16_3.z nh_sw[1] vdd vdd sg13_lv_pmos ad=0.34p pd=2.68u as=0.19p ps=1.38u w=1u l=0.13u
M126 SC1/vss nh_sw[5] SC1/buf_8_5.z SC1/vss sg13_lv_nmos ad=95f pd=0.88u as=0.17p ps=1.68u w=0.5u l=0.13u
M127 SC1/buf_32_1.z nh_sw[0] SC1/vss SC1/vss sg13_lv_nmos ad=95f pd=0.88u as=95f ps=0.88u w=0.5u l=0.13u
M128 SC1/buf_8_3.z nh_sw[3] SC1/vss SC1/vss sg13_lv_nmos ad=0.17p pd=1.68u as=95f ps=0.88u w=0.5u l=0.13u
M129 SC1/buf_32_0.z nl_sw[0] SC1/vss SC1/vss sg13_lv_nmos ad=95f pd=0.88u as=95f ps=0.88u w=0.5u l=0.13u
M130 SC1/buf_4_3.z nl_sw[6] vdd vdd sg13_lv_pmos ad=0.19p pd=1.38u as=0.19p ps=1.38u w=1u l=0.13u
M131 SC1/buf_32_1.z nh_sw[0] vdd vdd sg13_lv_pmos ad=0.19p pd=1.38u as=0.19p ps=1.38u w=1u l=0.13u
M132 SC1/vss nl_sw[7] SC1/buf_4_0.z SC1/vss sg13_lv_nmos ad=95f pd=0.88u as=0.17p ps=1.68u w=0.5u l=0.13u
M133 vdd nh_sw[0] SC1/buf_32_1.z vdd sg13_lv_pmos ad=0.19p pd=1.38u as=0.19p ps=1.38u w=1u l=0.13u
M134 SC1/buf_16_3.z nh_sw[1] SC1/vss SC1/vss sg13_lv_nmos ad=95f pd=0.88u as=95f ps=0.88u w=0.5u l=0.13u
M135 vdd nh_sw[6] SC1/buf_4_1.z vdd sg13_lv_pmos ad=0.19p pd=1.38u as=0.19p ps=1.38u w=1u l=0.13u
M136 SC1/buf_16_0.z nh_sw[2] vdd vdd sg13_lv_pmos ad=0.19p pd=1.38u as=0.19p ps=1.38u w=1u l=0.13u
M137 SC1/vss nh_sw[8] SC1/buf_2_0.z SC1/vss sg13_lv_nmos ad=95f pd=0.88u as=0.17p ps=1.68u w=0.5u l=0.13u
M138 SC1/buf_16_2.z nl_sw[1] SC1/vss SC1/vss sg13_lv_nmos ad=0.17p pd=1.68u as=95f ps=0.88u w=0.5u l=0.13u
M139 SC1/buf_8_3.z nh_sw[3] SC1/vss SC1/vss sg13_lv_nmos ad=95f pd=0.88u as=95f ps=0.88u w=0.5u l=0.13u
M140 vdd nl_sw[2] SC1/buf_16_1.z vdd sg13_lv_pmos ad=0.19p pd=1.38u as=0.19p ps=1.38u w=1u l=0.13u
M141 SC1/buf_8_5.z nh_sw[5] vdd vdd sg13_lv_pmos ad=0.19p pd=1.38u as=0.19p ps=1.38u w=1u l=0.13u
M142 SC1/buf_8_4.z nl_sw[5] SC1/vss SC1/vss sg13_lv_nmos ad=95f pd=0.88u as=95f ps=0.88u w=0.5u l=0.13u
M143 SC1/vss nl_sw[1] SC1/buf_16_2.z SC1/vss sg13_lv_nmos ad=95f pd=0.88u as=95f ps=0.88u w=0.5u l=0.13u
M144 SC1/buf_16_2.z nl_sw[1] vdd vdd sg13_lv_pmos ad=0.19p pd=1.38u as=0.19p ps=1.38u w=1u l=0.13u
M145 SC1/buf_16_1.z nl_sw[2] vdd vdd sg13_lv_pmos ad=0.34p pd=2.68u as=0.19p ps=1.38u w=1u l=0.13u
M146 vdd nl_sw[0] SC1/buf_32_0.z vdd sg13_lv_pmos ad=0.19p pd=1.38u as=0.19p ps=1.38u w=1u l=0.13u
M147 SC1/buf_16_3.z nh_sw[1] vdd vdd sg13_lv_pmos ad=0.19p pd=1.38u as=0.19p ps=1.38u w=1u l=0.13u
M148 SC1/buf_32_1.z nh_sw[0] SC1/vss SC1/vss sg13_lv_nmos ad=95f pd=0.88u as=95f ps=0.88u w=0.5u l=0.13u
M149 SC1/buf_4_0.z nl_sw[7] vdd vdd sg13_lv_pmos ad=0.34p pd=2.68u as=0.19p ps=1.38u w=1u l=0.13u
M150 SC1/buf_8_0.z nl_sw[4] vdd vdd sg13_lv_pmos ad=0.19p pd=1.38u as=0.19p ps=1.38u w=1u l=0.13u
M151 SC1/buf_32_0.z nl_sw[0] vdd vdd sg13_lv_pmos ad=0.19p pd=1.38u as=0.19p ps=1.38u w=1u l=0.13u
M152 SC1/vss nl_sw[2] SC1/buf_16_1.z SC1/vss sg13_lv_nmos ad=95f pd=0.88u as=95f ps=0.88u w=0.5u l=0.13u
M153 SC1/vss nl_sw[0] SC1/buf_32_0.z SC1/vss sg13_lv_nmos ad=95f pd=0.88u as=95f ps=0.88u w=0.5u l=0.13u
M154 SC1/buf_4_2.z nh_sw[7] vdd vdd sg13_lv_pmos ad=0.34p pd=2.68u as=0.19p ps=1.38u w=1u l=0.13u
M155 SC1/buf_16_0.z nh_sw[2] SC1/vss SC1/vss sg13_lv_nmos ad=95f pd=0.88u as=95f ps=0.88u w=0.5u l=0.13u
M156 SC1/buf_16_0.z nh_sw[2] SC1/vss SC1/vss sg13_lv_nmos ad=95f pd=0.88u as=95f ps=0.88u w=0.5u l=0.13u
M157 SC1/vss nh_sw[0] SC1/buf_32_1.z SC1/vss sg13_lv_nmos ad=95f pd=0.88u as=95f ps=0.88u w=0.5u l=0.13u
M158 SC1/vss nl_sw[2] SC1/buf_16_1.z SC1/vss sg13_lv_nmos ad=95f pd=0.88u as=95f ps=0.88u w=0.5u l=0.13u
M159 SC1/buf_2_3.z nh_sw[9] SC1/vss SC1/vss sg13_lv_nmos ad=0.17p pd=1.68u as=95f ps=0.88u w=0.5u l=0.13u
M160 SC1/buf_32_0.z nl_sw[0] vdd vdd sg13_lv_pmos ad=0.19p pd=1.38u as=0.19p ps=1.38u w=1u l=0.13u
M161 vdd nl_sw[0] SC1/buf_32_0.z vdd sg13_lv_pmos ad=0.19p pd=1.38u as=0.19p ps=1.38u w=1u l=0.13u
M162 SC1/vss nl_sw[9] SC1/buf_2_2.z SC1/vss sg13_lv_nmos ad=95f pd=0.88u as=0.17p ps=1.68u w=0.5u l=0.13u
M163 SC1/buf_32_1.z nh_sw[0] vdd vdd sg13_lv_pmos ad=0.19p pd=1.38u as=0.19p ps=1.38u w=1u l=0.13u
M164 SC1/buf_32_0.z nl_sw[0] SC1/vss SC1/vss sg13_lv_nmos ad=95f pd=0.88u as=95f ps=0.88u w=0.5u l=0.13u
M165 SC1/vss nh_sw[4] SC1/buf_8_2.z SC1/vss sg13_lv_nmos ad=95f pd=0.88u as=95f ps=0.88u w=0.5u l=0.13u
M166 SC1/buf_32_1.z nh_sw[0] SC1/vss SC1/vss sg13_lv_nmos ad=95f pd=0.88u as=95f ps=0.88u w=0.5u l=0.13u
M167 vdd nh_sw[2] SC1/buf_16_0.z vdd sg13_lv_pmos ad=0.19p pd=1.38u as=0.19p ps=1.38u w=1u l=0.13u
M168 vdd nh_sw[1] SC1/buf_16_3.z vdd sg13_lv_pmos ad=0.19p pd=1.38u as=0.19p ps=1.38u w=1u l=0.13u
M169 SC1/buf_16_3.z nh_sw[1] SC1/vss SC1/vss sg13_lv_nmos ad=0.17p pd=1.68u as=95f ps=0.88u w=0.5u l=0.13u
M170 SC1/vss nl_sw[4] SC1/buf_8_0.z SC1/vss sg13_lv_nmos ad=95f pd=0.88u as=95f ps=0.88u w=0.5u l=0.13u
M171 vdd nh_sw[0] SC1/buf_32_1.z vdd sg13_lv_pmos ad=0.19p pd=1.38u as=0.19p ps=1.38u w=1u l=0.13u
M172 SC1/vss nl_sw[0] SC1/buf_32_0.z SC1/vss sg13_lv_nmos ad=95f pd=0.88u as=95f ps=0.88u w=0.5u l=0.13u
M173 vdd nl_sw[8] SC1/buf_2_1.z vdd sg13_lv_pmos ad=0.19p pd=1.38u as=0.34p ps=2.68u w=1u l=0.13u
M174 SC1/buf_16_0.z nh_sw[2] SC1/vss SC1/vss sg13_lv_nmos ad=95f pd=0.88u as=95f ps=0.88u w=0.5u l=0.13u
M175 SC1/vss nh_sw[0] SC1/buf_32_1.z SC1/vss sg13_lv_nmos ad=95f pd=0.88u as=95f ps=0.88u w=0.5u l=0.13u
M176 SC1/vss nl_sw[3] SC1/buf_8_1.z SC1/vss sg13_lv_nmos ad=95f pd=0.88u as=0.17p ps=1.68u w=0.5u l=0.13u
M177 SC1/buf_4_3.z nl_sw[6] SC1/vss SC1/vss sg13_lv_nmos ad=0.17p pd=1.68u as=95f ps=0.88u w=0.5u l=0.13u
M178 SC1/buf_8_1.z nl_sw[3] vdd vdd sg13_lv_pmos ad=0.19p pd=1.38u as=0.19p ps=1.38u w=1u l=0.13u
M179 SC1/vss nl_sw[1] SC1/buf_16_2.z SC1/vss sg13_lv_nmos ad=95f pd=0.88u as=0.17p ps=1.68u w=0.5u l=0.13u
M180 SC1/buf_32_1.z nh_sw[0] vdd vdd sg13_lv_pmos ad=0.19p pd=1.38u as=0.19p ps=1.38u w=1u l=0.13u
M181 SC1/vss nh_sw[1] SC1/buf_16_3.z SC1/vss sg13_lv_nmos ad=95f pd=0.88u as=95f ps=0.88u w=0.5u l=0.13u
M182 SC1/buf_32_0.z nl_sw[0] SC1/vss SC1/vss sg13_lv_nmos ad=95f pd=0.88u as=95f ps=0.88u w=0.5u l=0.13u
M183 SC1/vss nh_sw[4] SC1/buf_8_2.z SC1/vss sg13_lv_nmos ad=95f pd=0.88u as=95f ps=0.88u w=0.5u l=0.13u
M184 SC1/buf_32_1.z nh_sw[0] SC1/vss SC1/vss sg13_lv_nmos ad=95f pd=0.88u as=95f ps=0.88u w=0.5u l=0.13u
M185 SC1/buf_32_1.z nh_sw[0] vdd vdd sg13_lv_pmos ad=0.19p pd=1.38u as=0.19p ps=1.38u w=1u l=0.13u
M186 vdd nh_sw[2] SC1/buf_16_0.z vdd sg13_lv_pmos ad=0.19p pd=1.38u as=0.19p ps=1.38u w=1u l=0.13u
M187 SC1/vss nl_sw[1] SC1/buf_16_2.z SC1/vss sg13_lv_nmos ad=95f pd=0.88u as=95f ps=0.88u w=0.5u l=0.13u
M188 SC1/buf_16_2.z nl_sw[1] SC1/vss SC1/vss sg13_lv_nmos ad=95f pd=0.88u as=95f ps=0.88u w=0.5u l=0.13u
M189 SC1/vss nh_sw[3] SC1/buf_8_3.z SC1/vss sg13_lv_nmos ad=95f pd=0.88u as=95f ps=0.88u w=0.5u l=0.13u
M190 SC1/vss nl_sw[0] SC1/buf_32_0.z SC1/vss sg13_lv_nmos ad=95f pd=0.88u as=95f ps=0.88u w=0.5u l=0.13u
M191 vdd nl_sw[1] SC1/buf_16_2.z vdd sg13_lv_pmos ad=0.19p pd=1.38u as=0.19p ps=1.38u w=1u l=0.13u
M192 SC1/buf_8_3.z nh_sw[3] vdd vdd sg13_lv_pmos ad=0.19p pd=1.38u as=0.19p ps=1.38u w=1u l=0.13u
M193 vdd nl_sw[2] SC1/buf_16_1.z vdd sg13_lv_pmos ad=0.19p pd=1.38u as=0.19p ps=1.38u w=1u l=0.13u
M194 SC1/buf_32_0.z nl_sw[0] vdd vdd sg13_lv_pmos ad=0.19p pd=1.38u as=0.19p ps=1.38u w=1u l=0.13u
M195 SC1/buf_8_2.z nh_sw[4] vdd vdd sg13_lv_pmos ad=0.34p pd=2.68u as=0.19p ps=1.38u w=1u l=0.13u
M196 SC1/buf_4_2.z nh_sw[7] SC1/vss SC1/vss sg13_lv_nmos ad=95f pd=0.88u as=95f ps=0.88u w=0.5u l=0.13u
M197 SC1/vss nl_sw[2] SC1/buf_16_1.z SC1/vss sg13_lv_nmos ad=95f pd=0.88u as=0.17p ps=1.68u w=0.5u l=0.13u
M198 vdd nh_sw[1] SC1/buf_16_3.z vdd sg13_lv_pmos ad=0.19p pd=1.38u as=0.19p ps=1.38u w=1u l=0.13u
M199 vdd nl_sw[9] SC1/buf_2_2.z vdd sg13_lv_pmos ad=0.19p pd=1.38u as=0.34p ps=2.68u w=1u l=0.13u
M200 SC1/buf_4_1.z nh_sw[6] SC1/vss SC1/vss sg13_lv_nmos ad=0.17p pd=1.68u as=95f ps=0.88u w=0.5u l=0.13u
M201 SC1/buf_32_1.z nh_sw[0] vdd vdd sg13_lv_pmos ad=0.19p pd=1.38u as=0.19p ps=1.38u w=1u l=0.13u
M202 vdd nl_sw[7] SC1/buf_4_0.z vdd sg13_lv_pmos ad=0.19p pd=1.38u as=0.34p ps=2.68u w=1u l=0.13u
M203 SC1/buf_32_0.z nl_sw[0] SC1/vss SC1/vss sg13_lv_nmos ad=95f pd=0.88u as=95f ps=0.88u w=0.5u l=0.13u
M204 SC1/vss nh_sw[5] SC1/buf_8_5.z SC1/vss sg13_lv_nmos ad=95f pd=0.88u as=95f ps=0.88u w=0.5u l=0.13u
M205 vdd nl_sw[0] SC1/buf_32_0.z vdd sg13_lv_pmos ad=0.19p pd=1.38u as=0.19p ps=1.38u w=1u l=0.13u
M206 SC1/buf_16_1.z nl_sw[2] SC1/vss SC1/vss sg13_lv_nmos ad=95f pd=0.88u as=95f ps=0.88u w=0.5u l=0.13u
M207 SC1/vss nh_sw[3] SC1/buf_8_3.z SC1/vss sg13_lv_nmos ad=95f pd=0.88u as=0.17p ps=1.68u w=0.5u l=0.13u
M208 SC1/buf_16_1.z nl_sw[2] vdd vdd sg13_lv_pmos ad=0.19p pd=1.38u as=0.19p ps=1.38u w=1u l=0.13u
M209 SC1/buf_16_2.z nl_sw[1] vdd vdd sg13_lv_pmos ad=0.19p pd=1.38u as=0.19p ps=1.38u w=1u l=0.13u
M210 SC1/vss nl_sw[5] SC1/buf_8_4.z SC1/vss sg13_lv_nmos ad=95f pd=0.88u as=95f ps=0.88u w=0.5u l=0.13u
M211 SC1/buf_8_0.z nl_sw[4] SC1/vss SC1/vss sg13_lv_nmos ad=0.17p pd=1.68u as=95f ps=0.88u w=0.5u l=0.13u
M212 SC1/buf_8_1.z nl_sw[3] SC1/vss SC1/vss sg13_lv_nmos ad=95f pd=0.88u as=95f ps=0.88u w=0.5u l=0.13u
M213 SC1/buf_32_0.z nl_sw[0] vdd vdd sg13_lv_pmos ad=0.19p pd=1.38u as=0.19p ps=1.38u w=1u l=0.13u
M214 SC1/buf_8_2.z nh_sw[4] vdd vdd sg13_lv_pmos ad=0.19p pd=1.38u as=0.19p ps=1.38u w=1u l=0.13u
M215 vdd nh_sw[0] SC1/buf_32_1.z vdd sg13_lv_pmos ad=0.19p pd=1.38u as=0.19p ps=1.38u w=1u l=0.13u
M216 SC1/buf_8_4.z nl_sw[5] vdd vdd sg13_lv_pmos ad=0.19p pd=1.38u as=0.19p ps=1.38u w=1u l=0.13u
M217 vdd nh_sw[10] SC1/buf_1_1.z vdd sg13_lv_pmos ad=0.34p pd=2.68u as=0.34p ps=2.68u w=1u l=0.13u
M218 SC1/buf_16_0.z nh_sw[2] vdd vdd sg13_lv_pmos ad=0.19p pd=1.38u as=0.19p ps=1.38u w=1u l=0.13u
M219 SC1/vss nh_sw[5] SC1/buf_8_5.z SC1/vss sg13_lv_nmos ad=95f pd=0.88u as=95f ps=0.88u w=0.5u l=0.13u
M220 vdd nl_sw[0] SC1/buf_32_0.z vdd sg13_lv_pmos ad=0.19p pd=1.38u as=0.19p ps=1.38u w=1u l=0.13u
M221 SC1/vss nh_sw[1] SC1/buf_16_3.z SC1/vss sg13_lv_nmos ad=95f pd=0.88u as=95f ps=0.88u w=0.5u l=0.13u
M222 SC1/vss nh_sw[2] SC1/buf_16_0.z SC1/vss sg13_lv_nmos ad=95f pd=0.88u as=95f ps=0.88u w=0.5u l=0.13u
M223 SC1/buf_32_1.z nh_sw[0] SC1/vss SC1/vss sg13_lv_nmos ad=95f pd=0.88u as=95f ps=0.88u w=0.5u l=0.13u
M224 SC1/vss nl_sw[8] SC1/buf_2_1.z SC1/vss sg13_lv_nmos ad=95f pd=0.88u as=0.17p ps=1.68u w=0.5u l=0.13u
M225 SC1/buf_32_0.z nl_sw[0] vdd vdd sg13_lv_pmos ad=0.19p pd=1.38u as=0.19p ps=1.38u w=1u l=0.13u
M226 SC1/vss nl_sw[6] SC1/buf_4_3.z SC1/vss sg13_lv_nmos ad=95f pd=0.88u as=0.17p ps=1.68u w=0.5u l=0.13u
M227 vdd nl_sw[3] SC1/buf_8_1.z vdd sg13_lv_pmos ad=0.19p pd=1.38u as=0.19p ps=1.38u w=1u l=0.13u
M228 vdd nh_sw[0] SC1/buf_32_1.z vdd sg13_lv_pmos ad=0.19p pd=1.38u as=0.34p ps=2.68u w=1u l=0.13u
M229 vdd nh_sw[7] SC1/buf_4_2.z vdd sg13_lv_pmos ad=0.19p pd=1.38u as=0.34p ps=2.68u w=1u l=0.13u
M230 SC1/vss nl_sw[0] SC1/buf_32_0.z SC1/vss sg13_lv_nmos ad=95f pd=0.88u as=95f ps=0.88u w=0.5u l=0.13u
M231 SC1/vss nh_sw[0] SC1/buf_32_1.z SC1/vss sg13_lv_nmos ad=95f pd=0.88u as=95f ps=0.88u w=0.5u l=0.13u
M232 SC1/buf_8_2.z nh_sw[4] SC1/vss SC1/vss sg13_lv_nmos ad=95f pd=0.88u as=95f ps=0.88u w=0.5u l=0.13u
M233 SC1/buf_32_1.z nh_sw[0] SC1/vss SC1/vss sg13_lv_nmos ad=95f pd=0.88u as=95f ps=0.88u w=0.5u l=0.13u
M234 SC1/buf_4_3.z nl_sw[6] vdd vdd sg13_lv_pmos ad=0.34p pd=2.68u as=0.19p ps=1.38u w=1u l=0.13u
M235 SC1/vss nl_sw[1] SC1/buf_16_2.z SC1/vss sg13_lv_nmos ad=95f pd=0.88u as=95f ps=0.88u w=0.5u l=0.13u
M236 SC1/buf_32_1.z nh_sw[0] vdd vdd sg13_lv_pmos ad=0.19p pd=1.38u as=0.19p ps=1.38u w=1u l=0.13u
M237 SC1/buf_16_2.z nl_sw[1] vdd vdd sg13_lv_pmos ad=0.19p pd=1.38u as=0.19p ps=1.38u w=1u l=0.13u
M238 SC1/buf_32_0.z nl_sw[0] SC1/vss SC1/vss sg13_lv_nmos ad=95f pd=0.88u as=95f ps=0.88u w=0.5u l=0.13u
M239 SC1/vss nl_sw[7] SC1/buf_4_0.z SC1/vss sg13_lv_nmos ad=95f pd=0.88u as=95f ps=0.88u w=0.5u l=0.13u
M240 SC1/buf_8_4.z nl_sw[5] vdd vdd sg13_lv_pmos ad=0.19p pd=1.38u as=0.19p ps=1.38u w=1u l=0.13u
M241 SC1/buf_16_3.z nh_sw[1] vdd vdd sg13_lv_pmos ad=0.19p pd=1.38u as=0.19p ps=1.38u w=1u l=0.13u
M242 vdd nh_sw[0] SC1/buf_32_1.z vdd sg13_lv_pmos ad=0.19p pd=1.38u as=0.19p ps=1.38u w=1u l=0.13u
M243 SC1/buf_16_3.z nh_sw[1] SC1/vss SC1/vss sg13_lv_nmos ad=95f pd=0.88u as=95f ps=0.88u w=0.5u l=0.13u
M244 vdd nl_sw[4] SC1/buf_8_0.z vdd sg13_lv_pmos ad=0.19p pd=1.38u as=0.34p ps=2.68u w=1u l=0.13u
M245 SC1/buf_16_0.z nh_sw[2] vdd vdd sg13_lv_pmos ad=0.19p pd=1.38u as=0.19p ps=1.38u w=1u l=0.13u
M246 SC1/vss nl_sw[2] SC1/buf_16_1.z SC1/vss sg13_lv_nmos ad=95f pd=0.88u as=95f ps=0.88u w=0.5u l=0.13u
M247 SC1/buf_8_5.z nh_sw[5] vdd vdd sg13_lv_pmos ad=0.19p pd=1.38u as=0.19p ps=1.38u w=1u l=0.13u
M248 SC1/buf_8_4.z nl_sw[5] SC1/vss SC1/vss sg13_lv_nmos ad=0.17p pd=1.68u as=95f ps=0.88u w=0.5u l=0.13u
M249 vdd nl_sw[2] SC1/buf_16_1.z vdd sg13_lv_pmos ad=0.19p pd=1.38u as=0.19p ps=1.38u w=1u l=0.13u
M250 SC1/vss nl_sw[1] SC1/buf_16_2.z SC1/vss sg13_lv_nmos ad=95f pd=0.88u as=95f ps=0.88u w=0.5u l=0.13u
M251 SC1/vss nl_sw[4] SC1/buf_8_0.z SC1/vss sg13_lv_nmos ad=95f pd=0.88u as=95f ps=0.88u w=0.5u l=0.13u
M252 SC1/buf_16_2.z nl_sw[1] vdd vdd sg13_lv_pmos ad=0.19p pd=1.38u as=0.19p ps=1.38u w=1u l=0.13u
M253 vdd nh_sw[4] SC1/buf_8_2.z vdd sg13_lv_pmos ad=0.19p pd=1.38u as=0.19p ps=1.38u w=1u l=0.13u
M254 SC1/buf_16_3.z nh_sw[1] vdd vdd sg13_lv_pmos ad=0.19p pd=1.38u as=0.19p ps=1.38u w=1u l=0.13u
M255 SC1/vss nh_sw[2] SC1/buf_16_0.z SC1/vss sg13_lv_nmos ad=95f pd=0.88u as=0.17p ps=1.68u w=0.5u l=0.13u
M256 SC1/buf_32_1.z nh_sw[0] SC1/vss SC1/vss sg13_lv_nmos ad=95f pd=0.88u as=95f ps=0.88u w=0.5u l=0.13u
M257 SC1/buf_8_0.z nl_sw[4] vdd vdd sg13_lv_pmos ad=0.34p pd=2.68u as=0.19p ps=1.38u w=1u l=0.13u
M258 SC1/buf_8_5.z nh_sw[5] SC1/vss SC1/vss sg13_lv_nmos ad=95f pd=0.88u as=95f ps=0.88u w=0.5u l=0.13u
M259 SC1/buf_32_0.z nl_sw[0] vdd vdd sg13_lv_pmos ad=0.19p pd=1.38u as=0.19p ps=1.38u w=1u l=0.13u
M260 SC1/vss nl_sw[2] SC1/buf_16_1.z SC1/vss sg13_lv_nmos ad=95f pd=0.88u as=95f ps=0.88u w=0.5u l=0.13u
M261 SC1/vss nl_sw[0] SC1/buf_32_0.z SC1/vss sg13_lv_nmos ad=95f pd=0.88u as=95f ps=0.88u w=0.5u l=0.13u
M262 SC1/buf_16_0.z nh_sw[2] SC1/vss SC1/vss sg13_lv_nmos ad=95f pd=0.88u as=95f ps=0.88u w=0.5u l=0.13u
M263 SC1/buf_16_0.z nh_sw[2] SC1/vss SC1/vss sg13_lv_nmos ad=95f pd=0.88u as=95f ps=0.88u w=0.5u l=0.13u
M264 SC1/vss nh_sw[0] SC1/buf_32_1.z SC1/vss sg13_lv_nmos ad=95f pd=0.88u as=95f ps=0.88u w=0.5u l=0.13u
M265 vdd nl_sw[10] SC1/buf_1_0.z vdd sg13_lv_pmos ad=0.34p pd=2.68u as=0.34p ps=2.68u w=1u l=0.13u
M266 SC1/vss nh_sw[6] SC1/buf_4_1.z SC1/vss sg13_lv_nmos ad=95f pd=0.88u as=0.17p ps=1.68u w=0.5u l=0.13u
M267 SC1/vss nl_sw[2] SC1/buf_16_1.z SC1/vss sg13_lv_nmos ad=95f pd=0.88u as=95f ps=0.88u w=0.5u l=0.13u
M268 SC1/buf_32_0.z nl_sw[0] vdd vdd sg13_lv_pmos ad=0.19p pd=1.38u as=0.19p ps=1.38u w=1u l=0.13u
M269 vdd nl_sw[0] SC1/buf_32_0.z vdd sg13_lv_pmos ad=0.19p pd=1.38u as=0.19p ps=1.38u w=1u l=0.13u
M270 vdd nh_sw[4] SC1/buf_8_2.z vdd sg13_lv_pmos ad=0.19p pd=1.38u as=0.34p ps=2.68u w=1u l=0.13u
M271 SC1/buf_8_1.z nl_sw[3] vdd vdd sg13_lv_pmos ad=0.19p pd=1.38u as=0.19p ps=1.38u w=1u l=0.13u
M272 SC1/buf_32_0.z nl_sw[0] SC1/vss SC1/vss sg13_lv_nmos ad=95f pd=0.88u as=95f ps=0.88u w=0.5u l=0.13u
M273 SC1/buf_32_1.z nh_sw[0] SC1/vss SC1/vss sg13_lv_nmos ad=95f pd=0.88u as=95f ps=0.88u w=0.5u l=0.13u
M274 SC1/buf_4_2.z nh_sw[7] SC1/vss SC1/vss sg13_lv_nmos ad=0.17p pd=1.68u as=95f ps=0.88u w=0.5u l=0.13u
M275 vdd nh_sw[1] SC1/buf_16_3.z vdd sg13_lv_pmos ad=0.19p pd=1.38u as=0.19p ps=1.38u w=1u l=0.13u
M276 vdd nh_sw[0] SC1/buf_32_1.z vdd sg13_lv_pmos ad=0.19p pd=1.38u as=0.19p ps=1.38u w=1u l=0.13u
M277 SC1/vss nh_sw[3] SC1/buf_8_3.z SC1/vss sg13_lv_nmos ad=95f pd=0.88u as=95f ps=0.88u w=0.5u l=0.13u
M278 vdd nl_sw[6] SC1/buf_4_3.z vdd sg13_lv_pmos ad=0.19p pd=1.38u as=0.34p ps=2.68u w=1u l=0.13u
M279 SC1/vss nl_sw[0] SC1/buf_32_0.z SC1/vss sg13_lv_nmos ad=95f pd=0.88u as=95f ps=0.88u w=0.5u l=0.13u
M280 SC1/buf_8_3.z nh_sw[3] vdd vdd sg13_lv_pmos ad=0.34p pd=2.68u as=0.19p ps=1.38u w=1u l=0.13u
M281 SC1/vss nl_sw[3] SC1/buf_8_1.z SC1/vss sg13_lv_nmos ad=95f pd=0.88u as=95f ps=0.88u w=0.5u l=0.13u
M282 SC1/buf_32_1.z nh_sw[0] vdd vdd sg13_lv_pmos ad=0.19p pd=1.38u as=0.19p ps=1.38u w=1u l=0.13u
M283 SC1/vss nh_sw[1] SC1/buf_16_3.z SC1/vss sg13_lv_nmos ad=95f pd=0.88u as=95f ps=0.88u w=0.5u l=0.13u
M284 SC1/buf_32_1.z nh_sw[0] SC1/vss SC1/vss sg13_lv_nmos ad=95f pd=0.88u as=95f ps=0.88u w=0.5u l=0.13u
M285 SC1/buf_32_1.z nh_sw[0] vdd vdd sg13_lv_pmos ad=0.34p pd=2.68u as=0.19p ps=1.38u w=1u l=0.13u
M286 vdd nh_sw[2] SC1/buf_16_0.z vdd sg13_lv_pmos ad=0.19p pd=1.38u as=0.19p ps=1.38u w=1u l=0.13u
M287 SC1/buf_4_1.z nh_sw[6] vdd vdd sg13_lv_pmos ad=0.19p pd=1.38u as=0.19p ps=1.38u w=1u l=0.13u
M288 SC1/vss nl_sw[1] SC1/buf_16_2.z SC1/vss sg13_lv_nmos ad=95f pd=0.88u as=95f ps=0.88u w=0.5u l=0.13u
M289 SC1/vss nh_sw[3] SC1/buf_8_3.z SC1/vss sg13_lv_nmos ad=95f pd=0.88u as=95f ps=0.88u w=0.5u l=0.13u
M290 SC1/buf_16_1.z nl_sw[2] vdd vdd sg13_lv_pmos ad=0.19p pd=1.38u as=0.19p ps=1.38u w=1u l=0.13u
M291 SC1/buf_16_2.z nl_sw[1] SC1/vss SC1/vss sg13_lv_nmos ad=95f pd=0.88u as=95f ps=0.88u w=0.5u l=0.13u
M292 SC1/buf_8_3.z nh_sw[3] vdd vdd sg13_lv_pmos ad=0.19p pd=1.38u as=0.19p ps=1.38u w=1u l=0.13u
M293 SC1/vss nl_sw[5] SC1/buf_8_4.z SC1/vss sg13_lv_nmos ad=95f pd=0.88u as=95f ps=0.88u w=0.5u l=0.13u
M294 vdd nl_sw[1] SC1/buf_16_2.z vdd sg13_lv_pmos ad=0.19p pd=1.38u as=0.19p ps=1.38u w=1u l=0.13u
M295 vdd nl_sw[2] SC1/buf_16_1.z vdd sg13_lv_pmos ad=0.19p pd=1.38u as=0.19p ps=1.38u w=1u l=0.13u
M296 SC1/buf_32_0.z nl_sw[0] vdd vdd sg13_lv_pmos ad=0.19p pd=1.38u as=0.19p ps=1.38u w=1u l=0.13u
M297 vdd nh_sw[1] SC1/buf_16_3.z vdd sg13_lv_pmos ad=0.19p pd=1.38u as=0.19p ps=1.38u w=1u l=0.13u
M298 SC1/vss nh_sw[0] SC1/buf_32_1.z SC1/vss sg13_lv_nmos ad=95f pd=0.88u as=95f ps=0.88u w=0.5u l=0.13u
M299 vdd nl_sw[7] SC1/buf_4_0.z vdd sg13_lv_pmos ad=0.19p pd=1.38u as=0.19p ps=1.38u w=1u l=0.13u
M300 SC1/buf_32_0.z nl_sw[0] SC1/vss SC1/vss sg13_lv_nmos ad=0.17p pd=1.68u as=95f ps=0.88u w=0.5u l=0.13u
M301 SC1/buf_2_0.z nh_sw[8] vdd vdd sg13_lv_pmos ad=0.34p pd=2.68u as=0.19p ps=1.38u w=1u l=0.13u
M302 vdd nl_sw[4] SC1/buf_8_0.z vdd sg13_lv_pmos ad=0.19p pd=1.38u as=0.19p ps=1.38u w=1u l=0.13u
M303 vdd nl_sw[0] SC1/buf_32_0.z vdd sg13_lv_pmos ad=0.19p pd=1.38u as=0.19p ps=1.38u w=1u l=0.13u
M304 SC1/vss nh_sw[10] SC1/buf_1_1.z SC1/vss sg13_lv_nmos ad=0.17p pd=1.68u as=0.17p ps=1.68u w=0.5u l=0.13u
M305 SC1/buf_16_1.z nl_sw[2] SC1/vss SC1/vss sg13_lv_nmos ad=95f pd=0.88u as=95f ps=0.88u w=0.5u l=0.13u
M306 SC1/buf_32_0.z nl_sw[0] SC1/vss SC1/vss sg13_lv_nmos ad=95f pd=0.88u as=95f ps=0.88u w=0.5u l=0.13u
M307 SC1/vss nh_sw[2] SC1/buf_16_0.z SC1/vss sg13_lv_nmos ad=95f pd=0.88u as=95f ps=0.88u w=0.5u l=0.13u
M308 SC1/buf_16_1.z nl_sw[2] vdd vdd sg13_lv_pmos ad=0.19p pd=1.38u as=0.19p ps=1.38u w=1u l=0.13u
M309 SC1/buf_16_2.z nl_sw[1] vdd vdd sg13_lv_pmos ad=0.34p pd=2.68u as=0.19p ps=1.38u w=1u l=0.13u
M310 SC1/buf_16_1.z nl_sw[2] SC1/vss SC1/vss sg13_lv_nmos ad=95f pd=0.88u as=95f ps=0.88u w=0.5u l=0.13u
M311 SC1/vss nh_sw[9] SC1/buf_2_3.z SC1/vss sg13_lv_nmos ad=95f pd=0.88u as=0.17p ps=1.68u w=0.5u l=0.13u
M312 SC1/buf_8_1.z nl_sw[3] SC1/vss SC1/vss sg13_lv_nmos ad=0.17p pd=1.68u as=95f ps=0.88u w=0.5u l=0.13u
M313 SC1/vss nl_sw[10] SC1/buf_1_0.z SC1/vss sg13_lv_nmos ad=0.17p pd=1.68u as=0.17p ps=1.68u w=0.5u l=0.13u
M314 SC1/buf_32_0.z nl_sw[0] vdd vdd sg13_lv_pmos ad=0.19p pd=1.38u as=0.19p ps=1.38u w=1u l=0.13u
M315 vdd nh_sw[0] SC1/buf_32_1.z vdd sg13_lv_pmos ad=0.19p pd=1.38u as=0.19p ps=1.38u w=1u l=0.13u
M316 SC1/buf_8_4.z nl_sw[5] vdd vdd sg13_lv_pmos ad=0.34p pd=2.68u as=0.19p ps=1.38u w=1u l=0.13u
M317 SC1/vss nl_sw[0] SC1/buf_32_0.z SC1/vss sg13_lv_nmos ad=95f pd=0.88u as=95f ps=0.88u w=0.5u l=0.13u
M318 SC1/vss nh_sw[0] SC1/buf_32_1.z SC1/vss sg13_lv_nmos ad=95f pd=0.88u as=0.17p ps=1.68u w=0.5u l=0.13u
M319 SC1/buf_16_0.z nh_sw[2] vdd vdd sg13_lv_pmos ad=0.19p pd=1.38u as=0.19p ps=1.38u w=1u l=0.13u
M320 SC1/buf_16_3.z nh_sw[1] vdd vdd sg13_lv_pmos ad=0.19p pd=1.38u as=0.19p ps=1.38u w=1u l=0.13u
M321 SC1/vss nh_sw[1] SC1/buf_16_3.z SC1/vss sg13_lv_nmos ad=95f pd=0.88u as=95f ps=0.88u w=0.5u l=0.13u
M322 SC1/buf_32_1.z nh_sw[0] vdd vdd sg13_lv_pmos ad=0.19p pd=1.38u as=0.19p ps=1.38u w=1u l=0.13u
M323 SC1/buf_8_0.z nl_sw[4] SC1/vss SC1/vss sg13_lv_nmos ad=95f pd=0.88u as=95f ps=0.88u w=0.5u l=0.13u
M324 SC1/buf_32_0.z nl_sw[0] SC1/vss SC1/vss sg13_lv_nmos ad=95f pd=0.88u as=95f ps=0.88u w=0.5u l=0.13u
M325 SC1/vss nh_sw[2] SC1/buf_16_0.z SC1/vss sg13_lv_nmos ad=95f pd=0.88u as=95f ps=0.88u w=0.5u l=0.13u
M326 SC1/buf_32_1.z nh_sw[0] SC1/vss SC1/vss sg13_lv_nmos ad=95f pd=0.88u as=95f ps=0.88u w=0.5u l=0.13u
M327 SC1/vss nl_sw[6] SC1/buf_4_3.z SC1/vss sg13_lv_nmos ad=95f pd=0.88u as=95f ps=0.88u w=0.5u l=0.13u
M328 SC1/buf_32_0.z nl_sw[0] vdd vdd sg13_lv_pmos ad=0.19p pd=1.38u as=0.19p ps=1.38u w=1u l=0.13u
M329 vdd nl_sw[3] SC1/buf_8_1.z vdd sg13_lv_pmos ad=0.19p pd=1.38u as=0.34p ps=2.68u w=1u l=0.13u
M330 vdd nh_sw[0] SC1/buf_32_1.z vdd sg13_lv_pmos ad=0.19p pd=1.38u as=0.19p ps=1.38u w=1u l=0.13u
M331 vdd nl_sw[1] SC1/buf_16_2.z vdd sg13_lv_pmos ad=0.19p pd=1.38u as=0.34p ps=2.68u w=1u l=0.13u
M332 vdd nh_sw[7] SC1/buf_4_2.z vdd sg13_lv_pmos ad=0.19p pd=1.38u as=0.19p ps=1.38u w=1u l=0.13u
M333 SC1/buf_16_3.z nh_sw[1] SC1/vss SC1/vss sg13_lv_nmos ad=95f pd=0.88u as=95f ps=0.88u w=0.5u l=0.13u
M334 SC1/vss nl_sw[0] SC1/buf_32_0.z SC1/vss sg13_lv_nmos ad=95f pd=0.88u as=95f ps=0.88u w=0.5u l=0.13u
M335 SC1/buf_8_2.z nh_sw[4] SC1/vss SC1/vss sg13_lv_nmos ad=95f pd=0.88u as=95f ps=0.88u w=0.5u l=0.13u
M336 SC1/vss nh_sw[0] SC1/buf_32_1.z SC1/vss sg13_lv_nmos ad=95f pd=0.88u as=95f ps=0.88u w=0.5u l=0.13u
M337 vdd nh_sw[0] SC1/buf_32_1.z vdd sg13_lv_pmos ad=0.19p pd=1.38u as=0.19p ps=1.38u w=1u l=0.13u
M338 SC1/buf_16_0.z nh_sw[2] vdd vdd sg13_lv_pmos ad=0.19p pd=1.38u as=0.19p ps=1.38u w=1u l=0.13u
M339 SC1/buf_32_1.z nh_sw[0] SC1/vss SC1/vss sg13_lv_nmos ad=0.17p pd=1.68u as=95f ps=0.88u w=0.5u l=0.13u
M340 vdd nh_sw[1] SC1/buf_16_3.z vdd sg13_lv_pmos ad=0.19p pd=1.38u as=0.34p ps=2.68u w=1u l=0.13u
M341 SC1/buf_16_2.z nl_sw[1] SC1/vss SC1/vss sg13_lv_nmos ad=95f pd=0.88u as=95f ps=0.88u w=0.5u l=0.13u
M342 SC1/buf_8_5.z nh_sw[5] vdd vdd sg13_lv_pmos ad=0.34p pd=2.68u as=0.19p ps=1.38u w=1u l=0.13u
M343 SC1/vss nl_sw[1] SC1/buf_16_2.z SC1/vss sg13_lv_nmos ad=95f pd=0.88u as=95f ps=0.88u w=0.5u l=0.13u
M344 SC1/buf_32_1.z nh_sw[0] vdd vdd sg13_lv_pmos ad=0.19p pd=1.38u as=0.19p ps=1.38u w=1u l=0.13u
M345 SC1/buf_8_3.z nh_sw[3] SC1/vss SC1/vss sg13_lv_nmos ad=95f pd=0.88u as=95f ps=0.88u w=0.5u l=0.13u
M346 SC1/buf_32_0.z nl_sw[0] SC1/vss SC1/vss sg13_lv_nmos ad=95f pd=0.88u as=95f ps=0.88u w=0.5u l=0.13u
M347 vdd nh_sw[3] SC1/buf_8_3.z vdd sg13_lv_pmos ad=0.19p pd=1.38u as=0.19p ps=1.38u w=1u l=0.13u
M348 SC1/buf_16_2.z nl_sw[1] vdd vdd sg13_lv_pmos ad=0.19p pd=1.38u as=0.19p ps=1.38u w=1u l=0.13u
M349 SC1/buf_16_1.z nl_sw[2] vdd vdd sg13_lv_pmos ad=0.19p pd=1.38u as=0.19p ps=1.38u w=1u l=0.13u
M350 vdd nl_sw[0] SC1/buf_32_0.z vdd sg13_lv_pmos ad=0.19p pd=1.38u as=0.19p ps=1.38u w=1u l=0.13u
M351 vdd nh_sw[4] SC1/buf_8_2.z vdd sg13_lv_pmos ad=0.19p pd=1.38u as=0.19p ps=1.38u w=1u l=0.13u
M352 SC1/vss nh_sw[7] SC1/buf_4_2.z SC1/vss sg13_lv_nmos ad=95f pd=0.88u as=0.17p ps=1.68u w=0.5u l=0.13u
M353 SC1/buf_16_3.z nh_sw[1] vdd vdd sg13_lv_pmos ad=0.19p pd=1.38u as=0.19p ps=1.38u w=1u l=0.13u
M354 vdd nh_sw[0] SC1/buf_32_1.z vdd sg13_lv_pmos ad=0.19p pd=1.38u as=0.19p ps=1.38u w=1u l=0.13u
M355 SC1/buf_16_3.z nh_sw[1] SC1/vss SC1/vss sg13_lv_nmos ad=95f pd=0.88u as=95f ps=0.88u w=0.5u l=0.13u
M356 vdd nl_sw[4] SC1/buf_8_0.z vdd sg13_lv_pmos ad=0.19p pd=1.38u as=0.19p ps=1.38u w=1u l=0.13u
M357 SC1/vss nl_sw[0] SC1/buf_32_0.z SC1/vss sg13_lv_nmos ad=95f pd=0.88u as=95f ps=0.88u w=0.5u l=0.13u
M358 SC1/buf_16_0.z nh_sw[2] vdd vdd sg13_lv_pmos ad=0.19p pd=1.38u as=0.19p ps=1.38u w=1u l=0.13u
M359 SC1/vss nl_sw[2] SC1/buf_16_1.z SC1/vss sg13_lv_nmos ad=95f pd=0.88u as=95f ps=0.88u w=0.5u l=0.13u
M360 SC1/buf_8_5.z nh_sw[5] vdd vdd sg13_lv_pmos ad=0.19p pd=1.38u as=0.19p ps=1.38u w=1u l=0.13u
M361 SC1/vss nl_sw[4] SC1/buf_8_0.z SC1/vss sg13_lv_nmos ad=95f pd=0.88u as=95f ps=0.88u w=0.5u l=0.13u
M362 vdd nl_sw[2] SC1/buf_16_1.z vdd sg13_lv_pmos ad=0.19p pd=1.38u as=0.19p ps=1.38u w=1u l=0.13u
M363 vdd nl_sw[1] SC1/buf_16_2.z vdd sg13_lv_pmos ad=0.19p pd=1.38u as=0.19p ps=1.38u w=1u l=0.13u
M364 vdd nh_sw[3] SC1/buf_8_3.z vdd sg13_lv_pmos ad=0.19p pd=1.38u as=0.34p ps=2.68u w=1u l=0.13u
M365 SC1/buf_8_4.z nl_sw[5] SC1/vss SC1/vss sg13_lv_nmos ad=95f pd=0.88u as=95f ps=0.88u w=0.5u l=0.13u
M366 SC1/vss nl_sw[3] SC1/buf_8_1.z SC1/vss sg13_lv_nmos ad=95f pd=0.88u as=95f ps=0.88u w=0.5u l=0.13u
M367 vdd nl_sw[0] SC1/buf_32_0.z vdd sg13_lv_pmos ad=0.19p pd=1.38u as=0.34p ps=2.68u w=1u l=0.13u
M368 vdd nh_sw[4] SC1/buf_8_2.z vdd sg13_lv_pmos ad=0.19p pd=1.38u as=0.19p ps=1.38u w=1u l=0.13u
M369 SC1/buf_2_3.z nh_sw[9] vdd vdd sg13_lv_pmos ad=0.34p pd=2.68u as=0.19p ps=1.38u w=1u l=0.13u
M370 vdd nl_sw[5] SC1/buf_8_4.z vdd sg13_lv_pmos ad=0.19p pd=1.38u as=0.19p ps=1.38u w=1u l=0.13u
M371 SC1/buf_8_5.z nh_sw[5] SC1/vss SC1/vss sg13_lv_nmos ad=95f pd=0.88u as=95f ps=0.88u w=0.5u l=0.13u
M372 SC1/buf_32_0.z nl_sw[0] vdd vdd sg13_lv_pmos ad=0.19p pd=1.38u as=0.19p ps=1.38u w=1u l=0.13u
M373 SC1/buf_16_3.z nh_sw[1] SC1/vss SC1/vss sg13_lv_nmos ad=95f pd=0.88u as=95f ps=0.88u w=0.5u l=0.13u
M374 SC1/buf_16_0.z nh_sw[2] SC1/vss SC1/vss sg13_lv_nmos ad=0.17p pd=1.68u as=95f ps=0.88u w=0.5u l=0.13u
M375 SC1/buf_16_0.z nh_sw[2] SC1/vss SC1/vss sg13_lv_nmos ad=95f pd=0.88u as=95f ps=0.88u w=0.5u l=0.13u
M376 SC1/vss nh_sw[6] SC1/buf_4_1.z SC1/vss sg13_lv_nmos ad=95f pd=0.88u as=95f ps=0.88u w=0.5u l=0.13u
M377 SC1/vss nh_sw[0] SC1/buf_32_1.z SC1/vss sg13_lv_nmos ad=95f pd=0.88u as=95f ps=0.88u w=0.5u l=0.13u
M378 SC1/buf_32_0.z nl_sw[0] vdd vdd sg13_lv_pmos ad=0.34p pd=2.68u as=0.19p ps=1.38u w=1u l=0.13u
M379 SC1/buf_4_1.z nh_sw[6] vdd vdd sg13_lv_pmos ad=0.34p pd=2.68u as=0.19p ps=1.38u w=1u l=0.13u
M380 SC1/buf_8_1.z nl_sw[3] vdd vdd sg13_lv_pmos ad=0.19p pd=1.38u as=0.19p ps=1.38u w=1u l=0.13u
M381 vdd nl_sw[0] SC1/buf_32_0.z vdd sg13_lv_pmos ad=0.19p pd=1.38u as=0.19p ps=1.38u w=1u l=0.13u
M382 SC1/buf_32_0.z nl_sw[0] SC1/vss SC1/vss sg13_lv_nmos ad=95f pd=0.88u as=95f ps=0.88u w=0.5u l=0.13u
M383 SC1/buf_32_1.z nh_sw[0] SC1/vss SC1/vss sg13_lv_nmos ad=95f pd=0.88u as=95f ps=0.88u w=0.5u l=0.13u
M384 SC1/vss nh_sw[0] SC1/buf_32_1.z SC1/vss sg13_lv_nmos ad=95f pd=0.88u as=95f ps=0.88u w=0.5u l=0.13u
M385 vdd nl_sw[6] SC1/buf_4_3.z vdd sg13_lv_pmos ad=0.19p pd=1.38u as=0.19p ps=1.38u w=1u l=0.13u
M386 vdd nh_sw[0] SC1/buf_32_1.z vdd sg13_lv_pmos ad=0.19p pd=1.38u as=0.19p ps=1.38u w=1u l=0.13u
M387 SC1/vss nl_sw[0] SC1/buf_32_0.z SC1/vss sg13_lv_nmos ad=95f pd=0.88u as=95f ps=0.88u w=0.5u l=0.13u
M388 vdd nl_sw[1] SC1/buf_16_2.z vdd sg13_lv_pmos ad=0.19p pd=1.38u as=0.19p ps=1.38u w=1u l=0.13u
M389 SC1/buf_4_0.z nl_sw[7] SC1/vss SC1/vss sg13_lv_nmos ad=95f pd=0.88u as=95f ps=0.88u w=0.5u l=0.13u
M390 vdd nl_sw[5] SC1/buf_8_4.z vdd sg13_lv_pmos ad=0.19p pd=1.38u as=0.34p ps=2.68u w=1u l=0.13u
M391 vdd nh_sw[1] SC1/buf_16_3.z vdd sg13_lv_pmos ad=0.19p pd=1.38u as=0.19p ps=1.38u w=1u l=0.13u
M392 vdd nl_sw[2] SC1/buf_16_1.z vdd sg13_lv_pmos ad=0.19p pd=1.38u as=0.34p ps=2.68u w=1u l=0.13u
M393 SC1/buf_32_1.z nh_sw[0] vdd vdd sg13_lv_pmos ad=0.19p pd=1.38u as=0.19p ps=1.38u w=1u l=0.13u
M394 SC1/vss nh_sw[1] SC1/buf_16_3.z SC1/vss sg13_lv_nmos ad=95f pd=0.88u as=95f ps=0.88u w=0.5u l=0.13u
M395 vdd nh_sw[2] SC1/buf_16_0.z vdd sg13_lv_pmos ad=0.19p pd=1.38u as=0.19p ps=1.38u w=1u l=0.13u
M396 SC1/buf_2_0.z nh_sw[8] SC1/vss SC1/vss sg13_lv_nmos ad=0.17p pd=1.68u as=95f ps=0.88u w=0.5u l=0.13u
M397 SC1/buf_16_1.z nl_sw[2] vdd vdd sg13_lv_pmos ad=0.19p pd=1.38u as=0.19p ps=1.38u w=1u l=0.13u
M398 vdd nh_sw[5] SC1/buf_8_5.z vdd sg13_lv_pmos ad=0.19p pd=1.38u as=0.19p ps=1.38u w=1u l=0.13u
M399 SC1/vss nl_sw[5] SC1/buf_8_4.z SC1/vss sg13_lv_nmos ad=95f pd=0.88u as=95f ps=0.88u w=0.5u l=0.13u
M400 SC1/buf_16_2.z nl_sw[1] SC1/vss SC1/vss sg13_lv_nmos ad=95f pd=0.88u as=95f ps=0.88u w=0.5u l=0.13u
M401 SC1/buf_8_0.z nl_sw[4] SC1/vss SC1/vss sg13_lv_nmos ad=95f pd=0.88u as=95f ps=0.88u w=0.5u l=0.13u
M402 vdd nl_sw[1] SC1/buf_16_2.z vdd sg13_lv_pmos ad=0.19p pd=1.38u as=0.19p ps=1.38u w=1u l=0.13u
M403 SC1/buf_8_2.z nh_sw[4] vdd vdd sg13_lv_pmos ad=0.19p pd=1.38u as=0.19p ps=1.38u w=1u l=0.13u
M0 vdd DBS/a_946_4012# DBS/a_878_4048# DBS/vss sg13_lv_nmos ad=0.442p pd=3.28u as=0.442p ps=3.28u w=1.3u l=0.13u
M1 _vin DBS/a_2906_942# DBS/a_2150_942# DBS/vss sg13_lv_nmos ad=1.02p pd=6.68u as=1.02p ps=6.68u w=3u l=0.13u
M2 DBS/a_4042_6270# DBS/single_bsw_0.sg13cmos5l_inv_1$1_0.A DBS/vss DBS/vss sg13_lv_nmos ad=95f pd=0.88u as=0.17p ps=1.68u w=0.5u l=0.13u
M3 DBS/single_bsw_1.sg13cmos5l_inv_1$1_2.Y DBS/single_bsw_1.sg13cmos5l_inv_1$1_2.A DBS/vss DBS/vss sg13_lv_nmos ad=0.2516p pd=2.16u as=0.2516p ps=2.16u w=0.74u l=0.13u
M4 DBS/vss vdd DBS/vss DBS/vss sg13_lv_nmos ad=0.1428p pd=1.52u as=81.33254p ps=0.54442m w=0.42u l=1u
M5 vdd DBS/vss vdd vdd sg13_lv_pmos ad=0.34p pd=2.68u as=31.4284p ps=0.1861m w=1u l=1u
M6 DBS/a_2150_6110# DBS/single_bsw_0.sg13cmos5l_inv_1$1_0.A DBS/vss DBS/vss sg13_lv_nmos ad=0.442p pd=3.28u as=0.442p ps=3.28u w=1.3u l=0.4u
M7 vdd DBS/vss vdd vdd sg13_lv_pmos ad=0.34p pd=2.68u as=0 ps=0 w=1u l=1u
M8 DBS/vss vdd DBS/vss DBS/vss sg13_lv_nmos ad=0.1428p pd=1.52u as=0 ps=0 w=0.42u l=1u
M9 DBS/a_946_2908# DBS/a_878_3004# vdd DBS/vss sg13_lv_nmos ad=0.442p pd=3.28u as=0.442p ps=3.28u w=1.3u l=0.13u
M10 DBS/single_bsw_1.sg13cmos5l_inv_1$1_2.Y DBS/single_bsw_1.sg13cmos5l_inv_1$1_2.A vdd vdd sg13_lv_pmos ad=0.3808p pd=2.92u as=0.3808p ps=2.92u w=1.12u l=0.13u
M11 DBS/single_bsw_0.sg13cmos5l_inv_1$1_2.Y DBS/single_bsw_0.sg13cmos5l_inv_1$1_2.A DBS/vss DBS/vss sg13_lv_nmos ad=0.2516p pd=2.16u as=0.2516p ps=2.16u w=0.74u l=0.13u
M12 DBS/vss vdd DBS/vss DBS/vss sg13_lv_nmos ad=0.1428p pd=1.52u as=0 ps=0 w=0.42u l=1u
M13 DBS/a_3000_5770# vdd DBS/a_2906_4128# DBS/vss sg13_lv_nmos ad=0.57p pd=3.38u as=1.02p ps=6.68u w=3u l=0.13u
M14 DBS/a_946_4012# DBS/a_878_4048# vdd DBS/vss sg13_lv_nmos ad=0.442p pd=3.28u as=0.442p ps=3.28u w=1.3u l=0.13u
M15 _vin DBS/a_4144_942# vcn DBS/vss sg13_lv_nmos ad=0.85p pd=5.68u as=0.85p ps=5.68u w=2.5u l=0.13u
M16 DBS/single_bsw_1.sg13cmos5l_inv_1$1_0.A _cks vdd vdd sg13_lv_pmos ad=0.3808p pd=2.92u as=0.3808p ps=2.92u w=1.12u l=0.13u
M17 DBS/a_4144_5246# vdd DBS/a_4042_6270# DBS/vss sg13_lv_nmos ad=0.17p pd=1.68u as=95f ps=0.88u w=0.5u l=0.13u
M18 DBS/single_bsw_0.sg13cmos5l_inv_1$1_2.Y DBS/single_bsw_0.sg13cmos5l_inv_1$1_2.A vdd vdd sg13_lv_pmos ad=0.3808p pd=2.92u as=0.3808p ps=2.92u w=1.12u l=0.13u
M19 DBS/a_4144_5246# DBS/single_bsw_0.sg13cmos5l_inv_1$1_2.Y DBS/w_3740_4936# DBS/w_3740_4936# sg13_lv_pmos ad=0.17p pd=1.68u as=0.17p ps=1.68u w=0.5u l=0.13u
M20 DBS/single_bsw_1.sg13cmos5l_inv_1$1_0.Y DBS/single_bsw_1.sg13cmos5l_inv_1$1_0.A vdd vdd sg13_lv_pmos ad=0.3808p pd=2.92u as=0.3808p ps=2.92u w=1.12u l=0.13u
M21 vdd DBS/vss vdd vdd sg13_lv_pmos ad=0.34p pd=2.68u as=0 ps=0 w=1u l=1u
M22 vdd DBS/single_bsw_0.sg13cmos5l_inv_1$1_2.A DBS/a_2906_4128# vdd sg13_lv_pmos ad=0.17p pd=1.68u as=0.17p ps=1.68u w=0.5u l=0.13u
M23 DBS/vss DBS/single_bsw_1.sg13cmos5l_inv_1$1_0.A DBS/a_3000_942# DBS/vss sg13_lv_nmos ad=1.02p pd=6.68u as=0.57p ps=3.38u w=3u l=0.13u
M24 DBS/single_bsw_1.sg13cmos5l_inv_1$1_0.A _cks DBS/vss DBS/vss sg13_lv_nmos ad=0.2516p pd=2.16u as=0.2516p ps=2.16u w=0.74u l=0.13u
M25 DBS/single_bsw_1.sg13cmos5l_inv_1$1_0.Y DBS/single_bsw_1.sg13cmos5l_inv_1$1_0.A DBS/vss DBS/vss sg13_lv_nmos ad=0.2516p pd=2.16u as=0.2516p ps=2.16u w=0.74u l=0.13u
M26 DBS/single_bsw_0.sg13cmos5l_inv_1$1_0.A _cks vdd vdd sg13_lv_pmos ad=0.3808p pd=2.92u as=0.3808p ps=2.92u w=1.12u l=0.13u
M27 vdd DBS/single_bsw_1.sg13cmos5l_inv_1$1_2.A DBS/a_2906_942# vdd sg13_lv_pmos ad=0.17p pd=1.68u as=0.17p ps=1.68u w=0.5u l=0.13u
M28 DBS/a_2150_942# DBS/single_bsw_1.sg13cmos5l_inv_1$1_0.A DBS/vss DBS/vss sg13_lv_nmos ad=0.442p pd=3.28u as=0.442p ps=3.28u w=1.3u l=0.4u
M29 DBS/single_bsw_0.sg13cmos5l_inv_1$1_0.A _cks DBS/vss DBS/vss sg13_lv_nmos ad=0.2516p pd=2.16u as=0.2516p ps=2.16u w=0.74u l=0.13u
M30 DBS/a_3000_942# vdd DBS/a_2906_942# DBS/vss sg13_lv_nmos ad=0.57p pd=3.38u as=1.02p ps=6.68u w=3u l=0.13u
M31 DBS/single_bsw_0.sg13cmos5l_inv_1$1_0.Y DBS/single_bsw_0.sg13cmos5l_inv_1$1_0.A vdd vdd sg13_lv_pmos ad=0.3808p pd=2.92u as=0.3808p ps=2.92u w=1.12u l=0.13u
M32 vdd DBS/vss vdd vdd sg13_lv_pmos ad=0.34p pd=2.68u as=0 ps=0 w=1u l=1u
M33 DBS/a_4144_942# DBS/single_bsw_1.sg13cmos5l_inv_1$1_2.Y DBS/w_3740_1656# DBS/w_3740_1656# sg13_lv_pmos ad=0.17p pd=1.68u as=0.17p ps=1.68u w=0.5u l=0.13u
M34 DBS/single_bsw_0.sg13cmos5l_inv_1$1_0.Y DBS/single_bsw_0.sg13cmos5l_inv_1$1_0.A DBS/vss DBS/vss sg13_lv_nmos ad=0.2516p pd=2.16u as=0.2516p ps=2.16u w=0.74u l=0.13u
M35 DBS/w_3740_1656# DBS/a_878_3004# vdd DBS/vss sg13_lv_nmos ad=0.442p pd=3.28u as=0.442p ps=3.28u w=1.3u l=0.13u
M36 DBS/a_4042_942# DBS/single_bsw_1.sg13cmos5l_inv_1$1_0.A DBS/vss DBS/vss sg13_lv_nmos ad=95f pd=0.88u as=0.17p ps=1.68u w=0.5u l=0.13u
M37 vdd DBS/vss vdd vdd sg13_lv_pmos ad=0.34p pd=2.68u as=0 ps=0 w=1u l=1u
M38 _vip DBS/a_2906_4128# DBS/a_2150_6110# DBS/vss sg13_lv_nmos ad=1.02p pd=6.68u as=1.02p ps=6.68u w=3u l=0.13u
M39 DBS/a_4144_942# vdd DBS/a_4042_942# DBS/vss sg13_lv_nmos ad=0.17p pd=1.68u as=95f ps=0.88u w=0.5u l=0.13u
M40 DBS/w_3740_4936# DBS/a_878_4048# vdd DBS/vss sg13_lv_nmos ad=0.442p pd=3.28u as=0.442p ps=3.28u w=1.3u l=0.13u
M41 DBS/vss DBS/single_bsw_0.sg13cmos5l_inv_1$1_0.A DBS/a_3000_5770# DBS/vss sg13_lv_nmos ad=1.02p pd=6.68u as=0.57p ps=3.38u w=3u l=0.13u
M42 _vip DBS/a_4144_5246# vcp DBS/vss sg13_lv_nmos ad=0.85p pd=5.68u as=0.85p ps=5.68u w=2.5u l=0.13u
M43 DBS/vss vdd DBS/vss DBS/vss sg13_lv_nmos ad=0.1428p pd=1.52u as=0 ps=0 w=0.42u l=1u
M44 DBS/vss vdd DBS/vss DBS/vss sg13_lv_nmos ad=0.1428p pd=1.52u as=0 ps=0 w=0.42u l=1u
M45 vdd DBS/a_946_2908# DBS/a_878_3004# DBS/vss sg13_lv_nmos ad=0.442p pd=3.28u as=0.442p ps=3.28u w=1.3u l=0.13u
M46 DBS/vss vdd DBS/vss DBS/vss sg13_lv_nmos ad=0.1428p pd=1.52u as=0 ps=0 w=0.42u l=1u
M47 vdd DBS/vss vdd vdd sg13_lv_pmos ad=0.34p pd=2.68u as=0 ps=0 w=1u l=1u
M0 comp_p ckc vdd vdd sg13_lv_pmos ad=0.17p pd=1.68u as=95f ps=0.88u w=0.5u l=0.13u
M1 CMP/vss CMP/a_581042_926846# CMP/a_581154_926910# CMP/vss sg13_lv_nmos ad=0.1426p pd=1.16u as=0.1428p ps=1.52u w=0.42u l=0.5u
M2 CMP/sg13cmos5l_or2_1$1_0.X CMP/a_579900_927220# CMP/vss CMP/vss sg13_lv_nmos ad=0.2516p pd=2.16u as=0.1469p ps=1.155u w=0.74u l=0.13u
M3 CMP/vss vdd CMP/vss CMP/vss sg13_lv_nmos ad=0.1428p pd=1.52u as=41.9265p ps=0.27795m w=0.42u l=1u
M4 vdd ckc CMP/a_574318_928566# vdd sg13_lv_pmos ad=95f pd=0.88u as=0.17p ps=1.68u w=0.5u l=0.13u
M5 CMP/a_574934_925864# ckc CMP/vss CMP/vss sg13_lv_nmos ad=0.17p pd=1.68u as=95f ps=0.88u w=0.5u l=0.13u
M6 CMP/a_574934_925864# ckc CMP/vss CMP/vss sg13_lv_nmos ad=95f pd=0.88u as=95f ps=0.88u w=0.5u l=0.13u
M7 rdy CMP/a_581154_926910# vdd vdd sg13_lv_pmos ad=0.4256p pd=3u as=0.2254p ps=1.53u w=1.12u l=0.13u
M8 CMP/sg13cmos5l_inv_1$1_1.Y comp_n CMP/vss CMP/vss sg13_lv_nmos ad=0.2516p pd=2.16u as=0.2516p ps=2.16u w=0.74u l=0.13u
M9 CMP/a_577144_925864# vcp CMP/a_574934_925864# CMP/vss sg13_lv_nmos ad=1.7p pd=10.68u as=0.95p ps=5.38u w=5u l=0.13u
M10 CMP/vss CMP/sg13cmos5l_inv_1$1_0.Y CMP/a_579900_927220# CMP/vss sg13_lv_nmos ad=0.1469p pd=1.155u as=0.1045p ps=0.93u w=0.55u l=0.13u
M11 comp_n ckc vdd vdd sg13_lv_pmos ad=0.17p pd=1.68u as=95f ps=0.88u w=0.5u l=0.13u
M12 comp_n comp_p vdd vdd sg13_lv_pmos ad=0.425p pd=3.18u as=0.2375p ps=1.63u w=1.25u l=0.13u
M13 CMP/sg13cmos5l_inv_1$1_1.Y comp_n vdd vdd sg13_lv_pmos ad=0.3808p pd=2.92u as=0.3808p ps=2.92u w=1.12u l=0.13u
M14 CMP/a_577144_925864# comp_p comp_n CMP/vss sg13_lv_nmos ad=1.7p pd=10.68u as=0.95p ps=5.38u w=5u l=0.13u
M15 comp_p comp_n CMP/a_574318_928566# CMP/vss sg13_lv_nmos ad=0.95p pd=5.38u as=1.7p ps=10.68u w=5u l=0.13u
M16 CMP/a_579900_927220# CMP/sg13cmos5l_inv_1$1_1.Y CMP/vss CMP/vss sg13_lv_nmos ad=0.1045p pd=0.93u as=0.187p ps=1.78u w=0.55u l=0.13u
M17 CMP/vss CMP/sg13cmos5l_or2_1$1_0.X CMP/a_580772_926846# CMP/vss sg13_lv_nmos ad=79.8f pd=0.8u as=0.1428p ps=1.52u w=0.42u l=0.13u
M18 vdd comp_n comp_p vdd sg13_lv_pmos ad=0.2375p pd=1.63u as=0.425p ps=3.18u w=1.25u l=0.13u
M19 vdd ckc comp_p vdd sg13_lv_pmos ad=95f pd=0.88u as=0.17p ps=1.68u w=0.5u l=0.13u
M20 vdd CMP/a_581042_926846# CMP/a_581154_926910# vdd sg13_lv_pmos ad=0.2254p pd=1.53u as=0.34p ps=2.68u w=1u l=0.5u
M21 vdd CMP/vss vdd vdd sg13_lv_pmos ad=0.34p pd=2.68u as=42.0809p ps=0.28309m w=1u l=1u
M22 vdd CMP/sg13cmos5l_or2_1$1_0.X CMP/a_580772_926846# vdd sg13_lv_pmos ad=0.1523p pd=1.38u as=0.1428p ps=1.52u w=0.42u l=0.13u
M23 CMP/sg13cmos5l_inv_1$1_0.Y comp_p CMP/vss CMP/vss sg13_lv_nmos ad=0.2516p pd=2.16u as=0.2516p ps=2.16u w=0.74u l=0.13u
M24 rdy CMP/a_581154_926910# CMP/vss CMP/vss sg13_lv_nmos ad=0.2516p pd=2.16u as=0.1426p ps=1.16u w=0.74u l=0.13u
M25 CMP/a_574318_928566# ckc vdd vdd sg13_lv_pmos ad=0.17p pd=1.68u as=95f ps=0.88u w=0.5u l=0.13u
M26 comp_p comp_n vdd vdd sg13_lv_pmos ad=0.425p pd=3.18u as=0.2375p ps=1.63u w=1.25u l=0.13u
M27 CMP/vss ckc CMP/a_574934_925864# CMP/vss sg13_lv_nmos ad=95f pd=0.88u as=95f ps=0.88u w=0.5u l=0.13u
M28 CMP/vss ckc CMP/a_574934_925864# CMP/vss sg13_lv_nmos ad=95f pd=0.88u as=0.17p ps=1.68u w=0.5u l=0.13u
M29 CMP/sg13cmos5l_inv_1$1_0.Y comp_p vdd vdd sg13_lv_pmos ad=0.3808p pd=2.92u as=0.3808p ps=2.92u w=1.12u l=0.13u
M30 vdd CMP/sg13cmos5l_inv_1$1_0.Y CMP/a_579994_927220# vdd sg13_lv_pmos ad=0.2226p pd=1.535u as=0.1596p ps=1.22u w=0.84u l=0.13u
M31 CMP/a_574934_925864# vcn CMP/a_574318_928566# CMP/vss sg13_lv_nmos ad=0.95p pd=5.38u as=1.7p ps=10.68u w=5u l=0.13u
M32 CMP/vss vdd CMP/vss CMP/vss sg13_lv_nmos ad=0.1428p pd=1.52u as=0 ps=0 w=0.42u l=1u
M33 CMP/a_577144_925864# ckc vdd vdd sg13_lv_pmos ad=0.17p pd=1.68u as=95f ps=0.88u w=0.5u l=0.13u
M34 CMP/a_574934_925864# vcp CMP/a_577144_925864# CMP/vss sg13_lv_nmos ad=0.95p pd=5.38u as=1.7p ps=10.68u w=5u l=0.13u
M35 CMP/a_581042_926846# CMP/a_580772_926846# vdd vdd sg13_lv_pmos ad=0.34p pd=2.68u as=0.1523p ps=1.38u w=1u l=0.5u
M36 vdd ckc comp_n vdd sg13_lv_pmos ad=95f pd=0.88u as=0.17p ps=1.68u w=0.5u l=0.13u
M37 vdd comp_p comp_n vdd sg13_lv_pmos ad=0.2375p pd=1.63u as=0.425p ps=3.18u w=1.25u l=0.13u
M38 comp_n comp_p CMP/a_577144_925864# CMP/vss sg13_lv_nmos ad=0.95p pd=5.38u as=1.7p ps=10.68u w=5u l=0.13u
M39 CMP/a_579994_927220# CMP/sg13cmos5l_inv_1$1_1.Y CMP/a_579900_927220# vdd sg13_lv_pmos ad=0.1596p pd=1.22u as=0.2856p ps=2.36u w=0.84u l=0.13u
M40 CMP/a_574318_928566# comp_n comp_p CMP/vss sg13_lv_nmos ad=1.7p pd=10.68u as=0.95p ps=5.38u w=5u l=0.13u
M41 CMP/a_581042_926846# CMP/a_580772_926846# CMP/vss CMP/vss sg13_lv_nmos ad=0.1428p pd=1.52u as=79.8f ps=0.8u w=0.42u l=0.5u
M42 vdd ckc CMP/a_577144_925864# vdd sg13_lv_pmos ad=95f pd=0.88u as=0.17p ps=1.68u w=0.5u l=0.13u
M43 vdd CMP/vss vdd vdd sg13_lv_pmos ad=0.34p pd=2.68u as=0 ps=0 w=1u l=1u
M44 CMP/sg13cmos5l_or2_1$1_0.X CMP/a_579900_927220# vdd vdd sg13_lv_pmos ad=0.3976p pd=2.95u as=0.2226p ps=1.535u w=1.12u l=0.13u
M45 CMP/a_574318_928566# vcn CMP/a_574934_925864# CMP/vss sg13_lv_nmos ad=1.7p pd=10.68u as=0.95p ps=5.38u w=5u l=0.13u
M0 P0/iovdd_uq0 P0/a_5044_13476# vip P0/iovdd_uq0 sg13_hv_pmos ad=2.1312p pd=7.3u as=3.9294p ps=7.84u w=6.66u l=0.6u
M1 vip P0/a_5044_1676# vss vss sg13_hv_nmos ad=2.596p pd=5.58u as=1.408p ps=5.04u w=4.4u l=0.6u
M2 vip P0/a_5044_13476# P0/iovdd_uq0 P0/iovdd_uq0 sg13_hv_pmos ad=3.9294p pd=7.84u as=2.1312p ps=7.3u w=6.66u l=0.6u
M3 P0/iovdd_uq0 P0/a_5044_13476# vip P0/iovdd_uq0 sg13_hv_pmos ad=2.1312p pd=7.3u as=3.9294p ps=7.84u w=6.66u l=0.6u
M4 P0/iovdd_uq0 P0/a_5044_13476# vip P0/iovdd_uq0 sg13_hv_pmos ad=2.1312p pd=7.3u as=3.9294p ps=7.84u w=6.66u l=0.6u
M5 vip P0/a_5044_1676# vss vss sg13_hv_nmos ad=2.596p pd=5.58u as=1.408p ps=5.04u w=4.4u l=0.6u
M6 vip P0/a_5044_13476# P0/iovdd_uq0 P0/iovdd_uq0 sg13_hv_pmos ad=3.9294p pd=7.84u as=2.1312p ps=7.3u w=6.66u l=0.6u
M7 P0/iovdd_uq0 P0/a_5044_13476# vip P0/iovdd_uq0 sg13_hv_pmos ad=2.1312p pd=7.3u as=3.9294p ps=7.84u w=6.66u l=0.6u
M8 vip P0/a_5044_1676# vss vss sg13_hv_nmos ad=2.596p pd=5.58u as=1.408p ps=5.04u w=4.4u l=0.6u
M9 vss P0/a_5044_1676# vip vss sg13_hv_nmos ad=2.068p pd=9.74u as=2.596p ps=5.58u w=4.4u l=0.6u
M10 vip P0/a_5044_13476# P0/iovdd_uq0 P0/iovdd_uq0 sg13_hv_pmos ad=3.9294p pd=7.84u as=2.1312p ps=7.3u w=6.66u l=0.6u
X11 P0/a_5044_13476# P0/iovdd_uq0 P0/iovdd_uq0 P0/rppd l=12.9u w=0.5u
M12 vss P0/a_5044_1676# vip vss sg13_hv_nmos ad=1.408p pd=5.04u as=2.596p ps=5.58u w=4.4u l=0.6u
M13 vip P0/a_5044_13476# P0/iovdd_uq0 P0/iovdd_uq0 sg13_hv_pmos ad=3.9294p pd=7.84u as=2.1312p ps=7.3u w=6.66u l=0.6u
X14 vss P0/a_5222_4862# P0/dantenna P0/l=1.26u w=27.78u
M15 vss P0/a_5044_1676# vip vss sg13_hv_nmos ad=1.408p pd=5.04u as=2.596p ps=5.58u w=4.4u l=0.6u
M16 vip P0/a_5044_1676# vss vss sg13_hv_nmos ad=2.596p pd=5.58u as=1.408p ps=5.04u w=4.4u l=0.6u
M17 vss P0/a_5044_1676# vip vss sg13_hv_nmos ad=1.408p pd=5.04u as=2.596p ps=5.58u w=4.4u l=0.6u
M18 P0/iovdd_uq0 P0/a_5044_13476# vip P0/iovdd_uq0 sg13_hv_pmos ad=2.1312p pd=7.3u as=3.9294p ps=7.84u w=6.66u l=0.6u
M19 vip P0/a_5044_1676# vss vss sg13_hv_nmos ad=2.596p pd=5.58u as=1.408p ps=5.04u w=4.4u l=0.6u
M20 vip P0/a_5044_13476# P0/iovdd_uq0 P0/iovdd_uq0 sg13_hv_pmos ad=3.9294p pd=7.84u as=2.1312p ps=7.3u w=6.66u l=0.6u
M21 P0/iovdd_uq0 P0/a_5044_13476# vip P0/iovdd_uq0 sg13_hv_pmos ad=2.1312p pd=7.3u as=3.9294p ps=7.84u w=6.66u l=0.6u
M22 vip P0/a_5044_13476# P0/iovdd_uq0 P0/iovdd_uq0 sg13_hv_pmos ad=3.9294p pd=7.84u as=2.1312p ps=7.3u w=6.66u l=0.6u
M23 vip P0/a_5044_13476# P0/iovdd_uq0 P0/iovdd_uq0 sg13_hv_pmos ad=3.9294p pd=7.84u as=2.1312p ps=7.3u w=6.66u l=0.6u
M24 vss P0/a_5044_1676# vip vss sg13_hv_nmos ad=1.408p pd=5.04u as=2.596p ps=5.58u w=4.4u l=0.6u
X25 _vip P0/iovdd P0/dpantenna P0/l=0.64u w=4.98u
M26 P0/iovdd_uq0 P0/a_5044_13476# vip P0/iovdd_uq0 sg13_hv_pmos ad=2.1312p pd=7.3u as=3.9294p ps=7.84u w=6.66u l=0.6u
M27 vip P0/a_5044_13476# P0/iovdd_uq0 P0/iovdd_uq0 sg13_hv_pmos ad=3.9294p pd=7.84u as=2.1312p ps=7.3u w=6.66u l=0.6u
M28 vip P0/a_5044_13476# P0/iovdd_uq0 P0/iovdd_uq0 sg13_hv_pmos ad=3.9294p pd=7.84u as=2.1312p ps=7.3u w=6.66u l=0.6u
M29 vip P0/a_5044_1676# vss vss sg13_hv_nmos ad=2.596p pd=5.58u as=1.408p ps=5.04u w=4.4u l=0.6u
M30 P0/iovdd_uq0 P0/a_5044_13476# vip P0/iovdd_uq0 sg13_hv_pmos ad=2.1312p pd=7.3u as=3.9294p ps=7.84u w=6.66u l=0.6u
X31 _vip vip vss P0/rppd l=2u w=1u
M32 P0/iovdd_uq0 P0/a_5044_13476# vip P0/iovdd_uq0 sg13_hv_pmos ad=2.1312p pd=7.3u as=3.9294p ps=7.84u w=6.66u l=0.6u
M33 P0/iovdd_uq0 P0/a_5044_13476# vip P0/iovdd_uq0 sg13_hv_pmos ad=2.1312p pd=7.3u as=3.9294p ps=7.84u w=6.66u l=0.6u
M34 vip P0/a_5044_13476# P0/iovdd_uq0 P0/iovdd_uq0 sg13_hv_pmos ad=3.9294p pd=7.84u as=2.1312p ps=7.3u w=6.66u l=0.6u
M35 vip P0/a_5044_1676# vss vss sg13_hv_nmos ad=2.596p pd=5.58u as=1.408p ps=5.04u w=4.4u l=0.6u
M36 vss P0/a_5044_1676# vip vss sg13_hv_nmos ad=1.408p pd=5.04u as=2.596p ps=5.58u w=4.4u l=0.6u
M37 vip P0/a_5044_1676# vss vss sg13_hv_nmos ad=2.596p pd=5.58u as=1.408p ps=5.04u w=4.4u l=0.6u
M38 P0/iovdd_uq0 P0/a_5044_13476# vip P0/iovdd_uq0 sg13_hv_pmos ad=2.1312p pd=7.3u as=3.9294p ps=7.84u w=6.66u l=0.6u
M39 vip P0/a_5044_13476# P0/iovdd_uq0 P0/iovdd_uq0 sg13_hv_pmos ad=3.9294p pd=7.84u as=2.1312p ps=7.3u w=6.66u l=0.6u
X40 vip P0/iovdd_uq0 P0/dpantenna P0/l=1.26u w=27.78u
M41 vss P0/a_5044_1676# vip vss sg13_hv_nmos ad=1.408p pd=5.04u as=2.596p ps=5.58u w=4.4u l=0.6u
M42 P0/iovdd_uq0 P0/a_5044_13476# vip P0/iovdd_uq0 sg13_hv_pmos ad=2.1312p pd=7.3u as=3.9294p ps=7.84u w=6.66u l=0.6u
M43 vss P0/a_5044_1676# vip vss sg13_hv_nmos ad=1.408p pd=5.04u as=2.596p ps=5.58u w=4.4u l=0.6u
M44 vip P0/a_5044_13476# P0/iovdd_uq0 P0/iovdd_uq0 sg13_hv_pmos ad=3.9294p pd=7.84u as=2.1312p ps=7.3u w=6.66u l=0.6u
M45 P0/iovdd_uq0 P0/a_5044_13476# vip P0/iovdd_uq0 sg13_hv_pmos ad=2.1312p pd=7.3u as=3.9294p ps=7.84u w=6.66u l=0.6u
M46 vip P0/a_5044_13476# P0/iovdd_uq0 P0/iovdd_uq0 sg13_hv_pmos ad=3.9294p pd=7.84u as=2.1312p ps=7.3u w=6.66u l=0.6u
M47 vip P0/a_5044_1676# vss vss sg13_hv_nmos ad=2.596p pd=5.58u as=1.408p ps=5.04u w=4.4u l=0.6u
M48 vss P0/a_5044_1676# vip vss sg13_hv_nmos ad=1.408p pd=5.04u as=2.596p ps=5.58u w=4.4u l=0.6u
M49 vip P0/a_5044_13476# P0/iovdd_uq0 P0/iovdd_uq0 sg13_hv_pmos ad=3.9294p pd=7.84u as=3.1302p ps=14.26u w=6.66u l=0.6u
M50 P0/iovdd_uq0 P0/a_5044_13476# vip P0/iovdd_uq0 sg13_hv_pmos ad=3.1302p pd=14.26u as=3.9294p ps=7.84u w=6.66u l=0.6u
M51 P0/iovdd_uq0 P0/a_5044_13476# vip P0/iovdd_uq0 sg13_hv_pmos ad=2.1312p pd=7.3u as=3.9294p ps=7.84u w=6.66u l=0.6u
M52 vip P0/a_5044_13476# P0/iovdd_uq0 P0/iovdd_uq0 sg13_hv_pmos ad=3.9294p pd=7.84u as=2.1312p ps=7.3u w=6.66u l=0.6u
X53 vip P0/iovdd_uq0 P0/dpantenna P0/l=1.26u w=27.78u
M54 vip P0/a_5044_13476# P0/iovdd_uq0 P0/iovdd_uq0 sg13_hv_pmos ad=3.9294p pd=7.84u as=3.1302p ps=14.26u w=6.66u l=0.6u
M55 P0/iovdd_uq0 P0/a_5044_13476# vip P0/iovdd_uq0 sg13_hv_pmos ad=3.1302p pd=14.26u as=3.9294p ps=7.84u w=6.66u l=0.6u
M56 P0/iovdd_uq0 P0/a_5044_13476# vip P0/iovdd_uq0 sg13_hv_pmos ad=2.1312p pd=7.3u as=3.9294p ps=7.84u w=6.66u l=0.6u
M57 vip P0/a_5044_13476# P0/iovdd_uq0 P0/iovdd_uq0 sg13_hv_pmos ad=3.9294p pd=7.84u as=2.1312p ps=7.3u w=6.66u l=0.6u
X58 vss P0/a_11462_28198# P0/dantenna P0/l=3.1u w=0.64u
X59 vss P0/a_5222_3962# P0/dantenna P0/l=1.26u w=27.78u
X60 P0/a_5044_1676# vss vss P0/rppd l=3.54u w=0.5u
M61 P0/iovdd_uq0 P0/a_5044_13476# vip P0/iovdd_uq0 sg13_hv_pmos ad=2.1312p pd=7.3u as=3.9294p ps=7.84u w=6.66u l=0.6u
M62 P0/iovdd_uq0 P0/a_5044_13476# vip P0/iovdd_uq0 sg13_hv_pmos ad=2.1312p pd=7.3u as=3.9294p ps=7.84u w=6.66u l=0.6u
M63 vip P0/a_5044_1676# vss vss sg13_hv_nmos ad=2.596p pd=5.58u as=2.068p ps=9.74u w=4.4u l=0.6u
M64 P0/iovdd_uq0 P0/a_5044_13476# vip P0/iovdd_uq0 sg13_hv_pmos ad=2.1312p pd=7.3u as=3.9294p ps=7.84u w=6.66u l=0.6u
M65 vip P0/a_5044_13476# P0/iovdd_uq0 P0/iovdd_uq0 sg13_hv_pmos ad=3.9294p pd=7.84u as=2.1312p ps=7.3u w=6.66u l=0.6u
M66 vip P0/a_5044_13476# P0/iovdd_uq0 P0/iovdd_uq0 sg13_hv_pmos ad=3.9294p pd=7.84u as=2.1312p ps=7.3u w=6.66u l=0.6u
M67 vip P0/a_5044_13476# P0/iovdd_uq0 P0/iovdd_uq0 sg13_hv_pmos ad=3.9294p pd=7.84u as=2.1312p ps=7.3u w=6.66u l=0.6u
M68 vss P0/a_5044_1676# vip vss sg13_hv_nmos ad=1.408p pd=5.04u as=2.596p ps=5.58u w=4.4u l=0.6u
M0 P1/iovdd_uq0 P1/a_5044_13476# vin P1/iovdd_uq0 sg13_hv_pmos ad=2.1312p pd=7.3u as=3.9294p ps=7.84u w=6.66u l=0.6u
M1 vin P1/a_5044_1676# vss vss sg13_hv_nmos ad=2.596p pd=5.58u as=1.408p ps=5.04u w=4.4u l=0.6u
M2 vin P1/a_5044_13476# P1/iovdd_uq0 P1/iovdd_uq0 sg13_hv_pmos ad=3.9294p pd=7.84u as=2.1312p ps=7.3u w=6.66u l=0.6u
M3 P1/iovdd_uq0 P1/a_5044_13476# vin P1/iovdd_uq0 sg13_hv_pmos ad=2.1312p pd=7.3u as=3.9294p ps=7.84u w=6.66u l=0.6u
M4 P1/iovdd_uq0 P1/a_5044_13476# vin P1/iovdd_uq0 sg13_hv_pmos ad=2.1312p pd=7.3u as=3.9294p ps=7.84u w=6.66u l=0.6u
M5 vin P1/a_5044_1676# vss vss sg13_hv_nmos ad=2.596p pd=5.58u as=1.408p ps=5.04u w=4.4u l=0.6u
M6 vin P1/a_5044_13476# P1/iovdd_uq0 P1/iovdd_uq0 sg13_hv_pmos ad=3.9294p pd=7.84u as=2.1312p ps=7.3u w=6.66u l=0.6u
M7 P1/iovdd_uq0 P1/a_5044_13476# vin P1/iovdd_uq0 sg13_hv_pmos ad=2.1312p pd=7.3u as=3.9294p ps=7.84u w=6.66u l=0.6u
M8 vin P1/a_5044_1676# vss vss sg13_hv_nmos ad=2.596p pd=5.58u as=1.408p ps=5.04u w=4.4u l=0.6u
M9 vss P1/a_5044_1676# vin vss sg13_hv_nmos ad=2.068p pd=9.74u as=2.596p ps=5.58u w=4.4u l=0.6u
M10 vin P1/a_5044_13476# P1/iovdd_uq0 P1/iovdd_uq0 sg13_hv_pmos ad=3.9294p pd=7.84u as=2.1312p ps=7.3u w=6.66u l=0.6u
X11 P1/a_5044_13476# P1/iovdd_uq0 P1/iovdd_uq0 P1/rppd l=12.9u w=0.5u
M12 vss P1/a_5044_1676# vin vss sg13_hv_nmos ad=1.408p pd=5.04u as=2.596p ps=5.58u w=4.4u l=0.6u
M13 vin P1/a_5044_13476# P1/iovdd_uq0 P1/iovdd_uq0 sg13_hv_pmos ad=3.9294p pd=7.84u as=2.1312p ps=7.3u w=6.66u l=0.6u
X14 vss P1/a_5222_4862# P1/dantenna P1/l=1.26u w=27.78u
M15 vss P1/a_5044_1676# vin vss sg13_hv_nmos ad=1.408p pd=5.04u as=2.596p ps=5.58u w=4.4u l=0.6u
M16 vin P1/a_5044_1676# vss vss sg13_hv_nmos ad=2.596p pd=5.58u as=1.408p ps=5.04u w=4.4u l=0.6u
M17 vss P1/a_5044_1676# vin vss sg13_hv_nmos ad=1.408p pd=5.04u as=2.596p ps=5.58u w=4.4u l=0.6u
M18 P1/iovdd_uq0 P1/a_5044_13476# vin P1/iovdd_uq0 sg13_hv_pmos ad=2.1312p pd=7.3u as=3.9294p ps=7.84u w=6.66u l=0.6u
M19 vin P1/a_5044_1676# vss vss sg13_hv_nmos ad=2.596p pd=5.58u as=1.408p ps=5.04u w=4.4u l=0.6u
M20 vin P1/a_5044_13476# P1/iovdd_uq0 P1/iovdd_uq0 sg13_hv_pmos ad=3.9294p pd=7.84u as=2.1312p ps=7.3u w=6.66u l=0.6u
M21 P1/iovdd_uq0 P1/a_5044_13476# vin P1/iovdd_uq0 sg13_hv_pmos ad=2.1312p pd=7.3u as=3.9294p ps=7.84u w=6.66u l=0.6u
M22 vin P1/a_5044_13476# P1/iovdd_uq0 P1/iovdd_uq0 sg13_hv_pmos ad=3.9294p pd=7.84u as=2.1312p ps=7.3u w=6.66u l=0.6u
M23 vin P1/a_5044_13476# P1/iovdd_uq0 P1/iovdd_uq0 sg13_hv_pmos ad=3.9294p pd=7.84u as=2.1312p ps=7.3u w=6.66u l=0.6u
M24 vss P1/a_5044_1676# vin vss sg13_hv_nmos ad=1.408p pd=5.04u as=2.596p ps=5.58u w=4.4u l=0.6u
X25 _vin P1/iovdd P1/dpantenna P1/l=0.64u w=4.98u
M26 P1/iovdd_uq0 P1/a_5044_13476# vin P1/iovdd_uq0 sg13_hv_pmos ad=2.1312p pd=7.3u as=3.9294p ps=7.84u w=6.66u l=0.6u
M27 vin P1/a_5044_13476# P1/iovdd_uq0 P1/iovdd_uq0 sg13_hv_pmos ad=3.9294p pd=7.84u as=2.1312p ps=7.3u w=6.66u l=0.6u
M28 vin P1/a_5044_13476# P1/iovdd_uq0 P1/iovdd_uq0 sg13_hv_pmos ad=3.9294p pd=7.84u as=2.1312p ps=7.3u w=6.66u l=0.6u
M29 vin P1/a_5044_1676# vss vss sg13_hv_nmos ad=2.596p pd=5.58u as=1.408p ps=5.04u w=4.4u l=0.6u
M30 P1/iovdd_uq0 P1/a_5044_13476# vin P1/iovdd_uq0 sg13_hv_pmos ad=2.1312p pd=7.3u as=3.9294p ps=7.84u w=6.66u l=0.6u
X31 _vin vin vss P1/rppd l=2u w=1u
M32 P1/iovdd_uq0 P1/a_5044_13476# vin P1/iovdd_uq0 sg13_hv_pmos ad=2.1312p pd=7.3u as=3.9294p ps=7.84u w=6.66u l=0.6u
M33 P1/iovdd_uq0 P1/a_5044_13476# vin P1/iovdd_uq0 sg13_hv_pmos ad=2.1312p pd=7.3u as=3.9294p ps=7.84u w=6.66u l=0.6u
M34 vin P1/a_5044_13476# P1/iovdd_uq0 P1/iovdd_uq0 sg13_hv_pmos ad=3.9294p pd=7.84u as=2.1312p ps=7.3u w=6.66u l=0.6u
M35 vin P1/a_5044_1676# vss vss sg13_hv_nmos ad=2.596p pd=5.58u as=1.408p ps=5.04u w=4.4u l=0.6u
M36 vss P1/a_5044_1676# vin vss sg13_hv_nmos ad=1.408p pd=5.04u as=2.596p ps=5.58u w=4.4u l=0.6u
M37 vin P1/a_5044_1676# vss vss sg13_hv_nmos ad=2.596p pd=5.58u as=1.408p ps=5.04u w=4.4u l=0.6u
M38 P1/iovdd_uq0 P1/a_5044_13476# vin P1/iovdd_uq0 sg13_hv_pmos ad=2.1312p pd=7.3u as=3.9294p ps=7.84u w=6.66u l=0.6u
M39 vin P1/a_5044_13476# P1/iovdd_uq0 P1/iovdd_uq0 sg13_hv_pmos ad=3.9294p pd=7.84u as=2.1312p ps=7.3u w=6.66u l=0.6u
X40 vin P1/iovdd_uq0 P1/dpantenna P1/l=1.26u w=27.78u
M41 vss P1/a_5044_1676# vin vss sg13_hv_nmos ad=1.408p pd=5.04u as=2.596p ps=5.58u w=4.4u l=0.6u
M42 P1/iovdd_uq0 P1/a_5044_13476# vin P1/iovdd_uq0 sg13_hv_pmos ad=2.1312p pd=7.3u as=3.9294p ps=7.84u w=6.66u l=0.6u
M43 vss P1/a_5044_1676# vin vss sg13_hv_nmos ad=1.408p pd=5.04u as=2.596p ps=5.58u w=4.4u l=0.6u
M44 vin P1/a_5044_13476# P1/iovdd_uq0 P1/iovdd_uq0 sg13_hv_pmos ad=3.9294p pd=7.84u as=2.1312p ps=7.3u w=6.66u l=0.6u
M45 P1/iovdd_uq0 P1/a_5044_13476# vin P1/iovdd_uq0 sg13_hv_pmos ad=2.1312p pd=7.3u as=3.9294p ps=7.84u w=6.66u l=0.6u
M46 vin P1/a_5044_13476# P1/iovdd_uq0 P1/iovdd_uq0 sg13_hv_pmos ad=3.9294p pd=7.84u as=2.1312p ps=7.3u w=6.66u l=0.6u
M47 vin P1/a_5044_1676# vss vss sg13_hv_nmos ad=2.596p pd=5.58u as=1.408p ps=5.04u w=4.4u l=0.6u
M48 vss P1/a_5044_1676# vin vss sg13_hv_nmos ad=1.408p pd=5.04u as=2.596p ps=5.58u w=4.4u l=0.6u
M49 vin P1/a_5044_13476# P1/iovdd_uq0 P1/iovdd_uq0 sg13_hv_pmos ad=3.9294p pd=7.84u as=3.1302p ps=14.26u w=6.66u l=0.6u
M50 P1/iovdd_uq0 P1/a_5044_13476# vin P1/iovdd_uq0 sg13_hv_pmos ad=3.1302p pd=14.26u as=3.9294p ps=7.84u w=6.66u l=0.6u
M51 P1/iovdd_uq0 P1/a_5044_13476# vin P1/iovdd_uq0 sg13_hv_pmos ad=2.1312p pd=7.3u as=3.9294p ps=7.84u w=6.66u l=0.6u
M52 vin P1/a_5044_13476# P1/iovdd_uq0 P1/iovdd_uq0 sg13_hv_pmos ad=3.9294p pd=7.84u as=2.1312p ps=7.3u w=6.66u l=0.6u
X53 vin P1/iovdd_uq0 P1/dpantenna P1/l=1.26u w=27.78u
M54 vin P1/a_5044_13476# P1/iovdd_uq0 P1/iovdd_uq0 sg13_hv_pmos ad=3.9294p pd=7.84u as=3.1302p ps=14.26u w=6.66u l=0.6u
M55 P1/iovdd_uq0 P1/a_5044_13476# vin P1/iovdd_uq0 sg13_hv_pmos ad=3.1302p pd=14.26u as=3.9294p ps=7.84u w=6.66u l=0.6u
M56 P1/iovdd_uq0 P1/a_5044_13476# vin P1/iovdd_uq0 sg13_hv_pmos ad=2.1312p pd=7.3u as=3.9294p ps=7.84u w=6.66u l=0.6u
M57 vin P1/a_5044_13476# P1/iovdd_uq0 P1/iovdd_uq0 sg13_hv_pmos ad=3.9294p pd=7.84u as=2.1312p ps=7.3u w=6.66u l=0.6u
X58 vss P1/a_11462_28198# P1/dantenna P1/l=3.1u w=0.64u
X59 vss P1/a_5222_3962# P1/dantenna P1/l=1.26u w=27.78u
X60 P1/a_5044_1676# vss vss P1/rppd l=3.54u w=0.5u
M61 P1/iovdd_uq0 P1/a_5044_13476# vin P1/iovdd_uq0 sg13_hv_pmos ad=2.1312p pd=7.3u as=3.9294p ps=7.84u w=6.66u l=0.6u
M62 P1/iovdd_uq0 P1/a_5044_13476# vin P1/iovdd_uq0 sg13_hv_pmos ad=2.1312p pd=7.3u as=3.9294p ps=7.84u w=6.66u l=0.6u
M63 vin P1/a_5044_1676# vss vss sg13_hv_nmos ad=2.596p pd=5.58u as=2.068p ps=9.74u w=4.4u l=0.6u
M64 P1/iovdd_uq0 P1/a_5044_13476# vin P1/iovdd_uq0 sg13_hv_pmos ad=2.1312p pd=7.3u as=3.9294p ps=7.84u w=6.66u l=0.6u
M65 vin P1/a_5044_13476# P1/iovdd_uq0 P1/iovdd_uq0 sg13_hv_pmos ad=3.9294p pd=7.84u as=2.1312p ps=7.3u w=6.66u l=0.6u
M66 vin P1/a_5044_13476# P1/iovdd_uq0 P1/iovdd_uq0 sg13_hv_pmos ad=3.9294p pd=7.84u as=2.1312p ps=7.3u w=6.66u l=0.6u
M67 vin P1/a_5044_13476# P1/iovdd_uq0 P1/iovdd_uq0 sg13_hv_pmos ad=3.9294p pd=7.84u as=2.1312p ps=7.3u w=6.66u l=0.6u
M68 vss P1/a_5044_1676# vin vss sg13_hv_nmos ad=1.408p pd=5.04u as=2.596p ps=5.58u w=4.4u l=0.6u
M0 P2/iovdd_uq0 P2/a_5044_13476# cks P2/iovdd_uq0 sg13_hv_pmos ad=2.1312p pd=7.3u as=3.9294p ps=7.84u w=6.66u l=0.6u
M1 cks P2/a_5044_1676# vss vss sg13_hv_nmos ad=2.596p pd=5.58u as=1.408p ps=5.04u w=4.4u l=0.6u
M2 cks P2/a_5044_13476# P2/iovdd_uq0 P2/iovdd_uq0 sg13_hv_pmos ad=3.9294p pd=7.84u as=2.1312p ps=7.3u w=6.66u l=0.6u
M3 P2/iovdd_uq0 P2/a_5044_13476# cks P2/iovdd_uq0 sg13_hv_pmos ad=2.1312p pd=7.3u as=3.9294p ps=7.84u w=6.66u l=0.6u
M4 P2/iovdd_uq0 P2/a_5044_13476# cks P2/iovdd_uq0 sg13_hv_pmos ad=2.1312p pd=7.3u as=3.9294p ps=7.84u w=6.66u l=0.6u
M5 cks P2/a_5044_1676# vss vss sg13_hv_nmos ad=2.596p pd=5.58u as=1.408p ps=5.04u w=4.4u l=0.6u
M6 cks P2/a_5044_13476# P2/iovdd_uq0 P2/iovdd_uq0 sg13_hv_pmos ad=3.9294p pd=7.84u as=2.1312p ps=7.3u w=6.66u l=0.6u
M7 P2/iovdd_uq0 P2/a_5044_13476# cks P2/iovdd_uq0 sg13_hv_pmos ad=2.1312p pd=7.3u as=3.9294p ps=7.84u w=6.66u l=0.6u
M8 cks P2/a_5044_1676# vss vss sg13_hv_nmos ad=2.596p pd=5.58u as=1.408p ps=5.04u w=4.4u l=0.6u
M9 vss P2/a_5044_1676# cks vss sg13_hv_nmos ad=2.068p pd=9.74u as=2.596p ps=5.58u w=4.4u l=0.6u
M10 cks P2/a_5044_13476# P2/iovdd_uq0 P2/iovdd_uq0 sg13_hv_pmos ad=3.9294p pd=7.84u as=2.1312p ps=7.3u w=6.66u l=0.6u
X11 P2/a_5044_13476# P2/iovdd_uq0 P2/iovdd_uq0 P2/rppd l=12.9u w=0.5u
M12 vss P2/a_5044_1676# cks vss sg13_hv_nmos ad=1.408p pd=5.04u as=2.596p ps=5.58u w=4.4u l=0.6u
M13 cks P2/a_5044_13476# P2/iovdd_uq0 P2/iovdd_uq0 sg13_hv_pmos ad=3.9294p pd=7.84u as=2.1312p ps=7.3u w=6.66u l=0.6u
X14 vss P2/a_5222_4862# P2/dantenna P2/l=1.26u w=27.78u
M15 vss P2/a_5044_1676# cks vss sg13_hv_nmos ad=1.408p pd=5.04u as=2.596p ps=5.58u w=4.4u l=0.6u
M16 cks P2/a_5044_1676# vss vss sg13_hv_nmos ad=2.596p pd=5.58u as=1.408p ps=5.04u w=4.4u l=0.6u
M17 vss P2/a_5044_1676# cks vss sg13_hv_nmos ad=1.408p pd=5.04u as=2.596p ps=5.58u w=4.4u l=0.6u
M18 P2/iovdd_uq0 P2/a_5044_13476# cks P2/iovdd_uq0 sg13_hv_pmos ad=2.1312p pd=7.3u as=3.9294p ps=7.84u w=6.66u l=0.6u
M19 cks P2/a_5044_1676# vss vss sg13_hv_nmos ad=2.596p pd=5.58u as=1.408p ps=5.04u w=4.4u l=0.6u
M20 cks P2/a_5044_13476# P2/iovdd_uq0 P2/iovdd_uq0 sg13_hv_pmos ad=3.9294p pd=7.84u as=2.1312p ps=7.3u w=6.66u l=0.6u
M21 P2/iovdd_uq0 P2/a_5044_13476# cks P2/iovdd_uq0 sg13_hv_pmos ad=2.1312p pd=7.3u as=3.9294p ps=7.84u w=6.66u l=0.6u
M22 cks P2/a_5044_13476# P2/iovdd_uq0 P2/iovdd_uq0 sg13_hv_pmos ad=3.9294p pd=7.84u as=2.1312p ps=7.3u w=6.66u l=0.6u
M23 cks P2/a_5044_13476# P2/iovdd_uq0 P2/iovdd_uq0 sg13_hv_pmos ad=3.9294p pd=7.84u as=2.1312p ps=7.3u w=6.66u l=0.6u
M24 vss P2/a_5044_1676# cks vss sg13_hv_nmos ad=1.408p pd=5.04u as=2.596p ps=5.58u w=4.4u l=0.6u
X25 _cks P2/iovdd P2/dpantenna P2/l=0.64u w=4.98u
M26 P2/iovdd_uq0 P2/a_5044_13476# cks P2/iovdd_uq0 sg13_hv_pmos ad=2.1312p pd=7.3u as=3.9294p ps=7.84u w=6.66u l=0.6u
M27 cks P2/a_5044_13476# P2/iovdd_uq0 P2/iovdd_uq0 sg13_hv_pmos ad=3.9294p pd=7.84u as=2.1312p ps=7.3u w=6.66u l=0.6u
M28 cks P2/a_5044_13476# P2/iovdd_uq0 P2/iovdd_uq0 sg13_hv_pmos ad=3.9294p pd=7.84u as=2.1312p ps=7.3u w=6.66u l=0.6u
M29 cks P2/a_5044_1676# vss vss sg13_hv_nmos ad=2.596p pd=5.58u as=1.408p ps=5.04u w=4.4u l=0.6u
M30 P2/iovdd_uq0 P2/a_5044_13476# cks P2/iovdd_uq0 sg13_hv_pmos ad=2.1312p pd=7.3u as=3.9294p ps=7.84u w=6.66u l=0.6u
X31 _cks cks vss P2/rppd l=2u w=1u
M32 P2/iovdd_uq0 P2/a_5044_13476# cks P2/iovdd_uq0 sg13_hv_pmos ad=2.1312p pd=7.3u as=3.9294p ps=7.84u w=6.66u l=0.6u
M33 P2/iovdd_uq0 P2/a_5044_13476# cks P2/iovdd_uq0 sg13_hv_pmos ad=2.1312p pd=7.3u as=3.9294p ps=7.84u w=6.66u l=0.6u
M34 cks P2/a_5044_13476# P2/iovdd_uq0 P2/iovdd_uq0 sg13_hv_pmos ad=3.9294p pd=7.84u as=2.1312p ps=7.3u w=6.66u l=0.6u
M35 cks P2/a_5044_1676# vss vss sg13_hv_nmos ad=2.596p pd=5.58u as=1.408p ps=5.04u w=4.4u l=0.6u
M36 vss P2/a_5044_1676# cks vss sg13_hv_nmos ad=1.408p pd=5.04u as=2.596p ps=5.58u w=4.4u l=0.6u
M37 cks P2/a_5044_1676# vss vss sg13_hv_nmos ad=2.596p pd=5.58u as=1.408p ps=5.04u w=4.4u l=0.6u
M38 P2/iovdd_uq0 P2/a_5044_13476# cks P2/iovdd_uq0 sg13_hv_pmos ad=2.1312p pd=7.3u as=3.9294p ps=7.84u w=6.66u l=0.6u
M39 cks P2/a_5044_13476# P2/iovdd_uq0 P2/iovdd_uq0 sg13_hv_pmos ad=3.9294p pd=7.84u as=2.1312p ps=7.3u w=6.66u l=0.6u
X40 cks P2/iovdd_uq0 P2/dpantenna P2/l=1.26u w=27.78u
M41 vss P2/a_5044_1676# cks vss sg13_hv_nmos ad=1.408p pd=5.04u as=2.596p ps=5.58u w=4.4u l=0.6u
M42 P2/iovdd_uq0 P2/a_5044_13476# cks P2/iovdd_uq0 sg13_hv_pmos ad=2.1312p pd=7.3u as=3.9294p ps=7.84u w=6.66u l=0.6u
M43 vss P2/a_5044_1676# cks vss sg13_hv_nmos ad=1.408p pd=5.04u as=2.596p ps=5.58u w=4.4u l=0.6u
M44 cks P2/a_5044_13476# P2/iovdd_uq0 P2/iovdd_uq0 sg13_hv_pmos ad=3.9294p pd=7.84u as=2.1312p ps=7.3u w=6.66u l=0.6u
M45 P2/iovdd_uq0 P2/a_5044_13476# cks P2/iovdd_uq0 sg13_hv_pmos ad=2.1312p pd=7.3u as=3.9294p ps=7.84u w=6.66u l=0.6u
M46 cks P2/a_5044_13476# P2/iovdd_uq0 P2/iovdd_uq0 sg13_hv_pmos ad=3.9294p pd=7.84u as=2.1312p ps=7.3u w=6.66u l=0.6u
M47 cks P2/a_5044_1676# vss vss sg13_hv_nmos ad=2.596p pd=5.58u as=1.408p ps=5.04u w=4.4u l=0.6u
M48 vss P2/a_5044_1676# cks vss sg13_hv_nmos ad=1.408p pd=5.04u as=2.596p ps=5.58u w=4.4u l=0.6u
M49 cks P2/a_5044_13476# P2/iovdd_uq0 P2/iovdd_uq0 sg13_hv_pmos ad=3.9294p pd=7.84u as=3.1302p ps=14.26u w=6.66u l=0.6u
M50 P2/iovdd_uq0 P2/a_5044_13476# cks P2/iovdd_uq0 sg13_hv_pmos ad=3.1302p pd=14.26u as=3.9294p ps=7.84u w=6.66u l=0.6u
M51 P2/iovdd_uq0 P2/a_5044_13476# cks P2/iovdd_uq0 sg13_hv_pmos ad=2.1312p pd=7.3u as=3.9294p ps=7.84u w=6.66u l=0.6u
M52 cks P2/a_5044_13476# P2/iovdd_uq0 P2/iovdd_uq0 sg13_hv_pmos ad=3.9294p pd=7.84u as=2.1312p ps=7.3u w=6.66u l=0.6u
X53 cks P2/iovdd_uq0 P2/dpantenna P2/l=1.26u w=27.78u
M54 cks P2/a_5044_13476# P2/iovdd_uq0 P2/iovdd_uq0 sg13_hv_pmos ad=3.9294p pd=7.84u as=3.1302p ps=14.26u w=6.66u l=0.6u
M55 P2/iovdd_uq0 P2/a_5044_13476# cks P2/iovdd_uq0 sg13_hv_pmos ad=3.1302p pd=14.26u as=3.9294p ps=7.84u w=6.66u l=0.6u
M56 P2/iovdd_uq0 P2/a_5044_13476# cks P2/iovdd_uq0 sg13_hv_pmos ad=2.1312p pd=7.3u as=3.9294p ps=7.84u w=6.66u l=0.6u
M57 cks P2/a_5044_13476# P2/iovdd_uq0 P2/iovdd_uq0 sg13_hv_pmos ad=3.9294p pd=7.84u as=2.1312p ps=7.3u w=6.66u l=0.6u
X58 vss P2/a_11462_28198# P2/dantenna P2/l=3.1u w=0.64u
X59 vss P2/a_5222_3962# P2/dantenna P2/l=1.26u w=27.78u
X60 P2/a_5044_1676# vss vss P2/rppd l=3.54u w=0.5u
M61 P2/iovdd_uq0 P2/a_5044_13476# cks P2/iovdd_uq0 sg13_hv_pmos ad=2.1312p pd=7.3u as=3.9294p ps=7.84u w=6.66u l=0.6u
M62 P2/iovdd_uq0 P2/a_5044_13476# cks P2/iovdd_uq0 sg13_hv_pmos ad=2.1312p pd=7.3u as=3.9294p ps=7.84u w=6.66u l=0.6u
M63 cks P2/a_5044_1676# vss vss sg13_hv_nmos ad=2.596p pd=5.58u as=2.068p ps=9.74u w=4.4u l=0.6u
M64 P2/iovdd_uq0 P2/a_5044_13476# cks P2/iovdd_uq0 sg13_hv_pmos ad=2.1312p pd=7.3u as=3.9294p ps=7.84u w=6.66u l=0.6u
M65 cks P2/a_5044_13476# P2/iovdd_uq0 P2/iovdd_uq0 sg13_hv_pmos ad=3.9294p pd=7.84u as=2.1312p ps=7.3u w=6.66u l=0.6u
M66 cks P2/a_5044_13476# P2/iovdd_uq0 P2/iovdd_uq0 sg13_hv_pmos ad=3.9294p pd=7.84u as=2.1312p ps=7.3u w=6.66u l=0.6u
M67 cks P2/a_5044_13476# P2/iovdd_uq0 P2/iovdd_uq0 sg13_hv_pmos ad=3.9294p pd=7.84u as=2.1312p ps=7.3u w=6.66u l=0.6u
M68 vss P2/a_5044_1676# cks vss sg13_hv_nmos ad=1.408p pd=5.04u as=2.596p ps=5.58u w=4.4u l=0.6u
M0 P3/iovdd_uq0 P3/a_5044_13476# data[0] P3/iovdd_uq0 sg13_hv_pmos ad=2.1312p pd=7.3u as=3.9294p ps=7.84u w=6.66u l=0.6u
M1 data[0] P3/a_5044_1676# vss vss sg13_hv_nmos ad=2.596p pd=5.58u as=1.408p ps=5.04u w=4.4u l=0.6u
M2 data[0] P3/a_5044_13476# P3/iovdd_uq0 P3/iovdd_uq0 sg13_hv_pmos ad=3.9294p pd=7.84u as=2.1312p ps=7.3u w=6.66u l=0.6u
M3 P3/iovdd_uq0 P3/a_5044_13476# data[0] P3/iovdd_uq0 sg13_hv_pmos ad=2.1312p pd=7.3u as=3.9294p ps=7.84u w=6.66u l=0.6u
M4 P3/iovdd_uq0 P3/a_5044_13476# data[0] P3/iovdd_uq0 sg13_hv_pmos ad=2.1312p pd=7.3u as=3.9294p ps=7.84u w=6.66u l=0.6u
M5 data[0] P3/a_5044_1676# vss vss sg13_hv_nmos ad=2.596p pd=5.58u as=1.408p ps=5.04u w=4.4u l=0.6u
M6 data[0] P3/a_5044_13476# P3/iovdd_uq0 P3/iovdd_uq0 sg13_hv_pmos ad=3.9294p pd=7.84u as=2.1312p ps=7.3u w=6.66u l=0.6u
M7 P3/iovdd_uq0 P3/a_5044_13476# data[0] P3/iovdd_uq0 sg13_hv_pmos ad=2.1312p pd=7.3u as=3.9294p ps=7.84u w=6.66u l=0.6u
M8 data[0] P3/a_5044_1676# vss vss sg13_hv_nmos ad=2.596p pd=5.58u as=1.408p ps=5.04u w=4.4u l=0.6u
M9 vss P3/a_5044_1676# data[0] vss sg13_hv_nmos ad=2.068p pd=9.74u as=2.596p ps=5.58u w=4.4u l=0.6u
M10 data[0] P3/a_5044_13476# P3/iovdd_uq0 P3/iovdd_uq0 sg13_hv_pmos ad=3.9294p pd=7.84u as=2.1312p ps=7.3u w=6.66u l=0.6u
X11 P3/a_5044_13476# P3/iovdd_uq0 P3/iovdd_uq0 P3/rppd l=12.9u w=0.5u
M12 vss P3/a_5044_1676# data[0] vss sg13_hv_nmos ad=1.408p pd=5.04u as=2.596p ps=5.58u w=4.4u l=0.6u
M13 data[0] P3/a_5044_13476# P3/iovdd_uq0 P3/iovdd_uq0 sg13_hv_pmos ad=3.9294p pd=7.84u as=2.1312p ps=7.3u w=6.66u l=0.6u
X14 vss P3/a_5222_4862# P3/dantenna P3/l=1.26u w=27.78u
M15 vss P3/a_5044_1676# data[0] vss sg13_hv_nmos ad=1.408p pd=5.04u as=2.596p ps=5.58u w=4.4u l=0.6u
M16 data[0] P3/a_5044_1676# vss vss sg13_hv_nmos ad=2.596p pd=5.58u as=1.408p ps=5.04u w=4.4u l=0.6u
M17 vss P3/a_5044_1676# data[0] vss sg13_hv_nmos ad=1.408p pd=5.04u as=2.596p ps=5.58u w=4.4u l=0.6u
M18 P3/iovdd_uq0 P3/a_5044_13476# data[0] P3/iovdd_uq0 sg13_hv_pmos ad=2.1312p pd=7.3u as=3.9294p ps=7.84u w=6.66u l=0.6u
M19 data[0] P3/a_5044_1676# vss vss sg13_hv_nmos ad=2.596p pd=5.58u as=1.408p ps=5.04u w=4.4u l=0.6u
M20 data[0] P3/a_5044_13476# P3/iovdd_uq0 P3/iovdd_uq0 sg13_hv_pmos ad=3.9294p pd=7.84u as=2.1312p ps=7.3u w=6.66u l=0.6u
M21 P3/iovdd_uq0 P3/a_5044_13476# data[0] P3/iovdd_uq0 sg13_hv_pmos ad=2.1312p pd=7.3u as=3.9294p ps=7.84u w=6.66u l=0.6u
M22 data[0] P3/a_5044_13476# P3/iovdd_uq0 P3/iovdd_uq0 sg13_hv_pmos ad=3.9294p pd=7.84u as=2.1312p ps=7.3u w=6.66u l=0.6u
M23 data[0] P3/a_5044_13476# P3/iovdd_uq0 P3/iovdd_uq0 sg13_hv_pmos ad=3.9294p pd=7.84u as=2.1312p ps=7.3u w=6.66u l=0.6u
M24 vss P3/a_5044_1676# data[0] vss sg13_hv_nmos ad=1.408p pd=5.04u as=2.596p ps=5.58u w=4.4u l=0.6u
X25 _d0 P3/iovdd P3/dpantenna P3/l=0.64u w=4.98u
M26 P3/iovdd_uq0 P3/a_5044_13476# data[0] P3/iovdd_uq0 sg13_hv_pmos ad=2.1312p pd=7.3u as=3.9294p ps=7.84u w=6.66u l=0.6u
M27 data[0] P3/a_5044_13476# P3/iovdd_uq0 P3/iovdd_uq0 sg13_hv_pmos ad=3.9294p pd=7.84u as=2.1312p ps=7.3u w=6.66u l=0.6u
M28 data[0] P3/a_5044_13476# P3/iovdd_uq0 P3/iovdd_uq0 sg13_hv_pmos ad=3.9294p pd=7.84u as=2.1312p ps=7.3u w=6.66u l=0.6u
M29 data[0] P3/a_5044_1676# vss vss sg13_hv_nmos ad=2.596p pd=5.58u as=1.408p ps=5.04u w=4.4u l=0.6u
M30 P3/iovdd_uq0 P3/a_5044_13476# data[0] P3/iovdd_uq0 sg13_hv_pmos ad=2.1312p pd=7.3u as=3.9294p ps=7.84u w=6.66u l=0.6u
X31 _d0 data[0] vss P3/rppd l=2u w=1u
M32 P3/iovdd_uq0 P3/a_5044_13476# data[0] P3/iovdd_uq0 sg13_hv_pmos ad=2.1312p pd=7.3u as=3.9294p ps=7.84u w=6.66u l=0.6u
M33 P3/iovdd_uq0 P3/a_5044_13476# data[0] P3/iovdd_uq0 sg13_hv_pmos ad=2.1312p pd=7.3u as=3.9294p ps=7.84u w=6.66u l=0.6u
M34 data[0] P3/a_5044_13476# P3/iovdd_uq0 P3/iovdd_uq0 sg13_hv_pmos ad=3.9294p pd=7.84u as=2.1312p ps=7.3u w=6.66u l=0.6u
M35 data[0] P3/a_5044_1676# vss vss sg13_hv_nmos ad=2.596p pd=5.58u as=1.408p ps=5.04u w=4.4u l=0.6u
M36 vss P3/a_5044_1676# data[0] vss sg13_hv_nmos ad=1.408p pd=5.04u as=2.596p ps=5.58u w=4.4u l=0.6u
M37 data[0] P3/a_5044_1676# vss vss sg13_hv_nmos ad=2.596p pd=5.58u as=1.408p ps=5.04u w=4.4u l=0.6u
M38 P3/iovdd_uq0 P3/a_5044_13476# data[0] P3/iovdd_uq0 sg13_hv_pmos ad=2.1312p pd=7.3u as=3.9294p ps=7.84u w=6.66u l=0.6u
M39 data[0] P3/a_5044_13476# P3/iovdd_uq0 P3/iovdd_uq0 sg13_hv_pmos ad=3.9294p pd=7.84u as=2.1312p ps=7.3u w=6.66u l=0.6u
X40 data[0] P3/iovdd_uq0 P3/dpantenna P3/l=1.26u w=27.78u
M41 vss P3/a_5044_1676# data[0] vss sg13_hv_nmos ad=1.408p pd=5.04u as=2.596p ps=5.58u w=4.4u l=0.6u
M42 P3/iovdd_uq0 P3/a_5044_13476# data[0] P3/iovdd_uq0 sg13_hv_pmos ad=2.1312p pd=7.3u as=3.9294p ps=7.84u w=6.66u l=0.6u
M43 vss P3/a_5044_1676# data[0] vss sg13_hv_nmos ad=1.408p pd=5.04u as=2.596p ps=5.58u w=4.4u l=0.6u
M44 data[0] P3/a_5044_13476# P3/iovdd_uq0 P3/iovdd_uq0 sg13_hv_pmos ad=3.9294p pd=7.84u as=2.1312p ps=7.3u w=6.66u l=0.6u
M45 P3/iovdd_uq0 P3/a_5044_13476# data[0] P3/iovdd_uq0 sg13_hv_pmos ad=2.1312p pd=7.3u as=3.9294p ps=7.84u w=6.66u l=0.6u
M46 data[0] P3/a_5044_13476# P3/iovdd_uq0 P3/iovdd_uq0 sg13_hv_pmos ad=3.9294p pd=7.84u as=2.1312p ps=7.3u w=6.66u l=0.6u
M47 data[0] P3/a_5044_1676# vss vss sg13_hv_nmos ad=2.596p pd=5.58u as=1.408p ps=5.04u w=4.4u l=0.6u
M48 vss P3/a_5044_1676# data[0] vss sg13_hv_nmos ad=1.408p pd=5.04u as=2.596p ps=5.58u w=4.4u l=0.6u
M49 data[0] P3/a_5044_13476# P3/iovdd_uq0 P3/iovdd_uq0 sg13_hv_pmos ad=3.9294p pd=7.84u as=3.1302p ps=14.26u w=6.66u l=0.6u
M50 P3/iovdd_uq0 P3/a_5044_13476# data[0] P3/iovdd_uq0 sg13_hv_pmos ad=3.1302p pd=14.26u as=3.9294p ps=7.84u w=6.66u l=0.6u
M51 P3/iovdd_uq0 P3/a_5044_13476# data[0] P3/iovdd_uq0 sg13_hv_pmos ad=2.1312p pd=7.3u as=3.9294p ps=7.84u w=6.66u l=0.6u
M52 data[0] P3/a_5044_13476# P3/iovdd_uq0 P3/iovdd_uq0 sg13_hv_pmos ad=3.9294p pd=7.84u as=2.1312p ps=7.3u w=6.66u l=0.6u
X53 data[0] P3/iovdd_uq0 P3/dpantenna P3/l=1.26u w=27.78u
M54 data[0] P3/a_5044_13476# P3/iovdd_uq0 P3/iovdd_uq0 sg13_hv_pmos ad=3.9294p pd=7.84u as=3.1302p ps=14.26u w=6.66u l=0.6u
M55 P3/iovdd_uq0 P3/a_5044_13476# data[0] P3/iovdd_uq0 sg13_hv_pmos ad=3.1302p pd=14.26u as=3.9294p ps=7.84u w=6.66u l=0.6u
M56 P3/iovdd_uq0 P3/a_5044_13476# data[0] P3/iovdd_uq0 sg13_hv_pmos ad=2.1312p pd=7.3u as=3.9294p ps=7.84u w=6.66u l=0.6u
M57 data[0] P3/a_5044_13476# P3/iovdd_uq0 P3/iovdd_uq0 sg13_hv_pmos ad=3.9294p pd=7.84u as=2.1312p ps=7.3u w=6.66u l=0.6u
X58 vss P3/a_11462_28198# P3/dantenna P3/l=3.1u w=0.64u
X59 vss P3/a_5222_3962# P3/dantenna P3/l=1.26u w=27.78u
X60 P3/a_5044_1676# vss vss P3/rppd l=3.54u w=0.5u
M61 P3/iovdd_uq0 P3/a_5044_13476# data[0] P3/iovdd_uq0 sg13_hv_pmos ad=2.1312p pd=7.3u as=3.9294p ps=7.84u w=6.66u l=0.6u
M62 P3/iovdd_uq0 P3/a_5044_13476# data[0] P3/iovdd_uq0 sg13_hv_pmos ad=2.1312p pd=7.3u as=3.9294p ps=7.84u w=6.66u l=0.6u
M63 data[0] P3/a_5044_1676# vss vss sg13_hv_nmos ad=2.596p pd=5.58u as=2.068p ps=9.74u w=4.4u l=0.6u
M64 P3/iovdd_uq0 P3/a_5044_13476# data[0] P3/iovdd_uq0 sg13_hv_pmos ad=2.1312p pd=7.3u as=3.9294p ps=7.84u w=6.66u l=0.6u
M65 data[0] P3/a_5044_13476# P3/iovdd_uq0 P3/iovdd_uq0 sg13_hv_pmos ad=3.9294p pd=7.84u as=2.1312p ps=7.3u w=6.66u l=0.6u
M66 data[0] P3/a_5044_13476# P3/iovdd_uq0 P3/iovdd_uq0 sg13_hv_pmos ad=3.9294p pd=7.84u as=2.1312p ps=7.3u w=6.66u l=0.6u
M67 data[0] P3/a_5044_13476# P3/iovdd_uq0 P3/iovdd_uq0 sg13_hv_pmos ad=3.9294p pd=7.84u as=2.1312p ps=7.3u w=6.66u l=0.6u
M68 vss P3/a_5044_1676# data[0] vss sg13_hv_nmos ad=1.408p pd=5.04u as=2.596p ps=5.58u w=4.4u l=0.6u
M0 P4/iovdd_uq0 P4/a_5044_13476# data[1] P4/iovdd_uq0 sg13_hv_pmos ad=2.1312p pd=7.3u as=3.9294p ps=7.84u w=6.66u l=0.6u
M1 data[1] P4/a_5044_1676# vss vss sg13_hv_nmos ad=2.596p pd=5.58u as=1.408p ps=5.04u w=4.4u l=0.6u
M2 data[1] P4/a_5044_13476# P4/iovdd_uq0 P4/iovdd_uq0 sg13_hv_pmos ad=3.9294p pd=7.84u as=2.1312p ps=7.3u w=6.66u l=0.6u
M3 P4/iovdd_uq0 P4/a_5044_13476# data[1] P4/iovdd_uq0 sg13_hv_pmos ad=2.1312p pd=7.3u as=3.9294p ps=7.84u w=6.66u l=0.6u
M4 P4/iovdd_uq0 P4/a_5044_13476# data[1] P4/iovdd_uq0 sg13_hv_pmos ad=2.1312p pd=7.3u as=3.9294p ps=7.84u w=6.66u l=0.6u
M5 data[1] P4/a_5044_1676# vss vss sg13_hv_nmos ad=2.596p pd=5.58u as=1.408p ps=5.04u w=4.4u l=0.6u
M6 data[1] P4/a_5044_13476# P4/iovdd_uq0 P4/iovdd_uq0 sg13_hv_pmos ad=3.9294p pd=7.84u as=2.1312p ps=7.3u w=6.66u l=0.6u
M7 P4/iovdd_uq0 P4/a_5044_13476# data[1] P4/iovdd_uq0 sg13_hv_pmos ad=2.1312p pd=7.3u as=3.9294p ps=7.84u w=6.66u l=0.6u
M8 data[1] P4/a_5044_1676# vss vss sg13_hv_nmos ad=2.596p pd=5.58u as=1.408p ps=5.04u w=4.4u l=0.6u
M9 vss P4/a_5044_1676# data[1] vss sg13_hv_nmos ad=2.068p pd=9.74u as=2.596p ps=5.58u w=4.4u l=0.6u
M10 data[1] P4/a_5044_13476# P4/iovdd_uq0 P4/iovdd_uq0 sg13_hv_pmos ad=3.9294p pd=7.84u as=2.1312p ps=7.3u w=6.66u l=0.6u
X11 P4/a_5044_13476# P4/iovdd_uq0 P4/iovdd_uq0 P4/rppd l=12.9u w=0.5u
M12 vss P4/a_5044_1676# data[1] vss sg13_hv_nmos ad=1.408p pd=5.04u as=2.596p ps=5.58u w=4.4u l=0.6u
M13 data[1] P4/a_5044_13476# P4/iovdd_uq0 P4/iovdd_uq0 sg13_hv_pmos ad=3.9294p pd=7.84u as=2.1312p ps=7.3u w=6.66u l=0.6u
X14 vss P4/a_5222_4862# P4/dantenna P4/l=1.26u w=27.78u
M15 vss P4/a_5044_1676# data[1] vss sg13_hv_nmos ad=1.408p pd=5.04u as=2.596p ps=5.58u w=4.4u l=0.6u
M16 data[1] P4/a_5044_1676# vss vss sg13_hv_nmos ad=2.596p pd=5.58u as=1.408p ps=5.04u w=4.4u l=0.6u
M17 vss P4/a_5044_1676# data[1] vss sg13_hv_nmos ad=1.408p pd=5.04u as=2.596p ps=5.58u w=4.4u l=0.6u
M18 P4/iovdd_uq0 P4/a_5044_13476# data[1] P4/iovdd_uq0 sg13_hv_pmos ad=2.1312p pd=7.3u as=3.9294p ps=7.84u w=6.66u l=0.6u
M19 data[1] P4/a_5044_1676# vss vss sg13_hv_nmos ad=2.596p pd=5.58u as=1.408p ps=5.04u w=4.4u l=0.6u
M20 data[1] P4/a_5044_13476# P4/iovdd_uq0 P4/iovdd_uq0 sg13_hv_pmos ad=3.9294p pd=7.84u as=2.1312p ps=7.3u w=6.66u l=0.6u
M21 P4/iovdd_uq0 P4/a_5044_13476# data[1] P4/iovdd_uq0 sg13_hv_pmos ad=2.1312p pd=7.3u as=3.9294p ps=7.84u w=6.66u l=0.6u
M22 data[1] P4/a_5044_13476# P4/iovdd_uq0 P4/iovdd_uq0 sg13_hv_pmos ad=3.9294p pd=7.84u as=2.1312p ps=7.3u w=6.66u l=0.6u
M23 data[1] P4/a_5044_13476# P4/iovdd_uq0 P4/iovdd_uq0 sg13_hv_pmos ad=3.9294p pd=7.84u as=2.1312p ps=7.3u w=6.66u l=0.6u
M24 vss P4/a_5044_1676# data[1] vss sg13_hv_nmos ad=1.408p pd=5.04u as=2.596p ps=5.58u w=4.4u l=0.6u
X25 _d1 P4/iovdd P4/dpantenna P4/l=0.64u w=4.98u
M26 P4/iovdd_uq0 P4/a_5044_13476# data[1] P4/iovdd_uq0 sg13_hv_pmos ad=2.1312p pd=7.3u as=3.9294p ps=7.84u w=6.66u l=0.6u
M27 data[1] P4/a_5044_13476# P4/iovdd_uq0 P4/iovdd_uq0 sg13_hv_pmos ad=3.9294p pd=7.84u as=2.1312p ps=7.3u w=6.66u l=0.6u
M28 data[1] P4/a_5044_13476# P4/iovdd_uq0 P4/iovdd_uq0 sg13_hv_pmos ad=3.9294p pd=7.84u as=2.1312p ps=7.3u w=6.66u l=0.6u
M29 data[1] P4/a_5044_1676# vss vss sg13_hv_nmos ad=2.596p pd=5.58u as=1.408p ps=5.04u w=4.4u l=0.6u
M30 P4/iovdd_uq0 P4/a_5044_13476# data[1] P4/iovdd_uq0 sg13_hv_pmos ad=2.1312p pd=7.3u as=3.9294p ps=7.84u w=6.66u l=0.6u
X31 _d1 data[1] vss P4/rppd l=2u w=1u
M32 P4/iovdd_uq0 P4/a_5044_13476# data[1] P4/iovdd_uq0 sg13_hv_pmos ad=2.1312p pd=7.3u as=3.9294p ps=7.84u w=6.66u l=0.6u
M33 P4/iovdd_uq0 P4/a_5044_13476# data[1] P4/iovdd_uq0 sg13_hv_pmos ad=2.1312p pd=7.3u as=3.9294p ps=7.84u w=6.66u l=0.6u
M34 data[1] P4/a_5044_13476# P4/iovdd_uq0 P4/iovdd_uq0 sg13_hv_pmos ad=3.9294p pd=7.84u as=2.1312p ps=7.3u w=6.66u l=0.6u
M35 data[1] P4/a_5044_1676# vss vss sg13_hv_nmos ad=2.596p pd=5.58u as=1.408p ps=5.04u w=4.4u l=0.6u
M36 vss P4/a_5044_1676# data[1] vss sg13_hv_nmos ad=1.408p pd=5.04u as=2.596p ps=5.58u w=4.4u l=0.6u
M37 data[1] P4/a_5044_1676# vss vss sg13_hv_nmos ad=2.596p pd=5.58u as=1.408p ps=5.04u w=4.4u l=0.6u
M38 P4/iovdd_uq0 P4/a_5044_13476# data[1] P4/iovdd_uq0 sg13_hv_pmos ad=2.1312p pd=7.3u as=3.9294p ps=7.84u w=6.66u l=0.6u
M39 data[1] P4/a_5044_13476# P4/iovdd_uq0 P4/iovdd_uq0 sg13_hv_pmos ad=3.9294p pd=7.84u as=2.1312p ps=7.3u w=6.66u l=0.6u
X40 data[1] P4/iovdd_uq0 P4/dpantenna P4/l=1.26u w=27.78u
M41 vss P4/a_5044_1676# data[1] vss sg13_hv_nmos ad=1.408p pd=5.04u as=2.596p ps=5.58u w=4.4u l=0.6u
M42 P4/iovdd_uq0 P4/a_5044_13476# data[1] P4/iovdd_uq0 sg13_hv_pmos ad=2.1312p pd=7.3u as=3.9294p ps=7.84u w=6.66u l=0.6u
M43 vss P4/a_5044_1676# data[1] vss sg13_hv_nmos ad=1.408p pd=5.04u as=2.596p ps=5.58u w=4.4u l=0.6u
M44 data[1] P4/a_5044_13476# P4/iovdd_uq0 P4/iovdd_uq0 sg13_hv_pmos ad=3.9294p pd=7.84u as=2.1312p ps=7.3u w=6.66u l=0.6u
M45 P4/iovdd_uq0 P4/a_5044_13476# data[1] P4/iovdd_uq0 sg13_hv_pmos ad=2.1312p pd=7.3u as=3.9294p ps=7.84u w=6.66u l=0.6u
M46 data[1] P4/a_5044_13476# P4/iovdd_uq0 P4/iovdd_uq0 sg13_hv_pmos ad=3.9294p pd=7.84u as=2.1312p ps=7.3u w=6.66u l=0.6u
M47 data[1] P4/a_5044_1676# vss vss sg13_hv_nmos ad=2.596p pd=5.58u as=1.408p ps=5.04u w=4.4u l=0.6u
M48 vss P4/a_5044_1676# data[1] vss sg13_hv_nmos ad=1.408p pd=5.04u as=2.596p ps=5.58u w=4.4u l=0.6u
M49 data[1] P4/a_5044_13476# P4/iovdd_uq0 P4/iovdd_uq0 sg13_hv_pmos ad=3.9294p pd=7.84u as=3.1302p ps=14.26u w=6.66u l=0.6u
M50 P4/iovdd_uq0 P4/a_5044_13476# data[1] P4/iovdd_uq0 sg13_hv_pmos ad=3.1302p pd=14.26u as=3.9294p ps=7.84u w=6.66u l=0.6u
M51 P4/iovdd_uq0 P4/a_5044_13476# data[1] P4/iovdd_uq0 sg13_hv_pmos ad=2.1312p pd=7.3u as=3.9294p ps=7.84u w=6.66u l=0.6u
M52 data[1] P4/a_5044_13476# P4/iovdd_uq0 P4/iovdd_uq0 sg13_hv_pmos ad=3.9294p pd=7.84u as=2.1312p ps=7.3u w=6.66u l=0.6u
X53 data[1] P4/iovdd_uq0 P4/dpantenna P4/l=1.26u w=27.78u
M54 data[1] P4/a_5044_13476# P4/iovdd_uq0 P4/iovdd_uq0 sg13_hv_pmos ad=3.9294p pd=7.84u as=3.1302p ps=14.26u w=6.66u l=0.6u
M55 P4/iovdd_uq0 P4/a_5044_13476# data[1] P4/iovdd_uq0 sg13_hv_pmos ad=3.1302p pd=14.26u as=3.9294p ps=7.84u w=6.66u l=0.6u
M56 P4/iovdd_uq0 P4/a_5044_13476# data[1] P4/iovdd_uq0 sg13_hv_pmos ad=2.1312p pd=7.3u as=3.9294p ps=7.84u w=6.66u l=0.6u
M57 data[1] P4/a_5044_13476# P4/iovdd_uq0 P4/iovdd_uq0 sg13_hv_pmos ad=3.9294p pd=7.84u as=2.1312p ps=7.3u w=6.66u l=0.6u
X58 vss P4/a_11462_28198# P4/dantenna P4/l=3.1u w=0.64u
X59 vss P4/a_5222_3962# P4/dantenna P4/l=1.26u w=27.78u
X60 P4/a_5044_1676# vss vss P4/rppd l=3.54u w=0.5u
M61 P4/iovdd_uq0 P4/a_5044_13476# data[1] P4/iovdd_uq0 sg13_hv_pmos ad=2.1312p pd=7.3u as=3.9294p ps=7.84u w=6.66u l=0.6u
M62 P4/iovdd_uq0 P4/a_5044_13476# data[1] P4/iovdd_uq0 sg13_hv_pmos ad=2.1312p pd=7.3u as=3.9294p ps=7.84u w=6.66u l=0.6u
M63 data[1] P4/a_5044_1676# vss vss sg13_hv_nmos ad=2.596p pd=5.58u as=2.068p ps=9.74u w=4.4u l=0.6u
M64 P4/iovdd_uq0 P4/a_5044_13476# data[1] P4/iovdd_uq0 sg13_hv_pmos ad=2.1312p pd=7.3u as=3.9294p ps=7.84u w=6.66u l=0.6u
M65 data[1] P4/a_5044_13476# P4/iovdd_uq0 P4/iovdd_uq0 sg13_hv_pmos ad=3.9294p pd=7.84u as=2.1312p ps=7.3u w=6.66u l=0.6u
M66 data[1] P4/a_5044_13476# P4/iovdd_uq0 P4/iovdd_uq0 sg13_hv_pmos ad=3.9294p pd=7.84u as=2.1312p ps=7.3u w=6.66u l=0.6u
M67 data[1] P4/a_5044_13476# P4/iovdd_uq0 P4/iovdd_uq0 sg13_hv_pmos ad=3.9294p pd=7.84u as=2.1312p ps=7.3u w=6.66u l=0.6u
M68 vss P4/a_5044_1676# data[1] vss sg13_hv_nmos ad=1.408p pd=5.04u as=2.596p ps=5.58u w=4.4u l=0.6u
M0 P5/iovdd_uq0 P5/a_5044_13476# data[2] P5/iovdd_uq0 sg13_hv_pmos ad=2.1312p pd=7.3u as=3.9294p ps=7.84u w=6.66u l=0.6u
M1 data[2] P5/a_5044_1676# vss vss sg13_hv_nmos ad=2.596p pd=5.58u as=1.408p ps=5.04u w=4.4u l=0.6u
M2 data[2] P5/a_5044_13476# P5/iovdd_uq0 P5/iovdd_uq0 sg13_hv_pmos ad=3.9294p pd=7.84u as=2.1312p ps=7.3u w=6.66u l=0.6u
M3 P5/iovdd_uq0 P5/a_5044_13476# data[2] P5/iovdd_uq0 sg13_hv_pmos ad=2.1312p pd=7.3u as=3.9294p ps=7.84u w=6.66u l=0.6u
M4 P5/iovdd_uq0 P5/a_5044_13476# data[2] P5/iovdd_uq0 sg13_hv_pmos ad=2.1312p pd=7.3u as=3.9294p ps=7.84u w=6.66u l=0.6u
M5 data[2] P5/a_5044_1676# vss vss sg13_hv_nmos ad=2.596p pd=5.58u as=1.408p ps=5.04u w=4.4u l=0.6u
M6 data[2] P5/a_5044_13476# P5/iovdd_uq0 P5/iovdd_uq0 sg13_hv_pmos ad=3.9294p pd=7.84u as=2.1312p ps=7.3u w=6.66u l=0.6u
M7 P5/iovdd_uq0 P5/a_5044_13476# data[2] P5/iovdd_uq0 sg13_hv_pmos ad=2.1312p pd=7.3u as=3.9294p ps=7.84u w=6.66u l=0.6u
M8 data[2] P5/a_5044_1676# vss vss sg13_hv_nmos ad=2.596p pd=5.58u as=1.408p ps=5.04u w=4.4u l=0.6u
M9 vss P5/a_5044_1676# data[2] vss sg13_hv_nmos ad=2.068p pd=9.74u as=2.596p ps=5.58u w=4.4u l=0.6u
M10 data[2] P5/a_5044_13476# P5/iovdd_uq0 P5/iovdd_uq0 sg13_hv_pmos ad=3.9294p pd=7.84u as=2.1312p ps=7.3u w=6.66u l=0.6u
X11 P5/a_5044_13476# P5/iovdd_uq0 P5/iovdd_uq0 P5/rppd l=12.9u w=0.5u
M12 vss P5/a_5044_1676# data[2] vss sg13_hv_nmos ad=1.408p pd=5.04u as=2.596p ps=5.58u w=4.4u l=0.6u
M13 data[2] P5/a_5044_13476# P5/iovdd_uq0 P5/iovdd_uq0 sg13_hv_pmos ad=3.9294p pd=7.84u as=2.1312p ps=7.3u w=6.66u l=0.6u
X14 vss P5/a_5222_4862# P5/dantenna P5/l=1.26u w=27.78u
M15 vss P5/a_5044_1676# data[2] vss sg13_hv_nmos ad=1.408p pd=5.04u as=2.596p ps=5.58u w=4.4u l=0.6u
M16 data[2] P5/a_5044_1676# vss vss sg13_hv_nmos ad=2.596p pd=5.58u as=1.408p ps=5.04u w=4.4u l=0.6u
M17 vss P5/a_5044_1676# data[2] vss sg13_hv_nmos ad=1.408p pd=5.04u as=2.596p ps=5.58u w=4.4u l=0.6u
M18 P5/iovdd_uq0 P5/a_5044_13476# data[2] P5/iovdd_uq0 sg13_hv_pmos ad=2.1312p pd=7.3u as=3.9294p ps=7.84u w=6.66u l=0.6u
M19 data[2] P5/a_5044_1676# vss vss sg13_hv_nmos ad=2.596p pd=5.58u as=1.408p ps=5.04u w=4.4u l=0.6u
M20 data[2] P5/a_5044_13476# P5/iovdd_uq0 P5/iovdd_uq0 sg13_hv_pmos ad=3.9294p pd=7.84u as=2.1312p ps=7.3u w=6.66u l=0.6u
M21 P5/iovdd_uq0 P5/a_5044_13476# data[2] P5/iovdd_uq0 sg13_hv_pmos ad=2.1312p pd=7.3u as=3.9294p ps=7.84u w=6.66u l=0.6u
M22 data[2] P5/a_5044_13476# P5/iovdd_uq0 P5/iovdd_uq0 sg13_hv_pmos ad=3.9294p pd=7.84u as=2.1312p ps=7.3u w=6.66u l=0.6u
M23 data[2] P5/a_5044_13476# P5/iovdd_uq0 P5/iovdd_uq0 sg13_hv_pmos ad=3.9294p pd=7.84u as=2.1312p ps=7.3u w=6.66u l=0.6u
M24 vss P5/a_5044_1676# data[2] vss sg13_hv_nmos ad=1.408p pd=5.04u as=2.596p ps=5.58u w=4.4u l=0.6u
X25 _d2 P5/iovdd P5/dpantenna P5/l=0.64u w=4.98u
M26 P5/iovdd_uq0 P5/a_5044_13476# data[2] P5/iovdd_uq0 sg13_hv_pmos ad=2.1312p pd=7.3u as=3.9294p ps=7.84u w=6.66u l=0.6u
M27 data[2] P5/a_5044_13476# P5/iovdd_uq0 P5/iovdd_uq0 sg13_hv_pmos ad=3.9294p pd=7.84u as=2.1312p ps=7.3u w=6.66u l=0.6u
M28 data[2] P5/a_5044_13476# P5/iovdd_uq0 P5/iovdd_uq0 sg13_hv_pmos ad=3.9294p pd=7.84u as=2.1312p ps=7.3u w=6.66u l=0.6u
M29 data[2] P5/a_5044_1676# vss vss sg13_hv_nmos ad=2.596p pd=5.58u as=1.408p ps=5.04u w=4.4u l=0.6u
M30 P5/iovdd_uq0 P5/a_5044_13476# data[2] P5/iovdd_uq0 sg13_hv_pmos ad=2.1312p pd=7.3u as=3.9294p ps=7.84u w=6.66u l=0.6u
X31 _d2 data[2] vss P5/rppd l=2u w=1u
M32 P5/iovdd_uq0 P5/a_5044_13476# data[2] P5/iovdd_uq0 sg13_hv_pmos ad=2.1312p pd=7.3u as=3.9294p ps=7.84u w=6.66u l=0.6u
M33 P5/iovdd_uq0 P5/a_5044_13476# data[2] P5/iovdd_uq0 sg13_hv_pmos ad=2.1312p pd=7.3u as=3.9294p ps=7.84u w=6.66u l=0.6u
M34 data[2] P5/a_5044_13476# P5/iovdd_uq0 P5/iovdd_uq0 sg13_hv_pmos ad=3.9294p pd=7.84u as=2.1312p ps=7.3u w=6.66u l=0.6u
M35 data[2] P5/a_5044_1676# vss vss sg13_hv_nmos ad=2.596p pd=5.58u as=1.408p ps=5.04u w=4.4u l=0.6u
M36 vss P5/a_5044_1676# data[2] vss sg13_hv_nmos ad=1.408p pd=5.04u as=2.596p ps=5.58u w=4.4u l=0.6u
M37 data[2] P5/a_5044_1676# vss vss sg13_hv_nmos ad=2.596p pd=5.58u as=1.408p ps=5.04u w=4.4u l=0.6u
M38 P5/iovdd_uq0 P5/a_5044_13476# data[2] P5/iovdd_uq0 sg13_hv_pmos ad=2.1312p pd=7.3u as=3.9294p ps=7.84u w=6.66u l=0.6u
M39 data[2] P5/a_5044_13476# P5/iovdd_uq0 P5/iovdd_uq0 sg13_hv_pmos ad=3.9294p pd=7.84u as=2.1312p ps=7.3u w=6.66u l=0.6u
X40 data[2] P5/iovdd_uq0 P5/dpantenna P5/l=1.26u w=27.78u
M41 vss P5/a_5044_1676# data[2] vss sg13_hv_nmos ad=1.408p pd=5.04u as=2.596p ps=5.58u w=4.4u l=0.6u
M42 P5/iovdd_uq0 P5/a_5044_13476# data[2] P5/iovdd_uq0 sg13_hv_pmos ad=2.1312p pd=7.3u as=3.9294p ps=7.84u w=6.66u l=0.6u
M43 vss P5/a_5044_1676# data[2] vss sg13_hv_nmos ad=1.408p pd=5.04u as=2.596p ps=5.58u w=4.4u l=0.6u
M44 data[2] P5/a_5044_13476# P5/iovdd_uq0 P5/iovdd_uq0 sg13_hv_pmos ad=3.9294p pd=7.84u as=2.1312p ps=7.3u w=6.66u l=0.6u
M45 P5/iovdd_uq0 P5/a_5044_13476# data[2] P5/iovdd_uq0 sg13_hv_pmos ad=2.1312p pd=7.3u as=3.9294p ps=7.84u w=6.66u l=0.6u
M46 data[2] P5/a_5044_13476# P5/iovdd_uq0 P5/iovdd_uq0 sg13_hv_pmos ad=3.9294p pd=7.84u as=2.1312p ps=7.3u w=6.66u l=0.6u
M47 data[2] P5/a_5044_1676# vss vss sg13_hv_nmos ad=2.596p pd=5.58u as=1.408p ps=5.04u w=4.4u l=0.6u
M48 vss P5/a_5044_1676# data[2] vss sg13_hv_nmos ad=1.408p pd=5.04u as=2.596p ps=5.58u w=4.4u l=0.6u
M49 data[2] P5/a_5044_13476# P5/iovdd_uq0 P5/iovdd_uq0 sg13_hv_pmos ad=3.9294p pd=7.84u as=3.1302p ps=14.26u w=6.66u l=0.6u
M50 P5/iovdd_uq0 P5/a_5044_13476# data[2] P5/iovdd_uq0 sg13_hv_pmos ad=3.1302p pd=14.26u as=3.9294p ps=7.84u w=6.66u l=0.6u
M51 P5/iovdd_uq0 P5/a_5044_13476# data[2] P5/iovdd_uq0 sg13_hv_pmos ad=2.1312p pd=7.3u as=3.9294p ps=7.84u w=6.66u l=0.6u
M52 data[2] P5/a_5044_13476# P5/iovdd_uq0 P5/iovdd_uq0 sg13_hv_pmos ad=3.9294p pd=7.84u as=2.1312p ps=7.3u w=6.66u l=0.6u
X53 data[2] P5/iovdd_uq0 P5/dpantenna P5/l=1.26u w=27.78u
M54 data[2] P5/a_5044_13476# P5/iovdd_uq0 P5/iovdd_uq0 sg13_hv_pmos ad=3.9294p pd=7.84u as=3.1302p ps=14.26u w=6.66u l=0.6u
M55 P5/iovdd_uq0 P5/a_5044_13476# data[2] P5/iovdd_uq0 sg13_hv_pmos ad=3.1302p pd=14.26u as=3.9294p ps=7.84u w=6.66u l=0.6u
M56 P5/iovdd_uq0 P5/a_5044_13476# data[2] P5/iovdd_uq0 sg13_hv_pmos ad=2.1312p pd=7.3u as=3.9294p ps=7.84u w=6.66u l=0.6u
M57 data[2] P5/a_5044_13476# P5/iovdd_uq0 P5/iovdd_uq0 sg13_hv_pmos ad=3.9294p pd=7.84u as=2.1312p ps=7.3u w=6.66u l=0.6u
X58 vss P5/a_11462_28198# P5/dantenna P5/l=3.1u w=0.64u
X59 vss P5/a_5222_3962# P5/dantenna P5/l=1.26u w=27.78u
X60 P5/a_5044_1676# vss vss P5/rppd l=3.54u w=0.5u
M61 P5/iovdd_uq0 P5/a_5044_13476# data[2] P5/iovdd_uq0 sg13_hv_pmos ad=2.1312p pd=7.3u as=3.9294p ps=7.84u w=6.66u l=0.6u
M62 P5/iovdd_uq0 P5/a_5044_13476# data[2] P5/iovdd_uq0 sg13_hv_pmos ad=2.1312p pd=7.3u as=3.9294p ps=7.84u w=6.66u l=0.6u
M63 data[2] P5/a_5044_1676# vss vss sg13_hv_nmos ad=2.596p pd=5.58u as=2.068p ps=9.74u w=4.4u l=0.6u
M64 P5/iovdd_uq0 P5/a_5044_13476# data[2] P5/iovdd_uq0 sg13_hv_pmos ad=2.1312p pd=7.3u as=3.9294p ps=7.84u w=6.66u l=0.6u
M65 data[2] P5/a_5044_13476# P5/iovdd_uq0 P5/iovdd_uq0 sg13_hv_pmos ad=3.9294p pd=7.84u as=2.1312p ps=7.3u w=6.66u l=0.6u
M66 data[2] P5/a_5044_13476# P5/iovdd_uq0 P5/iovdd_uq0 sg13_hv_pmos ad=3.9294p pd=7.84u as=2.1312p ps=7.3u w=6.66u l=0.6u
M67 data[2] P5/a_5044_13476# P5/iovdd_uq0 P5/iovdd_uq0 sg13_hv_pmos ad=3.9294p pd=7.84u as=2.1312p ps=7.3u w=6.66u l=0.6u
M68 vss P5/a_5044_1676# data[2] vss sg13_hv_nmos ad=1.408p pd=5.04u as=2.596p ps=5.58u w=4.4u l=0.6u
M0 P6/iovdd_uq0 P6/a_5044_13476# cko P6/iovdd_uq0 sg13_hv_pmos ad=2.1312p pd=7.3u as=3.9294p ps=7.84u w=6.66u l=0.6u
M1 cko P6/a_5044_1676# vss vss sg13_hv_nmos ad=2.596p pd=5.58u as=1.408p ps=5.04u w=4.4u l=0.6u
M2 cko P6/a_5044_13476# P6/iovdd_uq0 P6/iovdd_uq0 sg13_hv_pmos ad=3.9294p pd=7.84u as=2.1312p ps=7.3u w=6.66u l=0.6u
M3 P6/iovdd_uq0 P6/a_5044_13476# cko P6/iovdd_uq0 sg13_hv_pmos ad=2.1312p pd=7.3u as=3.9294p ps=7.84u w=6.66u l=0.6u
M4 P6/iovdd_uq0 P6/a_5044_13476# cko P6/iovdd_uq0 sg13_hv_pmos ad=2.1312p pd=7.3u as=3.9294p ps=7.84u w=6.66u l=0.6u
M5 cko P6/a_5044_1676# vss vss sg13_hv_nmos ad=2.596p pd=5.58u as=1.408p ps=5.04u w=4.4u l=0.6u
M6 cko P6/a_5044_13476# P6/iovdd_uq0 P6/iovdd_uq0 sg13_hv_pmos ad=3.9294p pd=7.84u as=2.1312p ps=7.3u w=6.66u l=0.6u
M7 P6/iovdd_uq0 P6/a_5044_13476# cko P6/iovdd_uq0 sg13_hv_pmos ad=2.1312p pd=7.3u as=3.9294p ps=7.84u w=6.66u l=0.6u
M8 cko P6/a_5044_1676# vss vss sg13_hv_nmos ad=2.596p pd=5.58u as=1.408p ps=5.04u w=4.4u l=0.6u
M9 vss P6/a_5044_1676# cko vss sg13_hv_nmos ad=2.068p pd=9.74u as=2.596p ps=5.58u w=4.4u l=0.6u
M10 cko P6/a_5044_13476# P6/iovdd_uq0 P6/iovdd_uq0 sg13_hv_pmos ad=3.9294p pd=7.84u as=2.1312p ps=7.3u w=6.66u l=0.6u
X11 P6/a_5044_13476# P6/iovdd_uq0 P6/iovdd_uq0 P6/rppd l=12.9u w=0.5u
M12 vss P6/a_5044_1676# cko vss sg13_hv_nmos ad=1.408p pd=5.04u as=2.596p ps=5.58u w=4.4u l=0.6u
M13 cko P6/a_5044_13476# P6/iovdd_uq0 P6/iovdd_uq0 sg13_hv_pmos ad=3.9294p pd=7.84u as=2.1312p ps=7.3u w=6.66u l=0.6u
X14 vss P6/a_5222_4862# P6/dantenna P6/l=1.26u w=27.78u
M15 vss P6/a_5044_1676# cko vss sg13_hv_nmos ad=1.408p pd=5.04u as=2.596p ps=5.58u w=4.4u l=0.6u
M16 cko P6/a_5044_1676# vss vss sg13_hv_nmos ad=2.596p pd=5.58u as=1.408p ps=5.04u w=4.4u l=0.6u
M17 vss P6/a_5044_1676# cko vss sg13_hv_nmos ad=1.408p pd=5.04u as=2.596p ps=5.58u w=4.4u l=0.6u
M18 P6/iovdd_uq0 P6/a_5044_13476# cko P6/iovdd_uq0 sg13_hv_pmos ad=2.1312p pd=7.3u as=3.9294p ps=7.84u w=6.66u l=0.6u
M19 cko P6/a_5044_1676# vss vss sg13_hv_nmos ad=2.596p pd=5.58u as=1.408p ps=5.04u w=4.4u l=0.6u
M20 cko P6/a_5044_13476# P6/iovdd_uq0 P6/iovdd_uq0 sg13_hv_pmos ad=3.9294p pd=7.84u as=2.1312p ps=7.3u w=6.66u l=0.6u
M21 P6/iovdd_uq0 P6/a_5044_13476# cko P6/iovdd_uq0 sg13_hv_pmos ad=2.1312p pd=7.3u as=3.9294p ps=7.84u w=6.66u l=0.6u
M22 cko P6/a_5044_13476# P6/iovdd_uq0 P6/iovdd_uq0 sg13_hv_pmos ad=3.9294p pd=7.84u as=2.1312p ps=7.3u w=6.66u l=0.6u
M23 cko P6/a_5044_13476# P6/iovdd_uq0 P6/iovdd_uq0 sg13_hv_pmos ad=3.9294p pd=7.84u as=2.1312p ps=7.3u w=6.66u l=0.6u
M24 vss P6/a_5044_1676# cko vss sg13_hv_nmos ad=1.408p pd=5.04u as=2.596p ps=5.58u w=4.4u l=0.6u
X25 _cko P6/iovdd P6/dpantenna P6/l=0.64u w=4.98u
M26 P6/iovdd_uq0 P6/a_5044_13476# cko P6/iovdd_uq0 sg13_hv_pmos ad=2.1312p pd=7.3u as=3.9294p ps=7.84u w=6.66u l=0.6u
M27 cko P6/a_5044_13476# P6/iovdd_uq0 P6/iovdd_uq0 sg13_hv_pmos ad=3.9294p pd=7.84u as=2.1312p ps=7.3u w=6.66u l=0.6u
M28 cko P6/a_5044_13476# P6/iovdd_uq0 P6/iovdd_uq0 sg13_hv_pmos ad=3.9294p pd=7.84u as=2.1312p ps=7.3u w=6.66u l=0.6u
M29 cko P6/a_5044_1676# vss vss sg13_hv_nmos ad=2.596p pd=5.58u as=1.408p ps=5.04u w=4.4u l=0.6u
M30 P6/iovdd_uq0 P6/a_5044_13476# cko P6/iovdd_uq0 sg13_hv_pmos ad=2.1312p pd=7.3u as=3.9294p ps=7.84u w=6.66u l=0.6u
X31 _cko cko vss P6/rppd l=2u w=1u
M32 P6/iovdd_uq0 P6/a_5044_13476# cko P6/iovdd_uq0 sg13_hv_pmos ad=2.1312p pd=7.3u as=3.9294p ps=7.84u w=6.66u l=0.6u
M33 P6/iovdd_uq0 P6/a_5044_13476# cko P6/iovdd_uq0 sg13_hv_pmos ad=2.1312p pd=7.3u as=3.9294p ps=7.84u w=6.66u l=0.6u
M34 cko P6/a_5044_13476# P6/iovdd_uq0 P6/iovdd_uq0 sg13_hv_pmos ad=3.9294p pd=7.84u as=2.1312p ps=7.3u w=6.66u l=0.6u
M35 cko P6/a_5044_1676# vss vss sg13_hv_nmos ad=2.596p pd=5.58u as=1.408p ps=5.04u w=4.4u l=0.6u
M36 vss P6/a_5044_1676# cko vss sg13_hv_nmos ad=1.408p pd=5.04u as=2.596p ps=5.58u w=4.4u l=0.6u
M37 cko P6/a_5044_1676# vss vss sg13_hv_nmos ad=2.596p pd=5.58u as=1.408p ps=5.04u w=4.4u l=0.6u
M38 P6/iovdd_uq0 P6/a_5044_13476# cko P6/iovdd_uq0 sg13_hv_pmos ad=2.1312p pd=7.3u as=3.9294p ps=7.84u w=6.66u l=0.6u
M39 cko P6/a_5044_13476# P6/iovdd_uq0 P6/iovdd_uq0 sg13_hv_pmos ad=3.9294p pd=7.84u as=2.1312p ps=7.3u w=6.66u l=0.6u
X40 cko P6/iovdd_uq0 P6/dpantenna P6/l=1.26u w=27.78u
M41 vss P6/a_5044_1676# cko vss sg13_hv_nmos ad=1.408p pd=5.04u as=2.596p ps=5.58u w=4.4u l=0.6u
M42 P6/iovdd_uq0 P6/a_5044_13476# cko P6/iovdd_uq0 sg13_hv_pmos ad=2.1312p pd=7.3u as=3.9294p ps=7.84u w=6.66u l=0.6u
M43 vss P6/a_5044_1676# cko vss sg13_hv_nmos ad=1.408p pd=5.04u as=2.596p ps=5.58u w=4.4u l=0.6u
M44 cko P6/a_5044_13476# P6/iovdd_uq0 P6/iovdd_uq0 sg13_hv_pmos ad=3.9294p pd=7.84u as=2.1312p ps=7.3u w=6.66u l=0.6u
M45 P6/iovdd_uq0 P6/a_5044_13476# cko P6/iovdd_uq0 sg13_hv_pmos ad=2.1312p pd=7.3u as=3.9294p ps=7.84u w=6.66u l=0.6u
M46 cko P6/a_5044_13476# P6/iovdd_uq0 P6/iovdd_uq0 sg13_hv_pmos ad=3.9294p pd=7.84u as=2.1312p ps=7.3u w=6.66u l=0.6u
M47 cko P6/a_5044_1676# vss vss sg13_hv_nmos ad=2.596p pd=5.58u as=1.408p ps=5.04u w=4.4u l=0.6u
M48 vss P6/a_5044_1676# cko vss sg13_hv_nmos ad=1.408p pd=5.04u as=2.596p ps=5.58u w=4.4u l=0.6u
M49 cko P6/a_5044_13476# P6/iovdd_uq0 P6/iovdd_uq0 sg13_hv_pmos ad=3.9294p pd=7.84u as=3.1302p ps=14.26u w=6.66u l=0.6u
M50 P6/iovdd_uq0 P6/a_5044_13476# cko P6/iovdd_uq0 sg13_hv_pmos ad=3.1302p pd=14.26u as=3.9294p ps=7.84u w=6.66u l=0.6u
M51 P6/iovdd_uq0 P6/a_5044_13476# cko P6/iovdd_uq0 sg13_hv_pmos ad=2.1312p pd=7.3u as=3.9294p ps=7.84u w=6.66u l=0.6u
M52 cko P6/a_5044_13476# P6/iovdd_uq0 P6/iovdd_uq0 sg13_hv_pmos ad=3.9294p pd=7.84u as=2.1312p ps=7.3u w=6.66u l=0.6u
X53 cko P6/iovdd_uq0 P6/dpantenna P6/l=1.26u w=27.78u
M54 cko P6/a_5044_13476# P6/iovdd_uq0 P6/iovdd_uq0 sg13_hv_pmos ad=3.9294p pd=7.84u as=3.1302p ps=14.26u w=6.66u l=0.6u
M55 P6/iovdd_uq0 P6/a_5044_13476# cko P6/iovdd_uq0 sg13_hv_pmos ad=3.1302p pd=14.26u as=3.9294p ps=7.84u w=6.66u l=0.6u
M56 P6/iovdd_uq0 P6/a_5044_13476# cko P6/iovdd_uq0 sg13_hv_pmos ad=2.1312p pd=7.3u as=3.9294p ps=7.84u w=6.66u l=0.6u
M57 cko P6/a_5044_13476# P6/iovdd_uq0 P6/iovdd_uq0 sg13_hv_pmos ad=3.9294p pd=7.84u as=2.1312p ps=7.3u w=6.66u l=0.6u
X58 vss P6/a_11462_28198# P6/dantenna P6/l=3.1u w=0.64u
X59 vss P6/a_5222_3962# P6/dantenna P6/l=1.26u w=27.78u
X60 P6/a_5044_1676# vss vss P6/rppd l=3.54u w=0.5u
M61 P6/iovdd_uq0 P6/a_5044_13476# cko P6/iovdd_uq0 sg13_hv_pmos ad=2.1312p pd=7.3u as=3.9294p ps=7.84u w=6.66u l=0.6u
M62 P6/iovdd_uq0 P6/a_5044_13476# cko P6/iovdd_uq0 sg13_hv_pmos ad=2.1312p pd=7.3u as=3.9294p ps=7.84u w=6.66u l=0.6u
M63 cko P6/a_5044_1676# vss vss sg13_hv_nmos ad=2.596p pd=5.58u as=2.068p ps=9.74u w=4.4u l=0.6u
M64 P6/iovdd_uq0 P6/a_5044_13476# cko P6/iovdd_uq0 sg13_hv_pmos ad=2.1312p pd=7.3u as=3.9294p ps=7.84u w=6.66u l=0.6u
M65 cko P6/a_5044_13476# P6/iovdd_uq0 P6/iovdd_uq0 sg13_hv_pmos ad=3.9294p pd=7.84u as=2.1312p ps=7.3u w=6.66u l=0.6u
M66 cko P6/a_5044_13476# P6/iovdd_uq0 P6/iovdd_uq0 sg13_hv_pmos ad=3.9294p pd=7.84u as=2.1312p ps=7.3u w=6.66u l=0.6u
M67 cko P6/a_5044_13476# P6/iovdd_uq0 P6/iovdd_uq0 sg13_hv_pmos ad=3.9294p pd=7.84u as=2.1312p ps=7.3u w=6.66u l=0.6u
M68 vss P6/a_5044_1676# cko vss sg13_hv_nmos ad=1.408p pd=5.04u as=2.596p ps=5.58u w=4.4u l=0.6u
M0 P7/iovdd_uq0 P7/a_5044_13476# frame P7/iovdd_uq0 sg13_hv_pmos ad=2.1312p pd=7.3u as=3.9294p ps=7.84u w=6.66u l=0.6u
M1 frame P7/a_5044_1676# vss vss sg13_hv_nmos ad=2.596p pd=5.58u as=1.408p ps=5.04u w=4.4u l=0.6u
M2 frame P7/a_5044_13476# P7/iovdd_uq0 P7/iovdd_uq0 sg13_hv_pmos ad=3.9294p pd=7.84u as=2.1312p ps=7.3u w=6.66u l=0.6u
M3 P7/iovdd_uq0 P7/a_5044_13476# frame P7/iovdd_uq0 sg13_hv_pmos ad=2.1312p pd=7.3u as=3.9294p ps=7.84u w=6.66u l=0.6u
M4 P7/iovdd_uq0 P7/a_5044_13476# frame P7/iovdd_uq0 sg13_hv_pmos ad=2.1312p pd=7.3u as=3.9294p ps=7.84u w=6.66u l=0.6u
M5 frame P7/a_5044_1676# vss vss sg13_hv_nmos ad=2.596p pd=5.58u as=1.408p ps=5.04u w=4.4u l=0.6u
M6 frame P7/a_5044_13476# P7/iovdd_uq0 P7/iovdd_uq0 sg13_hv_pmos ad=3.9294p pd=7.84u as=2.1312p ps=7.3u w=6.66u l=0.6u
M7 P7/iovdd_uq0 P7/a_5044_13476# frame P7/iovdd_uq0 sg13_hv_pmos ad=2.1312p pd=7.3u as=3.9294p ps=7.84u w=6.66u l=0.6u
M8 frame P7/a_5044_1676# vss vss sg13_hv_nmos ad=2.596p pd=5.58u as=1.408p ps=5.04u w=4.4u l=0.6u
M9 vss P7/a_5044_1676# frame vss sg13_hv_nmos ad=2.068p pd=9.74u as=2.596p ps=5.58u w=4.4u l=0.6u
M10 frame P7/a_5044_13476# P7/iovdd_uq0 P7/iovdd_uq0 sg13_hv_pmos ad=3.9294p pd=7.84u as=2.1312p ps=7.3u w=6.66u l=0.6u
X11 P7/a_5044_13476# P7/iovdd_uq0 P7/iovdd_uq0 P7/rppd l=12.9u w=0.5u
M12 vss P7/a_5044_1676# frame vss sg13_hv_nmos ad=1.408p pd=5.04u as=2.596p ps=5.58u w=4.4u l=0.6u
M13 frame P7/a_5044_13476# P7/iovdd_uq0 P7/iovdd_uq0 sg13_hv_pmos ad=3.9294p pd=7.84u as=2.1312p ps=7.3u w=6.66u l=0.6u
X14 vss P7/a_5222_4862# P7/dantenna P7/l=1.26u w=27.78u
M15 vss P7/a_5044_1676# frame vss sg13_hv_nmos ad=1.408p pd=5.04u as=2.596p ps=5.58u w=4.4u l=0.6u
M16 frame P7/a_5044_1676# vss vss sg13_hv_nmos ad=2.596p pd=5.58u as=1.408p ps=5.04u w=4.4u l=0.6u
M17 vss P7/a_5044_1676# frame vss sg13_hv_nmos ad=1.408p pd=5.04u as=2.596p ps=5.58u w=4.4u l=0.6u
M18 P7/iovdd_uq0 P7/a_5044_13476# frame P7/iovdd_uq0 sg13_hv_pmos ad=2.1312p pd=7.3u as=3.9294p ps=7.84u w=6.66u l=0.6u
M19 frame P7/a_5044_1676# vss vss sg13_hv_nmos ad=2.596p pd=5.58u as=1.408p ps=5.04u w=4.4u l=0.6u
M20 frame P7/a_5044_13476# P7/iovdd_uq0 P7/iovdd_uq0 sg13_hv_pmos ad=3.9294p pd=7.84u as=2.1312p ps=7.3u w=6.66u l=0.6u
M21 P7/iovdd_uq0 P7/a_5044_13476# frame P7/iovdd_uq0 sg13_hv_pmos ad=2.1312p pd=7.3u as=3.9294p ps=7.84u w=6.66u l=0.6u
M22 frame P7/a_5044_13476# P7/iovdd_uq0 P7/iovdd_uq0 sg13_hv_pmos ad=3.9294p pd=7.84u as=2.1312p ps=7.3u w=6.66u l=0.6u
M23 frame P7/a_5044_13476# P7/iovdd_uq0 P7/iovdd_uq0 sg13_hv_pmos ad=3.9294p pd=7.84u as=2.1312p ps=7.3u w=6.66u l=0.6u
M24 vss P7/a_5044_1676# frame vss sg13_hv_nmos ad=1.408p pd=5.04u as=2.596p ps=5.58u w=4.4u l=0.6u
X25 _frm P7/iovdd P7/dpantenna P7/l=0.64u w=4.98u
M26 P7/iovdd_uq0 P7/a_5044_13476# frame P7/iovdd_uq0 sg13_hv_pmos ad=2.1312p pd=7.3u as=3.9294p ps=7.84u w=6.66u l=0.6u
M27 frame P7/a_5044_13476# P7/iovdd_uq0 P7/iovdd_uq0 sg13_hv_pmos ad=3.9294p pd=7.84u as=2.1312p ps=7.3u w=6.66u l=0.6u
M28 frame P7/a_5044_13476# P7/iovdd_uq0 P7/iovdd_uq0 sg13_hv_pmos ad=3.9294p pd=7.84u as=2.1312p ps=7.3u w=6.66u l=0.6u
M29 frame P7/a_5044_1676# vss vss sg13_hv_nmos ad=2.596p pd=5.58u as=1.408p ps=5.04u w=4.4u l=0.6u
M30 P7/iovdd_uq0 P7/a_5044_13476# frame P7/iovdd_uq0 sg13_hv_pmos ad=2.1312p pd=7.3u as=3.9294p ps=7.84u w=6.66u l=0.6u
X31 _frm frame vss P7/rppd l=2u w=1u
M32 P7/iovdd_uq0 P7/a_5044_13476# frame P7/iovdd_uq0 sg13_hv_pmos ad=2.1312p pd=7.3u as=3.9294p ps=7.84u w=6.66u l=0.6u
M33 P7/iovdd_uq0 P7/a_5044_13476# frame P7/iovdd_uq0 sg13_hv_pmos ad=2.1312p pd=7.3u as=3.9294p ps=7.84u w=6.66u l=0.6u
M34 frame P7/a_5044_13476# P7/iovdd_uq0 P7/iovdd_uq0 sg13_hv_pmos ad=3.9294p pd=7.84u as=2.1312p ps=7.3u w=6.66u l=0.6u
M35 frame P7/a_5044_1676# vss vss sg13_hv_nmos ad=2.596p pd=5.58u as=1.408p ps=5.04u w=4.4u l=0.6u
M36 vss P7/a_5044_1676# frame vss sg13_hv_nmos ad=1.408p pd=5.04u as=2.596p ps=5.58u w=4.4u l=0.6u
M37 frame P7/a_5044_1676# vss vss sg13_hv_nmos ad=2.596p pd=5.58u as=1.408p ps=5.04u w=4.4u l=0.6u
M38 P7/iovdd_uq0 P7/a_5044_13476# frame P7/iovdd_uq0 sg13_hv_pmos ad=2.1312p pd=7.3u as=3.9294p ps=7.84u w=6.66u l=0.6u
M39 frame P7/a_5044_13476# P7/iovdd_uq0 P7/iovdd_uq0 sg13_hv_pmos ad=3.9294p pd=7.84u as=2.1312p ps=7.3u w=6.66u l=0.6u
X40 frame P7/iovdd_uq0 P7/dpantenna P7/l=1.26u w=27.78u
M41 vss P7/a_5044_1676# frame vss sg13_hv_nmos ad=1.408p pd=5.04u as=2.596p ps=5.58u w=4.4u l=0.6u
M42 P7/iovdd_uq0 P7/a_5044_13476# frame P7/iovdd_uq0 sg13_hv_pmos ad=2.1312p pd=7.3u as=3.9294p ps=7.84u w=6.66u l=0.6u
M43 vss P7/a_5044_1676# frame vss sg13_hv_nmos ad=1.408p pd=5.04u as=2.596p ps=5.58u w=4.4u l=0.6u
M44 frame P7/a_5044_13476# P7/iovdd_uq0 P7/iovdd_uq0 sg13_hv_pmos ad=3.9294p pd=7.84u as=2.1312p ps=7.3u w=6.66u l=0.6u
M45 P7/iovdd_uq0 P7/a_5044_13476# frame P7/iovdd_uq0 sg13_hv_pmos ad=2.1312p pd=7.3u as=3.9294p ps=7.84u w=6.66u l=0.6u
M46 frame P7/a_5044_13476# P7/iovdd_uq0 P7/iovdd_uq0 sg13_hv_pmos ad=3.9294p pd=7.84u as=2.1312p ps=7.3u w=6.66u l=0.6u
M47 frame P7/a_5044_1676# vss vss sg13_hv_nmos ad=2.596p pd=5.58u as=1.408p ps=5.04u w=4.4u l=0.6u
M48 vss P7/a_5044_1676# frame vss sg13_hv_nmos ad=1.408p pd=5.04u as=2.596p ps=5.58u w=4.4u l=0.6u
M49 frame P7/a_5044_13476# P7/iovdd_uq0 P7/iovdd_uq0 sg13_hv_pmos ad=3.9294p pd=7.84u as=3.1302p ps=14.26u w=6.66u l=0.6u
M50 P7/iovdd_uq0 P7/a_5044_13476# frame P7/iovdd_uq0 sg13_hv_pmos ad=3.1302p pd=14.26u as=3.9294p ps=7.84u w=6.66u l=0.6u
M51 P7/iovdd_uq0 P7/a_5044_13476# frame P7/iovdd_uq0 sg13_hv_pmos ad=2.1312p pd=7.3u as=3.9294p ps=7.84u w=6.66u l=0.6u
M52 frame P7/a_5044_13476# P7/iovdd_uq0 P7/iovdd_uq0 sg13_hv_pmos ad=3.9294p pd=7.84u as=2.1312p ps=7.3u w=6.66u l=0.6u
X53 frame P7/iovdd_uq0 P7/dpantenna P7/l=1.26u w=27.78u
M54 frame P7/a_5044_13476# P7/iovdd_uq0 P7/iovdd_uq0 sg13_hv_pmos ad=3.9294p pd=7.84u as=3.1302p ps=14.26u w=6.66u l=0.6u
M55 P7/iovdd_uq0 P7/a_5044_13476# frame P7/iovdd_uq0 sg13_hv_pmos ad=3.1302p pd=14.26u as=3.9294p ps=7.84u w=6.66u l=0.6u
M56 P7/iovdd_uq0 P7/a_5044_13476# frame P7/iovdd_uq0 sg13_hv_pmos ad=2.1312p pd=7.3u as=3.9294p ps=7.84u w=6.66u l=0.6u
M57 frame P7/a_5044_13476# P7/iovdd_uq0 P7/iovdd_uq0 sg13_hv_pmos ad=3.9294p pd=7.84u as=2.1312p ps=7.3u w=6.66u l=0.6u
X58 vss P7/a_11462_28198# P7/dantenna P7/l=3.1u w=0.64u
X59 vss P7/a_5222_3962# P7/dantenna P7/l=1.26u w=27.78u
X60 P7/a_5044_1676# vss vss P7/rppd l=3.54u w=0.5u
M61 P7/iovdd_uq0 P7/a_5044_13476# frame P7/iovdd_uq0 sg13_hv_pmos ad=2.1312p pd=7.3u as=3.9294p ps=7.84u w=6.66u l=0.6u
M62 P7/iovdd_uq0 P7/a_5044_13476# frame P7/iovdd_uq0 sg13_hv_pmos ad=2.1312p pd=7.3u as=3.9294p ps=7.84u w=6.66u l=0.6u
M63 frame P7/a_5044_1676# vss vss sg13_hv_nmos ad=2.596p pd=5.58u as=2.068p ps=9.74u w=4.4u l=0.6u
M64 P7/iovdd_uq0 P7/a_5044_13476# frame P7/iovdd_uq0 sg13_hv_pmos ad=2.1312p pd=7.3u as=3.9294p ps=7.84u w=6.66u l=0.6u
M65 frame P7/a_5044_13476# P7/iovdd_uq0 P7/iovdd_uq0 sg13_hv_pmos ad=3.9294p pd=7.84u as=2.1312p ps=7.3u w=6.66u l=0.6u
M66 frame P7/a_5044_13476# P7/iovdd_uq0 P7/iovdd_uq0 sg13_hv_pmos ad=3.9294p pd=7.84u as=2.1312p ps=7.3u w=6.66u l=0.6u
M67 frame P7/a_5044_13476# P7/iovdd_uq0 P7/iovdd_uq0 sg13_hv_pmos ad=3.9294p pd=7.84u as=2.1312p ps=7.3u w=6.66u l=0.6u
M68 vss P7/a_5044_1676# frame vss sg13_hv_nmos ad=1.408p pd=5.04u as=2.596p ps=5.58u w=4.4u l=0.6u
M0 P8/iovdd_uq0 P8/a_5044_13476# vddr P8/iovdd_uq0 sg13_hv_pmos ad=2.1312p pd=7.3u as=3.9294p ps=7.84u w=6.66u l=0.6u
M1 vddr P8/a_5044_1676# vss vss sg13_hv_nmos ad=2.596p pd=5.58u as=1.408p ps=5.04u w=4.4u l=0.6u
M2 vddr P8/a_5044_13476# P8/iovdd_uq0 P8/iovdd_uq0 sg13_hv_pmos ad=3.9294p pd=7.84u as=2.1312p ps=7.3u w=6.66u l=0.6u
M3 P8/iovdd_uq0 P8/a_5044_13476# vddr P8/iovdd_uq0 sg13_hv_pmos ad=2.1312p pd=7.3u as=3.9294p ps=7.84u w=6.66u l=0.6u
M4 P8/iovdd_uq0 P8/a_5044_13476# vddr P8/iovdd_uq0 sg13_hv_pmos ad=2.1312p pd=7.3u as=3.9294p ps=7.84u w=6.66u l=0.6u
M5 vddr P8/a_5044_1676# vss vss sg13_hv_nmos ad=2.596p pd=5.58u as=1.408p ps=5.04u w=4.4u l=0.6u
M6 vddr P8/a_5044_13476# P8/iovdd_uq0 P8/iovdd_uq0 sg13_hv_pmos ad=3.9294p pd=7.84u as=2.1312p ps=7.3u w=6.66u l=0.6u
M7 P8/iovdd_uq0 P8/a_5044_13476# vddr P8/iovdd_uq0 sg13_hv_pmos ad=2.1312p pd=7.3u as=3.9294p ps=7.84u w=6.66u l=0.6u
M8 vddr P8/a_5044_1676# vss vss sg13_hv_nmos ad=2.596p pd=5.58u as=1.408p ps=5.04u w=4.4u l=0.6u
M9 vss P8/a_5044_1676# vddr vss sg13_hv_nmos ad=2.068p pd=9.74u as=2.596p ps=5.58u w=4.4u l=0.6u
M10 vddr P8/a_5044_13476# P8/iovdd_uq0 P8/iovdd_uq0 sg13_hv_pmos ad=3.9294p pd=7.84u as=2.1312p ps=7.3u w=6.66u l=0.6u
X11 P8/a_5044_13476# P8/iovdd_uq0 P8/iovdd_uq0 P8/rppd l=12.9u w=0.5u
M12 vss P8/a_5044_1676# vddr vss sg13_hv_nmos ad=1.408p pd=5.04u as=2.596p ps=5.58u w=4.4u l=0.6u
M13 vddr P8/a_5044_13476# P8/iovdd_uq0 P8/iovdd_uq0 sg13_hv_pmos ad=3.9294p pd=7.84u as=2.1312p ps=7.3u w=6.66u l=0.6u
X14 vss P8/a_5222_4862# P8/dantenna P8/l=1.26u w=27.78u
M15 vss P8/a_5044_1676# vddr vss sg13_hv_nmos ad=1.408p pd=5.04u as=2.596p ps=5.58u w=4.4u l=0.6u
M16 vddr P8/a_5044_1676# vss vss sg13_hv_nmos ad=2.596p pd=5.58u as=1.408p ps=5.04u w=4.4u l=0.6u
M17 vss P8/a_5044_1676# vddr vss sg13_hv_nmos ad=1.408p pd=5.04u as=2.596p ps=5.58u w=4.4u l=0.6u
M18 P8/iovdd_uq0 P8/a_5044_13476# vddr P8/iovdd_uq0 sg13_hv_pmos ad=2.1312p pd=7.3u as=3.9294p ps=7.84u w=6.66u l=0.6u
M19 vddr P8/a_5044_1676# vss vss sg13_hv_nmos ad=2.596p pd=5.58u as=1.408p ps=5.04u w=4.4u l=0.6u
M20 vddr P8/a_5044_13476# P8/iovdd_uq0 P8/iovdd_uq0 sg13_hv_pmos ad=3.9294p pd=7.84u as=2.1312p ps=7.3u w=6.66u l=0.6u
M21 P8/iovdd_uq0 P8/a_5044_13476# vddr P8/iovdd_uq0 sg13_hv_pmos ad=2.1312p pd=7.3u as=3.9294p ps=7.84u w=6.66u l=0.6u
M22 vddr P8/a_5044_13476# P8/iovdd_uq0 P8/iovdd_uq0 sg13_hv_pmos ad=3.9294p pd=7.84u as=2.1312p ps=7.3u w=6.66u l=0.6u
M23 vddr P8/a_5044_13476# P8/iovdd_uq0 P8/iovdd_uq0 sg13_hv_pmos ad=3.9294p pd=7.84u as=2.1312p ps=7.3u w=6.66u l=0.6u
M24 vss P8/a_5044_1676# vddr vss sg13_hv_nmos ad=1.408p pd=5.04u as=2.596p ps=5.58u w=4.4u l=0.6u
X25 vddr P8/iovdd P8/dpantenna P8/l=0.64u w=4.98u
M26 P8/iovdd_uq0 P8/a_5044_13476# vddr P8/iovdd_uq0 sg13_hv_pmos ad=2.1312p pd=7.3u as=3.9294p ps=7.84u w=6.66u l=0.6u
M27 vddr P8/a_5044_13476# P8/iovdd_uq0 P8/iovdd_uq0 sg13_hv_pmos ad=3.9294p pd=7.84u as=2.1312p ps=7.3u w=6.66u l=0.6u
M28 vddr P8/a_5044_13476# P8/iovdd_uq0 P8/iovdd_uq0 sg13_hv_pmos ad=3.9294p pd=7.84u as=2.1312p ps=7.3u w=6.66u l=0.6u
M29 vddr P8/a_5044_1676# vss vss sg13_hv_nmos ad=2.596p pd=5.58u as=1.408p ps=5.04u w=4.4u l=0.6u
M30 P8/iovdd_uq0 P8/a_5044_13476# vddr P8/iovdd_uq0 sg13_hv_pmos ad=2.1312p pd=7.3u as=3.9294p ps=7.84u w=6.66u l=0.6u
X31 vddr vddr vss P8/rppd l=2u w=1u
M32 P8/iovdd_uq0 P8/a_5044_13476# vddr P8/iovdd_uq0 sg13_hv_pmos ad=2.1312p pd=7.3u as=3.9294p ps=7.84u w=6.66u l=0.6u
M33 P8/iovdd_uq0 P8/a_5044_13476# vddr P8/iovdd_uq0 sg13_hv_pmos ad=2.1312p pd=7.3u as=3.9294p ps=7.84u w=6.66u l=0.6u
M34 vddr P8/a_5044_13476# P8/iovdd_uq0 P8/iovdd_uq0 sg13_hv_pmos ad=3.9294p pd=7.84u as=2.1312p ps=7.3u w=6.66u l=0.6u
M35 vddr P8/a_5044_1676# vss vss sg13_hv_nmos ad=2.596p pd=5.58u as=1.408p ps=5.04u w=4.4u l=0.6u
M36 vss P8/a_5044_1676# vddr vss sg13_hv_nmos ad=1.408p pd=5.04u as=2.596p ps=5.58u w=4.4u l=0.6u
M37 vddr P8/a_5044_1676# vss vss sg13_hv_nmos ad=2.596p pd=5.58u as=1.408p ps=5.04u w=4.4u l=0.6u
M38 P8/iovdd_uq0 P8/a_5044_13476# vddr P8/iovdd_uq0 sg13_hv_pmos ad=2.1312p pd=7.3u as=3.9294p ps=7.84u w=6.66u l=0.6u
M39 vddr P8/a_5044_13476# P8/iovdd_uq0 P8/iovdd_uq0 sg13_hv_pmos ad=3.9294p pd=7.84u as=2.1312p ps=7.3u w=6.66u l=0.6u
X40 vddr P8/iovdd_uq0 P8/dpantenna P8/l=1.26u w=27.78u
M41 vss P8/a_5044_1676# vddr vss sg13_hv_nmos ad=1.408p pd=5.04u as=2.596p ps=5.58u w=4.4u l=0.6u
M42 P8/iovdd_uq0 P8/a_5044_13476# vddr P8/iovdd_uq0 sg13_hv_pmos ad=2.1312p pd=7.3u as=3.9294p ps=7.84u w=6.66u l=0.6u
M43 vss P8/a_5044_1676# vddr vss sg13_hv_nmos ad=1.408p pd=5.04u as=2.596p ps=5.58u w=4.4u l=0.6u
M44 vddr P8/a_5044_13476# P8/iovdd_uq0 P8/iovdd_uq0 sg13_hv_pmos ad=3.9294p pd=7.84u as=2.1312p ps=7.3u w=6.66u l=0.6u
M45 P8/iovdd_uq0 P8/a_5044_13476# vddr P8/iovdd_uq0 sg13_hv_pmos ad=2.1312p pd=7.3u as=3.9294p ps=7.84u w=6.66u l=0.6u
M46 vddr P8/a_5044_13476# P8/iovdd_uq0 P8/iovdd_uq0 sg13_hv_pmos ad=3.9294p pd=7.84u as=2.1312p ps=7.3u w=6.66u l=0.6u
M47 vddr P8/a_5044_1676# vss vss sg13_hv_nmos ad=2.596p pd=5.58u as=1.408p ps=5.04u w=4.4u l=0.6u
M48 vss P8/a_5044_1676# vddr vss sg13_hv_nmos ad=1.408p pd=5.04u as=2.596p ps=5.58u w=4.4u l=0.6u
M49 vddr P8/a_5044_13476# P8/iovdd_uq0 P8/iovdd_uq0 sg13_hv_pmos ad=3.9294p pd=7.84u as=3.1302p ps=14.26u w=6.66u l=0.6u
M50 P8/iovdd_uq0 P8/a_5044_13476# vddr P8/iovdd_uq0 sg13_hv_pmos ad=3.1302p pd=14.26u as=3.9294p ps=7.84u w=6.66u l=0.6u
M51 P8/iovdd_uq0 P8/a_5044_13476# vddr P8/iovdd_uq0 sg13_hv_pmos ad=2.1312p pd=7.3u as=3.9294p ps=7.84u w=6.66u l=0.6u
M52 vddr P8/a_5044_13476# P8/iovdd_uq0 P8/iovdd_uq0 sg13_hv_pmos ad=3.9294p pd=7.84u as=2.1312p ps=7.3u w=6.66u l=0.6u
X53 vddr P8/iovdd_uq0 P8/dpantenna P8/l=1.26u w=27.78u
M54 vddr P8/a_5044_13476# P8/iovdd_uq0 P8/iovdd_uq0 sg13_hv_pmos ad=3.9294p pd=7.84u as=3.1302p ps=14.26u w=6.66u l=0.6u
M55 P8/iovdd_uq0 P8/a_5044_13476# vddr P8/iovdd_uq0 sg13_hv_pmos ad=3.1302p pd=14.26u as=3.9294p ps=7.84u w=6.66u l=0.6u
M56 P8/iovdd_uq0 P8/a_5044_13476# vddr P8/iovdd_uq0 sg13_hv_pmos ad=2.1312p pd=7.3u as=3.9294p ps=7.84u w=6.66u l=0.6u
M57 vddr P8/a_5044_13476# P8/iovdd_uq0 P8/iovdd_uq0 sg13_hv_pmos ad=3.9294p pd=7.84u as=2.1312p ps=7.3u w=6.66u l=0.6u
X58 vss P8/a_11462_28198# P8/dantenna P8/l=3.1u w=0.64u
X59 vss P8/a_5222_3962# P8/dantenna P8/l=1.26u w=27.78u
X60 P8/a_5044_1676# vss vss P8/rppd l=3.54u w=0.5u
M61 P8/iovdd_uq0 P8/a_5044_13476# vddr P8/iovdd_uq0 sg13_hv_pmos ad=2.1312p pd=7.3u as=3.9294p ps=7.84u w=6.66u l=0.6u
M62 P8/iovdd_uq0 P8/a_5044_13476# vddr P8/iovdd_uq0 sg13_hv_pmos ad=2.1312p pd=7.3u as=3.9294p ps=7.84u w=6.66u l=0.6u
M63 vddr P8/a_5044_1676# vss vss sg13_hv_nmos ad=2.596p pd=5.58u as=2.068p ps=9.74u w=4.4u l=0.6u
M64 P8/iovdd_uq0 P8/a_5044_13476# vddr P8/iovdd_uq0 sg13_hv_pmos ad=2.1312p pd=7.3u as=3.9294p ps=7.84u w=6.66u l=0.6u
M65 vddr P8/a_5044_13476# P8/iovdd_uq0 P8/iovdd_uq0 sg13_hv_pmos ad=3.9294p pd=7.84u as=2.1312p ps=7.3u w=6.66u l=0.6u
M66 vddr P8/a_5044_13476# P8/iovdd_uq0 P8/iovdd_uq0 sg13_hv_pmos ad=3.9294p pd=7.84u as=2.1312p ps=7.3u w=6.66u l=0.6u
M67 vddr P8/a_5044_13476# P8/iovdd_uq0 P8/iovdd_uq0 sg13_hv_pmos ad=3.9294p pd=7.84u as=2.1312p ps=7.3u w=6.66u l=0.6u
M68 vss P8/a_5044_1676# vddr vss sg13_hv_nmos ad=1.408p pd=5.04u as=2.596p ps=5.58u w=4.4u l=0.6u
M0 D0/iovdd_uq0 D0/a_5044_13476# _n1 D0/iovdd_uq0 sg13_hv_pmos ad=2.1312p pd=7.3u as=3.9294p ps=7.84u w=6.66u l=0.6u
M1 _n1 D0/a_5044_1676# vss vss sg13_hv_nmos ad=2.596p pd=5.58u as=1.408p ps=5.04u w=4.4u l=0.6u
M2 _n1 D0/a_5044_13476# D0/iovdd_uq0 D0/iovdd_uq0 sg13_hv_pmos ad=3.9294p pd=7.84u as=2.1312p ps=7.3u w=6.66u l=0.6u
M3 D0/iovdd_uq0 D0/a_5044_13476# _n1 D0/iovdd_uq0 sg13_hv_pmos ad=2.1312p pd=7.3u as=3.9294p ps=7.84u w=6.66u l=0.6u
M4 D0/iovdd_uq0 D0/a_5044_13476# _n1 D0/iovdd_uq0 sg13_hv_pmos ad=2.1312p pd=7.3u as=3.9294p ps=7.84u w=6.66u l=0.6u
M5 _n1 D0/a_5044_1676# vss vss sg13_hv_nmos ad=2.596p pd=5.58u as=1.408p ps=5.04u w=4.4u l=0.6u
M6 _n1 D0/a_5044_13476# D0/iovdd_uq0 D0/iovdd_uq0 sg13_hv_pmos ad=3.9294p pd=7.84u as=2.1312p ps=7.3u w=6.66u l=0.6u
M7 D0/iovdd_uq0 D0/a_5044_13476# _n1 D0/iovdd_uq0 sg13_hv_pmos ad=2.1312p pd=7.3u as=3.9294p ps=7.84u w=6.66u l=0.6u
M8 _n1 D0/a_5044_1676# vss vss sg13_hv_nmos ad=2.596p pd=5.58u as=1.408p ps=5.04u w=4.4u l=0.6u
M9 vss D0/a_5044_1676# _n1 vss sg13_hv_nmos ad=2.068p pd=9.74u as=2.596p ps=5.58u w=4.4u l=0.6u
M10 _n1 D0/a_5044_13476# D0/iovdd_uq0 D0/iovdd_uq0 sg13_hv_pmos ad=3.9294p pd=7.84u as=2.1312p ps=7.3u w=6.66u l=0.6u
X11 D0/a_5044_13476# D0/iovdd_uq0 D0/iovdd_uq0 D0/rppd l=12.9u w=0.5u
M12 vss D0/a_5044_1676# _n1 vss sg13_hv_nmos ad=1.408p pd=5.04u as=2.596p ps=5.58u w=4.4u l=0.6u
M13 _n1 D0/a_5044_13476# D0/iovdd_uq0 D0/iovdd_uq0 sg13_hv_pmos ad=3.9294p pd=7.84u as=2.1312p ps=7.3u w=6.66u l=0.6u
X14 vss D0/a_5222_4862# D0/dantenna D0/l=1.26u w=27.78u
M15 vss D0/a_5044_1676# _n1 vss sg13_hv_nmos ad=1.408p pd=5.04u as=2.596p ps=5.58u w=4.4u l=0.6u
M16 _n1 D0/a_5044_1676# vss vss sg13_hv_nmos ad=2.596p pd=5.58u as=1.408p ps=5.04u w=4.4u l=0.6u
M17 vss D0/a_5044_1676# _n1 vss sg13_hv_nmos ad=1.408p pd=5.04u as=2.596p ps=5.58u w=4.4u l=0.6u
M18 D0/iovdd_uq0 D0/a_5044_13476# _n1 D0/iovdd_uq0 sg13_hv_pmos ad=2.1312p pd=7.3u as=3.9294p ps=7.84u w=6.66u l=0.6u
M19 _n1 D0/a_5044_1676# vss vss sg13_hv_nmos ad=2.596p pd=5.58u as=1.408p ps=5.04u w=4.4u l=0.6u
M20 _n1 D0/a_5044_13476# D0/iovdd_uq0 D0/iovdd_uq0 sg13_hv_pmos ad=3.9294p pd=7.84u as=2.1312p ps=7.3u w=6.66u l=0.6u
M21 D0/iovdd_uq0 D0/a_5044_13476# _n1 D0/iovdd_uq0 sg13_hv_pmos ad=2.1312p pd=7.3u as=3.9294p ps=7.84u w=6.66u l=0.6u
M22 _n1 D0/a_5044_13476# D0/iovdd_uq0 D0/iovdd_uq0 sg13_hv_pmos ad=3.9294p pd=7.84u as=2.1312p ps=7.3u w=6.66u l=0.6u
M23 _n1 D0/a_5044_13476# D0/iovdd_uq0 D0/iovdd_uq0 sg13_hv_pmos ad=3.9294p pd=7.84u as=2.1312p ps=7.3u w=6.66u l=0.6u
M24 vss D0/a_5044_1676# _n1 vss sg13_hv_nmos ad=1.408p pd=5.04u as=2.596p ps=5.58u w=4.4u l=0.6u
X25 _n1c D0/iovdd D0/dpantenna D0/l=0.64u w=4.98u
M26 D0/iovdd_uq0 D0/a_5044_13476# _n1 D0/iovdd_uq0 sg13_hv_pmos ad=2.1312p pd=7.3u as=3.9294p ps=7.84u w=6.66u l=0.6u
M27 _n1 D0/a_5044_13476# D0/iovdd_uq0 D0/iovdd_uq0 sg13_hv_pmos ad=3.9294p pd=7.84u as=2.1312p ps=7.3u w=6.66u l=0.6u
M28 _n1 D0/a_5044_13476# D0/iovdd_uq0 D0/iovdd_uq0 sg13_hv_pmos ad=3.9294p pd=7.84u as=2.1312p ps=7.3u w=6.66u l=0.6u
M29 _n1 D0/a_5044_1676# vss vss sg13_hv_nmos ad=2.596p pd=5.58u as=1.408p ps=5.04u w=4.4u l=0.6u
M30 D0/iovdd_uq0 D0/a_5044_13476# _n1 D0/iovdd_uq0 sg13_hv_pmos ad=2.1312p pd=7.3u as=3.9294p ps=7.84u w=6.66u l=0.6u
X31 _n1c _n1 vss D0/rppd l=2u w=1u
M32 D0/iovdd_uq0 D0/a_5044_13476# _n1 D0/iovdd_uq0 sg13_hv_pmos ad=2.1312p pd=7.3u as=3.9294p ps=7.84u w=6.66u l=0.6u
M33 D0/iovdd_uq0 D0/a_5044_13476# _n1 D0/iovdd_uq0 sg13_hv_pmos ad=2.1312p pd=7.3u as=3.9294p ps=7.84u w=6.66u l=0.6u
M34 _n1 D0/a_5044_13476# D0/iovdd_uq0 D0/iovdd_uq0 sg13_hv_pmos ad=3.9294p pd=7.84u as=2.1312p ps=7.3u w=6.66u l=0.6u
M35 _n1 D0/a_5044_1676# vss vss sg13_hv_nmos ad=2.596p pd=5.58u as=1.408p ps=5.04u w=4.4u l=0.6u
M36 vss D0/a_5044_1676# _n1 vss sg13_hv_nmos ad=1.408p pd=5.04u as=2.596p ps=5.58u w=4.4u l=0.6u
M37 _n1 D0/a_5044_1676# vss vss sg13_hv_nmos ad=2.596p pd=5.58u as=1.408p ps=5.04u w=4.4u l=0.6u
M38 D0/iovdd_uq0 D0/a_5044_13476# _n1 D0/iovdd_uq0 sg13_hv_pmos ad=2.1312p pd=7.3u as=3.9294p ps=7.84u w=6.66u l=0.6u
M39 _n1 D0/a_5044_13476# D0/iovdd_uq0 D0/iovdd_uq0 sg13_hv_pmos ad=3.9294p pd=7.84u as=2.1312p ps=7.3u w=6.66u l=0.6u
X40 _n1 D0/iovdd_uq0 D0/dpantenna D0/l=1.26u w=27.78u
M41 vss D0/a_5044_1676# _n1 vss sg13_hv_nmos ad=1.408p pd=5.04u as=2.596p ps=5.58u w=4.4u l=0.6u
M42 D0/iovdd_uq0 D0/a_5044_13476# _n1 D0/iovdd_uq0 sg13_hv_pmos ad=2.1312p pd=7.3u as=3.9294p ps=7.84u w=6.66u l=0.6u
M43 vss D0/a_5044_1676# _n1 vss sg13_hv_nmos ad=1.408p pd=5.04u as=2.596p ps=5.58u w=4.4u l=0.6u
M44 _n1 D0/a_5044_13476# D0/iovdd_uq0 D0/iovdd_uq0 sg13_hv_pmos ad=3.9294p pd=7.84u as=2.1312p ps=7.3u w=6.66u l=0.6u
M45 D0/iovdd_uq0 D0/a_5044_13476# _n1 D0/iovdd_uq0 sg13_hv_pmos ad=2.1312p pd=7.3u as=3.9294p ps=7.84u w=6.66u l=0.6u
M46 _n1 D0/a_5044_13476# D0/iovdd_uq0 D0/iovdd_uq0 sg13_hv_pmos ad=3.9294p pd=7.84u as=2.1312p ps=7.3u w=6.66u l=0.6u
M47 _n1 D0/a_5044_1676# vss vss sg13_hv_nmos ad=2.596p pd=5.58u as=1.408p ps=5.04u w=4.4u l=0.6u
M48 vss D0/a_5044_1676# _n1 vss sg13_hv_nmos ad=1.408p pd=5.04u as=2.596p ps=5.58u w=4.4u l=0.6u
M49 _n1 D0/a_5044_13476# D0/iovdd_uq0 D0/iovdd_uq0 sg13_hv_pmos ad=3.9294p pd=7.84u as=3.1302p ps=14.26u w=6.66u l=0.6u
M50 D0/iovdd_uq0 D0/a_5044_13476# _n1 D0/iovdd_uq0 sg13_hv_pmos ad=3.1302p pd=14.26u as=3.9294p ps=7.84u w=6.66u l=0.6u
M51 D0/iovdd_uq0 D0/a_5044_13476# _n1 D0/iovdd_uq0 sg13_hv_pmos ad=2.1312p pd=7.3u as=3.9294p ps=7.84u w=6.66u l=0.6u
M52 _n1 D0/a_5044_13476# D0/iovdd_uq0 D0/iovdd_uq0 sg13_hv_pmos ad=3.9294p pd=7.84u as=2.1312p ps=7.3u w=6.66u l=0.6u
X53 _n1 D0/iovdd_uq0 D0/dpantenna D0/l=1.26u w=27.78u
M54 _n1 D0/a_5044_13476# D0/iovdd_uq0 D0/iovdd_uq0 sg13_hv_pmos ad=3.9294p pd=7.84u as=3.1302p ps=14.26u w=6.66u l=0.6u
M55 D0/iovdd_uq0 D0/a_5044_13476# _n1 D0/iovdd_uq0 sg13_hv_pmos ad=3.1302p pd=14.26u as=3.9294p ps=7.84u w=6.66u l=0.6u
M56 D0/iovdd_uq0 D0/a_5044_13476# _n1 D0/iovdd_uq0 sg13_hv_pmos ad=2.1312p pd=7.3u as=3.9294p ps=7.84u w=6.66u l=0.6u
M57 _n1 D0/a_5044_13476# D0/iovdd_uq0 D0/iovdd_uq0 sg13_hv_pmos ad=3.9294p pd=7.84u as=2.1312p ps=7.3u w=6.66u l=0.6u
X58 vss D0/a_11462_28198# D0/dantenna D0/l=3.1u w=0.64u
X59 vss D0/a_5222_3962# D0/dantenna D0/l=1.26u w=27.78u
X60 D0/a_5044_1676# vss vss D0/rppd l=3.54u w=0.5u
M61 D0/iovdd_uq0 D0/a_5044_13476# _n1 D0/iovdd_uq0 sg13_hv_pmos ad=2.1312p pd=7.3u as=3.9294p ps=7.84u w=6.66u l=0.6u
M62 D0/iovdd_uq0 D0/a_5044_13476# _n1 D0/iovdd_uq0 sg13_hv_pmos ad=2.1312p pd=7.3u as=3.9294p ps=7.84u w=6.66u l=0.6u
M63 _n1 D0/a_5044_1676# vss vss sg13_hv_nmos ad=2.596p pd=5.58u as=2.068p ps=9.74u w=4.4u l=0.6u
M64 D0/iovdd_uq0 D0/a_5044_13476# _n1 D0/iovdd_uq0 sg13_hv_pmos ad=2.1312p pd=7.3u as=3.9294p ps=7.84u w=6.66u l=0.6u
M65 _n1 D0/a_5044_13476# D0/iovdd_uq0 D0/iovdd_uq0 sg13_hv_pmos ad=3.9294p pd=7.84u as=2.1312p ps=7.3u w=6.66u l=0.6u
M66 _n1 D0/a_5044_13476# D0/iovdd_uq0 D0/iovdd_uq0 sg13_hv_pmos ad=3.9294p pd=7.84u as=2.1312p ps=7.3u w=6.66u l=0.6u
M67 _n1 D0/a_5044_13476# D0/iovdd_uq0 D0/iovdd_uq0 sg13_hv_pmos ad=3.9294p pd=7.84u as=2.1312p ps=7.3u w=6.66u l=0.6u
M68 vss D0/a_5044_1676# _n1 vss sg13_hv_nmos ad=1.408p pd=5.04u as=2.596p ps=5.58u w=4.4u l=0.6u
M0 D1/iovdd_uq0 D1/a_5044_13476# _n2 D1/iovdd_uq0 sg13_hv_pmos ad=2.1312p pd=7.3u as=3.9294p ps=7.84u w=6.66u l=0.6u
M1 _n2 D1/a_5044_1676# vss vss sg13_hv_nmos ad=2.596p pd=5.58u as=1.408p ps=5.04u w=4.4u l=0.6u
M2 _n2 D1/a_5044_13476# D1/iovdd_uq0 D1/iovdd_uq0 sg13_hv_pmos ad=3.9294p pd=7.84u as=2.1312p ps=7.3u w=6.66u l=0.6u
M3 D1/iovdd_uq0 D1/a_5044_13476# _n2 D1/iovdd_uq0 sg13_hv_pmos ad=2.1312p pd=7.3u as=3.9294p ps=7.84u w=6.66u l=0.6u
M4 D1/iovdd_uq0 D1/a_5044_13476# _n2 D1/iovdd_uq0 sg13_hv_pmos ad=2.1312p pd=7.3u as=3.9294p ps=7.84u w=6.66u l=0.6u
M5 _n2 D1/a_5044_1676# vss vss sg13_hv_nmos ad=2.596p pd=5.58u as=1.408p ps=5.04u w=4.4u l=0.6u
M6 _n2 D1/a_5044_13476# D1/iovdd_uq0 D1/iovdd_uq0 sg13_hv_pmos ad=3.9294p pd=7.84u as=2.1312p ps=7.3u w=6.66u l=0.6u
M7 D1/iovdd_uq0 D1/a_5044_13476# _n2 D1/iovdd_uq0 sg13_hv_pmos ad=2.1312p pd=7.3u as=3.9294p ps=7.84u w=6.66u l=0.6u
M8 _n2 D1/a_5044_1676# vss vss sg13_hv_nmos ad=2.596p pd=5.58u as=1.408p ps=5.04u w=4.4u l=0.6u
M9 vss D1/a_5044_1676# _n2 vss sg13_hv_nmos ad=2.068p pd=9.74u as=2.596p ps=5.58u w=4.4u l=0.6u
M10 _n2 D1/a_5044_13476# D1/iovdd_uq0 D1/iovdd_uq0 sg13_hv_pmos ad=3.9294p pd=7.84u as=2.1312p ps=7.3u w=6.66u l=0.6u
X11 D1/a_5044_13476# D1/iovdd_uq0 D1/iovdd_uq0 D1/rppd l=12.9u w=0.5u
M12 vss D1/a_5044_1676# _n2 vss sg13_hv_nmos ad=1.408p pd=5.04u as=2.596p ps=5.58u w=4.4u l=0.6u
M13 _n2 D1/a_5044_13476# D1/iovdd_uq0 D1/iovdd_uq0 sg13_hv_pmos ad=3.9294p pd=7.84u as=2.1312p ps=7.3u w=6.66u l=0.6u
X14 vss D1/a_5222_4862# D1/dantenna D1/l=1.26u w=27.78u
M15 vss D1/a_5044_1676# _n2 vss sg13_hv_nmos ad=1.408p pd=5.04u as=2.596p ps=5.58u w=4.4u l=0.6u
M16 _n2 D1/a_5044_1676# vss vss sg13_hv_nmos ad=2.596p pd=5.58u as=1.408p ps=5.04u w=4.4u l=0.6u
M17 vss D1/a_5044_1676# _n2 vss sg13_hv_nmos ad=1.408p pd=5.04u as=2.596p ps=5.58u w=4.4u l=0.6u
M18 D1/iovdd_uq0 D1/a_5044_13476# _n2 D1/iovdd_uq0 sg13_hv_pmos ad=2.1312p pd=7.3u as=3.9294p ps=7.84u w=6.66u l=0.6u
M19 _n2 D1/a_5044_1676# vss vss sg13_hv_nmos ad=2.596p pd=5.58u as=1.408p ps=5.04u w=4.4u l=0.6u
M20 _n2 D1/a_5044_13476# D1/iovdd_uq0 D1/iovdd_uq0 sg13_hv_pmos ad=3.9294p pd=7.84u as=2.1312p ps=7.3u w=6.66u l=0.6u
M21 D1/iovdd_uq0 D1/a_5044_13476# _n2 D1/iovdd_uq0 sg13_hv_pmos ad=2.1312p pd=7.3u as=3.9294p ps=7.84u w=6.66u l=0.6u
M22 _n2 D1/a_5044_13476# D1/iovdd_uq0 D1/iovdd_uq0 sg13_hv_pmos ad=3.9294p pd=7.84u as=2.1312p ps=7.3u w=6.66u l=0.6u
M23 _n2 D1/a_5044_13476# D1/iovdd_uq0 D1/iovdd_uq0 sg13_hv_pmos ad=3.9294p pd=7.84u as=2.1312p ps=7.3u w=6.66u l=0.6u
M24 vss D1/a_5044_1676# _n2 vss sg13_hv_nmos ad=1.408p pd=5.04u as=2.596p ps=5.58u w=4.4u l=0.6u
X25 _n2c D1/iovdd D1/dpantenna D1/l=0.64u w=4.98u
M26 D1/iovdd_uq0 D1/a_5044_13476# _n2 D1/iovdd_uq0 sg13_hv_pmos ad=2.1312p pd=7.3u as=3.9294p ps=7.84u w=6.66u l=0.6u
M27 _n2 D1/a_5044_13476# D1/iovdd_uq0 D1/iovdd_uq0 sg13_hv_pmos ad=3.9294p pd=7.84u as=2.1312p ps=7.3u w=6.66u l=0.6u
M28 _n2 D1/a_5044_13476# D1/iovdd_uq0 D1/iovdd_uq0 sg13_hv_pmos ad=3.9294p pd=7.84u as=2.1312p ps=7.3u w=6.66u l=0.6u
M29 _n2 D1/a_5044_1676# vss vss sg13_hv_nmos ad=2.596p pd=5.58u as=1.408p ps=5.04u w=4.4u l=0.6u
M30 D1/iovdd_uq0 D1/a_5044_13476# _n2 D1/iovdd_uq0 sg13_hv_pmos ad=2.1312p pd=7.3u as=3.9294p ps=7.84u w=6.66u l=0.6u
X31 _n2c _n2 vss D1/rppd l=2u w=1u
M32 D1/iovdd_uq0 D1/a_5044_13476# _n2 D1/iovdd_uq0 sg13_hv_pmos ad=2.1312p pd=7.3u as=3.9294p ps=7.84u w=6.66u l=0.6u
M33 D1/iovdd_uq0 D1/a_5044_13476# _n2 D1/iovdd_uq0 sg13_hv_pmos ad=2.1312p pd=7.3u as=3.9294p ps=7.84u w=6.66u l=0.6u
M34 _n2 D1/a_5044_13476# D1/iovdd_uq0 D1/iovdd_uq0 sg13_hv_pmos ad=3.9294p pd=7.84u as=2.1312p ps=7.3u w=6.66u l=0.6u
M35 _n2 D1/a_5044_1676# vss vss sg13_hv_nmos ad=2.596p pd=5.58u as=1.408p ps=5.04u w=4.4u l=0.6u
M36 vss D1/a_5044_1676# _n2 vss sg13_hv_nmos ad=1.408p pd=5.04u as=2.596p ps=5.58u w=4.4u l=0.6u
M37 _n2 D1/a_5044_1676# vss vss sg13_hv_nmos ad=2.596p pd=5.58u as=1.408p ps=5.04u w=4.4u l=0.6u
M38 D1/iovdd_uq0 D1/a_5044_13476# _n2 D1/iovdd_uq0 sg13_hv_pmos ad=2.1312p pd=7.3u as=3.9294p ps=7.84u w=6.66u l=0.6u
M39 _n2 D1/a_5044_13476# D1/iovdd_uq0 D1/iovdd_uq0 sg13_hv_pmos ad=3.9294p pd=7.84u as=2.1312p ps=7.3u w=6.66u l=0.6u
X40 _n2 D1/iovdd_uq0 D1/dpantenna D1/l=1.26u w=27.78u
M41 vss D1/a_5044_1676# _n2 vss sg13_hv_nmos ad=1.408p pd=5.04u as=2.596p ps=5.58u w=4.4u l=0.6u
M42 D1/iovdd_uq0 D1/a_5044_13476# _n2 D1/iovdd_uq0 sg13_hv_pmos ad=2.1312p pd=7.3u as=3.9294p ps=7.84u w=6.66u l=0.6u
M43 vss D1/a_5044_1676# _n2 vss sg13_hv_nmos ad=1.408p pd=5.04u as=2.596p ps=5.58u w=4.4u l=0.6u
M44 _n2 D1/a_5044_13476# D1/iovdd_uq0 D1/iovdd_uq0 sg13_hv_pmos ad=3.9294p pd=7.84u as=2.1312p ps=7.3u w=6.66u l=0.6u
M45 D1/iovdd_uq0 D1/a_5044_13476# _n2 D1/iovdd_uq0 sg13_hv_pmos ad=2.1312p pd=7.3u as=3.9294p ps=7.84u w=6.66u l=0.6u
M46 _n2 D1/a_5044_13476# D1/iovdd_uq0 D1/iovdd_uq0 sg13_hv_pmos ad=3.9294p pd=7.84u as=2.1312p ps=7.3u w=6.66u l=0.6u
M47 _n2 D1/a_5044_1676# vss vss sg13_hv_nmos ad=2.596p pd=5.58u as=1.408p ps=5.04u w=4.4u l=0.6u
M48 vss D1/a_5044_1676# _n2 vss sg13_hv_nmos ad=1.408p pd=5.04u as=2.596p ps=5.58u w=4.4u l=0.6u
M49 _n2 D1/a_5044_13476# D1/iovdd_uq0 D1/iovdd_uq0 sg13_hv_pmos ad=3.9294p pd=7.84u as=3.1302p ps=14.26u w=6.66u l=0.6u
M50 D1/iovdd_uq0 D1/a_5044_13476# _n2 D1/iovdd_uq0 sg13_hv_pmos ad=3.1302p pd=14.26u as=3.9294p ps=7.84u w=6.66u l=0.6u
M51 D1/iovdd_uq0 D1/a_5044_13476# _n2 D1/iovdd_uq0 sg13_hv_pmos ad=2.1312p pd=7.3u as=3.9294p ps=7.84u w=6.66u l=0.6u
M52 _n2 D1/a_5044_13476# D1/iovdd_uq0 D1/iovdd_uq0 sg13_hv_pmos ad=3.9294p pd=7.84u as=2.1312p ps=7.3u w=6.66u l=0.6u
X53 _n2 D1/iovdd_uq0 D1/dpantenna D1/l=1.26u w=27.78u
M54 _n2 D1/a_5044_13476# D1/iovdd_uq0 D1/iovdd_uq0 sg13_hv_pmos ad=3.9294p pd=7.84u as=3.1302p ps=14.26u w=6.66u l=0.6u
M55 D1/iovdd_uq0 D1/a_5044_13476# _n2 D1/iovdd_uq0 sg13_hv_pmos ad=3.1302p pd=14.26u as=3.9294p ps=7.84u w=6.66u l=0.6u
M56 D1/iovdd_uq0 D1/a_5044_13476# _n2 D1/iovdd_uq0 sg13_hv_pmos ad=2.1312p pd=7.3u as=3.9294p ps=7.84u w=6.66u l=0.6u
M57 _n2 D1/a_5044_13476# D1/iovdd_uq0 D1/iovdd_uq0 sg13_hv_pmos ad=3.9294p pd=7.84u as=2.1312p ps=7.3u w=6.66u l=0.6u
X58 vss D1/a_11462_28198# D1/dantenna D1/l=3.1u w=0.64u
X59 vss D1/a_5222_3962# D1/dantenna D1/l=1.26u w=27.78u
X60 D1/a_5044_1676# vss vss D1/rppd l=3.54u w=0.5u
M61 D1/iovdd_uq0 D1/a_5044_13476# _n2 D1/iovdd_uq0 sg13_hv_pmos ad=2.1312p pd=7.3u as=3.9294p ps=7.84u w=6.66u l=0.6u
M62 D1/iovdd_uq0 D1/a_5044_13476# _n2 D1/iovdd_uq0 sg13_hv_pmos ad=2.1312p pd=7.3u as=3.9294p ps=7.84u w=6.66u l=0.6u
M63 _n2 D1/a_5044_1676# vss vss sg13_hv_nmos ad=2.596p pd=5.58u as=2.068p ps=9.74u w=4.4u l=0.6u
M64 D1/iovdd_uq0 D1/a_5044_13476# _n2 D1/iovdd_uq0 sg13_hv_pmos ad=2.1312p pd=7.3u as=3.9294p ps=7.84u w=6.66u l=0.6u
M65 _n2 D1/a_5044_13476# D1/iovdd_uq0 D1/iovdd_uq0 sg13_hv_pmos ad=3.9294p pd=7.84u as=2.1312p ps=7.3u w=6.66u l=0.6u
M66 _n2 D1/a_5044_13476# D1/iovdd_uq0 D1/iovdd_uq0 sg13_hv_pmos ad=3.9294p pd=7.84u as=2.1312p ps=7.3u w=6.66u l=0.6u
M67 _n2 D1/a_5044_13476# D1/iovdd_uq0 D1/iovdd_uq0 sg13_hv_pmos ad=3.9294p pd=7.84u as=2.1312p ps=7.3u w=6.66u l=0.6u
M68 vss D1/a_5044_1676# _n2 vss sg13_hv_nmos ad=1.408p pd=5.04u as=2.596p ps=5.58u w=4.4u l=0.6u
M0 D2/iovdd_uq0 D2/a_5044_13476# _n3 D2/iovdd_uq0 sg13_hv_pmos ad=2.1312p pd=7.3u as=3.9294p ps=7.84u w=6.66u l=0.6u
M1 _n3 D2/a_5044_1676# vss vss sg13_hv_nmos ad=2.596p pd=5.58u as=1.408p ps=5.04u w=4.4u l=0.6u
M2 _n3 D2/a_5044_13476# D2/iovdd_uq0 D2/iovdd_uq0 sg13_hv_pmos ad=3.9294p pd=7.84u as=2.1312p ps=7.3u w=6.66u l=0.6u
M3 D2/iovdd_uq0 D2/a_5044_13476# _n3 D2/iovdd_uq0 sg13_hv_pmos ad=2.1312p pd=7.3u as=3.9294p ps=7.84u w=6.66u l=0.6u
M4 D2/iovdd_uq0 D2/a_5044_13476# _n3 D2/iovdd_uq0 sg13_hv_pmos ad=2.1312p pd=7.3u as=3.9294p ps=7.84u w=6.66u l=0.6u
M5 _n3 D2/a_5044_1676# vss vss sg13_hv_nmos ad=2.596p pd=5.58u as=1.408p ps=5.04u w=4.4u l=0.6u
M6 _n3 D2/a_5044_13476# D2/iovdd_uq0 D2/iovdd_uq0 sg13_hv_pmos ad=3.9294p pd=7.84u as=2.1312p ps=7.3u w=6.66u l=0.6u
M7 D2/iovdd_uq0 D2/a_5044_13476# _n3 D2/iovdd_uq0 sg13_hv_pmos ad=2.1312p pd=7.3u as=3.9294p ps=7.84u w=6.66u l=0.6u
M8 _n3 D2/a_5044_1676# vss vss sg13_hv_nmos ad=2.596p pd=5.58u as=1.408p ps=5.04u w=4.4u l=0.6u
M9 vss D2/a_5044_1676# _n3 vss sg13_hv_nmos ad=2.068p pd=9.74u as=2.596p ps=5.58u w=4.4u l=0.6u
M10 _n3 D2/a_5044_13476# D2/iovdd_uq0 D2/iovdd_uq0 sg13_hv_pmos ad=3.9294p pd=7.84u as=2.1312p ps=7.3u w=6.66u l=0.6u
X11 D2/a_5044_13476# D2/iovdd_uq0 D2/iovdd_uq0 D2/rppd l=12.9u w=0.5u
M12 vss D2/a_5044_1676# _n3 vss sg13_hv_nmos ad=1.408p pd=5.04u as=2.596p ps=5.58u w=4.4u l=0.6u
M13 _n3 D2/a_5044_13476# D2/iovdd_uq0 D2/iovdd_uq0 sg13_hv_pmos ad=3.9294p pd=7.84u as=2.1312p ps=7.3u w=6.66u l=0.6u
X14 vss D2/a_5222_4862# D2/dantenna D2/l=1.26u w=27.78u
M15 vss D2/a_5044_1676# _n3 vss sg13_hv_nmos ad=1.408p pd=5.04u as=2.596p ps=5.58u w=4.4u l=0.6u
M16 _n3 D2/a_5044_1676# vss vss sg13_hv_nmos ad=2.596p pd=5.58u as=1.408p ps=5.04u w=4.4u l=0.6u
M17 vss D2/a_5044_1676# _n3 vss sg13_hv_nmos ad=1.408p pd=5.04u as=2.596p ps=5.58u w=4.4u l=0.6u
M18 D2/iovdd_uq0 D2/a_5044_13476# _n3 D2/iovdd_uq0 sg13_hv_pmos ad=2.1312p pd=7.3u as=3.9294p ps=7.84u w=6.66u l=0.6u
M19 _n3 D2/a_5044_1676# vss vss sg13_hv_nmos ad=2.596p pd=5.58u as=1.408p ps=5.04u w=4.4u l=0.6u
M20 _n3 D2/a_5044_13476# D2/iovdd_uq0 D2/iovdd_uq0 sg13_hv_pmos ad=3.9294p pd=7.84u as=2.1312p ps=7.3u w=6.66u l=0.6u
M21 D2/iovdd_uq0 D2/a_5044_13476# _n3 D2/iovdd_uq0 sg13_hv_pmos ad=2.1312p pd=7.3u as=3.9294p ps=7.84u w=6.66u l=0.6u
M22 _n3 D2/a_5044_13476# D2/iovdd_uq0 D2/iovdd_uq0 sg13_hv_pmos ad=3.9294p pd=7.84u as=2.1312p ps=7.3u w=6.66u l=0.6u
M23 _n3 D2/a_5044_13476# D2/iovdd_uq0 D2/iovdd_uq0 sg13_hv_pmos ad=3.9294p pd=7.84u as=2.1312p ps=7.3u w=6.66u l=0.6u
M24 vss D2/a_5044_1676# _n3 vss sg13_hv_nmos ad=1.408p pd=5.04u as=2.596p ps=5.58u w=4.4u l=0.6u
X25 _n3c D2/iovdd D2/dpantenna D2/l=0.64u w=4.98u
M26 D2/iovdd_uq0 D2/a_5044_13476# _n3 D2/iovdd_uq0 sg13_hv_pmos ad=2.1312p pd=7.3u as=3.9294p ps=7.84u w=6.66u l=0.6u
M27 _n3 D2/a_5044_13476# D2/iovdd_uq0 D2/iovdd_uq0 sg13_hv_pmos ad=3.9294p pd=7.84u as=2.1312p ps=7.3u w=6.66u l=0.6u
M28 _n3 D2/a_5044_13476# D2/iovdd_uq0 D2/iovdd_uq0 sg13_hv_pmos ad=3.9294p pd=7.84u as=2.1312p ps=7.3u w=6.66u l=0.6u
M29 _n3 D2/a_5044_1676# vss vss sg13_hv_nmos ad=2.596p pd=5.58u as=1.408p ps=5.04u w=4.4u l=0.6u
M30 D2/iovdd_uq0 D2/a_5044_13476# _n3 D2/iovdd_uq0 sg13_hv_pmos ad=2.1312p pd=7.3u as=3.9294p ps=7.84u w=6.66u l=0.6u
X31 _n3c _n3 vss D2/rppd l=2u w=1u
M32 D2/iovdd_uq0 D2/a_5044_13476# _n3 D2/iovdd_uq0 sg13_hv_pmos ad=2.1312p pd=7.3u as=3.9294p ps=7.84u w=6.66u l=0.6u
M33 D2/iovdd_uq0 D2/a_5044_13476# _n3 D2/iovdd_uq0 sg13_hv_pmos ad=2.1312p pd=7.3u as=3.9294p ps=7.84u w=6.66u l=0.6u
M34 _n3 D2/a_5044_13476# D2/iovdd_uq0 D2/iovdd_uq0 sg13_hv_pmos ad=3.9294p pd=7.84u as=2.1312p ps=7.3u w=6.66u l=0.6u
M35 _n3 D2/a_5044_1676# vss vss sg13_hv_nmos ad=2.596p pd=5.58u as=1.408p ps=5.04u w=4.4u l=0.6u
M36 vss D2/a_5044_1676# _n3 vss sg13_hv_nmos ad=1.408p pd=5.04u as=2.596p ps=5.58u w=4.4u l=0.6u
M37 _n3 D2/a_5044_1676# vss vss sg13_hv_nmos ad=2.596p pd=5.58u as=1.408p ps=5.04u w=4.4u l=0.6u
M38 D2/iovdd_uq0 D2/a_5044_13476# _n3 D2/iovdd_uq0 sg13_hv_pmos ad=2.1312p pd=7.3u as=3.9294p ps=7.84u w=6.66u l=0.6u
M39 _n3 D2/a_5044_13476# D2/iovdd_uq0 D2/iovdd_uq0 sg13_hv_pmos ad=3.9294p pd=7.84u as=2.1312p ps=7.3u w=6.66u l=0.6u
X40 _n3 D2/iovdd_uq0 D2/dpantenna D2/l=1.26u w=27.78u
M41 vss D2/a_5044_1676# _n3 vss sg13_hv_nmos ad=1.408p pd=5.04u as=2.596p ps=5.58u w=4.4u l=0.6u
M42 D2/iovdd_uq0 D2/a_5044_13476# _n3 D2/iovdd_uq0 sg13_hv_pmos ad=2.1312p pd=7.3u as=3.9294p ps=7.84u w=6.66u l=0.6u
M43 vss D2/a_5044_1676# _n3 vss sg13_hv_nmos ad=1.408p pd=5.04u as=2.596p ps=5.58u w=4.4u l=0.6u
M44 _n3 D2/a_5044_13476# D2/iovdd_uq0 D2/iovdd_uq0 sg13_hv_pmos ad=3.9294p pd=7.84u as=2.1312p ps=7.3u w=6.66u l=0.6u
M45 D2/iovdd_uq0 D2/a_5044_13476# _n3 D2/iovdd_uq0 sg13_hv_pmos ad=2.1312p pd=7.3u as=3.9294p ps=7.84u w=6.66u l=0.6u
M46 _n3 D2/a_5044_13476# D2/iovdd_uq0 D2/iovdd_uq0 sg13_hv_pmos ad=3.9294p pd=7.84u as=2.1312p ps=7.3u w=6.66u l=0.6u
M47 _n3 D2/a_5044_1676# vss vss sg13_hv_nmos ad=2.596p pd=5.58u as=1.408p ps=5.04u w=4.4u l=0.6u
M48 vss D2/a_5044_1676# _n3 vss sg13_hv_nmos ad=1.408p pd=5.04u as=2.596p ps=5.58u w=4.4u l=0.6u
M49 _n3 D2/a_5044_13476# D2/iovdd_uq0 D2/iovdd_uq0 sg13_hv_pmos ad=3.9294p pd=7.84u as=3.1302p ps=14.26u w=6.66u l=0.6u
M50 D2/iovdd_uq0 D2/a_5044_13476# _n3 D2/iovdd_uq0 sg13_hv_pmos ad=3.1302p pd=14.26u as=3.9294p ps=7.84u w=6.66u l=0.6u
M51 D2/iovdd_uq0 D2/a_5044_13476# _n3 D2/iovdd_uq0 sg13_hv_pmos ad=2.1312p pd=7.3u as=3.9294p ps=7.84u w=6.66u l=0.6u
M52 _n3 D2/a_5044_13476# D2/iovdd_uq0 D2/iovdd_uq0 sg13_hv_pmos ad=3.9294p pd=7.84u as=2.1312p ps=7.3u w=6.66u l=0.6u
X53 _n3 D2/iovdd_uq0 D2/dpantenna D2/l=1.26u w=27.78u
M54 _n3 D2/a_5044_13476# D2/iovdd_uq0 D2/iovdd_uq0 sg13_hv_pmos ad=3.9294p pd=7.84u as=3.1302p ps=14.26u w=6.66u l=0.6u
M55 D2/iovdd_uq0 D2/a_5044_13476# _n3 D2/iovdd_uq0 sg13_hv_pmos ad=3.1302p pd=14.26u as=3.9294p ps=7.84u w=6.66u l=0.6u
M56 D2/iovdd_uq0 D2/a_5044_13476# _n3 D2/iovdd_uq0 sg13_hv_pmos ad=2.1312p pd=7.3u as=3.9294p ps=7.84u w=6.66u l=0.6u
M57 _n3 D2/a_5044_13476# D2/iovdd_uq0 D2/iovdd_uq0 sg13_hv_pmos ad=3.9294p pd=7.84u as=2.1312p ps=7.3u w=6.66u l=0.6u
X58 vss D2/a_11462_28198# D2/dantenna D2/l=3.1u w=0.64u
X59 vss D2/a_5222_3962# D2/dantenna D2/l=1.26u w=27.78u
X60 D2/a_5044_1676# vss vss D2/rppd l=3.54u w=0.5u
M61 D2/iovdd_uq0 D2/a_5044_13476# _n3 D2/iovdd_uq0 sg13_hv_pmos ad=2.1312p pd=7.3u as=3.9294p ps=7.84u w=6.66u l=0.6u
M62 D2/iovdd_uq0 D2/a_5044_13476# _n3 D2/iovdd_uq0 sg13_hv_pmos ad=2.1312p pd=7.3u as=3.9294p ps=7.84u w=6.66u l=0.6u
M63 _n3 D2/a_5044_1676# vss vss sg13_hv_nmos ad=2.596p pd=5.58u as=2.068p ps=9.74u w=4.4u l=0.6u
M64 D2/iovdd_uq0 D2/a_5044_13476# _n3 D2/iovdd_uq0 sg13_hv_pmos ad=2.1312p pd=7.3u as=3.9294p ps=7.84u w=6.66u l=0.6u
M65 _n3 D2/a_5044_13476# D2/iovdd_uq0 D2/iovdd_uq0 sg13_hv_pmos ad=3.9294p pd=7.84u as=2.1312p ps=7.3u w=6.66u l=0.6u
M66 _n3 D2/a_5044_13476# D2/iovdd_uq0 D2/iovdd_uq0 sg13_hv_pmos ad=3.9294p pd=7.84u as=2.1312p ps=7.3u w=6.66u l=0.6u
M67 _n3 D2/a_5044_13476# D2/iovdd_uq0 D2/iovdd_uq0 sg13_hv_pmos ad=3.9294p pd=7.84u as=2.1312p ps=7.3u w=6.66u l=0.6u
M68 vss D2/a_5044_1676# _n3 vss sg13_hv_nmos ad=1.408p pd=5.04u as=2.596p ps=5.58u w=4.4u l=0.6u
M0 D3/iovdd_uq0 D3/a_5044_13476# _n4 D3/iovdd_uq0 sg13_hv_pmos ad=2.1312p pd=7.3u as=3.9294p ps=7.84u w=6.66u l=0.6u
M1 _n4 D3/a_5044_1676# vss vss sg13_hv_nmos ad=2.596p pd=5.58u as=1.408p ps=5.04u w=4.4u l=0.6u
M2 _n4 D3/a_5044_13476# D3/iovdd_uq0 D3/iovdd_uq0 sg13_hv_pmos ad=3.9294p pd=7.84u as=2.1312p ps=7.3u w=6.66u l=0.6u
M3 D3/iovdd_uq0 D3/a_5044_13476# _n4 D3/iovdd_uq0 sg13_hv_pmos ad=2.1312p pd=7.3u as=3.9294p ps=7.84u w=6.66u l=0.6u
M4 D3/iovdd_uq0 D3/a_5044_13476# _n4 D3/iovdd_uq0 sg13_hv_pmos ad=2.1312p pd=7.3u as=3.9294p ps=7.84u w=6.66u l=0.6u
M5 _n4 D3/a_5044_1676# vss vss sg13_hv_nmos ad=2.596p pd=5.58u as=1.408p ps=5.04u w=4.4u l=0.6u
M6 _n4 D3/a_5044_13476# D3/iovdd_uq0 D3/iovdd_uq0 sg13_hv_pmos ad=3.9294p pd=7.84u as=2.1312p ps=7.3u w=6.66u l=0.6u
M7 D3/iovdd_uq0 D3/a_5044_13476# _n4 D3/iovdd_uq0 sg13_hv_pmos ad=2.1312p pd=7.3u as=3.9294p ps=7.84u w=6.66u l=0.6u
M8 _n4 D3/a_5044_1676# vss vss sg13_hv_nmos ad=2.596p pd=5.58u as=1.408p ps=5.04u w=4.4u l=0.6u
M9 vss D3/a_5044_1676# _n4 vss sg13_hv_nmos ad=2.068p pd=9.74u as=2.596p ps=5.58u w=4.4u l=0.6u
M10 _n4 D3/a_5044_13476# D3/iovdd_uq0 D3/iovdd_uq0 sg13_hv_pmos ad=3.9294p pd=7.84u as=2.1312p ps=7.3u w=6.66u l=0.6u
X11 D3/a_5044_13476# D3/iovdd_uq0 D3/iovdd_uq0 D3/rppd l=12.9u w=0.5u
M12 vss D3/a_5044_1676# _n4 vss sg13_hv_nmos ad=1.408p pd=5.04u as=2.596p ps=5.58u w=4.4u l=0.6u
M13 _n4 D3/a_5044_13476# D3/iovdd_uq0 D3/iovdd_uq0 sg13_hv_pmos ad=3.9294p pd=7.84u as=2.1312p ps=7.3u w=6.66u l=0.6u
X14 vss D3/a_5222_4862# D3/dantenna D3/l=1.26u w=27.78u
M15 vss D3/a_5044_1676# _n4 vss sg13_hv_nmos ad=1.408p pd=5.04u as=2.596p ps=5.58u w=4.4u l=0.6u
M16 _n4 D3/a_5044_1676# vss vss sg13_hv_nmos ad=2.596p pd=5.58u as=1.408p ps=5.04u w=4.4u l=0.6u
M17 vss D3/a_5044_1676# _n4 vss sg13_hv_nmos ad=1.408p pd=5.04u as=2.596p ps=5.58u w=4.4u l=0.6u
M18 D3/iovdd_uq0 D3/a_5044_13476# _n4 D3/iovdd_uq0 sg13_hv_pmos ad=2.1312p pd=7.3u as=3.9294p ps=7.84u w=6.66u l=0.6u
M19 _n4 D3/a_5044_1676# vss vss sg13_hv_nmos ad=2.596p pd=5.58u as=1.408p ps=5.04u w=4.4u l=0.6u
M20 _n4 D3/a_5044_13476# D3/iovdd_uq0 D3/iovdd_uq0 sg13_hv_pmos ad=3.9294p pd=7.84u as=2.1312p ps=7.3u w=6.66u l=0.6u
M21 D3/iovdd_uq0 D3/a_5044_13476# _n4 D3/iovdd_uq0 sg13_hv_pmos ad=2.1312p pd=7.3u as=3.9294p ps=7.84u w=6.66u l=0.6u
M22 _n4 D3/a_5044_13476# D3/iovdd_uq0 D3/iovdd_uq0 sg13_hv_pmos ad=3.9294p pd=7.84u as=2.1312p ps=7.3u w=6.66u l=0.6u
M23 _n4 D3/a_5044_13476# D3/iovdd_uq0 D3/iovdd_uq0 sg13_hv_pmos ad=3.9294p pd=7.84u as=2.1312p ps=7.3u w=6.66u l=0.6u
M24 vss D3/a_5044_1676# _n4 vss sg13_hv_nmos ad=1.408p pd=5.04u as=2.596p ps=5.58u w=4.4u l=0.6u
X25 _n4c D3/iovdd D3/dpantenna D3/l=0.64u w=4.98u
M26 D3/iovdd_uq0 D3/a_5044_13476# _n4 D3/iovdd_uq0 sg13_hv_pmos ad=2.1312p pd=7.3u as=3.9294p ps=7.84u w=6.66u l=0.6u
M27 _n4 D3/a_5044_13476# D3/iovdd_uq0 D3/iovdd_uq0 sg13_hv_pmos ad=3.9294p pd=7.84u as=2.1312p ps=7.3u w=6.66u l=0.6u
M28 _n4 D3/a_5044_13476# D3/iovdd_uq0 D3/iovdd_uq0 sg13_hv_pmos ad=3.9294p pd=7.84u as=2.1312p ps=7.3u w=6.66u l=0.6u
M29 _n4 D3/a_5044_1676# vss vss sg13_hv_nmos ad=2.596p pd=5.58u as=1.408p ps=5.04u w=4.4u l=0.6u
M30 D3/iovdd_uq0 D3/a_5044_13476# _n4 D3/iovdd_uq0 sg13_hv_pmos ad=2.1312p pd=7.3u as=3.9294p ps=7.84u w=6.66u l=0.6u
X31 _n4c _n4 vss D3/rppd l=2u w=1u
M32 D3/iovdd_uq0 D3/a_5044_13476# _n4 D3/iovdd_uq0 sg13_hv_pmos ad=2.1312p pd=7.3u as=3.9294p ps=7.84u w=6.66u l=0.6u
M33 D3/iovdd_uq0 D3/a_5044_13476# _n4 D3/iovdd_uq0 sg13_hv_pmos ad=2.1312p pd=7.3u as=3.9294p ps=7.84u w=6.66u l=0.6u
M34 _n4 D3/a_5044_13476# D3/iovdd_uq0 D3/iovdd_uq0 sg13_hv_pmos ad=3.9294p pd=7.84u as=2.1312p ps=7.3u w=6.66u l=0.6u
M35 _n4 D3/a_5044_1676# vss vss sg13_hv_nmos ad=2.596p pd=5.58u as=1.408p ps=5.04u w=4.4u l=0.6u
M36 vss D3/a_5044_1676# _n4 vss sg13_hv_nmos ad=1.408p pd=5.04u as=2.596p ps=5.58u w=4.4u l=0.6u
M37 _n4 D3/a_5044_1676# vss vss sg13_hv_nmos ad=2.596p pd=5.58u as=1.408p ps=5.04u w=4.4u l=0.6u
M38 D3/iovdd_uq0 D3/a_5044_13476# _n4 D3/iovdd_uq0 sg13_hv_pmos ad=2.1312p pd=7.3u as=3.9294p ps=7.84u w=6.66u l=0.6u
M39 _n4 D3/a_5044_13476# D3/iovdd_uq0 D3/iovdd_uq0 sg13_hv_pmos ad=3.9294p pd=7.84u as=2.1312p ps=7.3u w=6.66u l=0.6u
X40 _n4 D3/iovdd_uq0 D3/dpantenna D3/l=1.26u w=27.78u
M41 vss D3/a_5044_1676# _n4 vss sg13_hv_nmos ad=1.408p pd=5.04u as=2.596p ps=5.58u w=4.4u l=0.6u
M42 D3/iovdd_uq0 D3/a_5044_13476# _n4 D3/iovdd_uq0 sg13_hv_pmos ad=2.1312p pd=7.3u as=3.9294p ps=7.84u w=6.66u l=0.6u
M43 vss D3/a_5044_1676# _n4 vss sg13_hv_nmos ad=1.408p pd=5.04u as=2.596p ps=5.58u w=4.4u l=0.6u
M44 _n4 D3/a_5044_13476# D3/iovdd_uq0 D3/iovdd_uq0 sg13_hv_pmos ad=3.9294p pd=7.84u as=2.1312p ps=7.3u w=6.66u l=0.6u
M45 D3/iovdd_uq0 D3/a_5044_13476# _n4 D3/iovdd_uq0 sg13_hv_pmos ad=2.1312p pd=7.3u as=3.9294p ps=7.84u w=6.66u l=0.6u
M46 _n4 D3/a_5044_13476# D3/iovdd_uq0 D3/iovdd_uq0 sg13_hv_pmos ad=3.9294p pd=7.84u as=2.1312p ps=7.3u w=6.66u l=0.6u
M47 _n4 D3/a_5044_1676# vss vss sg13_hv_nmos ad=2.596p pd=5.58u as=1.408p ps=5.04u w=4.4u l=0.6u
M48 vss D3/a_5044_1676# _n4 vss sg13_hv_nmos ad=1.408p pd=5.04u as=2.596p ps=5.58u w=4.4u l=0.6u
M49 _n4 D3/a_5044_13476# D3/iovdd_uq0 D3/iovdd_uq0 sg13_hv_pmos ad=3.9294p pd=7.84u as=3.1302p ps=14.26u w=6.66u l=0.6u
M50 D3/iovdd_uq0 D3/a_5044_13476# _n4 D3/iovdd_uq0 sg13_hv_pmos ad=3.1302p pd=14.26u as=3.9294p ps=7.84u w=6.66u l=0.6u
M51 D3/iovdd_uq0 D3/a_5044_13476# _n4 D3/iovdd_uq0 sg13_hv_pmos ad=2.1312p pd=7.3u as=3.9294p ps=7.84u w=6.66u l=0.6u
M52 _n4 D3/a_5044_13476# D3/iovdd_uq0 D3/iovdd_uq0 sg13_hv_pmos ad=3.9294p pd=7.84u as=2.1312p ps=7.3u w=6.66u l=0.6u
X53 _n4 D3/iovdd_uq0 D3/dpantenna D3/l=1.26u w=27.78u
M54 _n4 D3/a_5044_13476# D3/iovdd_uq0 D3/iovdd_uq0 sg13_hv_pmos ad=3.9294p pd=7.84u as=3.1302p ps=14.26u w=6.66u l=0.6u
M55 D3/iovdd_uq0 D3/a_5044_13476# _n4 D3/iovdd_uq0 sg13_hv_pmos ad=3.1302p pd=14.26u as=3.9294p ps=7.84u w=6.66u l=0.6u
M56 D3/iovdd_uq0 D3/a_5044_13476# _n4 D3/iovdd_uq0 sg13_hv_pmos ad=2.1312p pd=7.3u as=3.9294p ps=7.84u w=6.66u l=0.6u
M57 _n4 D3/a_5044_13476# D3/iovdd_uq0 D3/iovdd_uq0 sg13_hv_pmos ad=3.9294p pd=7.84u as=2.1312p ps=7.3u w=6.66u l=0.6u
X58 vss D3/a_11462_28198# D3/dantenna D3/l=3.1u w=0.64u
X59 vss D3/a_5222_3962# D3/dantenna D3/l=1.26u w=27.78u
X60 D3/a_5044_1676# vss vss D3/rppd l=3.54u w=0.5u
M61 D3/iovdd_uq0 D3/a_5044_13476# _n4 D3/iovdd_uq0 sg13_hv_pmos ad=2.1312p pd=7.3u as=3.9294p ps=7.84u w=6.66u l=0.6u
M62 D3/iovdd_uq0 D3/a_5044_13476# _n4 D3/iovdd_uq0 sg13_hv_pmos ad=2.1312p pd=7.3u as=3.9294p ps=7.84u w=6.66u l=0.6u
M63 _n4 D3/a_5044_1676# vss vss sg13_hv_nmos ad=2.596p pd=5.58u as=2.068p ps=9.74u w=4.4u l=0.6u
M64 D3/iovdd_uq0 D3/a_5044_13476# _n4 D3/iovdd_uq0 sg13_hv_pmos ad=2.1312p pd=7.3u as=3.9294p ps=7.84u w=6.66u l=0.6u
M65 _n4 D3/a_5044_13476# D3/iovdd_uq0 D3/iovdd_uq0 sg13_hv_pmos ad=3.9294p pd=7.84u as=2.1312p ps=7.3u w=6.66u l=0.6u
M66 _n4 D3/a_5044_13476# D3/iovdd_uq0 D3/iovdd_uq0 sg13_hv_pmos ad=3.9294p pd=7.84u as=2.1312p ps=7.3u w=6.66u l=0.6u
M67 _n4 D3/a_5044_13476# D3/iovdd_uq0 D3/iovdd_uq0 sg13_hv_pmos ad=3.9294p pd=7.84u as=2.1312p ps=7.3u w=6.66u l=0.6u
M68 vss D3/a_5044_1676# _n4 vss sg13_hv_nmos ad=1.408p pd=5.04u as=2.596p ps=5.58u w=4.4u l=0.6u
M0 D4/iovdd_uq0 D4/a_5044_13476# _n5 D4/iovdd_uq0 sg13_hv_pmos ad=2.1312p pd=7.3u as=3.9294p ps=7.84u w=6.66u l=0.6u
M1 _n5 D4/a_5044_1676# vss vss sg13_hv_nmos ad=2.596p pd=5.58u as=1.408p ps=5.04u w=4.4u l=0.6u
M2 _n5 D4/a_5044_13476# D4/iovdd_uq0 D4/iovdd_uq0 sg13_hv_pmos ad=3.9294p pd=7.84u as=2.1312p ps=7.3u w=6.66u l=0.6u
M3 D4/iovdd_uq0 D4/a_5044_13476# _n5 D4/iovdd_uq0 sg13_hv_pmos ad=2.1312p pd=7.3u as=3.9294p ps=7.84u w=6.66u l=0.6u
M4 D4/iovdd_uq0 D4/a_5044_13476# _n5 D4/iovdd_uq0 sg13_hv_pmos ad=2.1312p pd=7.3u as=3.9294p ps=7.84u w=6.66u l=0.6u
M5 _n5 D4/a_5044_1676# vss vss sg13_hv_nmos ad=2.596p pd=5.58u as=1.408p ps=5.04u w=4.4u l=0.6u
M6 _n5 D4/a_5044_13476# D4/iovdd_uq0 D4/iovdd_uq0 sg13_hv_pmos ad=3.9294p pd=7.84u as=2.1312p ps=7.3u w=6.66u l=0.6u
M7 D4/iovdd_uq0 D4/a_5044_13476# _n5 D4/iovdd_uq0 sg13_hv_pmos ad=2.1312p pd=7.3u as=3.9294p ps=7.84u w=6.66u l=0.6u
M8 _n5 D4/a_5044_1676# vss vss sg13_hv_nmos ad=2.596p pd=5.58u as=1.408p ps=5.04u w=4.4u l=0.6u
M9 vss D4/a_5044_1676# _n5 vss sg13_hv_nmos ad=2.068p pd=9.74u as=2.596p ps=5.58u w=4.4u l=0.6u
M10 _n5 D4/a_5044_13476# D4/iovdd_uq0 D4/iovdd_uq0 sg13_hv_pmos ad=3.9294p pd=7.84u as=2.1312p ps=7.3u w=6.66u l=0.6u
X11 D4/a_5044_13476# D4/iovdd_uq0 D4/iovdd_uq0 D4/rppd l=12.9u w=0.5u
M12 vss D4/a_5044_1676# _n5 vss sg13_hv_nmos ad=1.408p pd=5.04u as=2.596p ps=5.58u w=4.4u l=0.6u
M13 _n5 D4/a_5044_13476# D4/iovdd_uq0 D4/iovdd_uq0 sg13_hv_pmos ad=3.9294p pd=7.84u as=2.1312p ps=7.3u w=6.66u l=0.6u
X14 vss D4/a_5222_4862# D4/dantenna D4/l=1.26u w=27.78u
M15 vss D4/a_5044_1676# _n5 vss sg13_hv_nmos ad=1.408p pd=5.04u as=2.596p ps=5.58u w=4.4u l=0.6u
M16 _n5 D4/a_5044_1676# vss vss sg13_hv_nmos ad=2.596p pd=5.58u as=1.408p ps=5.04u w=4.4u l=0.6u
M17 vss D4/a_5044_1676# _n5 vss sg13_hv_nmos ad=1.408p pd=5.04u as=2.596p ps=5.58u w=4.4u l=0.6u
M18 D4/iovdd_uq0 D4/a_5044_13476# _n5 D4/iovdd_uq0 sg13_hv_pmos ad=2.1312p pd=7.3u as=3.9294p ps=7.84u w=6.66u l=0.6u
M19 _n5 D4/a_5044_1676# vss vss sg13_hv_nmos ad=2.596p pd=5.58u as=1.408p ps=5.04u w=4.4u l=0.6u
M20 _n5 D4/a_5044_13476# D4/iovdd_uq0 D4/iovdd_uq0 sg13_hv_pmos ad=3.9294p pd=7.84u as=2.1312p ps=7.3u w=6.66u l=0.6u
M21 D4/iovdd_uq0 D4/a_5044_13476# _n5 D4/iovdd_uq0 sg13_hv_pmos ad=2.1312p pd=7.3u as=3.9294p ps=7.84u w=6.66u l=0.6u
M22 _n5 D4/a_5044_13476# D4/iovdd_uq0 D4/iovdd_uq0 sg13_hv_pmos ad=3.9294p pd=7.84u as=2.1312p ps=7.3u w=6.66u l=0.6u
M23 _n5 D4/a_5044_13476# D4/iovdd_uq0 D4/iovdd_uq0 sg13_hv_pmos ad=3.9294p pd=7.84u as=2.1312p ps=7.3u w=6.66u l=0.6u
M24 vss D4/a_5044_1676# _n5 vss sg13_hv_nmos ad=1.408p pd=5.04u as=2.596p ps=5.58u w=4.4u l=0.6u
X25 _n5c D4/iovdd D4/dpantenna D4/l=0.64u w=4.98u
M26 D4/iovdd_uq0 D4/a_5044_13476# _n5 D4/iovdd_uq0 sg13_hv_pmos ad=2.1312p pd=7.3u as=3.9294p ps=7.84u w=6.66u l=0.6u
M27 _n5 D4/a_5044_13476# D4/iovdd_uq0 D4/iovdd_uq0 sg13_hv_pmos ad=3.9294p pd=7.84u as=2.1312p ps=7.3u w=6.66u l=0.6u
M28 _n5 D4/a_5044_13476# D4/iovdd_uq0 D4/iovdd_uq0 sg13_hv_pmos ad=3.9294p pd=7.84u as=2.1312p ps=7.3u w=6.66u l=0.6u
M29 _n5 D4/a_5044_1676# vss vss sg13_hv_nmos ad=2.596p pd=5.58u as=1.408p ps=5.04u w=4.4u l=0.6u
M30 D4/iovdd_uq0 D4/a_5044_13476# _n5 D4/iovdd_uq0 sg13_hv_pmos ad=2.1312p pd=7.3u as=3.9294p ps=7.84u w=6.66u l=0.6u
X31 _n5c _n5 vss D4/rppd l=2u w=1u
M32 D4/iovdd_uq0 D4/a_5044_13476# _n5 D4/iovdd_uq0 sg13_hv_pmos ad=2.1312p pd=7.3u as=3.9294p ps=7.84u w=6.66u l=0.6u
M33 D4/iovdd_uq0 D4/a_5044_13476# _n5 D4/iovdd_uq0 sg13_hv_pmos ad=2.1312p pd=7.3u as=3.9294p ps=7.84u w=6.66u l=0.6u
M34 _n5 D4/a_5044_13476# D4/iovdd_uq0 D4/iovdd_uq0 sg13_hv_pmos ad=3.9294p pd=7.84u as=2.1312p ps=7.3u w=6.66u l=0.6u
M35 _n5 D4/a_5044_1676# vss vss sg13_hv_nmos ad=2.596p pd=5.58u as=1.408p ps=5.04u w=4.4u l=0.6u
M36 vss D4/a_5044_1676# _n5 vss sg13_hv_nmos ad=1.408p pd=5.04u as=2.596p ps=5.58u w=4.4u l=0.6u
M37 _n5 D4/a_5044_1676# vss vss sg13_hv_nmos ad=2.596p pd=5.58u as=1.408p ps=5.04u w=4.4u l=0.6u
M38 D4/iovdd_uq0 D4/a_5044_13476# _n5 D4/iovdd_uq0 sg13_hv_pmos ad=2.1312p pd=7.3u as=3.9294p ps=7.84u w=6.66u l=0.6u
M39 _n5 D4/a_5044_13476# D4/iovdd_uq0 D4/iovdd_uq0 sg13_hv_pmos ad=3.9294p pd=7.84u as=2.1312p ps=7.3u w=6.66u l=0.6u
X40 _n5 D4/iovdd_uq0 D4/dpantenna D4/l=1.26u w=27.78u
M41 vss D4/a_5044_1676# _n5 vss sg13_hv_nmos ad=1.408p pd=5.04u as=2.596p ps=5.58u w=4.4u l=0.6u
M42 D4/iovdd_uq0 D4/a_5044_13476# _n5 D4/iovdd_uq0 sg13_hv_pmos ad=2.1312p pd=7.3u as=3.9294p ps=7.84u w=6.66u l=0.6u
M43 vss D4/a_5044_1676# _n5 vss sg13_hv_nmos ad=1.408p pd=5.04u as=2.596p ps=5.58u w=4.4u l=0.6u
M44 _n5 D4/a_5044_13476# D4/iovdd_uq0 D4/iovdd_uq0 sg13_hv_pmos ad=3.9294p pd=7.84u as=2.1312p ps=7.3u w=6.66u l=0.6u
M45 D4/iovdd_uq0 D4/a_5044_13476# _n5 D4/iovdd_uq0 sg13_hv_pmos ad=2.1312p pd=7.3u as=3.9294p ps=7.84u w=6.66u l=0.6u
M46 _n5 D4/a_5044_13476# D4/iovdd_uq0 D4/iovdd_uq0 sg13_hv_pmos ad=3.9294p pd=7.84u as=2.1312p ps=7.3u w=6.66u l=0.6u
M47 _n5 D4/a_5044_1676# vss vss sg13_hv_nmos ad=2.596p pd=5.58u as=1.408p ps=5.04u w=4.4u l=0.6u
M48 vss D4/a_5044_1676# _n5 vss sg13_hv_nmos ad=1.408p pd=5.04u as=2.596p ps=5.58u w=4.4u l=0.6u
M49 _n5 D4/a_5044_13476# D4/iovdd_uq0 D4/iovdd_uq0 sg13_hv_pmos ad=3.9294p pd=7.84u as=3.1302p ps=14.26u w=6.66u l=0.6u
M50 D4/iovdd_uq0 D4/a_5044_13476# _n5 D4/iovdd_uq0 sg13_hv_pmos ad=3.1302p pd=14.26u as=3.9294p ps=7.84u w=6.66u l=0.6u
M51 D4/iovdd_uq0 D4/a_5044_13476# _n5 D4/iovdd_uq0 sg13_hv_pmos ad=2.1312p pd=7.3u as=3.9294p ps=7.84u w=6.66u l=0.6u
M52 _n5 D4/a_5044_13476# D4/iovdd_uq0 D4/iovdd_uq0 sg13_hv_pmos ad=3.9294p pd=7.84u as=2.1312p ps=7.3u w=6.66u l=0.6u
X53 _n5 D4/iovdd_uq0 D4/dpantenna D4/l=1.26u w=27.78u
M54 _n5 D4/a_5044_13476# D4/iovdd_uq0 D4/iovdd_uq0 sg13_hv_pmos ad=3.9294p pd=7.84u as=3.1302p ps=14.26u w=6.66u l=0.6u
M55 D4/iovdd_uq0 D4/a_5044_13476# _n5 D4/iovdd_uq0 sg13_hv_pmos ad=3.1302p pd=14.26u as=3.9294p ps=7.84u w=6.66u l=0.6u
M56 D4/iovdd_uq0 D4/a_5044_13476# _n5 D4/iovdd_uq0 sg13_hv_pmos ad=2.1312p pd=7.3u as=3.9294p ps=7.84u w=6.66u l=0.6u
M57 _n5 D4/a_5044_13476# D4/iovdd_uq0 D4/iovdd_uq0 sg13_hv_pmos ad=3.9294p pd=7.84u as=2.1312p ps=7.3u w=6.66u l=0.6u
X58 vss D4/a_11462_28198# D4/dantenna D4/l=3.1u w=0.64u
X59 vss D4/a_5222_3962# D4/dantenna D4/l=1.26u w=27.78u
X60 D4/a_5044_1676# vss vss D4/rppd l=3.54u w=0.5u
M61 D4/iovdd_uq0 D4/a_5044_13476# _n5 D4/iovdd_uq0 sg13_hv_pmos ad=2.1312p pd=7.3u as=3.9294p ps=7.84u w=6.66u l=0.6u
M62 D4/iovdd_uq0 D4/a_5044_13476# _n5 D4/iovdd_uq0 sg13_hv_pmos ad=2.1312p pd=7.3u as=3.9294p ps=7.84u w=6.66u l=0.6u
M63 _n5 D4/a_5044_1676# vss vss sg13_hv_nmos ad=2.596p pd=5.58u as=2.068p ps=9.74u w=4.4u l=0.6u
M64 D4/iovdd_uq0 D4/a_5044_13476# _n5 D4/iovdd_uq0 sg13_hv_pmos ad=2.1312p pd=7.3u as=3.9294p ps=7.84u w=6.66u l=0.6u
M65 _n5 D4/a_5044_13476# D4/iovdd_uq0 D4/iovdd_uq0 sg13_hv_pmos ad=3.9294p pd=7.84u as=2.1312p ps=7.3u w=6.66u l=0.6u
M66 _n5 D4/a_5044_13476# D4/iovdd_uq0 D4/iovdd_uq0 sg13_hv_pmos ad=3.9294p pd=7.84u as=2.1312p ps=7.3u w=6.66u l=0.6u
M67 _n5 D4/a_5044_13476# D4/iovdd_uq0 D4/iovdd_uq0 sg13_hv_pmos ad=3.9294p pd=7.84u as=2.1312p ps=7.3u w=6.66u l=0.6u
M68 vss D4/a_5044_1676# _n5 vss sg13_hv_nmos ad=1.408p pd=5.04u as=2.596p ps=5.58u w=4.4u l=0.6u
M0 D5/iovdd_uq0 D5/a_5044_13476# _n6 D5/iovdd_uq0 sg13_hv_pmos ad=2.1312p pd=7.3u as=3.9294p ps=7.84u w=6.66u l=0.6u
M1 _n6 D5/a_5044_1676# vss vss sg13_hv_nmos ad=2.596p pd=5.58u as=1.408p ps=5.04u w=4.4u l=0.6u
M2 _n6 D5/a_5044_13476# D5/iovdd_uq0 D5/iovdd_uq0 sg13_hv_pmos ad=3.9294p pd=7.84u as=2.1312p ps=7.3u w=6.66u l=0.6u
M3 D5/iovdd_uq0 D5/a_5044_13476# _n6 D5/iovdd_uq0 sg13_hv_pmos ad=2.1312p pd=7.3u as=3.9294p ps=7.84u w=6.66u l=0.6u
M4 D5/iovdd_uq0 D5/a_5044_13476# _n6 D5/iovdd_uq0 sg13_hv_pmos ad=2.1312p pd=7.3u as=3.9294p ps=7.84u w=6.66u l=0.6u
M5 _n6 D5/a_5044_1676# vss vss sg13_hv_nmos ad=2.596p pd=5.58u as=1.408p ps=5.04u w=4.4u l=0.6u
M6 _n6 D5/a_5044_13476# D5/iovdd_uq0 D5/iovdd_uq0 sg13_hv_pmos ad=3.9294p pd=7.84u as=2.1312p ps=7.3u w=6.66u l=0.6u
M7 D5/iovdd_uq0 D5/a_5044_13476# _n6 D5/iovdd_uq0 sg13_hv_pmos ad=2.1312p pd=7.3u as=3.9294p ps=7.84u w=6.66u l=0.6u
M8 _n6 D5/a_5044_1676# vss vss sg13_hv_nmos ad=2.596p pd=5.58u as=1.408p ps=5.04u w=4.4u l=0.6u
M9 vss D5/a_5044_1676# _n6 vss sg13_hv_nmos ad=2.068p pd=9.74u as=2.596p ps=5.58u w=4.4u l=0.6u
M10 _n6 D5/a_5044_13476# D5/iovdd_uq0 D5/iovdd_uq0 sg13_hv_pmos ad=3.9294p pd=7.84u as=2.1312p ps=7.3u w=6.66u l=0.6u
X11 D5/a_5044_13476# D5/iovdd_uq0 D5/iovdd_uq0 D5/rppd l=12.9u w=0.5u
M12 vss D5/a_5044_1676# _n6 vss sg13_hv_nmos ad=1.408p pd=5.04u as=2.596p ps=5.58u w=4.4u l=0.6u
M13 _n6 D5/a_5044_13476# D5/iovdd_uq0 D5/iovdd_uq0 sg13_hv_pmos ad=3.9294p pd=7.84u as=2.1312p ps=7.3u w=6.66u l=0.6u
X14 vss D5/a_5222_4862# D5/dantenna D5/l=1.26u w=27.78u
M15 vss D5/a_5044_1676# _n6 vss sg13_hv_nmos ad=1.408p pd=5.04u as=2.596p ps=5.58u w=4.4u l=0.6u
M16 _n6 D5/a_5044_1676# vss vss sg13_hv_nmos ad=2.596p pd=5.58u as=1.408p ps=5.04u w=4.4u l=0.6u
M17 vss D5/a_5044_1676# _n6 vss sg13_hv_nmos ad=1.408p pd=5.04u as=2.596p ps=5.58u w=4.4u l=0.6u
M18 D5/iovdd_uq0 D5/a_5044_13476# _n6 D5/iovdd_uq0 sg13_hv_pmos ad=2.1312p pd=7.3u as=3.9294p ps=7.84u w=6.66u l=0.6u
M19 _n6 D5/a_5044_1676# vss vss sg13_hv_nmos ad=2.596p pd=5.58u as=1.408p ps=5.04u w=4.4u l=0.6u
M20 _n6 D5/a_5044_13476# D5/iovdd_uq0 D5/iovdd_uq0 sg13_hv_pmos ad=3.9294p pd=7.84u as=2.1312p ps=7.3u w=6.66u l=0.6u
M21 D5/iovdd_uq0 D5/a_5044_13476# _n6 D5/iovdd_uq0 sg13_hv_pmos ad=2.1312p pd=7.3u as=3.9294p ps=7.84u w=6.66u l=0.6u
M22 _n6 D5/a_5044_13476# D5/iovdd_uq0 D5/iovdd_uq0 sg13_hv_pmos ad=3.9294p pd=7.84u as=2.1312p ps=7.3u w=6.66u l=0.6u
M23 _n6 D5/a_5044_13476# D5/iovdd_uq0 D5/iovdd_uq0 sg13_hv_pmos ad=3.9294p pd=7.84u as=2.1312p ps=7.3u w=6.66u l=0.6u
M24 vss D5/a_5044_1676# _n6 vss sg13_hv_nmos ad=1.408p pd=5.04u as=2.596p ps=5.58u w=4.4u l=0.6u
X25 _n6c D5/iovdd D5/dpantenna D5/l=0.64u w=4.98u
M26 D5/iovdd_uq0 D5/a_5044_13476# _n6 D5/iovdd_uq0 sg13_hv_pmos ad=2.1312p pd=7.3u as=3.9294p ps=7.84u w=6.66u l=0.6u
M27 _n6 D5/a_5044_13476# D5/iovdd_uq0 D5/iovdd_uq0 sg13_hv_pmos ad=3.9294p pd=7.84u as=2.1312p ps=7.3u w=6.66u l=0.6u
M28 _n6 D5/a_5044_13476# D5/iovdd_uq0 D5/iovdd_uq0 sg13_hv_pmos ad=3.9294p pd=7.84u as=2.1312p ps=7.3u w=6.66u l=0.6u
M29 _n6 D5/a_5044_1676# vss vss sg13_hv_nmos ad=2.596p pd=5.58u as=1.408p ps=5.04u w=4.4u l=0.6u
M30 D5/iovdd_uq0 D5/a_5044_13476# _n6 D5/iovdd_uq0 sg13_hv_pmos ad=2.1312p pd=7.3u as=3.9294p ps=7.84u w=6.66u l=0.6u
X31 _n6c _n6 vss D5/rppd l=2u w=1u
M32 D5/iovdd_uq0 D5/a_5044_13476# _n6 D5/iovdd_uq0 sg13_hv_pmos ad=2.1312p pd=7.3u as=3.9294p ps=7.84u w=6.66u l=0.6u
M33 D5/iovdd_uq0 D5/a_5044_13476# _n6 D5/iovdd_uq0 sg13_hv_pmos ad=2.1312p pd=7.3u as=3.9294p ps=7.84u w=6.66u l=0.6u
M34 _n6 D5/a_5044_13476# D5/iovdd_uq0 D5/iovdd_uq0 sg13_hv_pmos ad=3.9294p pd=7.84u as=2.1312p ps=7.3u w=6.66u l=0.6u
M35 _n6 D5/a_5044_1676# vss vss sg13_hv_nmos ad=2.596p pd=5.58u as=1.408p ps=5.04u w=4.4u l=0.6u
M36 vss D5/a_5044_1676# _n6 vss sg13_hv_nmos ad=1.408p pd=5.04u as=2.596p ps=5.58u w=4.4u l=0.6u
M37 _n6 D5/a_5044_1676# vss vss sg13_hv_nmos ad=2.596p pd=5.58u as=1.408p ps=5.04u w=4.4u l=0.6u
M38 D5/iovdd_uq0 D5/a_5044_13476# _n6 D5/iovdd_uq0 sg13_hv_pmos ad=2.1312p pd=7.3u as=3.9294p ps=7.84u w=6.66u l=0.6u
M39 _n6 D5/a_5044_13476# D5/iovdd_uq0 D5/iovdd_uq0 sg13_hv_pmos ad=3.9294p pd=7.84u as=2.1312p ps=7.3u w=6.66u l=0.6u
X40 _n6 D5/iovdd_uq0 D5/dpantenna D5/l=1.26u w=27.78u
M41 vss D5/a_5044_1676# _n6 vss sg13_hv_nmos ad=1.408p pd=5.04u as=2.596p ps=5.58u w=4.4u l=0.6u
M42 D5/iovdd_uq0 D5/a_5044_13476# _n6 D5/iovdd_uq0 sg13_hv_pmos ad=2.1312p pd=7.3u as=3.9294p ps=7.84u w=6.66u l=0.6u
M43 vss D5/a_5044_1676# _n6 vss sg13_hv_nmos ad=1.408p pd=5.04u as=2.596p ps=5.58u w=4.4u l=0.6u
M44 _n6 D5/a_5044_13476# D5/iovdd_uq0 D5/iovdd_uq0 sg13_hv_pmos ad=3.9294p pd=7.84u as=2.1312p ps=7.3u w=6.66u l=0.6u
M45 D5/iovdd_uq0 D5/a_5044_13476# _n6 D5/iovdd_uq0 sg13_hv_pmos ad=2.1312p pd=7.3u as=3.9294p ps=7.84u w=6.66u l=0.6u
M46 _n6 D5/a_5044_13476# D5/iovdd_uq0 D5/iovdd_uq0 sg13_hv_pmos ad=3.9294p pd=7.84u as=2.1312p ps=7.3u w=6.66u l=0.6u
M47 _n6 D5/a_5044_1676# vss vss sg13_hv_nmos ad=2.596p pd=5.58u as=1.408p ps=5.04u w=4.4u l=0.6u
M48 vss D5/a_5044_1676# _n6 vss sg13_hv_nmos ad=1.408p pd=5.04u as=2.596p ps=5.58u w=4.4u l=0.6u
M49 _n6 D5/a_5044_13476# D5/iovdd_uq0 D5/iovdd_uq0 sg13_hv_pmos ad=3.9294p pd=7.84u as=3.1302p ps=14.26u w=6.66u l=0.6u
M50 D5/iovdd_uq0 D5/a_5044_13476# _n6 D5/iovdd_uq0 sg13_hv_pmos ad=3.1302p pd=14.26u as=3.9294p ps=7.84u w=6.66u l=0.6u
M51 D5/iovdd_uq0 D5/a_5044_13476# _n6 D5/iovdd_uq0 sg13_hv_pmos ad=2.1312p pd=7.3u as=3.9294p ps=7.84u w=6.66u l=0.6u
M52 _n6 D5/a_5044_13476# D5/iovdd_uq0 D5/iovdd_uq0 sg13_hv_pmos ad=3.9294p pd=7.84u as=2.1312p ps=7.3u w=6.66u l=0.6u
X53 _n6 D5/iovdd_uq0 D5/dpantenna D5/l=1.26u w=27.78u
M54 _n6 D5/a_5044_13476# D5/iovdd_uq0 D5/iovdd_uq0 sg13_hv_pmos ad=3.9294p pd=7.84u as=3.1302p ps=14.26u w=6.66u l=0.6u
M55 D5/iovdd_uq0 D5/a_5044_13476# _n6 D5/iovdd_uq0 sg13_hv_pmos ad=3.1302p pd=14.26u as=3.9294p ps=7.84u w=6.66u l=0.6u
M56 D5/iovdd_uq0 D5/a_5044_13476# _n6 D5/iovdd_uq0 sg13_hv_pmos ad=2.1312p pd=7.3u as=3.9294p ps=7.84u w=6.66u l=0.6u
M57 _n6 D5/a_5044_13476# D5/iovdd_uq0 D5/iovdd_uq0 sg13_hv_pmos ad=3.9294p pd=7.84u as=2.1312p ps=7.3u w=6.66u l=0.6u
X58 vss D5/a_11462_28198# D5/dantenna D5/l=3.1u w=0.64u
X59 vss D5/a_5222_3962# D5/dantenna D5/l=1.26u w=27.78u
X60 D5/a_5044_1676# vss vss D5/rppd l=3.54u w=0.5u
M61 D5/iovdd_uq0 D5/a_5044_13476# _n6 D5/iovdd_uq0 sg13_hv_pmos ad=2.1312p pd=7.3u as=3.9294p ps=7.84u w=6.66u l=0.6u
M62 D5/iovdd_uq0 D5/a_5044_13476# _n6 D5/iovdd_uq0 sg13_hv_pmos ad=2.1312p pd=7.3u as=3.9294p ps=7.84u w=6.66u l=0.6u
M63 _n6 D5/a_5044_1676# vss vss sg13_hv_nmos ad=2.596p pd=5.58u as=2.068p ps=9.74u w=4.4u l=0.6u
M64 D5/iovdd_uq0 D5/a_5044_13476# _n6 D5/iovdd_uq0 sg13_hv_pmos ad=2.1312p pd=7.3u as=3.9294p ps=7.84u w=6.66u l=0.6u
M65 _n6 D5/a_5044_13476# D5/iovdd_uq0 D5/iovdd_uq0 sg13_hv_pmos ad=3.9294p pd=7.84u as=2.1312p ps=7.3u w=6.66u l=0.6u
M66 _n6 D5/a_5044_13476# D5/iovdd_uq0 D5/iovdd_uq0 sg13_hv_pmos ad=3.9294p pd=7.84u as=2.1312p ps=7.3u w=6.66u l=0.6u
M67 _n6 D5/a_5044_13476# D5/iovdd_uq0 D5/iovdd_uq0 sg13_hv_pmos ad=3.9294p pd=7.84u as=2.1312p ps=7.3u w=6.66u l=0.6u
M68 vss D5/a_5044_1676# _n6 vss sg13_hv_nmos ad=1.408p pd=5.04u as=2.596p ps=5.58u w=4.4u l=0.6u
M0 D6/iovdd_uq0 D6/a_5044_13476# _n7 D6/iovdd_uq0 sg13_hv_pmos ad=2.1312p pd=7.3u as=3.9294p ps=7.84u w=6.66u l=0.6u
M1 _n7 D6/a_5044_1676# vss vss sg13_hv_nmos ad=2.596p pd=5.58u as=1.408p ps=5.04u w=4.4u l=0.6u
M2 _n7 D6/a_5044_13476# D6/iovdd_uq0 D6/iovdd_uq0 sg13_hv_pmos ad=3.9294p pd=7.84u as=2.1312p ps=7.3u w=6.66u l=0.6u
M3 D6/iovdd_uq0 D6/a_5044_13476# _n7 D6/iovdd_uq0 sg13_hv_pmos ad=2.1312p pd=7.3u as=3.9294p ps=7.84u w=6.66u l=0.6u
M4 D6/iovdd_uq0 D6/a_5044_13476# _n7 D6/iovdd_uq0 sg13_hv_pmos ad=2.1312p pd=7.3u as=3.9294p ps=7.84u w=6.66u l=0.6u
M5 _n7 D6/a_5044_1676# vss vss sg13_hv_nmos ad=2.596p pd=5.58u as=1.408p ps=5.04u w=4.4u l=0.6u
M6 _n7 D6/a_5044_13476# D6/iovdd_uq0 D6/iovdd_uq0 sg13_hv_pmos ad=3.9294p pd=7.84u as=2.1312p ps=7.3u w=6.66u l=0.6u
M7 D6/iovdd_uq0 D6/a_5044_13476# _n7 D6/iovdd_uq0 sg13_hv_pmos ad=2.1312p pd=7.3u as=3.9294p ps=7.84u w=6.66u l=0.6u
M8 _n7 D6/a_5044_1676# vss vss sg13_hv_nmos ad=2.596p pd=5.58u as=1.408p ps=5.04u w=4.4u l=0.6u
M9 vss D6/a_5044_1676# _n7 vss sg13_hv_nmos ad=2.068p pd=9.74u as=2.596p ps=5.58u w=4.4u l=0.6u
M10 _n7 D6/a_5044_13476# D6/iovdd_uq0 D6/iovdd_uq0 sg13_hv_pmos ad=3.9294p pd=7.84u as=2.1312p ps=7.3u w=6.66u l=0.6u
X11 D6/a_5044_13476# D6/iovdd_uq0 D6/iovdd_uq0 D6/rppd l=12.9u w=0.5u
M12 vss D6/a_5044_1676# _n7 vss sg13_hv_nmos ad=1.408p pd=5.04u as=2.596p ps=5.58u w=4.4u l=0.6u
M13 _n7 D6/a_5044_13476# D6/iovdd_uq0 D6/iovdd_uq0 sg13_hv_pmos ad=3.9294p pd=7.84u as=2.1312p ps=7.3u w=6.66u l=0.6u
X14 vss D6/a_5222_4862# D6/dantenna D6/l=1.26u w=27.78u
M15 vss D6/a_5044_1676# _n7 vss sg13_hv_nmos ad=1.408p pd=5.04u as=2.596p ps=5.58u w=4.4u l=0.6u
M16 _n7 D6/a_5044_1676# vss vss sg13_hv_nmos ad=2.596p pd=5.58u as=1.408p ps=5.04u w=4.4u l=0.6u
M17 vss D6/a_5044_1676# _n7 vss sg13_hv_nmos ad=1.408p pd=5.04u as=2.596p ps=5.58u w=4.4u l=0.6u
M18 D6/iovdd_uq0 D6/a_5044_13476# _n7 D6/iovdd_uq0 sg13_hv_pmos ad=2.1312p pd=7.3u as=3.9294p ps=7.84u w=6.66u l=0.6u
M19 _n7 D6/a_5044_1676# vss vss sg13_hv_nmos ad=2.596p pd=5.58u as=1.408p ps=5.04u w=4.4u l=0.6u
M20 _n7 D6/a_5044_13476# D6/iovdd_uq0 D6/iovdd_uq0 sg13_hv_pmos ad=3.9294p pd=7.84u as=2.1312p ps=7.3u w=6.66u l=0.6u
M21 D6/iovdd_uq0 D6/a_5044_13476# _n7 D6/iovdd_uq0 sg13_hv_pmos ad=2.1312p pd=7.3u as=3.9294p ps=7.84u w=6.66u l=0.6u
M22 _n7 D6/a_5044_13476# D6/iovdd_uq0 D6/iovdd_uq0 sg13_hv_pmos ad=3.9294p pd=7.84u as=2.1312p ps=7.3u w=6.66u l=0.6u
M23 _n7 D6/a_5044_13476# D6/iovdd_uq0 D6/iovdd_uq0 sg13_hv_pmos ad=3.9294p pd=7.84u as=2.1312p ps=7.3u w=6.66u l=0.6u
M24 vss D6/a_5044_1676# _n7 vss sg13_hv_nmos ad=1.408p pd=5.04u as=2.596p ps=5.58u w=4.4u l=0.6u
X25 _n7c D6/iovdd D6/dpantenna D6/l=0.64u w=4.98u
M26 D6/iovdd_uq0 D6/a_5044_13476# _n7 D6/iovdd_uq0 sg13_hv_pmos ad=2.1312p pd=7.3u as=3.9294p ps=7.84u w=6.66u l=0.6u
M27 _n7 D6/a_5044_13476# D6/iovdd_uq0 D6/iovdd_uq0 sg13_hv_pmos ad=3.9294p pd=7.84u as=2.1312p ps=7.3u w=6.66u l=0.6u
M28 _n7 D6/a_5044_13476# D6/iovdd_uq0 D6/iovdd_uq0 sg13_hv_pmos ad=3.9294p pd=7.84u as=2.1312p ps=7.3u w=6.66u l=0.6u
M29 _n7 D6/a_5044_1676# vss vss sg13_hv_nmos ad=2.596p pd=5.58u as=1.408p ps=5.04u w=4.4u l=0.6u
M30 D6/iovdd_uq0 D6/a_5044_13476# _n7 D6/iovdd_uq0 sg13_hv_pmos ad=2.1312p pd=7.3u as=3.9294p ps=7.84u w=6.66u l=0.6u
X31 _n7c _n7 vss D6/rppd l=2u w=1u
M32 D6/iovdd_uq0 D6/a_5044_13476# _n7 D6/iovdd_uq0 sg13_hv_pmos ad=2.1312p pd=7.3u as=3.9294p ps=7.84u w=6.66u l=0.6u
M33 D6/iovdd_uq0 D6/a_5044_13476# _n7 D6/iovdd_uq0 sg13_hv_pmos ad=2.1312p pd=7.3u as=3.9294p ps=7.84u w=6.66u l=0.6u
M34 _n7 D6/a_5044_13476# D6/iovdd_uq0 D6/iovdd_uq0 sg13_hv_pmos ad=3.9294p pd=7.84u as=2.1312p ps=7.3u w=6.66u l=0.6u
M35 _n7 D6/a_5044_1676# vss vss sg13_hv_nmos ad=2.596p pd=5.58u as=1.408p ps=5.04u w=4.4u l=0.6u
M36 vss D6/a_5044_1676# _n7 vss sg13_hv_nmos ad=1.408p pd=5.04u as=2.596p ps=5.58u w=4.4u l=0.6u
M37 _n7 D6/a_5044_1676# vss vss sg13_hv_nmos ad=2.596p pd=5.58u as=1.408p ps=5.04u w=4.4u l=0.6u
M38 D6/iovdd_uq0 D6/a_5044_13476# _n7 D6/iovdd_uq0 sg13_hv_pmos ad=2.1312p pd=7.3u as=3.9294p ps=7.84u w=6.66u l=0.6u
M39 _n7 D6/a_5044_13476# D6/iovdd_uq0 D6/iovdd_uq0 sg13_hv_pmos ad=3.9294p pd=7.84u as=2.1312p ps=7.3u w=6.66u l=0.6u
X40 _n7 D6/iovdd_uq0 D6/dpantenna D6/l=1.26u w=27.78u
M41 vss D6/a_5044_1676# _n7 vss sg13_hv_nmos ad=1.408p pd=5.04u as=2.596p ps=5.58u w=4.4u l=0.6u
M42 D6/iovdd_uq0 D6/a_5044_13476# _n7 D6/iovdd_uq0 sg13_hv_pmos ad=2.1312p pd=7.3u as=3.9294p ps=7.84u w=6.66u l=0.6u
M43 vss D6/a_5044_1676# _n7 vss sg13_hv_nmos ad=1.408p pd=5.04u as=2.596p ps=5.58u w=4.4u l=0.6u
M44 _n7 D6/a_5044_13476# D6/iovdd_uq0 D6/iovdd_uq0 sg13_hv_pmos ad=3.9294p pd=7.84u as=2.1312p ps=7.3u w=6.66u l=0.6u
M45 D6/iovdd_uq0 D6/a_5044_13476# _n7 D6/iovdd_uq0 sg13_hv_pmos ad=2.1312p pd=7.3u as=3.9294p ps=7.84u w=6.66u l=0.6u
M46 _n7 D6/a_5044_13476# D6/iovdd_uq0 D6/iovdd_uq0 sg13_hv_pmos ad=3.9294p pd=7.84u as=2.1312p ps=7.3u w=6.66u l=0.6u
M47 _n7 D6/a_5044_1676# vss vss sg13_hv_nmos ad=2.596p pd=5.58u as=1.408p ps=5.04u w=4.4u l=0.6u
M48 vss D6/a_5044_1676# _n7 vss sg13_hv_nmos ad=1.408p pd=5.04u as=2.596p ps=5.58u w=4.4u l=0.6u
M49 _n7 D6/a_5044_13476# D6/iovdd_uq0 D6/iovdd_uq0 sg13_hv_pmos ad=3.9294p pd=7.84u as=3.1302p ps=14.26u w=6.66u l=0.6u
M50 D6/iovdd_uq0 D6/a_5044_13476# _n7 D6/iovdd_uq0 sg13_hv_pmos ad=3.1302p pd=14.26u as=3.9294p ps=7.84u w=6.66u l=0.6u
M51 D6/iovdd_uq0 D6/a_5044_13476# _n7 D6/iovdd_uq0 sg13_hv_pmos ad=2.1312p pd=7.3u as=3.9294p ps=7.84u w=6.66u l=0.6u
M52 _n7 D6/a_5044_13476# D6/iovdd_uq0 D6/iovdd_uq0 sg13_hv_pmos ad=3.9294p pd=7.84u as=2.1312p ps=7.3u w=6.66u l=0.6u
X53 _n7 D6/iovdd_uq0 D6/dpantenna D6/l=1.26u w=27.78u
M54 _n7 D6/a_5044_13476# D6/iovdd_uq0 D6/iovdd_uq0 sg13_hv_pmos ad=3.9294p pd=7.84u as=3.1302p ps=14.26u w=6.66u l=0.6u
M55 D6/iovdd_uq0 D6/a_5044_13476# _n7 D6/iovdd_uq0 sg13_hv_pmos ad=3.1302p pd=14.26u as=3.9294p ps=7.84u w=6.66u l=0.6u
M56 D6/iovdd_uq0 D6/a_5044_13476# _n7 D6/iovdd_uq0 sg13_hv_pmos ad=2.1312p pd=7.3u as=3.9294p ps=7.84u w=6.66u l=0.6u
M57 _n7 D6/a_5044_13476# D6/iovdd_uq0 D6/iovdd_uq0 sg13_hv_pmos ad=3.9294p pd=7.84u as=2.1312p ps=7.3u w=6.66u l=0.6u
X58 vss D6/a_11462_28198# D6/dantenna D6/l=3.1u w=0.64u
X59 vss D6/a_5222_3962# D6/dantenna D6/l=1.26u w=27.78u
X60 D6/a_5044_1676# vss vss D6/rppd l=3.54u w=0.5u
M61 D6/iovdd_uq0 D6/a_5044_13476# _n7 D6/iovdd_uq0 sg13_hv_pmos ad=2.1312p pd=7.3u as=3.9294p ps=7.84u w=6.66u l=0.6u
M62 D6/iovdd_uq0 D6/a_5044_13476# _n7 D6/iovdd_uq0 sg13_hv_pmos ad=2.1312p pd=7.3u as=3.9294p ps=7.84u w=6.66u l=0.6u
M63 _n7 D6/a_5044_1676# vss vss sg13_hv_nmos ad=2.596p pd=5.58u as=2.068p ps=9.74u w=4.4u l=0.6u
M64 D6/iovdd_uq0 D6/a_5044_13476# _n7 D6/iovdd_uq0 sg13_hv_pmos ad=2.1312p pd=7.3u as=3.9294p ps=7.84u w=6.66u l=0.6u
M65 _n7 D6/a_5044_13476# D6/iovdd_uq0 D6/iovdd_uq0 sg13_hv_pmos ad=3.9294p pd=7.84u as=2.1312p ps=7.3u w=6.66u l=0.6u
M66 _n7 D6/a_5044_13476# D6/iovdd_uq0 D6/iovdd_uq0 sg13_hv_pmos ad=3.9294p pd=7.84u as=2.1312p ps=7.3u w=6.66u l=0.6u
M67 _n7 D6/a_5044_13476# D6/iovdd_uq0 D6/iovdd_uq0 sg13_hv_pmos ad=3.9294p pd=7.84u as=2.1312p ps=7.3u w=6.66u l=0.6u
M68 vss D6/a_5044_1676# _n7 vss sg13_hv_nmos ad=1.408p pd=5.04u as=2.596p ps=5.58u w=4.4u l=0.6u
M0 D7/iovdd_uq0 D7/a_5044_13476# _n8 D7/iovdd_uq0 sg13_hv_pmos ad=2.1312p pd=7.3u as=3.9294p ps=7.84u w=6.66u l=0.6u
M1 _n8 D7/a_5044_1676# vss vss sg13_hv_nmos ad=2.596p pd=5.58u as=1.408p ps=5.04u w=4.4u l=0.6u
M2 _n8 D7/a_5044_13476# D7/iovdd_uq0 D7/iovdd_uq0 sg13_hv_pmos ad=3.9294p pd=7.84u as=2.1312p ps=7.3u w=6.66u l=0.6u
M3 D7/iovdd_uq0 D7/a_5044_13476# _n8 D7/iovdd_uq0 sg13_hv_pmos ad=2.1312p pd=7.3u as=3.9294p ps=7.84u w=6.66u l=0.6u
M4 D7/iovdd_uq0 D7/a_5044_13476# _n8 D7/iovdd_uq0 sg13_hv_pmos ad=2.1312p pd=7.3u as=3.9294p ps=7.84u w=6.66u l=0.6u
M5 _n8 D7/a_5044_1676# vss vss sg13_hv_nmos ad=2.596p pd=5.58u as=1.408p ps=5.04u w=4.4u l=0.6u
M6 _n8 D7/a_5044_13476# D7/iovdd_uq0 D7/iovdd_uq0 sg13_hv_pmos ad=3.9294p pd=7.84u as=2.1312p ps=7.3u w=6.66u l=0.6u
M7 D7/iovdd_uq0 D7/a_5044_13476# _n8 D7/iovdd_uq0 sg13_hv_pmos ad=2.1312p pd=7.3u as=3.9294p ps=7.84u w=6.66u l=0.6u
M8 _n8 D7/a_5044_1676# vss vss sg13_hv_nmos ad=2.596p pd=5.58u as=1.408p ps=5.04u w=4.4u l=0.6u
M9 vss D7/a_5044_1676# _n8 vss sg13_hv_nmos ad=2.068p pd=9.74u as=2.596p ps=5.58u w=4.4u l=0.6u
M10 _n8 D7/a_5044_13476# D7/iovdd_uq0 D7/iovdd_uq0 sg13_hv_pmos ad=3.9294p pd=7.84u as=2.1312p ps=7.3u w=6.66u l=0.6u
X11 D7/a_5044_13476# D7/iovdd_uq0 D7/iovdd_uq0 D7/rppd l=12.9u w=0.5u
M12 vss D7/a_5044_1676# _n8 vss sg13_hv_nmos ad=1.408p pd=5.04u as=2.596p ps=5.58u w=4.4u l=0.6u
M13 _n8 D7/a_5044_13476# D7/iovdd_uq0 D7/iovdd_uq0 sg13_hv_pmos ad=3.9294p pd=7.84u as=2.1312p ps=7.3u w=6.66u l=0.6u
X14 vss D7/a_5222_4862# D7/dantenna D7/l=1.26u w=27.78u
M15 vss D7/a_5044_1676# _n8 vss sg13_hv_nmos ad=1.408p pd=5.04u as=2.596p ps=5.58u w=4.4u l=0.6u
M16 _n8 D7/a_5044_1676# vss vss sg13_hv_nmos ad=2.596p pd=5.58u as=1.408p ps=5.04u w=4.4u l=0.6u
M17 vss D7/a_5044_1676# _n8 vss sg13_hv_nmos ad=1.408p pd=5.04u as=2.596p ps=5.58u w=4.4u l=0.6u
M18 D7/iovdd_uq0 D7/a_5044_13476# _n8 D7/iovdd_uq0 sg13_hv_pmos ad=2.1312p pd=7.3u as=3.9294p ps=7.84u w=6.66u l=0.6u
M19 _n8 D7/a_5044_1676# vss vss sg13_hv_nmos ad=2.596p pd=5.58u as=1.408p ps=5.04u w=4.4u l=0.6u
M20 _n8 D7/a_5044_13476# D7/iovdd_uq0 D7/iovdd_uq0 sg13_hv_pmos ad=3.9294p pd=7.84u as=2.1312p ps=7.3u w=6.66u l=0.6u
M21 D7/iovdd_uq0 D7/a_5044_13476# _n8 D7/iovdd_uq0 sg13_hv_pmos ad=2.1312p pd=7.3u as=3.9294p ps=7.84u w=6.66u l=0.6u
M22 _n8 D7/a_5044_13476# D7/iovdd_uq0 D7/iovdd_uq0 sg13_hv_pmos ad=3.9294p pd=7.84u as=2.1312p ps=7.3u w=6.66u l=0.6u
M23 _n8 D7/a_5044_13476# D7/iovdd_uq0 D7/iovdd_uq0 sg13_hv_pmos ad=3.9294p pd=7.84u as=2.1312p ps=7.3u w=6.66u l=0.6u
M24 vss D7/a_5044_1676# _n8 vss sg13_hv_nmos ad=1.408p pd=5.04u as=2.596p ps=5.58u w=4.4u l=0.6u
X25 _n8c D7/iovdd D7/dpantenna D7/l=0.64u w=4.98u
M26 D7/iovdd_uq0 D7/a_5044_13476# _n8 D7/iovdd_uq0 sg13_hv_pmos ad=2.1312p pd=7.3u as=3.9294p ps=7.84u w=6.66u l=0.6u
M27 _n8 D7/a_5044_13476# D7/iovdd_uq0 D7/iovdd_uq0 sg13_hv_pmos ad=3.9294p pd=7.84u as=2.1312p ps=7.3u w=6.66u l=0.6u
M28 _n8 D7/a_5044_13476# D7/iovdd_uq0 D7/iovdd_uq0 sg13_hv_pmos ad=3.9294p pd=7.84u as=2.1312p ps=7.3u w=6.66u l=0.6u
M29 _n8 D7/a_5044_1676# vss vss sg13_hv_nmos ad=2.596p pd=5.58u as=1.408p ps=5.04u w=4.4u l=0.6u
M30 D7/iovdd_uq0 D7/a_5044_13476# _n8 D7/iovdd_uq0 sg13_hv_pmos ad=2.1312p pd=7.3u as=3.9294p ps=7.84u w=6.66u l=0.6u
X31 _n8c _n8 vss D7/rppd l=2u w=1u
M32 D7/iovdd_uq0 D7/a_5044_13476# _n8 D7/iovdd_uq0 sg13_hv_pmos ad=2.1312p pd=7.3u as=3.9294p ps=7.84u w=6.66u l=0.6u
M33 D7/iovdd_uq0 D7/a_5044_13476# _n8 D7/iovdd_uq0 sg13_hv_pmos ad=2.1312p pd=7.3u as=3.9294p ps=7.84u w=6.66u l=0.6u
M34 _n8 D7/a_5044_13476# D7/iovdd_uq0 D7/iovdd_uq0 sg13_hv_pmos ad=3.9294p pd=7.84u as=2.1312p ps=7.3u w=6.66u l=0.6u
M35 _n8 D7/a_5044_1676# vss vss sg13_hv_nmos ad=2.596p pd=5.58u as=1.408p ps=5.04u w=4.4u l=0.6u
M36 vss D7/a_5044_1676# _n8 vss sg13_hv_nmos ad=1.408p pd=5.04u as=2.596p ps=5.58u w=4.4u l=0.6u
M37 _n8 D7/a_5044_1676# vss vss sg13_hv_nmos ad=2.596p pd=5.58u as=1.408p ps=5.04u w=4.4u l=0.6u
M38 D7/iovdd_uq0 D7/a_5044_13476# _n8 D7/iovdd_uq0 sg13_hv_pmos ad=2.1312p pd=7.3u as=3.9294p ps=7.84u w=6.66u l=0.6u
M39 _n8 D7/a_5044_13476# D7/iovdd_uq0 D7/iovdd_uq0 sg13_hv_pmos ad=3.9294p pd=7.84u as=2.1312p ps=7.3u w=6.66u l=0.6u
X40 _n8 D7/iovdd_uq0 D7/dpantenna D7/l=1.26u w=27.78u
M41 vss D7/a_5044_1676# _n8 vss sg13_hv_nmos ad=1.408p pd=5.04u as=2.596p ps=5.58u w=4.4u l=0.6u
M42 D7/iovdd_uq0 D7/a_5044_13476# _n8 D7/iovdd_uq0 sg13_hv_pmos ad=2.1312p pd=7.3u as=3.9294p ps=7.84u w=6.66u l=0.6u
M43 vss D7/a_5044_1676# _n8 vss sg13_hv_nmos ad=1.408p pd=5.04u as=2.596p ps=5.58u w=4.4u l=0.6u
M44 _n8 D7/a_5044_13476# D7/iovdd_uq0 D7/iovdd_uq0 sg13_hv_pmos ad=3.9294p pd=7.84u as=2.1312p ps=7.3u w=6.66u l=0.6u
M45 D7/iovdd_uq0 D7/a_5044_13476# _n8 D7/iovdd_uq0 sg13_hv_pmos ad=2.1312p pd=7.3u as=3.9294p ps=7.84u w=6.66u l=0.6u
M46 _n8 D7/a_5044_13476# D7/iovdd_uq0 D7/iovdd_uq0 sg13_hv_pmos ad=3.9294p pd=7.84u as=2.1312p ps=7.3u w=6.66u l=0.6u
M47 _n8 D7/a_5044_1676# vss vss sg13_hv_nmos ad=2.596p pd=5.58u as=1.408p ps=5.04u w=4.4u l=0.6u
M48 vss D7/a_5044_1676# _n8 vss sg13_hv_nmos ad=1.408p pd=5.04u as=2.596p ps=5.58u w=4.4u l=0.6u
M49 _n8 D7/a_5044_13476# D7/iovdd_uq0 D7/iovdd_uq0 sg13_hv_pmos ad=3.9294p pd=7.84u as=3.1302p ps=14.26u w=6.66u l=0.6u
M50 D7/iovdd_uq0 D7/a_5044_13476# _n8 D7/iovdd_uq0 sg13_hv_pmos ad=3.1302p pd=14.26u as=3.9294p ps=7.84u w=6.66u l=0.6u
M51 D7/iovdd_uq0 D7/a_5044_13476# _n8 D7/iovdd_uq0 sg13_hv_pmos ad=2.1312p pd=7.3u as=3.9294p ps=7.84u w=6.66u l=0.6u
M52 _n8 D7/a_5044_13476# D7/iovdd_uq0 D7/iovdd_uq0 sg13_hv_pmos ad=3.9294p pd=7.84u as=2.1312p ps=7.3u w=6.66u l=0.6u
X53 _n8 D7/iovdd_uq0 D7/dpantenna D7/l=1.26u w=27.78u
M54 _n8 D7/a_5044_13476# D7/iovdd_uq0 D7/iovdd_uq0 sg13_hv_pmos ad=3.9294p pd=7.84u as=3.1302p ps=14.26u w=6.66u l=0.6u
M55 D7/iovdd_uq0 D7/a_5044_13476# _n8 D7/iovdd_uq0 sg13_hv_pmos ad=3.1302p pd=14.26u as=3.9294p ps=7.84u w=6.66u l=0.6u
M56 D7/iovdd_uq0 D7/a_5044_13476# _n8 D7/iovdd_uq0 sg13_hv_pmos ad=2.1312p pd=7.3u as=3.9294p ps=7.84u w=6.66u l=0.6u
M57 _n8 D7/a_5044_13476# D7/iovdd_uq0 D7/iovdd_uq0 sg13_hv_pmos ad=3.9294p pd=7.84u as=2.1312p ps=7.3u w=6.66u l=0.6u
X58 vss D7/a_11462_28198# D7/dantenna D7/l=3.1u w=0.64u
X59 vss D7/a_5222_3962# D7/dantenna D7/l=1.26u w=27.78u
X60 D7/a_5044_1676# vss vss D7/rppd l=3.54u w=0.5u
M61 D7/iovdd_uq0 D7/a_5044_13476# _n8 D7/iovdd_uq0 sg13_hv_pmos ad=2.1312p pd=7.3u as=3.9294p ps=7.84u w=6.66u l=0.6u
M62 D7/iovdd_uq0 D7/a_5044_13476# _n8 D7/iovdd_uq0 sg13_hv_pmos ad=2.1312p pd=7.3u as=3.9294p ps=7.84u w=6.66u l=0.6u
M63 _n8 D7/a_5044_1676# vss vss sg13_hv_nmos ad=2.596p pd=5.58u as=2.068p ps=9.74u w=4.4u l=0.6u
M64 D7/iovdd_uq0 D7/a_5044_13476# _n8 D7/iovdd_uq0 sg13_hv_pmos ad=2.1312p pd=7.3u as=3.9294p ps=7.84u w=6.66u l=0.6u
M65 _n8 D7/a_5044_13476# D7/iovdd_uq0 D7/iovdd_uq0 sg13_hv_pmos ad=3.9294p pd=7.84u as=2.1312p ps=7.3u w=6.66u l=0.6u
M66 _n8 D7/a_5044_13476# D7/iovdd_uq0 D7/iovdd_uq0 sg13_hv_pmos ad=3.9294p pd=7.84u as=2.1312p ps=7.3u w=6.66u l=0.6u
M67 _n8 D7/a_5044_13476# D7/iovdd_uq0 D7/iovdd_uq0 sg13_hv_pmos ad=3.9294p pd=7.84u as=2.1312p ps=7.3u w=6.66u l=0.6u
M68 vss D7/a_5044_1676# _n8 vss sg13_hv_nmos ad=1.408p pd=5.04u as=2.596p ps=5.58u w=4.4u l=0.6u
M0 D8/iovdd_uq0 D8/a_5044_13476# _n9 D8/iovdd_uq0 sg13_hv_pmos ad=2.1312p pd=7.3u as=3.9294p ps=7.84u w=6.66u l=0.6u
M1 _n9 D8/a_5044_1676# vss vss sg13_hv_nmos ad=2.596p pd=5.58u as=1.408p ps=5.04u w=4.4u l=0.6u
M2 _n9 D8/a_5044_13476# D8/iovdd_uq0 D8/iovdd_uq0 sg13_hv_pmos ad=3.9294p pd=7.84u as=2.1312p ps=7.3u w=6.66u l=0.6u
M3 D8/iovdd_uq0 D8/a_5044_13476# _n9 D8/iovdd_uq0 sg13_hv_pmos ad=2.1312p pd=7.3u as=3.9294p ps=7.84u w=6.66u l=0.6u
M4 D8/iovdd_uq0 D8/a_5044_13476# _n9 D8/iovdd_uq0 sg13_hv_pmos ad=2.1312p pd=7.3u as=3.9294p ps=7.84u w=6.66u l=0.6u
M5 _n9 D8/a_5044_1676# vss vss sg13_hv_nmos ad=2.596p pd=5.58u as=1.408p ps=5.04u w=4.4u l=0.6u
M6 _n9 D8/a_5044_13476# D8/iovdd_uq0 D8/iovdd_uq0 sg13_hv_pmos ad=3.9294p pd=7.84u as=2.1312p ps=7.3u w=6.66u l=0.6u
M7 D8/iovdd_uq0 D8/a_5044_13476# _n9 D8/iovdd_uq0 sg13_hv_pmos ad=2.1312p pd=7.3u as=3.9294p ps=7.84u w=6.66u l=0.6u
M8 _n9 D8/a_5044_1676# vss vss sg13_hv_nmos ad=2.596p pd=5.58u as=1.408p ps=5.04u w=4.4u l=0.6u
M9 vss D8/a_5044_1676# _n9 vss sg13_hv_nmos ad=2.068p pd=9.74u as=2.596p ps=5.58u w=4.4u l=0.6u
M10 _n9 D8/a_5044_13476# D8/iovdd_uq0 D8/iovdd_uq0 sg13_hv_pmos ad=3.9294p pd=7.84u as=2.1312p ps=7.3u w=6.66u l=0.6u
X11 D8/a_5044_13476# D8/iovdd_uq0 D8/iovdd_uq0 D8/rppd l=12.9u w=0.5u
M12 vss D8/a_5044_1676# _n9 vss sg13_hv_nmos ad=1.408p pd=5.04u as=2.596p ps=5.58u w=4.4u l=0.6u
M13 _n9 D8/a_5044_13476# D8/iovdd_uq0 D8/iovdd_uq0 sg13_hv_pmos ad=3.9294p pd=7.84u as=2.1312p ps=7.3u w=6.66u l=0.6u
X14 vss D8/a_5222_4862# D8/dantenna D8/l=1.26u w=27.78u
M15 vss D8/a_5044_1676# _n9 vss sg13_hv_nmos ad=1.408p pd=5.04u as=2.596p ps=5.58u w=4.4u l=0.6u
M16 _n9 D8/a_5044_1676# vss vss sg13_hv_nmos ad=2.596p pd=5.58u as=1.408p ps=5.04u w=4.4u l=0.6u
M17 vss D8/a_5044_1676# _n9 vss sg13_hv_nmos ad=1.408p pd=5.04u as=2.596p ps=5.58u w=4.4u l=0.6u
M18 D8/iovdd_uq0 D8/a_5044_13476# _n9 D8/iovdd_uq0 sg13_hv_pmos ad=2.1312p pd=7.3u as=3.9294p ps=7.84u w=6.66u l=0.6u
M19 _n9 D8/a_5044_1676# vss vss sg13_hv_nmos ad=2.596p pd=5.58u as=1.408p ps=5.04u w=4.4u l=0.6u
M20 _n9 D8/a_5044_13476# D8/iovdd_uq0 D8/iovdd_uq0 sg13_hv_pmos ad=3.9294p pd=7.84u as=2.1312p ps=7.3u w=6.66u l=0.6u
M21 D8/iovdd_uq0 D8/a_5044_13476# _n9 D8/iovdd_uq0 sg13_hv_pmos ad=2.1312p pd=7.3u as=3.9294p ps=7.84u w=6.66u l=0.6u
M22 _n9 D8/a_5044_13476# D8/iovdd_uq0 D8/iovdd_uq0 sg13_hv_pmos ad=3.9294p pd=7.84u as=2.1312p ps=7.3u w=6.66u l=0.6u
M23 _n9 D8/a_5044_13476# D8/iovdd_uq0 D8/iovdd_uq0 sg13_hv_pmos ad=3.9294p pd=7.84u as=2.1312p ps=7.3u w=6.66u l=0.6u
M24 vss D8/a_5044_1676# _n9 vss sg13_hv_nmos ad=1.408p pd=5.04u as=2.596p ps=5.58u w=4.4u l=0.6u
X25 _n9c D8/iovdd D8/dpantenna D8/l=0.64u w=4.98u
M26 D8/iovdd_uq0 D8/a_5044_13476# _n9 D8/iovdd_uq0 sg13_hv_pmos ad=2.1312p pd=7.3u as=3.9294p ps=7.84u w=6.66u l=0.6u
M27 _n9 D8/a_5044_13476# D8/iovdd_uq0 D8/iovdd_uq0 sg13_hv_pmos ad=3.9294p pd=7.84u as=2.1312p ps=7.3u w=6.66u l=0.6u
M28 _n9 D8/a_5044_13476# D8/iovdd_uq0 D8/iovdd_uq0 sg13_hv_pmos ad=3.9294p pd=7.84u as=2.1312p ps=7.3u w=6.66u l=0.6u
M29 _n9 D8/a_5044_1676# vss vss sg13_hv_nmos ad=2.596p pd=5.58u as=1.408p ps=5.04u w=4.4u l=0.6u
M30 D8/iovdd_uq0 D8/a_5044_13476# _n9 D8/iovdd_uq0 sg13_hv_pmos ad=2.1312p pd=7.3u as=3.9294p ps=7.84u w=6.66u l=0.6u
X31 _n9c _n9 vss D8/rppd l=2u w=1u
M32 D8/iovdd_uq0 D8/a_5044_13476# _n9 D8/iovdd_uq0 sg13_hv_pmos ad=2.1312p pd=7.3u as=3.9294p ps=7.84u w=6.66u l=0.6u
M33 D8/iovdd_uq0 D8/a_5044_13476# _n9 D8/iovdd_uq0 sg13_hv_pmos ad=2.1312p pd=7.3u as=3.9294p ps=7.84u w=6.66u l=0.6u
M34 _n9 D8/a_5044_13476# D8/iovdd_uq0 D8/iovdd_uq0 sg13_hv_pmos ad=3.9294p pd=7.84u as=2.1312p ps=7.3u w=6.66u l=0.6u
M35 _n9 D8/a_5044_1676# vss vss sg13_hv_nmos ad=2.596p pd=5.58u as=1.408p ps=5.04u w=4.4u l=0.6u
M36 vss D8/a_5044_1676# _n9 vss sg13_hv_nmos ad=1.408p pd=5.04u as=2.596p ps=5.58u w=4.4u l=0.6u
M37 _n9 D8/a_5044_1676# vss vss sg13_hv_nmos ad=2.596p pd=5.58u as=1.408p ps=5.04u w=4.4u l=0.6u
M38 D8/iovdd_uq0 D8/a_5044_13476# _n9 D8/iovdd_uq0 sg13_hv_pmos ad=2.1312p pd=7.3u as=3.9294p ps=7.84u w=6.66u l=0.6u
M39 _n9 D8/a_5044_13476# D8/iovdd_uq0 D8/iovdd_uq0 sg13_hv_pmos ad=3.9294p pd=7.84u as=2.1312p ps=7.3u w=6.66u l=0.6u
X40 _n9 D8/iovdd_uq0 D8/dpantenna D8/l=1.26u w=27.78u
M41 vss D8/a_5044_1676# _n9 vss sg13_hv_nmos ad=1.408p pd=5.04u as=2.596p ps=5.58u w=4.4u l=0.6u
M42 D8/iovdd_uq0 D8/a_5044_13476# _n9 D8/iovdd_uq0 sg13_hv_pmos ad=2.1312p pd=7.3u as=3.9294p ps=7.84u w=6.66u l=0.6u
M43 vss D8/a_5044_1676# _n9 vss sg13_hv_nmos ad=1.408p pd=5.04u as=2.596p ps=5.58u w=4.4u l=0.6u
M44 _n9 D8/a_5044_13476# D8/iovdd_uq0 D8/iovdd_uq0 sg13_hv_pmos ad=3.9294p pd=7.84u as=2.1312p ps=7.3u w=6.66u l=0.6u
M45 D8/iovdd_uq0 D8/a_5044_13476# _n9 D8/iovdd_uq0 sg13_hv_pmos ad=2.1312p pd=7.3u as=3.9294p ps=7.84u w=6.66u l=0.6u
M46 _n9 D8/a_5044_13476# D8/iovdd_uq0 D8/iovdd_uq0 sg13_hv_pmos ad=3.9294p pd=7.84u as=2.1312p ps=7.3u w=6.66u l=0.6u
M47 _n9 D8/a_5044_1676# vss vss sg13_hv_nmos ad=2.596p pd=5.58u as=1.408p ps=5.04u w=4.4u l=0.6u
M48 vss D8/a_5044_1676# _n9 vss sg13_hv_nmos ad=1.408p pd=5.04u as=2.596p ps=5.58u w=4.4u l=0.6u
M49 _n9 D8/a_5044_13476# D8/iovdd_uq0 D8/iovdd_uq0 sg13_hv_pmos ad=3.9294p pd=7.84u as=3.1302p ps=14.26u w=6.66u l=0.6u
M50 D8/iovdd_uq0 D8/a_5044_13476# _n9 D8/iovdd_uq0 sg13_hv_pmos ad=3.1302p pd=14.26u as=3.9294p ps=7.84u w=6.66u l=0.6u
M51 D8/iovdd_uq0 D8/a_5044_13476# _n9 D8/iovdd_uq0 sg13_hv_pmos ad=2.1312p pd=7.3u as=3.9294p ps=7.84u w=6.66u l=0.6u
M52 _n9 D8/a_5044_13476# D8/iovdd_uq0 D8/iovdd_uq0 sg13_hv_pmos ad=3.9294p pd=7.84u as=2.1312p ps=7.3u w=6.66u l=0.6u
X53 _n9 D8/iovdd_uq0 D8/dpantenna D8/l=1.26u w=27.78u
M54 _n9 D8/a_5044_13476# D8/iovdd_uq0 D8/iovdd_uq0 sg13_hv_pmos ad=3.9294p pd=7.84u as=3.1302p ps=14.26u w=6.66u l=0.6u
M55 D8/iovdd_uq0 D8/a_5044_13476# _n9 D8/iovdd_uq0 sg13_hv_pmos ad=3.1302p pd=14.26u as=3.9294p ps=7.84u w=6.66u l=0.6u
M56 D8/iovdd_uq0 D8/a_5044_13476# _n9 D8/iovdd_uq0 sg13_hv_pmos ad=2.1312p pd=7.3u as=3.9294p ps=7.84u w=6.66u l=0.6u
M57 _n9 D8/a_5044_13476# D8/iovdd_uq0 D8/iovdd_uq0 sg13_hv_pmos ad=3.9294p pd=7.84u as=2.1312p ps=7.3u w=6.66u l=0.6u
X58 vss D8/a_11462_28198# D8/dantenna D8/l=3.1u w=0.64u
X59 vss D8/a_5222_3962# D8/dantenna D8/l=1.26u w=27.78u
X60 D8/a_5044_1676# vss vss D8/rppd l=3.54u w=0.5u
M61 D8/iovdd_uq0 D8/a_5044_13476# _n9 D8/iovdd_uq0 sg13_hv_pmos ad=2.1312p pd=7.3u as=3.9294p ps=7.84u w=6.66u l=0.6u
M62 D8/iovdd_uq0 D8/a_5044_13476# _n9 D8/iovdd_uq0 sg13_hv_pmos ad=2.1312p pd=7.3u as=3.9294p ps=7.84u w=6.66u l=0.6u
M63 _n9 D8/a_5044_1676# vss vss sg13_hv_nmos ad=2.596p pd=5.58u as=2.068p ps=9.74u w=4.4u l=0.6u
M64 D8/iovdd_uq0 D8/a_5044_13476# _n9 D8/iovdd_uq0 sg13_hv_pmos ad=2.1312p pd=7.3u as=3.9294p ps=7.84u w=6.66u l=0.6u
M65 _n9 D8/a_5044_13476# D8/iovdd_uq0 D8/iovdd_uq0 sg13_hv_pmos ad=3.9294p pd=7.84u as=2.1312p ps=7.3u w=6.66u l=0.6u
M66 _n9 D8/a_5044_13476# D8/iovdd_uq0 D8/iovdd_uq0 sg13_hv_pmos ad=3.9294p pd=7.84u as=2.1312p ps=7.3u w=6.66u l=0.6u
M67 _n9 D8/a_5044_13476# D8/iovdd_uq0 D8/iovdd_uq0 sg13_hv_pmos ad=3.9294p pd=7.84u as=2.1312p ps=7.3u w=6.66u l=0.6u
M68 vss D8/a_5044_1676# _n9 vss sg13_hv_nmos ad=1.408p pd=5.04u as=2.596p ps=5.58u w=4.4u l=0.6u
M0 vdd PVDD/sg13cmos5l_RCClampInverter_0.in PVDD/sg13cmos5l_Clamp_N43N43D4R_0.gate vdd sg13_hv_pmos ad=1.33p pd=7.38u as=1.33p ps=7.38u w=7u l=0.5u
X1 PVDD/a_8065_11542# PVDD/a_7735_7456# vss PVDD/rppd l=20u w=1u
M2 vss PVDD/sg13cmos5l_Clamp_N43N43D4R_0.gate vdd vss sg13_hv_nmos ad=1.408p pd=5.04u as=2.596p ps=5.58u w=4.4u l=0.6u
M3 vss PVDD/sg13cmos5l_Clamp_N43N43D4R_0.gate vdd vss sg13_hv_nmos ad=1.408p pd=5.04u as=2.596p ps=5.58u w=4.4u l=0.6u
M4 vss PVDD/sg13cmos5l_Clamp_N43N43D4R_0.gate vdd vss sg13_hv_nmos ad=1.408p pd=5.04u as=2.596p ps=5.58u w=4.4u l=0.6u
M5 vdd PVDD/sg13cmos5l_RCClampInverter_0.in PVDD/sg13cmos5l_Clamp_N43N43D4R_0.gate vdd sg13_hv_pmos ad=1.33p pd=7.38u as=1.33p ps=7.38u w=7u l=0.5u
M6 vdd PVDD/sg13cmos5l_Clamp_N43N43D4R_0.gate vss vss sg13_hv_nmos ad=2.596p pd=5.58u as=1.408p ps=5.04u w=4.4u l=0.6u
M7 vss PVDD/sg13cmos5l_Clamp_N43N43D4R_0.gate vdd vss sg13_hv_nmos ad=1.408p pd=5.04u as=2.596p ps=5.58u w=4.4u l=0.6u
M8 vdd PVDD/sg13cmos5l_RCClampInverter_0.in PVDD/sg13cmos5l_Clamp_N43N43D4R_0.gate vdd sg13_hv_pmos ad=1.33p pd=7.38u as=1.33p ps=7.38u w=7u l=0.5u
M9 vdd PVDD/sg13cmos5l_Clamp_N43N43D4R_0.gate vss vss sg13_hv_nmos ad=2.596p pd=5.58u as=1.408p ps=5.04u w=4.4u l=0.6u
M10 vss PVDD/sg13cmos5l_Clamp_N43N43D4R_0.gate vdd vss sg13_hv_nmos ad=1.408p pd=5.04u as=2.596p ps=5.58u w=4.4u l=0.6u
M11 vdd PVDD/sg13cmos5l_RCClampInverter_0.in PVDD/sg13cmos5l_Clamp_N43N43D4R_0.gate vdd sg13_hv_pmos ad=1.33p pd=7.38u as=1.33p ps=7.38u w=7u l=0.5u
M12 vss PVDD/sg13cmos5l_Clamp_N43N43D4R_0.gate vdd vss sg13_hv_nmos ad=1.408p pd=5.04u as=2.596p ps=5.58u w=4.4u l=0.6u
M13 vdd PVDD/sg13cmos5l_RCClampInverter_0.in PVDD/sg13cmos5l_Clamp_N43N43D4R_0.gate vdd sg13_hv_pmos ad=1.33p pd=7.38u as=1.33p ps=7.38u w=7u l=0.5u
M14 vdd PVDD/sg13cmos5l_RCClampInverter_0.in PVDD/sg13cmos5l_Clamp_N43N43D4R_0.gate vdd sg13_hv_pmos ad=1.33p pd=7.38u as=1.33p ps=7.38u w=7u l=0.5u
M15 vss PVDD/sg13cmos5l_Clamp_N43N43D4R_0.gate vdd vss sg13_hv_nmos ad=1.408p pd=5.04u as=2.596p ps=5.58u w=4.4u l=0.6u
M16 vdd PVDD/sg13cmos5l_Clamp_N43N43D4R_0.gate vss vss sg13_hv_nmos ad=2.596p pd=5.58u as=1.408p ps=5.04u w=4.4u l=0.6u
M17 vss PVDD/sg13cmos5l_Clamp_N43N43D4R_0.gate vdd vss sg13_hv_nmos ad=1.408p pd=5.04u as=2.596p ps=5.58u w=4.4u l=0.6u
M18 vss PVDD/sg13cmos5l_Clamp_N43N43D4R_0.gate vdd vss sg13_hv_nmos ad=1.408p pd=5.04u as=2.596p ps=5.58u w=4.4u l=0.6u
M19 vdd PVDD/sg13cmos5l_Clamp_N43N43D4R_0.gate vss vss sg13_hv_nmos ad=2.596p pd=5.58u as=1.408p ps=5.04u w=4.4u l=0.6u
M20 vdd PVDD/sg13cmos5l_RCClampInverter_0.in PVDD/sg13cmos5l_Clamp_N43N43D4R_0.gate vdd sg13_hv_pmos ad=1.33p pd=7.38u as=1.33p ps=7.38u w=7u l=0.5u
X21 PVDD/a_6745_11542# PVDD/a_6415_7456# vss PVDD/rppd l=20u w=1u
M22 vss PVDD/sg13cmos5l_Clamp_N43N43D4R_0.gate vdd vss sg13_hv_nmos ad=1.408p pd=5.04u as=2.596p ps=5.58u w=4.4u l=0.6u
M23 vdd PVDD/sg13cmos5l_RCClampInverter_0.in PVDD/sg13cmos5l_Clamp_N43N43D4R_0.gate vdd sg13_hv_pmos ad=1.33p pd=7.38u as=1.33p ps=7.38u w=7u l=0.5u
M24 vdd PVDD/sg13cmos5l_Clamp_N43N43D4R_0.gate vss vss sg13_hv_nmos ad=2.596p pd=5.58u as=1.408p ps=5.04u w=4.4u l=0.6u
M25 vss PVDD/sg13cmos5l_Clamp_N43N43D4R_0.gate vdd vss sg13_hv_nmos ad=1.408p pd=5.04u as=2.596p ps=5.58u w=4.4u l=0.6u
M26 vdd PVDD/sg13cmos5l_RCClampInverter_0.in PVDD/sg13cmos5l_Clamp_N43N43D4R_0.gate vdd sg13_hv_pmos ad=1.33p pd=7.38u as=1.33p ps=7.38u w=7u l=0.5u
M27 vdd PVDD/sg13cmos5l_Clamp_N43N43D4R_0.gate vss vss sg13_hv_nmos ad=2.596p pd=5.58u as=1.408p ps=5.04u w=4.4u l=0.6u
M28 vdd PVDD/sg13cmos5l_Clamp_N43N43D4R_0.gate vss vss sg13_hv_nmos ad=2.596p pd=5.58u as=1.408p ps=5.04u w=4.4u l=0.6u
M29 vss PVDD/sg13cmos5l_Clamp_N43N43D4R_0.gate vdd vss sg13_hv_nmos ad=1.408p pd=5.04u as=2.596p ps=5.58u w=4.4u l=0.6u
M30 vss PVDD/sg13cmos5l_Clamp_N43N43D4R_0.gate vdd vss sg13_hv_nmos ad=1.408p pd=5.04u as=2.596p ps=5.58u w=4.4u l=0.6u
M31 vdd PVDD/sg13cmos5l_Clamp_N43N43D4R_0.gate vss vss sg13_hv_nmos ad=2.596p pd=5.58u as=1.408p ps=5.04u w=4.4u l=0.6u
M32 vss PVDD/sg13cmos5l_Clamp_N43N43D4R_0.gate vdd vss sg13_hv_nmos ad=1.408p pd=5.04u as=2.596p ps=5.58u w=4.4u l=0.6u
M33 vdd PVDD/sg13cmos5l_Clamp_N43N43D4R_0.gate vss vss sg13_hv_nmos ad=2.596p pd=5.58u as=1.408p ps=5.04u w=4.4u l=0.6u
M34 vdd PVDD/sg13cmos5l_RCClampInverter_0.in PVDD/sg13cmos5l_Clamp_N43N43D4R_0.gate vdd sg13_hv_pmos ad=1.33p pd=7.38u as=1.33p ps=7.38u w=7u l=0.5u
M35 vdd PVDD/sg13cmos5l_RCClampInverter_0.in PVDD/sg13cmos5l_Clamp_N43N43D4R_0.gate vdd sg13_hv_pmos ad=1.33p pd=7.38u as=1.33p ps=7.38u w=7u l=0.5u
M36 vss PVDD/sg13cmos5l_Clamp_N43N43D4R_0.gate vdd vss sg13_hv_nmos ad=1.408p pd=5.04u as=2.596p ps=5.58u w=4.4u l=0.6u
M37 vss PVDD/sg13cmos5l_Clamp_N43N43D4R_0.gate vdd vss sg13_hv_nmos ad=1.408p pd=5.04u as=2.596p ps=5.58u w=4.4u l=0.6u
M38 vss PVDD/sg13cmos5l_RCClampInverter_0.in vss vss sg13_hv_nmos ad=1.71p pd=9.38u as=2.24759n ps=2.5228m w=9u l=9.5u
M39 vdd PVDD/sg13cmos5l_RCClampInverter_0.in PVDD/sg13cmos5l_Clamp_N43N43D4R_0.gate vdd sg13_hv_pmos ad=2.38p pd=14.68u as=1.33p ps=7.38u w=7u l=0.5u
M40 vss PVDD/sg13cmos5l_RCClampInverter_0.in vss vss sg13_hv_nmos ad=1.71p pd=9.38u as=0 ps=0 w=9u l=9.5u
M41 vdd PVDD/sg13cmos5l_RCClampInverter_0.in PVDD/sg13cmos5l_Clamp_N43N43D4R_0.gate vdd sg13_hv_pmos ad=1.33p pd=7.38u as=1.33p ps=7.38u w=7u l=0.5u
M42 vss PVDD/sg13cmos5l_Clamp_N43N43D4R_0.gate vdd vss sg13_hv_nmos ad=1.408p pd=5.04u as=2.596p ps=5.58u w=4.4u l=0.6u
M43 vdd PVDD/sg13cmos5l_Clamp_N43N43D4R_0.gate vss vss sg13_hv_nmos ad=2.596p pd=5.58u as=1.408p ps=5.04u w=4.4u l=0.6u
X44 PVDD/a_11365_11542# PVDD/a_11695_7456# vss PVDD/rppd l=20u w=1u
M45 vss PVDD/sg13cmos5l_Clamp_N43N43D4R_0.gate vdd vss sg13_hv_nmos ad=1.408p pd=5.04u as=2.596p ps=5.58u w=4.4u l=0.6u
M46 vdd PVDD/sg13cmos5l_Clamp_N43N43D4R_0.gate vss vss sg13_hv_nmos ad=2.596p pd=5.58u as=1.408p ps=5.04u w=4.4u l=0.6u
M47 vdd PVDD/sg13cmos5l_Clamp_N43N43D4R_0.gate vss vss sg13_hv_nmos ad=3.256p pd=10.28u as=1.408p ps=5.04u w=4.4u l=0.6u
M48 vdd PVDD/sg13cmos5l_Clamp_N43N43D4R_0.gate vss vss sg13_hv_nmos ad=2.596p pd=5.58u as=1.408p ps=5.04u w=4.4u l=0.6u
M49 vdd PVDD/sg13cmos5l_Clamp_N43N43D4R_0.gate vss vss sg13_hv_nmos ad=2.596p pd=5.58u as=1.408p ps=5.04u w=4.4u l=0.6u
M50 vss PVDD/sg13cmos5l_Clamp_N43N43D4R_0.gate vdd vss sg13_hv_nmos ad=1.408p pd=5.04u as=2.596p ps=5.58u w=4.4u l=0.6u
M51 vdd PVDD/sg13cmos5l_Clamp_N43N43D4R_0.gate vss vss sg13_hv_nmos ad=2.596p pd=5.58u as=1.408p ps=5.04u w=4.4u l=0.6u
M52 vss PVDD/sg13cmos5l_Clamp_N43N43D4R_0.gate vdd vss sg13_hv_nmos ad=1.408p pd=5.04u as=2.596p ps=5.58u w=4.4u l=0.6u
M53 vss PVDD/sg13cmos5l_Clamp_N43N43D4R_0.gate vdd vss sg13_hv_nmos ad=1.408p pd=5.04u as=2.596p ps=5.58u w=4.4u l=0.6u
M54 vss PVDD/sg13cmos5l_RCClampInverter_0.in PVDD/sg13cmos5l_Clamp_N43N43D4R_0.gate vss sg13_hv_nmos ad=1.71p pd=9.38u as=1.71p ps=9.38u w=9u l=0.5u
X55 PVDD/a_8725_11542# PVDD/a_9055_7456# vss PVDD/rppd l=20u w=1u
M56 vss PVDD/sg13cmos5l_Clamp_N43N43D4R_0.gate vdd vss sg13_hv_nmos ad=1.408p pd=5.04u as=2.596p ps=5.58u w=4.4u l=0.6u
M57 vss PVDD/sg13cmos5l_RCClampInverter_0.in PVDD/sg13cmos5l_Clamp_N43N43D4R_0.gate vss sg13_hv_nmos ad=1.71p pd=9.38u as=1.71p ps=9.38u w=9u l=0.5u
M58 vdd PVDD/sg13cmos5l_Clamp_N43N43D4R_0.gate vss vss sg13_hv_nmos ad=2.596p pd=5.58u as=1.408p ps=5.04u w=4.4u l=0.6u
M59 vss PVDD/sg13cmos5l_RCClampInverter_0.in PVDD/sg13cmos5l_Clamp_N43N43D4R_0.gate vss sg13_hv_nmos ad=1.71p pd=9.38u as=1.71p ps=9.38u w=9u l=0.5u
X60 PVDD/a_10045_11542# PVDD/a_9715_7456# vss PVDD/rppd l=20u w=1u
M61 vdd PVDD/sg13cmos5l_RCClampInverter_0.in PVDD/sg13cmos5l_Clamp_N43N43D4R_0.gate vdd sg13_hv_pmos ad=1.33p pd=7.38u as=1.33p ps=7.38u w=7u l=0.5u
M62 vss PVDD/sg13cmos5l_RCClampInverter_0.in vss vss sg13_hv_nmos ad=1.71p pd=9.38u as=0 ps=0 w=9u l=9.5u
M63 vss PVDD/sg13cmos5l_Clamp_N43N43D4R_0.gate vdd vss sg13_hv_nmos ad=1.408p pd=5.04u as=2.596p ps=5.58u w=4.4u l=0.6u
M64 vdd PVDD/sg13cmos5l_Clamp_N43N43D4R_0.gate vss vss sg13_hv_nmos ad=2.596p pd=5.58u as=1.408p ps=5.04u w=4.4u l=0.6u
M65 vss PVDD/sg13cmos5l_RCClampInverter_0.in PVDD/sg13cmos5l_Clamp_N43N43D4R_0.gate vss sg13_hv_nmos ad=1.71p pd=9.38u as=1.71p ps=9.38u w=9u l=0.5u
M66 vdd PVDD/sg13cmos5l_Clamp_N43N43D4R_0.gate vss vss sg13_hv_nmos ad=2.596p pd=5.58u as=1.408p ps=5.04u w=4.4u l=0.6u
M67 vss PVDD/sg13cmos5l_RCClampInverter_0.in vss vss sg13_hv_nmos ad=1.71p pd=9.38u as=0 ps=0 w=9u l=9.5u
M68 vdd PVDD/sg13cmos5l_Clamp_N43N43D4R_0.gate vss vss sg13_hv_nmos ad=2.596p pd=5.58u as=2.068p ps=9.74u w=4.4u l=0.6u
M69 vdd PVDD/sg13cmos5l_RCClampInverter_0.in PVDD/sg13cmos5l_Clamp_N43N43D4R_0.gate vdd sg13_hv_pmos ad=1.33p pd=7.38u as=1.33p ps=7.38u w=7u l=0.5u
M70 vss PVDD/sg13cmos5l_RCClampInverter_0.in vss vss sg13_hv_nmos ad=1.71p pd=9.38u as=0 ps=0 w=9u l=9.5u
M71 vdd PVDD/sg13cmos5l_Clamp_N43N43D4R_0.gate vss vss sg13_hv_nmos ad=2.596p pd=5.58u as=1.408p ps=5.04u w=4.4u l=0.6u
M72 vdd PVDD/sg13cmos5l_Clamp_N43N43D4R_0.gate vss vss sg13_hv_nmos ad=2.596p pd=5.58u as=1.408p ps=5.04u w=4.4u l=0.6u
M73 vdd PVDD/sg13cmos5l_Clamp_N43N43D4R_0.gate vss vss sg13_hv_nmos ad=2.596p pd=5.58u as=1.408p ps=5.04u w=4.4u l=0.6u
M74 vss PVDD/sg13cmos5l_Clamp_N43N43D4R_0.gate vdd vss sg13_hv_nmos ad=1.408p pd=5.04u as=2.596p ps=5.58u w=4.4u l=0.6u
M75 vss PVDD/sg13cmos5l_RCClampInverter_0.in vss vss sg13_hv_nmos ad=1.71p pd=9.38u as=0 ps=0 w=9u l=9.5u
M76 vdd PVDD/sg13cmos5l_Clamp_N43N43D4R_0.gate vss vss sg13_hv_nmos ad=2.596p pd=5.58u as=1.408p ps=5.04u w=4.4u l=0.6u
M77 vdd PVDD/sg13cmos5l_Clamp_N43N43D4R_0.gate vss vss sg13_hv_nmos ad=2.596p pd=5.58u as=1.408p ps=5.04u w=4.4u l=0.6u
M78 vdd PVDD/sg13cmos5l_Clamp_N43N43D4R_0.gate vss vss sg13_hv_nmos ad=2.596p pd=5.58u as=1.408p ps=5.04u w=4.4u l=0.6u
M79 vss PVDD/sg13cmos5l_Clamp_N43N43D4R_0.gate vdd vss sg13_hv_nmos ad=1.408p pd=5.04u as=2.596p ps=5.58u w=4.4u l=0.6u
M80 vdd PVDD/sg13cmos5l_RCClampInverter_0.in PVDD/sg13cmos5l_Clamp_N43N43D4R_0.gate vdd sg13_hv_pmos ad=1.33p pd=7.38u as=1.33p ps=7.38u w=7u l=0.5u
X81 PVDD/a_4105_11542# PVDD/a_4435_7456# vss PVDD/rppd l=20u w=1u
X82 PVDD/a_7405_11542# PVDD/a_7735_7456# vss PVDD/rppd l=20u w=1u
M83 vdd PVDD/sg13cmos5l_RCClampInverter_0.in PVDD/sg13cmos5l_Clamp_N43N43D4R_0.gate vdd sg13_hv_pmos ad=1.33p pd=7.38u as=1.33p ps=7.38u w=7u l=0.5u
M84 vss PVDD/sg13cmos5l_RCClampInverter_0.in PVDD/sg13cmos5l_Clamp_N43N43D4R_0.gate vss sg13_hv_nmos ad=1.71p pd=9.38u as=1.71p ps=9.38u w=9u l=0.5u
M85 vss PVDD/sg13cmos5l_Clamp_N43N43D4R_0.gate vdd vss sg13_hv_nmos ad=1.408p pd=5.04u as=2.596p ps=5.58u w=4.4u l=0.6u
M86 vdd PVDD/sg13cmos5l_Clamp_N43N43D4R_0.gate vss vss sg13_hv_nmos ad=2.596p pd=5.58u as=1.408p ps=5.04u w=4.4u l=0.6u
M87 vss PVDD/sg13cmos5l_RCClampInverter_0.in PVDD/sg13cmos5l_Clamp_N43N43D4R_0.gate vss sg13_hv_nmos ad=1.71p pd=9.38u as=1.71p ps=9.38u w=9u l=0.5u
M88 vdd PVDD/sg13cmos5l_Clamp_N43N43D4R_0.gate vss vss sg13_hv_nmos ad=2.596p pd=5.58u as=1.408p ps=5.04u w=4.4u l=0.6u
M89 vdd PVDD/sg13cmos5l_Clamp_N43N43D4R_0.gate vss vss sg13_hv_nmos ad=2.596p pd=5.58u as=1.408p ps=5.04u w=4.4u l=0.6u
M90 vdd PVDD/sg13cmos5l_Clamp_N43N43D4R_0.gate vss vss sg13_hv_nmos ad=2.596p pd=5.58u as=1.408p ps=5.04u w=4.4u l=0.6u
M91 vdd PVDD/sg13cmos5l_Clamp_N43N43D4R_0.gate vss vss sg13_hv_nmos ad=2.596p pd=5.58u as=1.408p ps=5.04u w=4.4u l=0.6u
M92 vdd PVDD/sg13cmos5l_Clamp_N43N43D4R_0.gate vss vss sg13_hv_nmos ad=2.596p pd=5.58u as=1.408p ps=5.04u w=4.4u l=0.6u
M93 vdd PVDD/sg13cmos5l_Clamp_N43N43D4R_0.gate vss vss sg13_hv_nmos ad=2.596p pd=5.58u as=1.408p ps=5.04u w=4.4u l=0.6u
M94 vss PVDD/sg13cmos5l_Clamp_N43N43D4R_0.gate vdd vss sg13_hv_nmos ad=1.408p pd=5.04u as=2.596p ps=5.58u w=4.4u l=0.6u
M95 vss PVDD/sg13cmos5l_Clamp_N43N43D4R_0.gate vdd vss sg13_hv_nmos ad=1.408p pd=5.04u as=2.596p ps=5.58u w=4.4u l=0.6u
M96 vdd PVDD/sg13cmos5l_RCClampInverter_0.in PVDD/sg13cmos5l_Clamp_N43N43D4R_0.gate vdd sg13_hv_pmos ad=1.33p pd=7.38u as=1.33p ps=7.38u w=7u l=0.5u
M97 vdd PVDD/sg13cmos5l_RCClampInverter_0.in PVDD/sg13cmos5l_Clamp_N43N43D4R_0.gate vdd sg13_hv_pmos ad=1.33p pd=7.38u as=1.33p ps=7.38u w=7u l=0.5u
M98 vss PVDD/sg13cmos5l_Clamp_N43N43D4R_0.gate vdd vss sg13_hv_nmos ad=1.408p pd=5.04u as=2.596p ps=5.58u w=4.4u l=0.6u
M99 vss PVDD/sg13cmos5l_Clamp_N43N43D4R_0.gate vdd vss sg13_hv_nmos ad=1.408p pd=5.04u as=2.596p ps=5.58u w=4.4u l=0.6u
X100 PVDD/a_4765_11542# PVDD/a_5095_7456# vss PVDD/rppd l=20u w=1u
X101 PVDD/a_8065_11542# PVDD/a_8395_7456# vss PVDD/rppd l=20u w=1u
M102 vdd PVDD/sg13cmos5l_Clamp_N43N43D4R_0.gate vss vss sg13_hv_nmos ad=2.596p pd=5.58u as=1.408p ps=5.04u w=4.4u l=0.6u
M103 vss PVDD/sg13cmos5l_Clamp_N43N43D4R_0.gate vdd vss sg13_hv_nmos ad=1.408p pd=5.04u as=2.596p ps=5.58u w=4.4u l=0.6u
M104 PVDD/sg13cmos5l_Clamp_N43N43D4R_0.gate PVDD/sg13cmos5l_RCClampInverter_0.in vdd vdd sg13_hv_pmos ad=1.33p pd=7.38u as=1.33p ps=7.38u w=7u l=0.5u
M105 vdd PVDD/sg13cmos5l_RCClampInverter_0.in PVDD/sg13cmos5l_Clamp_N43N43D4R_0.gate vdd sg13_hv_pmos ad=1.33p pd=7.38u as=1.33p ps=7.38u w=7u l=0.5u
M106 vdd PVDD/sg13cmos5l_Clamp_N43N43D4R_0.gate vss vss sg13_hv_nmos ad=3.256p pd=10.28u as=1.408p ps=5.04u w=4.4u l=0.6u
M107 PVDD/sg13cmos5l_Clamp_N43N43D4R_0.gate PVDD/sg13cmos5l_RCClampInverter_0.in vdd vdd sg13_hv_pmos ad=1.33p pd=7.38u as=1.33p ps=7.38u w=7u l=0.5u
M108 vdd PVDD/sg13cmos5l_Clamp_N43N43D4R_0.gate vss vss sg13_hv_nmos ad=2.596p pd=5.58u as=1.408p ps=5.04u w=4.4u l=0.6u
M109 vdd PVDD/sg13cmos5l_Clamp_N43N43D4R_0.gate vss vss sg13_hv_nmos ad=2.596p pd=5.58u as=1.408p ps=5.04u w=4.4u l=0.6u
M110 vdd PVDD/sg13cmos5l_Clamp_N43N43D4R_0.gate vss vss sg13_hv_nmos ad=2.596p pd=5.58u as=1.408p ps=5.04u w=4.4u l=0.6u
M111 vdd PVDD/sg13cmos5l_Clamp_N43N43D4R_0.gate vss vss sg13_hv_nmos ad=2.596p pd=5.58u as=1.408p ps=5.04u w=4.4u l=0.6u
M112 vss PVDD/sg13cmos5l_Clamp_N43N43D4R_0.gate vdd vss sg13_hv_nmos ad=1.408p pd=5.04u as=2.596p ps=5.58u w=4.4u l=0.6u
M113 vss PVDD/sg13cmos5l_Clamp_N43N43D4R_0.gate vdd vss sg13_hv_nmos ad=1.408p pd=5.04u as=2.596p ps=5.58u w=4.4u l=0.6u
M114 vss PVDD/sg13cmos5l_Clamp_N43N43D4R_0.gate vdd vss sg13_hv_nmos ad=1.408p pd=5.04u as=2.596p ps=5.58u w=4.4u l=0.6u
M115 vdd PVDD/sg13cmos5l_Clamp_N43N43D4R_0.gate vss vss sg13_hv_nmos ad=2.596p pd=5.58u as=1.408p ps=5.04u w=4.4u l=0.6u
M116 vss PVDD/sg13cmos5l_Clamp_N43N43D4R_0.gate vdd vss sg13_hv_nmos ad=1.408p pd=5.04u as=2.596p ps=5.58u w=4.4u l=0.6u
M117 vss PVDD/sg13cmos5l_RCClampInverter_0.in vss vss sg13_hv_nmos ad=1.71p pd=9.38u as=0 ps=0 w=9u l=9.5u
M118 vdd PVDD/sg13cmos5l_RCClampInverter_0.in PVDD/sg13cmos5l_Clamp_N43N43D4R_0.gate vdd sg13_hv_pmos ad=1.33p pd=7.38u as=1.33p ps=7.38u w=7u l=0.5u
M119 vss PVDD/sg13cmos5l_RCClampInverter_0.in vss vss sg13_hv_nmos ad=1.71p pd=9.38u as=0 ps=0 w=9u l=9.5u
X120 PVDD/a_10705_11542# PVDD/a_11035_7456# vss PVDD/rppd l=20u w=1u
M121 vdd PVDD/sg13cmos5l_Clamp_N43N43D4R_0.gate vss vss sg13_hv_nmos ad=2.596p pd=5.58u as=1.408p ps=5.04u w=4.4u l=0.6u
M122 vss PVDD/sg13cmos5l_Clamp_N43N43D4R_0.gate vdd vss sg13_hv_nmos ad=1.408p pd=5.04u as=2.596p ps=5.58u w=4.4u l=0.6u
M123 vss PVDD/sg13cmos5l_Clamp_N43N43D4R_0.gate vdd vss sg13_hv_nmos ad=1.408p pd=5.04u as=2.596p ps=5.58u w=4.4u l=0.6u
M124 PVDD/sg13cmos5l_Clamp_N43N43D4R_0.gate PVDD/sg13cmos5l_RCClampInverter_0.in vdd vdd sg13_hv_pmos ad=1.33p pd=7.38u as=1.33p ps=7.38u w=7u l=0.5u
M125 vss PVDD/sg13cmos5l_Clamp_N43N43D4R_0.gate vdd vss sg13_hv_nmos ad=1.408p pd=5.04u as=2.596p ps=5.58u w=4.4u l=0.6u
X126 vdd PVDD/a_3775_7456# vss PVDD/rppd l=20u w=1u
M127 vdd PVDD/sg13cmos5l_Clamp_N43N43D4R_0.gate vss vss sg13_hv_nmos ad=2.596p pd=5.58u as=2.068p ps=9.74u w=4.4u l=0.6u
M128 vdd PVDD/sg13cmos5l_Clamp_N43N43D4R_0.gate vss vss sg13_hv_nmos ad=2.596p pd=5.58u as=1.408p ps=5.04u w=4.4u l=0.6u
M129 vdd PVDD/sg13cmos5l_Clamp_N43N43D4R_0.gate vss vss sg13_hv_nmos ad=2.596p pd=5.58u as=1.408p ps=5.04u w=4.4u l=0.6u
M130 vss PVDD/sg13cmos5l_Clamp_N43N43D4R_0.gate vdd vss sg13_hv_nmos ad=1.408p pd=5.04u as=2.596p ps=5.58u w=4.4u l=0.6u
M131 vss PVDD/sg13cmos5l_Clamp_N43N43D4R_0.gate vdd vss sg13_hv_nmos ad=1.408p pd=5.04u as=2.596p ps=5.58u w=4.4u l=0.6u
M132 vdd PVDD/sg13cmos5l_Clamp_N43N43D4R_0.gate vss vss sg13_hv_nmos ad=2.596p pd=5.58u as=1.408p ps=5.04u w=4.4u l=0.6u
M133 vss PVDD/sg13cmos5l_Clamp_N43N43D4R_0.gate vdd vss sg13_hv_nmos ad=1.408p pd=5.04u as=2.596p ps=5.58u w=4.4u l=0.6u
M134 vss PVDD/sg13cmos5l_Clamp_N43N43D4R_0.gate vdd vss sg13_hv_nmos ad=1.408p pd=5.04u as=2.596p ps=5.58u w=4.4u l=0.6u
X135 PVDD/a_8725_11542# PVDD/a_8395_7456# vss PVDD/rppd l=20u w=1u
M136 vss PVDD/sg13cmos5l_Clamp_N43N43D4R_0.gate vdd vss sg13_hv_nmos ad=1.408p pd=5.04u as=2.596p ps=5.58u w=4.4u l=0.6u
M137 vss PVDD/sg13cmos5l_Clamp_N43N43D4R_0.gate vdd vss sg13_hv_nmos ad=1.408p pd=5.04u as=2.596p ps=5.58u w=4.4u l=0.6u
M138 PVDD/sg13cmos5l_Clamp_N43N43D4R_0.gate PVDD/sg13cmos5l_RCClampInverter_0.in vdd vdd sg13_hv_pmos ad=1.33p pd=7.38u as=1.33p ps=7.38u w=7u l=0.5u
M139 PVDD/sg13cmos5l_Clamp_N43N43D4R_0.gate PVDD/sg13cmos5l_RCClampInverter_0.in vdd vdd sg13_hv_pmos ad=1.33p pd=7.38u as=1.33p ps=7.38u w=7u l=0.5u
X140 PVDD/a_5425_11542# PVDD/a_5095_7456# vss PVDD/rppd l=20u w=1u
M141 vss PVDD/sg13cmos5l_Clamp_N43N43D4R_0.gate vdd vss sg13_hv_nmos ad=1.408p pd=5.04u as=2.596p ps=5.58u w=4.4u l=0.6u
M142 PVDD/sg13cmos5l_Clamp_N43N43D4R_0.gate PVDD/sg13cmos5l_RCClampInverter_0.in vdd vdd sg13_hv_pmos ad=1.33p pd=7.38u as=1.33p ps=7.38u w=7u l=0.5u
M143 PVDD/sg13cmos5l_Clamp_N43N43D4R_0.gate PVDD/sg13cmos5l_RCClampInverter_0.in vdd vdd sg13_hv_pmos ad=1.33p pd=7.38u as=1.33p ps=7.38u w=7u l=0.5u
M144 vdd PVDD/sg13cmos5l_Clamp_N43N43D4R_0.gate vss vss sg13_hv_nmos ad=2.596p pd=5.58u as=1.408p ps=5.04u w=4.4u l=0.6u
M145 vss PVDD/sg13cmos5l_Clamp_N43N43D4R_0.gate vdd vss sg13_hv_nmos ad=1.408p pd=5.04u as=2.596p ps=5.58u w=4.4u l=0.6u
M146 vss PVDD/sg13cmos5l_Clamp_N43N43D4R_0.gate vdd vss sg13_hv_nmos ad=1.408p pd=5.04u as=2.596p ps=5.58u w=4.4u l=0.6u
M147 PVDD/sg13cmos5l_Clamp_N43N43D4R_0.gate PVDD/sg13cmos5l_RCClampInverter_0.in vdd vdd sg13_hv_pmos ad=1.33p pd=7.38u as=1.33p ps=7.38u w=7u l=0.5u
M148 vss PVDD/sg13cmos5l_Clamp_N43N43D4R_0.gate vdd vss sg13_hv_nmos ad=1.408p pd=5.04u as=2.596p ps=5.58u w=4.4u l=0.6u
M149 vdd PVDD/sg13cmos5l_Clamp_N43N43D4R_0.gate vss vss sg13_hv_nmos ad=2.596p pd=5.58u as=1.408p ps=5.04u w=4.4u l=0.6u
M150 PVDD/sg13cmos5l_Clamp_N43N43D4R_0.gate PVDD/sg13cmos5l_RCClampInverter_0.in vdd vdd sg13_hv_pmos ad=1.33p pd=7.38u as=1.33p ps=7.38u w=7u l=0.5u
M151 vss PVDD/sg13cmos5l_Clamp_N43N43D4R_0.gate vdd vss sg13_hv_nmos ad=1.408p pd=5.04u as=2.596p ps=5.58u w=4.4u l=0.6u
M152 vss PVDD/sg13cmos5l_Clamp_N43N43D4R_0.gate vdd vss sg13_hv_nmos ad=1.408p pd=5.04u as=2.596p ps=5.58u w=4.4u l=0.6u
M153 vss PVDD/sg13cmos5l_Clamp_N43N43D4R_0.gate vdd vss sg13_hv_nmos ad=1.408p pd=5.04u as=2.596p ps=5.58u w=4.4u l=0.6u
M154 vss PVDD/sg13cmos5l_Clamp_N43N43D4R_0.gate vdd vss sg13_hv_nmos ad=1.408p pd=5.04u as=2.596p ps=5.58u w=4.4u l=0.6u
M155 vss PVDD/sg13cmos5l_Clamp_N43N43D4R_0.gate vdd vss sg13_hv_nmos ad=1.408p pd=5.04u as=2.596p ps=5.58u w=4.4u l=0.6u
M156 vdd PVDD/sg13cmos5l_Clamp_N43N43D4R_0.gate vss vss sg13_hv_nmos ad=2.596p pd=5.58u as=1.408p ps=5.04u w=4.4u l=0.6u
M157 PVDD/sg13cmos5l_Clamp_N43N43D4R_0.gate PVDD/sg13cmos5l_RCClampInverter_0.in vdd vdd sg13_hv_pmos ad=1.33p pd=7.38u as=1.33p ps=7.38u w=7u l=0.5u
X158 PVDD/a_9385_11542# PVDD/a_9055_7456# vss PVDD/rppd l=20u w=1u
M159 PVDD/sg13cmos5l_Clamp_N43N43D4R_0.gate PVDD/sg13cmos5l_RCClampInverter_0.in vdd vdd sg13_hv_pmos ad=1.33p pd=7.38u as=1.33p ps=7.38u w=7u l=0.5u
X160 PVDD/a_6085_11542# PVDD/a_5755_7456# vss PVDD/rppd l=20u w=1u
M161 vdd PVDD/sg13cmos5l_Clamp_N43N43D4R_0.gate vss vss sg13_hv_nmos ad=2.596p pd=5.58u as=1.408p ps=5.04u w=4.4u l=0.6u
M162 vss PVDD/sg13cmos5l_RCClampInverter_0.in vss vss sg13_hv_nmos ad=1.71p pd=9.38u as=0 ps=0 w=9u l=9.5u
M163 PVDD/sg13cmos5l_Clamp_N43N43D4R_0.gate PVDD/sg13cmos5l_RCClampInverter_0.in vdd vdd sg13_hv_pmos ad=1.33p pd=7.38u as=1.33p ps=7.38u w=7u l=0.5u
X164 PVDD/a_10045_11542# PVDD/a_10375_7456# vss PVDD/rppd l=20u w=1u
M165 PVDD/sg13cmos5l_Clamp_N43N43D4R_0.gate PVDD/sg13cmos5l_RCClampInverter_0.in vdd vdd sg13_hv_pmos ad=1.33p pd=7.38u as=1.33p ps=7.38u w=7u l=0.5u
M166 PVDD/sg13cmos5l_Clamp_N43N43D4R_0.gate PVDD/sg13cmos5l_RCClampInverter_0.in vdd vdd sg13_hv_pmos ad=1.33p pd=7.38u as=1.33p ps=7.38u w=7u l=0.5u
M167 vss PVDD/sg13cmos5l_RCClampInverter_0.in vss vss sg13_hv_nmos ad=1.71p pd=9.38u as=0 ps=0 w=9u l=9.5u
M168 vss PVDD/sg13cmos5l_Clamp_N43N43D4R_0.gate vdd vss sg13_hv_nmos ad=1.408p pd=5.04u as=2.596p ps=5.58u w=4.4u l=0.6u
M169 vdd PVDD/sg13cmos5l_Clamp_N43N43D4R_0.gate vss vss sg13_hv_nmos ad=2.596p pd=5.58u as=1.408p ps=5.04u w=4.4u l=0.6u
M170 vss PVDD/sg13cmos5l_Clamp_N43N43D4R_0.gate vdd vss sg13_hv_nmos ad=1.408p pd=5.04u as=2.596p ps=5.58u w=4.4u l=0.6u
M171 vdd PVDD/sg13cmos5l_Clamp_N43N43D4R_0.gate vss vss sg13_hv_nmos ad=2.596p pd=5.58u as=1.408p ps=5.04u w=4.4u l=0.6u
M172 vdd PVDD/sg13cmos5l_Clamp_N43N43D4R_0.gate vss vss sg13_hv_nmos ad=2.596p pd=5.58u as=1.408p ps=5.04u w=4.4u l=0.6u
M173 vdd PVDD/sg13cmos5l_Clamp_N43N43D4R_0.gate vss vss sg13_hv_nmos ad=2.596p pd=5.58u as=1.408p ps=5.04u w=4.4u l=0.6u
M174 vss PVDD/sg13cmos5l_Clamp_N43N43D4R_0.gate vdd vss sg13_hv_nmos ad=1.408p pd=5.04u as=2.596p ps=5.58u w=4.4u l=0.6u
M175 PVDD/sg13cmos5l_Clamp_N43N43D4R_0.gate PVDD/sg13cmos5l_RCClampInverter_0.in vdd vdd sg13_hv_pmos ad=1.33p pd=7.38u as=1.33p ps=7.38u w=7u l=0.5u
M176 vdd PVDD/sg13cmos5l_Clamp_N43N43D4R_0.gate vss vss sg13_hv_nmos ad=2.596p pd=5.58u as=1.408p ps=5.04u w=4.4u l=0.6u
M177 vss PVDD/sg13cmos5l_Clamp_N43N43D4R_0.gate vdd vss sg13_hv_nmos ad=1.408p pd=5.04u as=2.596p ps=5.58u w=4.4u l=0.6u
M178 PVDD/sg13cmos5l_Clamp_N43N43D4R_0.gate PVDD/sg13cmos5l_RCClampInverter_0.in vdd vdd sg13_hv_pmos ad=1.33p pd=7.38u as=1.33p ps=7.38u w=7u l=0.5u
X179 PVDD/sg13cmos5l_RCClampInverter_0.in PVDD/a_11695_7456# vss PVDD/rppd l=20u w=1u
M180 vss PVDD/sg13cmos5l_Clamp_N43N43D4R_0.gate vdd vss sg13_hv_nmos ad=1.408p pd=5.04u as=2.596p ps=5.58u w=4.4u l=0.6u
M181 vss PVDD/sg13cmos5l_Clamp_N43N43D4R_0.gate vdd vss sg13_hv_nmos ad=1.408p pd=5.04u as=2.596p ps=5.58u w=4.4u l=0.6u
M182 PVDD/sg13cmos5l_Clamp_N43N43D4R_0.gate PVDD/sg13cmos5l_RCClampInverter_0.in vdd vdd sg13_hv_pmos ad=1.33p pd=7.38u as=1.33p ps=7.38u w=7u l=0.5u
M183 vdd PVDD/sg13cmos5l_Clamp_N43N43D4R_0.gate vss vss sg13_hv_nmos ad=2.596p pd=5.58u as=1.408p ps=5.04u w=4.4u l=0.6u
M184 PVDD/sg13cmos5l_Clamp_N43N43D4R_0.gate PVDD/sg13cmos5l_RCClampInverter_0.in vdd vdd sg13_hv_pmos ad=1.33p pd=7.38u as=1.33p ps=7.38u w=7u l=0.5u
X185 PVDD/a_4765_11542# PVDD/a_4435_7456# vss PVDD/rppd l=20u w=1u
M186 vdd PVDD/sg13cmos5l_Clamp_N43N43D4R_0.gate vss vss sg13_hv_nmos ad=2.596p pd=5.58u as=1.408p ps=5.04u w=4.4u l=0.6u
M187 vss PVDD/sg13cmos5l_Clamp_N43N43D4R_0.gate vdd vss sg13_hv_nmos ad=1.408p pd=5.04u as=2.596p ps=5.58u w=4.4u l=0.6u
M188 vdd PVDD/sg13cmos5l_Clamp_N43N43D4R_0.gate vss vss sg13_hv_nmos ad=2.596p pd=5.58u as=1.408p ps=5.04u w=4.4u l=0.6u
M189 PVDD/sg13cmos5l_Clamp_N43N43D4R_0.gate PVDD/sg13cmos5l_RCClampInverter_0.in vdd vdd sg13_hv_pmos ad=1.33p pd=7.38u as=1.33p ps=7.38u w=7u l=0.5u
M190 vss PVDD/sg13cmos5l_Clamp_N43N43D4R_0.gate vdd vss sg13_hv_nmos ad=1.408p pd=5.04u as=2.596p ps=5.58u w=4.4u l=0.6u
M191 vdd PVDD/sg13cmos5l_Clamp_N43N43D4R_0.gate vss vss sg13_hv_nmos ad=2.596p pd=5.58u as=1.408p ps=5.04u w=4.4u l=0.6u
M192 vdd PVDD/sg13cmos5l_Clamp_N43N43D4R_0.gate vss vss sg13_hv_nmos ad=2.596p pd=5.58u as=1.408p ps=5.04u w=4.4u l=0.6u
M193 PVDD/sg13cmos5l_Clamp_N43N43D4R_0.gate PVDD/sg13cmos5l_RCClampInverter_0.in vss vss sg13_hv_nmos ad=1.71p pd=9.38u as=1.71p ps=9.38u w=9u l=0.5u
X194 PVDD/a_6085_11542# PVDD/a_6415_7456# vss PVDD/rppd l=20u w=1u
X195 PVDD/a_9385_11542# PVDD/a_9715_7456# vss PVDD/rppd l=20u w=1u
M196 vss PVDD/sg13cmos5l_Clamp_N43N43D4R_0.gate vdd vss sg13_hv_nmos ad=1.408p pd=5.04u as=2.596p ps=5.58u w=4.4u l=0.6u
M197 vss PVDD/sg13cmos5l_RCClampInverter_0.in vss vss sg13_hv_nmos ad=1.71p pd=9.38u as=0 ps=0 w=9u l=9.5u
M198 PVDD/sg13cmos5l_Clamp_N43N43D4R_0.gate PVDD/sg13cmos5l_RCClampInverter_0.in vss vss sg13_hv_nmos ad=1.71p pd=9.38u as=1.71p ps=9.38u w=9u l=0.5u
M199 vss PVDD/sg13cmos5l_RCClampInverter_0.in vss vss sg13_hv_nmos ad=1.71p pd=9.38u as=0 ps=0 w=9u l=9.5u
X200 PVDD/a_10705_11542# PVDD/a_10375_7456# vss PVDD/rppd l=20u w=1u
M201 PVDD/sg13cmos5l_Clamp_N43N43D4R_0.gate PVDD/sg13cmos5l_RCClampInverter_0.in vss vss sg13_hv_nmos ad=1.71p pd=9.38u as=3.06p ps=18.68u w=9u l=0.5u
M202 vss PVDD/sg13cmos5l_Clamp_N43N43D4R_0.gate vdd vss sg13_hv_nmos ad=1.408p pd=5.04u as=2.596p ps=5.58u w=4.4u l=0.6u
M203 PVDD/sg13cmos5l_Clamp_N43N43D4R_0.gate PVDD/sg13cmos5l_RCClampInverter_0.in vdd vdd sg13_hv_pmos ad=1.33p pd=7.38u as=2.38p ps=14.68u w=7u l=0.5u
M204 vdd PVDD/sg13cmos5l_Clamp_N43N43D4R_0.gate vss vss sg13_hv_nmos ad=3.256p pd=10.28u as=1.408p ps=5.04u w=4.4u l=0.6u
M205 PVDD/sg13cmos5l_Clamp_N43N43D4R_0.gate PVDD/sg13cmos5l_RCClampInverter_0.in vss vss sg13_hv_nmos ad=1.71p pd=9.38u as=3.06p ps=18.68u w=9u l=0.5u
M206 vdd PVDD/sg13cmos5l_Clamp_N43N43D4R_0.gate vss vss sg13_hv_nmos ad=2.596p pd=5.58u as=1.408p ps=5.04u w=4.4u l=0.6u
M207 vdd PVDD/sg13cmos5l_Clamp_N43N43D4R_0.gate vss vss sg13_hv_nmos ad=2.596p pd=5.58u as=1.408p ps=5.04u w=4.4u l=0.6u
M208 vdd PVDD/sg13cmos5l_Clamp_N43N43D4R_0.gate vss vss sg13_hv_nmos ad=2.596p pd=5.58u as=1.408p ps=5.04u w=4.4u l=0.6u
M209 vdd PVDD/sg13cmos5l_Clamp_N43N43D4R_0.gate vss vss sg13_hv_nmos ad=2.596p pd=5.58u as=1.408p ps=5.04u w=4.4u l=0.6u
M210 vdd PVDD/sg13cmos5l_Clamp_N43N43D4R_0.gate vss vss sg13_hv_nmos ad=2.596p pd=5.58u as=1.408p ps=5.04u w=4.4u l=0.6u
M211 vdd PVDD/sg13cmos5l_Clamp_N43N43D4R_0.gate vss vss sg13_hv_nmos ad=2.596p pd=5.58u as=1.408p ps=5.04u w=4.4u l=0.6u
M212 vss PVDD/sg13cmos5l_Clamp_N43N43D4R_0.gate vdd vss sg13_hv_nmos ad=1.408p pd=5.04u as=2.596p ps=5.58u w=4.4u l=0.6u
M213 vdd PVDD/sg13cmos5l_Clamp_N43N43D4R_0.gate vss vss sg13_hv_nmos ad=2.596p pd=5.58u as=1.408p ps=5.04u w=4.4u l=0.6u
M214 vss PVDD/sg13cmos5l_Clamp_N43N43D4R_0.gate vdd vss sg13_hv_nmos ad=1.408p pd=5.04u as=2.596p ps=5.58u w=4.4u l=0.6u
M215 vdd PVDD/sg13cmos5l_Clamp_N43N43D4R_0.gate vss vss sg13_hv_nmos ad=2.596p pd=5.58u as=1.408p ps=5.04u w=4.4u l=0.6u
M216 vss PVDD/sg13cmos5l_RCClampInverter_0.in vss vss sg13_hv_nmos ad=1.71p pd=9.38u as=0 ps=0 w=9u l=9.5u
X217 PVDD/a_6745_11542# PVDD/a_7075_7456# vss PVDD/rppd l=20u w=1u
M218 vdd PVDD/sg13cmos5l_Clamp_N43N43D4R_0.gate vss vss sg13_hv_nmos ad=2.596p pd=5.58u as=1.408p ps=5.04u w=4.4u l=0.6u
M219 vss PVDD/sg13cmos5l_Clamp_N43N43D4R_0.gate vdd vss sg13_hv_nmos ad=1.408p pd=5.04u as=2.596p ps=5.58u w=4.4u l=0.6u
M220 PVDD/sg13cmos5l_Clamp_N43N43D4R_0.gate PVDD/sg13cmos5l_RCClampInverter_0.in vdd vdd sg13_hv_pmos ad=1.33p pd=7.38u as=1.33p ps=7.38u w=7u l=0.5u
M221 vss PVDD/sg13cmos5l_RCClampInverter_0.in vss vss sg13_hv_nmos ad=1.71p pd=9.38u as=0 ps=0 w=9u l=9.5u
M222 vss PVDD/sg13cmos5l_Clamp_N43N43D4R_0.gate vdd vss sg13_hv_nmos ad=1.408p pd=5.04u as=2.596p ps=5.58u w=4.4u l=0.6u
X223 PVDD/a_11365_11542# PVDD/a_11035_7456# vss PVDD/rppd l=20u w=1u
M224 vdd PVDD/sg13cmos5l_Clamp_N43N43D4R_0.gate vss vss sg13_hv_nmos ad=2.596p pd=5.58u as=1.408p ps=5.04u w=4.4u l=0.6u
M225 vdd PVDD/sg13cmos5l_Clamp_N43N43D4R_0.gate vss vss sg13_hv_nmos ad=2.596p pd=5.58u as=2.068p ps=9.74u w=4.4u l=0.6u
M226 PVDD/sg13cmos5l_Clamp_N43N43D4R_0.gate PVDD/sg13cmos5l_RCClampInverter_0.in vdd vdd sg13_hv_pmos ad=1.33p pd=7.38u as=1.33p ps=7.38u w=7u l=0.5u
M227 vdd PVDD/sg13cmos5l_Clamp_N43N43D4R_0.gate vss vss sg13_hv_nmos ad=2.596p pd=5.58u as=1.408p ps=5.04u w=4.4u l=0.6u
M228 vss PVDD/sg13cmos5l_Clamp_N43N43D4R_0.gate vdd vss sg13_hv_nmos ad=1.408p pd=5.04u as=2.596p ps=5.58u w=4.4u l=0.6u
M229 vdd PVDD/sg13cmos5l_RCClampInverter_0.in PVDD/sg13cmos5l_Clamp_N43N43D4R_0.gate vdd sg13_hv_pmos ad=1.33p pd=7.38u as=1.33p ps=7.38u w=7u l=0.5u
M230 PVDD/sg13cmos5l_Clamp_N43N43D4R_0.gate PVDD/sg13cmos5l_RCClampInverter_0.in vdd vdd sg13_hv_pmos ad=1.33p pd=7.38u as=1.33p ps=7.38u w=7u l=0.5u
M231 vdd PVDD/sg13cmos5l_Clamp_N43N43D4R_0.gate vss vss sg13_hv_nmos ad=2.596p pd=5.58u as=1.408p ps=5.04u w=4.4u l=0.6u
M232 vdd PVDD/sg13cmos5l_Clamp_N43N43D4R_0.gate vss vss sg13_hv_nmos ad=2.596p pd=5.58u as=1.408p ps=5.04u w=4.4u l=0.6u
M233 vdd PVDD/sg13cmos5l_Clamp_N43N43D4R_0.gate vss vss sg13_hv_nmos ad=3.256p pd=10.28u as=1.408p ps=5.04u w=4.4u l=0.6u
M234 vdd PVDD/sg13cmos5l_Clamp_N43N43D4R_0.gate vss vss sg13_hv_nmos ad=2.596p pd=5.58u as=1.408p ps=5.04u w=4.4u l=0.6u
M235 vss PVDD/sg13cmos5l_Clamp_N43N43D4R_0.gate vdd vss sg13_hv_nmos ad=1.408p pd=5.04u as=2.596p ps=5.58u w=4.4u l=0.6u
M236 vdd PVDD/sg13cmos5l_Clamp_N43N43D4R_0.gate vss vss sg13_hv_nmos ad=2.596p pd=5.58u as=1.408p ps=5.04u w=4.4u l=0.6u
M237 PVDD/sg13cmos5l_Clamp_N43N43D4R_0.gate PVDD/sg13cmos5l_RCClampInverter_0.in vdd vdd sg13_hv_pmos ad=1.33p pd=7.38u as=1.33p ps=7.38u w=7u l=0.5u
M238 vss PVDD/sg13cmos5l_Clamp_N43N43D4R_0.gate vdd vss sg13_hv_nmos ad=1.408p pd=5.04u as=2.596p ps=5.58u w=4.4u l=0.6u
M239 vss PVDD/sg13cmos5l_Clamp_N43N43D4R_0.gate vdd vss sg13_hv_nmos ad=1.408p pd=5.04u as=2.596p ps=5.58u w=4.4u l=0.6u
M240 vss PVDD/sg13cmos5l_Clamp_N43N43D4R_0.gate vdd vss sg13_hv_nmos ad=1.408p pd=5.04u as=2.596p ps=5.58u w=4.4u l=0.6u
X241 PVDD/a_5425_11542# PVDD/a_5755_7456# vss PVDD/rppd l=20u w=1u
M242 vdd PVDD/sg13cmos5l_Clamp_N43N43D4R_0.gate vss vss sg13_hv_nmos ad=2.596p pd=5.58u as=1.408p ps=5.04u w=4.4u l=0.6u
M243 vdd PVDD/sg13cmos5l_RCClampInverter_0.in PVDD/sg13cmos5l_Clamp_N43N43D4R_0.gate vdd sg13_hv_pmos ad=1.33p pd=7.38u as=1.33p ps=7.38u w=7u l=0.5u
M244 PVDD/sg13cmos5l_Clamp_N43N43D4R_0.gate PVDD/sg13cmos5l_RCClampInverter_0.in vdd vdd sg13_hv_pmos ad=1.33p pd=7.38u as=1.33p ps=7.38u w=7u l=0.5u
M245 vdd PVDD/sg13cmos5l_Clamp_N43N43D4R_0.gate vss vss sg13_hv_nmos ad=2.596p pd=5.58u as=1.408p ps=5.04u w=4.4u l=0.6u
M246 vss PVDD/sg13cmos5l_Clamp_N43N43D4R_0.gate vdd vss sg13_hv_nmos ad=1.408p pd=5.04u as=2.596p ps=5.58u w=4.4u l=0.6u
M247 vdd PVDD/sg13cmos5l_Clamp_N43N43D4R_0.gate vss vss sg13_hv_nmos ad=2.596p pd=5.58u as=1.408p ps=5.04u w=4.4u l=0.6u
M248 vdd PVDD/sg13cmos5l_Clamp_N43N43D4R_0.gate vss vss sg13_hv_nmos ad=2.596p pd=5.58u as=2.068p ps=9.74u w=4.4u l=0.6u
M249 vss PVDD/sg13cmos5l_Clamp_N43N43D4R_0.gate vdd vss sg13_hv_nmos ad=1.408p pd=5.04u as=2.596p ps=5.58u w=4.4u l=0.6u
M250 vdd PVDD/sg13cmos5l_Clamp_N43N43D4R_0.gate vss vss sg13_hv_nmos ad=2.596p pd=5.58u as=1.408p ps=5.04u w=4.4u l=0.6u
M251 vdd PVDD/sg13cmos5l_Clamp_N43N43D4R_0.gate vss vss sg13_hv_nmos ad=2.596p pd=5.58u as=1.408p ps=5.04u w=4.4u l=0.6u
M252 vss PVDD/sg13cmos5l_Clamp_N43N43D4R_0.gate vdd vss sg13_hv_nmos ad=1.408p pd=5.04u as=2.596p ps=5.58u w=4.4u l=0.6u
X253 PVDD/a_4105_11542# PVDD/a_3775_7456# vss PVDD/rppd l=20u w=1u
X254 PVDD/a_7405_11542# PVDD/a_7075_7456# vss PVDD/rppd l=20u w=1u
M255 vss PVDD/sg13cmos5l_Clamp_N43N43D4R_0.gate vdd vss sg13_hv_nmos ad=1.408p pd=5.04u as=2.596p ps=5.58u w=4.4u l=0.6u
M256 vss PVDD/sg13cmos5l_Clamp_N43N43D4R_0.gate vdd vss sg13_hv_nmos ad=1.408p pd=5.04u as=2.596p ps=5.58u w=4.4u l=0.6u
M257 vdd PVDD/sg13cmos5l_Clamp_N43N43D4R_0.gate vss vss sg13_hv_nmos ad=2.596p pd=5.58u as=1.408p ps=5.04u w=4.4u l=0.6u
M258 vss PVDD/sg13cmos5l_Clamp_N43N43D4R_0.gate vdd vss sg13_hv_nmos ad=1.408p pd=5.04u as=2.596p ps=5.58u w=4.4u l=0.6u
M259 vss PVDD/sg13cmos5l_Clamp_N43N43D4R_0.gate vdd vss sg13_hv_nmos ad=1.408p pd=5.04u as=2.596p ps=5.58u w=4.4u l=0.6u
M260 vdd PVDD/sg13cmos5l_RCClampInverter_0.in PVDD/sg13cmos5l_Clamp_N43N43D4R_0.gate vdd sg13_hv_pmos ad=1.33p pd=7.38u as=1.33p ps=7.38u w=7u l=0.5u
M261 vdd PVDD/sg13cmos5l_Clamp_N43N43D4R_0.gate vss vss sg13_hv_nmos ad=2.596p pd=5.58u as=1.408p ps=5.04u w=4.4u l=0.6u
M262 vdd PVDD/sg13cmos5l_Clamp_N43N43D4R_0.gate vss vss sg13_hv_nmos ad=2.596p pd=5.58u as=1.408p ps=5.04u w=4.4u l=0.6u
M263 vdd PVDD/sg13cmos5l_Clamp_N43N43D4R_0.gate vss vss sg13_hv_nmos ad=2.596p pd=5.58u as=1.408p ps=5.04u w=4.4u l=0.6u
M264 vss PVDD/sg13cmos5l_Clamp_N43N43D4R_0.gate vdd vss sg13_hv_nmos ad=1.408p pd=5.04u as=2.596p ps=5.58u w=4.4u l=0.6u
M265 vdd PVDD/sg13cmos5l_RCClampInverter_0.in PVDD/sg13cmos5l_Clamp_N43N43D4R_0.gate vdd sg13_hv_pmos ad=1.33p pd=7.38u as=1.33p ps=7.38u w=7u l=0.5u
M266 vdd PVDD/sg13cmos5l_Clamp_N43N43D4R_0.gate vss vss sg13_hv_nmos ad=2.596p pd=5.58u as=1.408p ps=5.04u w=4.4u l=0.6u
M267 vdd PVDD/sg13cmos5l_Clamp_N43N43D4R_0.gate vss vss sg13_hv_nmos ad=2.596p pd=5.58u as=1.408p ps=5.04u w=4.4u l=0.6u
X268 vss PVDD/a_906_5348# PVDD/dantenna PVDD/l=0.48u w=0.48u
M269 vss PVDD/sg13cmos5l_Clamp_N43N43D4R_0.gate vdd vss sg13_hv_nmos ad=1.408p pd=5.04u as=2.596p ps=5.58u w=4.4u l=0.6u
M270 PVDD/sg13cmos5l_Clamp_N43N43D4R_0.gate PVDD/sg13cmos5l_RCClampInverter_0.in vss vss sg13_hv_nmos ad=1.71p pd=9.38u as=1.71p ps=9.38u w=9u l=0.5u
M271 vss PVDD/sg13cmos5l_Clamp_N43N43D4R_0.gate vdd vss sg13_hv_nmos ad=1.408p pd=5.04u as=2.596p ps=5.58u w=4.4u l=0.6u
M272 vss PVDD/sg13cmos5l_Clamp_N43N43D4R_0.gate vdd vss sg13_hv_nmos ad=1.408p pd=5.04u as=2.596p ps=5.58u w=4.4u l=0.6u
M273 vss PVDD/sg13cmos5l_Clamp_N43N43D4R_0.gate vdd vss sg13_hv_nmos ad=1.408p pd=5.04u as=2.596p ps=5.58u w=4.4u l=0.6u
M274 PVDD/sg13cmos5l_Clamp_N43N43D4R_0.gate PVDD/sg13cmos5l_RCClampInverter_0.in vss vss sg13_hv_nmos ad=1.71p pd=9.38u as=1.71p ps=9.38u w=9u l=0.5u
X0 vss PVSS/iovdd PVSS/dpantenna PVSS/l=27.78u w=1.26u
X1 vss PVSS/iovdd PVSS/dpantenna PVSS/l=27.78u w=1.26u
X2 vss PVSS/a_1682_2060# PVSS/dantenna PVSS/l=27.78u w=1.26u
X3 vss PVSS/a_782_2060# PVSS/dantenna PVSS/l=27.78u w=1.26u
.ends
