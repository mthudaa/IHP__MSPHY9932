* Extracted by KLayout with SG13CMOS5L LVS runset on : 11/07/2026 19:03

.SUBCKT MSPHY9932 A A$1 A|A1|B|Y A|A_N|B|B_N|Q A|B|B2|B_N|Q A|B|B_N|Q A|B|X
+ A|B_N|Q A|CLK|Q A|CLK|X A|CLK|X$1 A|D|Q A|D|Q$1 A|Q A|Q$1 A|Q$2 A|Q$3 A|Q$4
+ A|Q$5 A|Q$6 A|Q$7 A|Q$8 A|Q$9 A|Q$10 A|Q$11 A|Q$12 A|Q$13 A|Q$14 A|Q$15
+ A|Q$16 A|Q$17 A|Q$18 A|Q$19 A|Q$20 A|Q$21 A|Q$22 A|Q$23 A|Q$24 A|X A|X$1
+ A|X$2 A|X$3 A|X$4 A|X$5 A|X$6 A|X$7 A|X$8 A|X$9 A|X$10 A|X$11 A|X$12 A|X$13
+ A|X$14 A|X$15 A|X$16 A|X$17 A|X$18 A|X$19 A|X$20 A|X$21 A|X$22 A|X$23 A|X$24
+ A|X$25 A|X$26 A|X$27 A|X$28 A|X$29 A|X$30 A|X$31 A|X$32 A|X$33 A|X$34 A|X$35
+ A|X$36 A|X$37 A|X$38 A|X$39 A|X$40 A|X$41 A|X$42 A|X$43 A|X$44 A|X$45 A|X$46
+ A|X$47 A|X$48 A|X$49 A|X$50 A|X$51 A|X$52 A|X$53 A|X$54 A|X$55 A|X$56 A|X$57
+ A|X$58 A|X$59 A|X$60 A|X$61 A|X$62 A|X$63 A|X$64 A|X$65 A|X$66 A|X$67 A|X$68
+ A|X$69 A|X$70 A|X$71 A|X$72 A|X$73 A|X|rdy A|Y A|Y$1 A|Y$2 A|Y$3 A|Y$4 A|Y$5
+ A|Y$6 A|Y$7 A|Y$8 A|Y$9 A|Y$10 A|Y$11 A|Y$12 A|Y$13 A|Y$14 A|Y$15 A|Y$16
+ A|Y$17 A|Y$18 A|Y$19 A|Y$20 A|Y$21 A|Y$22 A|Y$23 A|Y$24 A|Y$25 A|Y$26 A|Y$27
+ A|Y$28 A|Y$29 A|Y$30 A|anode|cathode|ck|cks|core|pad|padres A|comp_p|outp
+ A|outn A1|D|Q A1|D|Q$1 A1|D|Q$2 A1|D|Q$3 A1|Y A1|Y$1 A1|Y$2 A1|Y$3 A1|Y$4
+ A2|B|B1|C1|Y A2|B|B1|Y A2|B|B1|Y$1 A2|B1|Y A2|D|Q A2|Y A_N|D|Q B|D|Y B|Y
+ B|Y$1 B|Y$2 B1|X B1|Y B1|Y$1 B1|Y$2 B1|Y$3 B2|D|Q B2|D|Q$1 B2|Y B2|Y$1 B2|Y$2
+ BOTTOM|TOP|VGND|VSS|anode|cathode|core|h_sw[0]|h_sw[10]|h_sw[1]|h_sw[2]|h_sw[3]|h_sw[4]|h_sw[5]|h_sw[6]|h_sw[7]|h_sw[8]|h_sw[9]|l_sw[0]|l_sw[10]|l_sw[1]|l_sw[2]|l_sw[3]|l_sw[4]|l_sw[5]|l_sw[6]|l_sw[7]|l_sw[8]|l_sw[9]|out|pad|padres|vc|vcp|vdd|vddr|vip|vss|z
+ C|D|Q C|Q C1|X C1|X$1 CLK|D|GATE|Q CLK|D|GATE|Q$1 CLK|D|GATE|Q$2
+ CLK|D|GATE|Q$3 CLK|D|GATE|Q$4 CLK|D|GATE|Q$5 CLK|D|GATE|Q$6 CLK|D|GATE|Q$7
+ CLK|D|GATE|Q$8 CLK|D|GATE|Q$9 CLK|D|GATE|Q$10 CLK|Y D|L_HI D|Q_N D|Q_N$1
+ D|Q_N$2 D|Q_N$3 D|Q_N$4 D|Q_N$5 D|Q_N$6 D|Q_N$7 D|Q_N$8 D|Q_N$9 D|Q_N$10 D|X
+ D|X$1 D|Y D|Y$1 D|Y$2 D|Y$3 D|Y$4 D|Y$5 Q_N Q_N$1 Q_N$2 Q_N$3 Q_N$4 Q_N$5
+ Q_N$6 Q_N$7 Q_N$8 Q_N$9 Q_N$10 Q_N$11 Q_N$12 Q_N$13 Q_N$14 Q_N$15 Q_N$16
+ Q_N$17 Q_N$18 Q_N$19 Q_N$20 Q_N$21 Q_N$22 Q_N$23 Q_N$24 Q_N$25 Q_N$26 Q_N$27
+ Q_N$28 Q_N$29 Q_N$30 Q_N$31 Q_N$32 Q_N$33 Q_N$34 Q_N$35 Q_N$36 Q_N$37 Q_N$38
+ Q_N$39 Q_N$40 Q_N$41 RESET_B|Y RESET_B|Y$1 RESET_B|Y$2 VDD|VPWR|vdd
+ X|anode|cathode|cko|core|pad|padres
+ X|anode|cathode|core|d_out[0]|dout[0]|pad|padres
+ X|anode|cathode|core|d_out[1]|dout[1]|pad|padres
+ X|anode|cathode|core|d_out[2]|dout[2]|pad|padres
+ X|anode|cathode|core|frame|pad|padres X|ckc|clk X|in_h_sw[0]|nh_sw[0]|x
+ X|in_h_sw[0]|ph_sw[0]|x X|in_h_sw[10]|nh_sw[10]|x X|in_h_sw[10]|ph_sw[10]|x
+ X|in_h_sw[1]|nh_sw[1]|x X|in_h_sw[1]|ph_sw[1]|x X|in_h_sw[2]|nh_sw[2]|x
+ X|in_h_sw[2]|ph_sw[2]|x X|in_h_sw[3]|nh_sw[3]|x X|in_h_sw[3]|ph_sw[3]|x
+ X|in_h_sw[4]|nh_sw[4]|x X|in_h_sw[4]|ph_sw[4]|x X|in_h_sw[5]|nh_sw[5]|x
+ X|in_h_sw[5]|ph_sw[5]|x X|in_h_sw[6]|nh_sw[6]|x X|in_h_sw[6]|ph_sw[6]|x
+ X|in_h_sw[7]|nh_sw[7]|x X|in_h_sw[7]|ph_sw[7]|x X|in_h_sw[8]|nh_sw[8]|x
+ X|in_h_sw[8]|ph_sw[8]|x X|in_h_sw[9]|nh_sw[9]|x X|in_h_sw[9]|ph_sw[9]|x
+ X|in_l_sw[0]|nl_sw[0]|x X|in_l_sw[0]|pl_sw[0]|x X|in_l_sw[10]|nl_sw[10]|x
+ X|in_l_sw[10]|pl_sw[10]|x X|in_l_sw[1]|nl_sw[1]|x X|in_l_sw[1]|pl_sw[1]|x
+ X|in_l_sw[2]|nl_sw[2]|x X|in_l_sw[2]|pl_sw[2]|x X|in_l_sw[3]|nl_sw[3]|x
+ X|in_l_sw[3]|pl_sw[3]|x X|in_l_sw[4]|nl_sw[4]|x X|in_l_sw[4]|pl_sw[4]|x
+ X|in_l_sw[5]|nl_sw[5]|x X|in_l_sw[5]|pl_sw[5]|x X|in_l_sw[6]|nl_sw[6]|x
+ X|in_l_sw[6]|pl_sw[6]|x X|in_l_sw[7]|nl_sw[7]|x X|in_l_sw[7]|pl_sw[7]|x
+ X|in_l_sw[8]|nl_sw[8]|x X|in_l_sw[8]|pl_sw[8]|x X|in_l_sw[9]|nl_sw[9]|x
+ X|in_l_sw[9]|pl_sw[9]|x Y Y$1 Y$2 Y$3 anode|cathode|core|in|pad|padres|vin
+ anode|cathode|core|in|pad|padres|vip anode|cathode|core|pad|padres
+ anode|cathode|core|pad|padres$1 anode|cathode|core|pad|padres$2
+ anode|cathode|core|pad|padres$3 anode|cathode|core|pad|padres$4
+ anode|cathode|core|pad|padres$5 anode|cathode|core|pad|padres$6
+ anode|cathode|core|pad|padres$7 anode|cathode|core|pad|padres$8
+ anode|cathode|vss anode|guard|iovss cathode|iovdd gate|out
+ in|pad|pin1|pin2|vdd out|vcn|vin supply|vdd
M$1
+ BOTTOM|TOP|VGND|VSS|anode|cathode|core|h_sw[0]|h_sw[10]|h_sw[1]|h_sw[2]|h_sw[3]|h_sw[4]|h_sw[5]|h_sw[6]|h_sw[7]|h_sw[8]|h_sw[9]|l_sw[0]|l_sw[10]|l_sw[1]|l_sw[2]|l_sw[3]|l_sw[4]|l_sw[5]|l_sw[6]|l_sw[7]|l_sw[8]|l_sw[9]|out|pad|padres|vc|vcp|vdd|vddr|vip|vss|z
+ X|in_h_sw[0]|nh_sw[0]|x
+ BOTTOM|TOP|VGND|VSS|anode|cathode|core|h_sw[0]|h_sw[10]|h_sw[1]|h_sw[2]|h_sw[3]|h_sw[4]|h_sw[5]|h_sw[6]|h_sw[7]|h_sw[8]|h_sw[9]|l_sw[0]|l_sw[10]|l_sw[1]|l_sw[2]|l_sw[3]|l_sw[4]|l_sw[5]|l_sw[6]|l_sw[7]|l_sw[8]|l_sw[9]|out|pad|padres|vc|vcp|vdd|vddr|vip|vss|z
+ BOTTOM|TOP|VGND|VSS|anode|cathode|core|h_sw[0]|h_sw[10]|h_sw[1]|h_sw[2]|h_sw[3]|h_sw[4]|h_sw[5]|h_sw[6]|h_sw[7]|h_sw[8]|h_sw[9]|l_sw[0]|l_sw[10]|l_sw[1]|l_sw[2]|l_sw[3]|l_sw[4]|l_sw[5]|l_sw[6]|l_sw[7]|l_sw[8]|l_sw[9]|out|pad|padres|vc|vcp|vdd|vddr|vip|vss|z
+ sg13_lv_nmos L=0.13u W=16u AS=3.115p AD=3.115p PS=28.96u PD=28.96u rfmode=0
M$33
+ BOTTOM|TOP|VGND|VSS|anode|cathode|core|h_sw[0]|h_sw[10]|h_sw[1]|h_sw[2]|h_sw[3]|h_sw[4]|h_sw[5]|h_sw[6]|h_sw[7]|h_sw[8]|h_sw[9]|l_sw[0]|l_sw[10]|l_sw[1]|l_sw[2]|l_sw[3]|l_sw[4]|l_sw[5]|l_sw[6]|l_sw[7]|l_sw[8]|l_sw[9]|out|pad|padres|vc|vcp|vdd|vddr|vip|vss|z
+ X|in_h_sw[1]|nh_sw[1]|x
+ BOTTOM|TOP|VGND|VSS|anode|cathode|core|h_sw[0]|h_sw[10]|h_sw[1]|h_sw[2]|h_sw[3]|h_sw[4]|h_sw[5]|h_sw[6]|h_sw[7]|h_sw[8]|h_sw[9]|l_sw[0]|l_sw[10]|l_sw[1]|l_sw[2]|l_sw[3]|l_sw[4]|l_sw[5]|l_sw[6]|l_sw[7]|l_sw[8]|l_sw[9]|out|pad|padres|vc|vcp|vdd|vddr|vip|vss|z
+ BOTTOM|TOP|VGND|VSS|anode|cathode|core|h_sw[0]|h_sw[10]|h_sw[1]|h_sw[2]|h_sw[3]|h_sw[4]|h_sw[5]|h_sw[6]|h_sw[7]|h_sw[8]|h_sw[9]|l_sw[0]|l_sw[10]|l_sw[1]|l_sw[2]|l_sw[3]|l_sw[4]|l_sw[5]|l_sw[6]|l_sw[7]|l_sw[8]|l_sw[9]|out|pad|padres|vc|vcp|vdd|vddr|vip|vss|z
+ sg13_lv_nmos L=0.13u W=8u AS=1.595p AD=1.595p PS=14.88u PD=14.88u rfmode=0
M$49
+ BOTTOM|TOP|VGND|VSS|anode|cathode|core|h_sw[0]|h_sw[10]|h_sw[1]|h_sw[2]|h_sw[3]|h_sw[4]|h_sw[5]|h_sw[6]|h_sw[7]|h_sw[8]|h_sw[9]|l_sw[0]|l_sw[10]|l_sw[1]|l_sw[2]|l_sw[3]|l_sw[4]|l_sw[5]|l_sw[6]|l_sw[7]|l_sw[8]|l_sw[9]|out|pad|padres|vc|vcp|vdd|vddr|vip|vss|z
+ X|in_l_sw[3]|nl_sw[3]|x
+ BOTTOM|TOP|VGND|VSS|anode|cathode|core|h_sw[0]|h_sw[10]|h_sw[1]|h_sw[2]|h_sw[3]|h_sw[4]|h_sw[5]|h_sw[6]|h_sw[7]|h_sw[8]|h_sw[9]|l_sw[0]|l_sw[10]|l_sw[1]|l_sw[2]|l_sw[3]|l_sw[4]|l_sw[5]|l_sw[6]|l_sw[7]|l_sw[8]|l_sw[9]|out|pad|padres|vc|vcp|vdd|vddr|vip|vss|z
+ BOTTOM|TOP|VGND|VSS|anode|cathode|core|h_sw[0]|h_sw[10]|h_sw[1]|h_sw[2]|h_sw[3]|h_sw[4]|h_sw[5]|h_sw[6]|h_sw[7]|h_sw[8]|h_sw[9]|l_sw[0]|l_sw[10]|l_sw[1]|l_sw[2]|l_sw[3]|l_sw[4]|l_sw[5]|l_sw[6]|l_sw[7]|l_sw[8]|l_sw[9]|out|pad|padres|vc|vcp|vdd|vddr|vip|vss|z
+ sg13_lv_nmos L=0.13u W=4u AS=0.835p AD=0.835p PS=7.84u PD=7.84u rfmode=0
M$57
+ BOTTOM|TOP|VGND|VSS|anode|cathode|core|h_sw[0]|h_sw[10]|h_sw[1]|h_sw[2]|h_sw[3]|h_sw[4]|h_sw[5]|h_sw[6]|h_sw[7]|h_sw[8]|h_sw[9]|l_sw[0]|l_sw[10]|l_sw[1]|l_sw[2]|l_sw[3]|l_sw[4]|l_sw[5]|l_sw[6]|l_sw[7]|l_sw[8]|l_sw[9]|out|pad|padres|vc|vcp|vdd|vddr|vip|vss|z
+ X|in_l_sw[4]|nl_sw[4]|x
+ BOTTOM|TOP|VGND|VSS|anode|cathode|core|h_sw[0]|h_sw[10]|h_sw[1]|h_sw[2]|h_sw[3]|h_sw[4]|h_sw[5]|h_sw[6]|h_sw[7]|h_sw[8]|h_sw[9]|l_sw[0]|l_sw[10]|l_sw[1]|l_sw[2]|l_sw[3]|l_sw[4]|l_sw[5]|l_sw[6]|l_sw[7]|l_sw[8]|l_sw[9]|out|pad|padres|vc|vcp|vdd|vddr|vip|vss|z
+ BOTTOM|TOP|VGND|VSS|anode|cathode|core|h_sw[0]|h_sw[10]|h_sw[1]|h_sw[2]|h_sw[3]|h_sw[4]|h_sw[5]|h_sw[6]|h_sw[7]|h_sw[8]|h_sw[9]|l_sw[0]|l_sw[10]|l_sw[1]|l_sw[2]|l_sw[3]|l_sw[4]|l_sw[5]|l_sw[6]|l_sw[7]|l_sw[8]|l_sw[9]|out|pad|padres|vc|vcp|vdd|vddr|vip|vss|z
+ sg13_lv_nmos L=0.13u W=4u AS=0.835p AD=0.835p PS=7.84u PD=7.84u rfmode=0
M$65
+ BOTTOM|TOP|VGND|VSS|anode|cathode|core|h_sw[0]|h_sw[10]|h_sw[1]|h_sw[2]|h_sw[3]|h_sw[4]|h_sw[5]|h_sw[6]|h_sw[7]|h_sw[8]|h_sw[9]|l_sw[0]|l_sw[10]|l_sw[1]|l_sw[2]|l_sw[3]|l_sw[4]|l_sw[5]|l_sw[6]|l_sw[7]|l_sw[8]|l_sw[9]|out|pad|padres|vc|vcp|vdd|vddr|vip|vss|z
+ X|in_l_sw[5]|nl_sw[5]|x
+ BOTTOM|TOP|VGND|VSS|anode|cathode|core|h_sw[0]|h_sw[10]|h_sw[1]|h_sw[2]|h_sw[3]|h_sw[4]|h_sw[5]|h_sw[6]|h_sw[7]|h_sw[8]|h_sw[9]|l_sw[0]|l_sw[10]|l_sw[1]|l_sw[2]|l_sw[3]|l_sw[4]|l_sw[5]|l_sw[6]|l_sw[7]|l_sw[8]|l_sw[9]|out|pad|padres|vc|vcp|vdd|vddr|vip|vss|z
+ BOTTOM|TOP|VGND|VSS|anode|cathode|core|h_sw[0]|h_sw[10]|h_sw[1]|h_sw[2]|h_sw[3]|h_sw[4]|h_sw[5]|h_sw[6]|h_sw[7]|h_sw[8]|h_sw[9]|l_sw[0]|l_sw[10]|l_sw[1]|l_sw[2]|l_sw[3]|l_sw[4]|l_sw[5]|l_sw[6]|l_sw[7]|l_sw[8]|l_sw[9]|out|pad|padres|vc|vcp|vdd|vddr|vip|vss|z
+ sg13_lv_nmos L=0.13u W=4u AS=0.835p AD=0.835p PS=7.84u PD=7.84u rfmode=0
M$73
+ BOTTOM|TOP|VGND|VSS|anode|cathode|core|h_sw[0]|h_sw[10]|h_sw[1]|h_sw[2]|h_sw[3]|h_sw[4]|h_sw[5]|h_sw[6]|h_sw[7]|h_sw[8]|h_sw[9]|l_sw[0]|l_sw[10]|l_sw[1]|l_sw[2]|l_sw[3]|l_sw[4]|l_sw[5]|l_sw[6]|l_sw[7]|l_sw[8]|l_sw[9]|out|pad|padres|vc|vcp|vdd|vddr|vip|vss|z
+ X|in_l_sw[6]|nl_sw[6]|x
+ BOTTOM|TOP|VGND|VSS|anode|cathode|core|h_sw[0]|h_sw[10]|h_sw[1]|h_sw[2]|h_sw[3]|h_sw[4]|h_sw[5]|h_sw[6]|h_sw[7]|h_sw[8]|h_sw[9]|l_sw[0]|l_sw[10]|l_sw[1]|l_sw[2]|l_sw[3]|l_sw[4]|l_sw[5]|l_sw[6]|l_sw[7]|l_sw[8]|l_sw[9]|out|pad|padres|vc|vcp|vdd|vddr|vip|vss|z
+ BOTTOM|TOP|VGND|VSS|anode|cathode|core|h_sw[0]|h_sw[10]|h_sw[1]|h_sw[2]|h_sw[3]|h_sw[4]|h_sw[5]|h_sw[6]|h_sw[7]|h_sw[8]|h_sw[9]|l_sw[0]|l_sw[10]|l_sw[1]|l_sw[2]|l_sw[3]|l_sw[4]|l_sw[5]|l_sw[6]|l_sw[7]|l_sw[8]|l_sw[9]|out|pad|padres|vc|vcp|vdd|vddr|vip|vss|z
+ sg13_lv_nmos L=0.13u W=2u AS=0.455p AD=0.455p PS=4.32u PD=4.32u rfmode=0
M$77
+ BOTTOM|TOP|VGND|VSS|anode|cathode|core|h_sw[0]|h_sw[10]|h_sw[1]|h_sw[2]|h_sw[3]|h_sw[4]|h_sw[5]|h_sw[6]|h_sw[7]|h_sw[8]|h_sw[9]|l_sw[0]|l_sw[10]|l_sw[1]|l_sw[2]|l_sw[3]|l_sw[4]|l_sw[5]|l_sw[6]|l_sw[7]|l_sw[8]|l_sw[9]|out|pad|padres|vc|vcp|vdd|vddr|vip|vss|z
+ X|in_l_sw[7]|nl_sw[7]|x
+ BOTTOM|TOP|VGND|VSS|anode|cathode|core|h_sw[0]|h_sw[10]|h_sw[1]|h_sw[2]|h_sw[3]|h_sw[4]|h_sw[5]|h_sw[6]|h_sw[7]|h_sw[8]|h_sw[9]|l_sw[0]|l_sw[10]|l_sw[1]|l_sw[2]|l_sw[3]|l_sw[4]|l_sw[5]|l_sw[6]|l_sw[7]|l_sw[8]|l_sw[9]|out|pad|padres|vc|vcp|vdd|vddr|vip|vss|z
+ BOTTOM|TOP|VGND|VSS|anode|cathode|core|h_sw[0]|h_sw[10]|h_sw[1]|h_sw[2]|h_sw[3]|h_sw[4]|h_sw[5]|h_sw[6]|h_sw[7]|h_sw[8]|h_sw[9]|l_sw[0]|l_sw[10]|l_sw[1]|l_sw[2]|l_sw[3]|l_sw[4]|l_sw[5]|l_sw[6]|l_sw[7]|l_sw[8]|l_sw[9]|out|pad|padres|vc|vcp|vdd|vddr|vip|vss|z
+ sg13_lv_nmos L=0.13u W=2u AS=0.455p AD=0.455p PS=4.32u PD=4.32u rfmode=0
M$81
+ BOTTOM|TOP|VGND|VSS|anode|cathode|core|h_sw[0]|h_sw[10]|h_sw[1]|h_sw[2]|h_sw[3]|h_sw[4]|h_sw[5]|h_sw[6]|h_sw[7]|h_sw[8]|h_sw[9]|l_sw[0]|l_sw[10]|l_sw[1]|l_sw[2]|l_sw[3]|l_sw[4]|l_sw[5]|l_sw[6]|l_sw[7]|l_sw[8]|l_sw[9]|out|pad|padres|vc|vcp|vdd|vddr|vip|vss|z
+ X|in_l_sw[8]|nl_sw[8]|x
+ BOTTOM|TOP|VGND|VSS|anode|cathode|core|h_sw[0]|h_sw[10]|h_sw[1]|h_sw[2]|h_sw[3]|h_sw[4]|h_sw[5]|h_sw[6]|h_sw[7]|h_sw[8]|h_sw[9]|l_sw[0]|l_sw[10]|l_sw[1]|l_sw[2]|l_sw[3]|l_sw[4]|l_sw[5]|l_sw[6]|l_sw[7]|l_sw[8]|l_sw[9]|out|pad|padres|vc|vcp|vdd|vddr|vip|vss|z
+ BOTTOM|TOP|VGND|VSS|anode|cathode|core|h_sw[0]|h_sw[10]|h_sw[1]|h_sw[2]|h_sw[3]|h_sw[4]|h_sw[5]|h_sw[6]|h_sw[7]|h_sw[8]|h_sw[9]|l_sw[0]|l_sw[10]|l_sw[1]|l_sw[2]|l_sw[3]|l_sw[4]|l_sw[5]|l_sw[6]|l_sw[7]|l_sw[8]|l_sw[9]|out|pad|padres|vc|vcp|vdd|vddr|vip|vss|z
+ sg13_lv_nmos L=0.13u W=1u AS=0.265p AD=0.265p PS=2.56u PD=2.56u rfmode=0
M$83
+ BOTTOM|TOP|VGND|VSS|anode|cathode|core|h_sw[0]|h_sw[10]|h_sw[1]|h_sw[2]|h_sw[3]|h_sw[4]|h_sw[5]|h_sw[6]|h_sw[7]|h_sw[8]|h_sw[9]|l_sw[0]|l_sw[10]|l_sw[1]|l_sw[2]|l_sw[3]|l_sw[4]|l_sw[5]|l_sw[6]|l_sw[7]|l_sw[8]|l_sw[9]|out|pad|padres|vc|vcp|vdd|vddr|vip|vss|z
+ X|in_l_sw[9]|nl_sw[9]|x
+ BOTTOM|TOP|VGND|VSS|anode|cathode|core|h_sw[0]|h_sw[10]|h_sw[1]|h_sw[2]|h_sw[3]|h_sw[4]|h_sw[5]|h_sw[6]|h_sw[7]|h_sw[8]|h_sw[9]|l_sw[0]|l_sw[10]|l_sw[1]|l_sw[2]|l_sw[3]|l_sw[4]|l_sw[5]|l_sw[6]|l_sw[7]|l_sw[8]|l_sw[9]|out|pad|padres|vc|vcp|vdd|vddr|vip|vss|z
+ BOTTOM|TOP|VGND|VSS|anode|cathode|core|h_sw[0]|h_sw[10]|h_sw[1]|h_sw[2]|h_sw[3]|h_sw[4]|h_sw[5]|h_sw[6]|h_sw[7]|h_sw[8]|h_sw[9]|l_sw[0]|l_sw[10]|l_sw[1]|l_sw[2]|l_sw[3]|l_sw[4]|l_sw[5]|l_sw[6]|l_sw[7]|l_sw[8]|l_sw[9]|out|pad|padres|vc|vcp|vdd|vddr|vip|vss|z
+ sg13_lv_nmos L=0.13u W=1u AS=0.265p AD=0.265p PS=2.56u PD=2.56u rfmode=0
M$85
+ BOTTOM|TOP|VGND|VSS|anode|cathode|core|h_sw[0]|h_sw[10]|h_sw[1]|h_sw[2]|h_sw[3]|h_sw[4]|h_sw[5]|h_sw[6]|h_sw[7]|h_sw[8]|h_sw[9]|l_sw[0]|l_sw[10]|l_sw[1]|l_sw[2]|l_sw[3]|l_sw[4]|l_sw[5]|l_sw[6]|l_sw[7]|l_sw[8]|l_sw[9]|out|pad|padres|vc|vcp|vdd|vddr|vip|vss|z
+ X|in_l_sw[10]|nl_sw[10]|x
+ BOTTOM|TOP|VGND|VSS|anode|cathode|core|h_sw[0]|h_sw[10]|h_sw[1]|h_sw[2]|h_sw[3]|h_sw[4]|h_sw[5]|h_sw[6]|h_sw[7]|h_sw[8]|h_sw[9]|l_sw[0]|l_sw[10]|l_sw[1]|l_sw[2]|l_sw[3]|l_sw[4]|l_sw[5]|l_sw[6]|l_sw[7]|l_sw[8]|l_sw[9]|out|pad|padres|vc|vcp|vdd|vddr|vip|vss|z
+ BOTTOM|TOP|VGND|VSS|anode|cathode|core|h_sw[0]|h_sw[10]|h_sw[1]|h_sw[2]|h_sw[3]|h_sw[4]|h_sw[5]|h_sw[6]|h_sw[7]|h_sw[8]|h_sw[9]|l_sw[0]|l_sw[10]|l_sw[1]|l_sw[2]|l_sw[3]|l_sw[4]|l_sw[5]|l_sw[6]|l_sw[7]|l_sw[8]|l_sw[9]|out|pad|padres|vc|vcp|vdd|vddr|vip|vss|z
+ sg13_lv_nmos L=0.13u W=0.5u AS=0.17p AD=0.17p PS=1.68u PD=1.68u rfmode=0
M$86
+ BOTTOM|TOP|VGND|VSS|anode|cathode|core|h_sw[0]|h_sw[10]|h_sw[1]|h_sw[2]|h_sw[3]|h_sw[4]|h_sw[5]|h_sw[6]|h_sw[7]|h_sw[8]|h_sw[9]|l_sw[0]|l_sw[10]|l_sw[1]|l_sw[2]|l_sw[3]|l_sw[4]|l_sw[5]|l_sw[6]|l_sw[7]|l_sw[8]|l_sw[9]|out|pad|padres|vc|vcp|vdd|vddr|vip|vss|z
+ X|in_l_sw[0]|nl_sw[0]|x
+ BOTTOM|TOP|VGND|VSS|anode|cathode|core|h_sw[0]|h_sw[10]|h_sw[1]|h_sw[2]|h_sw[3]|h_sw[4]|h_sw[5]|h_sw[6]|h_sw[7]|h_sw[8]|h_sw[9]|l_sw[0]|l_sw[10]|l_sw[1]|l_sw[2]|l_sw[3]|l_sw[4]|l_sw[5]|l_sw[6]|l_sw[7]|l_sw[8]|l_sw[9]|out|pad|padres|vc|vcp|vdd|vddr|vip|vss|z
+ BOTTOM|TOP|VGND|VSS|anode|cathode|core|h_sw[0]|h_sw[10]|h_sw[1]|h_sw[2]|h_sw[3]|h_sw[4]|h_sw[5]|h_sw[6]|h_sw[7]|h_sw[8]|h_sw[9]|l_sw[0]|l_sw[10]|l_sw[1]|l_sw[2]|l_sw[3]|l_sw[4]|l_sw[5]|l_sw[6]|l_sw[7]|l_sw[8]|l_sw[9]|out|pad|padres|vc|vcp|vdd|vddr|vip|vss|z
+ sg13_lv_nmos L=0.13u W=16u AS=3.115p AD=3.115p PS=28.96u PD=28.96u rfmode=0
M$118
+ BOTTOM|TOP|VGND|VSS|anode|cathode|core|h_sw[0]|h_sw[10]|h_sw[1]|h_sw[2]|h_sw[3]|h_sw[4]|h_sw[5]|h_sw[6]|h_sw[7]|h_sw[8]|h_sw[9]|l_sw[0]|l_sw[10]|l_sw[1]|l_sw[2]|l_sw[3]|l_sw[4]|l_sw[5]|l_sw[6]|l_sw[7]|l_sw[8]|l_sw[9]|out|pad|padres|vc|vcp|vdd|vddr|vip|vss|z
+ X|in_l_sw[1]|nl_sw[1]|x
+ BOTTOM|TOP|VGND|VSS|anode|cathode|core|h_sw[0]|h_sw[10]|h_sw[1]|h_sw[2]|h_sw[3]|h_sw[4]|h_sw[5]|h_sw[6]|h_sw[7]|h_sw[8]|h_sw[9]|l_sw[0]|l_sw[10]|l_sw[1]|l_sw[2]|l_sw[3]|l_sw[4]|l_sw[5]|l_sw[6]|l_sw[7]|l_sw[8]|l_sw[9]|out|pad|padres|vc|vcp|vdd|vddr|vip|vss|z
+ BOTTOM|TOP|VGND|VSS|anode|cathode|core|h_sw[0]|h_sw[10]|h_sw[1]|h_sw[2]|h_sw[3]|h_sw[4]|h_sw[5]|h_sw[6]|h_sw[7]|h_sw[8]|h_sw[9]|l_sw[0]|l_sw[10]|l_sw[1]|l_sw[2]|l_sw[3]|l_sw[4]|l_sw[5]|l_sw[6]|l_sw[7]|l_sw[8]|l_sw[9]|out|pad|padres|vc|vcp|vdd|vddr|vip|vss|z
+ sg13_lv_nmos L=0.13u W=8u AS=1.595p AD=1.595p PS=14.88u PD=14.88u rfmode=0
M$134
+ BOTTOM|TOP|VGND|VSS|anode|cathode|core|h_sw[0]|h_sw[10]|h_sw[1]|h_sw[2]|h_sw[3]|h_sw[4]|h_sw[5]|h_sw[6]|h_sw[7]|h_sw[8]|h_sw[9]|l_sw[0]|l_sw[10]|l_sw[1]|l_sw[2]|l_sw[3]|l_sw[4]|l_sw[5]|l_sw[6]|l_sw[7]|l_sw[8]|l_sw[9]|out|pad|padres|vc|vcp|vdd|vddr|vip|vss|z
+ X|in_l_sw[2]|nl_sw[2]|x
+ BOTTOM|TOP|VGND|VSS|anode|cathode|core|h_sw[0]|h_sw[10]|h_sw[1]|h_sw[2]|h_sw[3]|h_sw[4]|h_sw[5]|h_sw[6]|h_sw[7]|h_sw[8]|h_sw[9]|l_sw[0]|l_sw[10]|l_sw[1]|l_sw[2]|l_sw[3]|l_sw[4]|l_sw[5]|l_sw[6]|l_sw[7]|l_sw[8]|l_sw[9]|out|pad|padres|vc|vcp|vdd|vddr|vip|vss|z
+ BOTTOM|TOP|VGND|VSS|anode|cathode|core|h_sw[0]|h_sw[10]|h_sw[1]|h_sw[2]|h_sw[3]|h_sw[4]|h_sw[5]|h_sw[6]|h_sw[7]|h_sw[8]|h_sw[9]|l_sw[0]|l_sw[10]|l_sw[1]|l_sw[2]|l_sw[3]|l_sw[4]|l_sw[5]|l_sw[6]|l_sw[7]|l_sw[8]|l_sw[9]|out|pad|padres|vc|vcp|vdd|vddr|vip|vss|z
+ sg13_lv_nmos L=0.13u W=8u AS=1.595p AD=1.595p PS=14.88u PD=14.88u rfmode=0
M$150
+ BOTTOM|TOP|VGND|VSS|anode|cathode|core|h_sw[0]|h_sw[10]|h_sw[1]|h_sw[2]|h_sw[3]|h_sw[4]|h_sw[5]|h_sw[6]|h_sw[7]|h_sw[8]|h_sw[9]|l_sw[0]|l_sw[10]|l_sw[1]|l_sw[2]|l_sw[3]|l_sw[4]|l_sw[5]|l_sw[6]|l_sw[7]|l_sw[8]|l_sw[9]|out|pad|padres|vc|vcp|vdd|vddr|vip|vss|z
+ X|in_h_sw[2]|nh_sw[2]|x
+ BOTTOM|TOP|VGND|VSS|anode|cathode|core|h_sw[0]|h_sw[10]|h_sw[1]|h_sw[2]|h_sw[3]|h_sw[4]|h_sw[5]|h_sw[6]|h_sw[7]|h_sw[8]|h_sw[9]|l_sw[0]|l_sw[10]|l_sw[1]|l_sw[2]|l_sw[3]|l_sw[4]|l_sw[5]|l_sw[6]|l_sw[7]|l_sw[8]|l_sw[9]|out|pad|padres|vc|vcp|vdd|vddr|vip|vss|z
+ BOTTOM|TOP|VGND|VSS|anode|cathode|core|h_sw[0]|h_sw[10]|h_sw[1]|h_sw[2]|h_sw[3]|h_sw[4]|h_sw[5]|h_sw[6]|h_sw[7]|h_sw[8]|h_sw[9]|l_sw[0]|l_sw[10]|l_sw[1]|l_sw[2]|l_sw[3]|l_sw[4]|l_sw[5]|l_sw[6]|l_sw[7]|l_sw[8]|l_sw[9]|out|pad|padres|vc|vcp|vdd|vddr|vip|vss|z
+ sg13_lv_nmos L=0.13u W=8u AS=1.595p AD=1.595p PS=14.88u PD=14.88u rfmode=0
M$166
+ BOTTOM|TOP|VGND|VSS|anode|cathode|core|h_sw[0]|h_sw[10]|h_sw[1]|h_sw[2]|h_sw[3]|h_sw[4]|h_sw[5]|h_sw[6]|h_sw[7]|h_sw[8]|h_sw[9]|l_sw[0]|l_sw[10]|l_sw[1]|l_sw[2]|l_sw[3]|l_sw[4]|l_sw[5]|l_sw[6]|l_sw[7]|l_sw[8]|l_sw[9]|out|pad|padres|vc|vcp|vdd|vddr|vip|vss|z
+ X|in_h_sw[8]|nh_sw[8]|x
+ BOTTOM|TOP|VGND|VSS|anode|cathode|core|h_sw[0]|h_sw[10]|h_sw[1]|h_sw[2]|h_sw[3]|h_sw[4]|h_sw[5]|h_sw[6]|h_sw[7]|h_sw[8]|h_sw[9]|l_sw[0]|l_sw[10]|l_sw[1]|l_sw[2]|l_sw[3]|l_sw[4]|l_sw[5]|l_sw[6]|l_sw[7]|l_sw[8]|l_sw[9]|out|pad|padres|vc|vcp|vdd|vddr|vip|vss|z
+ BOTTOM|TOP|VGND|VSS|anode|cathode|core|h_sw[0]|h_sw[10]|h_sw[1]|h_sw[2]|h_sw[3]|h_sw[4]|h_sw[5]|h_sw[6]|h_sw[7]|h_sw[8]|h_sw[9]|l_sw[0]|l_sw[10]|l_sw[1]|l_sw[2]|l_sw[3]|l_sw[4]|l_sw[5]|l_sw[6]|l_sw[7]|l_sw[8]|l_sw[9]|out|pad|padres|vc|vcp|vdd|vddr|vip|vss|z
+ sg13_lv_nmos L=0.13u W=1u AS=0.265p AD=0.265p PS=2.56u PD=2.56u rfmode=0
M$168
+ BOTTOM|TOP|VGND|VSS|anode|cathode|core|h_sw[0]|h_sw[10]|h_sw[1]|h_sw[2]|h_sw[3]|h_sw[4]|h_sw[5]|h_sw[6]|h_sw[7]|h_sw[8]|h_sw[9]|l_sw[0]|l_sw[10]|l_sw[1]|l_sw[2]|l_sw[3]|l_sw[4]|l_sw[5]|l_sw[6]|l_sw[7]|l_sw[8]|l_sw[9]|out|pad|padres|vc|vcp|vdd|vddr|vip|vss|z
+ X|in_h_sw[9]|nh_sw[9]|x
+ BOTTOM|TOP|VGND|VSS|anode|cathode|core|h_sw[0]|h_sw[10]|h_sw[1]|h_sw[2]|h_sw[3]|h_sw[4]|h_sw[5]|h_sw[6]|h_sw[7]|h_sw[8]|h_sw[9]|l_sw[0]|l_sw[10]|l_sw[1]|l_sw[2]|l_sw[3]|l_sw[4]|l_sw[5]|l_sw[6]|l_sw[7]|l_sw[8]|l_sw[9]|out|pad|padres|vc|vcp|vdd|vddr|vip|vss|z
+ BOTTOM|TOP|VGND|VSS|anode|cathode|core|h_sw[0]|h_sw[10]|h_sw[1]|h_sw[2]|h_sw[3]|h_sw[4]|h_sw[5]|h_sw[6]|h_sw[7]|h_sw[8]|h_sw[9]|l_sw[0]|l_sw[10]|l_sw[1]|l_sw[2]|l_sw[3]|l_sw[4]|l_sw[5]|l_sw[6]|l_sw[7]|l_sw[8]|l_sw[9]|out|pad|padres|vc|vcp|vdd|vddr|vip|vss|z
+ sg13_lv_nmos L=0.13u W=1u AS=0.265p AD=0.265p PS=2.56u PD=2.56u rfmode=0
M$170
+ BOTTOM|TOP|VGND|VSS|anode|cathode|core|h_sw[0]|h_sw[10]|h_sw[1]|h_sw[2]|h_sw[3]|h_sw[4]|h_sw[5]|h_sw[6]|h_sw[7]|h_sw[8]|h_sw[9]|l_sw[0]|l_sw[10]|l_sw[1]|l_sw[2]|l_sw[3]|l_sw[4]|l_sw[5]|l_sw[6]|l_sw[7]|l_sw[8]|l_sw[9]|out|pad|padres|vc|vcp|vdd|vddr|vip|vss|z
+ X|in_h_sw[10]|nh_sw[10]|x
+ BOTTOM|TOP|VGND|VSS|anode|cathode|core|h_sw[0]|h_sw[10]|h_sw[1]|h_sw[2]|h_sw[3]|h_sw[4]|h_sw[5]|h_sw[6]|h_sw[7]|h_sw[8]|h_sw[9]|l_sw[0]|l_sw[10]|l_sw[1]|l_sw[2]|l_sw[3]|l_sw[4]|l_sw[5]|l_sw[6]|l_sw[7]|l_sw[8]|l_sw[9]|out|pad|padres|vc|vcp|vdd|vddr|vip|vss|z
+ BOTTOM|TOP|VGND|VSS|anode|cathode|core|h_sw[0]|h_sw[10]|h_sw[1]|h_sw[2]|h_sw[3]|h_sw[4]|h_sw[5]|h_sw[6]|h_sw[7]|h_sw[8]|h_sw[9]|l_sw[0]|l_sw[10]|l_sw[1]|l_sw[2]|l_sw[3]|l_sw[4]|l_sw[5]|l_sw[6]|l_sw[7]|l_sw[8]|l_sw[9]|out|pad|padres|vc|vcp|vdd|vddr|vip|vss|z
+ sg13_lv_nmos L=0.13u W=0.5u AS=0.17p AD=0.17p PS=1.68u PD=1.68u rfmode=0
M$171
+ BOTTOM|TOP|VGND|VSS|anode|cathode|core|h_sw[0]|h_sw[10]|h_sw[1]|h_sw[2]|h_sw[3]|h_sw[4]|h_sw[5]|h_sw[6]|h_sw[7]|h_sw[8]|h_sw[9]|l_sw[0]|l_sw[10]|l_sw[1]|l_sw[2]|l_sw[3]|l_sw[4]|l_sw[5]|l_sw[6]|l_sw[7]|l_sw[8]|l_sw[9]|out|pad|padres|vc|vcp|vdd|vddr|vip|vss|z
+ X|in_h_sw[6]|nh_sw[6]|x
+ BOTTOM|TOP|VGND|VSS|anode|cathode|core|h_sw[0]|h_sw[10]|h_sw[1]|h_sw[2]|h_sw[3]|h_sw[4]|h_sw[5]|h_sw[6]|h_sw[7]|h_sw[8]|h_sw[9]|l_sw[0]|l_sw[10]|l_sw[1]|l_sw[2]|l_sw[3]|l_sw[4]|l_sw[5]|l_sw[6]|l_sw[7]|l_sw[8]|l_sw[9]|out|pad|padres|vc|vcp|vdd|vddr|vip|vss|z
+ BOTTOM|TOP|VGND|VSS|anode|cathode|core|h_sw[0]|h_sw[10]|h_sw[1]|h_sw[2]|h_sw[3]|h_sw[4]|h_sw[5]|h_sw[6]|h_sw[7]|h_sw[8]|h_sw[9]|l_sw[0]|l_sw[10]|l_sw[1]|l_sw[2]|l_sw[3]|l_sw[4]|l_sw[5]|l_sw[6]|l_sw[7]|l_sw[8]|l_sw[9]|out|pad|padres|vc|vcp|vdd|vddr|vip|vss|z
+ sg13_lv_nmos L=0.13u W=2u AS=0.455p AD=0.455p PS=4.32u PD=4.32u rfmode=0
M$175
+ BOTTOM|TOP|VGND|VSS|anode|cathode|core|h_sw[0]|h_sw[10]|h_sw[1]|h_sw[2]|h_sw[3]|h_sw[4]|h_sw[5]|h_sw[6]|h_sw[7]|h_sw[8]|h_sw[9]|l_sw[0]|l_sw[10]|l_sw[1]|l_sw[2]|l_sw[3]|l_sw[4]|l_sw[5]|l_sw[6]|l_sw[7]|l_sw[8]|l_sw[9]|out|pad|padres|vc|vcp|vdd|vddr|vip|vss|z
+ X|in_h_sw[7]|nh_sw[7]|x
+ BOTTOM|TOP|VGND|VSS|anode|cathode|core|h_sw[0]|h_sw[10]|h_sw[1]|h_sw[2]|h_sw[3]|h_sw[4]|h_sw[5]|h_sw[6]|h_sw[7]|h_sw[8]|h_sw[9]|l_sw[0]|l_sw[10]|l_sw[1]|l_sw[2]|l_sw[3]|l_sw[4]|l_sw[5]|l_sw[6]|l_sw[7]|l_sw[8]|l_sw[9]|out|pad|padres|vc|vcp|vdd|vddr|vip|vss|z
+ BOTTOM|TOP|VGND|VSS|anode|cathode|core|h_sw[0]|h_sw[10]|h_sw[1]|h_sw[2]|h_sw[3]|h_sw[4]|h_sw[5]|h_sw[6]|h_sw[7]|h_sw[8]|h_sw[9]|l_sw[0]|l_sw[10]|l_sw[1]|l_sw[2]|l_sw[3]|l_sw[4]|l_sw[5]|l_sw[6]|l_sw[7]|l_sw[8]|l_sw[9]|out|pad|padres|vc|vcp|vdd|vddr|vip|vss|z
+ sg13_lv_nmos L=0.13u W=2u AS=0.455p AD=0.455p PS=4.32u PD=4.32u rfmode=0
M$179
+ BOTTOM|TOP|VGND|VSS|anode|cathode|core|h_sw[0]|h_sw[10]|h_sw[1]|h_sw[2]|h_sw[3]|h_sw[4]|h_sw[5]|h_sw[6]|h_sw[7]|h_sw[8]|h_sw[9]|l_sw[0]|l_sw[10]|l_sw[1]|l_sw[2]|l_sw[3]|l_sw[4]|l_sw[5]|l_sw[6]|l_sw[7]|l_sw[8]|l_sw[9]|out|pad|padres|vc|vcp|vdd|vddr|vip|vss|z
+ X|in_h_sw[3]|nh_sw[3]|x
+ BOTTOM|TOP|VGND|VSS|anode|cathode|core|h_sw[0]|h_sw[10]|h_sw[1]|h_sw[2]|h_sw[3]|h_sw[4]|h_sw[5]|h_sw[6]|h_sw[7]|h_sw[8]|h_sw[9]|l_sw[0]|l_sw[10]|l_sw[1]|l_sw[2]|l_sw[3]|l_sw[4]|l_sw[5]|l_sw[6]|l_sw[7]|l_sw[8]|l_sw[9]|out|pad|padres|vc|vcp|vdd|vddr|vip|vss|z
+ BOTTOM|TOP|VGND|VSS|anode|cathode|core|h_sw[0]|h_sw[10]|h_sw[1]|h_sw[2]|h_sw[3]|h_sw[4]|h_sw[5]|h_sw[6]|h_sw[7]|h_sw[8]|h_sw[9]|l_sw[0]|l_sw[10]|l_sw[1]|l_sw[2]|l_sw[3]|l_sw[4]|l_sw[5]|l_sw[6]|l_sw[7]|l_sw[8]|l_sw[9]|out|pad|padres|vc|vcp|vdd|vddr|vip|vss|z
+ sg13_lv_nmos L=0.13u W=4u AS=0.835p AD=0.835p PS=7.84u PD=7.84u rfmode=0
M$187
+ BOTTOM|TOP|VGND|VSS|anode|cathode|core|h_sw[0]|h_sw[10]|h_sw[1]|h_sw[2]|h_sw[3]|h_sw[4]|h_sw[5]|h_sw[6]|h_sw[7]|h_sw[8]|h_sw[9]|l_sw[0]|l_sw[10]|l_sw[1]|l_sw[2]|l_sw[3]|l_sw[4]|l_sw[5]|l_sw[6]|l_sw[7]|l_sw[8]|l_sw[9]|out|pad|padres|vc|vcp|vdd|vddr|vip|vss|z
+ X|in_h_sw[4]|nh_sw[4]|x
+ BOTTOM|TOP|VGND|VSS|anode|cathode|core|h_sw[0]|h_sw[10]|h_sw[1]|h_sw[2]|h_sw[3]|h_sw[4]|h_sw[5]|h_sw[6]|h_sw[7]|h_sw[8]|h_sw[9]|l_sw[0]|l_sw[10]|l_sw[1]|l_sw[2]|l_sw[3]|l_sw[4]|l_sw[5]|l_sw[6]|l_sw[7]|l_sw[8]|l_sw[9]|out|pad|padres|vc|vcp|vdd|vddr|vip|vss|z
+ BOTTOM|TOP|VGND|VSS|anode|cathode|core|h_sw[0]|h_sw[10]|h_sw[1]|h_sw[2]|h_sw[3]|h_sw[4]|h_sw[5]|h_sw[6]|h_sw[7]|h_sw[8]|h_sw[9]|l_sw[0]|l_sw[10]|l_sw[1]|l_sw[2]|l_sw[3]|l_sw[4]|l_sw[5]|l_sw[6]|l_sw[7]|l_sw[8]|l_sw[9]|out|pad|padres|vc|vcp|vdd|vddr|vip|vss|z
+ sg13_lv_nmos L=0.13u W=4u AS=0.835p AD=0.835p PS=7.84u PD=7.84u rfmode=0
M$195
+ BOTTOM|TOP|VGND|VSS|anode|cathode|core|h_sw[0]|h_sw[10]|h_sw[1]|h_sw[2]|h_sw[3]|h_sw[4]|h_sw[5]|h_sw[6]|h_sw[7]|h_sw[8]|h_sw[9]|l_sw[0]|l_sw[10]|l_sw[1]|l_sw[2]|l_sw[3]|l_sw[4]|l_sw[5]|l_sw[6]|l_sw[7]|l_sw[8]|l_sw[9]|out|pad|padres|vc|vcp|vdd|vddr|vip|vss|z
+ X|in_h_sw[5]|nh_sw[5]|x
+ BOTTOM|TOP|VGND|VSS|anode|cathode|core|h_sw[0]|h_sw[10]|h_sw[1]|h_sw[2]|h_sw[3]|h_sw[4]|h_sw[5]|h_sw[6]|h_sw[7]|h_sw[8]|h_sw[9]|l_sw[0]|l_sw[10]|l_sw[1]|l_sw[2]|l_sw[3]|l_sw[4]|l_sw[5]|l_sw[6]|l_sw[7]|l_sw[8]|l_sw[9]|out|pad|padres|vc|vcp|vdd|vddr|vip|vss|z
+ BOTTOM|TOP|VGND|VSS|anode|cathode|core|h_sw[0]|h_sw[10]|h_sw[1]|h_sw[2]|h_sw[3]|h_sw[4]|h_sw[5]|h_sw[6]|h_sw[7]|h_sw[8]|h_sw[9]|l_sw[0]|l_sw[10]|l_sw[1]|l_sw[2]|l_sw[3]|l_sw[4]|l_sw[5]|l_sw[6]|l_sw[7]|l_sw[8]|l_sw[9]|out|pad|padres|vc|vcp|vdd|vddr|vip|vss|z
+ sg13_lv_nmos L=0.13u W=4u AS=0.835p AD=0.835p PS=7.84u PD=7.84u rfmode=0
M$203
+ BOTTOM|TOP|VGND|VSS|anode|cathode|core|h_sw[0]|h_sw[10]|h_sw[1]|h_sw[2]|h_sw[3]|h_sw[4]|h_sw[5]|h_sw[6]|h_sw[7]|h_sw[8]|h_sw[9]|l_sw[0]|l_sw[10]|l_sw[1]|l_sw[2]|l_sw[3]|l_sw[4]|l_sw[5]|l_sw[6]|l_sw[7]|l_sw[8]|l_sw[9]|out|pad|padres|vc|vcp|vdd|vddr|vip|vss|z
+ A|comp_p|outp \$69079
+ BOTTOM|TOP|VGND|VSS|anode|cathode|core|h_sw[0]|h_sw[10]|h_sw[1]|h_sw[2]|h_sw[3]|h_sw[4]|h_sw[5]|h_sw[6]|h_sw[7]|h_sw[8]|h_sw[9]|l_sw[0]|l_sw[10]|l_sw[1]|l_sw[2]|l_sw[3]|l_sw[4]|l_sw[5]|l_sw[6]|l_sw[7]|l_sw[8]|l_sw[9]|out|pad|padres|vc|vcp|vdd|vddr|vip|vss|z
+ sg13_lv_nmos L=0.13u W=0.55u AS=0.14875p AD=0.187p PS=1.16u PD=1.78u rfmode=0
M$204
+ BOTTOM|TOP|VGND|VSS|anode|cathode|core|h_sw[0]|h_sw[10]|h_sw[1]|h_sw[2]|h_sw[3]|h_sw[4]|h_sw[5]|h_sw[6]|h_sw[7]|h_sw[8]|h_sw[9]|l_sw[0]|l_sw[10]|l_sw[1]|l_sw[2]|l_sw[3]|l_sw[4]|l_sw[5]|l_sw[6]|l_sw[7]|l_sw[8]|l_sw[9]|out|pad|padres|vc|vcp|vdd|vddr|vip|vss|z
+ \$69079 A|X
+ BOTTOM|TOP|VGND|VSS|anode|cathode|core|h_sw[0]|h_sw[10]|h_sw[1]|h_sw[2]|h_sw[3]|h_sw[4]|h_sw[5]|h_sw[6]|h_sw[7]|h_sw[8]|h_sw[9]|l_sw[0]|l_sw[10]|l_sw[1]|l_sw[2]|l_sw[3]|l_sw[4]|l_sw[5]|l_sw[6]|l_sw[7]|l_sw[8]|l_sw[9]|out|pad|padres|vc|vcp|vdd|vddr|vip|vss|z
+ sg13_lv_nmos L=0.13u W=0.74u AS=0.14875p AD=0.2886p PS=1.16u PD=2.26u rfmode=0
M$205 A|X$1 \$69080
+ BOTTOM|TOP|VGND|VSS|anode|cathode|core|h_sw[0]|h_sw[10]|h_sw[1]|h_sw[2]|h_sw[3]|h_sw[4]|h_sw[5]|h_sw[6]|h_sw[7]|h_sw[8]|h_sw[9]|l_sw[0]|l_sw[10]|l_sw[1]|l_sw[2]|l_sw[3]|l_sw[4]|l_sw[5]|l_sw[6]|l_sw[7]|l_sw[8]|l_sw[9]|out|pad|padres|vc|vcp|vdd|vddr|vip|vss|z
+ BOTTOM|TOP|VGND|VSS|anode|cathode|core|h_sw[0]|h_sw[10]|h_sw[1]|h_sw[2]|h_sw[3]|h_sw[4]|h_sw[5]|h_sw[6]|h_sw[7]|h_sw[8]|h_sw[9]|l_sw[0]|l_sw[10]|l_sw[1]|l_sw[2]|l_sw[3]|l_sw[4]|l_sw[5]|l_sw[6]|l_sw[7]|l_sw[8]|l_sw[9]|out|pad|padres|vc|vcp|vdd|vddr|vip|vss|z
+ sg13_lv_nmos L=0.13u W=0.74u AS=0.2886p AD=0.14875p PS=2.26u PD=1.16u rfmode=0
M$206
+ BOTTOM|TOP|VGND|VSS|anode|cathode|core|h_sw[0]|h_sw[10]|h_sw[1]|h_sw[2]|h_sw[3]|h_sw[4]|h_sw[5]|h_sw[6]|h_sw[7]|h_sw[8]|h_sw[9]|l_sw[0]|l_sw[10]|l_sw[1]|l_sw[2]|l_sw[3]|l_sw[4]|l_sw[5]|l_sw[6]|l_sw[7]|l_sw[8]|l_sw[9]|out|pad|padres|vc|vcp|vdd|vddr|vip|vss|z
+ A|Y$1 \$69080
+ BOTTOM|TOP|VGND|VSS|anode|cathode|core|h_sw[0]|h_sw[10]|h_sw[1]|h_sw[2]|h_sw[3]|h_sw[4]|h_sw[5]|h_sw[6]|h_sw[7]|h_sw[8]|h_sw[9]|l_sw[0]|l_sw[10]|l_sw[1]|l_sw[2]|l_sw[3]|l_sw[4]|l_sw[5]|l_sw[6]|l_sw[7]|l_sw[8]|l_sw[9]|out|pad|padres|vc|vcp|vdd|vddr|vip|vss|z
+ sg13_lv_nmos L=0.13u W=0.55u AS=0.14875p AD=0.187p PS=1.16u PD=1.78u rfmode=0
M$207
+ BOTTOM|TOP|VGND|VSS|anode|cathode|core|h_sw[0]|h_sw[10]|h_sw[1]|h_sw[2]|h_sw[3]|h_sw[4]|h_sw[5]|h_sw[6]|h_sw[7]|h_sw[8]|h_sw[9]|l_sw[0]|l_sw[10]|l_sw[1]|l_sw[2]|l_sw[3]|l_sw[4]|l_sw[5]|l_sw[6]|l_sw[7]|l_sw[8]|l_sw[9]|out|pad|padres|vc|vcp|vdd|vddr|vip|vss|z
+ A|X$17 \$69081
+ BOTTOM|TOP|VGND|VSS|anode|cathode|core|h_sw[0]|h_sw[10]|h_sw[1]|h_sw[2]|h_sw[3]|h_sw[4]|h_sw[5]|h_sw[6]|h_sw[7]|h_sw[8]|h_sw[9]|l_sw[0]|l_sw[10]|l_sw[1]|l_sw[2]|l_sw[3]|l_sw[4]|l_sw[5]|l_sw[6]|l_sw[7]|l_sw[8]|l_sw[9]|out|pad|padres|vc|vcp|vdd|vddr|vip|vss|z
+ sg13_lv_nmos L=0.13u W=0.55u AS=0.14875p AD=0.187p PS=1.16u PD=1.78u rfmode=0
M$208
+ BOTTOM|TOP|VGND|VSS|anode|cathode|core|h_sw[0]|h_sw[10]|h_sw[1]|h_sw[2]|h_sw[3]|h_sw[4]|h_sw[5]|h_sw[6]|h_sw[7]|h_sw[8]|h_sw[9]|l_sw[0]|l_sw[10]|l_sw[1]|l_sw[2]|l_sw[3]|l_sw[4]|l_sw[5]|l_sw[6]|l_sw[7]|l_sw[8]|l_sw[9]|out|pad|padres|vc|vcp|vdd|vddr|vip|vss|z
+ \$69081 A|X$2
+ BOTTOM|TOP|VGND|VSS|anode|cathode|core|h_sw[0]|h_sw[10]|h_sw[1]|h_sw[2]|h_sw[3]|h_sw[4]|h_sw[5]|h_sw[6]|h_sw[7]|h_sw[8]|h_sw[9]|l_sw[0]|l_sw[10]|l_sw[1]|l_sw[2]|l_sw[3]|l_sw[4]|l_sw[5]|l_sw[6]|l_sw[7]|l_sw[8]|l_sw[9]|out|pad|padres|vc|vcp|vdd|vddr|vip|vss|z
+ sg13_lv_nmos L=0.13u W=0.74u AS=0.14875p AD=0.2886p PS=1.16u PD=2.26u rfmode=0
M$209
+ BOTTOM|TOP|VGND|VSS|anode|cathode|core|h_sw[0]|h_sw[10]|h_sw[1]|h_sw[2]|h_sw[3]|h_sw[4]|h_sw[5]|h_sw[6]|h_sw[7]|h_sw[8]|h_sw[9]|l_sw[0]|l_sw[10]|l_sw[1]|l_sw[2]|l_sw[3]|l_sw[4]|l_sw[5]|l_sw[6]|l_sw[7]|l_sw[8]|l_sw[9]|out|pad|padres|vc|vcp|vdd|vddr|vip|vss|z
+ A|X$18 \$69082
+ BOTTOM|TOP|VGND|VSS|anode|cathode|core|h_sw[0]|h_sw[10]|h_sw[1]|h_sw[2]|h_sw[3]|h_sw[4]|h_sw[5]|h_sw[6]|h_sw[7]|h_sw[8]|h_sw[9]|l_sw[0]|l_sw[10]|l_sw[1]|l_sw[2]|l_sw[3]|l_sw[4]|l_sw[5]|l_sw[6]|l_sw[7]|l_sw[8]|l_sw[9]|out|pad|padres|vc|vcp|vdd|vddr|vip|vss|z
+ sg13_lv_nmos L=0.13u W=0.55u AS=0.14875p AD=0.187p PS=1.16u PD=1.78u rfmode=0
M$210
+ BOTTOM|TOP|VGND|VSS|anode|cathode|core|h_sw[0]|h_sw[10]|h_sw[1]|h_sw[2]|h_sw[3]|h_sw[4]|h_sw[5]|h_sw[6]|h_sw[7]|h_sw[8]|h_sw[9]|l_sw[0]|l_sw[10]|l_sw[1]|l_sw[2]|l_sw[3]|l_sw[4]|l_sw[5]|l_sw[6]|l_sw[7]|l_sw[8]|l_sw[9]|out|pad|padres|vc|vcp|vdd|vddr|vip|vss|z
+ \$69082 X|in_l_sw[1]|nl_sw[1]|x
+ BOTTOM|TOP|VGND|VSS|anode|cathode|core|h_sw[0]|h_sw[10]|h_sw[1]|h_sw[2]|h_sw[3]|h_sw[4]|h_sw[5]|h_sw[6]|h_sw[7]|h_sw[8]|h_sw[9]|l_sw[0]|l_sw[10]|l_sw[1]|l_sw[2]|l_sw[3]|l_sw[4]|l_sw[5]|l_sw[6]|l_sw[7]|l_sw[8]|l_sw[9]|out|pad|padres|vc|vcp|vdd|vddr|vip|vss|z
+ sg13_lv_nmos L=0.13u W=0.74u AS=0.14875p AD=0.2886p PS=1.16u PD=2.26u rfmode=0
M$211
+ BOTTOM|TOP|VGND|VSS|anode|cathode|core|h_sw[0]|h_sw[10]|h_sw[1]|h_sw[2]|h_sw[3]|h_sw[4]|h_sw[5]|h_sw[6]|h_sw[7]|h_sw[8]|h_sw[9]|l_sw[0]|l_sw[10]|l_sw[1]|l_sw[2]|l_sw[3]|l_sw[4]|l_sw[5]|l_sw[6]|l_sw[7]|l_sw[8]|l_sw[9]|out|pad|padres|vc|vcp|vdd|vddr|vip|vss|z
+ A|X$4 \$69083
+ BOTTOM|TOP|VGND|VSS|anode|cathode|core|h_sw[0]|h_sw[10]|h_sw[1]|h_sw[2]|h_sw[3]|h_sw[4]|h_sw[5]|h_sw[6]|h_sw[7]|h_sw[8]|h_sw[9]|l_sw[0]|l_sw[10]|l_sw[1]|l_sw[2]|l_sw[3]|l_sw[4]|l_sw[5]|l_sw[6]|l_sw[7]|l_sw[8]|l_sw[9]|out|pad|padres|vc|vcp|vdd|vddr|vip|vss|z
+ sg13_lv_nmos L=0.13u W=0.55u AS=0.14875p AD=0.187p PS=1.16u PD=1.78u rfmode=0
M$212
+ BOTTOM|TOP|VGND|VSS|anode|cathode|core|h_sw[0]|h_sw[10]|h_sw[1]|h_sw[2]|h_sw[3]|h_sw[4]|h_sw[5]|h_sw[6]|h_sw[7]|h_sw[8]|h_sw[9]|l_sw[0]|l_sw[10]|l_sw[1]|l_sw[2]|l_sw[3]|l_sw[4]|l_sw[5]|l_sw[6]|l_sw[7]|l_sw[8]|l_sw[9]|out|pad|padres|vc|vcp|vdd|vddr|vip|vss|z
+ \$69083 X|in_l_sw[2]|nl_sw[2]|x
+ BOTTOM|TOP|VGND|VSS|anode|cathode|core|h_sw[0]|h_sw[10]|h_sw[1]|h_sw[2]|h_sw[3]|h_sw[4]|h_sw[5]|h_sw[6]|h_sw[7]|h_sw[8]|h_sw[9]|l_sw[0]|l_sw[10]|l_sw[1]|l_sw[2]|l_sw[3]|l_sw[4]|l_sw[5]|l_sw[6]|l_sw[7]|l_sw[8]|l_sw[9]|out|pad|padres|vc|vcp|vdd|vddr|vip|vss|z
+ sg13_lv_nmos L=0.13u W=0.74u AS=0.14875p AD=0.2886p PS=1.16u PD=2.26u rfmode=0
M$213 A|X$18 \$69084
+ BOTTOM|TOP|VGND|VSS|anode|cathode|core|h_sw[0]|h_sw[10]|h_sw[1]|h_sw[2]|h_sw[3]|h_sw[4]|h_sw[5]|h_sw[6]|h_sw[7]|h_sw[8]|h_sw[9]|l_sw[0]|l_sw[10]|l_sw[1]|l_sw[2]|l_sw[3]|l_sw[4]|l_sw[5]|l_sw[6]|l_sw[7]|l_sw[8]|l_sw[9]|out|pad|padres|vc|vcp|vdd|vddr|vip|vss|z
+ BOTTOM|TOP|VGND|VSS|anode|cathode|core|h_sw[0]|h_sw[10]|h_sw[1]|h_sw[2]|h_sw[3]|h_sw[4]|h_sw[5]|h_sw[6]|h_sw[7]|h_sw[8]|h_sw[9]|l_sw[0]|l_sw[10]|l_sw[1]|l_sw[2]|l_sw[3]|l_sw[4]|l_sw[5]|l_sw[6]|l_sw[7]|l_sw[8]|l_sw[9]|out|pad|padres|vc|vcp|vdd|vddr|vip|vss|z
+ sg13_lv_nmos L=0.13u W=0.74u AS=0.2886p AD=0.14875p PS=2.26u PD=1.16u rfmode=0
M$214
+ BOTTOM|TOP|VGND|VSS|anode|cathode|core|h_sw[0]|h_sw[10]|h_sw[1]|h_sw[2]|h_sw[3]|h_sw[4]|h_sw[5]|h_sw[6]|h_sw[7]|h_sw[8]|h_sw[9]|l_sw[0]|l_sw[10]|l_sw[1]|l_sw[2]|l_sw[3]|l_sw[4]|l_sw[5]|l_sw[6]|l_sw[7]|l_sw[8]|l_sw[9]|out|pad|padres|vc|vcp|vdd|vddr|vip|vss|z
+ A|Y$2 \$69084
+ BOTTOM|TOP|VGND|VSS|anode|cathode|core|h_sw[0]|h_sw[10]|h_sw[1]|h_sw[2]|h_sw[3]|h_sw[4]|h_sw[5]|h_sw[6]|h_sw[7]|h_sw[8]|h_sw[9]|l_sw[0]|l_sw[10]|l_sw[1]|l_sw[2]|l_sw[3]|l_sw[4]|l_sw[5]|l_sw[6]|l_sw[7]|l_sw[8]|l_sw[9]|out|pad|padres|vc|vcp|vdd|vddr|vip|vss|z
+ sg13_lv_nmos L=0.13u W=0.55u AS=0.14875p AD=0.187p PS=1.16u PD=1.78u rfmode=0
M$215 A|X$3 \$69085
+ BOTTOM|TOP|VGND|VSS|anode|cathode|core|h_sw[0]|h_sw[10]|h_sw[1]|h_sw[2]|h_sw[3]|h_sw[4]|h_sw[5]|h_sw[6]|h_sw[7]|h_sw[8]|h_sw[9]|l_sw[0]|l_sw[10]|l_sw[1]|l_sw[2]|l_sw[3]|l_sw[4]|l_sw[5]|l_sw[6]|l_sw[7]|l_sw[8]|l_sw[9]|out|pad|padres|vc|vcp|vdd|vddr|vip|vss|z
+ BOTTOM|TOP|VGND|VSS|anode|cathode|core|h_sw[0]|h_sw[10]|h_sw[1]|h_sw[2]|h_sw[3]|h_sw[4]|h_sw[5]|h_sw[6]|h_sw[7]|h_sw[8]|h_sw[9]|l_sw[0]|l_sw[10]|l_sw[1]|l_sw[2]|l_sw[3]|l_sw[4]|l_sw[5]|l_sw[6]|l_sw[7]|l_sw[8]|l_sw[9]|out|pad|padres|vc|vcp|vdd|vddr|vip|vss|z
+ sg13_lv_nmos L=0.13u W=0.74u AS=0.2886p AD=0.14875p PS=2.26u PD=1.16u rfmode=0
M$216
+ BOTTOM|TOP|VGND|VSS|anode|cathode|core|h_sw[0]|h_sw[10]|h_sw[1]|h_sw[2]|h_sw[3]|h_sw[4]|h_sw[5]|h_sw[6]|h_sw[7]|h_sw[8]|h_sw[9]|l_sw[0]|l_sw[10]|l_sw[1]|l_sw[2]|l_sw[3]|l_sw[4]|l_sw[5]|l_sw[6]|l_sw[7]|l_sw[8]|l_sw[9]|out|pad|padres|vc|vcp|vdd|vddr|vip|vss|z
+ A|X$19 \$69085
+ BOTTOM|TOP|VGND|VSS|anode|cathode|core|h_sw[0]|h_sw[10]|h_sw[1]|h_sw[2]|h_sw[3]|h_sw[4]|h_sw[5]|h_sw[6]|h_sw[7]|h_sw[8]|h_sw[9]|l_sw[0]|l_sw[10]|l_sw[1]|l_sw[2]|l_sw[3]|l_sw[4]|l_sw[5]|l_sw[6]|l_sw[7]|l_sw[8]|l_sw[9]|out|pad|padres|vc|vcp|vdd|vddr|vip|vss|z
+ sg13_lv_nmos L=0.13u W=0.55u AS=0.14875p AD=0.187p PS=1.16u PD=1.78u rfmode=0
M$217
+ BOTTOM|TOP|VGND|VSS|anode|cathode|core|h_sw[0]|h_sw[10]|h_sw[1]|h_sw[2]|h_sw[3]|h_sw[4]|h_sw[5]|h_sw[6]|h_sw[7]|h_sw[8]|h_sw[9]|l_sw[0]|l_sw[10]|l_sw[1]|l_sw[2]|l_sw[3]|l_sw[4]|l_sw[5]|l_sw[6]|l_sw[7]|l_sw[8]|l_sw[9]|out|pad|padres|vc|vcp|vdd|vddr|vip|vss|z
+ A|X$20 \$69086
+ BOTTOM|TOP|VGND|VSS|anode|cathode|core|h_sw[0]|h_sw[10]|h_sw[1]|h_sw[2]|h_sw[3]|h_sw[4]|h_sw[5]|h_sw[6]|h_sw[7]|h_sw[8]|h_sw[9]|l_sw[0]|l_sw[10]|l_sw[1]|l_sw[2]|l_sw[3]|l_sw[4]|l_sw[5]|l_sw[6]|l_sw[7]|l_sw[8]|l_sw[9]|out|pad|padres|vc|vcp|vdd|vddr|vip|vss|z
+ sg13_lv_nmos L=0.13u W=0.55u AS=0.14875p AD=0.187p PS=1.16u PD=1.78u rfmode=0
M$218
+ BOTTOM|TOP|VGND|VSS|anode|cathode|core|h_sw[0]|h_sw[10]|h_sw[1]|h_sw[2]|h_sw[3]|h_sw[4]|h_sw[5]|h_sw[6]|h_sw[7]|h_sw[8]|h_sw[9]|l_sw[0]|l_sw[10]|l_sw[1]|l_sw[2]|l_sw[3]|l_sw[4]|l_sw[5]|l_sw[6]|l_sw[7]|l_sw[8]|l_sw[9]|out|pad|padres|vc|vcp|vdd|vddr|vip|vss|z
+ \$69086 X|in_h_sw[2]|nh_sw[2]|x
+ BOTTOM|TOP|VGND|VSS|anode|cathode|core|h_sw[0]|h_sw[10]|h_sw[1]|h_sw[2]|h_sw[3]|h_sw[4]|h_sw[5]|h_sw[6]|h_sw[7]|h_sw[8]|h_sw[9]|l_sw[0]|l_sw[10]|l_sw[1]|l_sw[2]|l_sw[3]|l_sw[4]|l_sw[5]|l_sw[6]|l_sw[7]|l_sw[8]|l_sw[9]|out|pad|padres|vc|vcp|vdd|vddr|vip|vss|z
+ sg13_lv_nmos L=0.13u W=0.74u AS=0.14875p AD=0.2886p PS=1.16u PD=2.26u rfmode=0
M$219 A|X$4 \$69087
+ BOTTOM|TOP|VGND|VSS|anode|cathode|core|h_sw[0]|h_sw[10]|h_sw[1]|h_sw[2]|h_sw[3]|h_sw[4]|h_sw[5]|h_sw[6]|h_sw[7]|h_sw[8]|h_sw[9]|l_sw[0]|l_sw[10]|l_sw[1]|l_sw[2]|l_sw[3]|l_sw[4]|l_sw[5]|l_sw[6]|l_sw[7]|l_sw[8]|l_sw[9]|out|pad|padres|vc|vcp|vdd|vddr|vip|vss|z
+ BOTTOM|TOP|VGND|VSS|anode|cathode|core|h_sw[0]|h_sw[10]|h_sw[1]|h_sw[2]|h_sw[3]|h_sw[4]|h_sw[5]|h_sw[6]|h_sw[7]|h_sw[8]|h_sw[9]|l_sw[0]|l_sw[10]|l_sw[1]|l_sw[2]|l_sw[3]|l_sw[4]|l_sw[5]|l_sw[6]|l_sw[7]|l_sw[8]|l_sw[9]|out|pad|padres|vc|vcp|vdd|vddr|vip|vss|z
+ sg13_lv_nmos L=0.13u W=0.74u AS=0.2886p AD=0.14875p PS=2.26u PD=1.16u rfmode=0
M$220
+ BOTTOM|TOP|VGND|VSS|anode|cathode|core|h_sw[0]|h_sw[10]|h_sw[1]|h_sw[2]|h_sw[3]|h_sw[4]|h_sw[5]|h_sw[6]|h_sw[7]|h_sw[8]|h_sw[9]|l_sw[0]|l_sw[10]|l_sw[1]|l_sw[2]|l_sw[3]|l_sw[4]|l_sw[5]|l_sw[6]|l_sw[7]|l_sw[8]|l_sw[9]|out|pad|padres|vc|vcp|vdd|vddr|vip|vss|z
+ A|Y$3 \$69087
+ BOTTOM|TOP|VGND|VSS|anode|cathode|core|h_sw[0]|h_sw[10]|h_sw[1]|h_sw[2]|h_sw[3]|h_sw[4]|h_sw[5]|h_sw[6]|h_sw[7]|h_sw[8]|h_sw[9]|l_sw[0]|l_sw[10]|l_sw[1]|l_sw[2]|l_sw[3]|l_sw[4]|l_sw[5]|l_sw[6]|l_sw[7]|l_sw[8]|l_sw[9]|out|pad|padres|vc|vcp|vdd|vddr|vip|vss|z
+ sg13_lv_nmos L=0.13u W=0.55u AS=0.14875p AD=0.187p PS=1.16u PD=1.78u rfmode=0
M$221
+ BOTTOM|TOP|VGND|VSS|anode|cathode|core|h_sw[0]|h_sw[10]|h_sw[1]|h_sw[2]|h_sw[3]|h_sw[4]|h_sw[5]|h_sw[6]|h_sw[7]|h_sw[8]|h_sw[9]|l_sw[0]|l_sw[10]|l_sw[1]|l_sw[2]|l_sw[3]|l_sw[4]|l_sw[5]|l_sw[6]|l_sw[7]|l_sw[8]|l_sw[9]|out|pad|padres|vc|vcp|vdd|vddr|vip|vss|z
+ A|X$21 \$69088
+ BOTTOM|TOP|VGND|VSS|anode|cathode|core|h_sw[0]|h_sw[10]|h_sw[1]|h_sw[2]|h_sw[3]|h_sw[4]|h_sw[5]|h_sw[6]|h_sw[7]|h_sw[8]|h_sw[9]|l_sw[0]|l_sw[10]|l_sw[1]|l_sw[2]|l_sw[3]|l_sw[4]|l_sw[5]|l_sw[6]|l_sw[7]|l_sw[8]|l_sw[9]|out|pad|padres|vc|vcp|vdd|vddr|vip|vss|z
+ sg13_lv_nmos L=0.13u W=0.55u AS=0.14875p AD=0.187p PS=1.16u PD=1.78u rfmode=0
M$222
+ BOTTOM|TOP|VGND|VSS|anode|cathode|core|h_sw[0]|h_sw[10]|h_sw[1]|h_sw[2]|h_sw[3]|h_sw[4]|h_sw[5]|h_sw[6]|h_sw[7]|h_sw[8]|h_sw[9]|l_sw[0]|l_sw[10]|l_sw[1]|l_sw[2]|l_sw[3]|l_sw[4]|l_sw[5]|l_sw[6]|l_sw[7]|l_sw[8]|l_sw[9]|out|pad|padres|vc|vcp|vdd|vddr|vip|vss|z
+ \$69088 X|in_l_sw[3]|nl_sw[3]|x
+ BOTTOM|TOP|VGND|VSS|anode|cathode|core|h_sw[0]|h_sw[10]|h_sw[1]|h_sw[2]|h_sw[3]|h_sw[4]|h_sw[5]|h_sw[6]|h_sw[7]|h_sw[8]|h_sw[9]|l_sw[0]|l_sw[10]|l_sw[1]|l_sw[2]|l_sw[3]|l_sw[4]|l_sw[5]|l_sw[6]|l_sw[7]|l_sw[8]|l_sw[9]|out|pad|padres|vc|vcp|vdd|vddr|vip|vss|z
+ sg13_lv_nmos L=0.13u W=0.74u AS=0.14875p AD=0.2886p PS=1.16u PD=2.26u rfmode=0
M$223
+ BOTTOM|TOP|VGND|VSS|anode|cathode|core|h_sw[0]|h_sw[10]|h_sw[1]|h_sw[2]|h_sw[3]|h_sw[4]|h_sw[5]|h_sw[6]|h_sw[7]|h_sw[8]|h_sw[9]|l_sw[0]|l_sw[10]|l_sw[1]|l_sw[2]|l_sw[3]|l_sw[4]|l_sw[5]|l_sw[6]|l_sw[7]|l_sw[8]|l_sw[9]|out|pad|padres|vc|vcp|vdd|vddr|vip|vss|z
+ A|Q$2 \$69089
+ BOTTOM|TOP|VGND|VSS|anode|cathode|core|h_sw[0]|h_sw[10]|h_sw[1]|h_sw[2]|h_sw[3]|h_sw[4]|h_sw[5]|h_sw[6]|h_sw[7]|h_sw[8]|h_sw[9]|l_sw[0]|l_sw[10]|l_sw[1]|l_sw[2]|l_sw[3]|l_sw[4]|l_sw[5]|l_sw[6]|l_sw[7]|l_sw[8]|l_sw[9]|out|pad|padres|vc|vcp|vdd|vddr|vip|vss|z
+ sg13_lv_nmos L=0.13u W=0.55u AS=0.14875p AD=0.187p PS=1.16u PD=1.78u rfmode=0
M$224
+ BOTTOM|TOP|VGND|VSS|anode|cathode|core|h_sw[0]|h_sw[10]|h_sw[1]|h_sw[2]|h_sw[3]|h_sw[4]|h_sw[5]|h_sw[6]|h_sw[7]|h_sw[8]|h_sw[9]|l_sw[0]|l_sw[10]|l_sw[1]|l_sw[2]|l_sw[3]|l_sw[4]|l_sw[5]|l_sw[6]|l_sw[7]|l_sw[8]|l_sw[9]|out|pad|padres|vc|vcp|vdd|vddr|vip|vss|z
+ \$69089 A|X$5
+ BOTTOM|TOP|VGND|VSS|anode|cathode|core|h_sw[0]|h_sw[10]|h_sw[1]|h_sw[2]|h_sw[3]|h_sw[4]|h_sw[5]|h_sw[6]|h_sw[7]|h_sw[8]|h_sw[9]|l_sw[0]|l_sw[10]|l_sw[1]|l_sw[2]|l_sw[3]|l_sw[4]|l_sw[5]|l_sw[6]|l_sw[7]|l_sw[8]|l_sw[9]|out|pad|padres|vc|vcp|vdd|vddr|vip|vss|z
+ sg13_lv_nmos L=0.13u W=0.74u AS=0.14875p AD=0.2886p PS=1.16u PD=2.26u rfmode=0
M$225 A|X$20 \$69090
+ BOTTOM|TOP|VGND|VSS|anode|cathode|core|h_sw[0]|h_sw[10]|h_sw[1]|h_sw[2]|h_sw[3]|h_sw[4]|h_sw[5]|h_sw[6]|h_sw[7]|h_sw[8]|h_sw[9]|l_sw[0]|l_sw[10]|l_sw[1]|l_sw[2]|l_sw[3]|l_sw[4]|l_sw[5]|l_sw[6]|l_sw[7]|l_sw[8]|l_sw[9]|out|pad|padres|vc|vcp|vdd|vddr|vip|vss|z
+ BOTTOM|TOP|VGND|VSS|anode|cathode|core|h_sw[0]|h_sw[10]|h_sw[1]|h_sw[2]|h_sw[3]|h_sw[4]|h_sw[5]|h_sw[6]|h_sw[7]|h_sw[8]|h_sw[9]|l_sw[0]|l_sw[10]|l_sw[1]|l_sw[2]|l_sw[3]|l_sw[4]|l_sw[5]|l_sw[6]|l_sw[7]|l_sw[8]|l_sw[9]|out|pad|padres|vc|vcp|vdd|vddr|vip|vss|z
+ sg13_lv_nmos L=0.13u W=0.74u AS=0.2886p AD=0.14875p PS=2.26u PD=1.16u rfmode=0
M$226
+ BOTTOM|TOP|VGND|VSS|anode|cathode|core|h_sw[0]|h_sw[10]|h_sw[1]|h_sw[2]|h_sw[3]|h_sw[4]|h_sw[5]|h_sw[6]|h_sw[7]|h_sw[8]|h_sw[9]|l_sw[0]|l_sw[10]|l_sw[1]|l_sw[2]|l_sw[3]|l_sw[4]|l_sw[5]|l_sw[6]|l_sw[7]|l_sw[8]|l_sw[9]|out|pad|padres|vc|vcp|vdd|vddr|vip|vss|z
+ A|X$5 \$69090
+ BOTTOM|TOP|VGND|VSS|anode|cathode|core|h_sw[0]|h_sw[10]|h_sw[1]|h_sw[2]|h_sw[3]|h_sw[4]|h_sw[5]|h_sw[6]|h_sw[7]|h_sw[8]|h_sw[9]|l_sw[0]|l_sw[10]|l_sw[1]|l_sw[2]|l_sw[3]|l_sw[4]|l_sw[5]|l_sw[6]|l_sw[7]|l_sw[8]|l_sw[9]|out|pad|padres|vc|vcp|vdd|vddr|vip|vss|z
+ sg13_lv_nmos L=0.13u W=0.55u AS=0.14875p AD=0.187p PS=1.16u PD=1.78u rfmode=0
M$227
+ BOTTOM|TOP|VGND|VSS|anode|cathode|core|h_sw[0]|h_sw[10]|h_sw[1]|h_sw[2]|h_sw[3]|h_sw[4]|h_sw[5]|h_sw[6]|h_sw[7]|h_sw[8]|h_sw[9]|l_sw[0]|l_sw[10]|l_sw[1]|l_sw[2]|l_sw[3]|l_sw[4]|l_sw[5]|l_sw[6]|l_sw[7]|l_sw[8]|l_sw[9]|out|pad|padres|vc|vcp|vdd|vddr|vip|vss|z
+ A|X$22 \$69091
+ BOTTOM|TOP|VGND|VSS|anode|cathode|core|h_sw[0]|h_sw[10]|h_sw[1]|h_sw[2]|h_sw[3]|h_sw[4]|h_sw[5]|h_sw[6]|h_sw[7]|h_sw[8]|h_sw[9]|l_sw[0]|l_sw[10]|l_sw[1]|l_sw[2]|l_sw[3]|l_sw[4]|l_sw[5]|l_sw[6]|l_sw[7]|l_sw[8]|l_sw[9]|out|pad|padres|vc|vcp|vdd|vddr|vip|vss|z
+ sg13_lv_nmos L=0.13u W=0.55u AS=0.14875p AD=0.187p PS=1.16u PD=1.78u rfmode=0
M$228
+ BOTTOM|TOP|VGND|VSS|anode|cathode|core|h_sw[0]|h_sw[10]|h_sw[1]|h_sw[2]|h_sw[3]|h_sw[4]|h_sw[5]|h_sw[6]|h_sw[7]|h_sw[8]|h_sw[9]|l_sw[0]|l_sw[10]|l_sw[1]|l_sw[2]|l_sw[3]|l_sw[4]|l_sw[5]|l_sw[6]|l_sw[7]|l_sw[8]|l_sw[9]|out|pad|padres|vc|vcp|vdd|vddr|vip|vss|z
+ \$69091 X|in_h_sw[3]|nh_sw[3]|x
+ BOTTOM|TOP|VGND|VSS|anode|cathode|core|h_sw[0]|h_sw[10]|h_sw[1]|h_sw[2]|h_sw[3]|h_sw[4]|h_sw[5]|h_sw[6]|h_sw[7]|h_sw[8]|h_sw[9]|l_sw[0]|l_sw[10]|l_sw[1]|l_sw[2]|l_sw[3]|l_sw[4]|l_sw[5]|l_sw[6]|l_sw[7]|l_sw[8]|l_sw[9]|out|pad|padres|vc|vcp|vdd|vddr|vip|vss|z
+ sg13_lv_nmos L=0.13u W=0.74u AS=0.14875p AD=0.2886p PS=1.16u PD=2.26u rfmode=0
M$229 A|X$21 \$69092
+ BOTTOM|TOP|VGND|VSS|anode|cathode|core|h_sw[0]|h_sw[10]|h_sw[1]|h_sw[2]|h_sw[3]|h_sw[4]|h_sw[5]|h_sw[6]|h_sw[7]|h_sw[8]|h_sw[9]|l_sw[0]|l_sw[10]|l_sw[1]|l_sw[2]|l_sw[3]|l_sw[4]|l_sw[5]|l_sw[6]|l_sw[7]|l_sw[8]|l_sw[9]|out|pad|padres|vc|vcp|vdd|vddr|vip|vss|z
+ BOTTOM|TOP|VGND|VSS|anode|cathode|core|h_sw[0]|h_sw[10]|h_sw[1]|h_sw[2]|h_sw[3]|h_sw[4]|h_sw[5]|h_sw[6]|h_sw[7]|h_sw[8]|h_sw[9]|l_sw[0]|l_sw[10]|l_sw[1]|l_sw[2]|l_sw[3]|l_sw[4]|l_sw[5]|l_sw[6]|l_sw[7]|l_sw[8]|l_sw[9]|out|pad|padres|vc|vcp|vdd|vddr|vip|vss|z
+ sg13_lv_nmos L=0.13u W=0.74u AS=0.2886p AD=0.14875p PS=2.26u PD=1.16u rfmode=0
M$230
+ BOTTOM|TOP|VGND|VSS|anode|cathode|core|h_sw[0]|h_sw[10]|h_sw[1]|h_sw[2]|h_sw[3]|h_sw[4]|h_sw[5]|h_sw[6]|h_sw[7]|h_sw[8]|h_sw[9]|l_sw[0]|l_sw[10]|l_sw[1]|l_sw[2]|l_sw[3]|l_sw[4]|l_sw[5]|l_sw[6]|l_sw[7]|l_sw[8]|l_sw[9]|out|pad|padres|vc|vcp|vdd|vddr|vip|vss|z
+ A|Y$4 \$69092
+ BOTTOM|TOP|VGND|VSS|anode|cathode|core|h_sw[0]|h_sw[10]|h_sw[1]|h_sw[2]|h_sw[3]|h_sw[4]|h_sw[5]|h_sw[6]|h_sw[7]|h_sw[8]|h_sw[9]|l_sw[0]|l_sw[10]|l_sw[1]|l_sw[2]|l_sw[3]|l_sw[4]|l_sw[5]|l_sw[6]|l_sw[7]|l_sw[8]|l_sw[9]|out|pad|padres|vc|vcp|vdd|vddr|vip|vss|z
+ sg13_lv_nmos L=0.13u W=0.55u AS=0.14875p AD=0.187p PS=1.16u PD=1.78u rfmode=0
M$231 A|X$22 \$69093
+ BOTTOM|TOP|VGND|VSS|anode|cathode|core|h_sw[0]|h_sw[10]|h_sw[1]|h_sw[2]|h_sw[3]|h_sw[4]|h_sw[5]|h_sw[6]|h_sw[7]|h_sw[8]|h_sw[9]|l_sw[0]|l_sw[10]|l_sw[1]|l_sw[2]|l_sw[3]|l_sw[4]|l_sw[5]|l_sw[6]|l_sw[7]|l_sw[8]|l_sw[9]|out|pad|padres|vc|vcp|vdd|vddr|vip|vss|z
+ BOTTOM|TOP|VGND|VSS|anode|cathode|core|h_sw[0]|h_sw[10]|h_sw[1]|h_sw[2]|h_sw[3]|h_sw[4]|h_sw[5]|h_sw[6]|h_sw[7]|h_sw[8]|h_sw[9]|l_sw[0]|l_sw[10]|l_sw[1]|l_sw[2]|l_sw[3]|l_sw[4]|l_sw[5]|l_sw[6]|l_sw[7]|l_sw[8]|l_sw[9]|out|pad|padres|vc|vcp|vdd|vddr|vip|vss|z
+ sg13_lv_nmos L=0.13u W=0.74u AS=0.2886p AD=0.14875p PS=2.26u PD=1.16u rfmode=0
M$232
+ BOTTOM|TOP|VGND|VSS|anode|cathode|core|h_sw[0]|h_sw[10]|h_sw[1]|h_sw[2]|h_sw[3]|h_sw[4]|h_sw[5]|h_sw[6]|h_sw[7]|h_sw[8]|h_sw[9]|l_sw[0]|l_sw[10]|l_sw[1]|l_sw[2]|l_sw[3]|l_sw[4]|l_sw[5]|l_sw[6]|l_sw[7]|l_sw[8]|l_sw[9]|out|pad|padres|vc|vcp|vdd|vddr|vip|vss|z
+ A|X$23 \$69093
+ BOTTOM|TOP|VGND|VSS|anode|cathode|core|h_sw[0]|h_sw[10]|h_sw[1]|h_sw[2]|h_sw[3]|h_sw[4]|h_sw[5]|h_sw[6]|h_sw[7]|h_sw[8]|h_sw[9]|l_sw[0]|l_sw[10]|l_sw[1]|l_sw[2]|l_sw[3]|l_sw[4]|l_sw[5]|l_sw[6]|l_sw[7]|l_sw[8]|l_sw[9]|out|pad|padres|vc|vcp|vdd|vddr|vip|vss|z
+ sg13_lv_nmos L=0.13u W=0.55u AS=0.14875p AD=0.187p PS=1.16u PD=1.78u rfmode=0
M$233
+ BOTTOM|TOP|VGND|VSS|anode|cathode|core|h_sw[0]|h_sw[10]|h_sw[1]|h_sw[2]|h_sw[3]|h_sw[4]|h_sw[5]|h_sw[6]|h_sw[7]|h_sw[8]|h_sw[9]|l_sw[0]|l_sw[10]|l_sw[1]|l_sw[2]|l_sw[3]|l_sw[4]|l_sw[5]|l_sw[6]|l_sw[7]|l_sw[8]|l_sw[9]|out|pad|padres|vc|vcp|vdd|vddr|vip|vss|z
+ \$69094 \$69114
+ BOTTOM|TOP|VGND|VSS|anode|cathode|core|h_sw[0]|h_sw[10]|h_sw[1]|h_sw[2]|h_sw[3]|h_sw[4]|h_sw[5]|h_sw[6]|h_sw[7]|h_sw[8]|h_sw[9]|l_sw[0]|l_sw[10]|l_sw[1]|l_sw[2]|l_sw[3]|l_sw[4]|l_sw[5]|l_sw[6]|l_sw[7]|l_sw[8]|l_sw[9]|out|pad|padres|vc|vcp|vdd|vddr|vip|vss|z
+ sg13_lv_nmos L=0.13u W=0.64u AS=0.213425p AD=0.072p PS=1.62u PD=0.865u
+ rfmode=0
M$234 \$69114 \$69095 \$69028
+ BOTTOM|TOP|VGND|VSS|anode|cathode|core|h_sw[0]|h_sw[10]|h_sw[1]|h_sw[2]|h_sw[3]|h_sw[4]|h_sw[5]|h_sw[6]|h_sw[7]|h_sw[8]|h_sw[9]|l_sw[0]|l_sw[10]|l_sw[1]|l_sw[2]|l_sw[3]|l_sw[4]|l_sw[5]|l_sw[6]|l_sw[7]|l_sw[8]|l_sw[9]|out|pad|padres|vc|vcp|vdd|vddr|vip|vss|z
+ sg13_lv_nmos L=0.13u W=0.64u AS=0.072p AD=0.141p PS=0.865u PD=1.17u rfmode=0
M$235 \$69028 \$69027 \$69113
+ BOTTOM|TOP|VGND|VSS|anode|cathode|core|h_sw[0]|h_sw[10]|h_sw[1]|h_sw[2]|h_sw[3]|h_sw[4]|h_sw[5]|h_sw[6]|h_sw[7]|h_sw[8]|h_sw[9]|l_sw[0]|l_sw[10]|l_sw[1]|l_sw[2]|l_sw[3]|l_sw[4]|l_sw[5]|l_sw[6]|l_sw[7]|l_sw[8]|l_sw[9]|out|pad|padres|vc|vcp|vdd|vddr|vip|vss|z
+ sg13_lv_nmos L=0.13u W=0.42u AS=0.141p AD=0.04725p PS=1.17u PD=0.645u rfmode=0
M$236 \$69113 \$69029
+ BOTTOM|TOP|VGND|VSS|anode|cathode|core|h_sw[0]|h_sw[10]|h_sw[1]|h_sw[2]|h_sw[3]|h_sw[4]|h_sw[5]|h_sw[6]|h_sw[7]|h_sw[8]|h_sw[9]|l_sw[0]|l_sw[10]|l_sw[1]|l_sw[2]|l_sw[3]|l_sw[4]|l_sw[5]|l_sw[6]|l_sw[7]|l_sw[8]|l_sw[9]|out|pad|padres|vc|vcp|vdd|vddr|vip|vss|z
+ BOTTOM|TOP|VGND|VSS|anode|cathode|core|h_sw[0]|h_sw[10]|h_sw[1]|h_sw[2]|h_sw[3]|h_sw[4]|h_sw[5]|h_sw[6]|h_sw[7]|h_sw[8]|h_sw[9]|l_sw[0]|l_sw[10]|l_sw[1]|l_sw[2]|l_sw[3]|l_sw[4]|l_sw[5]|l_sw[6]|l_sw[7]|l_sw[8]|l_sw[9]|out|pad|padres|vc|vcp|vdd|vddr|vip|vss|z
+ sg13_lv_nmos L=0.13u W=0.42u AS=0.04725p AD=0.1428p PS=0.645u PD=1.52u
+ rfmode=0
M$237
+ BOTTOM|TOP|VGND|VSS|anode|cathode|core|h_sw[0]|h_sw[10]|h_sw[1]|h_sw[2]|h_sw[3]|h_sw[4]|h_sw[5]|h_sw[6]|h_sw[7]|h_sw[8]|h_sw[9]|l_sw[0]|l_sw[10]|l_sw[1]|l_sw[2]|l_sw[3]|l_sw[4]|l_sw[5]|l_sw[6]|l_sw[7]|l_sw[8]|l_sw[9]|out|pad|padres|vc|vcp|vdd|vddr|vip|vss|z
+ \$69027 \$69095
+ BOTTOM|TOP|VGND|VSS|anode|cathode|core|h_sw[0]|h_sw[10]|h_sw[1]|h_sw[2]|h_sw[3]|h_sw[4]|h_sw[5]|h_sw[6]|h_sw[7]|h_sw[8]|h_sw[9]|l_sw[0]|l_sw[10]|l_sw[1]|l_sw[2]|l_sw[3]|l_sw[4]|l_sw[5]|l_sw[6]|l_sw[7]|l_sw[8]|l_sw[9]|out|pad|padres|vc|vcp|vdd|vddr|vip|vss|z
+ sg13_lv_nmos L=0.13u W=0.74u AS=0.213425p AD=0.2775p PS=1.62u PD=2.23u
+ rfmode=0
M$238 \$69029 \$69028 \$69115
+ BOTTOM|TOP|VGND|VSS|anode|cathode|core|h_sw[0]|h_sw[10]|h_sw[1]|h_sw[2]|h_sw[3]|h_sw[4]|h_sw[5]|h_sw[6]|h_sw[7]|h_sw[8]|h_sw[9]|l_sw[0]|l_sw[10]|l_sw[1]|l_sw[2]|l_sw[3]|l_sw[4]|l_sw[5]|l_sw[6]|l_sw[7]|l_sw[8]|l_sw[9]|out|pad|padres|vc|vcp|vdd|vddr|vip|vss|z
+ sg13_lv_nmos L=0.13u W=0.74u AS=0.2516p AD=0.0777p PS=2.16u PD=0.95u rfmode=0
M$239 \$69115 RESET_B|Y$1
+ BOTTOM|TOP|VGND|VSS|anode|cathode|core|h_sw[0]|h_sw[10]|h_sw[1]|h_sw[2]|h_sw[3]|h_sw[4]|h_sw[5]|h_sw[6]|h_sw[7]|h_sw[8]|h_sw[9]|l_sw[0]|l_sw[10]|l_sw[1]|l_sw[2]|l_sw[3]|l_sw[4]|l_sw[5]|l_sw[6]|l_sw[7]|l_sw[8]|l_sw[9]|out|pad|padres|vc|vcp|vdd|vddr|vip|vss|z
+ BOTTOM|TOP|VGND|VSS|anode|cathode|core|h_sw[0]|h_sw[10]|h_sw[1]|h_sw[2]|h_sw[3]|h_sw[4]|h_sw[5]|h_sw[6]|h_sw[7]|h_sw[8]|h_sw[9]|l_sw[0]|l_sw[10]|l_sw[1]|l_sw[2]|l_sw[3]|l_sw[4]|l_sw[5]|l_sw[6]|l_sw[7]|l_sw[8]|l_sw[9]|out|pad|padres|vc|vcp|vdd|vddr|vip|vss|z
+ sg13_lv_nmos L=0.13u W=0.74u AS=0.0777p AD=0.1406p PS=0.95u PD=1.12u rfmode=0
M$240
+ BOTTOM|TOP|VGND|VSS|anode|cathode|core|h_sw[0]|h_sw[10]|h_sw[1]|h_sw[2]|h_sw[3]|h_sw[4]|h_sw[5]|h_sw[6]|h_sw[7]|h_sw[8]|h_sw[9]|l_sw[0]|l_sw[10]|l_sw[1]|l_sw[2]|l_sw[3]|l_sw[4]|l_sw[5]|l_sw[6]|l_sw[7]|l_sw[8]|l_sw[9]|out|pad|padres|vc|vcp|vdd|vddr|vip|vss|z
+ \$69029 A|Q
+ BOTTOM|TOP|VGND|VSS|anode|cathode|core|h_sw[0]|h_sw[10]|h_sw[1]|h_sw[2]|h_sw[3]|h_sw[4]|h_sw[5]|h_sw[6]|h_sw[7]|h_sw[8]|h_sw[9]|l_sw[0]|l_sw[10]|l_sw[1]|l_sw[2]|l_sw[3]|l_sw[4]|l_sw[5]|l_sw[6]|l_sw[7]|l_sw[8]|l_sw[9]|out|pad|padres|vc|vcp|vdd|vddr|vip|vss|z
+ sg13_lv_nmos L=0.13u W=0.74u AS=0.1406p AD=0.2516p PS=1.12u PD=2.16u rfmode=0
M$241
+ BOTTOM|TOP|VGND|VSS|anode|cathode|core|h_sw[0]|h_sw[10]|h_sw[1]|h_sw[2]|h_sw[3]|h_sw[4]|h_sw[5]|h_sw[6]|h_sw[7]|h_sw[8]|h_sw[9]|l_sw[0]|l_sw[10]|l_sw[1]|l_sw[2]|l_sw[3]|l_sw[4]|l_sw[5]|l_sw[6]|l_sw[7]|l_sw[8]|l_sw[9]|out|pad|padres|vc|vcp|vdd|vddr|vip|vss|z
+ \$69029 \$69031
+ BOTTOM|TOP|VGND|VSS|anode|cathode|core|h_sw[0]|h_sw[10]|h_sw[1]|h_sw[2]|h_sw[3]|h_sw[4]|h_sw[5]|h_sw[6]|h_sw[7]|h_sw[8]|h_sw[9]|l_sw[0]|l_sw[10]|l_sw[1]|l_sw[2]|l_sw[3]|l_sw[4]|l_sw[5]|l_sw[6]|l_sw[7]|l_sw[8]|l_sw[9]|out|pad|padres|vc|vcp|vdd|vddr|vip|vss|z
+ sg13_lv_nmos L=0.13u W=0.55u AS=0.1491p AD=0.187p PS=1.18u PD=1.78u rfmode=0
M$242
+ BOTTOM|TOP|VGND|VSS|anode|cathode|core|h_sw[0]|h_sw[10]|h_sw[1]|h_sw[2]|h_sw[3]|h_sw[4]|h_sw[5]|h_sw[6]|h_sw[7]|h_sw[8]|h_sw[9]|l_sw[0]|l_sw[10]|l_sw[1]|l_sw[2]|l_sw[3]|l_sw[4]|l_sw[5]|l_sw[6]|l_sw[7]|l_sw[8]|l_sw[9]|out|pad|padres|vc|vcp|vdd|vddr|vip|vss|z
+ \$69031 Q_N
+ BOTTOM|TOP|VGND|VSS|anode|cathode|core|h_sw[0]|h_sw[10]|h_sw[1]|h_sw[2]|h_sw[3]|h_sw[4]|h_sw[5]|h_sw[6]|h_sw[7]|h_sw[8]|h_sw[9]|l_sw[0]|l_sw[10]|l_sw[1]|l_sw[2]|l_sw[3]|l_sw[4]|l_sw[5]|l_sw[6]|l_sw[7]|l_sw[8]|l_sw[9]|out|pad|padres|vc|vcp|vdd|vddr|vip|vss|z
+ sg13_lv_nmos L=0.13u W=0.74u AS=0.1491p AD=0.2516p PS=1.18u PD=2.16u rfmode=0
M$243
+ BOTTOM|TOP|VGND|VSS|anode|cathode|core|h_sw[0]|h_sw[10]|h_sw[1]|h_sw[2]|h_sw[3]|h_sw[4]|h_sw[5]|h_sw[6]|h_sw[7]|h_sw[8]|h_sw[9]|l_sw[0]|l_sw[10]|l_sw[1]|l_sw[2]|l_sw[3]|l_sw[4]|l_sw[5]|l_sw[6]|l_sw[7]|l_sw[8]|l_sw[9]|out|pad|padres|vc|vcp|vdd|vddr|vip|vss|z
+ A|X$24 \$69096
+ BOTTOM|TOP|VGND|VSS|anode|cathode|core|h_sw[0]|h_sw[10]|h_sw[1]|h_sw[2]|h_sw[3]|h_sw[4]|h_sw[5]|h_sw[6]|h_sw[7]|h_sw[8]|h_sw[9]|l_sw[0]|l_sw[10]|l_sw[1]|l_sw[2]|l_sw[3]|l_sw[4]|l_sw[5]|l_sw[6]|l_sw[7]|l_sw[8]|l_sw[9]|out|pad|padres|vc|vcp|vdd|vddr|vip|vss|z
+ sg13_lv_nmos L=0.13u W=0.55u AS=0.14875p AD=0.187p PS=1.16u PD=1.78u rfmode=0
M$244
+ BOTTOM|TOP|VGND|VSS|anode|cathode|core|h_sw[0]|h_sw[10]|h_sw[1]|h_sw[2]|h_sw[3]|h_sw[4]|h_sw[5]|h_sw[6]|h_sw[7]|h_sw[8]|h_sw[9]|l_sw[0]|l_sw[10]|l_sw[1]|l_sw[2]|l_sw[3]|l_sw[4]|l_sw[5]|l_sw[6]|l_sw[7]|l_sw[8]|l_sw[9]|out|pad|padres|vc|vcp|vdd|vddr|vip|vss|z
+ \$69096 A|X$6
+ BOTTOM|TOP|VGND|VSS|anode|cathode|core|h_sw[0]|h_sw[10]|h_sw[1]|h_sw[2]|h_sw[3]|h_sw[4]|h_sw[5]|h_sw[6]|h_sw[7]|h_sw[8]|h_sw[9]|l_sw[0]|l_sw[10]|l_sw[1]|l_sw[2]|l_sw[3]|l_sw[4]|l_sw[5]|l_sw[6]|l_sw[7]|l_sw[8]|l_sw[9]|out|pad|padres|vc|vcp|vdd|vddr|vip|vss|z
+ sg13_lv_nmos L=0.13u W=0.74u AS=0.14875p AD=0.2886p PS=1.16u PD=2.26u rfmode=0
M$245 A|X$7 \$69097
+ BOTTOM|TOP|VGND|VSS|anode|cathode|core|h_sw[0]|h_sw[10]|h_sw[1]|h_sw[2]|h_sw[3]|h_sw[4]|h_sw[5]|h_sw[6]|h_sw[7]|h_sw[8]|h_sw[9]|l_sw[0]|l_sw[10]|l_sw[1]|l_sw[2]|l_sw[3]|l_sw[4]|l_sw[5]|l_sw[6]|l_sw[7]|l_sw[8]|l_sw[9]|out|pad|padres|vc|vcp|vdd|vddr|vip|vss|z
+ BOTTOM|TOP|VGND|VSS|anode|cathode|core|h_sw[0]|h_sw[10]|h_sw[1]|h_sw[2]|h_sw[3]|h_sw[4]|h_sw[5]|h_sw[6]|h_sw[7]|h_sw[8]|h_sw[9]|l_sw[0]|l_sw[10]|l_sw[1]|l_sw[2]|l_sw[3]|l_sw[4]|l_sw[5]|l_sw[6]|l_sw[7]|l_sw[8]|l_sw[9]|out|pad|padres|vc|vcp|vdd|vddr|vip|vss|z
+ sg13_lv_nmos L=0.13u W=0.74u AS=0.2886p AD=0.14875p PS=2.26u PD=1.16u rfmode=0
M$246
+ BOTTOM|TOP|VGND|VSS|anode|cathode|core|h_sw[0]|h_sw[10]|h_sw[1]|h_sw[2]|h_sw[3]|h_sw[4]|h_sw[5]|h_sw[6]|h_sw[7]|h_sw[8]|h_sw[9]|l_sw[0]|l_sw[10]|l_sw[1]|l_sw[2]|l_sw[3]|l_sw[4]|l_sw[5]|l_sw[6]|l_sw[7]|l_sw[8]|l_sw[9]|out|pad|padres|vc|vcp|vdd|vddr|vip|vss|z
+ A|Y$5 \$69097
+ BOTTOM|TOP|VGND|VSS|anode|cathode|core|h_sw[0]|h_sw[10]|h_sw[1]|h_sw[2]|h_sw[3]|h_sw[4]|h_sw[5]|h_sw[6]|h_sw[7]|h_sw[8]|h_sw[9]|l_sw[0]|l_sw[10]|l_sw[1]|l_sw[2]|l_sw[3]|l_sw[4]|l_sw[5]|l_sw[6]|l_sw[7]|l_sw[8]|l_sw[9]|out|pad|padres|vc|vcp|vdd|vddr|vip|vss|z
+ sg13_lv_nmos L=0.13u W=0.55u AS=0.14875p AD=0.187p PS=1.16u PD=1.78u rfmode=0
M$247
+ BOTTOM|TOP|VGND|VSS|anode|cathode|core|h_sw[0]|h_sw[10]|h_sw[1]|h_sw[2]|h_sw[3]|h_sw[4]|h_sw[5]|h_sw[6]|h_sw[7]|h_sw[8]|h_sw[9]|l_sw[0]|l_sw[10]|l_sw[1]|l_sw[2]|l_sw[3]|l_sw[4]|l_sw[5]|l_sw[6]|l_sw[7]|l_sw[8]|l_sw[9]|out|pad|padres|vc|vcp|vdd|vddr|vip|vss|z
+ A|Y$6 \$69098
+ BOTTOM|TOP|VGND|VSS|anode|cathode|core|h_sw[0]|h_sw[10]|h_sw[1]|h_sw[2]|h_sw[3]|h_sw[4]|h_sw[5]|h_sw[6]|h_sw[7]|h_sw[8]|h_sw[9]|l_sw[0]|l_sw[10]|l_sw[1]|l_sw[2]|l_sw[3]|l_sw[4]|l_sw[5]|l_sw[6]|l_sw[7]|l_sw[8]|l_sw[9]|out|pad|padres|vc|vcp|vdd|vddr|vip|vss|z
+ sg13_lv_nmos L=0.13u W=0.55u AS=0.14875p AD=0.187p PS=1.16u PD=1.78u rfmode=0
M$248
+ BOTTOM|TOP|VGND|VSS|anode|cathode|core|h_sw[0]|h_sw[10]|h_sw[1]|h_sw[2]|h_sw[3]|h_sw[4]|h_sw[5]|h_sw[6]|h_sw[7]|h_sw[8]|h_sw[9]|l_sw[0]|l_sw[10]|l_sw[1]|l_sw[2]|l_sw[3]|l_sw[4]|l_sw[5]|l_sw[6]|l_sw[7]|l_sw[8]|l_sw[9]|out|pad|padres|vc|vcp|vdd|vddr|vip|vss|z
+ \$69098 A|X$8
+ BOTTOM|TOP|VGND|VSS|anode|cathode|core|h_sw[0]|h_sw[10]|h_sw[1]|h_sw[2]|h_sw[3]|h_sw[4]|h_sw[5]|h_sw[6]|h_sw[7]|h_sw[8]|h_sw[9]|l_sw[0]|l_sw[10]|l_sw[1]|l_sw[2]|l_sw[3]|l_sw[4]|l_sw[5]|l_sw[6]|l_sw[7]|l_sw[8]|l_sw[9]|out|pad|padres|vc|vcp|vdd|vddr|vip|vss|z
+ sg13_lv_nmos L=0.13u W=0.74u AS=0.14875p AD=0.2886p PS=1.16u PD=2.26u rfmode=0
M$249
+ BOTTOM|TOP|VGND|VSS|anode|cathode|core|h_sw[0]|h_sw[10]|h_sw[1]|h_sw[2]|h_sw[3]|h_sw[4]|h_sw[5]|h_sw[6]|h_sw[7]|h_sw[8]|h_sw[9]|l_sw[0]|l_sw[10]|l_sw[1]|l_sw[2]|l_sw[3]|l_sw[4]|l_sw[5]|l_sw[6]|l_sw[7]|l_sw[8]|l_sw[9]|out|pad|padres|vc|vcp|vdd|vddr|vip|vss|z
+ A|X$25 \$69099
+ BOTTOM|TOP|VGND|VSS|anode|cathode|core|h_sw[0]|h_sw[10]|h_sw[1]|h_sw[2]|h_sw[3]|h_sw[4]|h_sw[5]|h_sw[6]|h_sw[7]|h_sw[8]|h_sw[9]|l_sw[0]|l_sw[10]|l_sw[1]|l_sw[2]|l_sw[3]|l_sw[4]|l_sw[5]|l_sw[6]|l_sw[7]|l_sw[8]|l_sw[9]|out|pad|padres|vc|vcp|vdd|vddr|vip|vss|z
+ sg13_lv_nmos L=0.13u W=0.55u AS=0.14875p AD=0.187p PS=1.16u PD=1.78u rfmode=0
M$250
+ BOTTOM|TOP|VGND|VSS|anode|cathode|core|h_sw[0]|h_sw[10]|h_sw[1]|h_sw[2]|h_sw[3]|h_sw[4]|h_sw[5]|h_sw[6]|h_sw[7]|h_sw[8]|h_sw[9]|l_sw[0]|l_sw[10]|l_sw[1]|l_sw[2]|l_sw[3]|l_sw[4]|l_sw[5]|l_sw[6]|l_sw[7]|l_sw[8]|l_sw[9]|out|pad|padres|vc|vcp|vdd|vddr|vip|vss|z
+ \$69099 A|X$9
+ BOTTOM|TOP|VGND|VSS|anode|cathode|core|h_sw[0]|h_sw[10]|h_sw[1]|h_sw[2]|h_sw[3]|h_sw[4]|h_sw[5]|h_sw[6]|h_sw[7]|h_sw[8]|h_sw[9]|l_sw[0]|l_sw[10]|l_sw[1]|l_sw[2]|l_sw[3]|l_sw[4]|l_sw[5]|l_sw[6]|l_sw[7]|l_sw[8]|l_sw[9]|out|pad|padres|vc|vcp|vdd|vddr|vip|vss|z
+ sg13_lv_nmos L=0.13u W=0.74u AS=0.14875p AD=0.2886p PS=1.16u PD=2.26u rfmode=0
M$251
+ BOTTOM|TOP|VGND|VSS|anode|cathode|core|h_sw[0]|h_sw[10]|h_sw[1]|h_sw[2]|h_sw[3]|h_sw[4]|h_sw[5]|h_sw[6]|h_sw[7]|h_sw[8]|h_sw[9]|l_sw[0]|l_sw[10]|l_sw[1]|l_sw[2]|l_sw[3]|l_sw[4]|l_sw[5]|l_sw[6]|l_sw[7]|l_sw[8]|l_sw[9]|out|pad|padres|vc|vcp|vdd|vddr|vip|vss|z
+ A|Y$7 \$69101
+ BOTTOM|TOP|VGND|VSS|anode|cathode|core|h_sw[0]|h_sw[10]|h_sw[1]|h_sw[2]|h_sw[3]|h_sw[4]|h_sw[5]|h_sw[6]|h_sw[7]|h_sw[8]|h_sw[9]|l_sw[0]|l_sw[10]|l_sw[1]|l_sw[2]|l_sw[3]|l_sw[4]|l_sw[5]|l_sw[6]|l_sw[7]|l_sw[8]|l_sw[9]|out|pad|padres|vc|vcp|vdd|vddr|vip|vss|z
+ sg13_lv_nmos L=0.13u W=0.55u AS=0.14875p AD=0.187p PS=1.16u PD=1.78u rfmode=0
M$252
+ BOTTOM|TOP|VGND|VSS|anode|cathode|core|h_sw[0]|h_sw[10]|h_sw[1]|h_sw[2]|h_sw[3]|h_sw[4]|h_sw[5]|h_sw[6]|h_sw[7]|h_sw[8]|h_sw[9]|l_sw[0]|l_sw[10]|l_sw[1]|l_sw[2]|l_sw[3]|l_sw[4]|l_sw[5]|l_sw[6]|l_sw[7]|l_sw[8]|l_sw[9]|out|pad|padres|vc|vcp|vdd|vddr|vip|vss|z
+ \$69101 A|X$10
+ BOTTOM|TOP|VGND|VSS|anode|cathode|core|h_sw[0]|h_sw[10]|h_sw[1]|h_sw[2]|h_sw[3]|h_sw[4]|h_sw[5]|h_sw[6]|h_sw[7]|h_sw[8]|h_sw[9]|l_sw[0]|l_sw[10]|l_sw[1]|l_sw[2]|l_sw[3]|l_sw[4]|l_sw[5]|l_sw[6]|l_sw[7]|l_sw[8]|l_sw[9]|out|pad|padres|vc|vcp|vdd|vddr|vip|vss|z
+ sg13_lv_nmos L=0.13u W=0.74u AS=0.14875p AD=0.2886p PS=1.16u PD=2.26u rfmode=0
M$253 \$69039 D|Y \$69120
+ BOTTOM|TOP|VGND|VSS|anode|cathode|core|h_sw[0]|h_sw[10]|h_sw[1]|h_sw[2]|h_sw[3]|h_sw[4]|h_sw[5]|h_sw[6]|h_sw[7]|h_sw[8]|h_sw[9]|l_sw[0]|l_sw[10]|l_sw[1]|l_sw[2]|l_sw[3]|l_sw[4]|l_sw[5]|l_sw[6]|l_sw[7]|l_sw[8]|l_sw[9]|out|pad|padres|vc|vcp|vdd|vddr|vip|vss|z
+ sg13_lv_nmos L=0.13u W=0.42u AS=0.1428p AD=0.0609p PS=1.52u PD=0.71u rfmode=0
M$254 \$69120 RESET_B|Y
+ BOTTOM|TOP|VGND|VSS|anode|cathode|core|h_sw[0]|h_sw[10]|h_sw[1]|h_sw[2]|h_sw[3]|h_sw[4]|h_sw[5]|h_sw[6]|h_sw[7]|h_sw[8]|h_sw[9]|l_sw[0]|l_sw[10]|l_sw[1]|l_sw[2]|l_sw[3]|l_sw[4]|l_sw[5]|l_sw[6]|l_sw[7]|l_sw[8]|l_sw[9]|out|pad|padres|vc|vcp|vdd|vddr|vip|vss|z
+ BOTTOM|TOP|VGND|VSS|anode|cathode|core|h_sw[0]|h_sw[10]|h_sw[1]|h_sw[2]|h_sw[3]|h_sw[4]|h_sw[5]|h_sw[6]|h_sw[7]|h_sw[8]|h_sw[9]|l_sw[0]|l_sw[10]|l_sw[1]|l_sw[2]|l_sw[3]|l_sw[4]|l_sw[5]|l_sw[6]|l_sw[7]|l_sw[8]|l_sw[9]|out|pad|padres|vc|vcp|vdd|vddr|vip|vss|z
+ sg13_lv_nmos L=0.13u W=0.42u AS=0.0609p AD=0.1626p PS=0.71u PD=1.415u rfmode=0
M$255
+ BOTTOM|TOP|VGND|VSS|anode|cathode|core|h_sw[0]|h_sw[10]|h_sw[1]|h_sw[2]|h_sw[3]|h_sw[4]|h_sw[5]|h_sw[6]|h_sw[7]|h_sw[8]|h_sw[9]|l_sw[0]|l_sw[10]|l_sw[1]|l_sw[2]|l_sw[3]|l_sw[4]|l_sw[5]|l_sw[6]|l_sw[7]|l_sw[8]|l_sw[9]|out|pad|padres|vc|vcp|vdd|vddr|vip|vss|z
+ \$69204 \$69041
+ BOTTOM|TOP|VGND|VSS|anode|cathode|core|h_sw[0]|h_sw[10]|h_sw[1]|h_sw[2]|h_sw[3]|h_sw[4]|h_sw[5]|h_sw[6]|h_sw[7]|h_sw[8]|h_sw[9]|l_sw[0]|l_sw[10]|l_sw[1]|l_sw[2]|l_sw[3]|l_sw[4]|l_sw[5]|l_sw[6]|l_sw[7]|l_sw[8]|l_sw[9]|out|pad|padres|vc|vcp|vdd|vddr|vip|vss|z
+ sg13_lv_nmos L=0.13u W=0.74u AS=0.1626p AD=0.2516p PS=1.415u PD=2.16u rfmode=0
M$256 \$69043 \$69206
+ BOTTOM|TOP|VGND|VSS|anode|cathode|core|h_sw[0]|h_sw[10]|h_sw[1]|h_sw[2]|h_sw[3]|h_sw[4]|h_sw[5]|h_sw[6]|h_sw[7]|h_sw[8]|h_sw[9]|l_sw[0]|l_sw[10]|l_sw[1]|l_sw[2]|l_sw[3]|l_sw[4]|l_sw[5]|l_sw[6]|l_sw[7]|l_sw[8]|l_sw[9]|out|pad|padres|vc|vcp|vdd|vddr|vip|vss|z
+ BOTTOM|TOP|VGND|VSS|anode|cathode|core|h_sw[0]|h_sw[10]|h_sw[1]|h_sw[2]|h_sw[3]|h_sw[4]|h_sw[5]|h_sw[6]|h_sw[7]|h_sw[8]|h_sw[9]|l_sw[0]|l_sw[10]|l_sw[1]|l_sw[2]|l_sw[3]|l_sw[4]|l_sw[5]|l_sw[6]|l_sw[7]|l_sw[8]|l_sw[9]|out|pad|padres|vc|vcp|vdd|vddr|vip|vss|z
+ sg13_lv_nmos L=0.13u W=0.42u AS=0.1428p AD=0.0798p PS=1.52u PD=0.8u rfmode=0
M$257
+ BOTTOM|TOP|VGND|VSS|anode|cathode|core|h_sw[0]|h_sw[10]|h_sw[1]|h_sw[2]|h_sw[3]|h_sw[4]|h_sw[5]|h_sw[6]|h_sw[7]|h_sw[8]|h_sw[9]|l_sw[0]|l_sw[10]|l_sw[1]|l_sw[2]|l_sw[3]|l_sw[4]|l_sw[5]|l_sw[6]|l_sw[7]|l_sw[8]|l_sw[9]|out|pad|padres|vc|vcp|vdd|vddr|vip|vss|z
+ RESET_B|Y \$69121
+ BOTTOM|TOP|VGND|VSS|anode|cathode|core|h_sw[0]|h_sw[10]|h_sw[1]|h_sw[2]|h_sw[3]|h_sw[4]|h_sw[5]|h_sw[6]|h_sw[7]|h_sw[8]|h_sw[9]|l_sw[0]|l_sw[10]|l_sw[1]|l_sw[2]|l_sw[3]|l_sw[4]|l_sw[5]|l_sw[6]|l_sw[7]|l_sw[8]|l_sw[9]|out|pad|padres|vc|vcp|vdd|vddr|vip|vss|z
+ sg13_lv_nmos L=0.13u W=0.42u AS=0.0798p AD=0.0378p PS=0.8u PD=0.6u rfmode=0
M$258 \$69121 \$69102 \$69206
+ BOTTOM|TOP|VGND|VSS|anode|cathode|core|h_sw[0]|h_sw[10]|h_sw[1]|h_sw[2]|h_sw[3]|h_sw[4]|h_sw[5]|h_sw[6]|h_sw[7]|h_sw[8]|h_sw[9]|l_sw[0]|l_sw[10]|l_sw[1]|l_sw[2]|l_sw[3]|l_sw[4]|l_sw[5]|l_sw[6]|l_sw[7]|l_sw[8]|l_sw[9]|out|pad|padres|vc|vcp|vdd|vddr|vip|vss|z
+ sg13_lv_nmos L=0.13u W=0.42u AS=0.0378p AD=0.1428p PS=0.6u PD=1.52u rfmode=0
M$259
+ BOTTOM|TOP|VGND|VSS|anode|cathode|core|h_sw[0]|h_sw[10]|h_sw[1]|h_sw[2]|h_sw[3]|h_sw[4]|h_sw[5]|h_sw[6]|h_sw[7]|h_sw[8]|h_sw[9]|l_sw[0]|l_sw[10]|l_sw[1]|l_sw[2]|l_sw[3]|l_sw[4]|l_sw[5]|l_sw[6]|l_sw[7]|l_sw[8]|l_sw[9]|out|pad|padres|vc|vcp|vdd|vddr|vip|vss|z
+ \$69102 Q_N$1
+ BOTTOM|TOP|VGND|VSS|anode|cathode|core|h_sw[0]|h_sw[10]|h_sw[1]|h_sw[2]|h_sw[3]|h_sw[4]|h_sw[5]|h_sw[6]|h_sw[7]|h_sw[8]|h_sw[9]|l_sw[0]|l_sw[10]|l_sw[1]|l_sw[2]|l_sw[3]|l_sw[4]|l_sw[5]|l_sw[6]|l_sw[7]|l_sw[8]|l_sw[9]|out|pad|padres|vc|vcp|vdd|vddr|vip|vss|z
+ sg13_lv_nmos L=0.13u W=0.74u AS=0.2516p AD=0.2849p PS=2.16u PD=2.25u rfmode=0
M$260 \$69045 \$69102
+ BOTTOM|TOP|VGND|VSS|anode|cathode|core|h_sw[0]|h_sw[10]|h_sw[1]|h_sw[2]|h_sw[3]|h_sw[4]|h_sw[5]|h_sw[6]|h_sw[7]|h_sw[8]|h_sw[9]|l_sw[0]|l_sw[10]|l_sw[1]|l_sw[2]|l_sw[3]|l_sw[4]|l_sw[5]|l_sw[6]|l_sw[7]|l_sw[8]|l_sw[9]|out|pad|padres|vc|vcp|vdd|vddr|vip|vss|z
+ BOTTOM|TOP|VGND|VSS|anode|cathode|core|h_sw[0]|h_sw[10]|h_sw[1]|h_sw[2]|h_sw[3]|h_sw[4]|h_sw[5]|h_sw[6]|h_sw[7]|h_sw[8]|h_sw[9]|l_sw[0]|l_sw[10]|l_sw[1]|l_sw[2]|l_sw[3]|l_sw[4]|l_sw[5]|l_sw[6]|l_sw[7]|l_sw[8]|l_sw[9]|out|pad|padres|vc|vcp|vdd|vddr|vip|vss|z
+ sg13_lv_nmos L=0.13u W=0.74u AS=0.2516p AD=0.1406p PS=2.16u PD=1.12u rfmode=0
M$261
+ BOTTOM|TOP|VGND|VSS|anode|cathode|core|h_sw[0]|h_sw[10]|h_sw[1]|h_sw[2]|h_sw[3]|h_sw[4]|h_sw[5]|h_sw[6]|h_sw[7]|h_sw[8]|h_sw[9]|l_sw[0]|l_sw[10]|l_sw[1]|l_sw[2]|l_sw[3]|l_sw[4]|l_sw[5]|l_sw[6]|l_sw[7]|l_sw[8]|l_sw[9]|out|pad|padres|vc|vcp|vdd|vddr|vip|vss|z
+ \$69045 A|Q$1
+ BOTTOM|TOP|VGND|VSS|anode|cathode|core|h_sw[0]|h_sw[10]|h_sw[1]|h_sw[2]|h_sw[3]|h_sw[4]|h_sw[5]|h_sw[6]|h_sw[7]|h_sw[8]|h_sw[9]|l_sw[0]|l_sw[10]|l_sw[1]|l_sw[2]|l_sw[3]|l_sw[4]|l_sw[5]|l_sw[6]|l_sw[7]|l_sw[8]|l_sw[9]|out|pad|padres|vc|vcp|vdd|vddr|vip|vss|z
+ sg13_lv_nmos L=0.13u W=0.74u AS=0.1406p AD=0.2516p PS=1.12u PD=2.16u rfmode=0
M$262
+ BOTTOM|TOP|VGND|VSS|anode|cathode|core|h_sw[0]|h_sw[10]|h_sw[1]|h_sw[2]|h_sw[3]|h_sw[4]|h_sw[5]|h_sw[6]|h_sw[7]|h_sw[8]|h_sw[9]|l_sw[0]|l_sw[10]|l_sw[1]|l_sw[2]|l_sw[3]|l_sw[4]|l_sw[5]|l_sw[6]|l_sw[7]|l_sw[8]|l_sw[9]|out|pad|padres|vc|vcp|vdd|vddr|vip|vss|z
+ A|Y$8 \$69103
+ BOTTOM|TOP|VGND|VSS|anode|cathode|core|h_sw[0]|h_sw[10]|h_sw[1]|h_sw[2]|h_sw[3]|h_sw[4]|h_sw[5]|h_sw[6]|h_sw[7]|h_sw[8]|h_sw[9]|l_sw[0]|l_sw[10]|l_sw[1]|l_sw[2]|l_sw[3]|l_sw[4]|l_sw[5]|l_sw[6]|l_sw[7]|l_sw[8]|l_sw[9]|out|pad|padres|vc|vcp|vdd|vddr|vip|vss|z
+ sg13_lv_nmos L=0.13u W=0.55u AS=0.14875p AD=0.187p PS=1.16u PD=1.78u rfmode=0
M$263
+ BOTTOM|TOP|VGND|VSS|anode|cathode|core|h_sw[0]|h_sw[10]|h_sw[1]|h_sw[2]|h_sw[3]|h_sw[4]|h_sw[5]|h_sw[6]|h_sw[7]|h_sw[8]|h_sw[9]|l_sw[0]|l_sw[10]|l_sw[1]|l_sw[2]|l_sw[3]|l_sw[4]|l_sw[5]|l_sw[6]|l_sw[7]|l_sw[8]|l_sw[9]|out|pad|padres|vc|vcp|vdd|vddr|vip|vss|z
+ \$69103 A|X$11
+ BOTTOM|TOP|VGND|VSS|anode|cathode|core|h_sw[0]|h_sw[10]|h_sw[1]|h_sw[2]|h_sw[3]|h_sw[4]|h_sw[5]|h_sw[6]|h_sw[7]|h_sw[8]|h_sw[9]|l_sw[0]|l_sw[10]|l_sw[1]|l_sw[2]|l_sw[3]|l_sw[4]|l_sw[5]|l_sw[6]|l_sw[7]|l_sw[8]|l_sw[9]|out|pad|padres|vc|vcp|vdd|vddr|vip|vss|z
+ sg13_lv_nmos L=0.13u W=0.74u AS=0.14875p AD=0.2886p PS=1.16u PD=2.26u rfmode=0
M$264
+ BOTTOM|TOP|VGND|VSS|anode|cathode|core|h_sw[0]|h_sw[10]|h_sw[1]|h_sw[2]|h_sw[3]|h_sw[4]|h_sw[5]|h_sw[6]|h_sw[7]|h_sw[8]|h_sw[9]|l_sw[0]|l_sw[10]|l_sw[1]|l_sw[2]|l_sw[3]|l_sw[4]|l_sw[5]|l_sw[6]|l_sw[7]|l_sw[8]|l_sw[9]|out|pad|padres|vc|vcp|vdd|vddr|vip|vss|z
+ A|X$46 \$69104
+ BOTTOM|TOP|VGND|VSS|anode|cathode|core|h_sw[0]|h_sw[10]|h_sw[1]|h_sw[2]|h_sw[3]|h_sw[4]|h_sw[5]|h_sw[6]|h_sw[7]|h_sw[8]|h_sw[9]|l_sw[0]|l_sw[10]|l_sw[1]|l_sw[2]|l_sw[3]|l_sw[4]|l_sw[5]|l_sw[6]|l_sw[7]|l_sw[8]|l_sw[9]|out|pad|padres|vc|vcp|vdd|vddr|vip|vss|z
+ sg13_lv_nmos L=0.13u W=0.55u AS=0.14875p AD=0.187p PS=1.16u PD=1.78u rfmode=0
M$265
+ BOTTOM|TOP|VGND|VSS|anode|cathode|core|h_sw[0]|h_sw[10]|h_sw[1]|h_sw[2]|h_sw[3]|h_sw[4]|h_sw[5]|h_sw[6]|h_sw[7]|h_sw[8]|h_sw[9]|l_sw[0]|l_sw[10]|l_sw[1]|l_sw[2]|l_sw[3]|l_sw[4]|l_sw[5]|l_sw[6]|l_sw[7]|l_sw[8]|l_sw[9]|out|pad|padres|vc|vcp|vdd|vddr|vip|vss|z
+ \$69104 A|X$12
+ BOTTOM|TOP|VGND|VSS|anode|cathode|core|h_sw[0]|h_sw[10]|h_sw[1]|h_sw[2]|h_sw[3]|h_sw[4]|h_sw[5]|h_sw[6]|h_sw[7]|h_sw[8]|h_sw[9]|l_sw[0]|l_sw[10]|l_sw[1]|l_sw[2]|l_sw[3]|l_sw[4]|l_sw[5]|l_sw[6]|l_sw[7]|l_sw[8]|l_sw[9]|out|pad|padres|vc|vcp|vdd|vddr|vip|vss|z
+ sg13_lv_nmos L=0.13u W=0.74u AS=0.14875p AD=0.2886p PS=1.16u PD=2.26u rfmode=0
M$266 X|in_h_sw[6]|nh_sw[6]|x \$69105
+ BOTTOM|TOP|VGND|VSS|anode|cathode|core|h_sw[0]|h_sw[10]|h_sw[1]|h_sw[2]|h_sw[3]|h_sw[4]|h_sw[5]|h_sw[6]|h_sw[7]|h_sw[8]|h_sw[9]|l_sw[0]|l_sw[10]|l_sw[1]|l_sw[2]|l_sw[3]|l_sw[4]|l_sw[5]|l_sw[6]|l_sw[7]|l_sw[8]|l_sw[9]|out|pad|padres|vc|vcp|vdd|vddr|vip|vss|z
+ BOTTOM|TOP|VGND|VSS|anode|cathode|core|h_sw[0]|h_sw[10]|h_sw[1]|h_sw[2]|h_sw[3]|h_sw[4]|h_sw[5]|h_sw[6]|h_sw[7]|h_sw[8]|h_sw[9]|l_sw[0]|l_sw[10]|l_sw[1]|l_sw[2]|l_sw[3]|l_sw[4]|l_sw[5]|l_sw[6]|l_sw[7]|l_sw[8]|l_sw[9]|out|pad|padres|vc|vcp|vdd|vddr|vip|vss|z
+ sg13_lv_nmos L=0.13u W=0.74u AS=0.2886p AD=0.14875p PS=2.26u PD=1.16u rfmode=0
M$267
+ BOTTOM|TOP|VGND|VSS|anode|cathode|core|h_sw[0]|h_sw[10]|h_sw[1]|h_sw[2]|h_sw[3]|h_sw[4]|h_sw[5]|h_sw[6]|h_sw[7]|h_sw[8]|h_sw[9]|l_sw[0]|l_sw[10]|l_sw[1]|l_sw[2]|l_sw[3]|l_sw[4]|l_sw[5]|l_sw[6]|l_sw[7]|l_sw[8]|l_sw[9]|out|pad|padres|vc|vcp|vdd|vddr|vip|vss|z
+ A|X$26 \$69105
+ BOTTOM|TOP|VGND|VSS|anode|cathode|core|h_sw[0]|h_sw[10]|h_sw[1]|h_sw[2]|h_sw[3]|h_sw[4]|h_sw[5]|h_sw[6]|h_sw[7]|h_sw[8]|h_sw[9]|l_sw[0]|l_sw[10]|l_sw[1]|l_sw[2]|l_sw[3]|l_sw[4]|l_sw[5]|l_sw[6]|l_sw[7]|l_sw[8]|l_sw[9]|out|pad|padres|vc|vcp|vdd|vddr|vip|vss|z
+ sg13_lv_nmos L=0.13u W=0.55u AS=0.14875p AD=0.187p PS=1.16u PD=1.78u rfmode=0
M$268
+ BOTTOM|TOP|VGND|VSS|anode|cathode|core|h_sw[0]|h_sw[10]|h_sw[1]|h_sw[2]|h_sw[3]|h_sw[4]|h_sw[5]|h_sw[6]|h_sw[7]|h_sw[8]|h_sw[9]|l_sw[0]|l_sw[10]|l_sw[1]|l_sw[2]|l_sw[3]|l_sw[4]|l_sw[5]|l_sw[6]|l_sw[7]|l_sw[8]|l_sw[9]|out|pad|padres|vc|vcp|vdd|vddr|vip|vss|z
+ A|Y$9 \$69107
+ BOTTOM|TOP|VGND|VSS|anode|cathode|core|h_sw[0]|h_sw[10]|h_sw[1]|h_sw[2]|h_sw[3]|h_sw[4]|h_sw[5]|h_sw[6]|h_sw[7]|h_sw[8]|h_sw[9]|l_sw[0]|l_sw[10]|l_sw[1]|l_sw[2]|l_sw[3]|l_sw[4]|l_sw[5]|l_sw[6]|l_sw[7]|l_sw[8]|l_sw[9]|out|pad|padres|vc|vcp|vdd|vddr|vip|vss|z
+ sg13_lv_nmos L=0.13u W=0.55u AS=0.14875p AD=0.187p PS=1.16u PD=1.78u rfmode=0
M$269
+ BOTTOM|TOP|VGND|VSS|anode|cathode|core|h_sw[0]|h_sw[10]|h_sw[1]|h_sw[2]|h_sw[3]|h_sw[4]|h_sw[5]|h_sw[6]|h_sw[7]|h_sw[8]|h_sw[9]|l_sw[0]|l_sw[10]|l_sw[1]|l_sw[2]|l_sw[3]|l_sw[4]|l_sw[5]|l_sw[6]|l_sw[7]|l_sw[8]|l_sw[9]|out|pad|padres|vc|vcp|vdd|vddr|vip|vss|z
+ \$69107 A|X$13
+ BOTTOM|TOP|VGND|VSS|anode|cathode|core|h_sw[0]|h_sw[10]|h_sw[1]|h_sw[2]|h_sw[3]|h_sw[4]|h_sw[5]|h_sw[6]|h_sw[7]|h_sw[8]|h_sw[9]|l_sw[0]|l_sw[10]|l_sw[1]|l_sw[2]|l_sw[3]|l_sw[4]|l_sw[5]|l_sw[6]|l_sw[7]|l_sw[8]|l_sw[9]|out|pad|padres|vc|vcp|vdd|vddr|vip|vss|z
+ sg13_lv_nmos L=0.13u W=0.74u AS=0.14875p AD=0.2886p PS=1.16u PD=2.26u rfmode=0
M$270 X|in_l_sw[7]|nl_sw[7]|x \$69108
+ BOTTOM|TOP|VGND|VSS|anode|cathode|core|h_sw[0]|h_sw[10]|h_sw[1]|h_sw[2]|h_sw[3]|h_sw[4]|h_sw[5]|h_sw[6]|h_sw[7]|h_sw[8]|h_sw[9]|l_sw[0]|l_sw[10]|l_sw[1]|l_sw[2]|l_sw[3]|l_sw[4]|l_sw[5]|l_sw[6]|l_sw[7]|l_sw[8]|l_sw[9]|out|pad|padres|vc|vcp|vdd|vddr|vip|vss|z
+ BOTTOM|TOP|VGND|VSS|anode|cathode|core|h_sw[0]|h_sw[10]|h_sw[1]|h_sw[2]|h_sw[3]|h_sw[4]|h_sw[5]|h_sw[6]|h_sw[7]|h_sw[8]|h_sw[9]|l_sw[0]|l_sw[10]|l_sw[1]|l_sw[2]|l_sw[3]|l_sw[4]|l_sw[5]|l_sw[6]|l_sw[7]|l_sw[8]|l_sw[9]|out|pad|padres|vc|vcp|vdd|vddr|vip|vss|z
+ sg13_lv_nmos L=0.13u W=0.74u AS=0.2886p AD=0.14875p PS=2.26u PD=1.16u rfmode=0
M$271
+ BOTTOM|TOP|VGND|VSS|anode|cathode|core|h_sw[0]|h_sw[10]|h_sw[1]|h_sw[2]|h_sw[3]|h_sw[4]|h_sw[5]|h_sw[6]|h_sw[7]|h_sw[8]|h_sw[9]|l_sw[0]|l_sw[10]|l_sw[1]|l_sw[2]|l_sw[3]|l_sw[4]|l_sw[5]|l_sw[6]|l_sw[7]|l_sw[8]|l_sw[9]|out|pad|padres|vc|vcp|vdd|vddr|vip|vss|z
+ A|X$11 \$69108
+ BOTTOM|TOP|VGND|VSS|anode|cathode|core|h_sw[0]|h_sw[10]|h_sw[1]|h_sw[2]|h_sw[3]|h_sw[4]|h_sw[5]|h_sw[6]|h_sw[7]|h_sw[8]|h_sw[9]|l_sw[0]|l_sw[10]|l_sw[1]|l_sw[2]|l_sw[3]|l_sw[4]|l_sw[5]|l_sw[6]|l_sw[7]|l_sw[8]|l_sw[9]|out|pad|padres|vc|vcp|vdd|vddr|vip|vss|z
+ sg13_lv_nmos L=0.13u W=0.55u AS=0.14875p AD=0.187p PS=1.16u PD=1.78u rfmode=0
M$272
+ BOTTOM|TOP|VGND|VSS|anode|cathode|core|h_sw[0]|h_sw[10]|h_sw[1]|h_sw[2]|h_sw[3]|h_sw[4]|h_sw[5]|h_sw[6]|h_sw[7]|h_sw[8]|h_sw[9]|l_sw[0]|l_sw[10]|l_sw[1]|l_sw[2]|l_sw[3]|l_sw[4]|l_sw[5]|l_sw[6]|l_sw[7]|l_sw[8]|l_sw[9]|out|pad|padres|vc|vcp|vdd|vddr|vip|vss|z
+ A|X$27 \$69109
+ BOTTOM|TOP|VGND|VSS|anode|cathode|core|h_sw[0]|h_sw[10]|h_sw[1]|h_sw[2]|h_sw[3]|h_sw[4]|h_sw[5]|h_sw[6]|h_sw[7]|h_sw[8]|h_sw[9]|l_sw[0]|l_sw[10]|l_sw[1]|l_sw[2]|l_sw[3]|l_sw[4]|l_sw[5]|l_sw[6]|l_sw[7]|l_sw[8]|l_sw[9]|out|pad|padres|vc|vcp|vdd|vddr|vip|vss|z
+ sg13_lv_nmos L=0.13u W=0.55u AS=0.14875p AD=0.187p PS=1.16u PD=1.78u rfmode=0
M$273
+ BOTTOM|TOP|VGND|VSS|anode|cathode|core|h_sw[0]|h_sw[10]|h_sw[1]|h_sw[2]|h_sw[3]|h_sw[4]|h_sw[5]|h_sw[6]|h_sw[7]|h_sw[8]|h_sw[9]|l_sw[0]|l_sw[10]|l_sw[1]|l_sw[2]|l_sw[3]|l_sw[4]|l_sw[5]|l_sw[6]|l_sw[7]|l_sw[8]|l_sw[9]|out|pad|padres|vc|vcp|vdd|vddr|vip|vss|z
+ \$69109 A|X$14
+ BOTTOM|TOP|VGND|VSS|anode|cathode|core|h_sw[0]|h_sw[10]|h_sw[1]|h_sw[2]|h_sw[3]|h_sw[4]|h_sw[5]|h_sw[6]|h_sw[7]|h_sw[8]|h_sw[9]|l_sw[0]|l_sw[10]|l_sw[1]|l_sw[2]|l_sw[3]|l_sw[4]|l_sw[5]|l_sw[6]|l_sw[7]|l_sw[8]|l_sw[9]|out|pad|padres|vc|vcp|vdd|vddr|vip|vss|z
+ sg13_lv_nmos L=0.13u W=0.74u AS=0.14875p AD=0.2886p PS=1.16u PD=2.26u rfmode=0
M$274 \$69051 B|D|Y \$69117
+ BOTTOM|TOP|VGND|VSS|anode|cathode|core|h_sw[0]|h_sw[10]|h_sw[1]|h_sw[2]|h_sw[3]|h_sw[4]|h_sw[5]|h_sw[6]|h_sw[7]|h_sw[8]|h_sw[9]|l_sw[0]|l_sw[10]|l_sw[1]|l_sw[2]|l_sw[3]|l_sw[4]|l_sw[5]|l_sw[6]|l_sw[7]|l_sw[8]|l_sw[9]|out|pad|padres|vc|vcp|vdd|vddr|vip|vss|z
+ sg13_lv_nmos L=0.13u W=0.42u AS=0.1428p AD=0.0609p PS=1.52u PD=0.71u rfmode=0
M$275 \$69117 RESET_B|Y
+ BOTTOM|TOP|VGND|VSS|anode|cathode|core|h_sw[0]|h_sw[10]|h_sw[1]|h_sw[2]|h_sw[3]|h_sw[4]|h_sw[5]|h_sw[6]|h_sw[7]|h_sw[8]|h_sw[9]|l_sw[0]|l_sw[10]|l_sw[1]|l_sw[2]|l_sw[3]|l_sw[4]|l_sw[5]|l_sw[6]|l_sw[7]|l_sw[8]|l_sw[9]|out|pad|padres|vc|vcp|vdd|vddr|vip|vss|z
+ BOTTOM|TOP|VGND|VSS|anode|cathode|core|h_sw[0]|h_sw[10]|h_sw[1]|h_sw[2]|h_sw[3]|h_sw[4]|h_sw[5]|h_sw[6]|h_sw[7]|h_sw[8]|h_sw[9]|l_sw[0]|l_sw[10]|l_sw[1]|l_sw[2]|l_sw[3]|l_sw[4]|l_sw[5]|l_sw[6]|l_sw[7]|l_sw[8]|l_sw[9]|out|pad|padres|vc|vcp|vdd|vddr|vip|vss|z
+ sg13_lv_nmos L=0.13u W=0.42u AS=0.0609p AD=0.1626p PS=0.71u PD=1.415u rfmode=0
M$276
+ BOTTOM|TOP|VGND|VSS|anode|cathode|core|h_sw[0]|h_sw[10]|h_sw[1]|h_sw[2]|h_sw[3]|h_sw[4]|h_sw[5]|h_sw[6]|h_sw[7]|h_sw[8]|h_sw[9]|l_sw[0]|l_sw[10]|l_sw[1]|l_sw[2]|l_sw[3]|l_sw[4]|l_sw[5]|l_sw[6]|l_sw[7]|l_sw[8]|l_sw[9]|out|pad|padres|vc|vcp|vdd|vddr|vip|vss|z
+ \$69211 \$69053
+ BOTTOM|TOP|VGND|VSS|anode|cathode|core|h_sw[0]|h_sw[10]|h_sw[1]|h_sw[2]|h_sw[3]|h_sw[4]|h_sw[5]|h_sw[6]|h_sw[7]|h_sw[8]|h_sw[9]|l_sw[0]|l_sw[10]|l_sw[1]|l_sw[2]|l_sw[3]|l_sw[4]|l_sw[5]|l_sw[6]|l_sw[7]|l_sw[8]|l_sw[9]|out|pad|padres|vc|vcp|vdd|vddr|vip|vss|z
+ sg13_lv_nmos L=0.13u W=0.74u AS=0.1626p AD=0.2516p PS=1.415u PD=2.16u rfmode=0
M$277 \$69055 \$69214
+ BOTTOM|TOP|VGND|VSS|anode|cathode|core|h_sw[0]|h_sw[10]|h_sw[1]|h_sw[2]|h_sw[3]|h_sw[4]|h_sw[5]|h_sw[6]|h_sw[7]|h_sw[8]|h_sw[9]|l_sw[0]|l_sw[10]|l_sw[1]|l_sw[2]|l_sw[3]|l_sw[4]|l_sw[5]|l_sw[6]|l_sw[7]|l_sw[8]|l_sw[9]|out|pad|padres|vc|vcp|vdd|vddr|vip|vss|z
+ BOTTOM|TOP|VGND|VSS|anode|cathode|core|h_sw[0]|h_sw[10]|h_sw[1]|h_sw[2]|h_sw[3]|h_sw[4]|h_sw[5]|h_sw[6]|h_sw[7]|h_sw[8]|h_sw[9]|l_sw[0]|l_sw[10]|l_sw[1]|l_sw[2]|l_sw[3]|l_sw[4]|l_sw[5]|l_sw[6]|l_sw[7]|l_sw[8]|l_sw[9]|out|pad|padres|vc|vcp|vdd|vddr|vip|vss|z
+ sg13_lv_nmos L=0.13u W=0.42u AS=0.1428p AD=0.0798p PS=1.52u PD=0.8u rfmode=0
M$278
+ BOTTOM|TOP|VGND|VSS|anode|cathode|core|h_sw[0]|h_sw[10]|h_sw[1]|h_sw[2]|h_sw[3]|h_sw[4]|h_sw[5]|h_sw[6]|h_sw[7]|h_sw[8]|h_sw[9]|l_sw[0]|l_sw[10]|l_sw[1]|l_sw[2]|l_sw[3]|l_sw[4]|l_sw[5]|l_sw[6]|l_sw[7]|l_sw[8]|l_sw[9]|out|pad|padres|vc|vcp|vdd|vddr|vip|vss|z
+ RESET_B|Y \$69116
+ BOTTOM|TOP|VGND|VSS|anode|cathode|core|h_sw[0]|h_sw[10]|h_sw[1]|h_sw[2]|h_sw[3]|h_sw[4]|h_sw[5]|h_sw[6]|h_sw[7]|h_sw[8]|h_sw[9]|l_sw[0]|l_sw[10]|l_sw[1]|l_sw[2]|l_sw[3]|l_sw[4]|l_sw[5]|l_sw[6]|l_sw[7]|l_sw[8]|l_sw[9]|out|pad|padres|vc|vcp|vdd|vddr|vip|vss|z
+ sg13_lv_nmos L=0.13u W=0.42u AS=0.0798p AD=0.0378p PS=0.8u PD=0.6u rfmode=0
M$279 \$69116 \$69110 \$69214
+ BOTTOM|TOP|VGND|VSS|anode|cathode|core|h_sw[0]|h_sw[10]|h_sw[1]|h_sw[2]|h_sw[3]|h_sw[4]|h_sw[5]|h_sw[6]|h_sw[7]|h_sw[8]|h_sw[9]|l_sw[0]|l_sw[10]|l_sw[1]|l_sw[2]|l_sw[3]|l_sw[4]|l_sw[5]|l_sw[6]|l_sw[7]|l_sw[8]|l_sw[9]|out|pad|padres|vc|vcp|vdd|vddr|vip|vss|z
+ sg13_lv_nmos L=0.13u W=0.42u AS=0.0378p AD=0.1428p PS=0.6u PD=1.52u rfmode=0
M$280
+ BOTTOM|TOP|VGND|VSS|anode|cathode|core|h_sw[0]|h_sw[10]|h_sw[1]|h_sw[2]|h_sw[3]|h_sw[4]|h_sw[5]|h_sw[6]|h_sw[7]|h_sw[8]|h_sw[9]|l_sw[0]|l_sw[10]|l_sw[1]|l_sw[2]|l_sw[3]|l_sw[4]|l_sw[5]|l_sw[6]|l_sw[7]|l_sw[8]|l_sw[9]|out|pad|padres|vc|vcp|vdd|vddr|vip|vss|z
+ \$69110 Q_N$2
+ BOTTOM|TOP|VGND|VSS|anode|cathode|core|h_sw[0]|h_sw[10]|h_sw[1]|h_sw[2]|h_sw[3]|h_sw[4]|h_sw[5]|h_sw[6]|h_sw[7]|h_sw[8]|h_sw[9]|l_sw[0]|l_sw[10]|l_sw[1]|l_sw[2]|l_sw[3]|l_sw[4]|l_sw[5]|l_sw[6]|l_sw[7]|l_sw[8]|l_sw[9]|out|pad|padres|vc|vcp|vdd|vddr|vip|vss|z
+ sg13_lv_nmos L=0.13u W=0.74u AS=0.2516p AD=0.2849p PS=2.16u PD=2.25u rfmode=0
M$281 \$69057 \$69110
+ BOTTOM|TOP|VGND|VSS|anode|cathode|core|h_sw[0]|h_sw[10]|h_sw[1]|h_sw[2]|h_sw[3]|h_sw[4]|h_sw[5]|h_sw[6]|h_sw[7]|h_sw[8]|h_sw[9]|l_sw[0]|l_sw[10]|l_sw[1]|l_sw[2]|l_sw[3]|l_sw[4]|l_sw[5]|l_sw[6]|l_sw[7]|l_sw[8]|l_sw[9]|out|pad|padres|vc|vcp|vdd|vddr|vip|vss|z
+ BOTTOM|TOP|VGND|VSS|anode|cathode|core|h_sw[0]|h_sw[10]|h_sw[1]|h_sw[2]|h_sw[3]|h_sw[4]|h_sw[5]|h_sw[6]|h_sw[7]|h_sw[8]|h_sw[9]|l_sw[0]|l_sw[10]|l_sw[1]|l_sw[2]|l_sw[3]|l_sw[4]|l_sw[5]|l_sw[6]|l_sw[7]|l_sw[8]|l_sw[9]|out|pad|padres|vc|vcp|vdd|vddr|vip|vss|z
+ sg13_lv_nmos L=0.13u W=0.74u AS=0.2516p AD=0.1406p PS=2.16u PD=1.12u rfmode=0
M$282
+ BOTTOM|TOP|VGND|VSS|anode|cathode|core|h_sw[0]|h_sw[10]|h_sw[1]|h_sw[2]|h_sw[3]|h_sw[4]|h_sw[5]|h_sw[6]|h_sw[7]|h_sw[8]|h_sw[9]|l_sw[0]|l_sw[10]|l_sw[1]|l_sw[2]|l_sw[3]|l_sw[4]|l_sw[5]|l_sw[6]|l_sw[7]|l_sw[8]|l_sw[9]|out|pad|padres|vc|vcp|vdd|vddr|vip|vss|z
+ \$69057 A|A_N|B|B_N|Q
+ BOTTOM|TOP|VGND|VSS|anode|cathode|core|h_sw[0]|h_sw[10]|h_sw[1]|h_sw[2]|h_sw[3]|h_sw[4]|h_sw[5]|h_sw[6]|h_sw[7]|h_sw[8]|h_sw[9]|l_sw[0]|l_sw[10]|l_sw[1]|l_sw[2]|l_sw[3]|l_sw[4]|l_sw[5]|l_sw[6]|l_sw[7]|l_sw[8]|l_sw[9]|out|pad|padres|vc|vcp|vdd|vddr|vip|vss|z
+ sg13_lv_nmos L=0.13u W=0.74u AS=0.1406p AD=0.2516p PS=1.12u PD=2.16u rfmode=0
M$283 A|X$15 \$69111
+ BOTTOM|TOP|VGND|VSS|anode|cathode|core|h_sw[0]|h_sw[10]|h_sw[1]|h_sw[2]|h_sw[3]|h_sw[4]|h_sw[5]|h_sw[6]|h_sw[7]|h_sw[8]|h_sw[9]|l_sw[0]|l_sw[10]|l_sw[1]|l_sw[2]|l_sw[3]|l_sw[4]|l_sw[5]|l_sw[6]|l_sw[7]|l_sw[8]|l_sw[9]|out|pad|padres|vc|vcp|vdd|vddr|vip|vss|z
+ BOTTOM|TOP|VGND|VSS|anode|cathode|core|h_sw[0]|h_sw[10]|h_sw[1]|h_sw[2]|h_sw[3]|h_sw[4]|h_sw[5]|h_sw[6]|h_sw[7]|h_sw[8]|h_sw[9]|l_sw[0]|l_sw[10]|l_sw[1]|l_sw[2]|l_sw[3]|l_sw[4]|l_sw[5]|l_sw[6]|l_sw[7]|l_sw[8]|l_sw[9]|out|pad|padres|vc|vcp|vdd|vddr|vip|vss|z
+ sg13_lv_nmos L=0.13u W=0.74u AS=0.2886p AD=0.14875p PS=2.26u PD=1.16u rfmode=0
M$284
+ BOTTOM|TOP|VGND|VSS|anode|cathode|core|h_sw[0]|h_sw[10]|h_sw[1]|h_sw[2]|h_sw[3]|h_sw[4]|h_sw[5]|h_sw[6]|h_sw[7]|h_sw[8]|h_sw[9]|l_sw[0]|l_sw[10]|l_sw[1]|l_sw[2]|l_sw[3]|l_sw[4]|l_sw[5]|l_sw[6]|l_sw[7]|l_sw[8]|l_sw[9]|out|pad|padres|vc|vcp|vdd|vddr|vip|vss|z
+ A|Y$10 \$69111
+ BOTTOM|TOP|VGND|VSS|anode|cathode|core|h_sw[0]|h_sw[10]|h_sw[1]|h_sw[2]|h_sw[3]|h_sw[4]|h_sw[5]|h_sw[6]|h_sw[7]|h_sw[8]|h_sw[9]|l_sw[0]|l_sw[10]|l_sw[1]|l_sw[2]|l_sw[3]|l_sw[4]|l_sw[5]|l_sw[6]|l_sw[7]|l_sw[8]|l_sw[9]|out|pad|padres|vc|vcp|vdd|vddr|vip|vss|z
+ sg13_lv_nmos L=0.13u W=0.55u AS=0.14875p AD=0.187p PS=1.16u PD=1.78u rfmode=0
M$285
+ BOTTOM|TOP|VGND|VSS|anode|cathode|core|h_sw[0]|h_sw[10]|h_sw[1]|h_sw[2]|h_sw[3]|h_sw[4]|h_sw[5]|h_sw[6]|h_sw[7]|h_sw[8]|h_sw[9]|l_sw[0]|l_sw[10]|l_sw[1]|l_sw[2]|l_sw[3]|l_sw[4]|l_sw[5]|l_sw[6]|l_sw[7]|l_sw[8]|l_sw[9]|out|pad|padres|vc|vcp|vdd|vddr|vip|vss|z
+ A|X$28 \$69112
+ BOTTOM|TOP|VGND|VSS|anode|cathode|core|h_sw[0]|h_sw[10]|h_sw[1]|h_sw[2]|h_sw[3]|h_sw[4]|h_sw[5]|h_sw[6]|h_sw[7]|h_sw[8]|h_sw[9]|l_sw[0]|l_sw[10]|l_sw[1]|l_sw[2]|l_sw[3]|l_sw[4]|l_sw[5]|l_sw[6]|l_sw[7]|l_sw[8]|l_sw[9]|out|pad|padres|vc|vcp|vdd|vddr|vip|vss|z
+ sg13_lv_nmos L=0.13u W=0.55u AS=0.14875p AD=0.187p PS=1.16u PD=1.78u rfmode=0
M$286
+ BOTTOM|TOP|VGND|VSS|anode|cathode|core|h_sw[0]|h_sw[10]|h_sw[1]|h_sw[2]|h_sw[3]|h_sw[4]|h_sw[5]|h_sw[6]|h_sw[7]|h_sw[8]|h_sw[9]|l_sw[0]|l_sw[10]|l_sw[1]|l_sw[2]|l_sw[3]|l_sw[4]|l_sw[5]|l_sw[6]|l_sw[7]|l_sw[8]|l_sw[9]|out|pad|padres|vc|vcp|vdd|vddr|vip|vss|z
+ \$69112 A|X$16
+ BOTTOM|TOP|VGND|VSS|anode|cathode|core|h_sw[0]|h_sw[10]|h_sw[1]|h_sw[2]|h_sw[3]|h_sw[4]|h_sw[5]|h_sw[6]|h_sw[7]|h_sw[8]|h_sw[9]|l_sw[0]|l_sw[10]|l_sw[1]|l_sw[2]|l_sw[3]|l_sw[4]|l_sw[5]|l_sw[6]|l_sw[7]|l_sw[8]|l_sw[9]|out|pad|padres|vc|vcp|vdd|vddr|vip|vss|z
+ sg13_lv_nmos L=0.13u W=0.74u AS=0.14875p AD=0.2886p PS=1.16u PD=2.26u rfmode=0
M$287
+ BOTTOM|TOP|VGND|VSS|anode|cathode|core|h_sw[0]|h_sw[10]|h_sw[1]|h_sw[2]|h_sw[3]|h_sw[4]|h_sw[5]|h_sw[6]|h_sw[7]|h_sw[8]|h_sw[9]|l_sw[0]|l_sw[10]|l_sw[1]|l_sw[2]|l_sw[3]|l_sw[4]|l_sw[5]|l_sw[6]|l_sw[7]|l_sw[8]|l_sw[9]|out|pad|padres|vc|vcp|vdd|vddr|vip|vss|z
+ A1|D|Q \$69094
+ BOTTOM|TOP|VGND|VSS|anode|cathode|core|h_sw[0]|h_sw[10]|h_sw[1]|h_sw[2]|h_sw[3]|h_sw[4]|h_sw[5]|h_sw[6]|h_sw[7]|h_sw[8]|h_sw[9]|l_sw[0]|l_sw[10]|l_sw[1]|l_sw[2]|l_sw[3]|l_sw[4]|l_sw[5]|l_sw[6]|l_sw[7]|l_sw[8]|l_sw[9]|out|pad|padres|vc|vcp|vdd|vddr|vip|vss|z
+ sg13_lv_nmos L=0.13u W=0.55u AS=0.15055p AD=0.187p PS=1.17u PD=1.78u rfmode=0
M$288
+ BOTTOM|TOP|VGND|VSS|anode|cathode|core|h_sw[0]|h_sw[10]|h_sw[1]|h_sw[2]|h_sw[3]|h_sw[4]|h_sw[5]|h_sw[6]|h_sw[7]|h_sw[8]|h_sw[9]|l_sw[0]|l_sw[10]|l_sw[1]|l_sw[2]|l_sw[3]|l_sw[4]|l_sw[5]|l_sw[6]|l_sw[7]|l_sw[8]|l_sw[9]|out|pad|padres|vc|vcp|vdd|vddr|vip|vss|z
+ CLK|D|GATE|Q$1 \$69027
+ BOTTOM|TOP|VGND|VSS|anode|cathode|core|h_sw[0]|h_sw[10]|h_sw[1]|h_sw[2]|h_sw[3]|h_sw[4]|h_sw[5]|h_sw[6]|h_sw[7]|h_sw[8]|h_sw[9]|l_sw[0]|l_sw[10]|l_sw[1]|l_sw[2]|l_sw[3]|l_sw[4]|l_sw[5]|l_sw[6]|l_sw[7]|l_sw[8]|l_sw[9]|out|pad|padres|vc|vcp|vdd|vddr|vip|vss|z
+ sg13_lv_nmos L=0.13u W=0.74u AS=0.15055p AD=0.2516p PS=1.17u PD=2.16u rfmode=0
M$289
+ BOTTOM|TOP|VGND|VSS|anode|cathode|core|h_sw[0]|h_sw[10]|h_sw[1]|h_sw[2]|h_sw[3]|h_sw[4]|h_sw[5]|h_sw[6]|h_sw[7]|h_sw[8]|h_sw[9]|l_sw[0]|l_sw[10]|l_sw[1]|l_sw[2]|l_sw[3]|l_sw[4]|l_sw[5]|l_sw[6]|l_sw[7]|l_sw[8]|l_sw[9]|out|pad|padres|vc|vcp|vdd|vddr|vip|vss|z
+ A2|B|B1|Y B1|Y
+ BOTTOM|TOP|VGND|VSS|anode|cathode|core|h_sw[0]|h_sw[10]|h_sw[1]|h_sw[2]|h_sw[3]|h_sw[4]|h_sw[5]|h_sw[6]|h_sw[7]|h_sw[8]|h_sw[9]|l_sw[0]|l_sw[10]|l_sw[1]|l_sw[2]|l_sw[3]|l_sw[4]|l_sw[5]|l_sw[6]|l_sw[7]|l_sw[8]|l_sw[9]|out|pad|padres|vc|vcp|vdd|vddr|vip|vss|z
+ sg13_lv_nmos L=0.13u W=0.74u AS=0.2516p AD=0.1406p PS=2.16u PD=1.12u rfmode=0
M$290 B1|Y A1|D|Q \$69179
+ BOTTOM|TOP|VGND|VSS|anode|cathode|core|h_sw[0]|h_sw[10]|h_sw[1]|h_sw[2]|h_sw[3]|h_sw[4]|h_sw[5]|h_sw[6]|h_sw[7]|h_sw[8]|h_sw[9]|l_sw[0]|l_sw[10]|l_sw[1]|l_sw[2]|l_sw[3]|l_sw[4]|l_sw[5]|l_sw[6]|l_sw[7]|l_sw[8]|l_sw[9]|out|pad|padres|vc|vcp|vdd|vddr|vip|vss|z
+ sg13_lv_nmos L=0.13u W=0.74u AS=0.1406p AD=0.1406p PS=1.12u PD=1.12u rfmode=0
M$291 \$69179 A2|B1|Y
+ BOTTOM|TOP|VGND|VSS|anode|cathode|core|h_sw[0]|h_sw[10]|h_sw[1]|h_sw[2]|h_sw[3]|h_sw[4]|h_sw[5]|h_sw[6]|h_sw[7]|h_sw[8]|h_sw[9]|l_sw[0]|l_sw[10]|l_sw[1]|l_sw[2]|l_sw[3]|l_sw[4]|l_sw[5]|l_sw[6]|l_sw[7]|l_sw[8]|l_sw[9]|out|pad|padres|vc|vcp|vdd|vddr|vip|vss|z
+ BOTTOM|TOP|VGND|VSS|anode|cathode|core|h_sw[0]|h_sw[10]|h_sw[1]|h_sw[2]|h_sw[3]|h_sw[4]|h_sw[5]|h_sw[6]|h_sw[7]|h_sw[8]|h_sw[9]|l_sw[0]|l_sw[10]|l_sw[1]|l_sw[2]|l_sw[3]|l_sw[4]|l_sw[5]|l_sw[6]|l_sw[7]|l_sw[8]|l_sw[9]|out|pad|padres|vc|vcp|vdd|vddr|vip|vss|z
+ sg13_lv_nmos L=0.13u W=0.74u AS=0.1406p AD=0.2516p PS=1.12u PD=2.16u rfmode=0
M$292
+ BOTTOM|TOP|VGND|VSS|anode|cathode|core|h_sw[0]|h_sw[10]|h_sw[1]|h_sw[2]|h_sw[3]|h_sw[4]|h_sw[5]|h_sw[6]|h_sw[7]|h_sw[8]|h_sw[9]|l_sw[0]|l_sw[10]|l_sw[1]|l_sw[2]|l_sw[3]|l_sw[4]|l_sw[5]|l_sw[6]|l_sw[7]|l_sw[8]|l_sw[9]|out|pad|padres|vc|vcp|vdd|vddr|vip|vss|z
+ RESET_B|Y \$69119
+ BOTTOM|TOP|VGND|VSS|anode|cathode|core|h_sw[0]|h_sw[10]|h_sw[1]|h_sw[2]|h_sw[3]|h_sw[4]|h_sw[5]|h_sw[6]|h_sw[7]|h_sw[8]|h_sw[9]|l_sw[0]|l_sw[10]|l_sw[1]|l_sw[2]|l_sw[3]|l_sw[4]|l_sw[5]|l_sw[6]|l_sw[7]|l_sw[8]|l_sw[9]|out|pad|padres|vc|vcp|vdd|vddr|vip|vss|z
+ sg13_lv_nmos L=0.13u W=0.42u AS=0.1701p AD=0.0378p PS=1.65u PD=0.6u rfmode=0
M$293 \$69119 \$69041 \$69040
+ BOTTOM|TOP|VGND|VSS|anode|cathode|core|h_sw[0]|h_sw[10]|h_sw[1]|h_sw[2]|h_sw[3]|h_sw[4]|h_sw[5]|h_sw[6]|h_sw[7]|h_sw[8]|h_sw[9]|l_sw[0]|l_sw[10]|l_sw[1]|l_sw[2]|l_sw[3]|l_sw[4]|l_sw[5]|l_sw[6]|l_sw[7]|l_sw[8]|l_sw[9]|out|pad|padres|vc|vcp|vdd|vddr|vip|vss|z
+ sg13_lv_nmos L=0.13u W=0.42u AS=0.0378p AD=0.1428p PS=0.6u PD=1.52u rfmode=0
M$294 \$69039 \$69042 \$69204
+ BOTTOM|TOP|VGND|VSS|anode|cathode|core|h_sw[0]|h_sw[10]|h_sw[1]|h_sw[2]|h_sw[3]|h_sw[4]|h_sw[5]|h_sw[6]|h_sw[7]|h_sw[8]|h_sw[9]|l_sw[0]|l_sw[10]|l_sw[1]|l_sw[2]|l_sw[3]|l_sw[4]|l_sw[5]|l_sw[6]|l_sw[7]|l_sw[8]|l_sw[9]|out|pad|padres|vc|vcp|vdd|vddr|vip|vss|z
+ sg13_lv_nmos L=0.13u W=0.42u AS=0.1296p AD=0.0798p PS=1.52u PD=0.8u rfmode=0
M$295 \$69204 \$69205 \$69040
+ BOTTOM|TOP|VGND|VSS|anode|cathode|core|h_sw[0]|h_sw[10]|h_sw[1]|h_sw[2]|h_sw[3]|h_sw[4]|h_sw[5]|h_sw[6]|h_sw[7]|h_sw[8]|h_sw[9]|l_sw[0]|l_sw[10]|l_sw[1]|l_sw[2]|l_sw[3]|l_sw[4]|l_sw[5]|l_sw[6]|l_sw[7]|l_sw[8]|l_sw[9]|out|pad|padres|vc|vcp|vdd|vddr|vip|vss|z
+ sg13_lv_nmos L=0.13u W=0.42u AS=0.0798p AD=0.2373p PS=0.8u PD=1.97u rfmode=0
M$296
+ BOTTOM|TOP|VGND|VSS|anode|cathode|core|h_sw[0]|h_sw[10]|h_sw[1]|h_sw[2]|h_sw[3]|h_sw[4]|h_sw[5]|h_sw[6]|h_sw[7]|h_sw[8]|h_sw[9]|l_sw[0]|l_sw[10]|l_sw[1]|l_sw[2]|l_sw[3]|l_sw[4]|l_sw[5]|l_sw[6]|l_sw[7]|l_sw[8]|l_sw[9]|out|pad|padres|vc|vcp|vdd|vddr|vip|vss|z
+ \$69042 \$69205
+ BOTTOM|TOP|VGND|VSS|anode|cathode|core|h_sw[0]|h_sw[10]|h_sw[1]|h_sw[2]|h_sw[3]|h_sw[4]|h_sw[5]|h_sw[6]|h_sw[7]|h_sw[8]|h_sw[9]|l_sw[0]|l_sw[10]|l_sw[1]|l_sw[2]|l_sw[3]|l_sw[4]|l_sw[5]|l_sw[6]|l_sw[7]|l_sw[8]|l_sw[9]|out|pad|padres|vc|vcp|vdd|vddr|vip|vss|z
+ sg13_lv_nmos L=0.13u W=0.74u AS=0.317325p AD=0.2516p PS=1.805u PD=2.16u
+ rfmode=0
M$297
+ BOTTOM|TOP|VGND|VSS|anode|cathode|core|h_sw[0]|h_sw[10]|h_sw[1]|h_sw[2]|h_sw[3]|h_sw[4]|h_sw[5]|h_sw[6]|h_sw[7]|h_sw[8]|h_sw[9]|l_sw[0]|l_sw[10]|l_sw[1]|l_sw[2]|l_sw[3]|l_sw[4]|l_sw[5]|l_sw[6]|l_sw[7]|l_sw[8]|l_sw[9]|out|pad|padres|vc|vcp|vdd|vddr|vip|vss|z
+ CLK|Y \$69042
+ BOTTOM|TOP|VGND|VSS|anode|cathode|core|h_sw[0]|h_sw[10]|h_sw[1]|h_sw[2]|h_sw[3]|h_sw[4]|h_sw[5]|h_sw[6]|h_sw[7]|h_sw[8]|h_sw[9]|l_sw[0]|l_sw[10]|l_sw[1]|l_sw[2]|l_sw[3]|l_sw[4]|l_sw[5]|l_sw[6]|l_sw[7]|l_sw[8]|l_sw[9]|out|pad|padres|vc|vcp|vdd|vddr|vip|vss|z
+ sg13_lv_nmos L=0.13u W=0.74u AS=0.317325p AD=0.2516p PS=1.805u PD=2.16u
+ rfmode=0
M$298 \$69102 \$69042 \$69043
+ BOTTOM|TOP|VGND|VSS|anode|cathode|core|h_sw[0]|h_sw[10]|h_sw[1]|h_sw[2]|h_sw[3]|h_sw[4]|h_sw[5]|h_sw[6]|h_sw[7]|h_sw[8]|h_sw[9]|l_sw[0]|l_sw[10]|l_sw[1]|l_sw[2]|l_sw[3]|l_sw[4]|l_sw[5]|l_sw[6]|l_sw[7]|l_sw[8]|l_sw[9]|out|pad|padres|vc|vcp|vdd|vddr|vip|vss|z
+ sg13_lv_nmos L=0.13u W=0.42u AS=0.12665p AD=0.1428p PS=1.145u PD=1.52u
+ rfmode=0
M$299 \$69041 \$69205 \$69102
+ BOTTOM|TOP|VGND|VSS|anode|cathode|core|h_sw[0]|h_sw[10]|h_sw[1]|h_sw[2]|h_sw[3]|h_sw[4]|h_sw[5]|h_sw[6]|h_sw[7]|h_sw[8]|h_sw[9]|l_sw[0]|l_sw[10]|l_sw[1]|l_sw[2]|l_sw[3]|l_sw[4]|l_sw[5]|l_sw[6]|l_sw[7]|l_sw[8]|l_sw[9]|out|pad|padres|vc|vcp|vdd|vddr|vip|vss|z
+ sg13_lv_nmos L=0.13u W=0.74u AS=0.3473p AD=0.12665p PS=2.71u PD=1.145u
+ rfmode=0
M$300 A2|B|B1|Y \$69106 \$69122
+ BOTTOM|TOP|VGND|VSS|anode|cathode|core|h_sw[0]|h_sw[10]|h_sw[1]|h_sw[2]|h_sw[3]|h_sw[4]|h_sw[5]|h_sw[6]|h_sw[7]|h_sw[8]|h_sw[9]|l_sw[0]|l_sw[10]|l_sw[1]|l_sw[2]|l_sw[3]|l_sw[4]|l_sw[5]|l_sw[6]|l_sw[7]|l_sw[8]|l_sw[9]|out|pad|padres|vc|vcp|vdd|vddr|vip|vss|z
+ sg13_lv_nmos L=0.13u W=0.74u AS=0.333p AD=0.1406p PS=2.38u PD=1.12u rfmode=0
M$301 \$69122 A|B|B_N|Q
+ BOTTOM|TOP|VGND|VSS|anode|cathode|core|h_sw[0]|h_sw[10]|h_sw[1]|h_sw[2]|h_sw[3]|h_sw[4]|h_sw[5]|h_sw[6]|h_sw[7]|h_sw[8]|h_sw[9]|l_sw[0]|l_sw[10]|l_sw[1]|l_sw[2]|l_sw[3]|l_sw[4]|l_sw[5]|l_sw[6]|l_sw[7]|l_sw[8]|l_sw[9]|out|pad|padres|vc|vcp|vdd|vddr|vip|vss|z
+ BOTTOM|TOP|VGND|VSS|anode|cathode|core|h_sw[0]|h_sw[10]|h_sw[1]|h_sw[2]|h_sw[3]|h_sw[4]|h_sw[5]|h_sw[6]|h_sw[7]|h_sw[8]|h_sw[9]|l_sw[0]|l_sw[10]|l_sw[1]|l_sw[2]|l_sw[3]|l_sw[4]|l_sw[5]|l_sw[6]|l_sw[7]|l_sw[8]|l_sw[9]|out|pad|padres|vc|vcp|vdd|vddr|vip|vss|z
+ sg13_lv_nmos L=0.13u W=0.74u AS=0.1406p AD=0.14505p PS=1.12u PD=1.15u rfmode=0
M$302
+ BOTTOM|TOP|VGND|VSS|anode|cathode|core|h_sw[0]|h_sw[10]|h_sw[1]|h_sw[2]|h_sw[3]|h_sw[4]|h_sw[5]|h_sw[6]|h_sw[7]|h_sw[8]|h_sw[9]|l_sw[0]|l_sw[10]|l_sw[1]|l_sw[2]|l_sw[3]|l_sw[4]|l_sw[5]|l_sw[6]|l_sw[7]|l_sw[8]|l_sw[9]|out|pad|padres|vc|vcp|vdd|vddr|vip|vss|z
+ A|A_N|B|B_N|Q \$69106
+ BOTTOM|TOP|VGND|VSS|anode|cathode|core|h_sw[0]|h_sw[10]|h_sw[1]|h_sw[2]|h_sw[3]|h_sw[4]|h_sw[5]|h_sw[6]|h_sw[7]|h_sw[8]|h_sw[9]|l_sw[0]|l_sw[10]|l_sw[1]|l_sw[2]|l_sw[3]|l_sw[4]|l_sw[5]|l_sw[6]|l_sw[7]|l_sw[8]|l_sw[9]|out|pad|padres|vc|vcp|vdd|vddr|vip|vss|z
+ sg13_lv_nmos L=0.13u W=0.55u AS=0.14505p AD=0.187p PS=1.15u PD=1.78u rfmode=0
M$303
+ BOTTOM|TOP|VGND|VSS|anode|cathode|core|h_sw[0]|h_sw[10]|h_sw[1]|h_sw[2]|h_sw[3]|h_sw[4]|h_sw[5]|h_sw[6]|h_sw[7]|h_sw[8]|h_sw[9]|l_sw[0]|l_sw[10]|l_sw[1]|l_sw[2]|l_sw[3]|l_sw[4]|l_sw[5]|l_sw[6]|l_sw[7]|l_sw[8]|l_sw[9]|out|pad|padres|vc|vcp|vdd|vddr|vip|vss|z
+ RESET_B|Y \$69118
+ BOTTOM|TOP|VGND|VSS|anode|cathode|core|h_sw[0]|h_sw[10]|h_sw[1]|h_sw[2]|h_sw[3]|h_sw[4]|h_sw[5]|h_sw[6]|h_sw[7]|h_sw[8]|h_sw[9]|l_sw[0]|l_sw[10]|l_sw[1]|l_sw[2]|l_sw[3]|l_sw[4]|l_sw[5]|l_sw[6]|l_sw[7]|l_sw[8]|l_sw[9]|out|pad|padres|vc|vcp|vdd|vddr|vip|vss|z
+ sg13_lv_nmos L=0.13u W=0.42u AS=0.1701p AD=0.0378p PS=1.65u PD=0.6u rfmode=0
M$304 \$69118 \$69053 \$69052
+ BOTTOM|TOP|VGND|VSS|anode|cathode|core|h_sw[0]|h_sw[10]|h_sw[1]|h_sw[2]|h_sw[3]|h_sw[4]|h_sw[5]|h_sw[6]|h_sw[7]|h_sw[8]|h_sw[9]|l_sw[0]|l_sw[10]|l_sw[1]|l_sw[2]|l_sw[3]|l_sw[4]|l_sw[5]|l_sw[6]|l_sw[7]|l_sw[8]|l_sw[9]|out|pad|padres|vc|vcp|vdd|vddr|vip|vss|z
+ sg13_lv_nmos L=0.13u W=0.42u AS=0.0378p AD=0.1428p PS=0.6u PD=1.52u rfmode=0
M$305 \$69051 \$69054 \$69211
+ BOTTOM|TOP|VGND|VSS|anode|cathode|core|h_sw[0]|h_sw[10]|h_sw[1]|h_sw[2]|h_sw[3]|h_sw[4]|h_sw[5]|h_sw[6]|h_sw[7]|h_sw[8]|h_sw[9]|l_sw[0]|l_sw[10]|l_sw[1]|l_sw[2]|l_sw[3]|l_sw[4]|l_sw[5]|l_sw[6]|l_sw[7]|l_sw[8]|l_sw[9]|out|pad|padres|vc|vcp|vdd|vddr|vip|vss|z
+ sg13_lv_nmos L=0.13u W=0.42u AS=0.1296p AD=0.0798p PS=1.52u PD=0.8u rfmode=0
M$306 \$69211 \$69212 \$69052
+ BOTTOM|TOP|VGND|VSS|anode|cathode|core|h_sw[0]|h_sw[10]|h_sw[1]|h_sw[2]|h_sw[3]|h_sw[4]|h_sw[5]|h_sw[6]|h_sw[7]|h_sw[8]|h_sw[9]|l_sw[0]|l_sw[10]|l_sw[1]|l_sw[2]|l_sw[3]|l_sw[4]|l_sw[5]|l_sw[6]|l_sw[7]|l_sw[8]|l_sw[9]|out|pad|padres|vc|vcp|vdd|vddr|vip|vss|z
+ sg13_lv_nmos L=0.13u W=0.42u AS=0.0798p AD=0.2373p PS=0.8u PD=1.97u rfmode=0
M$307
+ BOTTOM|TOP|VGND|VSS|anode|cathode|core|h_sw[0]|h_sw[10]|h_sw[1]|h_sw[2]|h_sw[3]|h_sw[4]|h_sw[5]|h_sw[6]|h_sw[7]|h_sw[8]|h_sw[9]|l_sw[0]|l_sw[10]|l_sw[1]|l_sw[2]|l_sw[3]|l_sw[4]|l_sw[5]|l_sw[6]|l_sw[7]|l_sw[8]|l_sw[9]|out|pad|padres|vc|vcp|vdd|vddr|vip|vss|z
+ \$69054 \$69212
+ BOTTOM|TOP|VGND|VSS|anode|cathode|core|h_sw[0]|h_sw[10]|h_sw[1]|h_sw[2]|h_sw[3]|h_sw[4]|h_sw[5]|h_sw[6]|h_sw[7]|h_sw[8]|h_sw[9]|l_sw[0]|l_sw[10]|l_sw[1]|l_sw[2]|l_sw[3]|l_sw[4]|l_sw[5]|l_sw[6]|l_sw[7]|l_sw[8]|l_sw[9]|out|pad|padres|vc|vcp|vdd|vddr|vip|vss|z
+ sg13_lv_nmos L=0.13u W=0.74u AS=0.317325p AD=0.2516p PS=1.805u PD=2.16u
+ rfmode=0
M$308
+ BOTTOM|TOP|VGND|VSS|anode|cathode|core|h_sw[0]|h_sw[10]|h_sw[1]|h_sw[2]|h_sw[3]|h_sw[4]|h_sw[5]|h_sw[6]|h_sw[7]|h_sw[8]|h_sw[9]|l_sw[0]|l_sw[10]|l_sw[1]|l_sw[2]|l_sw[3]|l_sw[4]|l_sw[5]|l_sw[6]|l_sw[7]|l_sw[8]|l_sw[9]|out|pad|padres|vc|vcp|vdd|vddr|vip|vss|z
+ CLK|Y \$69054
+ BOTTOM|TOP|VGND|VSS|anode|cathode|core|h_sw[0]|h_sw[10]|h_sw[1]|h_sw[2]|h_sw[3]|h_sw[4]|h_sw[5]|h_sw[6]|h_sw[7]|h_sw[8]|h_sw[9]|l_sw[0]|l_sw[10]|l_sw[1]|l_sw[2]|l_sw[3]|l_sw[4]|l_sw[5]|l_sw[6]|l_sw[7]|l_sw[8]|l_sw[9]|out|pad|padres|vc|vcp|vdd|vddr|vip|vss|z
+ sg13_lv_nmos L=0.13u W=0.74u AS=0.317325p AD=0.2516p PS=1.805u PD=2.16u
+ rfmode=0
M$309 \$69110 \$69054 \$69055
+ BOTTOM|TOP|VGND|VSS|anode|cathode|core|h_sw[0]|h_sw[10]|h_sw[1]|h_sw[2]|h_sw[3]|h_sw[4]|h_sw[5]|h_sw[6]|h_sw[7]|h_sw[8]|h_sw[9]|l_sw[0]|l_sw[10]|l_sw[1]|l_sw[2]|l_sw[3]|l_sw[4]|l_sw[5]|l_sw[6]|l_sw[7]|l_sw[8]|l_sw[9]|out|pad|padres|vc|vcp|vdd|vddr|vip|vss|z
+ sg13_lv_nmos L=0.13u W=0.42u AS=0.12665p AD=0.1428p PS=1.145u PD=1.52u
+ rfmode=0
M$310 \$69053 \$69212 \$69110
+ BOTTOM|TOP|VGND|VSS|anode|cathode|core|h_sw[0]|h_sw[10]|h_sw[1]|h_sw[2]|h_sw[3]|h_sw[4]|h_sw[5]|h_sw[6]|h_sw[7]|h_sw[8]|h_sw[9]|l_sw[0]|l_sw[10]|l_sw[1]|l_sw[2]|l_sw[3]|l_sw[4]|l_sw[5]|l_sw[6]|l_sw[7]|l_sw[8]|l_sw[9]|out|pad|padres|vc|vcp|vdd|vddr|vip|vss|z
+ sg13_lv_nmos L=0.13u W=0.74u AS=0.3473p AD=0.12665p PS=2.71u PD=1.145u
+ rfmode=0
M$311 A|Y$11 A|X$39
+ BOTTOM|TOP|VGND|VSS|anode|cathode|core|h_sw[0]|h_sw[10]|h_sw[1]|h_sw[2]|h_sw[3]|h_sw[4]|h_sw[5]|h_sw[6]|h_sw[7]|h_sw[8]|h_sw[9]|l_sw[0]|l_sw[10]|l_sw[1]|l_sw[2]|l_sw[3]|l_sw[4]|l_sw[5]|l_sw[6]|l_sw[7]|l_sw[8]|l_sw[9]|out|pad|padres|vc|vcp|vdd|vddr|vip|vss|z
+ BOTTOM|TOP|VGND|VSS|anode|cathode|core|h_sw[0]|h_sw[10]|h_sw[1]|h_sw[2]|h_sw[3]|h_sw[4]|h_sw[5]|h_sw[6]|h_sw[7]|h_sw[8]|h_sw[9]|l_sw[0]|l_sw[10]|l_sw[1]|l_sw[2]|l_sw[3]|l_sw[4]|l_sw[5]|l_sw[6]|l_sw[7]|l_sw[8]|l_sw[9]|out|pad|padres|vc|vcp|vdd|vddr|vip|vss|z
+ sg13_lv_nmos L=0.13u W=0.74u AS=0.2516p AD=0.2516p PS=2.16u PD=2.16u rfmode=0
M$312
+ BOTTOM|TOP|VGND|VSS|anode|cathode|core|h_sw[0]|h_sw[10]|h_sw[1]|h_sw[2]|h_sw[3]|h_sw[4]|h_sw[5]|h_sw[6]|h_sw[7]|h_sw[8]|h_sw[9]|l_sw[0]|l_sw[10]|l_sw[1]|l_sw[2]|l_sw[3]|l_sw[4]|l_sw[5]|l_sw[6]|l_sw[7]|l_sw[8]|l_sw[9]|out|pad|padres|vc|vcp|vdd|vddr|vip|vss|z
+ A|Y$14 A|Y$12
+ BOTTOM|TOP|VGND|VSS|anode|cathode|core|h_sw[0]|h_sw[10]|h_sw[1]|h_sw[2]|h_sw[3]|h_sw[4]|h_sw[5]|h_sw[6]|h_sw[7]|h_sw[8]|h_sw[9]|l_sw[0]|l_sw[10]|l_sw[1]|l_sw[2]|l_sw[3]|l_sw[4]|l_sw[5]|l_sw[6]|l_sw[7]|l_sw[8]|l_sw[9]|out|pad|padres|vc|vcp|vdd|vddr|vip|vss|z
+ sg13_lv_nmos L=0.13u W=0.74u AS=0.2516p AD=0.2516p PS=2.16u PD=2.16u rfmode=0
M$313 A|Y$1 A|X$33
+ BOTTOM|TOP|VGND|VSS|anode|cathode|core|h_sw[0]|h_sw[10]|h_sw[1]|h_sw[2]|h_sw[3]|h_sw[4]|h_sw[5]|h_sw[6]|h_sw[7]|h_sw[8]|h_sw[9]|l_sw[0]|l_sw[10]|l_sw[1]|l_sw[2]|l_sw[3]|l_sw[4]|l_sw[5]|l_sw[6]|l_sw[7]|l_sw[8]|l_sw[9]|out|pad|padres|vc|vcp|vdd|vddr|vip|vss|z
+ BOTTOM|TOP|VGND|VSS|anode|cathode|core|h_sw[0]|h_sw[10]|h_sw[1]|h_sw[2]|h_sw[3]|h_sw[4]|h_sw[5]|h_sw[6]|h_sw[7]|h_sw[8]|h_sw[9]|l_sw[0]|l_sw[10]|l_sw[1]|l_sw[2]|l_sw[3]|l_sw[4]|l_sw[5]|l_sw[6]|l_sw[7]|l_sw[8]|l_sw[9]|out|pad|padres|vc|vcp|vdd|vddr|vip|vss|z
+ sg13_lv_nmos L=0.13u W=0.74u AS=0.2516p AD=0.2516p PS=2.16u PD=2.16u rfmode=0
M$314 A|Y$2 A|X$34
+ BOTTOM|TOP|VGND|VSS|anode|cathode|core|h_sw[0]|h_sw[10]|h_sw[1]|h_sw[2]|h_sw[3]|h_sw[4]|h_sw[5]|h_sw[6]|h_sw[7]|h_sw[8]|h_sw[9]|l_sw[0]|l_sw[10]|l_sw[1]|l_sw[2]|l_sw[3]|l_sw[4]|l_sw[5]|l_sw[6]|l_sw[7]|l_sw[8]|l_sw[9]|out|pad|padres|vc|vcp|vdd|vddr|vip|vss|z
+ BOTTOM|TOP|VGND|VSS|anode|cathode|core|h_sw[0]|h_sw[10]|h_sw[1]|h_sw[2]|h_sw[3]|h_sw[4]|h_sw[5]|h_sw[6]|h_sw[7]|h_sw[8]|h_sw[9]|l_sw[0]|l_sw[10]|l_sw[1]|l_sw[2]|l_sw[3]|l_sw[4]|l_sw[5]|l_sw[6]|l_sw[7]|l_sw[8]|l_sw[9]|out|pad|padres|vc|vcp|vdd|vddr|vip|vss|z
+ sg13_lv_nmos L=0.13u W=0.74u AS=0.2516p AD=0.2516p PS=2.16u PD=2.16u rfmode=0
M$315 \$69574 D|Q_N$1
+ BOTTOM|TOP|VGND|VSS|anode|cathode|core|h_sw[0]|h_sw[10]|h_sw[1]|h_sw[2]|h_sw[3]|h_sw[4]|h_sw[5]|h_sw[6]|h_sw[7]|h_sw[8]|h_sw[9]|l_sw[0]|l_sw[10]|l_sw[1]|l_sw[2]|l_sw[3]|l_sw[4]|l_sw[5]|l_sw[6]|l_sw[7]|l_sw[8]|l_sw[9]|out|pad|padres|vc|vcp|vdd|vddr|vip|vss|z
+ BOTTOM|TOP|VGND|VSS|anode|cathode|core|h_sw[0]|h_sw[10]|h_sw[1]|h_sw[2]|h_sw[3]|h_sw[4]|h_sw[5]|h_sw[6]|h_sw[7]|h_sw[8]|h_sw[9]|l_sw[0]|l_sw[10]|l_sw[1]|l_sw[2]|l_sw[3]|l_sw[4]|l_sw[5]|l_sw[6]|l_sw[7]|l_sw[8]|l_sw[9]|out|pad|padres|vc|vcp|vdd|vddr|vip|vss|z
+ sg13_lv_nmos L=0.13u W=0.55u AS=0.187p AD=0.15055p PS=1.78u PD=1.17u rfmode=0
M$316
+ BOTTOM|TOP|VGND|VSS|anode|cathode|core|h_sw[0]|h_sw[10]|h_sw[1]|h_sw[2]|h_sw[3]|h_sw[4]|h_sw[5]|h_sw[6]|h_sw[7]|h_sw[8]|h_sw[9]|l_sw[0]|l_sw[10]|l_sw[1]|l_sw[2]|l_sw[3]|l_sw[4]|l_sw[5]|l_sw[6]|l_sw[7]|l_sw[8]|l_sw[9]|out|pad|padres|vc|vcp|vdd|vddr|vip|vss|z
+ CLK|D|GATE|Q \$69615
+ BOTTOM|TOP|VGND|VSS|anode|cathode|core|h_sw[0]|h_sw[10]|h_sw[1]|h_sw[2]|h_sw[3]|h_sw[4]|h_sw[5]|h_sw[6]|h_sw[7]|h_sw[8]|h_sw[9]|l_sw[0]|l_sw[10]|l_sw[1]|l_sw[2]|l_sw[3]|l_sw[4]|l_sw[5]|l_sw[6]|l_sw[7]|l_sw[8]|l_sw[9]|out|pad|padres|vc|vcp|vdd|vddr|vip|vss|z
+ sg13_lv_nmos L=0.13u W=0.74u AS=0.15055p AD=0.2516p PS=1.17u PD=2.16u rfmode=0
M$317 \$69575 \$69615 \$70133
+ BOTTOM|TOP|VGND|VSS|anode|cathode|core|h_sw[0]|h_sw[10]|h_sw[1]|h_sw[2]|h_sw[3]|h_sw[4]|h_sw[5]|h_sw[6]|h_sw[7]|h_sw[8]|h_sw[9]|l_sw[0]|l_sw[10]|l_sw[1]|l_sw[2]|l_sw[3]|l_sw[4]|l_sw[5]|l_sw[6]|l_sw[7]|l_sw[8]|l_sw[9]|out|pad|padres|vc|vcp|vdd|vddr|vip|vss|z
+ sg13_lv_nmos L=0.13u W=0.42u AS=0.141p AD=0.04725p PS=1.17u PD=0.645u rfmode=0
M$318 \$70133 \$69576
+ BOTTOM|TOP|VGND|VSS|anode|cathode|core|h_sw[0]|h_sw[10]|h_sw[1]|h_sw[2]|h_sw[3]|h_sw[4]|h_sw[5]|h_sw[6]|h_sw[7]|h_sw[8]|h_sw[9]|l_sw[0]|l_sw[10]|l_sw[1]|l_sw[2]|l_sw[3]|l_sw[4]|l_sw[5]|l_sw[6]|l_sw[7]|l_sw[8]|l_sw[9]|out|pad|padres|vc|vcp|vdd|vddr|vip|vss|z
+ BOTTOM|TOP|VGND|VSS|anode|cathode|core|h_sw[0]|h_sw[10]|h_sw[1]|h_sw[2]|h_sw[3]|h_sw[4]|h_sw[5]|h_sw[6]|h_sw[7]|h_sw[8]|h_sw[9]|l_sw[0]|l_sw[10]|l_sw[1]|l_sw[2]|l_sw[3]|l_sw[4]|l_sw[5]|l_sw[6]|l_sw[7]|l_sw[8]|l_sw[9]|out|pad|padres|vc|vcp|vdd|vddr|vip|vss|z
+ sg13_lv_nmos L=0.13u W=0.42u AS=0.04725p AD=0.1428p PS=0.645u PD=1.52u
+ rfmode=0
M$319 \$69616 \$69615
+ BOTTOM|TOP|VGND|VSS|anode|cathode|core|h_sw[0]|h_sw[10]|h_sw[1]|h_sw[2]|h_sw[3]|h_sw[4]|h_sw[5]|h_sw[6]|h_sw[7]|h_sw[8]|h_sw[9]|l_sw[0]|l_sw[10]|l_sw[1]|l_sw[2]|l_sw[3]|l_sw[4]|l_sw[5]|l_sw[6]|l_sw[7]|l_sw[8]|l_sw[9]|out|pad|padres|vc|vcp|vdd|vddr|vip|vss|z
+ BOTTOM|TOP|VGND|VSS|anode|cathode|core|h_sw[0]|h_sw[10]|h_sw[1]|h_sw[2]|h_sw[3]|h_sw[4]|h_sw[5]|h_sw[6]|h_sw[7]|h_sw[8]|h_sw[9]|l_sw[0]|l_sw[10]|l_sw[1]|l_sw[2]|l_sw[3]|l_sw[4]|l_sw[5]|l_sw[6]|l_sw[7]|l_sw[8]|l_sw[9]|out|pad|padres|vc|vcp|vdd|vddr|vip|vss|z
+ sg13_lv_nmos L=0.13u W=0.74u AS=0.2775p AD=0.213425p PS=2.23u PD=1.62u
+ rfmode=0
M$320
+ BOTTOM|TOP|VGND|VSS|anode|cathode|core|h_sw[0]|h_sw[10]|h_sw[1]|h_sw[2]|h_sw[3]|h_sw[4]|h_sw[5]|h_sw[6]|h_sw[7]|h_sw[8]|h_sw[9]|l_sw[0]|l_sw[10]|l_sw[1]|l_sw[2]|l_sw[3]|l_sw[4]|l_sw[5]|l_sw[6]|l_sw[7]|l_sw[8]|l_sw[9]|out|pad|padres|vc|vcp|vdd|vddr|vip|vss|z
+ \$69574 \$70131
+ BOTTOM|TOP|VGND|VSS|anode|cathode|core|h_sw[0]|h_sw[10]|h_sw[1]|h_sw[2]|h_sw[3]|h_sw[4]|h_sw[5]|h_sw[6]|h_sw[7]|h_sw[8]|h_sw[9]|l_sw[0]|l_sw[10]|l_sw[1]|l_sw[2]|l_sw[3]|l_sw[4]|l_sw[5]|l_sw[6]|l_sw[7]|l_sw[8]|l_sw[9]|out|pad|padres|vc|vcp|vdd|vddr|vip|vss|z
+ sg13_lv_nmos L=0.13u W=0.64u AS=0.213425p AD=0.072p PS=1.62u PD=0.865u
+ rfmode=0
M$321 \$70131 \$69616 \$69575
+ BOTTOM|TOP|VGND|VSS|anode|cathode|core|h_sw[0]|h_sw[10]|h_sw[1]|h_sw[2]|h_sw[3]|h_sw[4]|h_sw[5]|h_sw[6]|h_sw[7]|h_sw[8]|h_sw[9]|l_sw[0]|l_sw[10]|l_sw[1]|l_sw[2]|l_sw[3]|l_sw[4]|l_sw[5]|l_sw[6]|l_sw[7]|l_sw[8]|l_sw[9]|out|pad|padres|vc|vcp|vdd|vddr|vip|vss|z
+ sg13_lv_nmos L=0.13u W=0.64u AS=0.072p AD=0.141p PS=0.865u PD=1.17u rfmode=0
M$322 \$69507 \$69617 \$69581
+ BOTTOM|TOP|VGND|VSS|anode|cathode|core|h_sw[0]|h_sw[10]|h_sw[1]|h_sw[2]|h_sw[3]|h_sw[4]|h_sw[5]|h_sw[6]|h_sw[7]|h_sw[8]|h_sw[9]|l_sw[0]|l_sw[10]|l_sw[1]|l_sw[2]|l_sw[3]|l_sw[4]|l_sw[5]|l_sw[6]|l_sw[7]|l_sw[8]|l_sw[9]|out|pad|padres|vc|vcp|vdd|vddr|vip|vss|z
+ sg13_lv_nmos L=0.13u W=0.42u AS=0.1296p AD=0.0798p PS=1.52u PD=0.8u rfmode=0
M$323 \$69581 \$69582 \$70003
+ BOTTOM|TOP|VGND|VSS|anode|cathode|core|h_sw[0]|h_sw[10]|h_sw[1]|h_sw[2]|h_sw[3]|h_sw[4]|h_sw[5]|h_sw[6]|h_sw[7]|h_sw[8]|h_sw[9]|l_sw[0]|l_sw[10]|l_sw[1]|l_sw[2]|l_sw[3]|l_sw[4]|l_sw[5]|l_sw[6]|l_sw[7]|l_sw[8]|l_sw[9]|out|pad|padres|vc|vcp|vdd|vddr|vip|vss|z
+ sg13_lv_nmos L=0.13u W=0.42u AS=0.0798p AD=0.2373p PS=0.8u PD=1.97u rfmode=0
M$324 \$69582 \$69617
+ BOTTOM|TOP|VGND|VSS|anode|cathode|core|h_sw[0]|h_sw[10]|h_sw[1]|h_sw[2]|h_sw[3]|h_sw[4]|h_sw[5]|h_sw[6]|h_sw[7]|h_sw[8]|h_sw[9]|l_sw[0]|l_sw[10]|l_sw[1]|l_sw[2]|l_sw[3]|l_sw[4]|l_sw[5]|l_sw[6]|l_sw[7]|l_sw[8]|l_sw[9]|out|pad|padres|vc|vcp|vdd|vddr|vip|vss|z
+ BOTTOM|TOP|VGND|VSS|anode|cathode|core|h_sw[0]|h_sw[10]|h_sw[1]|h_sw[2]|h_sw[3]|h_sw[4]|h_sw[5]|h_sw[6]|h_sw[7]|h_sw[8]|h_sw[9]|l_sw[0]|l_sw[10]|l_sw[1]|l_sw[2]|l_sw[3]|l_sw[4]|l_sw[5]|l_sw[6]|l_sw[7]|l_sw[8]|l_sw[9]|out|pad|padres|vc|vcp|vdd|vddr|vip|vss|z
+ sg13_lv_nmos L=0.13u W=0.74u AS=0.2516p AD=0.317325p PS=2.16u PD=1.805u
+ rfmode=0
M$325
+ BOTTOM|TOP|VGND|VSS|anode|cathode|core|h_sw[0]|h_sw[10]|h_sw[1]|h_sw[2]|h_sw[3]|h_sw[4]|h_sw[5]|h_sw[6]|h_sw[7]|h_sw[8]|h_sw[9]|l_sw[0]|l_sw[10]|l_sw[1]|l_sw[2]|l_sw[3]|l_sw[4]|l_sw[5]|l_sw[6]|l_sw[7]|l_sw[8]|l_sw[9]|out|pad|padres|vc|vcp|vdd|vddr|vip|vss|z
+ CLK|D|GATE|Q$1 \$69617
+ BOTTOM|TOP|VGND|VSS|anode|cathode|core|h_sw[0]|h_sw[10]|h_sw[1]|h_sw[2]|h_sw[3]|h_sw[4]|h_sw[5]|h_sw[6]|h_sw[7]|h_sw[8]|h_sw[9]|l_sw[0]|l_sw[10]|l_sw[1]|l_sw[2]|l_sw[3]|l_sw[4]|l_sw[5]|l_sw[6]|l_sw[7]|l_sw[8]|l_sw[9]|out|pad|padres|vc|vcp|vdd|vddr|vip|vss|z
+ sg13_lv_nmos L=0.13u W=0.74u AS=0.317325p AD=0.2516p PS=1.805u PD=2.16u
+ rfmode=0
M$326 \$70012 \$69617 \$70005
+ BOTTOM|TOP|VGND|VSS|anode|cathode|core|h_sw[0]|h_sw[10]|h_sw[1]|h_sw[2]|h_sw[3]|h_sw[4]|h_sw[5]|h_sw[6]|h_sw[7]|h_sw[8]|h_sw[9]|l_sw[0]|l_sw[10]|l_sw[1]|l_sw[2]|l_sw[3]|l_sw[4]|l_sw[5]|l_sw[6]|l_sw[7]|l_sw[8]|l_sw[9]|out|pad|padres|vc|vcp|vdd|vddr|vip|vss|z
+ sg13_lv_nmos L=0.13u W=0.42u AS=0.1428p AD=0.12665p PS=1.52u PD=1.145u
+ rfmode=0
M$327 \$70005 \$69582 \$69580
+ BOTTOM|TOP|VGND|VSS|anode|cathode|core|h_sw[0]|h_sw[10]|h_sw[1]|h_sw[2]|h_sw[3]|h_sw[4]|h_sw[5]|h_sw[6]|h_sw[7]|h_sw[8]|h_sw[9]|l_sw[0]|l_sw[10]|l_sw[1]|l_sw[2]|l_sw[3]|l_sw[4]|l_sw[5]|l_sw[6]|l_sw[7]|l_sw[8]|l_sw[9]|out|pad|padres|vc|vcp|vdd|vddr|vip|vss|z
+ sg13_lv_nmos L=0.13u W=0.74u AS=0.12665p AD=0.3473p PS=1.145u PD=2.71u
+ rfmode=0
M$328 A|Y$6 A|X$35
+ BOTTOM|TOP|VGND|VSS|anode|cathode|core|h_sw[0]|h_sw[10]|h_sw[1]|h_sw[2]|h_sw[3]|h_sw[4]|h_sw[5]|h_sw[6]|h_sw[7]|h_sw[8]|h_sw[9]|l_sw[0]|l_sw[10]|l_sw[1]|l_sw[2]|l_sw[3]|l_sw[4]|l_sw[5]|l_sw[6]|l_sw[7]|l_sw[8]|l_sw[9]|out|pad|padres|vc|vcp|vdd|vddr|vip|vss|z
+ BOTTOM|TOP|VGND|VSS|anode|cathode|core|h_sw[0]|h_sw[10]|h_sw[1]|h_sw[2]|h_sw[3]|h_sw[4]|h_sw[5]|h_sw[6]|h_sw[7]|h_sw[8]|h_sw[9]|l_sw[0]|l_sw[10]|l_sw[1]|l_sw[2]|l_sw[3]|l_sw[4]|l_sw[5]|l_sw[6]|l_sw[7]|l_sw[8]|l_sw[9]|out|pad|padres|vc|vcp|vdd|vddr|vip|vss|z
+ sg13_lv_nmos L=0.13u W=0.74u AS=0.2516p AD=0.2516p PS=2.16u PD=2.16u rfmode=0
M$329
+ BOTTOM|TOP|VGND|VSS|anode|cathode|core|h_sw[0]|h_sw[10]|h_sw[1]|h_sw[2]|h_sw[3]|h_sw[4]|h_sw[5]|h_sw[6]|h_sw[7]|h_sw[8]|h_sw[9]|l_sw[0]|l_sw[10]|l_sw[1]|l_sw[2]|l_sw[3]|l_sw[4]|l_sw[5]|l_sw[6]|l_sw[7]|l_sw[8]|l_sw[9]|out|pad|padres|vc|vcp|vdd|vddr|vip|vss|z
+ A|B_N|Q \$70160
+ BOTTOM|TOP|VGND|VSS|anode|cathode|core|h_sw[0]|h_sw[10]|h_sw[1]|h_sw[2]|h_sw[3]|h_sw[4]|h_sw[5]|h_sw[6]|h_sw[7]|h_sw[8]|h_sw[9]|l_sw[0]|l_sw[10]|l_sw[1]|l_sw[2]|l_sw[3]|l_sw[4]|l_sw[5]|l_sw[6]|l_sw[7]|l_sw[8]|l_sw[9]|out|pad|padres|vc|vcp|vdd|vddr|vip|vss|z
+ sg13_lv_nmos L=0.13u W=0.64u AS=0.2272p AD=0.0784p PS=1.99u PD=0.885u rfmode=0
M$330 \$70160 A2|B|B1|Y \$69590
+ BOTTOM|TOP|VGND|VSS|anode|cathode|core|h_sw[0]|h_sw[10]|h_sw[1]|h_sw[2]|h_sw[3]|h_sw[4]|h_sw[5]|h_sw[6]|h_sw[7]|h_sw[8]|h_sw[9]|l_sw[0]|l_sw[10]|l_sw[1]|l_sw[2]|l_sw[3]|l_sw[4]|l_sw[5]|l_sw[6]|l_sw[7]|l_sw[8]|l_sw[9]|out|pad|padres|vc|vcp|vdd|vddr|vip|vss|z
+ sg13_lv_nmos L=0.13u W=0.64u AS=0.0784p AD=0.2176p PS=0.885u PD=1.96u rfmode=0
M$331 \$70019 A|B_N|Q
+ BOTTOM|TOP|VGND|VSS|anode|cathode|core|h_sw[0]|h_sw[10]|h_sw[1]|h_sw[2]|h_sw[3]|h_sw[4]|h_sw[5]|h_sw[6]|h_sw[7]|h_sw[8]|h_sw[9]|l_sw[0]|l_sw[10]|l_sw[1]|l_sw[2]|l_sw[3]|l_sw[4]|l_sw[5]|l_sw[6]|l_sw[7]|l_sw[8]|l_sw[9]|out|pad|padres|vc|vcp|vdd|vddr|vip|vss|z
+ BOTTOM|TOP|VGND|VSS|anode|cathode|core|h_sw[0]|h_sw[10]|h_sw[1]|h_sw[2]|h_sw[3]|h_sw[4]|h_sw[5]|h_sw[6]|h_sw[7]|h_sw[8]|h_sw[9]|l_sw[0]|l_sw[10]|l_sw[1]|l_sw[2]|l_sw[3]|l_sw[4]|l_sw[5]|l_sw[6]|l_sw[7]|l_sw[8]|l_sw[9]|out|pad|padres|vc|vcp|vdd|vddr|vip|vss|z
+ sg13_lv_nmos L=0.13u W=0.74u AS=0.2516p AD=0.1898p PS=2.16u PD=1.36u rfmode=0
M$332
+ BOTTOM|TOP|VGND|VSS|anode|cathode|core|h_sw[0]|h_sw[10]|h_sw[1]|h_sw[2]|h_sw[3]|h_sw[4]|h_sw[5]|h_sw[6]|h_sw[7]|h_sw[8]|h_sw[9]|l_sw[0]|l_sw[10]|l_sw[1]|l_sw[2]|l_sw[3]|l_sw[4]|l_sw[5]|l_sw[6]|l_sw[7]|l_sw[8]|l_sw[9]|out|pad|padres|vc|vcp|vdd|vddr|vip|vss|z
+ A2|B|B1|Y \$70019
+ BOTTOM|TOP|VGND|VSS|anode|cathode|core|h_sw[0]|h_sw[10]|h_sw[1]|h_sw[2]|h_sw[3]|h_sw[4]|h_sw[5]|h_sw[6]|h_sw[7]|h_sw[8]|h_sw[9]|l_sw[0]|l_sw[10]|l_sw[1]|l_sw[2]|l_sw[3]|l_sw[4]|l_sw[5]|l_sw[6]|l_sw[7]|l_sw[8]|l_sw[9]|out|pad|padres|vc|vcp|vdd|vddr|vip|vss|z
+ sg13_lv_nmos L=0.13u W=0.74u AS=0.1898p AD=0.1406p PS=1.36u PD=1.12u rfmode=0
M$333 \$70019 \$69590 D|Y$1
+ BOTTOM|TOP|VGND|VSS|anode|cathode|core|h_sw[0]|h_sw[10]|h_sw[1]|h_sw[2]|h_sw[3]|h_sw[4]|h_sw[5]|h_sw[6]|h_sw[7]|h_sw[8]|h_sw[9]|l_sw[0]|l_sw[10]|l_sw[1]|l_sw[2]|l_sw[3]|l_sw[4]|l_sw[5]|l_sw[6]|l_sw[7]|l_sw[8]|l_sw[9]|out|pad|padres|vc|vcp|vdd|vddr|vip|vss|z
+ sg13_lv_nmos L=0.13u W=0.74u AS=0.1406p AD=0.2516p PS=1.12u PD=2.16u rfmode=0
M$334 \$69510 \$69622 \$69594
+ BOTTOM|TOP|VGND|VSS|anode|cathode|core|h_sw[0]|h_sw[10]|h_sw[1]|h_sw[2]|h_sw[3]|h_sw[4]|h_sw[5]|h_sw[6]|h_sw[7]|h_sw[8]|h_sw[9]|l_sw[0]|l_sw[10]|l_sw[1]|l_sw[2]|l_sw[3]|l_sw[4]|l_sw[5]|l_sw[6]|l_sw[7]|l_sw[8]|l_sw[9]|out|pad|padres|vc|vcp|vdd|vddr|vip|vss|z
+ sg13_lv_nmos L=0.13u W=0.42u AS=0.1296p AD=0.0798p PS=1.52u PD=0.8u rfmode=0
M$335 \$69594 \$69595 \$70008
+ BOTTOM|TOP|VGND|VSS|anode|cathode|core|h_sw[0]|h_sw[10]|h_sw[1]|h_sw[2]|h_sw[3]|h_sw[4]|h_sw[5]|h_sw[6]|h_sw[7]|h_sw[8]|h_sw[9]|l_sw[0]|l_sw[10]|l_sw[1]|l_sw[2]|l_sw[3]|l_sw[4]|l_sw[5]|l_sw[6]|l_sw[7]|l_sw[8]|l_sw[9]|out|pad|padres|vc|vcp|vdd|vddr|vip|vss|z
+ sg13_lv_nmos L=0.13u W=0.42u AS=0.0798p AD=0.2373p PS=0.8u PD=1.97u rfmode=0
M$336 \$69595 \$69622
+ BOTTOM|TOP|VGND|VSS|anode|cathode|core|h_sw[0]|h_sw[10]|h_sw[1]|h_sw[2]|h_sw[3]|h_sw[4]|h_sw[5]|h_sw[6]|h_sw[7]|h_sw[8]|h_sw[9]|l_sw[0]|l_sw[10]|l_sw[1]|l_sw[2]|l_sw[3]|l_sw[4]|l_sw[5]|l_sw[6]|l_sw[7]|l_sw[8]|l_sw[9]|out|pad|padres|vc|vcp|vdd|vddr|vip|vss|z
+ BOTTOM|TOP|VGND|VSS|anode|cathode|core|h_sw[0]|h_sw[10]|h_sw[1]|h_sw[2]|h_sw[3]|h_sw[4]|h_sw[5]|h_sw[6]|h_sw[7]|h_sw[8]|h_sw[9]|l_sw[0]|l_sw[10]|l_sw[1]|l_sw[2]|l_sw[3]|l_sw[4]|l_sw[5]|l_sw[6]|l_sw[7]|l_sw[8]|l_sw[9]|out|pad|padres|vc|vcp|vdd|vddr|vip|vss|z
+ sg13_lv_nmos L=0.13u W=0.74u AS=0.2516p AD=0.317325p PS=2.16u PD=1.805u
+ rfmode=0
M$337
+ BOTTOM|TOP|VGND|VSS|anode|cathode|core|h_sw[0]|h_sw[10]|h_sw[1]|h_sw[2]|h_sw[3]|h_sw[4]|h_sw[5]|h_sw[6]|h_sw[7]|h_sw[8]|h_sw[9]|l_sw[0]|l_sw[10]|l_sw[1]|l_sw[2]|l_sw[3]|l_sw[4]|l_sw[5]|l_sw[6]|l_sw[7]|l_sw[8]|l_sw[9]|out|pad|padres|vc|vcp|vdd|vddr|vip|vss|z
+ CLK|Y \$69622
+ BOTTOM|TOP|VGND|VSS|anode|cathode|core|h_sw[0]|h_sw[10]|h_sw[1]|h_sw[2]|h_sw[3]|h_sw[4]|h_sw[5]|h_sw[6]|h_sw[7]|h_sw[8]|h_sw[9]|l_sw[0]|l_sw[10]|l_sw[1]|l_sw[2]|l_sw[3]|l_sw[4]|l_sw[5]|l_sw[6]|l_sw[7]|l_sw[8]|l_sw[9]|out|pad|padres|vc|vcp|vdd|vddr|vip|vss|z
+ sg13_lv_nmos L=0.13u W=0.74u AS=0.317325p AD=0.2516p PS=1.805u PD=2.16u
+ rfmode=0
M$338 \$70013 \$69622 \$70009
+ BOTTOM|TOP|VGND|VSS|anode|cathode|core|h_sw[0]|h_sw[10]|h_sw[1]|h_sw[2]|h_sw[3]|h_sw[4]|h_sw[5]|h_sw[6]|h_sw[7]|h_sw[8]|h_sw[9]|l_sw[0]|l_sw[10]|l_sw[1]|l_sw[2]|l_sw[3]|l_sw[4]|l_sw[5]|l_sw[6]|l_sw[7]|l_sw[8]|l_sw[9]|out|pad|padres|vc|vcp|vdd|vddr|vip|vss|z
+ sg13_lv_nmos L=0.13u W=0.42u AS=0.1428p AD=0.12665p PS=1.52u PD=1.145u
+ rfmode=0
M$339 \$70009 \$69595 \$69593
+ BOTTOM|TOP|VGND|VSS|anode|cathode|core|h_sw[0]|h_sw[10]|h_sw[1]|h_sw[2]|h_sw[3]|h_sw[4]|h_sw[5]|h_sw[6]|h_sw[7]|h_sw[8]|h_sw[9]|l_sw[0]|l_sw[10]|l_sw[1]|l_sw[2]|l_sw[3]|l_sw[4]|l_sw[5]|l_sw[6]|l_sw[7]|l_sw[8]|l_sw[9]|out|pad|padres|vc|vcp|vdd|vddr|vip|vss|z
+ sg13_lv_nmos L=0.13u W=0.74u AS=0.12665p AD=0.3473p PS=1.145u PD=2.71u
+ rfmode=0
M$340
+ BOTTOM|TOP|VGND|VSS|anode|cathode|core|h_sw[0]|h_sw[10]|h_sw[1]|h_sw[2]|h_sw[3]|h_sw[4]|h_sw[5]|h_sw[6]|h_sw[7]|h_sw[8]|h_sw[9]|l_sw[0]|l_sw[10]|l_sw[1]|l_sw[2]|l_sw[3]|l_sw[4]|l_sw[5]|l_sw[6]|l_sw[7]|l_sw[8]|l_sw[9]|out|pad|padres|vc|vcp|vdd|vddr|vip|vss|z
+ A|X$54 A|Y$7
+ BOTTOM|TOP|VGND|VSS|anode|cathode|core|h_sw[0]|h_sw[10]|h_sw[1]|h_sw[2]|h_sw[3]|h_sw[4]|h_sw[5]|h_sw[6]|h_sw[7]|h_sw[8]|h_sw[9]|l_sw[0]|l_sw[10]|l_sw[1]|l_sw[2]|l_sw[3]|l_sw[4]|l_sw[5]|l_sw[6]|l_sw[7]|l_sw[8]|l_sw[9]|out|pad|padres|vc|vcp|vdd|vddr|vip|vss|z
+ sg13_lv_nmos L=0.13u W=0.74u AS=0.2516p AD=0.2516p PS=2.16u PD=2.16u rfmode=0
M$341 \$69598 A|A_N|B|B_N|Q
+ BOTTOM|TOP|VGND|VSS|anode|cathode|core|h_sw[0]|h_sw[10]|h_sw[1]|h_sw[2]|h_sw[3]|h_sw[4]|h_sw[5]|h_sw[6]|h_sw[7]|h_sw[8]|h_sw[9]|l_sw[0]|l_sw[10]|l_sw[1]|l_sw[2]|l_sw[3]|l_sw[4]|l_sw[5]|l_sw[6]|l_sw[7]|l_sw[8]|l_sw[9]|out|pad|padres|vc|vcp|vdd|vddr|vip|vss|z
+ BOTTOM|TOP|VGND|VSS|anode|cathode|core|h_sw[0]|h_sw[10]|h_sw[1]|h_sw[2]|h_sw[3]|h_sw[4]|h_sw[5]|h_sw[6]|h_sw[7]|h_sw[8]|h_sw[9]|l_sw[0]|l_sw[10]|l_sw[1]|l_sw[2]|l_sw[3]|l_sw[4]|l_sw[5]|l_sw[6]|l_sw[7]|l_sw[8]|l_sw[9]|out|pad|padres|vc|vcp|vdd|vddr|vip|vss|z
+ sg13_lv_nmos L=0.13u W=0.55u AS=0.187p AD=0.17255p PS=1.78u PD=1.25u rfmode=0
M$342
+ BOTTOM|TOP|VGND|VSS|anode|cathode|core|h_sw[0]|h_sw[10]|h_sw[1]|h_sw[2]|h_sw[3]|h_sw[4]|h_sw[5]|h_sw[6]|h_sw[7]|h_sw[8]|h_sw[9]|l_sw[0]|l_sw[10]|l_sw[1]|l_sw[2]|l_sw[3]|l_sw[4]|l_sw[5]|l_sw[6]|l_sw[7]|l_sw[8]|l_sw[9]|out|pad|padres|vc|vcp|vdd|vddr|vip|vss|z
+ \$69598 D|Y$2
+ BOTTOM|TOP|VGND|VSS|anode|cathode|core|h_sw[0]|h_sw[10]|h_sw[1]|h_sw[2]|h_sw[3]|h_sw[4]|h_sw[5]|h_sw[6]|h_sw[7]|h_sw[8]|h_sw[9]|l_sw[0]|l_sw[10]|l_sw[1]|l_sw[2]|l_sw[3]|l_sw[4]|l_sw[5]|l_sw[6]|l_sw[7]|l_sw[8]|l_sw[9]|out|pad|padres|vc|vcp|vdd|vddr|vip|vss|z
+ sg13_lv_nmos L=0.13u W=0.74u AS=0.17255p AD=0.1406p PS=1.25u PD=1.12u rfmode=0
M$343 D|Y$2 A|B|B_N|Q
+ BOTTOM|TOP|VGND|VSS|anode|cathode|core|h_sw[0]|h_sw[10]|h_sw[1]|h_sw[2]|h_sw[3]|h_sw[4]|h_sw[5]|h_sw[6]|h_sw[7]|h_sw[8]|h_sw[9]|l_sw[0]|l_sw[10]|l_sw[1]|l_sw[2]|l_sw[3]|l_sw[4]|l_sw[5]|l_sw[6]|l_sw[7]|l_sw[8]|l_sw[9]|out|pad|padres|vc|vcp|vdd|vddr|vip|vss|z
+ BOTTOM|TOP|VGND|VSS|anode|cathode|core|h_sw[0]|h_sw[10]|h_sw[1]|h_sw[2]|h_sw[3]|h_sw[4]|h_sw[5]|h_sw[6]|h_sw[7]|h_sw[8]|h_sw[9]|l_sw[0]|l_sw[10]|l_sw[1]|l_sw[2]|l_sw[3]|l_sw[4]|l_sw[5]|l_sw[6]|l_sw[7]|l_sw[8]|l_sw[9]|out|pad|padres|vc|vcp|vdd|vddr|vip|vss|z
+ sg13_lv_nmos L=0.13u W=0.74u AS=0.1406p AD=0.2516p PS=1.12u PD=2.16u rfmode=0
M$344
+ BOTTOM|TOP|VGND|VSS|anode|cathode|core|h_sw[0]|h_sw[10]|h_sw[1]|h_sw[2]|h_sw[3]|h_sw[4]|h_sw[5]|h_sw[6]|h_sw[7]|h_sw[8]|h_sw[9]|l_sw[0]|l_sw[10]|l_sw[1]|l_sw[2]|l_sw[3]|l_sw[4]|l_sw[5]|l_sw[6]|l_sw[7]|l_sw[8]|l_sw[9]|out|pad|padres|vc|vcp|vdd|vddr|vip|vss|z
+ A|B|B_N|Q \$69600
+ BOTTOM|TOP|VGND|VSS|anode|cathode|core|h_sw[0]|h_sw[10]|h_sw[1]|h_sw[2]|h_sw[3]|h_sw[4]|h_sw[5]|h_sw[6]|h_sw[7]|h_sw[8]|h_sw[9]|l_sw[0]|l_sw[10]|l_sw[1]|l_sw[2]|l_sw[3]|l_sw[4]|l_sw[5]|l_sw[6]|l_sw[7]|l_sw[8]|l_sw[9]|out|pad|padres|vc|vcp|vdd|vddr|vip|vss|z
+ sg13_lv_nmos L=0.13u W=0.55u AS=0.17255p AD=0.187p PS=1.25u PD=1.78u rfmode=0
M$345
+ BOTTOM|TOP|VGND|VSS|anode|cathode|core|h_sw[0]|h_sw[10]|h_sw[1]|h_sw[2]|h_sw[3]|h_sw[4]|h_sw[5]|h_sw[6]|h_sw[7]|h_sw[8]|h_sw[9]|l_sw[0]|l_sw[10]|l_sw[1]|l_sw[2]|l_sw[3]|l_sw[4]|l_sw[5]|l_sw[6]|l_sw[7]|l_sw[8]|l_sw[9]|out|pad|padres|vc|vcp|vdd|vddr|vip|vss|z
+ A|A_N|B|B_N|Q A|A1|B|Y
+ BOTTOM|TOP|VGND|VSS|anode|cathode|core|h_sw[0]|h_sw[10]|h_sw[1]|h_sw[2]|h_sw[3]|h_sw[4]|h_sw[5]|h_sw[6]|h_sw[7]|h_sw[8]|h_sw[9]|l_sw[0]|l_sw[10]|l_sw[1]|l_sw[2]|l_sw[3]|l_sw[4]|l_sw[5]|l_sw[6]|l_sw[7]|l_sw[8]|l_sw[9]|out|pad|padres|vc|vcp|vdd|vddr|vip|vss|z
+ sg13_lv_nmos L=0.13u W=0.74u AS=0.2516p AD=0.1406p PS=2.16u PD=1.12u rfmode=0
M$346 A|A1|B|Y \$69600
+ BOTTOM|TOP|VGND|VSS|anode|cathode|core|h_sw[0]|h_sw[10]|h_sw[1]|h_sw[2]|h_sw[3]|h_sw[4]|h_sw[5]|h_sw[6]|h_sw[7]|h_sw[8]|h_sw[9]|l_sw[0]|l_sw[10]|l_sw[1]|l_sw[2]|l_sw[3]|l_sw[4]|l_sw[5]|l_sw[6]|l_sw[7]|l_sw[8]|l_sw[9]|out|pad|padres|vc|vcp|vdd|vddr|vip|vss|z
+ BOTTOM|TOP|VGND|VSS|anode|cathode|core|h_sw[0]|h_sw[10]|h_sw[1]|h_sw[2]|h_sw[3]|h_sw[4]|h_sw[5]|h_sw[6]|h_sw[7]|h_sw[8]|h_sw[9]|l_sw[0]|l_sw[10]|l_sw[1]|l_sw[2]|l_sw[3]|l_sw[4]|l_sw[5]|l_sw[6]|l_sw[7]|l_sw[8]|l_sw[9]|out|pad|padres|vc|vcp|vdd|vddr|vip|vss|z
+ sg13_lv_nmos L=0.13u W=0.74u AS=0.1406p AD=0.17255p PS=1.12u PD=1.25u rfmode=0
M$347 \$69511 \$69624 \$69602
+ BOTTOM|TOP|VGND|VSS|anode|cathode|core|h_sw[0]|h_sw[10]|h_sw[1]|h_sw[2]|h_sw[3]|h_sw[4]|h_sw[5]|h_sw[6]|h_sw[7]|h_sw[8]|h_sw[9]|l_sw[0]|l_sw[10]|l_sw[1]|l_sw[2]|l_sw[3]|l_sw[4]|l_sw[5]|l_sw[6]|l_sw[7]|l_sw[8]|l_sw[9]|out|pad|padres|vc|vcp|vdd|vddr|vip|vss|z
+ sg13_lv_nmos L=0.13u W=0.42u AS=0.1296p AD=0.0798p PS=1.52u PD=0.8u rfmode=0
M$348 \$69602 \$69603 \$70010
+ BOTTOM|TOP|VGND|VSS|anode|cathode|core|h_sw[0]|h_sw[10]|h_sw[1]|h_sw[2]|h_sw[3]|h_sw[4]|h_sw[5]|h_sw[6]|h_sw[7]|h_sw[8]|h_sw[9]|l_sw[0]|l_sw[10]|l_sw[1]|l_sw[2]|l_sw[3]|l_sw[4]|l_sw[5]|l_sw[6]|l_sw[7]|l_sw[8]|l_sw[9]|out|pad|padres|vc|vcp|vdd|vddr|vip|vss|z
+ sg13_lv_nmos L=0.13u W=0.42u AS=0.0798p AD=0.2373p PS=0.8u PD=1.97u rfmode=0
M$349 \$69603 \$69624
+ BOTTOM|TOP|VGND|VSS|anode|cathode|core|h_sw[0]|h_sw[10]|h_sw[1]|h_sw[2]|h_sw[3]|h_sw[4]|h_sw[5]|h_sw[6]|h_sw[7]|h_sw[8]|h_sw[9]|l_sw[0]|l_sw[10]|l_sw[1]|l_sw[2]|l_sw[3]|l_sw[4]|l_sw[5]|l_sw[6]|l_sw[7]|l_sw[8]|l_sw[9]|out|pad|padres|vc|vcp|vdd|vddr|vip|vss|z
+ BOTTOM|TOP|VGND|VSS|anode|cathode|core|h_sw[0]|h_sw[10]|h_sw[1]|h_sw[2]|h_sw[3]|h_sw[4]|h_sw[5]|h_sw[6]|h_sw[7]|h_sw[8]|h_sw[9]|l_sw[0]|l_sw[10]|l_sw[1]|l_sw[2]|l_sw[3]|l_sw[4]|l_sw[5]|l_sw[6]|l_sw[7]|l_sw[8]|l_sw[9]|out|pad|padres|vc|vcp|vdd|vddr|vip|vss|z
+ sg13_lv_nmos L=0.13u W=0.74u AS=0.2516p AD=0.317325p PS=2.16u PD=1.805u
+ rfmode=0
M$350
+ BOTTOM|TOP|VGND|VSS|anode|cathode|core|h_sw[0]|h_sw[10]|h_sw[1]|h_sw[2]|h_sw[3]|h_sw[4]|h_sw[5]|h_sw[6]|h_sw[7]|h_sw[8]|h_sw[9]|l_sw[0]|l_sw[10]|l_sw[1]|l_sw[2]|l_sw[3]|l_sw[4]|l_sw[5]|l_sw[6]|l_sw[7]|l_sw[8]|l_sw[9]|out|pad|padres|vc|vcp|vdd|vddr|vip|vss|z
+ CLK|Y \$69624
+ BOTTOM|TOP|VGND|VSS|anode|cathode|core|h_sw[0]|h_sw[10]|h_sw[1]|h_sw[2]|h_sw[3]|h_sw[4]|h_sw[5]|h_sw[6]|h_sw[7]|h_sw[8]|h_sw[9]|l_sw[0]|l_sw[10]|l_sw[1]|l_sw[2]|l_sw[3]|l_sw[4]|l_sw[5]|l_sw[6]|l_sw[7]|l_sw[8]|l_sw[9]|out|pad|padres|vc|vcp|vdd|vddr|vip|vss|z
+ sg13_lv_nmos L=0.13u W=0.74u AS=0.317325p AD=0.2516p PS=1.805u PD=2.16u
+ rfmode=0
M$351 \$70014 \$69624 \$70011
+ BOTTOM|TOP|VGND|VSS|anode|cathode|core|h_sw[0]|h_sw[10]|h_sw[1]|h_sw[2]|h_sw[3]|h_sw[4]|h_sw[5]|h_sw[6]|h_sw[7]|h_sw[8]|h_sw[9]|l_sw[0]|l_sw[10]|l_sw[1]|l_sw[2]|l_sw[3]|l_sw[4]|l_sw[5]|l_sw[6]|l_sw[7]|l_sw[8]|l_sw[9]|out|pad|padres|vc|vcp|vdd|vddr|vip|vss|z
+ sg13_lv_nmos L=0.13u W=0.42u AS=0.1428p AD=0.12665p PS=1.52u PD=1.145u
+ rfmode=0
M$352 \$70011 \$69603 \$69601
+ BOTTOM|TOP|VGND|VSS|anode|cathode|core|h_sw[0]|h_sw[10]|h_sw[1]|h_sw[2]|h_sw[3]|h_sw[4]|h_sw[5]|h_sw[6]|h_sw[7]|h_sw[8]|h_sw[9]|l_sw[0]|l_sw[10]|l_sw[1]|l_sw[2]|l_sw[3]|l_sw[4]|l_sw[5]|l_sw[6]|l_sw[7]|l_sw[8]|l_sw[9]|out|pad|padres|vc|vcp|vdd|vddr|vip|vss|z
+ sg13_lv_nmos L=0.13u W=0.74u AS=0.12665p AD=0.3473p PS=1.145u PD=2.71u
+ rfmode=0
M$353
+ BOTTOM|TOP|VGND|VSS|anode|cathode|core|h_sw[0]|h_sw[10]|h_sw[1]|h_sw[2]|h_sw[3]|h_sw[4]|h_sw[5]|h_sw[6]|h_sw[7]|h_sw[8]|h_sw[9]|l_sw[0]|l_sw[10]|l_sw[1]|l_sw[2]|l_sw[3]|l_sw[4]|l_sw[5]|l_sw[6]|l_sw[7]|l_sw[8]|l_sw[9]|out|pad|padres|vc|vcp|vdd|vddr|vip|vss|z
+ A|B|B_N|Q B|D|Y
+ BOTTOM|TOP|VGND|VSS|anode|cathode|core|h_sw[0]|h_sw[10]|h_sw[1]|h_sw[2]|h_sw[3]|h_sw[4]|h_sw[5]|h_sw[6]|h_sw[7]|h_sw[8]|h_sw[9]|l_sw[0]|l_sw[10]|l_sw[1]|l_sw[2]|l_sw[3]|l_sw[4]|l_sw[5]|l_sw[6]|l_sw[7]|l_sw[8]|l_sw[9]|out|pad|padres|vc|vcp|vdd|vddr|vip|vss|z
+ sg13_lv_nmos L=0.13u W=0.74u AS=0.2516p AD=0.1406p PS=2.16u PD=1.12u rfmode=0
M$354 B|D|Y A|A_N|B|B_N|Q
+ BOTTOM|TOP|VGND|VSS|anode|cathode|core|h_sw[0]|h_sw[10]|h_sw[1]|h_sw[2]|h_sw[3]|h_sw[4]|h_sw[5]|h_sw[6]|h_sw[7]|h_sw[8]|h_sw[9]|l_sw[0]|l_sw[10]|l_sw[1]|l_sw[2]|l_sw[3]|l_sw[4]|l_sw[5]|l_sw[6]|l_sw[7]|l_sw[8]|l_sw[9]|out|pad|padres|vc|vcp|vdd|vddr|vip|vss|z
+ BOTTOM|TOP|VGND|VSS|anode|cathode|core|h_sw[0]|h_sw[10]|h_sw[1]|h_sw[2]|h_sw[3]|h_sw[4]|h_sw[5]|h_sw[6]|h_sw[7]|h_sw[8]|h_sw[9]|l_sw[0]|l_sw[10]|l_sw[1]|l_sw[2]|l_sw[3]|l_sw[4]|l_sw[5]|l_sw[6]|l_sw[7]|l_sw[8]|l_sw[9]|out|pad|padres|vc|vcp|vdd|vddr|vip|vss|z
+ sg13_lv_nmos L=0.13u W=0.74u AS=0.1406p AD=0.2516p PS=1.12u PD=2.16u rfmode=0
M$355
+ BOTTOM|TOP|VGND|VSS|anode|cathode|core|h_sw[0]|h_sw[10]|h_sw[1]|h_sw[2]|h_sw[3]|h_sw[4]|h_sw[5]|h_sw[6]|h_sw[7]|h_sw[8]|h_sw[9]|l_sw[0]|l_sw[10]|l_sw[1]|l_sw[2]|l_sw[3]|l_sw[4]|l_sw[5]|l_sw[6]|l_sw[7]|l_sw[8]|l_sw[9]|out|pad|padres|vc|vcp|vdd|vddr|vip|vss|z
+ A|X$1 \$69569
+ BOTTOM|TOP|VGND|VSS|anode|cathode|core|h_sw[0]|h_sw[10]|h_sw[1]|h_sw[2]|h_sw[3]|h_sw[4]|h_sw[5]|h_sw[6]|h_sw[7]|h_sw[8]|h_sw[9]|l_sw[0]|l_sw[10]|l_sw[1]|l_sw[2]|l_sw[3]|l_sw[4]|l_sw[5]|l_sw[6]|l_sw[7]|l_sw[8]|l_sw[9]|out|pad|padres|vc|vcp|vdd|vddr|vip|vss|z
+ sg13_lv_nmos L=0.13u W=0.55u AS=0.14875p AD=0.187p PS=1.16u PD=1.78u rfmode=0
M$356 X|in_l_sw[0]|nl_sw[0]|x \$69569
+ BOTTOM|TOP|VGND|VSS|anode|cathode|core|h_sw[0]|h_sw[10]|h_sw[1]|h_sw[2]|h_sw[3]|h_sw[4]|h_sw[5]|h_sw[6]|h_sw[7]|h_sw[8]|h_sw[9]|l_sw[0]|l_sw[10]|l_sw[1]|l_sw[2]|l_sw[3]|l_sw[4]|l_sw[5]|l_sw[6]|l_sw[7]|l_sw[8]|l_sw[9]|out|pad|padres|vc|vcp|vdd|vddr|vip|vss|z
+ BOTTOM|TOP|VGND|VSS|anode|cathode|core|h_sw[0]|h_sw[10]|h_sw[1]|h_sw[2]|h_sw[3]|h_sw[4]|h_sw[5]|h_sw[6]|h_sw[7]|h_sw[8]|h_sw[9]|l_sw[0]|l_sw[10]|l_sw[1]|l_sw[2]|l_sw[3]|l_sw[4]|l_sw[5]|l_sw[6]|l_sw[7]|l_sw[8]|l_sw[9]|out|pad|padres|vc|vcp|vdd|vddr|vip|vss|z
+ sg13_lv_nmos L=0.13u W=0.74u AS=0.2886p AD=0.14875p PS=2.26u PD=1.16u rfmode=0
M$357
+ BOTTOM|TOP|VGND|VSS|anode|cathode|core|h_sw[0]|h_sw[10]|h_sw[1]|h_sw[2]|h_sw[3]|h_sw[4]|h_sw[5]|h_sw[6]|h_sw[7]|h_sw[8]|h_sw[9]|l_sw[0]|l_sw[10]|l_sw[1]|l_sw[2]|l_sw[3]|l_sw[4]|l_sw[5]|l_sw[6]|l_sw[7]|l_sw[8]|l_sw[9]|out|pad|padres|vc|vcp|vdd|vddr|vip|vss|z
+ A|X$2 \$69572
+ BOTTOM|TOP|VGND|VSS|anode|cathode|core|h_sw[0]|h_sw[10]|h_sw[1]|h_sw[2]|h_sw[3]|h_sw[4]|h_sw[5]|h_sw[6]|h_sw[7]|h_sw[8]|h_sw[9]|l_sw[0]|l_sw[10]|l_sw[1]|l_sw[2]|l_sw[3]|l_sw[4]|l_sw[5]|l_sw[6]|l_sw[7]|l_sw[8]|l_sw[9]|out|pad|padres|vc|vcp|vdd|vddr|vip|vss|z
+ sg13_lv_nmos L=0.13u W=0.55u AS=0.14875p AD=0.187p PS=1.16u PD=1.78u rfmode=0
M$358 X|in_h_sw[0]|nh_sw[0]|x \$69572
+ BOTTOM|TOP|VGND|VSS|anode|cathode|core|h_sw[0]|h_sw[10]|h_sw[1]|h_sw[2]|h_sw[3]|h_sw[4]|h_sw[5]|h_sw[6]|h_sw[7]|h_sw[8]|h_sw[9]|l_sw[0]|l_sw[10]|l_sw[1]|l_sw[2]|l_sw[3]|l_sw[4]|l_sw[5]|l_sw[6]|l_sw[7]|l_sw[8]|l_sw[9]|out|pad|padres|vc|vcp|vdd|vddr|vip|vss|z
+ BOTTOM|TOP|VGND|VSS|anode|cathode|core|h_sw[0]|h_sw[10]|h_sw[1]|h_sw[2]|h_sw[3]|h_sw[4]|h_sw[5]|h_sw[6]|h_sw[7]|h_sw[8]|h_sw[9]|l_sw[0]|l_sw[10]|l_sw[1]|l_sw[2]|l_sw[3]|l_sw[4]|l_sw[5]|l_sw[6]|l_sw[7]|l_sw[8]|l_sw[9]|out|pad|padres|vc|vcp|vdd|vddr|vip|vss|z
+ sg13_lv_nmos L=0.13u W=0.74u AS=0.2886p AD=0.14875p PS=2.26u PD=1.16u rfmode=0
M$359 \$69573 A|X$3
+ BOTTOM|TOP|VGND|VSS|anode|cathode|core|h_sw[0]|h_sw[10]|h_sw[1]|h_sw[2]|h_sw[3]|h_sw[4]|h_sw[5]|h_sw[6]|h_sw[7]|h_sw[8]|h_sw[9]|l_sw[0]|l_sw[10]|l_sw[1]|l_sw[2]|l_sw[3]|l_sw[4]|l_sw[5]|l_sw[6]|l_sw[7]|l_sw[8]|l_sw[9]|out|pad|padres|vc|vcp|vdd|vddr|vip|vss|z
+ BOTTOM|TOP|VGND|VSS|anode|cathode|core|h_sw[0]|h_sw[10]|h_sw[1]|h_sw[2]|h_sw[3]|h_sw[4]|h_sw[5]|h_sw[6]|h_sw[7]|h_sw[8]|h_sw[9]|l_sw[0]|l_sw[10]|l_sw[1]|l_sw[2]|l_sw[3]|l_sw[4]|l_sw[5]|l_sw[6]|l_sw[7]|l_sw[8]|l_sw[9]|out|pad|padres|vc|vcp|vdd|vddr|vip|vss|z
+ sg13_lv_nmos L=0.13u W=0.55u AS=0.187p AD=0.14875p PS=1.78u PD=1.16u rfmode=0
M$360
+ BOTTOM|TOP|VGND|VSS|anode|cathode|core|h_sw[0]|h_sw[10]|h_sw[1]|h_sw[2]|h_sw[3]|h_sw[4]|h_sw[5]|h_sw[6]|h_sw[7]|h_sw[8]|h_sw[9]|l_sw[0]|l_sw[10]|l_sw[1]|l_sw[2]|l_sw[3]|l_sw[4]|l_sw[5]|l_sw[6]|l_sw[7]|l_sw[8]|l_sw[9]|out|pad|padres|vc|vcp|vdd|vddr|vip|vss|z
+ \$69573 X|in_h_sw[1]|nh_sw[1]|x
+ BOTTOM|TOP|VGND|VSS|anode|cathode|core|h_sw[0]|h_sw[10]|h_sw[1]|h_sw[2]|h_sw[3]|h_sw[4]|h_sw[5]|h_sw[6]|h_sw[7]|h_sw[8]|h_sw[9]|l_sw[0]|l_sw[10]|l_sw[1]|l_sw[2]|l_sw[3]|l_sw[4]|l_sw[5]|l_sw[6]|l_sw[7]|l_sw[8]|l_sw[9]|out|pad|padres|vc|vcp|vdd|vddr|vip|vss|z
+ sg13_lv_nmos L=0.13u W=0.74u AS=0.14875p AD=0.2886p PS=1.16u PD=2.26u rfmode=0
M$361 \$69576 \$69575 \$70132
+ BOTTOM|TOP|VGND|VSS|anode|cathode|core|h_sw[0]|h_sw[10]|h_sw[1]|h_sw[2]|h_sw[3]|h_sw[4]|h_sw[5]|h_sw[6]|h_sw[7]|h_sw[8]|h_sw[9]|l_sw[0]|l_sw[10]|l_sw[1]|l_sw[2]|l_sw[3]|l_sw[4]|l_sw[5]|l_sw[6]|l_sw[7]|l_sw[8]|l_sw[9]|out|pad|padres|vc|vcp|vdd|vddr|vip|vss|z
+ sg13_lv_nmos L=0.13u W=0.74u AS=0.2516p AD=0.0777p PS=2.16u PD=0.95u rfmode=0
M$362 \$70132 RESET_B|Y$1
+ BOTTOM|TOP|VGND|VSS|anode|cathode|core|h_sw[0]|h_sw[10]|h_sw[1]|h_sw[2]|h_sw[3]|h_sw[4]|h_sw[5]|h_sw[6]|h_sw[7]|h_sw[8]|h_sw[9]|l_sw[0]|l_sw[10]|l_sw[1]|l_sw[2]|l_sw[3]|l_sw[4]|l_sw[5]|l_sw[6]|l_sw[7]|l_sw[8]|l_sw[9]|out|pad|padres|vc|vcp|vdd|vddr|vip|vss|z
+ BOTTOM|TOP|VGND|VSS|anode|cathode|core|h_sw[0]|h_sw[10]|h_sw[1]|h_sw[2]|h_sw[3]|h_sw[4]|h_sw[5]|h_sw[6]|h_sw[7]|h_sw[8]|h_sw[9]|l_sw[0]|l_sw[10]|l_sw[1]|l_sw[2]|l_sw[3]|l_sw[4]|l_sw[5]|l_sw[6]|l_sw[7]|l_sw[8]|l_sw[9]|out|pad|padres|vc|vcp|vdd|vddr|vip|vss|z
+ sg13_lv_nmos L=0.13u W=0.74u AS=0.0777p AD=0.1406p PS=0.95u PD=1.12u rfmode=0
M$363
+ BOTTOM|TOP|VGND|VSS|anode|cathode|core|h_sw[0]|h_sw[10]|h_sw[1]|h_sw[2]|h_sw[3]|h_sw[4]|h_sw[5]|h_sw[6]|h_sw[7]|h_sw[8]|h_sw[9]|l_sw[0]|l_sw[10]|l_sw[1]|l_sw[2]|l_sw[3]|l_sw[4]|l_sw[5]|l_sw[6]|l_sw[7]|l_sw[8]|l_sw[9]|out|pad|padres|vc|vcp|vdd|vddr|vip|vss|z
+ \$69576 A|Q$2
+ BOTTOM|TOP|VGND|VSS|anode|cathode|core|h_sw[0]|h_sw[10]|h_sw[1]|h_sw[2]|h_sw[3]|h_sw[4]|h_sw[5]|h_sw[6]|h_sw[7]|h_sw[8]|h_sw[9]|l_sw[0]|l_sw[10]|l_sw[1]|l_sw[2]|l_sw[3]|l_sw[4]|l_sw[5]|l_sw[6]|l_sw[7]|l_sw[8]|l_sw[9]|out|pad|padres|vc|vcp|vdd|vddr|vip|vss|z
+ sg13_lv_nmos L=0.13u W=0.74u AS=0.1406p AD=0.2516p PS=1.12u PD=2.16u rfmode=0
M$364
+ BOTTOM|TOP|VGND|VSS|anode|cathode|core|h_sw[0]|h_sw[10]|h_sw[1]|h_sw[2]|h_sw[3]|h_sw[4]|h_sw[5]|h_sw[6]|h_sw[7]|h_sw[8]|h_sw[9]|l_sw[0]|l_sw[10]|l_sw[1]|l_sw[2]|l_sw[3]|l_sw[4]|l_sw[5]|l_sw[6]|l_sw[7]|l_sw[8]|l_sw[9]|out|pad|padres|vc|vcp|vdd|vddr|vip|vss|z
+ \$70005 D|Q_N
+ BOTTOM|TOP|VGND|VSS|anode|cathode|core|h_sw[0]|h_sw[10]|h_sw[1]|h_sw[2]|h_sw[3]|h_sw[4]|h_sw[5]|h_sw[6]|h_sw[7]|h_sw[8]|h_sw[9]|l_sw[0]|l_sw[10]|l_sw[1]|l_sw[2]|l_sw[3]|l_sw[4]|l_sw[5]|l_sw[6]|l_sw[7]|l_sw[8]|l_sw[9]|out|pad|padres|vc|vcp|vdd|vddr|vip|vss|z
+ sg13_lv_nmos L=0.13u W=0.74u AS=0.2516p AD=0.2849p PS=2.16u PD=2.25u rfmode=0
M$365 \$69584 \$70005
+ BOTTOM|TOP|VGND|VSS|anode|cathode|core|h_sw[0]|h_sw[10]|h_sw[1]|h_sw[2]|h_sw[3]|h_sw[4]|h_sw[5]|h_sw[6]|h_sw[7]|h_sw[8]|h_sw[9]|l_sw[0]|l_sw[10]|l_sw[1]|l_sw[2]|l_sw[3]|l_sw[4]|l_sw[5]|l_sw[6]|l_sw[7]|l_sw[8]|l_sw[9]|out|pad|padres|vc|vcp|vdd|vddr|vip|vss|z
+ BOTTOM|TOP|VGND|VSS|anode|cathode|core|h_sw[0]|h_sw[10]|h_sw[1]|h_sw[2]|h_sw[3]|h_sw[4]|h_sw[5]|h_sw[6]|h_sw[7]|h_sw[8]|h_sw[9]|l_sw[0]|l_sw[10]|l_sw[1]|l_sw[2]|l_sw[3]|l_sw[4]|l_sw[5]|l_sw[6]|l_sw[7]|l_sw[8]|l_sw[9]|out|pad|padres|vc|vcp|vdd|vddr|vip|vss|z
+ sg13_lv_nmos L=0.13u W=0.74u AS=0.2516p AD=0.1406p PS=2.16u PD=1.12u rfmode=0
M$366
+ BOTTOM|TOP|VGND|VSS|anode|cathode|core|h_sw[0]|h_sw[10]|h_sw[1]|h_sw[2]|h_sw[3]|h_sw[4]|h_sw[5]|h_sw[6]|h_sw[7]|h_sw[8]|h_sw[9]|l_sw[0]|l_sw[10]|l_sw[1]|l_sw[2]|l_sw[3]|l_sw[4]|l_sw[5]|l_sw[6]|l_sw[7]|l_sw[8]|l_sw[9]|out|pad|padres|vc|vcp|vdd|vddr|vip|vss|z
+ \$69584 A1|D|Q
+ BOTTOM|TOP|VGND|VSS|anode|cathode|core|h_sw[0]|h_sw[10]|h_sw[1]|h_sw[2]|h_sw[3]|h_sw[4]|h_sw[5]|h_sw[6]|h_sw[7]|h_sw[8]|h_sw[9]|l_sw[0]|l_sw[10]|l_sw[1]|l_sw[2]|l_sw[3]|l_sw[4]|l_sw[5]|l_sw[6]|l_sw[7]|l_sw[8]|l_sw[9]|out|pad|padres|vc|vcp|vdd|vddr|vip|vss|z
+ sg13_lv_nmos L=0.13u W=0.74u AS=0.1406p AD=0.2516p PS=1.12u PD=2.16u rfmode=0
M$367
+ BOTTOM|TOP|VGND|VSS|anode|cathode|core|h_sw[0]|h_sw[10]|h_sw[1]|h_sw[2]|h_sw[3]|h_sw[4]|h_sw[5]|h_sw[6]|h_sw[7]|h_sw[8]|h_sw[9]|l_sw[0]|l_sw[10]|l_sw[1]|l_sw[2]|l_sw[3]|l_sw[4]|l_sw[5]|l_sw[6]|l_sw[7]|l_sw[8]|l_sw[9]|out|pad|padres|vc|vcp|vdd|vddr|vip|vss|z
+ A|Q \$69586
+ BOTTOM|TOP|VGND|VSS|anode|cathode|core|h_sw[0]|h_sw[10]|h_sw[1]|h_sw[2]|h_sw[3]|h_sw[4]|h_sw[5]|h_sw[6]|h_sw[7]|h_sw[8]|h_sw[9]|l_sw[0]|l_sw[10]|l_sw[1]|l_sw[2]|l_sw[3]|l_sw[4]|l_sw[5]|l_sw[6]|l_sw[7]|l_sw[8]|l_sw[9]|out|pad|padres|vc|vcp|vdd|vddr|vip|vss|z
+ sg13_lv_nmos L=0.13u W=0.55u AS=0.14875p AD=0.187p PS=1.16u PD=1.78u rfmode=0
M$368 A|X$29 \$69586
+ BOTTOM|TOP|VGND|VSS|anode|cathode|core|h_sw[0]|h_sw[10]|h_sw[1]|h_sw[2]|h_sw[3]|h_sw[4]|h_sw[5]|h_sw[6]|h_sw[7]|h_sw[8]|h_sw[9]|l_sw[0]|l_sw[10]|l_sw[1]|l_sw[2]|l_sw[3]|l_sw[4]|l_sw[5]|l_sw[6]|l_sw[7]|l_sw[8]|l_sw[9]|out|pad|padres|vc|vcp|vdd|vddr|vip|vss|z
+ BOTTOM|TOP|VGND|VSS|anode|cathode|core|h_sw[0]|h_sw[10]|h_sw[1]|h_sw[2]|h_sw[3]|h_sw[4]|h_sw[5]|h_sw[6]|h_sw[7]|h_sw[8]|h_sw[9]|l_sw[0]|l_sw[10]|l_sw[1]|l_sw[2]|l_sw[3]|l_sw[4]|l_sw[5]|l_sw[6]|l_sw[7]|l_sw[8]|l_sw[9]|out|pad|padres|vc|vcp|vdd|vddr|vip|vss|z
+ sg13_lv_nmos L=0.13u W=0.74u AS=0.2886p AD=0.14875p PS=2.26u PD=1.16u rfmode=0
M$369
+ BOTTOM|TOP|VGND|VSS|anode|cathode|core|h_sw[0]|h_sw[10]|h_sw[1]|h_sw[2]|h_sw[3]|h_sw[4]|h_sw[5]|h_sw[6]|h_sw[7]|h_sw[8]|h_sw[9]|l_sw[0]|l_sw[10]|l_sw[1]|l_sw[2]|l_sw[3]|l_sw[4]|l_sw[5]|l_sw[6]|l_sw[7]|l_sw[8]|l_sw[9]|out|pad|padres|vc|vcp|vdd|vddr|vip|vss|z
+ A|Q$3 \$69587
+ BOTTOM|TOP|VGND|VSS|anode|cathode|core|h_sw[0]|h_sw[10]|h_sw[1]|h_sw[2]|h_sw[3]|h_sw[4]|h_sw[5]|h_sw[6]|h_sw[7]|h_sw[8]|h_sw[9]|l_sw[0]|l_sw[10]|l_sw[1]|l_sw[2]|l_sw[3]|l_sw[4]|l_sw[5]|l_sw[6]|l_sw[7]|l_sw[8]|l_sw[9]|out|pad|padres|vc|vcp|vdd|vddr|vip|vss|z
+ sg13_lv_nmos L=0.13u W=0.55u AS=0.14875p AD=0.187p PS=1.16u PD=1.78u rfmode=0
M$370 A|X$23 \$69587
+ BOTTOM|TOP|VGND|VSS|anode|cathode|core|h_sw[0]|h_sw[10]|h_sw[1]|h_sw[2]|h_sw[3]|h_sw[4]|h_sw[5]|h_sw[6]|h_sw[7]|h_sw[8]|h_sw[9]|l_sw[0]|l_sw[10]|l_sw[1]|l_sw[2]|l_sw[3]|l_sw[4]|l_sw[5]|l_sw[6]|l_sw[7]|l_sw[8]|l_sw[9]|out|pad|padres|vc|vcp|vdd|vddr|vip|vss|z
+ BOTTOM|TOP|VGND|VSS|anode|cathode|core|h_sw[0]|h_sw[10]|h_sw[1]|h_sw[2]|h_sw[3]|h_sw[4]|h_sw[5]|h_sw[6]|h_sw[7]|h_sw[8]|h_sw[9]|l_sw[0]|l_sw[10]|l_sw[1]|l_sw[2]|l_sw[3]|l_sw[4]|l_sw[5]|l_sw[6]|l_sw[7]|l_sw[8]|l_sw[9]|out|pad|padres|vc|vcp|vdd|vddr|vip|vss|z
+ sg13_lv_nmos L=0.13u W=0.74u AS=0.2886p AD=0.14875p PS=2.26u PD=1.16u rfmode=0
M$371
+ BOTTOM|TOP|VGND|VSS|anode|cathode|core|h_sw[0]|h_sw[10]|h_sw[1]|h_sw[2]|h_sw[3]|h_sw[4]|h_sw[5]|h_sw[6]|h_sw[7]|h_sw[8]|h_sw[9]|l_sw[0]|l_sw[10]|l_sw[1]|l_sw[2]|l_sw[3]|l_sw[4]|l_sw[5]|l_sw[6]|l_sw[7]|l_sw[8]|l_sw[9]|out|pad|padres|vc|vcp|vdd|vddr|vip|vss|z
+ A|X$7 \$69588
+ BOTTOM|TOP|VGND|VSS|anode|cathode|core|h_sw[0]|h_sw[10]|h_sw[1]|h_sw[2]|h_sw[3]|h_sw[4]|h_sw[5]|h_sw[6]|h_sw[7]|h_sw[8]|h_sw[9]|l_sw[0]|l_sw[10]|l_sw[1]|l_sw[2]|l_sw[3]|l_sw[4]|l_sw[5]|l_sw[6]|l_sw[7]|l_sw[8]|l_sw[9]|out|pad|padres|vc|vcp|vdd|vddr|vip|vss|z
+ sg13_lv_nmos L=0.13u W=0.55u AS=0.14875p AD=0.187p PS=1.16u PD=1.78u rfmode=0
M$372 X|in_l_sw[4]|nl_sw[4]|x \$69588
+ BOTTOM|TOP|VGND|VSS|anode|cathode|core|h_sw[0]|h_sw[10]|h_sw[1]|h_sw[2]|h_sw[3]|h_sw[4]|h_sw[5]|h_sw[6]|h_sw[7]|h_sw[8]|h_sw[9]|l_sw[0]|l_sw[10]|l_sw[1]|l_sw[2]|l_sw[3]|l_sw[4]|l_sw[5]|l_sw[6]|l_sw[7]|l_sw[8]|l_sw[9]|out|pad|padres|vc|vcp|vdd|vddr|vip|vss|z
+ BOTTOM|TOP|VGND|VSS|anode|cathode|core|h_sw[0]|h_sw[10]|h_sw[1]|h_sw[2]|h_sw[3]|h_sw[4]|h_sw[5]|h_sw[6]|h_sw[7]|h_sw[8]|h_sw[9]|l_sw[0]|l_sw[10]|l_sw[1]|l_sw[2]|l_sw[3]|l_sw[4]|l_sw[5]|l_sw[6]|l_sw[7]|l_sw[8]|l_sw[9]|out|pad|padres|vc|vcp|vdd|vddr|vip|vss|z
+ sg13_lv_nmos L=0.13u W=0.74u AS=0.2886p AD=0.14875p PS=2.26u PD=1.16u rfmode=0
M$373
+ BOTTOM|TOP|VGND|VSS|anode|cathode|core|h_sw[0]|h_sw[10]|h_sw[1]|h_sw[2]|h_sw[3]|h_sw[4]|h_sw[5]|h_sw[6]|h_sw[7]|h_sw[8]|h_sw[9]|l_sw[0]|l_sw[10]|l_sw[1]|l_sw[2]|l_sw[3]|l_sw[4]|l_sw[5]|l_sw[6]|l_sw[7]|l_sw[8]|l_sw[9]|out|pad|padres|vc|vcp|vdd|vddr|vip|vss|z
+ A|X$6 \$69589
+ BOTTOM|TOP|VGND|VSS|anode|cathode|core|h_sw[0]|h_sw[10]|h_sw[1]|h_sw[2]|h_sw[3]|h_sw[4]|h_sw[5]|h_sw[6]|h_sw[7]|h_sw[8]|h_sw[9]|l_sw[0]|l_sw[10]|l_sw[1]|l_sw[2]|l_sw[3]|l_sw[4]|l_sw[5]|l_sw[6]|l_sw[7]|l_sw[8]|l_sw[9]|out|pad|padres|vc|vcp|vdd|vddr|vip|vss|z
+ sg13_lv_nmos L=0.13u W=0.55u AS=0.14875p AD=0.187p PS=1.16u PD=1.78u rfmode=0
M$374 X|in_h_sw[4]|nh_sw[4]|x \$69589
+ BOTTOM|TOP|VGND|VSS|anode|cathode|core|h_sw[0]|h_sw[10]|h_sw[1]|h_sw[2]|h_sw[3]|h_sw[4]|h_sw[5]|h_sw[6]|h_sw[7]|h_sw[8]|h_sw[9]|l_sw[0]|l_sw[10]|l_sw[1]|l_sw[2]|l_sw[3]|l_sw[4]|l_sw[5]|l_sw[6]|l_sw[7]|l_sw[8]|l_sw[9]|out|pad|padres|vc|vcp|vdd|vddr|vip|vss|z
+ BOTTOM|TOP|VGND|VSS|anode|cathode|core|h_sw[0]|h_sw[10]|h_sw[1]|h_sw[2]|h_sw[3]|h_sw[4]|h_sw[5]|h_sw[6]|h_sw[7]|h_sw[8]|h_sw[9]|l_sw[0]|l_sw[10]|l_sw[1]|l_sw[2]|l_sw[3]|l_sw[4]|l_sw[5]|l_sw[6]|l_sw[7]|l_sw[8]|l_sw[9]|out|pad|padres|vc|vcp|vdd|vddr|vip|vss|z
+ sg13_lv_nmos L=0.13u W=0.74u AS=0.2886p AD=0.14875p PS=2.26u PD=1.16u rfmode=0
M$375
+ BOTTOM|TOP|VGND|VSS|anode|cathode|core|h_sw[0]|h_sw[10]|h_sw[1]|h_sw[2]|h_sw[3]|h_sw[4]|h_sw[5]|h_sw[6]|h_sw[7]|h_sw[8]|h_sw[9]|l_sw[0]|l_sw[10]|l_sw[1]|l_sw[2]|l_sw[3]|l_sw[4]|l_sw[5]|l_sw[6]|l_sw[7]|l_sw[8]|l_sw[9]|out|pad|padres|vc|vcp|vdd|vddr|vip|vss|z
+ \$70009 Q_N$4
+ BOTTOM|TOP|VGND|VSS|anode|cathode|core|h_sw[0]|h_sw[10]|h_sw[1]|h_sw[2]|h_sw[3]|h_sw[4]|h_sw[5]|h_sw[6]|h_sw[7]|h_sw[8]|h_sw[9]|l_sw[0]|l_sw[10]|l_sw[1]|l_sw[2]|l_sw[3]|l_sw[4]|l_sw[5]|l_sw[6]|l_sw[7]|l_sw[8]|l_sw[9]|out|pad|padres|vc|vcp|vdd|vddr|vip|vss|z
+ sg13_lv_nmos L=0.13u W=0.74u AS=0.2516p AD=0.2849p PS=2.16u PD=2.25u rfmode=0
M$376 \$69597 \$70009
+ BOTTOM|TOP|VGND|VSS|anode|cathode|core|h_sw[0]|h_sw[10]|h_sw[1]|h_sw[2]|h_sw[3]|h_sw[4]|h_sw[5]|h_sw[6]|h_sw[7]|h_sw[8]|h_sw[9]|l_sw[0]|l_sw[10]|l_sw[1]|l_sw[2]|l_sw[3]|l_sw[4]|l_sw[5]|l_sw[6]|l_sw[7]|l_sw[8]|l_sw[9]|out|pad|padres|vc|vcp|vdd|vddr|vip|vss|z
+ BOTTOM|TOP|VGND|VSS|anode|cathode|core|h_sw[0]|h_sw[10]|h_sw[1]|h_sw[2]|h_sw[3]|h_sw[4]|h_sw[5]|h_sw[6]|h_sw[7]|h_sw[8]|h_sw[9]|l_sw[0]|l_sw[10]|l_sw[1]|l_sw[2]|l_sw[3]|l_sw[4]|l_sw[5]|l_sw[6]|l_sw[7]|l_sw[8]|l_sw[9]|out|pad|padres|vc|vcp|vdd|vddr|vip|vss|z
+ sg13_lv_nmos L=0.13u W=0.74u AS=0.2516p AD=0.1406p PS=2.16u PD=1.12u rfmode=0
M$377
+ BOTTOM|TOP|VGND|VSS|anode|cathode|core|h_sw[0]|h_sw[10]|h_sw[1]|h_sw[2]|h_sw[3]|h_sw[4]|h_sw[5]|h_sw[6]|h_sw[7]|h_sw[8]|h_sw[9]|l_sw[0]|l_sw[10]|l_sw[1]|l_sw[2]|l_sw[3]|l_sw[4]|l_sw[5]|l_sw[6]|l_sw[7]|l_sw[8]|l_sw[9]|out|pad|padres|vc|vcp|vdd|vddr|vip|vss|z
+ \$69597 A|B_N|Q
+ BOTTOM|TOP|VGND|VSS|anode|cathode|core|h_sw[0]|h_sw[10]|h_sw[1]|h_sw[2]|h_sw[3]|h_sw[4]|h_sw[5]|h_sw[6]|h_sw[7]|h_sw[8]|h_sw[9]|l_sw[0]|l_sw[10]|l_sw[1]|l_sw[2]|l_sw[3]|l_sw[4]|l_sw[5]|l_sw[6]|l_sw[7]|l_sw[8]|l_sw[9]|out|pad|padres|vc|vcp|vdd|vddr|vip|vss|z
+ sg13_lv_nmos L=0.13u W=0.74u AS=0.1406p AD=0.2516p PS=1.12u PD=2.16u rfmode=0
M$378
+ BOTTOM|TOP|VGND|VSS|anode|cathode|core|h_sw[0]|h_sw[10]|h_sw[1]|h_sw[2]|h_sw[3]|h_sw[4]|h_sw[5]|h_sw[6]|h_sw[7]|h_sw[8]|h_sw[9]|l_sw[0]|l_sw[10]|l_sw[1]|l_sw[2]|l_sw[3]|l_sw[4]|l_sw[5]|l_sw[6]|l_sw[7]|l_sw[8]|l_sw[9]|out|pad|padres|vc|vcp|vdd|vddr|vip|vss|z
+ \$70011 Q_N$5
+ BOTTOM|TOP|VGND|VSS|anode|cathode|core|h_sw[0]|h_sw[10]|h_sw[1]|h_sw[2]|h_sw[3]|h_sw[4]|h_sw[5]|h_sw[6]|h_sw[7]|h_sw[8]|h_sw[9]|l_sw[0]|l_sw[10]|l_sw[1]|l_sw[2]|l_sw[3]|l_sw[4]|l_sw[5]|l_sw[6]|l_sw[7]|l_sw[8]|l_sw[9]|out|pad|padres|vc|vcp|vdd|vddr|vip|vss|z
+ sg13_lv_nmos L=0.13u W=0.74u AS=0.2516p AD=0.2849p PS=2.16u PD=2.25u rfmode=0
M$379 \$69605 \$70011
+ BOTTOM|TOP|VGND|VSS|anode|cathode|core|h_sw[0]|h_sw[10]|h_sw[1]|h_sw[2]|h_sw[3]|h_sw[4]|h_sw[5]|h_sw[6]|h_sw[7]|h_sw[8]|h_sw[9]|l_sw[0]|l_sw[10]|l_sw[1]|l_sw[2]|l_sw[3]|l_sw[4]|l_sw[5]|l_sw[6]|l_sw[7]|l_sw[8]|l_sw[9]|out|pad|padres|vc|vcp|vdd|vddr|vip|vss|z
+ BOTTOM|TOP|VGND|VSS|anode|cathode|core|h_sw[0]|h_sw[10]|h_sw[1]|h_sw[2]|h_sw[3]|h_sw[4]|h_sw[5]|h_sw[6]|h_sw[7]|h_sw[8]|h_sw[9]|l_sw[0]|l_sw[10]|l_sw[1]|l_sw[2]|l_sw[3]|l_sw[4]|l_sw[5]|l_sw[6]|l_sw[7]|l_sw[8]|l_sw[9]|out|pad|padres|vc|vcp|vdd|vddr|vip|vss|z
+ sg13_lv_nmos L=0.13u W=0.74u AS=0.2516p AD=0.1406p PS=2.16u PD=1.12u rfmode=0
M$380
+ BOTTOM|TOP|VGND|VSS|anode|cathode|core|h_sw[0]|h_sw[10]|h_sw[1]|h_sw[2]|h_sw[3]|h_sw[4]|h_sw[5]|h_sw[6]|h_sw[7]|h_sw[8]|h_sw[9]|l_sw[0]|l_sw[10]|l_sw[1]|l_sw[2]|l_sw[3]|l_sw[4]|l_sw[5]|l_sw[6]|l_sw[7]|l_sw[8]|l_sw[9]|out|pad|padres|vc|vcp|vdd|vddr|vip|vss|z
+ \$69605 A|B|B_N|Q
+ BOTTOM|TOP|VGND|VSS|anode|cathode|core|h_sw[0]|h_sw[10]|h_sw[1]|h_sw[2]|h_sw[3]|h_sw[4]|h_sw[5]|h_sw[6]|h_sw[7]|h_sw[8]|h_sw[9]|l_sw[0]|l_sw[10]|l_sw[1]|l_sw[2]|l_sw[3]|l_sw[4]|l_sw[5]|l_sw[6]|l_sw[7]|l_sw[8]|l_sw[9]|out|pad|padres|vc|vcp|vdd|vddr|vip|vss|z
+ sg13_lv_nmos L=0.13u W=0.74u AS=0.1406p AD=0.2516p PS=1.12u PD=2.16u rfmode=0
M$381 \$69606 A|Y$13
+ BOTTOM|TOP|VGND|VSS|anode|cathode|core|h_sw[0]|h_sw[10]|h_sw[1]|h_sw[2]|h_sw[3]|h_sw[4]|h_sw[5]|h_sw[6]|h_sw[7]|h_sw[8]|h_sw[9]|l_sw[0]|l_sw[10]|l_sw[1]|l_sw[2]|l_sw[3]|l_sw[4]|l_sw[5]|l_sw[6]|l_sw[7]|l_sw[8]|l_sw[9]|out|pad|padres|vc|vcp|vdd|vddr|vip|vss|z
+ BOTTOM|TOP|VGND|VSS|anode|cathode|core|h_sw[0]|h_sw[10]|h_sw[1]|h_sw[2]|h_sw[3]|h_sw[4]|h_sw[5]|h_sw[6]|h_sw[7]|h_sw[8]|h_sw[9]|l_sw[0]|l_sw[10]|l_sw[1]|l_sw[2]|l_sw[3]|l_sw[4]|l_sw[5]|l_sw[6]|l_sw[7]|l_sw[8]|l_sw[9]|out|pad|padres|vc|vcp|vdd|vddr|vip|vss|z
+ sg13_lv_nmos L=0.13u W=0.55u AS=0.187p AD=0.14875p PS=1.78u PD=1.16u rfmode=0
M$382
+ BOTTOM|TOP|VGND|VSS|anode|cathode|core|h_sw[0]|h_sw[10]|h_sw[1]|h_sw[2]|h_sw[3]|h_sw[4]|h_sw[5]|h_sw[6]|h_sw[7]|h_sw[8]|h_sw[9]|l_sw[0]|l_sw[10]|l_sw[1]|l_sw[2]|l_sw[3]|l_sw[4]|l_sw[5]|l_sw[6]|l_sw[7]|l_sw[8]|l_sw[9]|out|pad|padres|vc|vcp|vdd|vddr|vip|vss|z
+ \$69606 A|X$30
+ BOTTOM|TOP|VGND|VSS|anode|cathode|core|h_sw[0]|h_sw[10]|h_sw[1]|h_sw[2]|h_sw[3]|h_sw[4]|h_sw[5]|h_sw[6]|h_sw[7]|h_sw[8]|h_sw[9]|l_sw[0]|l_sw[10]|l_sw[1]|l_sw[2]|l_sw[3]|l_sw[4]|l_sw[5]|l_sw[6]|l_sw[7]|l_sw[8]|l_sw[9]|out|pad|padres|vc|vcp|vdd|vddr|vip|vss|z
+ sg13_lv_nmos L=0.13u W=0.74u AS=0.14875p AD=0.2886p PS=1.16u PD=2.26u rfmode=0
M$383 \$69608 A|X$32
+ BOTTOM|TOP|VGND|VSS|anode|cathode|core|h_sw[0]|h_sw[10]|h_sw[1]|h_sw[2]|h_sw[3]|h_sw[4]|h_sw[5]|h_sw[6]|h_sw[7]|h_sw[8]|h_sw[9]|l_sw[0]|l_sw[10]|l_sw[1]|l_sw[2]|l_sw[3]|l_sw[4]|l_sw[5]|l_sw[6]|l_sw[7]|l_sw[8]|l_sw[9]|out|pad|padres|vc|vcp|vdd|vddr|vip|vss|z
+ BOTTOM|TOP|VGND|VSS|anode|cathode|core|h_sw[0]|h_sw[10]|h_sw[1]|h_sw[2]|h_sw[3]|h_sw[4]|h_sw[5]|h_sw[6]|h_sw[7]|h_sw[8]|h_sw[9]|l_sw[0]|l_sw[10]|l_sw[1]|l_sw[2]|l_sw[3]|l_sw[4]|l_sw[5]|l_sw[6]|l_sw[7]|l_sw[8]|l_sw[9]|out|pad|padres|vc|vcp|vdd|vddr|vip|vss|z
+ sg13_lv_nmos L=0.13u W=0.55u AS=0.187p AD=0.14875p PS=1.78u PD=1.16u rfmode=0
M$384
+ BOTTOM|TOP|VGND|VSS|anode|cathode|core|h_sw[0]|h_sw[10]|h_sw[1]|h_sw[2]|h_sw[3]|h_sw[4]|h_sw[5]|h_sw[6]|h_sw[7]|h_sw[8]|h_sw[9]|l_sw[0]|l_sw[10]|l_sw[1]|l_sw[2]|l_sw[3]|l_sw[4]|l_sw[5]|l_sw[6]|l_sw[7]|l_sw[8]|l_sw[9]|out|pad|padres|vc|vcp|vdd|vddr|vip|vss|z
+ \$69608 A|X$31
+ BOTTOM|TOP|VGND|VSS|anode|cathode|core|h_sw[0]|h_sw[10]|h_sw[1]|h_sw[2]|h_sw[3]|h_sw[4]|h_sw[5]|h_sw[6]|h_sw[7]|h_sw[8]|h_sw[9]|l_sw[0]|l_sw[10]|l_sw[1]|l_sw[2]|l_sw[3]|l_sw[4]|l_sw[5]|l_sw[6]|l_sw[7]|l_sw[8]|l_sw[9]|out|pad|padres|vc|vcp|vdd|vddr|vip|vss|z
+ sg13_lv_nmos L=0.13u W=0.74u AS=0.14875p AD=0.2886p PS=1.16u PD=2.26u rfmode=0
M$385
+ BOTTOM|TOP|VGND|VSS|anode|cathode|core|h_sw[0]|h_sw[10]|h_sw[1]|h_sw[2]|h_sw[3]|h_sw[4]|h_sw[5]|h_sw[6]|h_sw[7]|h_sw[8]|h_sw[9]|l_sw[0]|l_sw[10]|l_sw[1]|l_sw[2]|l_sw[3]|l_sw[4]|l_sw[5]|l_sw[6]|l_sw[7]|l_sw[8]|l_sw[9]|out|pad|padres|vc|vcp|vdd|vddr|vip|vss|z
+ A|X$30 \$69610
+ BOTTOM|TOP|VGND|VSS|anode|cathode|core|h_sw[0]|h_sw[10]|h_sw[1]|h_sw[2]|h_sw[3]|h_sw[4]|h_sw[5]|h_sw[6]|h_sw[7]|h_sw[8]|h_sw[9]|l_sw[0]|l_sw[10]|l_sw[1]|l_sw[2]|l_sw[3]|l_sw[4]|l_sw[5]|l_sw[6]|l_sw[7]|l_sw[8]|l_sw[9]|out|pad|padres|vc|vcp|vdd|vddr|vip|vss|z
+ sg13_lv_nmos L=0.13u W=0.55u AS=0.14875p AD=0.187p PS=1.16u PD=1.78u rfmode=0
M$386 X|in_l_sw[9]|nl_sw[9]|x \$69610
+ BOTTOM|TOP|VGND|VSS|anode|cathode|core|h_sw[0]|h_sw[10]|h_sw[1]|h_sw[2]|h_sw[3]|h_sw[4]|h_sw[5]|h_sw[6]|h_sw[7]|h_sw[8]|h_sw[9]|l_sw[0]|l_sw[10]|l_sw[1]|l_sw[2]|l_sw[3]|l_sw[4]|l_sw[5]|l_sw[6]|l_sw[7]|l_sw[8]|l_sw[9]|out|pad|padres|vc|vcp|vdd|vddr|vip|vss|z
+ BOTTOM|TOP|VGND|VSS|anode|cathode|core|h_sw[0]|h_sw[10]|h_sw[1]|h_sw[2]|h_sw[3]|h_sw[4]|h_sw[5]|h_sw[6]|h_sw[7]|h_sw[8]|h_sw[9]|l_sw[0]|l_sw[10]|l_sw[1]|l_sw[2]|l_sw[3]|l_sw[4]|l_sw[5]|l_sw[6]|l_sw[7]|l_sw[8]|l_sw[9]|out|pad|padres|vc|vcp|vdd|vddr|vip|vss|z
+ sg13_lv_nmos L=0.13u W=0.74u AS=0.2886p AD=0.14875p PS=2.26u PD=1.16u rfmode=0
M$387
+ BOTTOM|TOP|VGND|VSS|anode|cathode|core|h_sw[0]|h_sw[10]|h_sw[1]|h_sw[2]|h_sw[3]|h_sw[4]|h_sw[5]|h_sw[6]|h_sw[7]|h_sw[8]|h_sw[9]|l_sw[0]|l_sw[10]|l_sw[1]|l_sw[2]|l_sw[3]|l_sw[4]|l_sw[5]|l_sw[6]|l_sw[7]|l_sw[8]|l_sw[9]|out|pad|padres|vc|vcp|vdd|vddr|vip|vss|z
+ A|X$31 \$69611
+ BOTTOM|TOP|VGND|VSS|anode|cathode|core|h_sw[0]|h_sw[10]|h_sw[1]|h_sw[2]|h_sw[3]|h_sw[4]|h_sw[5]|h_sw[6]|h_sw[7]|h_sw[8]|h_sw[9]|l_sw[0]|l_sw[10]|l_sw[1]|l_sw[2]|l_sw[3]|l_sw[4]|l_sw[5]|l_sw[6]|l_sw[7]|l_sw[8]|l_sw[9]|out|pad|padres|vc|vcp|vdd|vddr|vip|vss|z
+ sg13_lv_nmos L=0.13u W=0.55u AS=0.14875p AD=0.187p PS=1.16u PD=1.78u rfmode=0
M$388 X|in_h_sw[9]|nh_sw[9]|x \$69611
+ BOTTOM|TOP|VGND|VSS|anode|cathode|core|h_sw[0]|h_sw[10]|h_sw[1]|h_sw[2]|h_sw[3]|h_sw[4]|h_sw[5]|h_sw[6]|h_sw[7]|h_sw[8]|h_sw[9]|l_sw[0]|l_sw[10]|l_sw[1]|l_sw[2]|l_sw[3]|l_sw[4]|l_sw[5]|l_sw[6]|l_sw[7]|l_sw[8]|l_sw[9]|out|pad|padres|vc|vcp|vdd|vddr|vip|vss|z
+ BOTTOM|TOP|VGND|VSS|anode|cathode|core|h_sw[0]|h_sw[10]|h_sw[1]|h_sw[2]|h_sw[3]|h_sw[4]|h_sw[5]|h_sw[6]|h_sw[7]|h_sw[8]|h_sw[9]|l_sw[0]|l_sw[10]|l_sw[1]|l_sw[2]|l_sw[3]|l_sw[4]|l_sw[5]|l_sw[6]|l_sw[7]|l_sw[8]|l_sw[9]|out|pad|padres|vc|vcp|vdd|vddr|vip|vss|z
+ sg13_lv_nmos L=0.13u W=0.74u AS=0.2886p AD=0.14875p PS=2.26u PD=1.16u rfmode=0
M$389
+ BOTTOM|TOP|VGND|VSS|anode|cathode|core|h_sw[0]|h_sw[10]|h_sw[1]|h_sw[2]|h_sw[3]|h_sw[4]|h_sw[5]|h_sw[6]|h_sw[7]|h_sw[8]|h_sw[9]|l_sw[0]|l_sw[10]|l_sw[1]|l_sw[2]|l_sw[3]|l_sw[4]|l_sw[5]|l_sw[6]|l_sw[7]|l_sw[8]|l_sw[9]|out|pad|padres|vc|vcp|vdd|vddr|vip|vss|z
+ A|X$15 \$69612
+ BOTTOM|TOP|VGND|VSS|anode|cathode|core|h_sw[0]|h_sw[10]|h_sw[1]|h_sw[2]|h_sw[3]|h_sw[4]|h_sw[5]|h_sw[6]|h_sw[7]|h_sw[8]|h_sw[9]|l_sw[0]|l_sw[10]|l_sw[1]|l_sw[2]|l_sw[3]|l_sw[4]|l_sw[5]|l_sw[6]|l_sw[7]|l_sw[8]|l_sw[9]|out|pad|padres|vc|vcp|vdd|vddr|vip|vss|z
+ sg13_lv_nmos L=0.13u W=0.55u AS=0.14875p AD=0.187p PS=1.16u PD=1.78u rfmode=0
M$390 X|in_l_sw[10]|nl_sw[10]|x \$69612
+ BOTTOM|TOP|VGND|VSS|anode|cathode|core|h_sw[0]|h_sw[10]|h_sw[1]|h_sw[2]|h_sw[3]|h_sw[4]|h_sw[5]|h_sw[6]|h_sw[7]|h_sw[8]|h_sw[9]|l_sw[0]|l_sw[10]|l_sw[1]|l_sw[2]|l_sw[3]|l_sw[4]|l_sw[5]|l_sw[6]|l_sw[7]|l_sw[8]|l_sw[9]|out|pad|padres|vc|vcp|vdd|vddr|vip|vss|z
+ BOTTOM|TOP|VGND|VSS|anode|cathode|core|h_sw[0]|h_sw[10]|h_sw[1]|h_sw[2]|h_sw[3]|h_sw[4]|h_sw[5]|h_sw[6]|h_sw[7]|h_sw[8]|h_sw[9]|l_sw[0]|l_sw[10]|l_sw[1]|l_sw[2]|l_sw[3]|l_sw[4]|l_sw[5]|l_sw[6]|l_sw[7]|l_sw[8]|l_sw[9]|out|pad|padres|vc|vcp|vdd|vddr|vip|vss|z
+ sg13_lv_nmos L=0.13u W=0.74u AS=0.2886p AD=0.14875p PS=2.26u PD=1.16u rfmode=0
M$391 \$69613 A|Q$1
+ BOTTOM|TOP|VGND|VSS|anode|cathode|core|h_sw[0]|h_sw[10]|h_sw[1]|h_sw[2]|h_sw[3]|h_sw[4]|h_sw[5]|h_sw[6]|h_sw[7]|h_sw[8]|h_sw[9]|l_sw[0]|l_sw[10]|l_sw[1]|l_sw[2]|l_sw[3]|l_sw[4]|l_sw[5]|l_sw[6]|l_sw[7]|l_sw[8]|l_sw[9]|out|pad|padres|vc|vcp|vdd|vddr|vip|vss|z
+ BOTTOM|TOP|VGND|VSS|anode|cathode|core|h_sw[0]|h_sw[10]|h_sw[1]|h_sw[2]|h_sw[3]|h_sw[4]|h_sw[5]|h_sw[6]|h_sw[7]|h_sw[8]|h_sw[9]|l_sw[0]|l_sw[10]|l_sw[1]|l_sw[2]|l_sw[3]|l_sw[4]|l_sw[5]|l_sw[6]|l_sw[7]|l_sw[8]|l_sw[9]|out|pad|padres|vc|vcp|vdd|vddr|vip|vss|z
+ sg13_lv_nmos L=0.13u W=0.55u AS=0.187p AD=0.14875p PS=1.78u PD=1.16u rfmode=0
M$392
+ BOTTOM|TOP|VGND|VSS|anode|cathode|core|h_sw[0]|h_sw[10]|h_sw[1]|h_sw[2]|h_sw[3]|h_sw[4]|h_sw[5]|h_sw[6]|h_sw[7]|h_sw[8]|h_sw[9]|l_sw[0]|l_sw[10]|l_sw[1]|l_sw[2]|l_sw[3]|l_sw[4]|l_sw[5]|l_sw[6]|l_sw[7]|l_sw[8]|l_sw[9]|out|pad|padres|vc|vcp|vdd|vddr|vip|vss|z
+ \$69613 X|anode|cathode|core|d_out[0]|dout[0]|pad|padres
+ BOTTOM|TOP|VGND|VSS|anode|cathode|core|h_sw[0]|h_sw[10]|h_sw[1]|h_sw[2]|h_sw[3]|h_sw[4]|h_sw[5]|h_sw[6]|h_sw[7]|h_sw[8]|h_sw[9]|l_sw[0]|l_sw[10]|l_sw[1]|l_sw[2]|l_sw[3]|l_sw[4]|l_sw[5]|l_sw[6]|l_sw[7]|l_sw[8]|l_sw[9]|out|pad|padres|vc|vcp|vdd|vddr|vip|vss|z
+ sg13_lv_nmos L=0.13u W=0.74u AS=0.14875p AD=0.2886p PS=1.16u PD=2.26u rfmode=0
M$393
+ BOTTOM|TOP|VGND|VSS|anode|cathode|core|h_sw[0]|h_sw[10]|h_sw[1]|h_sw[2]|h_sw[3]|h_sw[4]|h_sw[5]|h_sw[6]|h_sw[7]|h_sw[8]|h_sw[9]|l_sw[0]|l_sw[10]|l_sw[1]|l_sw[2]|l_sw[3]|l_sw[4]|l_sw[5]|l_sw[6]|l_sw[7]|l_sw[8]|l_sw[9]|out|pad|padres|vc|vcp|vdd|vddr|vip|vss|z
+ VDD|VPWR|vdd
+ BOTTOM|TOP|VGND|VSS|anode|cathode|core|h_sw[0]|h_sw[10]|h_sw[1]|h_sw[2]|h_sw[3]|h_sw[4]|h_sw[5]|h_sw[6]|h_sw[7]|h_sw[8]|h_sw[9]|l_sw[0]|l_sw[10]|l_sw[1]|l_sw[2]|l_sw[3]|l_sw[4]|l_sw[5]|l_sw[6]|l_sw[7]|l_sw[8]|l_sw[9]|out|pad|padres|vc|vcp|vdd|vddr|vip|vss|z
+ BOTTOM|TOP|VGND|VSS|anode|cathode|core|h_sw[0]|h_sw[10]|h_sw[1]|h_sw[2]|h_sw[3]|h_sw[4]|h_sw[5]|h_sw[6]|h_sw[7]|h_sw[8]|h_sw[9]|l_sw[0]|l_sw[10]|l_sw[1]|l_sw[2]|l_sw[3]|l_sw[4]|l_sw[5]|l_sw[6]|l_sw[7]|l_sw[8]|l_sw[9]|out|pad|padres|vc|vcp|vdd|vddr|vip|vss|z
+ sg13_lv_nmos L=1u W=17.64u AS=5.1786p AD=5.1786p PS=54.48u PD=54.48u rfmode=0
M$394
+ BOTTOM|TOP|VGND|VSS|anode|cathode|core|h_sw[0]|h_sw[10]|h_sw[1]|h_sw[2]|h_sw[3]|h_sw[4]|h_sw[5]|h_sw[6]|h_sw[7]|h_sw[8]|h_sw[9]|l_sw[0]|l_sw[10]|l_sw[1]|l_sw[2]|l_sw[3]|l_sw[4]|l_sw[5]|l_sw[6]|l_sw[7]|l_sw[8]|l_sw[9]|out|pad|padres|vc|vcp|vdd|vddr|vip|vss|z
+ A|anode|cathode|ck|cks|core|pad|padres A|Y
+ BOTTOM|TOP|VGND|VSS|anode|cathode|core|h_sw[0]|h_sw[10]|h_sw[1]|h_sw[2]|h_sw[3]|h_sw[4]|h_sw[5]|h_sw[6]|h_sw[7]|h_sw[8]|h_sw[9]|l_sw[0]|l_sw[10]|l_sw[1]|l_sw[2]|l_sw[3]|l_sw[4]|l_sw[5]|l_sw[6]|l_sw[7]|l_sw[8]|l_sw[9]|out|pad|padres|vc|vcp|vdd|vddr|vip|vss|z
+ sg13_lv_nmos L=0.13u W=0.74u AS=0.2516p AD=0.2516p PS=2.16u PD=2.16u rfmode=0
M$395
+ BOTTOM|TOP|VGND|VSS|anode|cathode|core|h_sw[0]|h_sw[10]|h_sw[1]|h_sw[2]|h_sw[3]|h_sw[4]|h_sw[5]|h_sw[6]|h_sw[7]|h_sw[8]|h_sw[9]|l_sw[0]|l_sw[10]|l_sw[1]|l_sw[2]|l_sw[3]|l_sw[4]|l_sw[5]|l_sw[6]|l_sw[7]|l_sw[8]|l_sw[9]|out|pad|padres|vc|vcp|vdd|vddr|vip|vss|z
+ A|Y Y
+ BOTTOM|TOP|VGND|VSS|anode|cathode|core|h_sw[0]|h_sw[10]|h_sw[1]|h_sw[2]|h_sw[3]|h_sw[4]|h_sw[5]|h_sw[6]|h_sw[7]|h_sw[8]|h_sw[9]|l_sw[0]|l_sw[10]|l_sw[1]|l_sw[2]|l_sw[3]|l_sw[4]|l_sw[5]|l_sw[6]|l_sw[7]|l_sw[8]|l_sw[9]|out|pad|padres|vc|vcp|vdd|vddr|vip|vss|z
+ sg13_lv_nmos L=0.13u W=0.74u AS=0.2516p AD=0.2516p PS=2.16u PD=2.16u rfmode=0
M$398
+ BOTTOM|TOP|VGND|VSS|anode|cathode|core|h_sw[0]|h_sw[10]|h_sw[1]|h_sw[2]|h_sw[3]|h_sw[4]|h_sw[5]|h_sw[6]|h_sw[7]|h_sw[8]|h_sw[9]|l_sw[0]|l_sw[10]|l_sw[1]|l_sw[2]|l_sw[3]|l_sw[4]|l_sw[5]|l_sw[6]|l_sw[7]|l_sw[8]|l_sw[9]|out|pad|padres|vc|vcp|vdd|vddr|vip|vss|z
+ \$69576 \$69578
+ BOTTOM|TOP|VGND|VSS|anode|cathode|core|h_sw[0]|h_sw[10]|h_sw[1]|h_sw[2]|h_sw[3]|h_sw[4]|h_sw[5]|h_sw[6]|h_sw[7]|h_sw[8]|h_sw[9]|l_sw[0]|l_sw[10]|l_sw[1]|l_sw[2]|l_sw[3]|l_sw[4]|l_sw[5]|l_sw[6]|l_sw[7]|l_sw[8]|l_sw[9]|out|pad|padres|vc|vcp|vdd|vddr|vip|vss|z
+ sg13_lv_nmos L=0.13u W=0.55u AS=0.1491p AD=0.187p PS=1.18u PD=1.78u rfmode=0
M$399
+ BOTTOM|TOP|VGND|VSS|anode|cathode|core|h_sw[0]|h_sw[10]|h_sw[1]|h_sw[2]|h_sw[3]|h_sw[4]|h_sw[5]|h_sw[6]|h_sw[7]|h_sw[8]|h_sw[9]|l_sw[0]|l_sw[10]|l_sw[1]|l_sw[2]|l_sw[3]|l_sw[4]|l_sw[5]|l_sw[6]|l_sw[7]|l_sw[8]|l_sw[9]|out|pad|padres|vc|vcp|vdd|vddr|vip|vss|z
+ \$69578 Q_N$3
+ BOTTOM|TOP|VGND|VSS|anode|cathode|core|h_sw[0]|h_sw[10]|h_sw[1]|h_sw[2]|h_sw[3]|h_sw[4]|h_sw[5]|h_sw[6]|h_sw[7]|h_sw[8]|h_sw[9]|l_sw[0]|l_sw[10]|l_sw[1]|l_sw[2]|l_sw[3]|l_sw[4]|l_sw[5]|l_sw[6]|l_sw[7]|l_sw[8]|l_sw[9]|out|pad|padres|vc|vcp|vdd|vddr|vip|vss|z
+ sg13_lv_nmos L=0.13u W=0.74u AS=0.1491p AD=0.2516p PS=1.18u PD=2.16u rfmode=0
M$400
+ BOTTOM|TOP|VGND|VSS|anode|cathode|core|h_sw[0]|h_sw[10]|h_sw[1]|h_sw[2]|h_sw[3]|h_sw[4]|h_sw[5]|h_sw[6]|h_sw[7]|h_sw[8]|h_sw[9]|l_sw[0]|l_sw[10]|l_sw[1]|l_sw[2]|l_sw[3]|l_sw[4]|l_sw[5]|l_sw[6]|l_sw[7]|l_sw[8]|l_sw[9]|out|pad|padres|vc|vcp|vdd|vddr|vip|vss|z
+ \$69581 \$69580
+ BOTTOM|TOP|VGND|VSS|anode|cathode|core|h_sw[0]|h_sw[10]|h_sw[1]|h_sw[2]|h_sw[3]|h_sw[4]|h_sw[5]|h_sw[6]|h_sw[7]|h_sw[8]|h_sw[9]|l_sw[0]|l_sw[10]|l_sw[1]|l_sw[2]|l_sw[3]|l_sw[4]|l_sw[5]|l_sw[6]|l_sw[7]|l_sw[8]|l_sw[9]|out|pad|padres|vc|vcp|vdd|vddr|vip|vss|z
+ sg13_lv_nmos L=0.13u W=0.74u AS=0.1626p AD=0.2516p PS=1.415u PD=2.16u rfmode=0
M$401 \$69507 D|X \$70134
+ BOTTOM|TOP|VGND|VSS|anode|cathode|core|h_sw[0]|h_sw[10]|h_sw[1]|h_sw[2]|h_sw[3]|h_sw[4]|h_sw[5]|h_sw[6]|h_sw[7]|h_sw[8]|h_sw[9]|l_sw[0]|l_sw[10]|l_sw[1]|l_sw[2]|l_sw[3]|l_sw[4]|l_sw[5]|l_sw[6]|l_sw[7]|l_sw[8]|l_sw[9]|out|pad|padres|vc|vcp|vdd|vddr|vip|vss|z
+ sg13_lv_nmos L=0.13u W=0.42u AS=0.1428p AD=0.0609p PS=1.52u PD=0.71u rfmode=0
M$402
+ BOTTOM|TOP|VGND|VSS|anode|cathode|core|h_sw[0]|h_sw[10]|h_sw[1]|h_sw[2]|h_sw[3]|h_sw[4]|h_sw[5]|h_sw[6]|h_sw[7]|h_sw[8]|h_sw[9]|l_sw[0]|l_sw[10]|l_sw[1]|l_sw[2]|l_sw[3]|l_sw[4]|l_sw[5]|l_sw[6]|l_sw[7]|l_sw[8]|l_sw[9]|out|pad|padres|vc|vcp|vdd|vddr|vip|vss|z
+ RESET_B|Y$1 \$70134
+ BOTTOM|TOP|VGND|VSS|anode|cathode|core|h_sw[0]|h_sw[10]|h_sw[1]|h_sw[2]|h_sw[3]|h_sw[4]|h_sw[5]|h_sw[6]|h_sw[7]|h_sw[8]|h_sw[9]|l_sw[0]|l_sw[10]|l_sw[1]|l_sw[2]|l_sw[3]|l_sw[4]|l_sw[5]|l_sw[6]|l_sw[7]|l_sw[8]|l_sw[9]|out|pad|padres|vc|vcp|vdd|vddr|vip|vss|z
+ sg13_lv_nmos L=0.13u W=0.42u AS=0.1626p AD=0.0609p PS=1.415u PD=0.71u rfmode=0
M$403
+ BOTTOM|TOP|VGND|VSS|anode|cathode|core|h_sw[0]|h_sw[10]|h_sw[1]|h_sw[2]|h_sw[3]|h_sw[4]|h_sw[5]|h_sw[6]|h_sw[7]|h_sw[8]|h_sw[9]|l_sw[0]|l_sw[10]|l_sw[1]|l_sw[2]|l_sw[3]|l_sw[4]|l_sw[5]|l_sw[6]|l_sw[7]|l_sw[8]|l_sw[9]|out|pad|padres|vc|vcp|vdd|vddr|vip|vss|z
+ RESET_B|Y$1 \$70136
+ BOTTOM|TOP|VGND|VSS|anode|cathode|core|h_sw[0]|h_sw[10]|h_sw[1]|h_sw[2]|h_sw[3]|h_sw[4]|h_sw[5]|h_sw[6]|h_sw[7]|h_sw[8]|h_sw[9]|l_sw[0]|l_sw[10]|l_sw[1]|l_sw[2]|l_sw[3]|l_sw[4]|l_sw[5]|l_sw[6]|l_sw[7]|l_sw[8]|l_sw[9]|out|pad|padres|vc|vcp|vdd|vddr|vip|vss|z
+ sg13_lv_nmos L=0.13u W=0.42u AS=0.1701p AD=0.0378p PS=1.65u PD=0.6u rfmode=0
M$404 \$70136 \$69580 \$70003
+ BOTTOM|TOP|VGND|VSS|anode|cathode|core|h_sw[0]|h_sw[10]|h_sw[1]|h_sw[2]|h_sw[3]|h_sw[4]|h_sw[5]|h_sw[6]|h_sw[7]|h_sw[8]|h_sw[9]|l_sw[0]|l_sw[10]|l_sw[1]|l_sw[2]|l_sw[3]|l_sw[4]|l_sw[5]|l_sw[6]|l_sw[7]|l_sw[8]|l_sw[9]|out|pad|padres|vc|vcp|vdd|vddr|vip|vss|z
+ sg13_lv_nmos L=0.13u W=0.42u AS=0.0378p AD=0.1428p PS=0.6u PD=1.52u rfmode=0
M$405 \$70012 \$69618
+ BOTTOM|TOP|VGND|VSS|anode|cathode|core|h_sw[0]|h_sw[10]|h_sw[1]|h_sw[2]|h_sw[3]|h_sw[4]|h_sw[5]|h_sw[6]|h_sw[7]|h_sw[8]|h_sw[9]|l_sw[0]|l_sw[10]|l_sw[1]|l_sw[2]|l_sw[3]|l_sw[4]|l_sw[5]|l_sw[6]|l_sw[7]|l_sw[8]|l_sw[9]|out|pad|padres|vc|vcp|vdd|vddr|vip|vss|z
+ BOTTOM|TOP|VGND|VSS|anode|cathode|core|h_sw[0]|h_sw[10]|h_sw[1]|h_sw[2]|h_sw[3]|h_sw[4]|h_sw[5]|h_sw[6]|h_sw[7]|h_sw[8]|h_sw[9]|l_sw[0]|l_sw[10]|l_sw[1]|l_sw[2]|l_sw[3]|l_sw[4]|l_sw[5]|l_sw[6]|l_sw[7]|l_sw[8]|l_sw[9]|out|pad|padres|vc|vcp|vdd|vddr|vip|vss|z
+ sg13_lv_nmos L=0.13u W=0.42u AS=0.1428p AD=0.0798p PS=1.52u PD=0.8u rfmode=0
M$406
+ BOTTOM|TOP|VGND|VSS|anode|cathode|core|h_sw[0]|h_sw[10]|h_sw[1]|h_sw[2]|h_sw[3]|h_sw[4]|h_sw[5]|h_sw[6]|h_sw[7]|h_sw[8]|h_sw[9]|l_sw[0]|l_sw[10]|l_sw[1]|l_sw[2]|l_sw[3]|l_sw[4]|l_sw[5]|l_sw[6]|l_sw[7]|l_sw[8]|l_sw[9]|out|pad|padres|vc|vcp|vdd|vddr|vip|vss|z
+ RESET_B|Y$1 \$70138
+ BOTTOM|TOP|VGND|VSS|anode|cathode|core|h_sw[0]|h_sw[10]|h_sw[1]|h_sw[2]|h_sw[3]|h_sw[4]|h_sw[5]|h_sw[6]|h_sw[7]|h_sw[8]|h_sw[9]|l_sw[0]|l_sw[10]|l_sw[1]|l_sw[2]|l_sw[3]|l_sw[4]|l_sw[5]|l_sw[6]|l_sw[7]|l_sw[8]|l_sw[9]|out|pad|padres|vc|vcp|vdd|vddr|vip|vss|z
+ sg13_lv_nmos L=0.13u W=0.42u AS=0.0798p AD=0.0378p PS=0.8u PD=0.6u rfmode=0
M$407 \$70138 \$70005 \$69618
+ BOTTOM|TOP|VGND|VSS|anode|cathode|core|h_sw[0]|h_sw[10]|h_sw[1]|h_sw[2]|h_sw[3]|h_sw[4]|h_sw[5]|h_sw[6]|h_sw[7]|h_sw[8]|h_sw[9]|l_sw[0]|l_sw[10]|l_sw[1]|l_sw[2]|l_sw[3]|l_sw[4]|l_sw[5]|l_sw[6]|l_sw[7]|l_sw[8]|l_sw[9]|out|pad|padres|vc|vcp|vdd|vddr|vip|vss|z
+ sg13_lv_nmos L=0.13u W=0.42u AS=0.0378p AD=0.1428p PS=0.6u PD=1.52u rfmode=0
M$408
+ BOTTOM|TOP|VGND|VSS|anode|cathode|core|h_sw[0]|h_sw[10]|h_sw[1]|h_sw[2]|h_sw[3]|h_sw[4]|h_sw[5]|h_sw[6]|h_sw[7]|h_sw[8]|h_sw[9]|l_sw[0]|l_sw[10]|l_sw[1]|l_sw[2]|l_sw[3]|l_sw[4]|l_sw[5]|l_sw[6]|l_sw[7]|l_sw[8]|l_sw[9]|out|pad|padres|vc|vcp|vdd|vddr|vip|vss|z
+ B1|Y \$70162
+ BOTTOM|TOP|VGND|VSS|anode|cathode|core|h_sw[0]|h_sw[10]|h_sw[1]|h_sw[2]|h_sw[3]|h_sw[4]|h_sw[5]|h_sw[6]|h_sw[7]|h_sw[8]|h_sw[9]|l_sw[0]|l_sw[10]|l_sw[1]|l_sw[2]|l_sw[3]|l_sw[4]|l_sw[5]|l_sw[6]|l_sw[7]|l_sw[8]|l_sw[9]|out|pad|padres|vc|vcp|vdd|vddr|vip|vss|z
+ sg13_lv_nmos L=0.13u W=0.74u AS=0.2553p AD=0.13875p PS=2.17u PD=1.115u
+ rfmode=0
M$409 \$70162 B2|Y D|Y
+ BOTTOM|TOP|VGND|VSS|anode|cathode|core|h_sw[0]|h_sw[10]|h_sw[1]|h_sw[2]|h_sw[3]|h_sw[4]|h_sw[5]|h_sw[6]|h_sw[7]|h_sw[8]|h_sw[9]|l_sw[0]|l_sw[10]|l_sw[1]|l_sw[2]|l_sw[3]|l_sw[4]|l_sw[5]|l_sw[6]|l_sw[7]|l_sw[8]|l_sw[9]|out|pad|padres|vc|vcp|vdd|vddr|vip|vss|z
+ sg13_lv_nmos L=0.13u W=0.74u AS=0.13875p AD=0.2664p PS=1.115u PD=1.46u
+ rfmode=0
M$410 D|Y A1|Y \$70161
+ BOTTOM|TOP|VGND|VSS|anode|cathode|core|h_sw[0]|h_sw[10]|h_sw[1]|h_sw[2]|h_sw[3]|h_sw[4]|h_sw[5]|h_sw[6]|h_sw[7]|h_sw[8]|h_sw[9]|l_sw[0]|l_sw[10]|l_sw[1]|l_sw[2]|l_sw[3]|l_sw[4]|l_sw[5]|l_sw[6]|l_sw[7]|l_sw[8]|l_sw[9]|out|pad|padres|vc|vcp|vdd|vddr|vip|vss|z
+ sg13_lv_nmos L=0.13u W=0.74u AS=0.2664p AD=0.0962p PS=1.46u PD=1u rfmode=0
M$411 \$70161 A2|B|B1|Y
+ BOTTOM|TOP|VGND|VSS|anode|cathode|core|h_sw[0]|h_sw[10]|h_sw[1]|h_sw[2]|h_sw[3]|h_sw[4]|h_sw[5]|h_sw[6]|h_sw[7]|h_sw[8]|h_sw[9]|l_sw[0]|l_sw[10]|l_sw[1]|l_sw[2]|l_sw[3]|l_sw[4]|l_sw[5]|l_sw[6]|l_sw[7]|l_sw[8]|l_sw[9]|out|pad|padres|vc|vcp|vdd|vddr|vip|vss|z
+ BOTTOM|TOP|VGND|VSS|anode|cathode|core|h_sw[0]|h_sw[10]|h_sw[1]|h_sw[2]|h_sw[3]|h_sw[4]|h_sw[5]|h_sw[6]|h_sw[7]|h_sw[8]|h_sw[9]|l_sw[0]|l_sw[10]|l_sw[1]|l_sw[2]|l_sw[3]|l_sw[4]|l_sw[5]|l_sw[6]|l_sw[7]|l_sw[8]|l_sw[9]|out|pad|padres|vc|vcp|vdd|vddr|vip|vss|z
+ sg13_lv_nmos L=0.13u W=0.74u AS=0.0962p AD=0.2516p PS=1u PD=2.16u rfmode=0
M$412
+ BOTTOM|TOP|VGND|VSS|anode|cathode|core|h_sw[0]|h_sw[10]|h_sw[1]|h_sw[2]|h_sw[3]|h_sw[4]|h_sw[5]|h_sw[6]|h_sw[7]|h_sw[8]|h_sw[9]|l_sw[0]|l_sw[10]|l_sw[1]|l_sw[2]|l_sw[3]|l_sw[4]|l_sw[5]|l_sw[6]|l_sw[7]|l_sw[8]|l_sw[9]|out|pad|padres|vc|vcp|vdd|vddr|vip|vss|z
+ \$69594 \$69593
+ BOTTOM|TOP|VGND|VSS|anode|cathode|core|h_sw[0]|h_sw[10]|h_sw[1]|h_sw[2]|h_sw[3]|h_sw[4]|h_sw[5]|h_sw[6]|h_sw[7]|h_sw[8]|h_sw[9]|l_sw[0]|l_sw[10]|l_sw[1]|l_sw[2]|l_sw[3]|l_sw[4]|l_sw[5]|l_sw[6]|l_sw[7]|l_sw[8]|l_sw[9]|out|pad|padres|vc|vcp|vdd|vddr|vip|vss|z
+ sg13_lv_nmos L=0.13u W=0.74u AS=0.1626p AD=0.2516p PS=1.415u PD=2.16u rfmode=0
M$413 \$69510 D|Y$1 \$70163
+ BOTTOM|TOP|VGND|VSS|anode|cathode|core|h_sw[0]|h_sw[10]|h_sw[1]|h_sw[2]|h_sw[3]|h_sw[4]|h_sw[5]|h_sw[6]|h_sw[7]|h_sw[8]|h_sw[9]|l_sw[0]|l_sw[10]|l_sw[1]|l_sw[2]|l_sw[3]|l_sw[4]|l_sw[5]|l_sw[6]|l_sw[7]|l_sw[8]|l_sw[9]|out|pad|padres|vc|vcp|vdd|vddr|vip|vss|z
+ sg13_lv_nmos L=0.13u W=0.42u AS=0.1428p AD=0.0609p PS=1.52u PD=0.71u rfmode=0
M$414
+ BOTTOM|TOP|VGND|VSS|anode|cathode|core|h_sw[0]|h_sw[10]|h_sw[1]|h_sw[2]|h_sw[3]|h_sw[4]|h_sw[5]|h_sw[6]|h_sw[7]|h_sw[8]|h_sw[9]|l_sw[0]|l_sw[10]|l_sw[1]|l_sw[2]|l_sw[3]|l_sw[4]|l_sw[5]|l_sw[6]|l_sw[7]|l_sw[8]|l_sw[9]|out|pad|padres|vc|vcp|vdd|vddr|vip|vss|z
+ RESET_B|Y \$70163
+ BOTTOM|TOP|VGND|VSS|anode|cathode|core|h_sw[0]|h_sw[10]|h_sw[1]|h_sw[2]|h_sw[3]|h_sw[4]|h_sw[5]|h_sw[6]|h_sw[7]|h_sw[8]|h_sw[9]|l_sw[0]|l_sw[10]|l_sw[1]|l_sw[2]|l_sw[3]|l_sw[4]|l_sw[5]|l_sw[6]|l_sw[7]|l_sw[8]|l_sw[9]|out|pad|padres|vc|vcp|vdd|vddr|vip|vss|z
+ sg13_lv_nmos L=0.13u W=0.42u AS=0.1626p AD=0.0609p PS=1.415u PD=0.71u rfmode=0
M$415
+ BOTTOM|TOP|VGND|VSS|anode|cathode|core|h_sw[0]|h_sw[10]|h_sw[1]|h_sw[2]|h_sw[3]|h_sw[4]|h_sw[5]|h_sw[6]|h_sw[7]|h_sw[8]|h_sw[9]|l_sw[0]|l_sw[10]|l_sw[1]|l_sw[2]|l_sw[3]|l_sw[4]|l_sw[5]|l_sw[6]|l_sw[7]|l_sw[8]|l_sw[9]|out|pad|padres|vc|vcp|vdd|vddr|vip|vss|z
+ RESET_B|Y \$70164
+ BOTTOM|TOP|VGND|VSS|anode|cathode|core|h_sw[0]|h_sw[10]|h_sw[1]|h_sw[2]|h_sw[3]|h_sw[4]|h_sw[5]|h_sw[6]|h_sw[7]|h_sw[8]|h_sw[9]|l_sw[0]|l_sw[10]|l_sw[1]|l_sw[2]|l_sw[3]|l_sw[4]|l_sw[5]|l_sw[6]|l_sw[7]|l_sw[8]|l_sw[9]|out|pad|padres|vc|vcp|vdd|vddr|vip|vss|z
+ sg13_lv_nmos L=0.13u W=0.42u AS=0.1701p AD=0.0378p PS=1.65u PD=0.6u rfmode=0
M$416 \$70164 \$69593 \$70008
+ BOTTOM|TOP|VGND|VSS|anode|cathode|core|h_sw[0]|h_sw[10]|h_sw[1]|h_sw[2]|h_sw[3]|h_sw[4]|h_sw[5]|h_sw[6]|h_sw[7]|h_sw[8]|h_sw[9]|l_sw[0]|l_sw[10]|l_sw[1]|l_sw[2]|l_sw[3]|l_sw[4]|l_sw[5]|l_sw[6]|l_sw[7]|l_sw[8]|l_sw[9]|out|pad|padres|vc|vcp|vdd|vddr|vip|vss|z
+ sg13_lv_nmos L=0.13u W=0.42u AS=0.0378p AD=0.1428p PS=0.6u PD=1.52u rfmode=0
M$417 \$70013 \$69623
+ BOTTOM|TOP|VGND|VSS|anode|cathode|core|h_sw[0]|h_sw[10]|h_sw[1]|h_sw[2]|h_sw[3]|h_sw[4]|h_sw[5]|h_sw[6]|h_sw[7]|h_sw[8]|h_sw[9]|l_sw[0]|l_sw[10]|l_sw[1]|l_sw[2]|l_sw[3]|l_sw[4]|l_sw[5]|l_sw[6]|l_sw[7]|l_sw[8]|l_sw[9]|out|pad|padres|vc|vcp|vdd|vddr|vip|vss|z
+ BOTTOM|TOP|VGND|VSS|anode|cathode|core|h_sw[0]|h_sw[10]|h_sw[1]|h_sw[2]|h_sw[3]|h_sw[4]|h_sw[5]|h_sw[6]|h_sw[7]|h_sw[8]|h_sw[9]|l_sw[0]|l_sw[10]|l_sw[1]|l_sw[2]|l_sw[3]|l_sw[4]|l_sw[5]|l_sw[6]|l_sw[7]|l_sw[8]|l_sw[9]|out|pad|padres|vc|vcp|vdd|vddr|vip|vss|z
+ sg13_lv_nmos L=0.13u W=0.42u AS=0.1428p AD=0.0798p PS=1.52u PD=0.8u rfmode=0
M$418
+ BOTTOM|TOP|VGND|VSS|anode|cathode|core|h_sw[0]|h_sw[10]|h_sw[1]|h_sw[2]|h_sw[3]|h_sw[4]|h_sw[5]|h_sw[6]|h_sw[7]|h_sw[8]|h_sw[9]|l_sw[0]|l_sw[10]|l_sw[1]|l_sw[2]|l_sw[3]|l_sw[4]|l_sw[5]|l_sw[6]|l_sw[7]|l_sw[8]|l_sw[9]|out|pad|padres|vc|vcp|vdd|vddr|vip|vss|z
+ RESET_B|Y \$70165
+ BOTTOM|TOP|VGND|VSS|anode|cathode|core|h_sw[0]|h_sw[10]|h_sw[1]|h_sw[2]|h_sw[3]|h_sw[4]|h_sw[5]|h_sw[6]|h_sw[7]|h_sw[8]|h_sw[9]|l_sw[0]|l_sw[10]|l_sw[1]|l_sw[2]|l_sw[3]|l_sw[4]|l_sw[5]|l_sw[6]|l_sw[7]|l_sw[8]|l_sw[9]|out|pad|padres|vc|vcp|vdd|vddr|vip|vss|z
+ sg13_lv_nmos L=0.13u W=0.42u AS=0.0798p AD=0.0378p PS=0.8u PD=0.6u rfmode=0
M$419 \$70165 \$70009 \$69623
+ BOTTOM|TOP|VGND|VSS|anode|cathode|core|h_sw[0]|h_sw[10]|h_sw[1]|h_sw[2]|h_sw[3]|h_sw[4]|h_sw[5]|h_sw[6]|h_sw[7]|h_sw[8]|h_sw[9]|l_sw[0]|l_sw[10]|l_sw[1]|l_sw[2]|l_sw[3]|l_sw[4]|l_sw[5]|l_sw[6]|l_sw[7]|l_sw[8]|l_sw[9]|out|pad|padres|vc|vcp|vdd|vddr|vip|vss|z
+ sg13_lv_nmos L=0.13u W=0.42u AS=0.0378p AD=0.1428p PS=0.6u PD=1.52u rfmode=0
M$420
+ BOTTOM|TOP|VGND|VSS|anode|cathode|core|h_sw[0]|h_sw[10]|h_sw[1]|h_sw[2]|h_sw[3]|h_sw[4]|h_sw[5]|h_sw[6]|h_sw[7]|h_sw[8]|h_sw[9]|l_sw[0]|l_sw[10]|l_sw[1]|l_sw[2]|l_sw[3]|l_sw[4]|l_sw[5]|l_sw[6]|l_sw[7]|l_sw[8]|l_sw[9]|out|pad|padres|vc|vcp|vdd|vddr|vip|vss|z
+ \$69602 \$69601
+ BOTTOM|TOP|VGND|VSS|anode|cathode|core|h_sw[0]|h_sw[10]|h_sw[1]|h_sw[2]|h_sw[3]|h_sw[4]|h_sw[5]|h_sw[6]|h_sw[7]|h_sw[8]|h_sw[9]|l_sw[0]|l_sw[10]|l_sw[1]|l_sw[2]|l_sw[3]|l_sw[4]|l_sw[5]|l_sw[6]|l_sw[7]|l_sw[8]|l_sw[9]|out|pad|padres|vc|vcp|vdd|vddr|vip|vss|z
+ sg13_lv_nmos L=0.13u W=0.74u AS=0.1626p AD=0.2516p PS=1.415u PD=2.16u rfmode=0
M$421 \$69511 D|Y$2 \$70168
+ BOTTOM|TOP|VGND|VSS|anode|cathode|core|h_sw[0]|h_sw[10]|h_sw[1]|h_sw[2]|h_sw[3]|h_sw[4]|h_sw[5]|h_sw[6]|h_sw[7]|h_sw[8]|h_sw[9]|l_sw[0]|l_sw[10]|l_sw[1]|l_sw[2]|l_sw[3]|l_sw[4]|l_sw[5]|l_sw[6]|l_sw[7]|l_sw[8]|l_sw[9]|out|pad|padres|vc|vcp|vdd|vddr|vip|vss|z
+ sg13_lv_nmos L=0.13u W=0.42u AS=0.1428p AD=0.0609p PS=1.52u PD=0.71u rfmode=0
M$422
+ BOTTOM|TOP|VGND|VSS|anode|cathode|core|h_sw[0]|h_sw[10]|h_sw[1]|h_sw[2]|h_sw[3]|h_sw[4]|h_sw[5]|h_sw[6]|h_sw[7]|h_sw[8]|h_sw[9]|l_sw[0]|l_sw[10]|l_sw[1]|l_sw[2]|l_sw[3]|l_sw[4]|l_sw[5]|l_sw[6]|l_sw[7]|l_sw[8]|l_sw[9]|out|pad|padres|vc|vcp|vdd|vddr|vip|vss|z
+ RESET_B|Y \$70168
+ BOTTOM|TOP|VGND|VSS|anode|cathode|core|h_sw[0]|h_sw[10]|h_sw[1]|h_sw[2]|h_sw[3]|h_sw[4]|h_sw[5]|h_sw[6]|h_sw[7]|h_sw[8]|h_sw[9]|l_sw[0]|l_sw[10]|l_sw[1]|l_sw[2]|l_sw[3]|l_sw[4]|l_sw[5]|l_sw[6]|l_sw[7]|l_sw[8]|l_sw[9]|out|pad|padres|vc|vcp|vdd|vddr|vip|vss|z
+ sg13_lv_nmos L=0.13u W=0.42u AS=0.1626p AD=0.0609p PS=1.415u PD=0.71u rfmode=0
M$423
+ BOTTOM|TOP|VGND|VSS|anode|cathode|core|h_sw[0]|h_sw[10]|h_sw[1]|h_sw[2]|h_sw[3]|h_sw[4]|h_sw[5]|h_sw[6]|h_sw[7]|h_sw[8]|h_sw[9]|l_sw[0]|l_sw[10]|l_sw[1]|l_sw[2]|l_sw[3]|l_sw[4]|l_sw[5]|l_sw[6]|l_sw[7]|l_sw[8]|l_sw[9]|out|pad|padres|vc|vcp|vdd|vddr|vip|vss|z
+ RESET_B|Y \$70167
+ BOTTOM|TOP|VGND|VSS|anode|cathode|core|h_sw[0]|h_sw[10]|h_sw[1]|h_sw[2]|h_sw[3]|h_sw[4]|h_sw[5]|h_sw[6]|h_sw[7]|h_sw[8]|h_sw[9]|l_sw[0]|l_sw[10]|l_sw[1]|l_sw[2]|l_sw[3]|l_sw[4]|l_sw[5]|l_sw[6]|l_sw[7]|l_sw[8]|l_sw[9]|out|pad|padres|vc|vcp|vdd|vddr|vip|vss|z
+ sg13_lv_nmos L=0.13u W=0.42u AS=0.1701p AD=0.0378p PS=1.65u PD=0.6u rfmode=0
M$424 \$70167 \$69601 \$70010
+ BOTTOM|TOP|VGND|VSS|anode|cathode|core|h_sw[0]|h_sw[10]|h_sw[1]|h_sw[2]|h_sw[3]|h_sw[4]|h_sw[5]|h_sw[6]|h_sw[7]|h_sw[8]|h_sw[9]|l_sw[0]|l_sw[10]|l_sw[1]|l_sw[2]|l_sw[3]|l_sw[4]|l_sw[5]|l_sw[6]|l_sw[7]|l_sw[8]|l_sw[9]|out|pad|padres|vc|vcp|vdd|vddr|vip|vss|z
+ sg13_lv_nmos L=0.13u W=0.42u AS=0.0378p AD=0.1428p PS=0.6u PD=1.52u rfmode=0
M$425 \$70014 \$69625
+ BOTTOM|TOP|VGND|VSS|anode|cathode|core|h_sw[0]|h_sw[10]|h_sw[1]|h_sw[2]|h_sw[3]|h_sw[4]|h_sw[5]|h_sw[6]|h_sw[7]|h_sw[8]|h_sw[9]|l_sw[0]|l_sw[10]|l_sw[1]|l_sw[2]|l_sw[3]|l_sw[4]|l_sw[5]|l_sw[6]|l_sw[7]|l_sw[8]|l_sw[9]|out|pad|padres|vc|vcp|vdd|vddr|vip|vss|z
+ BOTTOM|TOP|VGND|VSS|anode|cathode|core|h_sw[0]|h_sw[10]|h_sw[1]|h_sw[2]|h_sw[3]|h_sw[4]|h_sw[5]|h_sw[6]|h_sw[7]|h_sw[8]|h_sw[9]|l_sw[0]|l_sw[10]|l_sw[1]|l_sw[2]|l_sw[3]|l_sw[4]|l_sw[5]|l_sw[6]|l_sw[7]|l_sw[8]|l_sw[9]|out|pad|padres|vc|vcp|vdd|vddr|vip|vss|z
+ sg13_lv_nmos L=0.13u W=0.42u AS=0.1428p AD=0.0798p PS=1.52u PD=0.8u rfmode=0
M$426
+ BOTTOM|TOP|VGND|VSS|anode|cathode|core|h_sw[0]|h_sw[10]|h_sw[1]|h_sw[2]|h_sw[3]|h_sw[4]|h_sw[5]|h_sw[6]|h_sw[7]|h_sw[8]|h_sw[9]|l_sw[0]|l_sw[10]|l_sw[1]|l_sw[2]|l_sw[3]|l_sw[4]|l_sw[5]|l_sw[6]|l_sw[7]|l_sw[8]|l_sw[9]|out|pad|padres|vc|vcp|vdd|vddr|vip|vss|z
+ RESET_B|Y \$70166
+ BOTTOM|TOP|VGND|VSS|anode|cathode|core|h_sw[0]|h_sw[10]|h_sw[1]|h_sw[2]|h_sw[3]|h_sw[4]|h_sw[5]|h_sw[6]|h_sw[7]|h_sw[8]|h_sw[9]|l_sw[0]|l_sw[10]|l_sw[1]|l_sw[2]|l_sw[3]|l_sw[4]|l_sw[5]|l_sw[6]|l_sw[7]|l_sw[8]|l_sw[9]|out|pad|padres|vc|vcp|vdd|vddr|vip|vss|z
+ sg13_lv_nmos L=0.13u W=0.42u AS=0.0798p AD=0.0378p PS=0.8u PD=0.6u rfmode=0
M$427 \$70166 \$70011 \$69625
+ BOTTOM|TOP|VGND|VSS|anode|cathode|core|h_sw[0]|h_sw[10]|h_sw[1]|h_sw[2]|h_sw[3]|h_sw[4]|h_sw[5]|h_sw[6]|h_sw[7]|h_sw[8]|h_sw[9]|l_sw[0]|l_sw[10]|l_sw[1]|l_sw[2]|l_sw[3]|l_sw[4]|l_sw[5]|l_sw[6]|l_sw[7]|l_sw[8]|l_sw[9]|out|pad|padres|vc|vcp|vdd|vddr|vip|vss|z
+ sg13_lv_nmos L=0.13u W=0.42u AS=0.0378p AD=0.1428p PS=0.6u PD=1.52u rfmode=0
M$428
+ BOTTOM|TOP|VGND|VSS|anode|cathode|core|h_sw[0]|h_sw[10]|h_sw[1]|h_sw[2]|h_sw[3]|h_sw[4]|h_sw[5]|h_sw[6]|h_sw[7]|h_sw[8]|h_sw[9]|l_sw[0]|l_sw[10]|l_sw[1]|l_sw[2]|l_sw[3]|l_sw[4]|l_sw[5]|l_sw[6]|l_sw[7]|l_sw[8]|l_sw[9]|out|pad|padres|vc|vcp|vdd|vddr|vip|vss|z
+ \$70177 \$70179
+ BOTTOM|TOP|VGND|VSS|anode|cathode|core|h_sw[0]|h_sw[10]|h_sw[1]|h_sw[2]|h_sw[3]|h_sw[4]|h_sw[5]|h_sw[6]|h_sw[7]|h_sw[8]|h_sw[9]|l_sw[0]|l_sw[10]|l_sw[1]|l_sw[2]|l_sw[3]|l_sw[4]|l_sw[5]|l_sw[6]|l_sw[7]|l_sw[8]|l_sw[9]|out|pad|padres|vc|vcp|vdd|vddr|vip|vss|z
+ sg13_lv_nmos L=0.13u W=0.55u AS=0.1491p AD=0.187p PS=1.18u PD=1.78u rfmode=0
M$429
+ BOTTOM|TOP|VGND|VSS|anode|cathode|core|h_sw[0]|h_sw[10]|h_sw[1]|h_sw[2]|h_sw[3]|h_sw[4]|h_sw[5]|h_sw[6]|h_sw[7]|h_sw[8]|h_sw[9]|l_sw[0]|l_sw[10]|l_sw[1]|l_sw[2]|l_sw[3]|l_sw[4]|l_sw[5]|l_sw[6]|l_sw[7]|l_sw[8]|l_sw[9]|out|pad|padres|vc|vcp|vdd|vddr|vip|vss|z
+ \$70179 Q_N$6
+ BOTTOM|TOP|VGND|VSS|anode|cathode|core|h_sw[0]|h_sw[10]|h_sw[1]|h_sw[2]|h_sw[3]|h_sw[4]|h_sw[5]|h_sw[6]|h_sw[7]|h_sw[8]|h_sw[9]|l_sw[0]|l_sw[10]|l_sw[1]|l_sw[2]|l_sw[3]|l_sw[4]|l_sw[5]|l_sw[6]|l_sw[7]|l_sw[8]|l_sw[9]|out|pad|padres|vc|vcp|vdd|vddr|vip|vss|z
+ sg13_lv_nmos L=0.13u W=0.74u AS=0.1491p AD=0.2516p PS=1.18u PD=2.16u rfmode=0
M$430
+ BOTTOM|TOP|VGND|VSS|anode|cathode|core|h_sw[0]|h_sw[10]|h_sw[1]|h_sw[2]|h_sw[3]|h_sw[4]|h_sw[5]|h_sw[6]|h_sw[7]|h_sw[8]|h_sw[9]|l_sw[0]|l_sw[10]|l_sw[1]|l_sw[2]|l_sw[3]|l_sw[4]|l_sw[5]|l_sw[6]|l_sw[7]|l_sw[8]|l_sw[9]|out|pad|padres|vc|vcp|vdd|vddr|vip|vss|z
+ \$70181 \$70182
+ BOTTOM|TOP|VGND|VSS|anode|cathode|core|h_sw[0]|h_sw[10]|h_sw[1]|h_sw[2]|h_sw[3]|h_sw[4]|h_sw[5]|h_sw[6]|h_sw[7]|h_sw[8]|h_sw[9]|l_sw[0]|l_sw[10]|l_sw[1]|l_sw[2]|l_sw[3]|l_sw[4]|l_sw[5]|l_sw[6]|l_sw[7]|l_sw[8]|l_sw[9]|out|pad|padres|vc|vcp|vdd|vddr|vip|vss|z
+ sg13_lv_nmos L=0.13u W=0.55u AS=0.1491p AD=0.187p PS=1.18u PD=1.78u rfmode=0
M$431
+ BOTTOM|TOP|VGND|VSS|anode|cathode|core|h_sw[0]|h_sw[10]|h_sw[1]|h_sw[2]|h_sw[3]|h_sw[4]|h_sw[5]|h_sw[6]|h_sw[7]|h_sw[8]|h_sw[9]|l_sw[0]|l_sw[10]|l_sw[1]|l_sw[2]|l_sw[3]|l_sw[4]|l_sw[5]|l_sw[6]|l_sw[7]|l_sw[8]|l_sw[9]|out|pad|padres|vc|vcp|vdd|vddr|vip|vss|z
+ \$70182 Q_N$7
+ BOTTOM|TOP|VGND|VSS|anode|cathode|core|h_sw[0]|h_sw[10]|h_sw[1]|h_sw[2]|h_sw[3]|h_sw[4]|h_sw[5]|h_sw[6]|h_sw[7]|h_sw[8]|h_sw[9]|l_sw[0]|l_sw[10]|l_sw[1]|l_sw[2]|l_sw[3]|l_sw[4]|l_sw[5]|l_sw[6]|l_sw[7]|l_sw[8]|l_sw[9]|out|pad|padres|vc|vcp|vdd|vddr|vip|vss|z
+ sg13_lv_nmos L=0.13u W=0.74u AS=0.1491p AD=0.2516p PS=1.18u PD=2.16u rfmode=0
M$432
+ BOTTOM|TOP|VGND|VSS|anode|cathode|core|h_sw[0]|h_sw[10]|h_sw[1]|h_sw[2]|h_sw[3]|h_sw[4]|h_sw[5]|h_sw[6]|h_sw[7]|h_sw[8]|h_sw[9]|l_sw[0]|l_sw[10]|l_sw[1]|l_sw[2]|l_sw[3]|l_sw[4]|l_sw[5]|l_sw[6]|l_sw[7]|l_sw[8]|l_sw[9]|out|pad|padres|vc|vcp|vdd|vddr|vip|vss|z
+ A|Y \$67665
+ BOTTOM|TOP|VGND|VSS|anode|cathode|core|h_sw[0]|h_sw[10]|h_sw[1]|h_sw[2]|h_sw[3]|h_sw[4]|h_sw[5]|h_sw[6]|h_sw[7]|h_sw[8]|h_sw[9]|l_sw[0]|l_sw[10]|l_sw[1]|l_sw[2]|l_sw[3]|l_sw[4]|l_sw[5]|l_sw[6]|l_sw[7]|l_sw[8]|l_sw[9]|out|pad|padres|vc|vcp|vdd|vddr|vip|vss|z
+ sg13_lv_nmos L=0.4u W=1.3u AS=0.442p AD=0.442p PS=3.28u PD=3.28u rfmode=0
M$433 \$70169 VDD|VPWR|vdd \$70170
+ BOTTOM|TOP|VGND|VSS|anode|cathode|core|h_sw[0]|h_sw[10]|h_sw[1]|h_sw[2]|h_sw[3]|h_sw[4]|h_sw[5]|h_sw[6]|h_sw[7]|h_sw[8]|h_sw[9]|l_sw[0]|l_sw[10]|l_sw[1]|l_sw[2]|l_sw[3]|l_sw[4]|l_sw[5]|l_sw[6]|l_sw[7]|l_sw[8]|l_sw[9]|out|pad|padres|vc|vcp|vdd|vddr|vip|vss|z
+ sg13_lv_nmos L=0.13u W=3u AS=1.02p AD=0.57p PS=6.68u PD=3.38u rfmode=0
M$434 \$70170 A|Y
+ BOTTOM|TOP|VGND|VSS|anode|cathode|core|h_sw[0]|h_sw[10]|h_sw[1]|h_sw[2]|h_sw[3]|h_sw[4]|h_sw[5]|h_sw[6]|h_sw[7]|h_sw[8]|h_sw[9]|l_sw[0]|l_sw[10]|l_sw[1]|l_sw[2]|l_sw[3]|l_sw[4]|l_sw[5]|l_sw[6]|l_sw[7]|l_sw[8]|l_sw[9]|out|pad|padres|vc|vcp|vdd|vddr|vip|vss|z
+ BOTTOM|TOP|VGND|VSS|anode|cathode|core|h_sw[0]|h_sw[10]|h_sw[1]|h_sw[2]|h_sw[3]|h_sw[4]|h_sw[5]|h_sw[6]|h_sw[7]|h_sw[8]|h_sw[9]|l_sw[0]|l_sw[10]|l_sw[1]|l_sw[2]|l_sw[3]|l_sw[4]|l_sw[5]|l_sw[6]|l_sw[7]|l_sw[8]|l_sw[9]|out|pad|padres|vc|vcp|vdd|vddr|vip|vss|z
+ sg13_lv_nmos L=0.13u W=3u AS=0.57p AD=1.02p PS=3.38u PD=6.68u rfmode=0
M$435
+ BOTTOM|TOP|VGND|VSS|anode|cathode|core|h_sw[0]|h_sw[10]|h_sw[1]|h_sw[2]|h_sw[3]|h_sw[4]|h_sw[5]|h_sw[6]|h_sw[7]|h_sw[8]|h_sw[9]|l_sw[0]|l_sw[10]|l_sw[1]|l_sw[2]|l_sw[3]|l_sw[4]|l_sw[5]|l_sw[6]|l_sw[7]|l_sw[8]|l_sw[9]|out|pad|padres|vc|vcp|vdd|vddr|vip|vss|z
+ A|Y \$70276
+ BOTTOM|TOP|VGND|VSS|anode|cathode|core|h_sw[0]|h_sw[10]|h_sw[1]|h_sw[2]|h_sw[3]|h_sw[4]|h_sw[5]|h_sw[6]|h_sw[7]|h_sw[8]|h_sw[9]|l_sw[0]|l_sw[10]|l_sw[1]|l_sw[2]|l_sw[3]|l_sw[4]|l_sw[5]|l_sw[6]|l_sw[7]|l_sw[8]|l_sw[9]|out|pad|padres|vc|vcp|vdd|vddr|vip|vss|z
+ sg13_lv_nmos L=0.13u W=0.5u AS=0.17p AD=0.095p PS=1.68u PD=0.88u rfmode=0
M$436 \$70276 VDD|VPWR|vdd \$70277
+ BOTTOM|TOP|VGND|VSS|anode|cathode|core|h_sw[0]|h_sw[10]|h_sw[1]|h_sw[2]|h_sw[3]|h_sw[4]|h_sw[5]|h_sw[6]|h_sw[7]|h_sw[8]|h_sw[9]|l_sw[0]|l_sw[10]|l_sw[1]|l_sw[2]|l_sw[3]|l_sw[4]|l_sw[5]|l_sw[6]|l_sw[7]|l_sw[8]|l_sw[9]|out|pad|padres|vc|vcp|vdd|vddr|vip|vss|z
+ sg13_lv_nmos L=0.13u W=0.5u AS=0.095p AD=0.17p PS=0.88u PD=1.68u rfmode=0
M$437 \$67665 \$70169 anode|cathode|core|in|pad|padres|vin
+ BOTTOM|TOP|VGND|VSS|anode|cathode|core|h_sw[0]|h_sw[10]|h_sw[1]|h_sw[2]|h_sw[3]|h_sw[4]|h_sw[5]|h_sw[6]|h_sw[7]|h_sw[8]|h_sw[9]|l_sw[0]|l_sw[10]|l_sw[1]|l_sw[2]|l_sw[3]|l_sw[4]|l_sw[5]|l_sw[6]|l_sw[7]|l_sw[8]|l_sw[9]|out|pad|padres|vc|vcp|vdd|vddr|vip|vss|z
+ sg13_lv_nmos L=0.13u W=3u AS=1.02p AD=1.02p PS=6.68u PD=6.68u rfmode=0
M$438 \$70177 \$70290 \$70317
+ BOTTOM|TOP|VGND|VSS|anode|cathode|core|h_sw[0]|h_sw[10]|h_sw[1]|h_sw[2]|h_sw[3]|h_sw[4]|h_sw[5]|h_sw[6]|h_sw[7]|h_sw[8]|h_sw[9]|l_sw[0]|l_sw[10]|l_sw[1]|l_sw[2]|l_sw[3]|l_sw[4]|l_sw[5]|l_sw[6]|l_sw[7]|l_sw[8]|l_sw[9]|out|pad|padres|vc|vcp|vdd|vddr|vip|vss|z
+ sg13_lv_nmos L=0.13u W=0.74u AS=0.2516p AD=0.0777p PS=2.16u PD=0.95u rfmode=0
M$439 \$70317 RESET_B|Y$1
+ BOTTOM|TOP|VGND|VSS|anode|cathode|core|h_sw[0]|h_sw[10]|h_sw[1]|h_sw[2]|h_sw[3]|h_sw[4]|h_sw[5]|h_sw[6]|h_sw[7]|h_sw[8]|h_sw[9]|l_sw[0]|l_sw[10]|l_sw[1]|l_sw[2]|l_sw[3]|l_sw[4]|l_sw[5]|l_sw[6]|l_sw[7]|l_sw[8]|l_sw[9]|out|pad|padres|vc|vcp|vdd|vddr|vip|vss|z
+ BOTTOM|TOP|VGND|VSS|anode|cathode|core|h_sw[0]|h_sw[10]|h_sw[1]|h_sw[2]|h_sw[3]|h_sw[4]|h_sw[5]|h_sw[6]|h_sw[7]|h_sw[8]|h_sw[9]|l_sw[0]|l_sw[10]|l_sw[1]|l_sw[2]|l_sw[3]|l_sw[4]|l_sw[5]|l_sw[6]|l_sw[7]|l_sw[8]|l_sw[9]|out|pad|padres|vc|vcp|vdd|vddr|vip|vss|z
+ sg13_lv_nmos L=0.13u W=0.74u AS=0.0777p AD=0.1406p PS=0.95u PD=1.12u rfmode=0
M$440
+ BOTTOM|TOP|VGND|VSS|anode|cathode|core|h_sw[0]|h_sw[10]|h_sw[1]|h_sw[2]|h_sw[3]|h_sw[4]|h_sw[5]|h_sw[6]|h_sw[7]|h_sw[8]|h_sw[9]|l_sw[0]|l_sw[10]|l_sw[1]|l_sw[2]|l_sw[3]|l_sw[4]|l_sw[5]|l_sw[6]|l_sw[7]|l_sw[8]|l_sw[9]|out|pad|padres|vc|vcp|vdd|vddr|vip|vss|z
+ \$70177 A|Q$4
+ BOTTOM|TOP|VGND|VSS|anode|cathode|core|h_sw[0]|h_sw[10]|h_sw[1]|h_sw[2]|h_sw[3]|h_sw[4]|h_sw[5]|h_sw[6]|h_sw[7]|h_sw[8]|h_sw[9]|l_sw[0]|l_sw[10]|l_sw[1]|l_sw[2]|l_sw[3]|l_sw[4]|l_sw[5]|l_sw[6]|l_sw[7]|l_sw[8]|l_sw[9]|out|pad|padres|vc|vcp|vdd|vddr|vip|vss|z
+ sg13_lv_nmos L=0.13u W=0.74u AS=0.1406p AD=0.2516p PS=1.12u PD=2.16u rfmode=0
M$441 \$70181 \$70294 \$70322
+ BOTTOM|TOP|VGND|VSS|anode|cathode|core|h_sw[0]|h_sw[10]|h_sw[1]|h_sw[2]|h_sw[3]|h_sw[4]|h_sw[5]|h_sw[6]|h_sw[7]|h_sw[8]|h_sw[9]|l_sw[0]|l_sw[10]|l_sw[1]|l_sw[2]|l_sw[3]|l_sw[4]|l_sw[5]|l_sw[6]|l_sw[7]|l_sw[8]|l_sw[9]|out|pad|padres|vc|vcp|vdd|vddr|vip|vss|z
+ sg13_lv_nmos L=0.13u W=0.74u AS=0.2516p AD=0.0777p PS=2.16u PD=0.95u rfmode=0
M$442 \$70322 RESET_B|Y$1
+ BOTTOM|TOP|VGND|VSS|anode|cathode|core|h_sw[0]|h_sw[10]|h_sw[1]|h_sw[2]|h_sw[3]|h_sw[4]|h_sw[5]|h_sw[6]|h_sw[7]|h_sw[8]|h_sw[9]|l_sw[0]|l_sw[10]|l_sw[1]|l_sw[2]|l_sw[3]|l_sw[4]|l_sw[5]|l_sw[6]|l_sw[7]|l_sw[8]|l_sw[9]|out|pad|padres|vc|vcp|vdd|vddr|vip|vss|z
+ BOTTOM|TOP|VGND|VSS|anode|cathode|core|h_sw[0]|h_sw[10]|h_sw[1]|h_sw[2]|h_sw[3]|h_sw[4]|h_sw[5]|h_sw[6]|h_sw[7]|h_sw[8]|h_sw[9]|l_sw[0]|l_sw[10]|l_sw[1]|l_sw[2]|l_sw[3]|l_sw[4]|l_sw[5]|l_sw[6]|l_sw[7]|l_sw[8]|l_sw[9]|out|pad|padres|vc|vcp|vdd|vddr|vip|vss|z
+ sg13_lv_nmos L=0.13u W=0.74u AS=0.0777p AD=0.1406p PS=0.95u PD=1.12u rfmode=0
M$443
+ BOTTOM|TOP|VGND|VSS|anode|cathode|core|h_sw[0]|h_sw[10]|h_sw[1]|h_sw[2]|h_sw[3]|h_sw[4]|h_sw[5]|h_sw[6]|h_sw[7]|h_sw[8]|h_sw[9]|l_sw[0]|l_sw[10]|l_sw[1]|l_sw[2]|l_sw[3]|l_sw[4]|l_sw[5]|l_sw[6]|l_sw[7]|l_sw[8]|l_sw[9]|out|pad|padres|vc|vcp|vdd|vddr|vip|vss|z
+ \$70181 A|Q$3
+ BOTTOM|TOP|VGND|VSS|anode|cathode|core|h_sw[0]|h_sw[10]|h_sw[1]|h_sw[2]|h_sw[3]|h_sw[4]|h_sw[5]|h_sw[6]|h_sw[7]|h_sw[8]|h_sw[9]|l_sw[0]|l_sw[10]|l_sw[1]|l_sw[2]|l_sw[3]|l_sw[4]|l_sw[5]|l_sw[6]|l_sw[7]|l_sw[8]|l_sw[9]|out|pad|padres|vc|vcp|vdd|vddr|vip|vss|z
+ sg13_lv_nmos L=0.13u W=0.74u AS=0.1406p AD=0.2516p PS=1.12u PD=2.16u rfmode=0
M$444
+ BOTTOM|TOP|VGND|VSS|anode|cathode|core|h_sw[0]|h_sw[10]|h_sw[1]|h_sw[2]|h_sw[3]|h_sw[4]|h_sw[5]|h_sw[6]|h_sw[7]|h_sw[8]|h_sw[9]|l_sw[0]|l_sw[10]|l_sw[1]|l_sw[2]|l_sw[3]|l_sw[4]|l_sw[5]|l_sw[6]|l_sw[7]|l_sw[8]|l_sw[9]|out|pad|padres|vc|vcp|vdd|vddr|vip|vss|z
+ A|X \$70283
+ BOTTOM|TOP|VGND|VSS|anode|cathode|core|h_sw[0]|h_sw[10]|h_sw[1]|h_sw[2]|h_sw[3]|h_sw[4]|h_sw[5]|h_sw[6]|h_sw[7]|h_sw[8]|h_sw[9]|l_sw[0]|l_sw[10]|l_sw[1]|l_sw[2]|l_sw[3]|l_sw[4]|l_sw[5]|l_sw[6]|l_sw[7]|l_sw[8]|l_sw[9]|out|pad|padres|vc|vcp|vdd|vddr|vip|vss|z
+ sg13_lv_nmos L=0.13u W=0.55u AS=0.14875p AD=0.187p PS=1.16u PD=1.78u rfmode=0
M$445
+ BOTTOM|TOP|VGND|VSS|anode|cathode|core|h_sw[0]|h_sw[10]|h_sw[1]|h_sw[2]|h_sw[3]|h_sw[4]|h_sw[5]|h_sw[6]|h_sw[7]|h_sw[8]|h_sw[9]|l_sw[0]|l_sw[10]|l_sw[1]|l_sw[2]|l_sw[3]|l_sw[4]|l_sw[5]|l_sw[6]|l_sw[7]|l_sw[8]|l_sw[9]|out|pad|padres|vc|vcp|vdd|vddr|vip|vss|z
+ \$70283 D|X
+ BOTTOM|TOP|VGND|VSS|anode|cathode|core|h_sw[0]|h_sw[10]|h_sw[1]|h_sw[2]|h_sw[3]|h_sw[4]|h_sw[5]|h_sw[6]|h_sw[7]|h_sw[8]|h_sw[9]|l_sw[0]|l_sw[10]|l_sw[1]|l_sw[2]|l_sw[3]|l_sw[4]|l_sw[5]|l_sw[6]|l_sw[7]|l_sw[8]|l_sw[9]|out|pad|padres|vc|vcp|vdd|vddr|vip|vss|z
+ sg13_lv_nmos L=0.13u W=0.74u AS=0.14875p AD=0.2886p PS=1.16u PD=2.26u rfmode=0
M$446 \$70285 D|X \$70314
+ BOTTOM|TOP|VGND|VSS|anode|cathode|core|h_sw[0]|h_sw[10]|h_sw[1]|h_sw[2]|h_sw[3]|h_sw[4]|h_sw[5]|h_sw[6]|h_sw[7]|h_sw[8]|h_sw[9]|l_sw[0]|l_sw[10]|l_sw[1]|l_sw[2]|l_sw[3]|l_sw[4]|l_sw[5]|l_sw[6]|l_sw[7]|l_sw[8]|l_sw[9]|out|pad|padres|vc|vcp|vdd|vddr|vip|vss|z
+ sg13_lv_nmos L=0.13u W=0.42u AS=0.1428p AD=0.0609p PS=1.52u PD=0.71u rfmode=0
M$447 \$70314 RESET_B|Y$1
+ BOTTOM|TOP|VGND|VSS|anode|cathode|core|h_sw[0]|h_sw[10]|h_sw[1]|h_sw[2]|h_sw[3]|h_sw[4]|h_sw[5]|h_sw[6]|h_sw[7]|h_sw[8]|h_sw[9]|l_sw[0]|l_sw[10]|l_sw[1]|l_sw[2]|l_sw[3]|l_sw[4]|l_sw[5]|l_sw[6]|l_sw[7]|l_sw[8]|l_sw[9]|out|pad|padres|vc|vcp|vdd|vddr|vip|vss|z
+ BOTTOM|TOP|VGND|VSS|anode|cathode|core|h_sw[0]|h_sw[10]|h_sw[1]|h_sw[2]|h_sw[3]|h_sw[4]|h_sw[5]|h_sw[6]|h_sw[7]|h_sw[8]|h_sw[9]|l_sw[0]|l_sw[10]|l_sw[1]|l_sw[2]|l_sw[3]|l_sw[4]|l_sw[5]|l_sw[6]|l_sw[7]|l_sw[8]|l_sw[9]|out|pad|padres|vc|vcp|vdd|vddr|vip|vss|z
+ sg13_lv_nmos L=0.13u W=0.42u AS=0.0609p AD=0.1626p PS=0.71u PD=1.415u rfmode=0
M$448
+ BOTTOM|TOP|VGND|VSS|anode|cathode|core|h_sw[0]|h_sw[10]|h_sw[1]|h_sw[2]|h_sw[3]|h_sw[4]|h_sw[5]|h_sw[6]|h_sw[7]|h_sw[8]|h_sw[9]|l_sw[0]|l_sw[10]|l_sw[1]|l_sw[2]|l_sw[3]|l_sw[4]|l_sw[5]|l_sw[6]|l_sw[7]|l_sw[8]|l_sw[9]|out|pad|padres|vc|vcp|vdd|vddr|vip|vss|z
+ \$70332 \$70171
+ BOTTOM|TOP|VGND|VSS|anode|cathode|core|h_sw[0]|h_sw[10]|h_sw[1]|h_sw[2]|h_sw[3]|h_sw[4]|h_sw[5]|h_sw[6]|h_sw[7]|h_sw[8]|h_sw[9]|l_sw[0]|l_sw[10]|l_sw[1]|l_sw[2]|l_sw[3]|l_sw[4]|l_sw[5]|l_sw[6]|l_sw[7]|l_sw[8]|l_sw[9]|out|pad|padres|vc|vcp|vdd|vddr|vip|vss|z
+ sg13_lv_nmos L=0.13u W=0.74u AS=0.1626p AD=0.2516p PS=1.415u PD=2.16u rfmode=0
M$449 \$70173 \$70174
+ BOTTOM|TOP|VGND|VSS|anode|cathode|core|h_sw[0]|h_sw[10]|h_sw[1]|h_sw[2]|h_sw[3]|h_sw[4]|h_sw[5]|h_sw[6]|h_sw[7]|h_sw[8]|h_sw[9]|l_sw[0]|l_sw[10]|l_sw[1]|l_sw[2]|l_sw[3]|l_sw[4]|l_sw[5]|l_sw[6]|l_sw[7]|l_sw[8]|l_sw[9]|out|pad|padres|vc|vcp|vdd|vddr|vip|vss|z
+ BOTTOM|TOP|VGND|VSS|anode|cathode|core|h_sw[0]|h_sw[10]|h_sw[1]|h_sw[2]|h_sw[3]|h_sw[4]|h_sw[5]|h_sw[6]|h_sw[7]|h_sw[8]|h_sw[9]|l_sw[0]|l_sw[10]|l_sw[1]|l_sw[2]|l_sw[3]|l_sw[4]|l_sw[5]|l_sw[6]|l_sw[7]|l_sw[8]|l_sw[9]|out|pad|padres|vc|vcp|vdd|vddr|vip|vss|z
+ sg13_lv_nmos L=0.13u W=0.42u AS=0.1428p AD=0.0798p PS=1.52u PD=0.8u rfmode=0
M$450
+ BOTTOM|TOP|VGND|VSS|anode|cathode|core|h_sw[0]|h_sw[10]|h_sw[1]|h_sw[2]|h_sw[3]|h_sw[4]|h_sw[5]|h_sw[6]|h_sw[7]|h_sw[8]|h_sw[9]|l_sw[0]|l_sw[10]|l_sw[1]|l_sw[2]|l_sw[3]|l_sw[4]|l_sw[5]|l_sw[6]|l_sw[7]|l_sw[8]|l_sw[9]|out|pad|padres|vc|vcp|vdd|vddr|vip|vss|z
+ RESET_B|Y$1 \$70315
+ BOTTOM|TOP|VGND|VSS|anode|cathode|core|h_sw[0]|h_sw[10]|h_sw[1]|h_sw[2]|h_sw[3]|h_sw[4]|h_sw[5]|h_sw[6]|h_sw[7]|h_sw[8]|h_sw[9]|l_sw[0]|l_sw[10]|l_sw[1]|l_sw[2]|l_sw[3]|l_sw[4]|l_sw[5]|l_sw[6]|l_sw[7]|l_sw[8]|l_sw[9]|out|pad|padres|vc|vcp|vdd|vddr|vip|vss|z
+ sg13_lv_nmos L=0.13u W=0.42u AS=0.0798p AD=0.0378p PS=0.8u PD=0.6u rfmode=0
M$451 \$70315 \$70286 \$70174
+ BOTTOM|TOP|VGND|VSS|anode|cathode|core|h_sw[0]|h_sw[10]|h_sw[1]|h_sw[2]|h_sw[3]|h_sw[4]|h_sw[5]|h_sw[6]|h_sw[7]|h_sw[8]|h_sw[9]|l_sw[0]|l_sw[10]|l_sw[1]|l_sw[2]|l_sw[3]|l_sw[4]|l_sw[5]|l_sw[6]|l_sw[7]|l_sw[8]|l_sw[9]|out|pad|padres|vc|vcp|vdd|vddr|vip|vss|z
+ sg13_lv_nmos L=0.13u W=0.42u AS=0.0378p AD=0.1428p PS=0.6u PD=1.52u rfmode=0
M$452
+ BOTTOM|TOP|VGND|VSS|anode|cathode|core|h_sw[0]|h_sw[10]|h_sw[1]|h_sw[2]|h_sw[3]|h_sw[4]|h_sw[5]|h_sw[6]|h_sw[7]|h_sw[8]|h_sw[9]|l_sw[0]|l_sw[10]|l_sw[1]|l_sw[2]|l_sw[3]|l_sw[4]|l_sw[5]|l_sw[6]|l_sw[7]|l_sw[8]|l_sw[9]|out|pad|padres|vc|vcp|vdd|vddr|vip|vss|z
+ \$70286 D|Q_N$1
+ BOTTOM|TOP|VGND|VSS|anode|cathode|core|h_sw[0]|h_sw[10]|h_sw[1]|h_sw[2]|h_sw[3]|h_sw[4]|h_sw[5]|h_sw[6]|h_sw[7]|h_sw[8]|h_sw[9]|l_sw[0]|l_sw[10]|l_sw[1]|l_sw[2]|l_sw[3]|l_sw[4]|l_sw[5]|l_sw[6]|l_sw[7]|l_sw[8]|l_sw[9]|out|pad|padres|vc|vcp|vdd|vddr|vip|vss|z
+ sg13_lv_nmos L=0.13u W=0.74u AS=0.2516p AD=0.2849p PS=2.16u PD=2.25u rfmode=0
M$453 \$70175 \$70286
+ BOTTOM|TOP|VGND|VSS|anode|cathode|core|h_sw[0]|h_sw[10]|h_sw[1]|h_sw[2]|h_sw[3]|h_sw[4]|h_sw[5]|h_sw[6]|h_sw[7]|h_sw[8]|h_sw[9]|l_sw[0]|l_sw[10]|l_sw[1]|l_sw[2]|l_sw[3]|l_sw[4]|l_sw[5]|l_sw[6]|l_sw[7]|l_sw[8]|l_sw[9]|out|pad|padres|vc|vcp|vdd|vddr|vip|vss|z
+ BOTTOM|TOP|VGND|VSS|anode|cathode|core|h_sw[0]|h_sw[10]|h_sw[1]|h_sw[2]|h_sw[3]|h_sw[4]|h_sw[5]|h_sw[6]|h_sw[7]|h_sw[8]|h_sw[9]|l_sw[0]|l_sw[10]|l_sw[1]|l_sw[2]|l_sw[3]|l_sw[4]|l_sw[5]|l_sw[6]|l_sw[7]|l_sw[8]|l_sw[9]|out|pad|padres|vc|vcp|vdd|vddr|vip|vss|z
+ sg13_lv_nmos L=0.13u W=0.74u AS=0.2516p AD=0.1406p PS=2.16u PD=1.12u rfmode=0
M$454
+ BOTTOM|TOP|VGND|VSS|anode|cathode|core|h_sw[0]|h_sw[10]|h_sw[1]|h_sw[2]|h_sw[3]|h_sw[4]|h_sw[5]|h_sw[6]|h_sw[7]|h_sw[8]|h_sw[9]|l_sw[0]|l_sw[10]|l_sw[1]|l_sw[2]|l_sw[3]|l_sw[4]|l_sw[5]|l_sw[6]|l_sw[7]|l_sw[8]|l_sw[9]|out|pad|padres|vc|vcp|vdd|vddr|vip|vss|z
+ \$70175 A1|D|Q$1
+ BOTTOM|TOP|VGND|VSS|anode|cathode|core|h_sw[0]|h_sw[10]|h_sw[1]|h_sw[2]|h_sw[3]|h_sw[4]|h_sw[5]|h_sw[6]|h_sw[7]|h_sw[8]|h_sw[9]|l_sw[0]|l_sw[10]|l_sw[1]|l_sw[2]|l_sw[3]|l_sw[4]|l_sw[5]|l_sw[6]|l_sw[7]|l_sw[8]|l_sw[9]|out|pad|padres|vc|vcp|vdd|vddr|vip|vss|z
+ sg13_lv_nmos L=0.13u W=0.74u AS=0.1406p AD=0.2516p PS=1.12u PD=2.16u rfmode=0
M$455
+ BOTTOM|TOP|VGND|VSS|anode|cathode|core|h_sw[0]|h_sw[10]|h_sw[1]|h_sw[2]|h_sw[3]|h_sw[4]|h_sw[5]|h_sw[6]|h_sw[7]|h_sw[8]|h_sw[9]|l_sw[0]|l_sw[10]|l_sw[1]|l_sw[2]|l_sw[3]|l_sw[4]|l_sw[5]|l_sw[6]|l_sw[7]|l_sw[8]|l_sw[9]|out|pad|padres|vc|vcp|vdd|vddr|vip|vss|z
+ \$70287 \$70316
+ BOTTOM|TOP|VGND|VSS|anode|cathode|core|h_sw[0]|h_sw[10]|h_sw[1]|h_sw[2]|h_sw[3]|h_sw[4]|h_sw[5]|h_sw[6]|h_sw[7]|h_sw[8]|h_sw[9]|l_sw[0]|l_sw[10]|l_sw[1]|l_sw[2]|l_sw[3]|l_sw[4]|l_sw[5]|l_sw[6]|l_sw[7]|l_sw[8]|l_sw[9]|out|pad|padres|vc|vcp|vdd|vddr|vip|vss|z
+ sg13_lv_nmos L=0.13u W=0.64u AS=0.213425p AD=0.072p PS=1.62u PD=0.865u
+ rfmode=0
M$456 \$70316 \$70289 \$70290
+ BOTTOM|TOP|VGND|VSS|anode|cathode|core|h_sw[0]|h_sw[10]|h_sw[1]|h_sw[2]|h_sw[3]|h_sw[4]|h_sw[5]|h_sw[6]|h_sw[7]|h_sw[8]|h_sw[9]|l_sw[0]|l_sw[10]|l_sw[1]|l_sw[2]|l_sw[3]|l_sw[4]|l_sw[5]|l_sw[6]|l_sw[7]|l_sw[8]|l_sw[9]|out|pad|padres|vc|vcp|vdd|vddr|vip|vss|z
+ sg13_lv_nmos L=0.13u W=0.64u AS=0.072p AD=0.141p PS=0.865u PD=1.17u rfmode=0
M$457 \$70290 \$70288 \$70318
+ BOTTOM|TOP|VGND|VSS|anode|cathode|core|h_sw[0]|h_sw[10]|h_sw[1]|h_sw[2]|h_sw[3]|h_sw[4]|h_sw[5]|h_sw[6]|h_sw[7]|h_sw[8]|h_sw[9]|l_sw[0]|l_sw[10]|l_sw[1]|l_sw[2]|l_sw[3]|l_sw[4]|l_sw[5]|l_sw[6]|l_sw[7]|l_sw[8]|l_sw[9]|out|pad|padres|vc|vcp|vdd|vddr|vip|vss|z
+ sg13_lv_nmos L=0.13u W=0.42u AS=0.141p AD=0.04725p PS=1.17u PD=0.645u rfmode=0
M$458 \$70318 \$70177
+ BOTTOM|TOP|VGND|VSS|anode|cathode|core|h_sw[0]|h_sw[10]|h_sw[1]|h_sw[2]|h_sw[3]|h_sw[4]|h_sw[5]|h_sw[6]|h_sw[7]|h_sw[8]|h_sw[9]|l_sw[0]|l_sw[10]|l_sw[1]|l_sw[2]|l_sw[3]|l_sw[4]|l_sw[5]|l_sw[6]|l_sw[7]|l_sw[8]|l_sw[9]|out|pad|padres|vc|vcp|vdd|vddr|vip|vss|z
+ BOTTOM|TOP|VGND|VSS|anode|cathode|core|h_sw[0]|h_sw[10]|h_sw[1]|h_sw[2]|h_sw[3]|h_sw[4]|h_sw[5]|h_sw[6]|h_sw[7]|h_sw[8]|h_sw[9]|l_sw[0]|l_sw[10]|l_sw[1]|l_sw[2]|l_sw[3]|l_sw[4]|l_sw[5]|l_sw[6]|l_sw[7]|l_sw[8]|l_sw[9]|out|pad|padres|vc|vcp|vdd|vddr|vip|vss|z
+ sg13_lv_nmos L=0.13u W=0.42u AS=0.04725p AD=0.1428p PS=0.645u PD=1.52u
+ rfmode=0
M$459
+ BOTTOM|TOP|VGND|VSS|anode|cathode|core|h_sw[0]|h_sw[10]|h_sw[1]|h_sw[2]|h_sw[3]|h_sw[4]|h_sw[5]|h_sw[6]|h_sw[7]|h_sw[8]|h_sw[9]|l_sw[0]|l_sw[10]|l_sw[1]|l_sw[2]|l_sw[3]|l_sw[4]|l_sw[5]|l_sw[6]|l_sw[7]|l_sw[8]|l_sw[9]|out|pad|padres|vc|vcp|vdd|vddr|vip|vss|z
+ \$70288 \$70289
+ BOTTOM|TOP|VGND|VSS|anode|cathode|core|h_sw[0]|h_sw[10]|h_sw[1]|h_sw[2]|h_sw[3]|h_sw[4]|h_sw[5]|h_sw[6]|h_sw[7]|h_sw[8]|h_sw[9]|l_sw[0]|l_sw[10]|l_sw[1]|l_sw[2]|l_sw[3]|l_sw[4]|l_sw[5]|l_sw[6]|l_sw[7]|l_sw[8]|l_sw[9]|out|pad|padres|vc|vcp|vdd|vddr|vip|vss|z
+ sg13_lv_nmos L=0.13u W=0.74u AS=0.213425p AD=0.2775p PS=1.62u PD=2.23u
+ rfmode=0
M$460
+ BOTTOM|TOP|VGND|VSS|anode|cathode|core|h_sw[0]|h_sw[10]|h_sw[1]|h_sw[2]|h_sw[3]|h_sw[4]|h_sw[5]|h_sw[6]|h_sw[7]|h_sw[8]|h_sw[9]|l_sw[0]|l_sw[10]|l_sw[1]|l_sw[2]|l_sw[3]|l_sw[4]|l_sw[5]|l_sw[6]|l_sw[7]|l_sw[8]|l_sw[9]|out|pad|padres|vc|vcp|vdd|vddr|vip|vss|z
+ \$70291 \$70320
+ BOTTOM|TOP|VGND|VSS|anode|cathode|core|h_sw[0]|h_sw[10]|h_sw[1]|h_sw[2]|h_sw[3]|h_sw[4]|h_sw[5]|h_sw[6]|h_sw[7]|h_sw[8]|h_sw[9]|l_sw[0]|l_sw[10]|l_sw[1]|l_sw[2]|l_sw[3]|l_sw[4]|l_sw[5]|l_sw[6]|l_sw[7]|l_sw[8]|l_sw[9]|out|pad|padres|vc|vcp|vdd|vddr|vip|vss|z
+ sg13_lv_nmos L=0.13u W=0.64u AS=0.213425p AD=0.072p PS=1.62u PD=0.865u
+ rfmode=0
M$461 \$70320 \$70293 \$70294
+ BOTTOM|TOP|VGND|VSS|anode|cathode|core|h_sw[0]|h_sw[10]|h_sw[1]|h_sw[2]|h_sw[3]|h_sw[4]|h_sw[5]|h_sw[6]|h_sw[7]|h_sw[8]|h_sw[9]|l_sw[0]|l_sw[10]|l_sw[1]|l_sw[2]|l_sw[3]|l_sw[4]|l_sw[5]|l_sw[6]|l_sw[7]|l_sw[8]|l_sw[9]|out|pad|padres|vc|vcp|vdd|vddr|vip|vss|z
+ sg13_lv_nmos L=0.13u W=0.64u AS=0.072p AD=0.141p PS=0.865u PD=1.17u rfmode=0
M$462 \$70294 \$70292 \$70323
+ BOTTOM|TOP|VGND|VSS|anode|cathode|core|h_sw[0]|h_sw[10]|h_sw[1]|h_sw[2]|h_sw[3]|h_sw[4]|h_sw[5]|h_sw[6]|h_sw[7]|h_sw[8]|h_sw[9]|l_sw[0]|l_sw[10]|l_sw[1]|l_sw[2]|l_sw[3]|l_sw[4]|l_sw[5]|l_sw[6]|l_sw[7]|l_sw[8]|l_sw[9]|out|pad|padres|vc|vcp|vdd|vddr|vip|vss|z
+ sg13_lv_nmos L=0.13u W=0.42u AS=0.141p AD=0.04725p PS=1.17u PD=0.645u rfmode=0
M$463 \$70323 \$70181
+ BOTTOM|TOP|VGND|VSS|anode|cathode|core|h_sw[0]|h_sw[10]|h_sw[1]|h_sw[2]|h_sw[3]|h_sw[4]|h_sw[5]|h_sw[6]|h_sw[7]|h_sw[8]|h_sw[9]|l_sw[0]|l_sw[10]|l_sw[1]|l_sw[2]|l_sw[3]|l_sw[4]|l_sw[5]|l_sw[6]|l_sw[7]|l_sw[8]|l_sw[9]|out|pad|padres|vc|vcp|vdd|vddr|vip|vss|z
+ BOTTOM|TOP|VGND|VSS|anode|cathode|core|h_sw[0]|h_sw[10]|h_sw[1]|h_sw[2]|h_sw[3]|h_sw[4]|h_sw[5]|h_sw[6]|h_sw[7]|h_sw[8]|h_sw[9]|l_sw[0]|l_sw[10]|l_sw[1]|l_sw[2]|l_sw[3]|l_sw[4]|l_sw[5]|l_sw[6]|l_sw[7]|l_sw[8]|l_sw[9]|out|pad|padres|vc|vcp|vdd|vddr|vip|vss|z
+ sg13_lv_nmos L=0.13u W=0.42u AS=0.04725p AD=0.1428p PS=0.645u PD=1.52u
+ rfmode=0
M$464
+ BOTTOM|TOP|VGND|VSS|anode|cathode|core|h_sw[0]|h_sw[10]|h_sw[1]|h_sw[2]|h_sw[3]|h_sw[4]|h_sw[5]|h_sw[6]|h_sw[7]|h_sw[8]|h_sw[9]|l_sw[0]|l_sw[10]|l_sw[1]|l_sw[2]|l_sw[3]|l_sw[4]|l_sw[5]|l_sw[6]|l_sw[7]|l_sw[8]|l_sw[9]|out|pad|padres|vc|vcp|vdd|vddr|vip|vss|z
+ \$70292 \$70293
+ BOTTOM|TOP|VGND|VSS|anode|cathode|core|h_sw[0]|h_sw[10]|h_sw[1]|h_sw[2]|h_sw[3]|h_sw[4]|h_sw[5]|h_sw[6]|h_sw[7]|h_sw[8]|h_sw[9]|l_sw[0]|l_sw[10]|l_sw[1]|l_sw[2]|l_sw[3]|l_sw[4]|l_sw[5]|l_sw[6]|l_sw[7]|l_sw[8]|l_sw[9]|out|pad|padres|vc|vcp|vdd|vddr|vip|vss|z
+ sg13_lv_nmos L=0.13u W=0.74u AS=0.213425p AD=0.2775p PS=1.62u PD=2.23u
+ rfmode=0
M$465 X|in_l_sw[5]|nl_sw[5]|x \$70295
+ BOTTOM|TOP|VGND|VSS|anode|cathode|core|h_sw[0]|h_sw[10]|h_sw[1]|h_sw[2]|h_sw[3]|h_sw[4]|h_sw[5]|h_sw[6]|h_sw[7]|h_sw[8]|h_sw[9]|l_sw[0]|l_sw[10]|l_sw[1]|l_sw[2]|l_sw[3]|l_sw[4]|l_sw[5]|l_sw[6]|l_sw[7]|l_sw[8]|l_sw[9]|out|pad|padres|vc|vcp|vdd|vddr|vip|vss|z
+ BOTTOM|TOP|VGND|VSS|anode|cathode|core|h_sw[0]|h_sw[10]|h_sw[1]|h_sw[2]|h_sw[3]|h_sw[4]|h_sw[5]|h_sw[6]|h_sw[7]|h_sw[8]|h_sw[9]|l_sw[0]|l_sw[10]|l_sw[1]|l_sw[2]|l_sw[3]|l_sw[4]|l_sw[5]|l_sw[6]|l_sw[7]|l_sw[8]|l_sw[9]|out|pad|padres|vc|vcp|vdd|vddr|vip|vss|z
+ sg13_lv_nmos L=0.13u W=0.74u AS=0.2886p AD=0.14875p PS=2.26u PD=1.16u rfmode=0
M$466
+ BOTTOM|TOP|VGND|VSS|anode|cathode|core|h_sw[0]|h_sw[10]|h_sw[1]|h_sw[2]|h_sw[3]|h_sw[4]|h_sw[5]|h_sw[6]|h_sw[7]|h_sw[8]|h_sw[9]|l_sw[0]|l_sw[10]|l_sw[1]|l_sw[2]|l_sw[3]|l_sw[4]|l_sw[5]|l_sw[6]|l_sw[7]|l_sw[8]|l_sw[9]|out|pad|padres|vc|vcp|vdd|vddr|vip|vss|z
+ A|X$8 \$70295
+ BOTTOM|TOP|VGND|VSS|anode|cathode|core|h_sw[0]|h_sw[10]|h_sw[1]|h_sw[2]|h_sw[3]|h_sw[4]|h_sw[5]|h_sw[6]|h_sw[7]|h_sw[8]|h_sw[9]|l_sw[0]|l_sw[10]|l_sw[1]|l_sw[2]|l_sw[3]|l_sw[4]|l_sw[5]|l_sw[6]|l_sw[7]|l_sw[8]|l_sw[9]|out|pad|padres|vc|vcp|vdd|vddr|vip|vss|z
+ sg13_lv_nmos L=0.13u W=0.55u AS=0.14875p AD=0.187p PS=1.16u PD=1.78u rfmode=0
M$467 X|in_h_sw[5]|nh_sw[5]|x \$70298
+ BOTTOM|TOP|VGND|VSS|anode|cathode|core|h_sw[0]|h_sw[10]|h_sw[1]|h_sw[2]|h_sw[3]|h_sw[4]|h_sw[5]|h_sw[6]|h_sw[7]|h_sw[8]|h_sw[9]|l_sw[0]|l_sw[10]|l_sw[1]|l_sw[2]|l_sw[3]|l_sw[4]|l_sw[5]|l_sw[6]|l_sw[7]|l_sw[8]|l_sw[9]|out|pad|padres|vc|vcp|vdd|vddr|vip|vss|z
+ BOTTOM|TOP|VGND|VSS|anode|cathode|core|h_sw[0]|h_sw[10]|h_sw[1]|h_sw[2]|h_sw[3]|h_sw[4]|h_sw[5]|h_sw[6]|h_sw[7]|h_sw[8]|h_sw[9]|l_sw[0]|l_sw[10]|l_sw[1]|l_sw[2]|l_sw[3]|l_sw[4]|l_sw[5]|l_sw[6]|l_sw[7]|l_sw[8]|l_sw[9]|out|pad|padres|vc|vcp|vdd|vddr|vip|vss|z
+ sg13_lv_nmos L=0.13u W=0.74u AS=0.2886p AD=0.14875p PS=2.26u PD=1.16u rfmode=0
M$468
+ BOTTOM|TOP|VGND|VSS|anode|cathode|core|h_sw[0]|h_sw[10]|h_sw[1]|h_sw[2]|h_sw[3]|h_sw[4]|h_sw[5]|h_sw[6]|h_sw[7]|h_sw[8]|h_sw[9]|l_sw[0]|l_sw[10]|l_sw[1]|l_sw[2]|l_sw[3]|l_sw[4]|l_sw[5]|l_sw[6]|l_sw[7]|l_sw[8]|l_sw[9]|out|pad|padres|vc|vcp|vdd|vddr|vip|vss|z
+ A|X$9 \$70298
+ BOTTOM|TOP|VGND|VSS|anode|cathode|core|h_sw[0]|h_sw[10]|h_sw[1]|h_sw[2]|h_sw[3]|h_sw[4]|h_sw[5]|h_sw[6]|h_sw[7]|h_sw[8]|h_sw[9]|l_sw[0]|l_sw[10]|l_sw[1]|l_sw[2]|l_sw[3]|l_sw[4]|l_sw[5]|l_sw[6]|l_sw[7]|l_sw[8]|l_sw[9]|out|pad|padres|vc|vcp|vdd|vddr|vip|vss|z
+ sg13_lv_nmos L=0.13u W=0.55u AS=0.14875p AD=0.187p PS=1.16u PD=1.78u rfmode=0
M$469
+ BOTTOM|TOP|VGND|VSS|anode|cathode|core|h_sw[0]|h_sw[10]|h_sw[1]|h_sw[2]|h_sw[3]|h_sw[4]|h_sw[5]|h_sw[6]|h_sw[7]|h_sw[8]|h_sw[9]|l_sw[0]|l_sw[10]|l_sw[1]|l_sw[2]|l_sw[3]|l_sw[4]|l_sw[5]|l_sw[6]|l_sw[7]|l_sw[8]|l_sw[9]|out|pad|padres|vc|vcp|vdd|vddr|vip|vss|z
+ A|X$10 \$70299
+ BOTTOM|TOP|VGND|VSS|anode|cathode|core|h_sw[0]|h_sw[10]|h_sw[1]|h_sw[2]|h_sw[3]|h_sw[4]|h_sw[5]|h_sw[6]|h_sw[7]|h_sw[8]|h_sw[9]|l_sw[0]|l_sw[10]|l_sw[1]|l_sw[2]|l_sw[3]|l_sw[4]|l_sw[5]|l_sw[6]|l_sw[7]|l_sw[8]|l_sw[9]|out|pad|padres|vc|vcp|vdd|vddr|vip|vss|z
+ sg13_lv_nmos L=0.13u W=0.55u AS=0.14875p AD=0.187p PS=1.16u PD=1.78u rfmode=0
M$470
+ BOTTOM|TOP|VGND|VSS|anode|cathode|core|h_sw[0]|h_sw[10]|h_sw[1]|h_sw[2]|h_sw[3]|h_sw[4]|h_sw[5]|h_sw[6]|h_sw[7]|h_sw[8]|h_sw[9]|l_sw[0]|l_sw[10]|l_sw[1]|l_sw[2]|l_sw[3]|l_sw[4]|l_sw[5]|l_sw[6]|l_sw[7]|l_sw[8]|l_sw[9]|out|pad|padres|vc|vcp|vdd|vddr|vip|vss|z
+ \$70299 X|in_l_sw[6]|nl_sw[6]|x
+ BOTTOM|TOP|VGND|VSS|anode|cathode|core|h_sw[0]|h_sw[10]|h_sw[1]|h_sw[2]|h_sw[3]|h_sw[4]|h_sw[5]|h_sw[6]|h_sw[7]|h_sw[8]|h_sw[9]|l_sw[0]|l_sw[10]|l_sw[1]|l_sw[2]|l_sw[3]|l_sw[4]|l_sw[5]|l_sw[6]|l_sw[7]|l_sw[8]|l_sw[9]|out|pad|padres|vc|vcp|vdd|vddr|vip|vss|z
+ sg13_lv_nmos L=0.13u W=0.74u AS=0.14875p AD=0.2886p PS=1.16u PD=2.26u rfmode=0
M$471 \$70184 A1|Y$1
+ BOTTOM|TOP|VGND|VSS|anode|cathode|core|h_sw[0]|h_sw[10]|h_sw[1]|h_sw[2]|h_sw[3]|h_sw[4]|h_sw[5]|h_sw[6]|h_sw[7]|h_sw[8]|h_sw[9]|l_sw[0]|l_sw[10]|l_sw[1]|l_sw[2]|l_sw[3]|l_sw[4]|l_sw[5]|l_sw[6]|l_sw[7]|l_sw[8]|l_sw[9]|out|pad|padres|vc|vcp|vdd|vddr|vip|vss|z
+ BOTTOM|TOP|VGND|VSS|anode|cathode|core|h_sw[0]|h_sw[10]|h_sw[1]|h_sw[2]|h_sw[3]|h_sw[4]|h_sw[5]|h_sw[6]|h_sw[7]|h_sw[8]|h_sw[9]|l_sw[0]|l_sw[10]|l_sw[1]|l_sw[2]|l_sw[3]|l_sw[4]|l_sw[5]|l_sw[6]|l_sw[7]|l_sw[8]|l_sw[9]|out|pad|padres|vc|vcp|vdd|vddr|vip|vss|z
+ sg13_lv_nmos L=0.15u W=0.74u AS=0.2516p AD=0.1406p PS=2.16u PD=1.12u rfmode=0
M$472
+ BOTTOM|TOP|VGND|VSS|anode|cathode|core|h_sw[0]|h_sw[10]|h_sw[1]|h_sw[2]|h_sw[3]|h_sw[4]|h_sw[5]|h_sw[6]|h_sw[7]|h_sw[8]|h_sw[9]|l_sw[0]|l_sw[10]|l_sw[1]|l_sw[2]|l_sw[3]|l_sw[4]|l_sw[5]|l_sw[6]|l_sw[7]|l_sw[8]|l_sw[9]|out|pad|padres|vc|vcp|vdd|vddr|vip|vss|z
+ A2|Y \$70184
+ BOTTOM|TOP|VGND|VSS|anode|cathode|core|h_sw[0]|h_sw[10]|h_sw[1]|h_sw[2]|h_sw[3]|h_sw[4]|h_sw[5]|h_sw[6]|h_sw[7]|h_sw[8]|h_sw[9]|l_sw[0]|l_sw[10]|l_sw[1]|l_sw[2]|l_sw[3]|l_sw[4]|l_sw[5]|l_sw[6]|l_sw[7]|l_sw[8]|l_sw[9]|out|pad|padres|vc|vcp|vdd|vddr|vip|vss|z
+ sg13_lv_nmos L=0.15u W=0.74u AS=0.1406p AD=0.1406p PS=1.12u PD=1.12u rfmode=0
M$473 \$70184 B1|Y$2 D|Y$3
+ BOTTOM|TOP|VGND|VSS|anode|cathode|core|h_sw[0]|h_sw[10]|h_sw[1]|h_sw[2]|h_sw[3]|h_sw[4]|h_sw[5]|h_sw[6]|h_sw[7]|h_sw[8]|h_sw[9]|l_sw[0]|l_sw[10]|l_sw[1]|l_sw[2]|l_sw[3]|l_sw[4]|l_sw[5]|l_sw[6]|l_sw[7]|l_sw[8]|l_sw[9]|out|pad|padres|vc|vcp|vdd|vddr|vip|vss|z
+ sg13_lv_nmos L=0.15u W=0.74u AS=0.1406p AD=0.2516p PS=1.12u PD=2.16u rfmode=0
M$474
+ BOTTOM|TOP|VGND|VSS|anode|cathode|core|h_sw[0]|h_sw[10]|h_sw[1]|h_sw[2]|h_sw[3]|h_sw[4]|h_sw[5]|h_sw[6]|h_sw[7]|h_sw[8]|h_sw[9]|l_sw[0]|l_sw[10]|l_sw[1]|l_sw[2]|l_sw[3]|l_sw[4]|l_sw[5]|l_sw[6]|l_sw[7]|l_sw[8]|l_sw[9]|out|pad|padres|vc|vcp|vdd|vddr|vip|vss|z
+ A|X$38 \$70300
+ BOTTOM|TOP|VGND|VSS|anode|cathode|core|h_sw[0]|h_sw[10]|h_sw[1]|h_sw[2]|h_sw[3]|h_sw[4]|h_sw[5]|h_sw[6]|h_sw[7]|h_sw[8]|h_sw[9]|l_sw[0]|l_sw[10]|l_sw[1]|l_sw[2]|l_sw[3]|l_sw[4]|l_sw[5]|l_sw[6]|l_sw[7]|l_sw[8]|l_sw[9]|out|pad|padres|vc|vcp|vdd|vddr|vip|vss|z
+ sg13_lv_nmos L=0.13u W=0.55u AS=0.14875p AD=0.187p PS=1.16u PD=1.78u rfmode=0
M$475
+ BOTTOM|TOP|VGND|VSS|anode|cathode|core|h_sw[0]|h_sw[10]|h_sw[1]|h_sw[2]|h_sw[3]|h_sw[4]|h_sw[5]|h_sw[6]|h_sw[7]|h_sw[8]|h_sw[9]|l_sw[0]|l_sw[10]|l_sw[1]|l_sw[2]|l_sw[3]|l_sw[4]|l_sw[5]|l_sw[6]|l_sw[7]|l_sw[8]|l_sw[9]|out|pad|padres|vc|vcp|vdd|vddr|vip|vss|z
+ \$70300 A|X$26
+ BOTTOM|TOP|VGND|VSS|anode|cathode|core|h_sw[0]|h_sw[10]|h_sw[1]|h_sw[2]|h_sw[3]|h_sw[4]|h_sw[5]|h_sw[6]|h_sw[7]|h_sw[8]|h_sw[9]|l_sw[0]|l_sw[10]|l_sw[1]|l_sw[2]|l_sw[3]|l_sw[4]|l_sw[5]|l_sw[6]|l_sw[7]|l_sw[8]|l_sw[9]|out|pad|padres|vc|vcp|vdd|vddr|vip|vss|z
+ sg13_lv_nmos L=0.13u W=0.74u AS=0.14875p AD=0.2886p PS=1.16u PD=2.26u rfmode=0
M$476 \$70302 D|Y$3 \$70328
+ BOTTOM|TOP|VGND|VSS|anode|cathode|core|h_sw[0]|h_sw[10]|h_sw[1]|h_sw[2]|h_sw[3]|h_sw[4]|h_sw[5]|h_sw[6]|h_sw[7]|h_sw[8]|h_sw[9]|l_sw[0]|l_sw[10]|l_sw[1]|l_sw[2]|l_sw[3]|l_sw[4]|l_sw[5]|l_sw[6]|l_sw[7]|l_sw[8]|l_sw[9]|out|pad|padres|vc|vcp|vdd|vddr|vip|vss|z
+ sg13_lv_nmos L=0.13u W=0.42u AS=0.1428p AD=0.0609p PS=1.52u PD=0.71u rfmode=0
M$477 \$70328 RESET_B|Y
+ BOTTOM|TOP|VGND|VSS|anode|cathode|core|h_sw[0]|h_sw[10]|h_sw[1]|h_sw[2]|h_sw[3]|h_sw[4]|h_sw[5]|h_sw[6]|h_sw[7]|h_sw[8]|h_sw[9]|l_sw[0]|l_sw[10]|l_sw[1]|l_sw[2]|l_sw[3]|l_sw[4]|l_sw[5]|l_sw[6]|l_sw[7]|l_sw[8]|l_sw[9]|out|pad|padres|vc|vcp|vdd|vddr|vip|vss|z
+ BOTTOM|TOP|VGND|VSS|anode|cathode|core|h_sw[0]|h_sw[10]|h_sw[1]|h_sw[2]|h_sw[3]|h_sw[4]|h_sw[5]|h_sw[6]|h_sw[7]|h_sw[8]|h_sw[9]|l_sw[0]|l_sw[10]|l_sw[1]|l_sw[2]|l_sw[3]|l_sw[4]|l_sw[5]|l_sw[6]|l_sw[7]|l_sw[8]|l_sw[9]|out|pad|padres|vc|vcp|vdd|vddr|vip|vss|z
+ sg13_lv_nmos L=0.13u W=0.42u AS=0.0609p AD=0.1626p PS=0.71u PD=1.415u rfmode=0
M$478
+ BOTTOM|TOP|VGND|VSS|anode|cathode|core|h_sw[0]|h_sw[10]|h_sw[1]|h_sw[2]|h_sw[3]|h_sw[4]|h_sw[5]|h_sw[6]|h_sw[7]|h_sw[8]|h_sw[9]|l_sw[0]|l_sw[10]|l_sw[1]|l_sw[2]|l_sw[3]|l_sw[4]|l_sw[5]|l_sw[6]|l_sw[7]|l_sw[8]|l_sw[9]|out|pad|padres|vc|vcp|vdd|vddr|vip|vss|z
+ \$70338 \$70186
+ BOTTOM|TOP|VGND|VSS|anode|cathode|core|h_sw[0]|h_sw[10]|h_sw[1]|h_sw[2]|h_sw[3]|h_sw[4]|h_sw[5]|h_sw[6]|h_sw[7]|h_sw[8]|h_sw[9]|l_sw[0]|l_sw[10]|l_sw[1]|l_sw[2]|l_sw[3]|l_sw[4]|l_sw[5]|l_sw[6]|l_sw[7]|l_sw[8]|l_sw[9]|out|pad|padres|vc|vcp|vdd|vddr|vip|vss|z
+ sg13_lv_nmos L=0.13u W=0.74u AS=0.1626p AD=0.2516p PS=1.415u PD=2.16u rfmode=0
M$479 \$70188 \$70189
+ BOTTOM|TOP|VGND|VSS|anode|cathode|core|h_sw[0]|h_sw[10]|h_sw[1]|h_sw[2]|h_sw[3]|h_sw[4]|h_sw[5]|h_sw[6]|h_sw[7]|h_sw[8]|h_sw[9]|l_sw[0]|l_sw[10]|l_sw[1]|l_sw[2]|l_sw[3]|l_sw[4]|l_sw[5]|l_sw[6]|l_sw[7]|l_sw[8]|l_sw[9]|out|pad|padres|vc|vcp|vdd|vddr|vip|vss|z
+ BOTTOM|TOP|VGND|VSS|anode|cathode|core|h_sw[0]|h_sw[10]|h_sw[1]|h_sw[2]|h_sw[3]|h_sw[4]|h_sw[5]|h_sw[6]|h_sw[7]|h_sw[8]|h_sw[9]|l_sw[0]|l_sw[10]|l_sw[1]|l_sw[2]|l_sw[3]|l_sw[4]|l_sw[5]|l_sw[6]|l_sw[7]|l_sw[8]|l_sw[9]|out|pad|padres|vc|vcp|vdd|vddr|vip|vss|z
+ sg13_lv_nmos L=0.13u W=0.42u AS=0.1428p AD=0.0798p PS=1.52u PD=0.8u rfmode=0
M$480
+ BOTTOM|TOP|VGND|VSS|anode|cathode|core|h_sw[0]|h_sw[10]|h_sw[1]|h_sw[2]|h_sw[3]|h_sw[4]|h_sw[5]|h_sw[6]|h_sw[7]|h_sw[8]|h_sw[9]|l_sw[0]|l_sw[10]|l_sw[1]|l_sw[2]|l_sw[3]|l_sw[4]|l_sw[5]|l_sw[6]|l_sw[7]|l_sw[8]|l_sw[9]|out|pad|padres|vc|vcp|vdd|vddr|vip|vss|z
+ RESET_B|Y \$70327
+ BOTTOM|TOP|VGND|VSS|anode|cathode|core|h_sw[0]|h_sw[10]|h_sw[1]|h_sw[2]|h_sw[3]|h_sw[4]|h_sw[5]|h_sw[6]|h_sw[7]|h_sw[8]|h_sw[9]|l_sw[0]|l_sw[10]|l_sw[1]|l_sw[2]|l_sw[3]|l_sw[4]|l_sw[5]|l_sw[6]|l_sw[7]|l_sw[8]|l_sw[9]|out|pad|padres|vc|vcp|vdd|vddr|vip|vss|z
+ sg13_lv_nmos L=0.13u W=0.42u AS=0.0798p AD=0.0378p PS=0.8u PD=0.6u rfmode=0
M$481 \$70327 \$70303 \$70189
+ BOTTOM|TOP|VGND|VSS|anode|cathode|core|h_sw[0]|h_sw[10]|h_sw[1]|h_sw[2]|h_sw[3]|h_sw[4]|h_sw[5]|h_sw[6]|h_sw[7]|h_sw[8]|h_sw[9]|l_sw[0]|l_sw[10]|l_sw[1]|l_sw[2]|l_sw[3]|l_sw[4]|l_sw[5]|l_sw[6]|l_sw[7]|l_sw[8]|l_sw[9]|out|pad|padres|vc|vcp|vdd|vddr|vip|vss|z
+ sg13_lv_nmos L=0.13u W=0.42u AS=0.0378p AD=0.1428p PS=0.6u PD=1.52u rfmode=0
M$482
+ BOTTOM|TOP|VGND|VSS|anode|cathode|core|h_sw[0]|h_sw[10]|h_sw[1]|h_sw[2]|h_sw[3]|h_sw[4]|h_sw[5]|h_sw[6]|h_sw[7]|h_sw[8]|h_sw[9]|l_sw[0]|l_sw[10]|l_sw[1]|l_sw[2]|l_sw[3]|l_sw[4]|l_sw[5]|l_sw[6]|l_sw[7]|l_sw[8]|l_sw[9]|out|pad|padres|vc|vcp|vdd|vddr|vip|vss|z
+ \$70303 Q_N$8
+ BOTTOM|TOP|VGND|VSS|anode|cathode|core|h_sw[0]|h_sw[10]|h_sw[1]|h_sw[2]|h_sw[3]|h_sw[4]|h_sw[5]|h_sw[6]|h_sw[7]|h_sw[8]|h_sw[9]|l_sw[0]|l_sw[10]|l_sw[1]|l_sw[2]|l_sw[3]|l_sw[4]|l_sw[5]|l_sw[6]|l_sw[7]|l_sw[8]|l_sw[9]|out|pad|padres|vc|vcp|vdd|vddr|vip|vss|z
+ sg13_lv_nmos L=0.13u W=0.74u AS=0.2516p AD=0.2849p PS=2.16u PD=2.25u rfmode=0
M$483 \$70191 \$70303
+ BOTTOM|TOP|VGND|VSS|anode|cathode|core|h_sw[0]|h_sw[10]|h_sw[1]|h_sw[2]|h_sw[3]|h_sw[4]|h_sw[5]|h_sw[6]|h_sw[7]|h_sw[8]|h_sw[9]|l_sw[0]|l_sw[10]|l_sw[1]|l_sw[2]|l_sw[3]|l_sw[4]|l_sw[5]|l_sw[6]|l_sw[7]|l_sw[8]|l_sw[9]|out|pad|padres|vc|vcp|vdd|vddr|vip|vss|z
+ BOTTOM|TOP|VGND|VSS|anode|cathode|core|h_sw[0]|h_sw[10]|h_sw[1]|h_sw[2]|h_sw[3]|h_sw[4]|h_sw[5]|h_sw[6]|h_sw[7]|h_sw[8]|h_sw[9]|l_sw[0]|l_sw[10]|l_sw[1]|l_sw[2]|l_sw[3]|l_sw[4]|l_sw[5]|l_sw[6]|l_sw[7]|l_sw[8]|l_sw[9]|out|pad|padres|vc|vcp|vdd|vddr|vip|vss|z
+ sg13_lv_nmos L=0.13u W=0.74u AS=0.2516p AD=0.1406p PS=2.16u PD=1.12u rfmode=0
M$484
+ BOTTOM|TOP|VGND|VSS|anode|cathode|core|h_sw[0]|h_sw[10]|h_sw[1]|h_sw[2]|h_sw[3]|h_sw[4]|h_sw[5]|h_sw[6]|h_sw[7]|h_sw[8]|h_sw[9]|l_sw[0]|l_sw[10]|l_sw[1]|l_sw[2]|l_sw[3]|l_sw[4]|l_sw[5]|l_sw[6]|l_sw[7]|l_sw[8]|l_sw[9]|out|pad|padres|vc|vcp|vdd|vddr|vip|vss|z
+ \$70191 A|Q$5
+ BOTTOM|TOP|VGND|VSS|anode|cathode|core|h_sw[0]|h_sw[10]|h_sw[1]|h_sw[2]|h_sw[3]|h_sw[4]|h_sw[5]|h_sw[6]|h_sw[7]|h_sw[8]|h_sw[9]|l_sw[0]|l_sw[10]|l_sw[1]|l_sw[2]|l_sw[3]|l_sw[4]|l_sw[5]|l_sw[6]|l_sw[7]|l_sw[8]|l_sw[9]|out|pad|padres|vc|vcp|vdd|vddr|vip|vss|z
+ sg13_lv_nmos L=0.13u W=0.74u AS=0.1406p AD=0.2516p PS=1.12u PD=2.16u rfmode=0
M$485 X|in_h_sw[7]|nh_sw[7]|x \$70304
+ BOTTOM|TOP|VGND|VSS|anode|cathode|core|h_sw[0]|h_sw[10]|h_sw[1]|h_sw[2]|h_sw[3]|h_sw[4]|h_sw[5]|h_sw[6]|h_sw[7]|h_sw[8]|h_sw[9]|l_sw[0]|l_sw[10]|l_sw[1]|l_sw[2]|l_sw[3]|l_sw[4]|l_sw[5]|l_sw[6]|l_sw[7]|l_sw[8]|l_sw[9]|out|pad|padres|vc|vcp|vdd|vddr|vip|vss|z
+ BOTTOM|TOP|VGND|VSS|anode|cathode|core|h_sw[0]|h_sw[10]|h_sw[1]|h_sw[2]|h_sw[3]|h_sw[4]|h_sw[5]|h_sw[6]|h_sw[7]|h_sw[8]|h_sw[9]|l_sw[0]|l_sw[10]|l_sw[1]|l_sw[2]|l_sw[3]|l_sw[4]|l_sw[5]|l_sw[6]|l_sw[7]|l_sw[8]|l_sw[9]|out|pad|padres|vc|vcp|vdd|vddr|vip|vss|z
+ sg13_lv_nmos L=0.13u W=0.74u AS=0.2886p AD=0.14875p PS=2.26u PD=1.16u rfmode=0
M$486
+ BOTTOM|TOP|VGND|VSS|anode|cathode|core|h_sw[0]|h_sw[10]|h_sw[1]|h_sw[2]|h_sw[3]|h_sw[4]|h_sw[5]|h_sw[6]|h_sw[7]|h_sw[8]|h_sw[9]|l_sw[0]|l_sw[10]|l_sw[1]|l_sw[2]|l_sw[3]|l_sw[4]|l_sw[5]|l_sw[6]|l_sw[7]|l_sw[8]|l_sw[9]|out|pad|padres|vc|vcp|vdd|vddr|vip|vss|z
+ A|X$12 \$70304
+ BOTTOM|TOP|VGND|VSS|anode|cathode|core|h_sw[0]|h_sw[10]|h_sw[1]|h_sw[2]|h_sw[3]|h_sw[4]|h_sw[5]|h_sw[6]|h_sw[7]|h_sw[8]|h_sw[9]|l_sw[0]|l_sw[10]|l_sw[1]|l_sw[2]|l_sw[3]|l_sw[4]|l_sw[5]|l_sw[6]|l_sw[7]|l_sw[8]|l_sw[9]|out|pad|padres|vc|vcp|vdd|vddr|vip|vss|z
+ sg13_lv_nmos L=0.13u W=0.55u AS=0.14875p AD=0.187p PS=1.16u PD=1.78u rfmode=0
M$487 X|in_l_sw[8]|nl_sw[8]|x \$70305
+ BOTTOM|TOP|VGND|VSS|anode|cathode|core|h_sw[0]|h_sw[10]|h_sw[1]|h_sw[2]|h_sw[3]|h_sw[4]|h_sw[5]|h_sw[6]|h_sw[7]|h_sw[8]|h_sw[9]|l_sw[0]|l_sw[10]|l_sw[1]|l_sw[2]|l_sw[3]|l_sw[4]|l_sw[5]|l_sw[6]|l_sw[7]|l_sw[8]|l_sw[9]|out|pad|padres|vc|vcp|vdd|vddr|vip|vss|z
+ BOTTOM|TOP|VGND|VSS|anode|cathode|core|h_sw[0]|h_sw[10]|h_sw[1]|h_sw[2]|h_sw[3]|h_sw[4]|h_sw[5]|h_sw[6]|h_sw[7]|h_sw[8]|h_sw[9]|l_sw[0]|l_sw[10]|l_sw[1]|l_sw[2]|l_sw[3]|l_sw[4]|l_sw[5]|l_sw[6]|l_sw[7]|l_sw[8]|l_sw[9]|out|pad|padres|vc|vcp|vdd|vddr|vip|vss|z
+ sg13_lv_nmos L=0.13u W=0.74u AS=0.2886p AD=0.14875p PS=2.26u PD=1.16u rfmode=0
M$488
+ BOTTOM|TOP|VGND|VSS|anode|cathode|core|h_sw[0]|h_sw[10]|h_sw[1]|h_sw[2]|h_sw[3]|h_sw[4]|h_sw[5]|h_sw[6]|h_sw[7]|h_sw[8]|h_sw[9]|l_sw[0]|l_sw[10]|l_sw[1]|l_sw[2]|l_sw[3]|l_sw[4]|l_sw[5]|l_sw[6]|l_sw[7]|l_sw[8]|l_sw[9]|out|pad|padres|vc|vcp|vdd|vddr|vip|vss|z
+ A|X$13 \$70305
+ BOTTOM|TOP|VGND|VSS|anode|cathode|core|h_sw[0]|h_sw[10]|h_sw[1]|h_sw[2]|h_sw[3]|h_sw[4]|h_sw[5]|h_sw[6]|h_sw[7]|h_sw[8]|h_sw[9]|l_sw[0]|l_sw[10]|l_sw[1]|l_sw[2]|l_sw[3]|l_sw[4]|l_sw[5]|l_sw[6]|l_sw[7]|l_sw[8]|l_sw[9]|out|pad|padres|vc|vcp|vdd|vddr|vip|vss|z
+ sg13_lv_nmos L=0.13u W=0.55u AS=0.14875p AD=0.187p PS=1.16u PD=1.78u rfmode=0
M$489 X|in_h_sw[8]|nh_sw[8]|x \$70306
+ BOTTOM|TOP|VGND|VSS|anode|cathode|core|h_sw[0]|h_sw[10]|h_sw[1]|h_sw[2]|h_sw[3]|h_sw[4]|h_sw[5]|h_sw[6]|h_sw[7]|h_sw[8]|h_sw[9]|l_sw[0]|l_sw[10]|l_sw[1]|l_sw[2]|l_sw[3]|l_sw[4]|l_sw[5]|l_sw[6]|l_sw[7]|l_sw[8]|l_sw[9]|out|pad|padres|vc|vcp|vdd|vddr|vip|vss|z
+ BOTTOM|TOP|VGND|VSS|anode|cathode|core|h_sw[0]|h_sw[10]|h_sw[1]|h_sw[2]|h_sw[3]|h_sw[4]|h_sw[5]|h_sw[6]|h_sw[7]|h_sw[8]|h_sw[9]|l_sw[0]|l_sw[10]|l_sw[1]|l_sw[2]|l_sw[3]|l_sw[4]|l_sw[5]|l_sw[6]|l_sw[7]|l_sw[8]|l_sw[9]|out|pad|padres|vc|vcp|vdd|vddr|vip|vss|z
+ sg13_lv_nmos L=0.13u W=0.74u AS=0.2886p AD=0.14875p PS=2.26u PD=1.16u rfmode=0
M$490
+ BOTTOM|TOP|VGND|VSS|anode|cathode|core|h_sw[0]|h_sw[10]|h_sw[1]|h_sw[2]|h_sw[3]|h_sw[4]|h_sw[5]|h_sw[6]|h_sw[7]|h_sw[8]|h_sw[9]|l_sw[0]|l_sw[10]|l_sw[1]|l_sw[2]|l_sw[3]|l_sw[4]|l_sw[5]|l_sw[6]|l_sw[7]|l_sw[8]|l_sw[9]|out|pad|padres|vc|vcp|vdd|vddr|vip|vss|z
+ A|X$14 \$70306
+ BOTTOM|TOP|VGND|VSS|anode|cathode|core|h_sw[0]|h_sw[10]|h_sw[1]|h_sw[2]|h_sw[3]|h_sw[4]|h_sw[5]|h_sw[6]|h_sw[7]|h_sw[8]|h_sw[9]|l_sw[0]|l_sw[10]|l_sw[1]|l_sw[2]|l_sw[3]|l_sw[4]|l_sw[5]|l_sw[6]|l_sw[7]|l_sw[8]|l_sw[9]|out|pad|padres|vc|vcp|vdd|vddr|vip|vss|z
+ sg13_lv_nmos L=0.13u W=0.55u AS=0.14875p AD=0.187p PS=1.16u PD=1.78u rfmode=0
M$491 \$70308 D|Y$5 \$70324
+ BOTTOM|TOP|VGND|VSS|anode|cathode|core|h_sw[0]|h_sw[10]|h_sw[1]|h_sw[2]|h_sw[3]|h_sw[4]|h_sw[5]|h_sw[6]|h_sw[7]|h_sw[8]|h_sw[9]|l_sw[0]|l_sw[10]|l_sw[1]|l_sw[2]|l_sw[3]|l_sw[4]|l_sw[5]|l_sw[6]|l_sw[7]|l_sw[8]|l_sw[9]|out|pad|padres|vc|vcp|vdd|vddr|vip|vss|z
+ sg13_lv_nmos L=0.13u W=0.42u AS=0.1428p AD=0.0609p PS=1.52u PD=0.71u rfmode=0
M$492 \$70324 RESET_B|Y
+ BOTTOM|TOP|VGND|VSS|anode|cathode|core|h_sw[0]|h_sw[10]|h_sw[1]|h_sw[2]|h_sw[3]|h_sw[4]|h_sw[5]|h_sw[6]|h_sw[7]|h_sw[8]|h_sw[9]|l_sw[0]|l_sw[10]|l_sw[1]|l_sw[2]|l_sw[3]|l_sw[4]|l_sw[5]|l_sw[6]|l_sw[7]|l_sw[8]|l_sw[9]|out|pad|padres|vc|vcp|vdd|vddr|vip|vss|z
+ BOTTOM|TOP|VGND|VSS|anode|cathode|core|h_sw[0]|h_sw[10]|h_sw[1]|h_sw[2]|h_sw[3]|h_sw[4]|h_sw[5]|h_sw[6]|h_sw[7]|h_sw[8]|h_sw[9]|l_sw[0]|l_sw[10]|l_sw[1]|l_sw[2]|l_sw[3]|l_sw[4]|l_sw[5]|l_sw[6]|l_sw[7]|l_sw[8]|l_sw[9]|out|pad|padres|vc|vcp|vdd|vddr|vip|vss|z
+ sg13_lv_nmos L=0.13u W=0.42u AS=0.0609p AD=0.1626p PS=0.71u PD=1.415u rfmode=0
M$493
+ BOTTOM|TOP|VGND|VSS|anode|cathode|core|h_sw[0]|h_sw[10]|h_sw[1]|h_sw[2]|h_sw[3]|h_sw[4]|h_sw[5]|h_sw[6]|h_sw[7]|h_sw[8]|h_sw[9]|l_sw[0]|l_sw[10]|l_sw[1]|l_sw[2]|l_sw[3]|l_sw[4]|l_sw[5]|l_sw[6]|l_sw[7]|l_sw[8]|l_sw[9]|out|pad|padres|vc|vcp|vdd|vddr|vip|vss|z
+ \$70339 \$70193
+ BOTTOM|TOP|VGND|VSS|anode|cathode|core|h_sw[0]|h_sw[10]|h_sw[1]|h_sw[2]|h_sw[3]|h_sw[4]|h_sw[5]|h_sw[6]|h_sw[7]|h_sw[8]|h_sw[9]|l_sw[0]|l_sw[10]|l_sw[1]|l_sw[2]|l_sw[3]|l_sw[4]|l_sw[5]|l_sw[6]|l_sw[7]|l_sw[8]|l_sw[9]|out|pad|padres|vc|vcp|vdd|vddr|vip|vss|z
+ sg13_lv_nmos L=0.13u W=0.74u AS=0.1626p AD=0.2516p PS=1.415u PD=2.16u rfmode=0
M$494 \$70195 \$70196
+ BOTTOM|TOP|VGND|VSS|anode|cathode|core|h_sw[0]|h_sw[10]|h_sw[1]|h_sw[2]|h_sw[3]|h_sw[4]|h_sw[5]|h_sw[6]|h_sw[7]|h_sw[8]|h_sw[9]|l_sw[0]|l_sw[10]|l_sw[1]|l_sw[2]|l_sw[3]|l_sw[4]|l_sw[5]|l_sw[6]|l_sw[7]|l_sw[8]|l_sw[9]|out|pad|padres|vc|vcp|vdd|vddr|vip|vss|z
+ BOTTOM|TOP|VGND|VSS|anode|cathode|core|h_sw[0]|h_sw[10]|h_sw[1]|h_sw[2]|h_sw[3]|h_sw[4]|h_sw[5]|h_sw[6]|h_sw[7]|h_sw[8]|h_sw[9]|l_sw[0]|l_sw[10]|l_sw[1]|l_sw[2]|l_sw[3]|l_sw[4]|l_sw[5]|l_sw[6]|l_sw[7]|l_sw[8]|l_sw[9]|out|pad|padres|vc|vcp|vdd|vddr|vip|vss|z
+ sg13_lv_nmos L=0.13u W=0.42u AS=0.1428p AD=0.0798p PS=1.52u PD=0.8u rfmode=0
M$495
+ BOTTOM|TOP|VGND|VSS|anode|cathode|core|h_sw[0]|h_sw[10]|h_sw[1]|h_sw[2]|h_sw[3]|h_sw[4]|h_sw[5]|h_sw[6]|h_sw[7]|h_sw[8]|h_sw[9]|l_sw[0]|l_sw[10]|l_sw[1]|l_sw[2]|l_sw[3]|l_sw[4]|l_sw[5]|l_sw[6]|l_sw[7]|l_sw[8]|l_sw[9]|out|pad|padres|vc|vcp|vdd|vddr|vip|vss|z
+ RESET_B|Y \$70319
+ BOTTOM|TOP|VGND|VSS|anode|cathode|core|h_sw[0]|h_sw[10]|h_sw[1]|h_sw[2]|h_sw[3]|h_sw[4]|h_sw[5]|h_sw[6]|h_sw[7]|h_sw[8]|h_sw[9]|l_sw[0]|l_sw[10]|l_sw[1]|l_sw[2]|l_sw[3]|l_sw[4]|l_sw[5]|l_sw[6]|l_sw[7]|l_sw[8]|l_sw[9]|out|pad|padres|vc|vcp|vdd|vddr|vip|vss|z
+ sg13_lv_nmos L=0.13u W=0.42u AS=0.0798p AD=0.0378p PS=0.8u PD=0.6u rfmode=0
M$496 \$70319 \$70309 \$70196
+ BOTTOM|TOP|VGND|VSS|anode|cathode|core|h_sw[0]|h_sw[10]|h_sw[1]|h_sw[2]|h_sw[3]|h_sw[4]|h_sw[5]|h_sw[6]|h_sw[7]|h_sw[8]|h_sw[9]|l_sw[0]|l_sw[10]|l_sw[1]|l_sw[2]|l_sw[3]|l_sw[4]|l_sw[5]|l_sw[6]|l_sw[7]|l_sw[8]|l_sw[9]|out|pad|padres|vc|vcp|vdd|vddr|vip|vss|z
+ sg13_lv_nmos L=0.13u W=0.42u AS=0.0378p AD=0.1428p PS=0.6u PD=1.52u rfmode=0
M$497
+ BOTTOM|TOP|VGND|VSS|anode|cathode|core|h_sw[0]|h_sw[10]|h_sw[1]|h_sw[2]|h_sw[3]|h_sw[4]|h_sw[5]|h_sw[6]|h_sw[7]|h_sw[8]|h_sw[9]|l_sw[0]|l_sw[10]|l_sw[1]|l_sw[2]|l_sw[3]|l_sw[4]|l_sw[5]|l_sw[6]|l_sw[7]|l_sw[8]|l_sw[9]|out|pad|padres|vc|vcp|vdd|vddr|vip|vss|z
+ \$70309 Q_N$9
+ BOTTOM|TOP|VGND|VSS|anode|cathode|core|h_sw[0]|h_sw[10]|h_sw[1]|h_sw[2]|h_sw[3]|h_sw[4]|h_sw[5]|h_sw[6]|h_sw[7]|h_sw[8]|h_sw[9]|l_sw[0]|l_sw[10]|l_sw[1]|l_sw[2]|l_sw[3]|l_sw[4]|l_sw[5]|l_sw[6]|l_sw[7]|l_sw[8]|l_sw[9]|out|pad|padres|vc|vcp|vdd|vddr|vip|vss|z
+ sg13_lv_nmos L=0.13u W=0.74u AS=0.2516p AD=0.2849p PS=2.16u PD=2.25u rfmode=0
M$498 \$70198 \$70309
+ BOTTOM|TOP|VGND|VSS|anode|cathode|core|h_sw[0]|h_sw[10]|h_sw[1]|h_sw[2]|h_sw[3]|h_sw[4]|h_sw[5]|h_sw[6]|h_sw[7]|h_sw[8]|h_sw[9]|l_sw[0]|l_sw[10]|l_sw[1]|l_sw[2]|l_sw[3]|l_sw[4]|l_sw[5]|l_sw[6]|l_sw[7]|l_sw[8]|l_sw[9]|out|pad|padres|vc|vcp|vdd|vddr|vip|vss|z
+ BOTTOM|TOP|VGND|VSS|anode|cathode|core|h_sw[0]|h_sw[10]|h_sw[1]|h_sw[2]|h_sw[3]|h_sw[4]|h_sw[5]|h_sw[6]|h_sw[7]|h_sw[8]|h_sw[9]|l_sw[0]|l_sw[10]|l_sw[1]|l_sw[2]|l_sw[3]|l_sw[4]|l_sw[5]|l_sw[6]|l_sw[7]|l_sw[8]|l_sw[9]|out|pad|padres|vc|vcp|vdd|vddr|vip|vss|z
+ sg13_lv_nmos L=0.13u W=0.74u AS=0.2516p AD=0.1406p PS=2.16u PD=1.12u rfmode=0
M$499
+ BOTTOM|TOP|VGND|VSS|anode|cathode|core|h_sw[0]|h_sw[10]|h_sw[1]|h_sw[2]|h_sw[3]|h_sw[4]|h_sw[5]|h_sw[6]|h_sw[7]|h_sw[8]|h_sw[9]|l_sw[0]|l_sw[10]|l_sw[1]|l_sw[2]|l_sw[3]|l_sw[4]|l_sw[5]|l_sw[6]|l_sw[7]|l_sw[8]|l_sw[9]|out|pad|padres|vc|vcp|vdd|vddr|vip|vss|z
+ \$70198 A|Q$6
+ BOTTOM|TOP|VGND|VSS|anode|cathode|core|h_sw[0]|h_sw[10]|h_sw[1]|h_sw[2]|h_sw[3]|h_sw[4]|h_sw[5]|h_sw[6]|h_sw[7]|h_sw[8]|h_sw[9]|l_sw[0]|l_sw[10]|l_sw[1]|l_sw[2]|l_sw[3]|l_sw[4]|l_sw[5]|l_sw[6]|l_sw[7]|l_sw[8]|l_sw[9]|out|pad|padres|vc|vcp|vdd|vddr|vip|vss|z
+ sg13_lv_nmos L=0.13u W=0.74u AS=0.1406p AD=0.2516p PS=1.12u PD=2.16u rfmode=0
M$500
+ BOTTOM|TOP|VGND|VSS|anode|cathode|core|h_sw[0]|h_sw[10]|h_sw[1]|h_sw[2]|h_sw[3]|h_sw[4]|h_sw[5]|h_sw[6]|h_sw[7]|h_sw[8]|h_sw[9]|l_sw[0]|l_sw[10]|l_sw[1]|l_sw[2]|l_sw[3]|l_sw[4]|l_sw[5]|l_sw[6]|l_sw[7]|l_sw[8]|l_sw[9]|out|pad|padres|vc|vcp|vdd|vddr|vip|vss|z
+ A|X$16 \$70310
+ BOTTOM|TOP|VGND|VSS|anode|cathode|core|h_sw[0]|h_sw[10]|h_sw[1]|h_sw[2]|h_sw[3]|h_sw[4]|h_sw[5]|h_sw[6]|h_sw[7]|h_sw[8]|h_sw[9]|l_sw[0]|l_sw[10]|l_sw[1]|l_sw[2]|l_sw[3]|l_sw[4]|l_sw[5]|l_sw[6]|l_sw[7]|l_sw[8]|l_sw[9]|out|pad|padres|vc|vcp|vdd|vddr|vip|vss|z
+ sg13_lv_nmos L=0.13u W=0.55u AS=0.14875p AD=0.187p PS=1.16u PD=1.78u rfmode=0
M$501
+ BOTTOM|TOP|VGND|VSS|anode|cathode|core|h_sw[0]|h_sw[10]|h_sw[1]|h_sw[2]|h_sw[3]|h_sw[4]|h_sw[5]|h_sw[6]|h_sw[7]|h_sw[8]|h_sw[9]|l_sw[0]|l_sw[10]|l_sw[1]|l_sw[2]|l_sw[3]|l_sw[4]|l_sw[5]|l_sw[6]|l_sw[7]|l_sw[8]|l_sw[9]|out|pad|padres|vc|vcp|vdd|vddr|vip|vss|z
+ \$70310 X|in_h_sw[10]|nh_sw[10]|x
+ BOTTOM|TOP|VGND|VSS|anode|cathode|core|h_sw[0]|h_sw[10]|h_sw[1]|h_sw[2]|h_sw[3]|h_sw[4]|h_sw[5]|h_sw[6]|h_sw[7]|h_sw[8]|h_sw[9]|l_sw[0]|l_sw[10]|l_sw[1]|l_sw[2]|l_sw[3]|l_sw[4]|l_sw[5]|l_sw[6]|l_sw[7]|l_sw[8]|l_sw[9]|out|pad|padres|vc|vcp|vdd|vddr|vip|vss|z
+ sg13_lv_nmos L=0.13u W=0.74u AS=0.14875p AD=0.2886p PS=1.16u PD=2.26u rfmode=0
M$502 A|Y$15 A|CLK|X
+ BOTTOM|TOP|VGND|VSS|anode|cathode|core|h_sw[0]|h_sw[10]|h_sw[1]|h_sw[2]|h_sw[3]|h_sw[4]|h_sw[5]|h_sw[6]|h_sw[7]|h_sw[8]|h_sw[9]|l_sw[0]|l_sw[10]|l_sw[1]|l_sw[2]|l_sw[3]|l_sw[4]|l_sw[5]|l_sw[6]|l_sw[7]|l_sw[8]|l_sw[9]|out|pad|padres|vc|vcp|vdd|vddr|vip|vss|z
+ BOTTOM|TOP|VGND|VSS|anode|cathode|core|h_sw[0]|h_sw[10]|h_sw[1]|h_sw[2]|h_sw[3]|h_sw[4]|h_sw[5]|h_sw[6]|h_sw[7]|h_sw[8]|h_sw[9]|l_sw[0]|l_sw[10]|l_sw[1]|l_sw[2]|l_sw[3]|l_sw[4]|l_sw[5]|l_sw[6]|l_sw[7]|l_sw[8]|l_sw[9]|out|pad|padres|vc|vcp|vdd|vddr|vip|vss|z
+ sg13_lv_nmos L=0.13u W=0.74u AS=0.2516p AD=0.2516p PS=2.16u PD=2.16u rfmode=0
M$503 \$70279 A|Y$16
+ BOTTOM|TOP|VGND|VSS|anode|cathode|core|h_sw[0]|h_sw[10]|h_sw[1]|h_sw[2]|h_sw[3]|h_sw[4]|h_sw[5]|h_sw[6]|h_sw[7]|h_sw[8]|h_sw[9]|l_sw[0]|l_sw[10]|l_sw[1]|l_sw[2]|l_sw[3]|l_sw[4]|l_sw[5]|l_sw[6]|l_sw[7]|l_sw[8]|l_sw[9]|out|pad|padres|vc|vcp|vdd|vddr|vip|vss|z
+ BOTTOM|TOP|VGND|VSS|anode|cathode|core|h_sw[0]|h_sw[10]|h_sw[1]|h_sw[2]|h_sw[3]|h_sw[4]|h_sw[5]|h_sw[6]|h_sw[7]|h_sw[8]|h_sw[9]|l_sw[0]|l_sw[10]|l_sw[1]|l_sw[2]|l_sw[3]|l_sw[4]|l_sw[5]|l_sw[6]|l_sw[7]|l_sw[8]|l_sw[9]|out|pad|padres|vc|vcp|vdd|vddr|vip|vss|z
+ sg13_lv_nmos L=0.13u W=0.42u AS=0.1428p AD=0.1323p PS=1.52u PD=1.05u rfmode=0
M$504
+ BOTTOM|TOP|VGND|VSS|anode|cathode|core|h_sw[0]|h_sw[10]|h_sw[1]|h_sw[2]|h_sw[3]|h_sw[4]|h_sw[5]|h_sw[6]|h_sw[7]|h_sw[8]|h_sw[9]|l_sw[0]|l_sw[10]|l_sw[1]|l_sw[2]|l_sw[3]|l_sw[4]|l_sw[5]|l_sw[6]|l_sw[7]|l_sw[8]|l_sw[9]|out|pad|padres|vc|vcp|vdd|vddr|vip|vss|z
+ \$70279 \$70280
+ BOTTOM|TOP|VGND|VSS|anode|cathode|core|h_sw[0]|h_sw[10]|h_sw[1]|h_sw[2]|h_sw[3]|h_sw[4]|h_sw[5]|h_sw[6]|h_sw[7]|h_sw[8]|h_sw[9]|l_sw[0]|l_sw[10]|l_sw[1]|l_sw[2]|l_sw[3]|l_sw[4]|l_sw[5]|l_sw[6]|l_sw[7]|l_sw[8]|l_sw[9]|out|pad|padres|vc|vcp|vdd|vddr|vip|vss|z
+ sg13_lv_nmos L=0.18u W=0.42u AS=0.1323p AD=0.1428p PS=1.05u PD=1.52u rfmode=0
M$505
+ BOTTOM|TOP|VGND|VSS|anode|cathode|core|h_sw[0]|h_sw[10]|h_sw[1]|h_sw[2]|h_sw[3]|h_sw[4]|h_sw[5]|h_sw[6]|h_sw[7]|h_sw[8]|h_sw[9]|l_sw[0]|l_sw[10]|l_sw[1]|l_sw[2]|l_sw[3]|l_sw[4]|l_sw[5]|l_sw[6]|l_sw[7]|l_sw[8]|l_sw[9]|out|pad|padres|vc|vcp|vdd|vddr|vip|vss|z
+ \$70280 \$70281
+ BOTTOM|TOP|VGND|VSS|anode|cathode|core|h_sw[0]|h_sw[10]|h_sw[1]|h_sw[2]|h_sw[3]|h_sw[4]|h_sw[5]|h_sw[6]|h_sw[7]|h_sw[8]|h_sw[9]|l_sw[0]|l_sw[10]|l_sw[1]|l_sw[2]|l_sw[3]|l_sw[4]|l_sw[5]|l_sw[6]|l_sw[7]|l_sw[8]|l_sw[9]|out|pad|padres|vc|vcp|vdd|vddr|vip|vss|z
+ sg13_lv_nmos L=0.18u W=0.42u AS=0.1405p AD=0.2163p PS=1.15u PD=1.87u rfmode=0
M$506
+ BOTTOM|TOP|VGND|VSS|anode|cathode|core|h_sw[0]|h_sw[10]|h_sw[1]|h_sw[2]|h_sw[3]|h_sw[4]|h_sw[5]|h_sw[6]|h_sw[7]|h_sw[8]|h_sw[9]|l_sw[0]|l_sw[10]|l_sw[1]|l_sw[2]|l_sw[3]|l_sw[4]|l_sw[5]|l_sw[6]|l_sw[7]|l_sw[8]|l_sw[9]|out|pad|padres|vc|vcp|vdd|vddr|vip|vss|z
+ \$70281 A|X$36
+ BOTTOM|TOP|VGND|VSS|anode|cathode|core|h_sw[0]|h_sw[10]|h_sw[1]|h_sw[2]|h_sw[3]|h_sw[4]|h_sw[5]|h_sw[6]|h_sw[7]|h_sw[8]|h_sw[9]|l_sw[0]|l_sw[10]|l_sw[1]|l_sw[2]|l_sw[3]|l_sw[4]|l_sw[5]|l_sw[6]|l_sw[7]|l_sw[8]|l_sw[9]|out|pad|padres|vc|vcp|vdd|vddr|vip|vss|z
+ sg13_lv_nmos L=0.13u W=0.74u AS=0.1405p AD=0.2516p PS=1.15u PD=2.16u rfmode=0
M$507
+ BOTTOM|TOP|VGND|VSS|anode|cathode|core|h_sw[0]|h_sw[10]|h_sw[1]|h_sw[2]|h_sw[3]|h_sw[4]|h_sw[5]|h_sw[6]|h_sw[7]|h_sw[8]|h_sw[9]|l_sw[0]|l_sw[10]|l_sw[1]|l_sw[2]|l_sw[3]|l_sw[4]|l_sw[5]|l_sw[6]|l_sw[7]|l_sw[8]|l_sw[9]|out|pad|padres|vc|vcp|vdd|vddr|vip|vss|z
+ RESET_B|Y$1 \$70313
+ BOTTOM|TOP|VGND|VSS|anode|cathode|core|h_sw[0]|h_sw[10]|h_sw[1]|h_sw[2]|h_sw[3]|h_sw[4]|h_sw[5]|h_sw[6]|h_sw[7]|h_sw[8]|h_sw[9]|l_sw[0]|l_sw[10]|l_sw[1]|l_sw[2]|l_sw[3]|l_sw[4]|l_sw[5]|l_sw[6]|l_sw[7]|l_sw[8]|l_sw[9]|out|pad|padres|vc|vcp|vdd|vddr|vip|vss|z
+ sg13_lv_nmos L=0.13u W=0.42u AS=0.1701p AD=0.0378p PS=1.65u PD=0.6u rfmode=0
M$508 \$70313 \$70171 \$70284
+ BOTTOM|TOP|VGND|VSS|anode|cathode|core|h_sw[0]|h_sw[10]|h_sw[1]|h_sw[2]|h_sw[3]|h_sw[4]|h_sw[5]|h_sw[6]|h_sw[7]|h_sw[8]|h_sw[9]|l_sw[0]|l_sw[10]|l_sw[1]|l_sw[2]|l_sw[3]|l_sw[4]|l_sw[5]|l_sw[6]|l_sw[7]|l_sw[8]|l_sw[9]|out|pad|padres|vc|vcp|vdd|vddr|vip|vss|z
+ sg13_lv_nmos L=0.13u W=0.42u AS=0.0378p AD=0.1428p PS=0.6u PD=1.52u rfmode=0
M$509 \$70285 \$70172 \$70332
+ BOTTOM|TOP|VGND|VSS|anode|cathode|core|h_sw[0]|h_sw[10]|h_sw[1]|h_sw[2]|h_sw[3]|h_sw[4]|h_sw[5]|h_sw[6]|h_sw[7]|h_sw[8]|h_sw[9]|l_sw[0]|l_sw[10]|l_sw[1]|l_sw[2]|l_sw[3]|l_sw[4]|l_sw[5]|l_sw[6]|l_sw[7]|l_sw[8]|l_sw[9]|out|pad|padres|vc|vcp|vdd|vddr|vip|vss|z
+ sg13_lv_nmos L=0.13u W=0.42u AS=0.1296p AD=0.0798p PS=1.52u PD=0.8u rfmode=0
M$510 \$70332 \$70398 \$70284
+ BOTTOM|TOP|VGND|VSS|anode|cathode|core|h_sw[0]|h_sw[10]|h_sw[1]|h_sw[2]|h_sw[3]|h_sw[4]|h_sw[5]|h_sw[6]|h_sw[7]|h_sw[8]|h_sw[9]|l_sw[0]|l_sw[10]|l_sw[1]|l_sw[2]|l_sw[3]|l_sw[4]|l_sw[5]|l_sw[6]|l_sw[7]|l_sw[8]|l_sw[9]|out|pad|padres|vc|vcp|vdd|vddr|vip|vss|z
+ sg13_lv_nmos L=0.13u W=0.42u AS=0.0798p AD=0.2373p PS=0.8u PD=1.97u rfmode=0
M$511
+ BOTTOM|TOP|VGND|VSS|anode|cathode|core|h_sw[0]|h_sw[10]|h_sw[1]|h_sw[2]|h_sw[3]|h_sw[4]|h_sw[5]|h_sw[6]|h_sw[7]|h_sw[8]|h_sw[9]|l_sw[0]|l_sw[10]|l_sw[1]|l_sw[2]|l_sw[3]|l_sw[4]|l_sw[5]|l_sw[6]|l_sw[7]|l_sw[8]|l_sw[9]|out|pad|padres|vc|vcp|vdd|vddr|vip|vss|z
+ \$70172 \$70398
+ BOTTOM|TOP|VGND|VSS|anode|cathode|core|h_sw[0]|h_sw[10]|h_sw[1]|h_sw[2]|h_sw[3]|h_sw[4]|h_sw[5]|h_sw[6]|h_sw[7]|h_sw[8]|h_sw[9]|l_sw[0]|l_sw[10]|l_sw[1]|l_sw[2]|l_sw[3]|l_sw[4]|l_sw[5]|l_sw[6]|l_sw[7]|l_sw[8]|l_sw[9]|out|pad|padres|vc|vcp|vdd|vddr|vip|vss|z
+ sg13_lv_nmos L=0.13u W=0.74u AS=0.317325p AD=0.2516p PS=1.805u PD=2.16u
+ rfmode=0
M$512
+ BOTTOM|TOP|VGND|VSS|anode|cathode|core|h_sw[0]|h_sw[10]|h_sw[1]|h_sw[2]|h_sw[3]|h_sw[4]|h_sw[5]|h_sw[6]|h_sw[7]|h_sw[8]|h_sw[9]|l_sw[0]|l_sw[10]|l_sw[1]|l_sw[2]|l_sw[3]|l_sw[4]|l_sw[5]|l_sw[6]|l_sw[7]|l_sw[8]|l_sw[9]|out|pad|padres|vc|vcp|vdd|vddr|vip|vss|z
+ CLK|D|GATE|Q \$70172
+ BOTTOM|TOP|VGND|VSS|anode|cathode|core|h_sw[0]|h_sw[10]|h_sw[1]|h_sw[2]|h_sw[3]|h_sw[4]|h_sw[5]|h_sw[6]|h_sw[7]|h_sw[8]|h_sw[9]|l_sw[0]|l_sw[10]|l_sw[1]|l_sw[2]|l_sw[3]|l_sw[4]|l_sw[5]|l_sw[6]|l_sw[7]|l_sw[8]|l_sw[9]|out|pad|padres|vc|vcp|vdd|vddr|vip|vss|z
+ sg13_lv_nmos L=0.13u W=0.74u AS=0.317325p AD=0.2516p PS=1.805u PD=2.16u
+ rfmode=0
M$513 \$70286 \$70172 \$70173
+ BOTTOM|TOP|VGND|VSS|anode|cathode|core|h_sw[0]|h_sw[10]|h_sw[1]|h_sw[2]|h_sw[3]|h_sw[4]|h_sw[5]|h_sw[6]|h_sw[7]|h_sw[8]|h_sw[9]|l_sw[0]|l_sw[10]|l_sw[1]|l_sw[2]|l_sw[3]|l_sw[4]|l_sw[5]|l_sw[6]|l_sw[7]|l_sw[8]|l_sw[9]|out|pad|padres|vc|vcp|vdd|vddr|vip|vss|z
+ sg13_lv_nmos L=0.13u W=0.42u AS=0.12665p AD=0.1428p PS=1.145u PD=1.52u
+ rfmode=0
M$514 \$70171 \$70398 \$70286
+ BOTTOM|TOP|VGND|VSS|anode|cathode|core|h_sw[0]|h_sw[10]|h_sw[1]|h_sw[2]|h_sw[3]|h_sw[4]|h_sw[5]|h_sw[6]|h_sw[7]|h_sw[8]|h_sw[9]|l_sw[0]|l_sw[10]|l_sw[1]|l_sw[2]|l_sw[3]|l_sw[4]|l_sw[5]|l_sw[6]|l_sw[7]|l_sw[8]|l_sw[9]|out|pad|padres|vc|vcp|vdd|vddr|vip|vss|z
+ sg13_lv_nmos L=0.13u W=0.74u AS=0.3473p AD=0.12665p PS=2.71u PD=1.145u
+ rfmode=0
M$515
+ BOTTOM|TOP|VGND|VSS|anode|cathode|core|h_sw[0]|h_sw[10]|h_sw[1]|h_sw[2]|h_sw[3]|h_sw[4]|h_sw[5]|h_sw[6]|h_sw[7]|h_sw[8]|h_sw[9]|l_sw[0]|l_sw[10]|l_sw[1]|l_sw[2]|l_sw[3]|l_sw[4]|l_sw[5]|l_sw[6]|l_sw[7]|l_sw[8]|l_sw[9]|out|pad|padres|vc|vcp|vdd|vddr|vip|vss|z
+ A1|D|Q$1 \$70287
+ BOTTOM|TOP|VGND|VSS|anode|cathode|core|h_sw[0]|h_sw[10]|h_sw[1]|h_sw[2]|h_sw[3]|h_sw[4]|h_sw[5]|h_sw[6]|h_sw[7]|h_sw[8]|h_sw[9]|l_sw[0]|l_sw[10]|l_sw[1]|l_sw[2]|l_sw[3]|l_sw[4]|l_sw[5]|l_sw[6]|l_sw[7]|l_sw[8]|l_sw[9]|out|pad|padres|vc|vcp|vdd|vddr|vip|vss|z
+ sg13_lv_nmos L=0.13u W=0.55u AS=0.15055p AD=0.187p PS=1.17u PD=1.78u rfmode=0
M$516
+ BOTTOM|TOP|VGND|VSS|anode|cathode|core|h_sw[0]|h_sw[10]|h_sw[1]|h_sw[2]|h_sw[3]|h_sw[4]|h_sw[5]|h_sw[6]|h_sw[7]|h_sw[8]|h_sw[9]|l_sw[0]|l_sw[10]|l_sw[1]|l_sw[2]|l_sw[3]|l_sw[4]|l_sw[5]|l_sw[6]|l_sw[7]|l_sw[8]|l_sw[9]|out|pad|padres|vc|vcp|vdd|vddr|vip|vss|z
+ CLK|D|GATE|Q \$70288
+ BOTTOM|TOP|VGND|VSS|anode|cathode|core|h_sw[0]|h_sw[10]|h_sw[1]|h_sw[2]|h_sw[3]|h_sw[4]|h_sw[5]|h_sw[6]|h_sw[7]|h_sw[8]|h_sw[9]|l_sw[0]|l_sw[10]|l_sw[1]|l_sw[2]|l_sw[3]|l_sw[4]|l_sw[5]|l_sw[6]|l_sw[7]|l_sw[8]|l_sw[9]|out|pad|padres|vc|vcp|vdd|vddr|vip|vss|z
+ sg13_lv_nmos L=0.13u W=0.74u AS=0.15055p AD=0.2516p PS=1.17u PD=2.16u rfmode=0
M$517
+ BOTTOM|TOP|VGND|VSS|anode|cathode|core|h_sw[0]|h_sw[10]|h_sw[1]|h_sw[2]|h_sw[3]|h_sw[4]|h_sw[5]|h_sw[6]|h_sw[7]|h_sw[8]|h_sw[9]|l_sw[0]|l_sw[10]|l_sw[1]|l_sw[2]|l_sw[3]|l_sw[4]|l_sw[5]|l_sw[6]|l_sw[7]|l_sw[8]|l_sw[9]|out|pad|padres|vc|vcp|vdd|vddr|vip|vss|z
+ D|Q_N \$70291
+ BOTTOM|TOP|VGND|VSS|anode|cathode|core|h_sw[0]|h_sw[10]|h_sw[1]|h_sw[2]|h_sw[3]|h_sw[4]|h_sw[5]|h_sw[6]|h_sw[7]|h_sw[8]|h_sw[9]|l_sw[0]|l_sw[10]|l_sw[1]|l_sw[2]|l_sw[3]|l_sw[4]|l_sw[5]|l_sw[6]|l_sw[7]|l_sw[8]|l_sw[9]|out|pad|padres|vc|vcp|vdd|vddr|vip|vss|z
+ sg13_lv_nmos L=0.13u W=0.55u AS=0.15055p AD=0.187p PS=1.17u PD=1.78u rfmode=0
M$518
+ BOTTOM|TOP|VGND|VSS|anode|cathode|core|h_sw[0]|h_sw[10]|h_sw[1]|h_sw[2]|h_sw[3]|h_sw[4]|h_sw[5]|h_sw[6]|h_sw[7]|h_sw[8]|h_sw[9]|l_sw[0]|l_sw[10]|l_sw[1]|l_sw[2]|l_sw[3]|l_sw[4]|l_sw[5]|l_sw[6]|l_sw[7]|l_sw[8]|l_sw[9]|out|pad|padres|vc|vcp|vdd|vddr|vip|vss|z
+ CLK|D|GATE|Q$1 \$70292
+ BOTTOM|TOP|VGND|VSS|anode|cathode|core|h_sw[0]|h_sw[10]|h_sw[1]|h_sw[2]|h_sw[3]|h_sw[4]|h_sw[5]|h_sw[6]|h_sw[7]|h_sw[8]|h_sw[9]|l_sw[0]|l_sw[10]|l_sw[1]|l_sw[2]|l_sw[3]|l_sw[4]|l_sw[5]|l_sw[6]|l_sw[7]|l_sw[8]|l_sw[9]|out|pad|padres|vc|vcp|vdd|vddr|vip|vss|z
+ sg13_lv_nmos L=0.13u W=0.74u AS=0.15055p AD=0.2516p PS=1.17u PD=2.16u rfmode=0
M$519
+ BOTTOM|TOP|VGND|VSS|anode|cathode|core|h_sw[0]|h_sw[10]|h_sw[1]|h_sw[2]|h_sw[3]|h_sw[4]|h_sw[5]|h_sw[6]|h_sw[7]|h_sw[8]|h_sw[9]|l_sw[0]|l_sw[10]|l_sw[1]|l_sw[2]|l_sw[3]|l_sw[4]|l_sw[5]|l_sw[6]|l_sw[7]|l_sw[8]|l_sw[9]|out|pad|padres|vc|vcp|vdd|vddr|vip|vss|z
+ A|X$37 A|Y$5
+ BOTTOM|TOP|VGND|VSS|anode|cathode|core|h_sw[0]|h_sw[10]|h_sw[1]|h_sw[2]|h_sw[3]|h_sw[4]|h_sw[5]|h_sw[6]|h_sw[7]|h_sw[8]|h_sw[9]|l_sw[0]|l_sw[10]|l_sw[1]|l_sw[2]|l_sw[3]|l_sw[4]|l_sw[5]|l_sw[6]|l_sw[7]|l_sw[8]|l_sw[9]|out|pad|padres|vc|vcp|vdd|vddr|vip|vss|z
+ sg13_lv_nmos L=0.13u W=0.74u AS=0.2516p AD=0.2516p PS=2.16u PD=2.16u rfmode=0
M$520
+ BOTTOM|TOP|VGND|VSS|anode|cathode|core|h_sw[0]|h_sw[10]|h_sw[1]|h_sw[2]|h_sw[3]|h_sw[4]|h_sw[5]|h_sw[6]|h_sw[7]|h_sw[8]|h_sw[9]|l_sw[0]|l_sw[10]|l_sw[1]|l_sw[2]|l_sw[3]|l_sw[4]|l_sw[5]|l_sw[6]|l_sw[7]|l_sw[8]|l_sw[9]|out|pad|padres|vc|vcp|vdd|vddr|vip|vss|z
+ A|X$29 A|Y$4
+ BOTTOM|TOP|VGND|VSS|anode|cathode|core|h_sw[0]|h_sw[10]|h_sw[1]|h_sw[2]|h_sw[3]|h_sw[4]|h_sw[5]|h_sw[6]|h_sw[7]|h_sw[8]|h_sw[9]|l_sw[0]|l_sw[10]|l_sw[1]|l_sw[2]|l_sw[3]|l_sw[4]|l_sw[5]|l_sw[6]|l_sw[7]|l_sw[8]|l_sw[9]|out|pad|padres|vc|vcp|vdd|vddr|vip|vss|z
+ sg13_lv_nmos L=0.13u W=0.74u AS=0.2516p AD=0.2516p PS=2.16u PD=2.16u rfmode=0
M$523 A1|Y A|Q$1
+ BOTTOM|TOP|VGND|VSS|anode|cathode|core|h_sw[0]|h_sw[10]|h_sw[1]|h_sw[2]|h_sw[3]|h_sw[4]|h_sw[5]|h_sw[6]|h_sw[7]|h_sw[8]|h_sw[9]|l_sw[0]|l_sw[10]|l_sw[1]|l_sw[2]|l_sw[3]|l_sw[4]|l_sw[5]|l_sw[6]|l_sw[7]|l_sw[8]|l_sw[9]|out|pad|padres|vc|vcp|vdd|vddr|vip|vss|z
+ BOTTOM|TOP|VGND|VSS|anode|cathode|core|h_sw[0]|h_sw[10]|h_sw[1]|h_sw[2]|h_sw[3]|h_sw[4]|h_sw[5]|h_sw[6]|h_sw[7]|h_sw[8]|h_sw[9]|l_sw[0]|l_sw[10]|l_sw[1]|l_sw[2]|l_sw[3]|l_sw[4]|l_sw[5]|l_sw[6]|l_sw[7]|l_sw[8]|l_sw[9]|out|pad|padres|vc|vcp|vdd|vddr|vip|vss|z
+ sg13_lv_nmos L=0.13u W=0.74u AS=0.2516p AD=0.2516p PS=2.16u PD=2.16u rfmode=0
M$524
+ BOTTOM|TOP|VGND|VSS|anode|cathode|core|h_sw[0]|h_sw[10]|h_sw[1]|h_sw[2]|h_sw[3]|h_sw[4]|h_sw[5]|h_sw[6]|h_sw[7]|h_sw[8]|h_sw[9]|l_sw[0]|l_sw[10]|l_sw[1]|l_sw[2]|l_sw[3]|l_sw[4]|l_sw[5]|l_sw[6]|l_sw[7]|l_sw[8]|l_sw[9]|out|pad|padres|vc|vcp|vdd|vddr|vip|vss|z
+ A|A1|B|Y \$70326
+ BOTTOM|TOP|VGND|VSS|anode|cathode|core|h_sw[0]|h_sw[10]|h_sw[1]|h_sw[2]|h_sw[3]|h_sw[4]|h_sw[5]|h_sw[6]|h_sw[7]|h_sw[8]|h_sw[9]|l_sw[0]|l_sw[10]|l_sw[1]|l_sw[2]|l_sw[3]|l_sw[4]|l_sw[5]|l_sw[6]|l_sw[7]|l_sw[8]|l_sw[9]|out|pad|padres|vc|vcp|vdd|vddr|vip|vss|z
+ sg13_lv_nmos L=0.13u W=0.74u AS=0.2516p AD=0.1406p PS=2.16u PD=1.12u rfmode=0
M$525 \$70326 A|B_N|Q B1|Y$1
+ BOTTOM|TOP|VGND|VSS|anode|cathode|core|h_sw[0]|h_sw[10]|h_sw[1]|h_sw[2]|h_sw[3]|h_sw[4]|h_sw[5]|h_sw[6]|h_sw[7]|h_sw[8]|h_sw[9]|l_sw[0]|l_sw[10]|l_sw[1]|l_sw[2]|l_sw[3]|l_sw[4]|l_sw[5]|l_sw[6]|l_sw[7]|l_sw[8]|l_sw[9]|out|pad|padres|vc|vcp|vdd|vddr|vip|vss|z
+ sg13_lv_nmos L=0.13u W=0.74u AS=0.1406p AD=0.2516p PS=1.12u PD=2.16u rfmode=0
M$526
+ BOTTOM|TOP|VGND|VSS|anode|cathode|core|h_sw[0]|h_sw[10]|h_sw[1]|h_sw[2]|h_sw[3]|h_sw[4]|h_sw[5]|h_sw[6]|h_sw[7]|h_sw[8]|h_sw[9]|l_sw[0]|l_sw[10]|l_sw[1]|l_sw[2]|l_sw[3]|l_sw[4]|l_sw[5]|l_sw[6]|l_sw[7]|l_sw[8]|l_sw[9]|out|pad|padres|vc|vcp|vdd|vddr|vip|vss|z
+ B|Y \$70325
+ BOTTOM|TOP|VGND|VSS|anode|cathode|core|h_sw[0]|h_sw[10]|h_sw[1]|h_sw[2]|h_sw[3]|h_sw[4]|h_sw[5]|h_sw[6]|h_sw[7]|h_sw[8]|h_sw[9]|l_sw[0]|l_sw[10]|l_sw[1]|l_sw[2]|l_sw[3]|l_sw[4]|l_sw[5]|l_sw[6]|l_sw[7]|l_sw[8]|l_sw[9]|out|pad|padres|vc|vcp|vdd|vddr|vip|vss|z
+ sg13_lv_nmos L=0.13u W=0.74u AS=0.2516p AD=0.1406p PS=2.16u PD=1.12u rfmode=0
M$527 \$70325 A|A1|B|Y A2|Y
+ BOTTOM|TOP|VGND|VSS|anode|cathode|core|h_sw[0]|h_sw[10]|h_sw[1]|h_sw[2]|h_sw[3]|h_sw[4]|h_sw[5]|h_sw[6]|h_sw[7]|h_sw[8]|h_sw[9]|l_sw[0]|l_sw[10]|l_sw[1]|l_sw[2]|l_sw[3]|l_sw[4]|l_sw[5]|l_sw[6]|l_sw[7]|l_sw[8]|l_sw[9]|out|pad|padres|vc|vcp|vdd|vddr|vip|vss|z
+ sg13_lv_nmos L=0.13u W=0.74u AS=0.1406p AD=0.2516p PS=1.12u PD=2.16u rfmode=0
M$528
+ BOTTOM|TOP|VGND|VSS|anode|cathode|core|h_sw[0]|h_sw[10]|h_sw[1]|h_sw[2]|h_sw[3]|h_sw[4]|h_sw[5]|h_sw[6]|h_sw[7]|h_sw[8]|h_sw[9]|l_sw[0]|l_sw[10]|l_sw[1]|l_sw[2]|l_sw[3]|l_sw[4]|l_sw[5]|l_sw[6]|l_sw[7]|l_sw[8]|l_sw[9]|out|pad|padres|vc|vcp|vdd|vddr|vip|vss|z
+ RESET_B|Y \$70329
+ BOTTOM|TOP|VGND|VSS|anode|cathode|core|h_sw[0]|h_sw[10]|h_sw[1]|h_sw[2]|h_sw[3]|h_sw[4]|h_sw[5]|h_sw[6]|h_sw[7]|h_sw[8]|h_sw[9]|l_sw[0]|l_sw[10]|l_sw[1]|l_sw[2]|l_sw[3]|l_sw[4]|l_sw[5]|l_sw[6]|l_sw[7]|l_sw[8]|l_sw[9]|out|pad|padres|vc|vcp|vdd|vddr|vip|vss|z
+ sg13_lv_nmos L=0.13u W=0.42u AS=0.1701p AD=0.0378p PS=1.65u PD=0.6u rfmode=0
M$529 \$70329 \$70186 \$70301
+ BOTTOM|TOP|VGND|VSS|anode|cathode|core|h_sw[0]|h_sw[10]|h_sw[1]|h_sw[2]|h_sw[3]|h_sw[4]|h_sw[5]|h_sw[6]|h_sw[7]|h_sw[8]|h_sw[9]|l_sw[0]|l_sw[10]|l_sw[1]|l_sw[2]|l_sw[3]|l_sw[4]|l_sw[5]|l_sw[6]|l_sw[7]|l_sw[8]|l_sw[9]|out|pad|padres|vc|vcp|vdd|vddr|vip|vss|z
+ sg13_lv_nmos L=0.13u W=0.42u AS=0.0378p AD=0.1428p PS=0.6u PD=1.52u rfmode=0
M$530 \$70302 \$70187 \$70338
+ BOTTOM|TOP|VGND|VSS|anode|cathode|core|h_sw[0]|h_sw[10]|h_sw[1]|h_sw[2]|h_sw[3]|h_sw[4]|h_sw[5]|h_sw[6]|h_sw[7]|h_sw[8]|h_sw[9]|l_sw[0]|l_sw[10]|l_sw[1]|l_sw[2]|l_sw[3]|l_sw[4]|l_sw[5]|l_sw[6]|l_sw[7]|l_sw[8]|l_sw[9]|out|pad|padres|vc|vcp|vdd|vddr|vip|vss|z
+ sg13_lv_nmos L=0.13u W=0.42u AS=0.1296p AD=0.0798p PS=1.52u PD=0.8u rfmode=0
M$531 \$70338 \$70399 \$70301
+ BOTTOM|TOP|VGND|VSS|anode|cathode|core|h_sw[0]|h_sw[10]|h_sw[1]|h_sw[2]|h_sw[3]|h_sw[4]|h_sw[5]|h_sw[6]|h_sw[7]|h_sw[8]|h_sw[9]|l_sw[0]|l_sw[10]|l_sw[1]|l_sw[2]|l_sw[3]|l_sw[4]|l_sw[5]|l_sw[6]|l_sw[7]|l_sw[8]|l_sw[9]|out|pad|padres|vc|vcp|vdd|vddr|vip|vss|z
+ sg13_lv_nmos L=0.13u W=0.42u AS=0.0798p AD=0.2373p PS=0.8u PD=1.97u rfmode=0
M$532
+ BOTTOM|TOP|VGND|VSS|anode|cathode|core|h_sw[0]|h_sw[10]|h_sw[1]|h_sw[2]|h_sw[3]|h_sw[4]|h_sw[5]|h_sw[6]|h_sw[7]|h_sw[8]|h_sw[9]|l_sw[0]|l_sw[10]|l_sw[1]|l_sw[2]|l_sw[3]|l_sw[4]|l_sw[5]|l_sw[6]|l_sw[7]|l_sw[8]|l_sw[9]|out|pad|padres|vc|vcp|vdd|vddr|vip|vss|z
+ \$70187 \$70399
+ BOTTOM|TOP|VGND|VSS|anode|cathode|core|h_sw[0]|h_sw[10]|h_sw[1]|h_sw[2]|h_sw[3]|h_sw[4]|h_sw[5]|h_sw[6]|h_sw[7]|h_sw[8]|h_sw[9]|l_sw[0]|l_sw[10]|l_sw[1]|l_sw[2]|l_sw[3]|l_sw[4]|l_sw[5]|l_sw[6]|l_sw[7]|l_sw[8]|l_sw[9]|out|pad|padres|vc|vcp|vdd|vddr|vip|vss|z
+ sg13_lv_nmos L=0.13u W=0.74u AS=0.317325p AD=0.2516p PS=1.805u PD=2.16u
+ rfmode=0
M$533
+ BOTTOM|TOP|VGND|VSS|anode|cathode|core|h_sw[0]|h_sw[10]|h_sw[1]|h_sw[2]|h_sw[3]|h_sw[4]|h_sw[5]|h_sw[6]|h_sw[7]|h_sw[8]|h_sw[9]|l_sw[0]|l_sw[10]|l_sw[1]|l_sw[2]|l_sw[3]|l_sw[4]|l_sw[5]|l_sw[6]|l_sw[7]|l_sw[8]|l_sw[9]|out|pad|padres|vc|vcp|vdd|vddr|vip|vss|z
+ CLK|Y \$70187
+ BOTTOM|TOP|VGND|VSS|anode|cathode|core|h_sw[0]|h_sw[10]|h_sw[1]|h_sw[2]|h_sw[3]|h_sw[4]|h_sw[5]|h_sw[6]|h_sw[7]|h_sw[8]|h_sw[9]|l_sw[0]|l_sw[10]|l_sw[1]|l_sw[2]|l_sw[3]|l_sw[4]|l_sw[5]|l_sw[6]|l_sw[7]|l_sw[8]|l_sw[9]|out|pad|padres|vc|vcp|vdd|vddr|vip|vss|z
+ sg13_lv_nmos L=0.13u W=0.74u AS=0.317325p AD=0.2516p PS=1.805u PD=2.16u
+ rfmode=0
M$534 \$70303 \$70187 \$70188
+ BOTTOM|TOP|VGND|VSS|anode|cathode|core|h_sw[0]|h_sw[10]|h_sw[1]|h_sw[2]|h_sw[3]|h_sw[4]|h_sw[5]|h_sw[6]|h_sw[7]|h_sw[8]|h_sw[9]|l_sw[0]|l_sw[10]|l_sw[1]|l_sw[2]|l_sw[3]|l_sw[4]|l_sw[5]|l_sw[6]|l_sw[7]|l_sw[8]|l_sw[9]|out|pad|padres|vc|vcp|vdd|vddr|vip|vss|z
+ sg13_lv_nmos L=0.13u W=0.42u AS=0.12665p AD=0.1428p PS=1.145u PD=1.52u
+ rfmode=0
M$535 \$70186 \$70399 \$70303
+ BOTTOM|TOP|VGND|VSS|anode|cathode|core|h_sw[0]|h_sw[10]|h_sw[1]|h_sw[2]|h_sw[3]|h_sw[4]|h_sw[5]|h_sw[6]|h_sw[7]|h_sw[8]|h_sw[9]|l_sw[0]|l_sw[10]|l_sw[1]|l_sw[2]|l_sw[3]|l_sw[4]|l_sw[5]|l_sw[6]|l_sw[7]|l_sw[8]|l_sw[9]|out|pad|padres|vc|vcp|vdd|vddr|vip|vss|z
+ sg13_lv_nmos L=0.13u W=0.74u AS=0.3473p AD=0.12665p PS=2.71u PD=1.145u
+ rfmode=0
M$536 RESET_B|Y A|anode|cathode|ck|cks|core|pad|padres
+ BOTTOM|TOP|VGND|VSS|anode|cathode|core|h_sw[0]|h_sw[10]|h_sw[1]|h_sw[2]|h_sw[3]|h_sw[4]|h_sw[5]|h_sw[6]|h_sw[7]|h_sw[8]|h_sw[9]|l_sw[0]|l_sw[10]|l_sw[1]|l_sw[2]|l_sw[3]|l_sw[4]|l_sw[5]|l_sw[6]|l_sw[7]|l_sw[8]|l_sw[9]|out|pad|padres|vc|vcp|vdd|vddr|vip|vss|z
+ BOTTOM|TOP|VGND|VSS|anode|cathode|core|h_sw[0]|h_sw[10]|h_sw[1]|h_sw[2]|h_sw[3]|h_sw[4]|h_sw[5]|h_sw[6]|h_sw[7]|h_sw[8]|h_sw[9]|l_sw[0]|l_sw[10]|l_sw[1]|l_sw[2]|l_sw[3]|l_sw[4]|l_sw[5]|l_sw[6]|l_sw[7]|l_sw[8]|l_sw[9]|out|pad|padres|vc|vcp|vdd|vddr|vip|vss|z
+ sg13_lv_nmos L=0.13u W=0.74u AS=0.2516p AD=0.2516p PS=2.16u PD=2.16u rfmode=0
M$537
+ BOTTOM|TOP|VGND|VSS|anode|cathode|core|h_sw[0]|h_sw[10]|h_sw[1]|h_sw[2]|h_sw[3]|h_sw[4]|h_sw[5]|h_sw[6]|h_sw[7]|h_sw[8]|h_sw[9]|l_sw[0]|l_sw[10]|l_sw[1]|l_sw[2]|l_sw[3]|l_sw[4]|l_sw[5]|l_sw[6]|l_sw[7]|l_sw[8]|l_sw[9]|out|pad|padres|vc|vcp|vdd|vddr|vip|vss|z
+ RESET_B|Y \$70321
+ BOTTOM|TOP|VGND|VSS|anode|cathode|core|h_sw[0]|h_sw[10]|h_sw[1]|h_sw[2]|h_sw[3]|h_sw[4]|h_sw[5]|h_sw[6]|h_sw[7]|h_sw[8]|h_sw[9]|l_sw[0]|l_sw[10]|l_sw[1]|l_sw[2]|l_sw[3]|l_sw[4]|l_sw[5]|l_sw[6]|l_sw[7]|l_sw[8]|l_sw[9]|out|pad|padres|vc|vcp|vdd|vddr|vip|vss|z
+ sg13_lv_nmos L=0.13u W=0.42u AS=0.1701p AD=0.0378p PS=1.65u PD=0.6u rfmode=0
M$538 \$70321 \$70193 \$70307
+ BOTTOM|TOP|VGND|VSS|anode|cathode|core|h_sw[0]|h_sw[10]|h_sw[1]|h_sw[2]|h_sw[3]|h_sw[4]|h_sw[5]|h_sw[6]|h_sw[7]|h_sw[8]|h_sw[9]|l_sw[0]|l_sw[10]|l_sw[1]|l_sw[2]|l_sw[3]|l_sw[4]|l_sw[5]|l_sw[6]|l_sw[7]|l_sw[8]|l_sw[9]|out|pad|padres|vc|vcp|vdd|vddr|vip|vss|z
+ sg13_lv_nmos L=0.13u W=0.42u AS=0.0378p AD=0.1428p PS=0.6u PD=1.52u rfmode=0
M$539 \$70308 \$70194 \$70339
+ BOTTOM|TOP|VGND|VSS|anode|cathode|core|h_sw[0]|h_sw[10]|h_sw[1]|h_sw[2]|h_sw[3]|h_sw[4]|h_sw[5]|h_sw[6]|h_sw[7]|h_sw[8]|h_sw[9]|l_sw[0]|l_sw[10]|l_sw[1]|l_sw[2]|l_sw[3]|l_sw[4]|l_sw[5]|l_sw[6]|l_sw[7]|l_sw[8]|l_sw[9]|out|pad|padres|vc|vcp|vdd|vddr|vip|vss|z
+ sg13_lv_nmos L=0.13u W=0.42u AS=0.1296p AD=0.0798p PS=1.52u PD=0.8u rfmode=0
M$540 \$70339 \$70400 \$70307
+ BOTTOM|TOP|VGND|VSS|anode|cathode|core|h_sw[0]|h_sw[10]|h_sw[1]|h_sw[2]|h_sw[3]|h_sw[4]|h_sw[5]|h_sw[6]|h_sw[7]|h_sw[8]|h_sw[9]|l_sw[0]|l_sw[10]|l_sw[1]|l_sw[2]|l_sw[3]|l_sw[4]|l_sw[5]|l_sw[6]|l_sw[7]|l_sw[8]|l_sw[9]|out|pad|padres|vc|vcp|vdd|vddr|vip|vss|z
+ sg13_lv_nmos L=0.13u W=0.42u AS=0.0798p AD=0.2373p PS=0.8u PD=1.97u rfmode=0
M$541
+ BOTTOM|TOP|VGND|VSS|anode|cathode|core|h_sw[0]|h_sw[10]|h_sw[1]|h_sw[2]|h_sw[3]|h_sw[4]|h_sw[5]|h_sw[6]|h_sw[7]|h_sw[8]|h_sw[9]|l_sw[0]|l_sw[10]|l_sw[1]|l_sw[2]|l_sw[3]|l_sw[4]|l_sw[5]|l_sw[6]|l_sw[7]|l_sw[8]|l_sw[9]|out|pad|padres|vc|vcp|vdd|vddr|vip|vss|z
+ \$70194 \$70400
+ BOTTOM|TOP|VGND|VSS|anode|cathode|core|h_sw[0]|h_sw[10]|h_sw[1]|h_sw[2]|h_sw[3]|h_sw[4]|h_sw[5]|h_sw[6]|h_sw[7]|h_sw[8]|h_sw[9]|l_sw[0]|l_sw[10]|l_sw[1]|l_sw[2]|l_sw[3]|l_sw[4]|l_sw[5]|l_sw[6]|l_sw[7]|l_sw[8]|l_sw[9]|out|pad|padres|vc|vcp|vdd|vddr|vip|vss|z
+ sg13_lv_nmos L=0.13u W=0.74u AS=0.317325p AD=0.2516p PS=1.805u PD=2.16u
+ rfmode=0
M$542
+ BOTTOM|TOP|VGND|VSS|anode|cathode|core|h_sw[0]|h_sw[10]|h_sw[1]|h_sw[2]|h_sw[3]|h_sw[4]|h_sw[5]|h_sw[6]|h_sw[7]|h_sw[8]|h_sw[9]|l_sw[0]|l_sw[10]|l_sw[1]|l_sw[2]|l_sw[3]|l_sw[4]|l_sw[5]|l_sw[6]|l_sw[7]|l_sw[8]|l_sw[9]|out|pad|padres|vc|vcp|vdd|vddr|vip|vss|z
+ CLK|Y \$70194
+ BOTTOM|TOP|VGND|VSS|anode|cathode|core|h_sw[0]|h_sw[10]|h_sw[1]|h_sw[2]|h_sw[3]|h_sw[4]|h_sw[5]|h_sw[6]|h_sw[7]|h_sw[8]|h_sw[9]|l_sw[0]|l_sw[10]|l_sw[1]|l_sw[2]|l_sw[3]|l_sw[4]|l_sw[5]|l_sw[6]|l_sw[7]|l_sw[8]|l_sw[9]|out|pad|padres|vc|vcp|vdd|vddr|vip|vss|z
+ sg13_lv_nmos L=0.13u W=0.74u AS=0.317325p AD=0.2516p PS=1.805u PD=2.16u
+ rfmode=0
M$543 \$70309 \$70194 \$70195
+ BOTTOM|TOP|VGND|VSS|anode|cathode|core|h_sw[0]|h_sw[10]|h_sw[1]|h_sw[2]|h_sw[3]|h_sw[4]|h_sw[5]|h_sw[6]|h_sw[7]|h_sw[8]|h_sw[9]|l_sw[0]|l_sw[10]|l_sw[1]|l_sw[2]|l_sw[3]|l_sw[4]|l_sw[5]|l_sw[6]|l_sw[7]|l_sw[8]|l_sw[9]|out|pad|padres|vc|vcp|vdd|vddr|vip|vss|z
+ sg13_lv_nmos L=0.13u W=0.42u AS=0.12665p AD=0.1428p PS=1.145u PD=1.52u
+ rfmode=0
M$544 \$70193 \$70400 \$70309
+ BOTTOM|TOP|VGND|VSS|anode|cathode|core|h_sw[0]|h_sw[10]|h_sw[1]|h_sw[2]|h_sw[3]|h_sw[4]|h_sw[5]|h_sw[6]|h_sw[7]|h_sw[8]|h_sw[9]|l_sw[0]|l_sw[10]|l_sw[1]|l_sw[2]|l_sw[3]|l_sw[4]|l_sw[5]|l_sw[6]|l_sw[7]|l_sw[8]|l_sw[9]|out|pad|padres|vc|vcp|vdd|vddr|vip|vss|z
+ sg13_lv_nmos L=0.13u W=0.74u AS=0.3473p AD=0.12665p PS=2.71u PD=1.145u
+ rfmode=0
M$545 out|vcn|vin \$70277 anode|cathode|core|in|pad|padres|vin
+ BOTTOM|TOP|VGND|VSS|anode|cathode|core|h_sw[0]|h_sw[10]|h_sw[1]|h_sw[2]|h_sw[3]|h_sw[4]|h_sw[5]|h_sw[6]|h_sw[7]|h_sw[8]|h_sw[9]|l_sw[0]|l_sw[10]|l_sw[1]|l_sw[2]|l_sw[3]|l_sw[4]|l_sw[5]|l_sw[6]|l_sw[7]|l_sw[8]|l_sw[9]|out|pad|padres|vc|vcp|vdd|vddr|vip|vss|z
+ sg13_lv_nmos L=0.13u W=2.5u AS=0.85p AD=0.85p PS=5.68u PD=5.68u rfmode=0
M$546
+ BOTTOM|TOP|VGND|VSS|anode|cathode|core|h_sw[0]|h_sw[10]|h_sw[1]|h_sw[2]|h_sw[3]|h_sw[4]|h_sw[5]|h_sw[6]|h_sw[7]|h_sw[8]|h_sw[9]|l_sw[0]|l_sw[10]|l_sw[1]|l_sw[2]|l_sw[3]|l_sw[4]|l_sw[5]|l_sw[6]|l_sw[7]|l_sw[8]|l_sw[9]|out|pad|padres|vc|vcp|vdd|vddr|vip|vss|z
+ A|Y$12 B|Y$1
+ BOTTOM|TOP|VGND|VSS|anode|cathode|core|h_sw[0]|h_sw[10]|h_sw[1]|h_sw[2]|h_sw[3]|h_sw[4]|h_sw[5]|h_sw[6]|h_sw[7]|h_sw[8]|h_sw[9]|l_sw[0]|l_sw[10]|l_sw[1]|l_sw[2]|l_sw[3]|l_sw[4]|l_sw[5]|l_sw[6]|l_sw[7]|l_sw[8]|l_sw[9]|out|pad|padres|vc|vcp|vdd|vddr|vip|vss|z
+ sg13_lv_nmos L=0.13u W=0.74u AS=0.2516p AD=0.1406p PS=2.16u PD=1.12u rfmode=0
M$547 B|Y$1 A|B|X
+ BOTTOM|TOP|VGND|VSS|anode|cathode|core|h_sw[0]|h_sw[10]|h_sw[1]|h_sw[2]|h_sw[3]|h_sw[4]|h_sw[5]|h_sw[6]|h_sw[7]|h_sw[8]|h_sw[9]|l_sw[0]|l_sw[10]|l_sw[1]|l_sw[2]|l_sw[3]|l_sw[4]|l_sw[5]|l_sw[6]|l_sw[7]|l_sw[8]|l_sw[9]|out|pad|padres|vc|vcp|vdd|vddr|vip|vss|z
+ BOTTOM|TOP|VGND|VSS|anode|cathode|core|h_sw[0]|h_sw[10]|h_sw[1]|h_sw[2]|h_sw[3]|h_sw[4]|h_sw[5]|h_sw[6]|h_sw[7]|h_sw[8]|h_sw[9]|l_sw[0]|l_sw[10]|l_sw[1]|l_sw[2]|l_sw[3]|l_sw[4]|l_sw[5]|l_sw[6]|l_sw[7]|l_sw[8]|l_sw[9]|out|pad|padres|vc|vcp|vdd|vddr|vip|vss|z
+ sg13_lv_nmos L=0.13u W=0.74u AS=0.1406p AD=0.2516p PS=1.12u PD=2.16u rfmode=0
M$548
+ BOTTOM|TOP|VGND|VSS|anode|cathode|core|h_sw[0]|h_sw[10]|h_sw[1]|h_sw[2]|h_sw[3]|h_sw[4]|h_sw[5]|h_sw[6]|h_sw[7]|h_sw[8]|h_sw[9]|l_sw[0]|l_sw[10]|l_sw[1]|l_sw[2]|l_sw[3]|l_sw[4]|l_sw[5]|l_sw[6]|l_sw[7]|l_sw[8]|l_sw[9]|out|pad|padres|vc|vcp|vdd|vddr|vip|vss|z
+ \$70937 \$70936
+ BOTTOM|TOP|VGND|VSS|anode|cathode|core|h_sw[0]|h_sw[10]|h_sw[1]|h_sw[2]|h_sw[3]|h_sw[4]|h_sw[5]|h_sw[6]|h_sw[7]|h_sw[8]|h_sw[9]|l_sw[0]|l_sw[10]|l_sw[1]|l_sw[2]|l_sw[3]|l_sw[4]|l_sw[5]|l_sw[6]|l_sw[7]|l_sw[8]|l_sw[9]|out|pad|padres|vc|vcp|vdd|vddr|vip|vss|z
+ sg13_lv_nmos L=0.5u W=0.42u AS=0.1426p AD=0.1428p PS=1.16u PD=1.52u rfmode=0
M$549 A|X$39 \$70936
+ BOTTOM|TOP|VGND|VSS|anode|cathode|core|h_sw[0]|h_sw[10]|h_sw[1]|h_sw[2]|h_sw[3]|h_sw[4]|h_sw[5]|h_sw[6]|h_sw[7]|h_sw[8]|h_sw[9]|l_sw[0]|l_sw[10]|l_sw[1]|l_sw[2]|l_sw[3]|l_sw[4]|l_sw[5]|l_sw[6]|l_sw[7]|l_sw[8]|l_sw[9]|out|pad|padres|vc|vcp|vdd|vddr|vip|vss|z
+ BOTTOM|TOP|VGND|VSS|anode|cathode|core|h_sw[0]|h_sw[10]|h_sw[1]|h_sw[2]|h_sw[3]|h_sw[4]|h_sw[5]|h_sw[6]|h_sw[7]|h_sw[8]|h_sw[9]|l_sw[0]|l_sw[10]|l_sw[1]|l_sw[2]|l_sw[3]|l_sw[4]|l_sw[5]|l_sw[6]|l_sw[7]|l_sw[8]|l_sw[9]|out|pad|padres|vc|vcp|vdd|vddr|vip|vss|z
+ sg13_lv_nmos L=0.13u W=0.74u AS=0.2516p AD=0.1426p PS=2.16u PD=1.16u rfmode=0
M$550 \$70939 \$70977 \$70940
+ BOTTOM|TOP|VGND|VSS|anode|cathode|core|h_sw[0]|h_sw[10]|h_sw[1]|h_sw[2]|h_sw[3]|h_sw[4]|h_sw[5]|h_sw[6]|h_sw[7]|h_sw[8]|h_sw[9]|l_sw[0]|l_sw[10]|l_sw[1]|l_sw[2]|l_sw[3]|l_sw[4]|l_sw[5]|l_sw[6]|l_sw[7]|l_sw[8]|l_sw[9]|out|pad|padres|vc|vcp|vdd|vddr|vip|vss|z
+ sg13_lv_nmos L=0.13u W=0.42u AS=0.1296p AD=0.0798p PS=1.52u PD=0.8u rfmode=0
M$551 \$70940 \$70941 \$71154
+ BOTTOM|TOP|VGND|VSS|anode|cathode|core|h_sw[0]|h_sw[10]|h_sw[1]|h_sw[2]|h_sw[3]|h_sw[4]|h_sw[5]|h_sw[6]|h_sw[7]|h_sw[8]|h_sw[9]|l_sw[0]|l_sw[10]|l_sw[1]|l_sw[2]|l_sw[3]|l_sw[4]|l_sw[5]|l_sw[6]|l_sw[7]|l_sw[8]|l_sw[9]|out|pad|padres|vc|vcp|vdd|vddr|vip|vss|z
+ sg13_lv_nmos L=0.13u W=0.42u AS=0.0798p AD=0.2373p PS=0.8u PD=1.97u rfmode=0
M$552 \$70941 \$70977
+ BOTTOM|TOP|VGND|VSS|anode|cathode|core|h_sw[0]|h_sw[10]|h_sw[1]|h_sw[2]|h_sw[3]|h_sw[4]|h_sw[5]|h_sw[6]|h_sw[7]|h_sw[8]|h_sw[9]|l_sw[0]|l_sw[10]|l_sw[1]|l_sw[2]|l_sw[3]|l_sw[4]|l_sw[5]|l_sw[6]|l_sw[7]|l_sw[8]|l_sw[9]|out|pad|padres|vc|vcp|vdd|vddr|vip|vss|z
+ BOTTOM|TOP|VGND|VSS|anode|cathode|core|h_sw[0]|h_sw[10]|h_sw[1]|h_sw[2]|h_sw[3]|h_sw[4]|h_sw[5]|h_sw[6]|h_sw[7]|h_sw[8]|h_sw[9]|l_sw[0]|l_sw[10]|l_sw[1]|l_sw[2]|l_sw[3]|l_sw[4]|l_sw[5]|l_sw[6]|l_sw[7]|l_sw[8]|l_sw[9]|out|pad|padres|vc|vcp|vdd|vddr|vip|vss|z
+ sg13_lv_nmos L=0.13u W=0.74u AS=0.2516p AD=0.317325p PS=2.16u PD=1.805u
+ rfmode=0
M$553
+ BOTTOM|TOP|VGND|VSS|anode|cathode|core|h_sw[0]|h_sw[10]|h_sw[1]|h_sw[2]|h_sw[3]|h_sw[4]|h_sw[5]|h_sw[6]|h_sw[7]|h_sw[8]|h_sw[9]|l_sw[0]|l_sw[10]|l_sw[1]|l_sw[2]|l_sw[3]|l_sw[4]|l_sw[5]|l_sw[6]|l_sw[7]|l_sw[8]|l_sw[9]|out|pad|padres|vc|vcp|vdd|vddr|vip|vss|z
+ A|CLK|X \$70977
+ BOTTOM|TOP|VGND|VSS|anode|cathode|core|h_sw[0]|h_sw[10]|h_sw[1]|h_sw[2]|h_sw[3]|h_sw[4]|h_sw[5]|h_sw[6]|h_sw[7]|h_sw[8]|h_sw[9]|l_sw[0]|l_sw[10]|l_sw[1]|l_sw[2]|l_sw[3]|l_sw[4]|l_sw[5]|l_sw[6]|l_sw[7]|l_sw[8]|l_sw[9]|out|pad|padres|vc|vcp|vdd|vddr|vip|vss|z
+ sg13_lv_nmos L=0.13u W=0.74u AS=0.317325p AD=0.2516p PS=1.805u PD=2.16u
+ rfmode=0
M$554 \$71169 \$70977 \$71155
+ BOTTOM|TOP|VGND|VSS|anode|cathode|core|h_sw[0]|h_sw[10]|h_sw[1]|h_sw[2]|h_sw[3]|h_sw[4]|h_sw[5]|h_sw[6]|h_sw[7]|h_sw[8]|h_sw[9]|l_sw[0]|l_sw[10]|l_sw[1]|l_sw[2]|l_sw[3]|l_sw[4]|l_sw[5]|l_sw[6]|l_sw[7]|l_sw[8]|l_sw[9]|out|pad|padres|vc|vcp|vdd|vddr|vip|vss|z
+ sg13_lv_nmos L=0.13u W=0.42u AS=0.1428p AD=0.12665p PS=1.52u PD=1.145u
+ rfmode=0
M$555 \$71155 \$70941 \$70976
+ BOTTOM|TOP|VGND|VSS|anode|cathode|core|h_sw[0]|h_sw[10]|h_sw[1]|h_sw[2]|h_sw[3]|h_sw[4]|h_sw[5]|h_sw[6]|h_sw[7]|h_sw[8]|h_sw[9]|l_sw[0]|l_sw[10]|l_sw[1]|l_sw[2]|l_sw[3]|l_sw[4]|l_sw[5]|l_sw[6]|l_sw[7]|l_sw[8]|l_sw[9]|out|pad|padres|vc|vcp|vdd|vddr|vip|vss|z
+ sg13_lv_nmos L=0.13u W=0.74u AS=0.12665p AD=0.3473p PS=1.145u PD=2.71u
+ rfmode=0
M$556 A|Y$3 A|X$40
+ BOTTOM|TOP|VGND|VSS|anode|cathode|core|h_sw[0]|h_sw[10]|h_sw[1]|h_sw[2]|h_sw[3]|h_sw[4]|h_sw[5]|h_sw[6]|h_sw[7]|h_sw[8]|h_sw[9]|l_sw[0]|l_sw[10]|l_sw[1]|l_sw[2]|l_sw[3]|l_sw[4]|l_sw[5]|l_sw[6]|l_sw[7]|l_sw[8]|l_sw[9]|out|pad|padres|vc|vcp|vdd|vddr|vip|vss|z
+ BOTTOM|TOP|VGND|VSS|anode|cathode|core|h_sw[0]|h_sw[10]|h_sw[1]|h_sw[2]|h_sw[3]|h_sw[4]|h_sw[5]|h_sw[6]|h_sw[7]|h_sw[8]|h_sw[9]|l_sw[0]|l_sw[10]|l_sw[1]|l_sw[2]|l_sw[3]|l_sw[4]|l_sw[5]|l_sw[6]|l_sw[7]|l_sw[8]|l_sw[9]|out|pad|padres|vc|vcp|vdd|vddr|vip|vss|z
+ sg13_lv_nmos L=0.13u W=0.74u AS=0.2516p AD=0.2516p PS=2.16u PD=2.16u rfmode=0
M$557 \$70946 \$70980 \$70947
+ BOTTOM|TOP|VGND|VSS|anode|cathode|core|h_sw[0]|h_sw[10]|h_sw[1]|h_sw[2]|h_sw[3]|h_sw[4]|h_sw[5]|h_sw[6]|h_sw[7]|h_sw[8]|h_sw[9]|l_sw[0]|l_sw[10]|l_sw[1]|l_sw[2]|l_sw[3]|l_sw[4]|l_sw[5]|l_sw[6]|l_sw[7]|l_sw[8]|l_sw[9]|out|pad|padres|vc|vcp|vdd|vddr|vip|vss|z
+ sg13_lv_nmos L=0.13u W=0.42u AS=0.1296p AD=0.0798p PS=1.52u PD=0.8u rfmode=0
M$558 \$70947 \$70948 \$71156
+ BOTTOM|TOP|VGND|VSS|anode|cathode|core|h_sw[0]|h_sw[10]|h_sw[1]|h_sw[2]|h_sw[3]|h_sw[4]|h_sw[5]|h_sw[6]|h_sw[7]|h_sw[8]|h_sw[9]|l_sw[0]|l_sw[10]|l_sw[1]|l_sw[2]|l_sw[3]|l_sw[4]|l_sw[5]|l_sw[6]|l_sw[7]|l_sw[8]|l_sw[9]|out|pad|padres|vc|vcp|vdd|vddr|vip|vss|z
+ sg13_lv_nmos L=0.13u W=0.42u AS=0.0798p AD=0.2373p PS=0.8u PD=1.97u rfmode=0
M$559 \$70948 \$70980
+ BOTTOM|TOP|VGND|VSS|anode|cathode|core|h_sw[0]|h_sw[10]|h_sw[1]|h_sw[2]|h_sw[3]|h_sw[4]|h_sw[5]|h_sw[6]|h_sw[7]|h_sw[8]|h_sw[9]|l_sw[0]|l_sw[10]|l_sw[1]|l_sw[2]|l_sw[3]|l_sw[4]|l_sw[5]|l_sw[6]|l_sw[7]|l_sw[8]|l_sw[9]|out|pad|padres|vc|vcp|vdd|vddr|vip|vss|z
+ BOTTOM|TOP|VGND|VSS|anode|cathode|core|h_sw[0]|h_sw[10]|h_sw[1]|h_sw[2]|h_sw[3]|h_sw[4]|h_sw[5]|h_sw[6]|h_sw[7]|h_sw[8]|h_sw[9]|l_sw[0]|l_sw[10]|l_sw[1]|l_sw[2]|l_sw[3]|l_sw[4]|l_sw[5]|l_sw[6]|l_sw[7]|l_sw[8]|l_sw[9]|out|pad|padres|vc|vcp|vdd|vddr|vip|vss|z
+ sg13_lv_nmos L=0.13u W=0.74u AS=0.2516p AD=0.317325p PS=2.16u PD=1.805u
+ rfmode=0
M$560
+ BOTTOM|TOP|VGND|VSS|anode|cathode|core|h_sw[0]|h_sw[10]|h_sw[1]|h_sw[2]|h_sw[3]|h_sw[4]|h_sw[5]|h_sw[6]|h_sw[7]|h_sw[8]|h_sw[9]|l_sw[0]|l_sw[10]|l_sw[1]|l_sw[2]|l_sw[3]|l_sw[4]|l_sw[5]|l_sw[6]|l_sw[7]|l_sw[8]|l_sw[9]|out|pad|padres|vc|vcp|vdd|vddr|vip|vss|z
+ CLK|D|GATE|Q$3 \$70980
+ BOTTOM|TOP|VGND|VSS|anode|cathode|core|h_sw[0]|h_sw[10]|h_sw[1]|h_sw[2]|h_sw[3]|h_sw[4]|h_sw[5]|h_sw[6]|h_sw[7]|h_sw[8]|h_sw[9]|l_sw[0]|l_sw[10]|l_sw[1]|l_sw[2]|l_sw[3]|l_sw[4]|l_sw[5]|l_sw[6]|l_sw[7]|l_sw[8]|l_sw[9]|out|pad|padres|vc|vcp|vdd|vddr|vip|vss|z
+ sg13_lv_nmos L=0.13u W=0.74u AS=0.317325p AD=0.2516p PS=1.805u PD=2.16u
+ rfmode=0
M$561 \$71170 \$70980 \$71158
+ BOTTOM|TOP|VGND|VSS|anode|cathode|core|h_sw[0]|h_sw[10]|h_sw[1]|h_sw[2]|h_sw[3]|h_sw[4]|h_sw[5]|h_sw[6]|h_sw[7]|h_sw[8]|h_sw[9]|l_sw[0]|l_sw[10]|l_sw[1]|l_sw[2]|l_sw[3]|l_sw[4]|l_sw[5]|l_sw[6]|l_sw[7]|l_sw[8]|l_sw[9]|out|pad|padres|vc|vcp|vdd|vddr|vip|vss|z
+ sg13_lv_nmos L=0.13u W=0.42u AS=0.1428p AD=0.12665p PS=1.52u PD=1.145u
+ rfmode=0
M$562 \$71158 \$70948 \$70979
+ BOTTOM|TOP|VGND|VSS|anode|cathode|core|h_sw[0]|h_sw[10]|h_sw[1]|h_sw[2]|h_sw[3]|h_sw[4]|h_sw[5]|h_sw[6]|h_sw[7]|h_sw[8]|h_sw[9]|l_sw[0]|l_sw[10]|l_sw[1]|l_sw[2]|l_sw[3]|l_sw[4]|l_sw[5]|l_sw[6]|l_sw[7]|l_sw[8]|l_sw[9]|out|pad|padres|vc|vcp|vdd|vddr|vip|vss|z
+ sg13_lv_nmos L=0.13u W=0.74u AS=0.12665p AD=0.3473p PS=1.145u PD=2.71u
+ rfmode=0
M$563 D|Y$4 A|Y$17
+ BOTTOM|TOP|VGND|VSS|anode|cathode|core|h_sw[0]|h_sw[10]|h_sw[1]|h_sw[2]|h_sw[3]|h_sw[4]|h_sw[5]|h_sw[6]|h_sw[7]|h_sw[8]|h_sw[9]|l_sw[0]|l_sw[10]|l_sw[1]|l_sw[2]|l_sw[3]|l_sw[4]|l_sw[5]|l_sw[6]|l_sw[7]|l_sw[8]|l_sw[9]|out|pad|padres|vc|vcp|vdd|vddr|vip|vss|z
+ BOTTOM|TOP|VGND|VSS|anode|cathode|core|h_sw[0]|h_sw[10]|h_sw[1]|h_sw[2]|h_sw[3]|h_sw[4]|h_sw[5]|h_sw[6]|h_sw[7]|h_sw[8]|h_sw[9]|l_sw[0]|l_sw[10]|l_sw[1]|l_sw[2]|l_sw[3]|l_sw[4]|l_sw[5]|l_sw[6]|l_sw[7]|l_sw[8]|l_sw[9]|out|pad|padres|vc|vcp|vdd|vddr|vip|vss|z
+ sg13_lv_nmos L=0.13u W=0.74u AS=0.2516p AD=0.2516p PS=2.16u PD=2.16u rfmode=0
M$564
+ BOTTOM|TOP|VGND|VSS|anode|cathode|core|h_sw[0]|h_sw[10]|h_sw[1]|h_sw[2]|h_sw[3]|h_sw[4]|h_sw[5]|h_sw[6]|h_sw[7]|h_sw[8]|h_sw[9]|l_sw[0]|l_sw[10]|l_sw[1]|l_sw[2]|l_sw[3]|l_sw[4]|l_sw[5]|l_sw[6]|l_sw[7]|l_sw[8]|l_sw[9]|out|pad|padres|vc|vcp|vdd|vddr|vip|vss|z
+ A2|B|B1|Y B1|Y$3
+ BOTTOM|TOP|VGND|VSS|anode|cathode|core|h_sw[0]|h_sw[10]|h_sw[1]|h_sw[2]|h_sw[3]|h_sw[4]|h_sw[5]|h_sw[6]|h_sw[7]|h_sw[8]|h_sw[9]|l_sw[0]|l_sw[10]|l_sw[1]|l_sw[2]|l_sw[3]|l_sw[4]|l_sw[5]|l_sw[6]|l_sw[7]|l_sw[8]|l_sw[9]|out|pad|padres|vc|vcp|vdd|vddr|vip|vss|z
+ sg13_lv_nmos L=0.13u W=0.74u AS=0.2516p AD=0.1406p PS=2.16u PD=1.12u rfmode=0
M$565 B1|Y$3 A1|D|Q$1 \$71305
+ BOTTOM|TOP|VGND|VSS|anode|cathode|core|h_sw[0]|h_sw[10]|h_sw[1]|h_sw[2]|h_sw[3]|h_sw[4]|h_sw[5]|h_sw[6]|h_sw[7]|h_sw[8]|h_sw[9]|l_sw[0]|l_sw[10]|l_sw[1]|l_sw[2]|l_sw[3]|l_sw[4]|l_sw[5]|l_sw[6]|l_sw[7]|l_sw[8]|l_sw[9]|out|pad|padres|vc|vcp|vdd|vddr|vip|vss|z
+ sg13_lv_nmos L=0.13u W=0.74u AS=0.1406p AD=0.1406p PS=1.12u PD=1.12u rfmode=0
M$566 \$71305 A2|B|B1|C1|Y
+ BOTTOM|TOP|VGND|VSS|anode|cathode|core|h_sw[0]|h_sw[10]|h_sw[1]|h_sw[2]|h_sw[3]|h_sw[4]|h_sw[5]|h_sw[6]|h_sw[7]|h_sw[8]|h_sw[9]|l_sw[0]|l_sw[10]|l_sw[1]|l_sw[2]|l_sw[3]|l_sw[4]|l_sw[5]|l_sw[6]|l_sw[7]|l_sw[8]|l_sw[9]|out|pad|padres|vc|vcp|vdd|vddr|vip|vss|z
+ BOTTOM|TOP|VGND|VSS|anode|cathode|core|h_sw[0]|h_sw[10]|h_sw[1]|h_sw[2]|h_sw[3]|h_sw[4]|h_sw[5]|h_sw[6]|h_sw[7]|h_sw[8]|h_sw[9]|l_sw[0]|l_sw[10]|l_sw[1]|l_sw[2]|l_sw[3]|l_sw[4]|l_sw[5]|l_sw[6]|l_sw[7]|l_sw[8]|l_sw[9]|out|pad|padres|vc|vcp|vdd|vddr|vip|vss|z
+ sg13_lv_nmos L=0.13u W=0.74u AS=0.1406p AD=0.2516p PS=1.12u PD=2.16u rfmode=0
M$567 \$70957 \$70986 \$70958
+ BOTTOM|TOP|VGND|VSS|anode|cathode|core|h_sw[0]|h_sw[10]|h_sw[1]|h_sw[2]|h_sw[3]|h_sw[4]|h_sw[5]|h_sw[6]|h_sw[7]|h_sw[8]|h_sw[9]|l_sw[0]|l_sw[10]|l_sw[1]|l_sw[2]|l_sw[3]|l_sw[4]|l_sw[5]|l_sw[6]|l_sw[7]|l_sw[8]|l_sw[9]|out|pad|padres|vc|vcp|vdd|vddr|vip|vss|z
+ sg13_lv_nmos L=0.13u W=0.42u AS=0.1296p AD=0.0798p PS=1.52u PD=0.8u rfmode=0
M$568 \$70958 \$70959 \$71160
+ BOTTOM|TOP|VGND|VSS|anode|cathode|core|h_sw[0]|h_sw[10]|h_sw[1]|h_sw[2]|h_sw[3]|h_sw[4]|h_sw[5]|h_sw[6]|h_sw[7]|h_sw[8]|h_sw[9]|l_sw[0]|l_sw[10]|l_sw[1]|l_sw[2]|l_sw[3]|l_sw[4]|l_sw[5]|l_sw[6]|l_sw[7]|l_sw[8]|l_sw[9]|out|pad|padres|vc|vcp|vdd|vddr|vip|vss|z
+ sg13_lv_nmos L=0.13u W=0.42u AS=0.0798p AD=0.2373p PS=0.8u PD=1.97u rfmode=0
M$569 \$70959 \$70986
+ BOTTOM|TOP|VGND|VSS|anode|cathode|core|h_sw[0]|h_sw[10]|h_sw[1]|h_sw[2]|h_sw[3]|h_sw[4]|h_sw[5]|h_sw[6]|h_sw[7]|h_sw[8]|h_sw[9]|l_sw[0]|l_sw[10]|l_sw[1]|l_sw[2]|l_sw[3]|l_sw[4]|l_sw[5]|l_sw[6]|l_sw[7]|l_sw[8]|l_sw[9]|out|pad|padres|vc|vcp|vdd|vddr|vip|vss|z
+ BOTTOM|TOP|VGND|VSS|anode|cathode|core|h_sw[0]|h_sw[10]|h_sw[1]|h_sw[2]|h_sw[3]|h_sw[4]|h_sw[5]|h_sw[6]|h_sw[7]|h_sw[8]|h_sw[9]|l_sw[0]|l_sw[10]|l_sw[1]|l_sw[2]|l_sw[3]|l_sw[4]|l_sw[5]|l_sw[6]|l_sw[7]|l_sw[8]|l_sw[9]|out|pad|padres|vc|vcp|vdd|vddr|vip|vss|z
+ sg13_lv_nmos L=0.13u W=0.74u AS=0.2516p AD=0.317325p PS=2.16u PD=1.805u
+ rfmode=0
M$570
+ BOTTOM|TOP|VGND|VSS|anode|cathode|core|h_sw[0]|h_sw[10]|h_sw[1]|h_sw[2]|h_sw[3]|h_sw[4]|h_sw[5]|h_sw[6]|h_sw[7]|h_sw[8]|h_sw[9]|l_sw[0]|l_sw[10]|l_sw[1]|l_sw[2]|l_sw[3]|l_sw[4]|l_sw[5]|l_sw[6]|l_sw[7]|l_sw[8]|l_sw[9]|out|pad|padres|vc|vcp|vdd|vddr|vip|vss|z
+ CLK|Y \$70986
+ BOTTOM|TOP|VGND|VSS|anode|cathode|core|h_sw[0]|h_sw[10]|h_sw[1]|h_sw[2]|h_sw[3]|h_sw[4]|h_sw[5]|h_sw[6]|h_sw[7]|h_sw[8]|h_sw[9]|l_sw[0]|l_sw[10]|l_sw[1]|l_sw[2]|l_sw[3]|l_sw[4]|l_sw[5]|l_sw[6]|l_sw[7]|l_sw[8]|l_sw[9]|out|pad|padres|vc|vcp|vdd|vddr|vip|vss|z
+ sg13_lv_nmos L=0.13u W=0.74u AS=0.317325p AD=0.2516p PS=1.805u PD=2.16u
+ rfmode=0
M$571 \$71171 \$70986 \$71161
+ BOTTOM|TOP|VGND|VSS|anode|cathode|core|h_sw[0]|h_sw[10]|h_sw[1]|h_sw[2]|h_sw[3]|h_sw[4]|h_sw[5]|h_sw[6]|h_sw[7]|h_sw[8]|h_sw[9]|l_sw[0]|l_sw[10]|l_sw[1]|l_sw[2]|l_sw[3]|l_sw[4]|l_sw[5]|l_sw[6]|l_sw[7]|l_sw[8]|l_sw[9]|out|pad|padres|vc|vcp|vdd|vddr|vip|vss|z
+ sg13_lv_nmos L=0.13u W=0.42u AS=0.1428p AD=0.12665p PS=1.52u PD=1.145u
+ rfmode=0
M$572 \$71161 \$70959 \$70985
+ BOTTOM|TOP|VGND|VSS|anode|cathode|core|h_sw[0]|h_sw[10]|h_sw[1]|h_sw[2]|h_sw[3]|h_sw[4]|h_sw[5]|h_sw[6]|h_sw[7]|h_sw[8]|h_sw[9]|l_sw[0]|l_sw[10]|l_sw[1]|l_sw[2]|l_sw[3]|l_sw[4]|l_sw[5]|l_sw[6]|l_sw[7]|l_sw[8]|l_sw[9]|out|pad|padres|vc|vcp|vdd|vddr|vip|vss|z
+ sg13_lv_nmos L=0.13u W=0.74u AS=0.12665p AD=0.3473p PS=1.145u PD=2.71u
+ rfmode=0
M$573 A|Y$8 A|X$56
+ BOTTOM|TOP|VGND|VSS|anode|cathode|core|h_sw[0]|h_sw[10]|h_sw[1]|h_sw[2]|h_sw[3]|h_sw[4]|h_sw[5]|h_sw[6]|h_sw[7]|h_sw[8]|h_sw[9]|l_sw[0]|l_sw[10]|l_sw[1]|l_sw[2]|l_sw[3]|l_sw[4]|l_sw[5]|l_sw[6]|l_sw[7]|l_sw[8]|l_sw[9]|out|pad|padres|vc|vcp|vdd|vddr|vip|vss|z
+ BOTTOM|TOP|VGND|VSS|anode|cathode|core|h_sw[0]|h_sw[10]|h_sw[1]|h_sw[2]|h_sw[3]|h_sw[4]|h_sw[5]|h_sw[6]|h_sw[7]|h_sw[8]|h_sw[9]|l_sw[0]|l_sw[10]|l_sw[1]|l_sw[2]|l_sw[3]|l_sw[4]|l_sw[5]|l_sw[6]|l_sw[7]|l_sw[8]|l_sw[9]|out|pad|padres|vc|vcp|vdd|vddr|vip|vss|z
+ sg13_lv_nmos L=0.13u W=0.74u AS=0.2516p AD=0.2516p PS=2.16u PD=2.16u rfmode=0
M$574
+ BOTTOM|TOP|VGND|VSS|anode|cathode|core|h_sw[0]|h_sw[10]|h_sw[1]|h_sw[2]|h_sw[3]|h_sw[4]|h_sw[5]|h_sw[6]|h_sw[7]|h_sw[8]|h_sw[9]|l_sw[0]|l_sw[10]|l_sw[1]|l_sw[2]|l_sw[3]|l_sw[4]|l_sw[5]|l_sw[6]|l_sw[7]|l_sw[8]|l_sw[9]|out|pad|padres|vc|vcp|vdd|vddr|vip|vss|z
+ A2|B|B1|Y \$71303
+ BOTTOM|TOP|VGND|VSS|anode|cathode|core|h_sw[0]|h_sw[10]|h_sw[1]|h_sw[2]|h_sw[3]|h_sw[4]|h_sw[5]|h_sw[6]|h_sw[7]|h_sw[8]|h_sw[9]|l_sw[0]|l_sw[10]|l_sw[1]|l_sw[2]|l_sw[3]|l_sw[4]|l_sw[5]|l_sw[6]|l_sw[7]|l_sw[8]|l_sw[9]|out|pad|padres|vc|vcp|vdd|vddr|vip|vss|z
+ sg13_lv_nmos L=0.13u W=0.74u AS=0.2516p AD=0.1406p PS=2.16u PD=1.12u rfmode=0
M$575 \$71303 A|Q$5 B1|Y$2
+ BOTTOM|TOP|VGND|VSS|anode|cathode|core|h_sw[0]|h_sw[10]|h_sw[1]|h_sw[2]|h_sw[3]|h_sw[4]|h_sw[5]|h_sw[6]|h_sw[7]|h_sw[8]|h_sw[9]|l_sw[0]|l_sw[10]|l_sw[1]|l_sw[2]|l_sw[3]|l_sw[4]|l_sw[5]|l_sw[6]|l_sw[7]|l_sw[8]|l_sw[9]|out|pad|padres|vc|vcp|vdd|vddr|vip|vss|z
+ sg13_lv_nmos L=0.13u W=0.74u AS=0.1406p AD=0.2516p PS=1.12u PD=2.16u rfmode=0
M$576 CLK|Y A|CLK|X$1
+ BOTTOM|TOP|VGND|VSS|anode|cathode|core|h_sw[0]|h_sw[10]|h_sw[1]|h_sw[2]|h_sw[3]|h_sw[4]|h_sw[5]|h_sw[6]|h_sw[7]|h_sw[8]|h_sw[9]|l_sw[0]|l_sw[10]|l_sw[1]|l_sw[2]|l_sw[3]|l_sw[4]|l_sw[5]|l_sw[6]|l_sw[7]|l_sw[8]|l_sw[9]|out|pad|padres|vc|vcp|vdd|vddr|vip|vss|z
+ BOTTOM|TOP|VGND|VSS|anode|cathode|core|h_sw[0]|h_sw[10]|h_sw[1]|h_sw[2]|h_sw[3]|h_sw[4]|h_sw[5]|h_sw[6]|h_sw[7]|h_sw[8]|h_sw[9]|l_sw[0]|l_sw[10]|l_sw[1]|l_sw[2]|l_sw[3]|l_sw[4]|l_sw[5]|l_sw[6]|l_sw[7]|l_sw[8]|l_sw[9]|out|pad|padres|vc|vcp|vdd|vddr|vip|vss|z
+ sg13_lv_nmos L=0.13u W=0.74u AS=0.2516p AD=0.2516p PS=2.16u PD=2.16u rfmode=0
M$577 \$71163 \$70991 \$71172
+ BOTTOM|TOP|VGND|VSS|anode|cathode|core|h_sw[0]|h_sw[10]|h_sw[1]|h_sw[2]|h_sw[3]|h_sw[4]|h_sw[5]|h_sw[6]|h_sw[7]|h_sw[8]|h_sw[9]|l_sw[0]|l_sw[10]|l_sw[1]|l_sw[2]|l_sw[3]|l_sw[4]|l_sw[5]|l_sw[6]|l_sw[7]|l_sw[8]|l_sw[9]|out|pad|padres|vc|vcp|vdd|vddr|vip|vss|z
+ sg13_lv_nmos L=0.13u W=0.42u AS=0.12665p AD=0.1428p PS=1.145u PD=1.52u
+ rfmode=0
M$578 \$70992 \$70967 \$71163
+ BOTTOM|TOP|VGND|VSS|anode|cathode|core|h_sw[0]|h_sw[10]|h_sw[1]|h_sw[2]|h_sw[3]|h_sw[4]|h_sw[5]|h_sw[6]|h_sw[7]|h_sw[8]|h_sw[9]|l_sw[0]|l_sw[10]|l_sw[1]|l_sw[2]|l_sw[3]|l_sw[4]|l_sw[5]|l_sw[6]|l_sw[7]|l_sw[8]|l_sw[9]|out|pad|padres|vc|vcp|vdd|vddr|vip|vss|z
+ sg13_lv_nmos L=0.13u W=0.74u AS=0.3473p AD=0.12665p PS=2.71u PD=1.145u
+ rfmode=0
M$579 \$70991 A|CLK|Q
+ BOTTOM|TOP|VGND|VSS|anode|cathode|core|h_sw[0]|h_sw[10]|h_sw[1]|h_sw[2]|h_sw[3]|h_sw[4]|h_sw[5]|h_sw[6]|h_sw[7]|h_sw[8]|h_sw[9]|l_sw[0]|l_sw[10]|l_sw[1]|l_sw[2]|l_sw[3]|l_sw[4]|l_sw[5]|l_sw[6]|l_sw[7]|l_sw[8]|l_sw[9]|out|pad|padres|vc|vcp|vdd|vddr|vip|vss|z
+ BOTTOM|TOP|VGND|VSS|anode|cathode|core|h_sw[0]|h_sw[10]|h_sw[1]|h_sw[2]|h_sw[3]|h_sw[4]|h_sw[5]|h_sw[6]|h_sw[7]|h_sw[8]|h_sw[9]|l_sw[0]|l_sw[10]|l_sw[1]|l_sw[2]|l_sw[3]|l_sw[4]|l_sw[5]|l_sw[6]|l_sw[7]|l_sw[8]|l_sw[9]|out|pad|padres|vc|vcp|vdd|vddr|vip|vss|z
+ sg13_lv_nmos L=0.13u W=0.74u AS=0.2516p AD=0.317325p PS=2.16u PD=1.805u
+ rfmode=0
M$580
+ BOTTOM|TOP|VGND|VSS|anode|cathode|core|h_sw[0]|h_sw[10]|h_sw[1]|h_sw[2]|h_sw[3]|h_sw[4]|h_sw[5]|h_sw[6]|h_sw[7]|h_sw[8]|h_sw[9]|l_sw[0]|l_sw[10]|l_sw[1]|l_sw[2]|l_sw[3]|l_sw[4]|l_sw[5]|l_sw[6]|l_sw[7]|l_sw[8]|l_sw[9]|out|pad|padres|vc|vcp|vdd|vddr|vip|vss|z
+ \$70991 \$70967
+ BOTTOM|TOP|VGND|VSS|anode|cathode|core|h_sw[0]|h_sw[10]|h_sw[1]|h_sw[2]|h_sw[3]|h_sw[4]|h_sw[5]|h_sw[6]|h_sw[7]|h_sw[8]|h_sw[9]|l_sw[0]|l_sw[10]|l_sw[1]|l_sw[2]|l_sw[3]|l_sw[4]|l_sw[5]|l_sw[6]|l_sw[7]|l_sw[8]|l_sw[9]|out|pad|padres|vc|vcp|vdd|vddr|vip|vss|z
+ sg13_lv_nmos L=0.13u W=0.74u AS=0.317325p AD=0.2516p PS=1.805u PD=2.16u
+ rfmode=0
M$581 \$71165 \$70967 \$70969
+ BOTTOM|TOP|VGND|VSS|anode|cathode|core|h_sw[0]|h_sw[10]|h_sw[1]|h_sw[2]|h_sw[3]|h_sw[4]|h_sw[5]|h_sw[6]|h_sw[7]|h_sw[8]|h_sw[9]|l_sw[0]|l_sw[10]|l_sw[1]|l_sw[2]|l_sw[3]|l_sw[4]|l_sw[5]|l_sw[6]|l_sw[7]|l_sw[8]|l_sw[9]|out|pad|padres|vc|vcp|vdd|vddr|vip|vss|z
+ sg13_lv_nmos L=0.13u W=0.42u AS=0.2373p AD=0.0798p PS=1.97u PD=0.8u rfmode=0
M$582 \$70969 \$70991 \$70968
+ BOTTOM|TOP|VGND|VSS|anode|cathode|core|h_sw[0]|h_sw[10]|h_sw[1]|h_sw[2]|h_sw[3]|h_sw[4]|h_sw[5]|h_sw[6]|h_sw[7]|h_sw[8]|h_sw[9]|l_sw[0]|l_sw[10]|l_sw[1]|l_sw[2]|l_sw[3]|l_sw[4]|l_sw[5]|l_sw[6]|l_sw[7]|l_sw[8]|l_sw[9]|out|pad|padres|vc|vcp|vdd|vddr|vip|vss|z
+ sg13_lv_nmos L=0.13u W=0.42u AS=0.0798p AD=0.1296p PS=0.8u PD=1.52u rfmode=0
M$583 \$70992 \$70969
+ BOTTOM|TOP|VGND|VSS|anode|cathode|core|h_sw[0]|h_sw[10]|h_sw[1]|h_sw[2]|h_sw[3]|h_sw[4]|h_sw[5]|h_sw[6]|h_sw[7]|h_sw[8]|h_sw[9]|l_sw[0]|l_sw[10]|l_sw[1]|l_sw[2]|l_sw[3]|l_sw[4]|l_sw[5]|l_sw[6]|l_sw[7]|l_sw[8]|l_sw[9]|out|pad|padres|vc|vcp|vdd|vddr|vip|vss|z
+ BOTTOM|TOP|VGND|VSS|anode|cathode|core|h_sw[0]|h_sw[10]|h_sw[1]|h_sw[2]|h_sw[3]|h_sw[4]|h_sw[5]|h_sw[6]|h_sw[7]|h_sw[8]|h_sw[9]|l_sw[0]|l_sw[10]|l_sw[1]|l_sw[2]|l_sw[3]|l_sw[4]|l_sw[5]|l_sw[6]|l_sw[7]|l_sw[8]|l_sw[9]|out|pad|padres|vc|vcp|vdd|vddr|vip|vss|z
+ sg13_lv_nmos L=0.13u W=0.74u AS=0.2516p AD=0.1626p PS=2.16u PD=1.415u rfmode=0
M$584
+ BOTTOM|TOP|VGND|VSS|anode|cathode|core|h_sw[0]|h_sw[10]|h_sw[1]|h_sw[2]|h_sw[3]|h_sw[4]|h_sw[5]|h_sw[6]|h_sw[7]|h_sw[8]|h_sw[9]|l_sw[0]|l_sw[10]|l_sw[1]|l_sw[2]|l_sw[3]|l_sw[4]|l_sw[5]|l_sw[6]|l_sw[7]|l_sw[8]|l_sw[9]|out|pad|padres|vc|vcp|vdd|vddr|vip|vss|z
+ RESET_B|Y$1 \$71298
+ BOTTOM|TOP|VGND|VSS|anode|cathode|core|h_sw[0]|h_sw[10]|h_sw[1]|h_sw[2]|h_sw[3]|h_sw[4]|h_sw[5]|h_sw[6]|h_sw[7]|h_sw[8]|h_sw[9]|l_sw[0]|l_sw[10]|l_sw[1]|l_sw[2]|l_sw[3]|l_sw[4]|l_sw[5]|l_sw[6]|l_sw[7]|l_sw[8]|l_sw[9]|out|pad|padres|vc|vcp|vdd|vddr|vip|vss|z
+ sg13_lv_nmos L=0.13u W=0.42u AS=0.1626p AD=0.0609p PS=1.415u PD=0.71u rfmode=0
M$585 \$71298 D|X \$70968
+ BOTTOM|TOP|VGND|VSS|anode|cathode|core|h_sw[0]|h_sw[10]|h_sw[1]|h_sw[2]|h_sw[3]|h_sw[4]|h_sw[5]|h_sw[6]|h_sw[7]|h_sw[8]|h_sw[9]|l_sw[0]|l_sw[10]|l_sw[1]|l_sw[2]|l_sw[3]|l_sw[4]|l_sw[5]|l_sw[6]|l_sw[7]|l_sw[8]|l_sw[9]|out|pad|padres|vc|vcp|vdd|vddr|vip|vss|z
+ sg13_lv_nmos L=0.13u W=0.42u AS=0.0609p AD=0.1428p PS=0.71u PD=1.52u rfmode=0
M$586 \$70970 A|CLK|Q
+ BOTTOM|TOP|VGND|VSS|anode|cathode|core|h_sw[0]|h_sw[10]|h_sw[1]|h_sw[2]|h_sw[3]|h_sw[4]|h_sw[5]|h_sw[6]|h_sw[7]|h_sw[8]|h_sw[9]|l_sw[0]|l_sw[10]|l_sw[1]|l_sw[2]|l_sw[3]|l_sw[4]|l_sw[5]|l_sw[6]|l_sw[7]|l_sw[8]|l_sw[9]|out|pad|padres|vc|vcp|vdd|vddr|vip|vss|z
+ BOTTOM|TOP|VGND|VSS|anode|cathode|core|h_sw[0]|h_sw[10]|h_sw[1]|h_sw[2]|h_sw[3]|h_sw[4]|h_sw[5]|h_sw[6]|h_sw[7]|h_sw[8]|h_sw[9]|l_sw[0]|l_sw[10]|l_sw[1]|l_sw[2]|l_sw[3]|l_sw[4]|l_sw[5]|l_sw[6]|l_sw[7]|l_sw[8]|l_sw[9]|out|pad|padres|vc|vcp|vdd|vddr|vip|vss|z
+ sg13_lv_nmos L=0.13u W=2.22u AS=0.5365p AD=0.4218p PS=4.41u PD=3.36u rfmode=0
M$589
+ BOTTOM|TOP|VGND|VSS|anode|cathode|core|h_sw[0]|h_sw[10]|h_sw[1]|h_sw[2]|h_sw[3]|h_sw[4]|h_sw[5]|h_sw[6]|h_sw[7]|h_sw[8]|h_sw[9]|l_sw[0]|l_sw[10]|l_sw[1]|l_sw[2]|l_sw[3]|l_sw[4]|l_sw[5]|l_sw[6]|l_sw[7]|l_sw[8]|l_sw[9]|out|pad|padres|vc|vcp|vdd|vddr|vip|vss|z
+ \$70970 A|B|X
+ BOTTOM|TOP|VGND|VSS|anode|cathode|core|h_sw[0]|h_sw[10]|h_sw[1]|h_sw[2]|h_sw[3]|h_sw[4]|h_sw[5]|h_sw[6]|h_sw[7]|h_sw[8]|h_sw[9]|l_sw[0]|l_sw[10]|l_sw[1]|l_sw[2]|l_sw[3]|l_sw[4]|l_sw[5]|l_sw[6]|l_sw[7]|l_sw[8]|l_sw[9]|out|pad|padres|vc|vcp|vdd|vddr|vip|vss|z
+ sg13_lv_nmos L=0.13u W=5.92u AS=1.1248p AD=1.2358p PS=8.96u PD=10u rfmode=0
M$597 A1|Y$2 A|Q$6
+ BOTTOM|TOP|VGND|VSS|anode|cathode|core|h_sw[0]|h_sw[10]|h_sw[1]|h_sw[2]|h_sw[3]|h_sw[4]|h_sw[5]|h_sw[6]|h_sw[7]|h_sw[8]|h_sw[9]|l_sw[0]|l_sw[10]|l_sw[1]|l_sw[2]|l_sw[3]|l_sw[4]|l_sw[5]|l_sw[6]|l_sw[7]|l_sw[8]|l_sw[9]|out|pad|padres|vc|vcp|vdd|vddr|vip|vss|z
+ BOTTOM|TOP|VGND|VSS|anode|cathode|core|h_sw[0]|h_sw[10]|h_sw[1]|h_sw[2]|h_sw[3]|h_sw[4]|h_sw[5]|h_sw[6]|h_sw[7]|h_sw[8]|h_sw[9]|l_sw[0]|l_sw[10]|l_sw[1]|l_sw[2]|l_sw[3]|l_sw[4]|l_sw[5]|l_sw[6]|l_sw[7]|l_sw[8]|l_sw[9]|out|pad|padres|vc|vcp|vdd|vddr|vip|vss|z
+ sg13_lv_nmos L=0.13u W=0.74u AS=0.2516p AD=0.2516p PS=2.16u PD=2.16u rfmode=0
M$598
+ BOTTOM|TOP|VGND|VSS|anode|cathode|core|h_sw[0]|h_sw[10]|h_sw[1]|h_sw[2]|h_sw[3]|h_sw[4]|h_sw[5]|h_sw[6]|h_sw[7]|h_sw[8]|h_sw[9]|l_sw[0]|l_sw[10]|l_sw[1]|l_sw[2]|l_sw[3]|l_sw[4]|l_sw[5]|l_sw[6]|l_sw[7]|l_sw[8]|l_sw[9]|out|pad|padres|vc|vcp|vdd|vddr|vip|vss|z
+ \$71155 Q_N$10
+ BOTTOM|TOP|VGND|VSS|anode|cathode|core|h_sw[0]|h_sw[10]|h_sw[1]|h_sw[2]|h_sw[3]|h_sw[4]|h_sw[5]|h_sw[6]|h_sw[7]|h_sw[8]|h_sw[9]|l_sw[0]|l_sw[10]|l_sw[1]|l_sw[2]|l_sw[3]|l_sw[4]|l_sw[5]|l_sw[6]|l_sw[7]|l_sw[8]|l_sw[9]|out|pad|padres|vc|vcp|vdd|vddr|vip|vss|z
+ sg13_lv_nmos L=0.13u W=0.74u AS=0.2516p AD=0.2849p PS=2.16u PD=2.25u rfmode=0
M$599 \$70943 \$71155
+ BOTTOM|TOP|VGND|VSS|anode|cathode|core|h_sw[0]|h_sw[10]|h_sw[1]|h_sw[2]|h_sw[3]|h_sw[4]|h_sw[5]|h_sw[6]|h_sw[7]|h_sw[8]|h_sw[9]|l_sw[0]|l_sw[10]|l_sw[1]|l_sw[2]|l_sw[3]|l_sw[4]|l_sw[5]|l_sw[6]|l_sw[7]|l_sw[8]|l_sw[9]|out|pad|padres|vc|vcp|vdd|vddr|vip|vss|z
+ BOTTOM|TOP|VGND|VSS|anode|cathode|core|h_sw[0]|h_sw[10]|h_sw[1]|h_sw[2]|h_sw[3]|h_sw[4]|h_sw[5]|h_sw[6]|h_sw[7]|h_sw[8]|h_sw[9]|l_sw[0]|l_sw[10]|l_sw[1]|l_sw[2]|l_sw[3]|l_sw[4]|l_sw[5]|l_sw[6]|l_sw[7]|l_sw[8]|l_sw[9]|out|pad|padres|vc|vcp|vdd|vddr|vip|vss|z
+ sg13_lv_nmos L=0.13u W=0.74u AS=0.2516p AD=0.1406p PS=2.16u PD=1.12u rfmode=0
M$600
+ BOTTOM|TOP|VGND|VSS|anode|cathode|core|h_sw[0]|h_sw[10]|h_sw[1]|h_sw[2]|h_sw[3]|h_sw[4]|h_sw[5]|h_sw[6]|h_sw[7]|h_sw[8]|h_sw[9]|l_sw[0]|l_sw[10]|l_sw[1]|l_sw[2]|l_sw[3]|l_sw[4]|l_sw[5]|l_sw[6]|l_sw[7]|l_sw[8]|l_sw[9]|out|pad|padres|vc|vcp|vdd|vddr|vip|vss|z
+ \$70943 CLK|D|GATE|Q
+ BOTTOM|TOP|VGND|VSS|anode|cathode|core|h_sw[0]|h_sw[10]|h_sw[1]|h_sw[2]|h_sw[3]|h_sw[4]|h_sw[5]|h_sw[6]|h_sw[7]|h_sw[8]|h_sw[9]|l_sw[0]|l_sw[10]|l_sw[1]|l_sw[2]|l_sw[3]|l_sw[4]|l_sw[5]|l_sw[6]|l_sw[7]|l_sw[8]|l_sw[9]|out|pad|padres|vc|vcp|vdd|vddr|vip|vss|z
+ sg13_lv_nmos L=0.13u W=0.74u AS=0.1406p AD=0.2516p PS=1.12u PD=2.16u rfmode=0
M$601
+ BOTTOM|TOP|VGND|VSS|anode|cathode|core|h_sw[0]|h_sw[10]|h_sw[1]|h_sw[2]|h_sw[3]|h_sw[4]|h_sw[5]|h_sw[6]|h_sw[7]|h_sw[8]|h_sw[9]|l_sw[0]|l_sw[10]|l_sw[1]|l_sw[2]|l_sw[3]|l_sw[4]|l_sw[5]|l_sw[6]|l_sw[7]|l_sw[8]|l_sw[9]|out|pad|padres|vc|vcp|vdd|vddr|vip|vss|z
+ A|Q$4 \$70945
+ BOTTOM|TOP|VGND|VSS|anode|cathode|core|h_sw[0]|h_sw[10]|h_sw[1]|h_sw[2]|h_sw[3]|h_sw[4]|h_sw[5]|h_sw[6]|h_sw[7]|h_sw[8]|h_sw[9]|l_sw[0]|l_sw[10]|l_sw[1]|l_sw[2]|l_sw[3]|l_sw[4]|l_sw[5]|l_sw[6]|l_sw[7]|l_sw[8]|l_sw[9]|out|pad|padres|vc|vcp|vdd|vddr|vip|vss|z
+ sg13_lv_nmos L=0.13u W=0.55u AS=0.14875p AD=0.187p PS=1.16u PD=1.78u rfmode=0
M$602 A|X$40 \$70945
+ BOTTOM|TOP|VGND|VSS|anode|cathode|core|h_sw[0]|h_sw[10]|h_sw[1]|h_sw[2]|h_sw[3]|h_sw[4]|h_sw[5]|h_sw[6]|h_sw[7]|h_sw[8]|h_sw[9]|l_sw[0]|l_sw[10]|l_sw[1]|l_sw[2]|l_sw[3]|l_sw[4]|l_sw[5]|l_sw[6]|l_sw[7]|l_sw[8]|l_sw[9]|out|pad|padres|vc|vcp|vdd|vddr|vip|vss|z
+ BOTTOM|TOP|VGND|VSS|anode|cathode|core|h_sw[0]|h_sw[10]|h_sw[1]|h_sw[2]|h_sw[3]|h_sw[4]|h_sw[5]|h_sw[6]|h_sw[7]|h_sw[8]|h_sw[9]|l_sw[0]|l_sw[10]|l_sw[1]|l_sw[2]|l_sw[3]|l_sw[4]|l_sw[5]|l_sw[6]|l_sw[7]|l_sw[8]|l_sw[9]|out|pad|padres|vc|vcp|vdd|vddr|vip|vss|z
+ sg13_lv_nmos L=0.13u W=0.74u AS=0.2886p AD=0.14875p PS=2.26u PD=1.16u rfmode=0
M$603
+ BOTTOM|TOP|VGND|VSS|anode|cathode|core|h_sw[0]|h_sw[10]|h_sw[1]|h_sw[2]|h_sw[3]|h_sw[4]|h_sw[5]|h_sw[6]|h_sw[7]|h_sw[8]|h_sw[9]|l_sw[0]|l_sw[10]|l_sw[1]|l_sw[2]|l_sw[3]|l_sw[4]|l_sw[5]|l_sw[6]|l_sw[7]|l_sw[8]|l_sw[9]|out|pad|padres|vc|vcp|vdd|vddr|vip|vss|z
+ \$71158 D|Q_N$2
+ BOTTOM|TOP|VGND|VSS|anode|cathode|core|h_sw[0]|h_sw[10]|h_sw[1]|h_sw[2]|h_sw[3]|h_sw[4]|h_sw[5]|h_sw[6]|h_sw[7]|h_sw[8]|h_sw[9]|l_sw[0]|l_sw[10]|l_sw[1]|l_sw[2]|l_sw[3]|l_sw[4]|l_sw[5]|l_sw[6]|l_sw[7]|l_sw[8]|l_sw[9]|out|pad|padres|vc|vcp|vdd|vddr|vip|vss|z
+ sg13_lv_nmos L=0.13u W=0.74u AS=0.2516p AD=0.2849p PS=2.16u PD=2.25u rfmode=0
M$604 \$70950 \$71158
+ BOTTOM|TOP|VGND|VSS|anode|cathode|core|h_sw[0]|h_sw[10]|h_sw[1]|h_sw[2]|h_sw[3]|h_sw[4]|h_sw[5]|h_sw[6]|h_sw[7]|h_sw[8]|h_sw[9]|l_sw[0]|l_sw[10]|l_sw[1]|l_sw[2]|l_sw[3]|l_sw[4]|l_sw[5]|l_sw[6]|l_sw[7]|l_sw[8]|l_sw[9]|out|pad|padres|vc|vcp|vdd|vddr|vip|vss|z
+ BOTTOM|TOP|VGND|VSS|anode|cathode|core|h_sw[0]|h_sw[10]|h_sw[1]|h_sw[2]|h_sw[3]|h_sw[4]|h_sw[5]|h_sw[6]|h_sw[7]|h_sw[8]|h_sw[9]|l_sw[0]|l_sw[10]|l_sw[1]|l_sw[2]|l_sw[3]|l_sw[4]|l_sw[5]|l_sw[6]|l_sw[7]|l_sw[8]|l_sw[9]|out|pad|padres|vc|vcp|vdd|vddr|vip|vss|z
+ sg13_lv_nmos L=0.13u W=0.74u AS=0.2516p AD=0.1406p PS=2.16u PD=1.12u rfmode=0
M$605
+ BOTTOM|TOP|VGND|VSS|anode|cathode|core|h_sw[0]|h_sw[10]|h_sw[1]|h_sw[2]|h_sw[3]|h_sw[4]|h_sw[5]|h_sw[6]|h_sw[7]|h_sw[8]|h_sw[9]|l_sw[0]|l_sw[10]|l_sw[1]|l_sw[2]|l_sw[3]|l_sw[4]|l_sw[5]|l_sw[6]|l_sw[7]|l_sw[8]|l_sw[9]|out|pad|padres|vc|vcp|vdd|vddr|vip|vss|z
+ \$70950 A2|D|Q
+ BOTTOM|TOP|VGND|VSS|anode|cathode|core|h_sw[0]|h_sw[10]|h_sw[1]|h_sw[2]|h_sw[3]|h_sw[4]|h_sw[5]|h_sw[6]|h_sw[7]|h_sw[8]|h_sw[9]|l_sw[0]|l_sw[10]|l_sw[1]|l_sw[2]|l_sw[3]|l_sw[4]|l_sw[5]|l_sw[6]|l_sw[7]|l_sw[8]|l_sw[9]|out|pad|padres|vc|vcp|vdd|vddr|vip|vss|z
+ sg13_lv_nmos L=0.13u W=0.74u AS=0.1406p AD=0.2516p PS=1.12u PD=2.16u rfmode=0
M$606
+ BOTTOM|TOP|VGND|VSS|anode|cathode|core|h_sw[0]|h_sw[10]|h_sw[1]|h_sw[2]|h_sw[3]|h_sw[4]|h_sw[5]|h_sw[6]|h_sw[7]|h_sw[8]|h_sw[9]|l_sw[0]|l_sw[10]|l_sw[1]|l_sw[2]|l_sw[3]|l_sw[4]|l_sw[5]|l_sw[6]|l_sw[7]|l_sw[8]|l_sw[9]|out|pad|padres|vc|vcp|vdd|vddr|vip|vss|z
+ A|Q$7 \$70952
+ BOTTOM|TOP|VGND|VSS|anode|cathode|core|h_sw[0]|h_sw[10]|h_sw[1]|h_sw[2]|h_sw[3]|h_sw[4]|h_sw[5]|h_sw[6]|h_sw[7]|h_sw[8]|h_sw[9]|l_sw[0]|l_sw[10]|l_sw[1]|l_sw[2]|l_sw[3]|l_sw[4]|l_sw[5]|l_sw[6]|l_sw[7]|l_sw[8]|l_sw[9]|out|pad|padres|vc|vcp|vdd|vddr|vip|vss|z
+ sg13_lv_nmos L=0.13u W=0.55u AS=0.14875p AD=0.187p PS=1.16u PD=1.78u rfmode=0
M$607 A|X$24 \$70952
+ BOTTOM|TOP|VGND|VSS|anode|cathode|core|h_sw[0]|h_sw[10]|h_sw[1]|h_sw[2]|h_sw[3]|h_sw[4]|h_sw[5]|h_sw[6]|h_sw[7]|h_sw[8]|h_sw[9]|l_sw[0]|l_sw[10]|l_sw[1]|l_sw[2]|l_sw[3]|l_sw[4]|l_sw[5]|l_sw[6]|l_sw[7]|l_sw[8]|l_sw[9]|out|pad|padres|vc|vcp|vdd|vddr|vip|vss|z
+ BOTTOM|TOP|VGND|VSS|anode|cathode|core|h_sw[0]|h_sw[10]|h_sw[1]|h_sw[2]|h_sw[3]|h_sw[4]|h_sw[5]|h_sw[6]|h_sw[7]|h_sw[8]|h_sw[9]|l_sw[0]|l_sw[10]|l_sw[1]|l_sw[2]|l_sw[3]|l_sw[4]|l_sw[5]|l_sw[6]|l_sw[7]|l_sw[8]|l_sw[9]|out|pad|padres|vc|vcp|vdd|vddr|vip|vss|z
+ sg13_lv_nmos L=0.13u W=0.74u AS=0.2886p AD=0.14875p PS=2.26u PD=1.16u rfmode=0
M$608
+ BOTTOM|TOP|VGND|VSS|anode|cathode|core|h_sw[0]|h_sw[10]|h_sw[1]|h_sw[2]|h_sw[3]|h_sw[4]|h_sw[5]|h_sw[6]|h_sw[7]|h_sw[8]|h_sw[9]|l_sw[0]|l_sw[10]|l_sw[1]|l_sw[2]|l_sw[3]|l_sw[4]|l_sw[5]|l_sw[6]|l_sw[7]|l_sw[8]|l_sw[9]|out|pad|padres|vc|vcp|vdd|vddr|vip|vss|z
+ A|Q$8 \$70953
+ BOTTOM|TOP|VGND|VSS|anode|cathode|core|h_sw[0]|h_sw[10]|h_sw[1]|h_sw[2]|h_sw[3]|h_sw[4]|h_sw[5]|h_sw[6]|h_sw[7]|h_sw[8]|h_sw[9]|l_sw[0]|l_sw[10]|l_sw[1]|l_sw[2]|l_sw[3]|l_sw[4]|l_sw[5]|l_sw[6]|l_sw[7]|l_sw[8]|l_sw[9]|out|pad|padres|vc|vcp|vdd|vddr|vip|vss|z
+ sg13_lv_nmos L=0.13u W=0.55u AS=0.14875p AD=0.187p PS=1.16u PD=1.78u rfmode=0
M$609 A|X$37 \$70953
+ BOTTOM|TOP|VGND|VSS|anode|cathode|core|h_sw[0]|h_sw[10]|h_sw[1]|h_sw[2]|h_sw[3]|h_sw[4]|h_sw[5]|h_sw[6]|h_sw[7]|h_sw[8]|h_sw[9]|l_sw[0]|l_sw[10]|l_sw[1]|l_sw[2]|l_sw[3]|l_sw[4]|l_sw[5]|l_sw[6]|l_sw[7]|l_sw[8]|l_sw[9]|out|pad|padres|vc|vcp|vdd|vddr|vip|vss|z
+ BOTTOM|TOP|VGND|VSS|anode|cathode|core|h_sw[0]|h_sw[10]|h_sw[1]|h_sw[2]|h_sw[3]|h_sw[4]|h_sw[5]|h_sw[6]|h_sw[7]|h_sw[8]|h_sw[9]|l_sw[0]|l_sw[10]|l_sw[1]|l_sw[2]|l_sw[3]|l_sw[4]|l_sw[5]|l_sw[6]|l_sw[7]|l_sw[8]|l_sw[9]|out|pad|padres|vc|vcp|vdd|vddr|vip|vss|z
+ sg13_lv_nmos L=0.13u W=0.74u AS=0.2886p AD=0.14875p PS=2.26u PD=1.16u rfmode=0
M$610
+ BOTTOM|TOP|VGND|VSS|anode|cathode|core|h_sw[0]|h_sw[10]|h_sw[1]|h_sw[2]|h_sw[3]|h_sw[4]|h_sw[5]|h_sw[6]|h_sw[7]|h_sw[8]|h_sw[9]|l_sw[0]|l_sw[10]|l_sw[1]|l_sw[2]|l_sw[3]|l_sw[4]|l_sw[5]|l_sw[6]|l_sw[7]|l_sw[8]|l_sw[9]|out|pad|padres|vc|vcp|vdd|vddr|vip|vss|z
+ B1|Y$1 \$71304
+ BOTTOM|TOP|VGND|VSS|anode|cathode|core|h_sw[0]|h_sw[10]|h_sw[1]|h_sw[2]|h_sw[3]|h_sw[4]|h_sw[5]|h_sw[6]|h_sw[7]|h_sw[8]|h_sw[9]|l_sw[0]|l_sw[10]|l_sw[1]|l_sw[2]|l_sw[3]|l_sw[4]|l_sw[5]|l_sw[6]|l_sw[7]|l_sw[8]|l_sw[9]|out|pad|padres|vc|vcp|vdd|vddr|vip|vss|z
+ sg13_lv_nmos L=0.13u W=0.74u AS=0.2553p AD=0.13875p PS=2.17u PD=1.115u
+ rfmode=0
M$611 \$71304 A|B|B2|B_N|Q A|Y$17
+ BOTTOM|TOP|VGND|VSS|anode|cathode|core|h_sw[0]|h_sw[10]|h_sw[1]|h_sw[2]|h_sw[3]|h_sw[4]|h_sw[5]|h_sw[6]|h_sw[7]|h_sw[8]|h_sw[9]|l_sw[0]|l_sw[10]|l_sw[1]|l_sw[2]|l_sw[3]|l_sw[4]|l_sw[5]|l_sw[6]|l_sw[7]|l_sw[8]|l_sw[9]|out|pad|padres|vc|vcp|vdd|vddr|vip|vss|z
+ sg13_lv_nmos L=0.13u W=0.74u AS=0.13875p AD=0.2664p PS=1.115u PD=1.46u
+ rfmode=0
M$612 A|Y$17 A|A1|B|Y \$71309
+ BOTTOM|TOP|VGND|VSS|anode|cathode|core|h_sw[0]|h_sw[10]|h_sw[1]|h_sw[2]|h_sw[3]|h_sw[4]|h_sw[5]|h_sw[6]|h_sw[7]|h_sw[8]|h_sw[9]|l_sw[0]|l_sw[10]|l_sw[1]|l_sw[2]|l_sw[3]|l_sw[4]|l_sw[5]|l_sw[6]|l_sw[7]|l_sw[8]|l_sw[9]|out|pad|padres|vc|vcp|vdd|vddr|vip|vss|z
+ sg13_lv_nmos L=0.13u W=0.74u AS=0.2664p AD=0.0962p PS=1.46u PD=1u rfmode=0
M$613 \$71309 A2|B1|Y
+ BOTTOM|TOP|VGND|VSS|anode|cathode|core|h_sw[0]|h_sw[10]|h_sw[1]|h_sw[2]|h_sw[3]|h_sw[4]|h_sw[5]|h_sw[6]|h_sw[7]|h_sw[8]|h_sw[9]|l_sw[0]|l_sw[10]|l_sw[1]|l_sw[2]|l_sw[3]|l_sw[4]|l_sw[5]|l_sw[6]|l_sw[7]|l_sw[8]|l_sw[9]|out|pad|padres|vc|vcp|vdd|vddr|vip|vss|z
+ BOTTOM|TOP|VGND|VSS|anode|cathode|core|h_sw[0]|h_sw[10]|h_sw[1]|h_sw[2]|h_sw[3]|h_sw[4]|h_sw[5]|h_sw[6]|h_sw[7]|h_sw[8]|h_sw[9]|l_sw[0]|l_sw[10]|l_sw[1]|l_sw[2]|l_sw[3]|l_sw[4]|l_sw[5]|l_sw[6]|l_sw[7]|l_sw[8]|l_sw[9]|out|pad|padres|vc|vcp|vdd|vddr|vip|vss|z
+ sg13_lv_nmos L=0.13u W=0.74u AS=0.0962p AD=0.2516p PS=1u PD=2.16u rfmode=0
M$614
+ BOTTOM|TOP|VGND|VSS|anode|cathode|core|h_sw[0]|h_sw[10]|h_sw[1]|h_sw[2]|h_sw[3]|h_sw[4]|h_sw[5]|h_sw[6]|h_sw[7]|h_sw[8]|h_sw[9]|l_sw[0]|l_sw[10]|l_sw[1]|l_sw[2]|l_sw[3]|l_sw[4]|l_sw[5]|l_sw[6]|l_sw[7]|l_sw[8]|l_sw[9]|out|pad|padres|vc|vcp|vdd|vddr|vip|vss|z
+ \$71161 Q_N$11
+ BOTTOM|TOP|VGND|VSS|anode|cathode|core|h_sw[0]|h_sw[10]|h_sw[1]|h_sw[2]|h_sw[3]|h_sw[4]|h_sw[5]|h_sw[6]|h_sw[7]|h_sw[8]|h_sw[9]|l_sw[0]|l_sw[10]|l_sw[1]|l_sw[2]|l_sw[3]|l_sw[4]|l_sw[5]|l_sw[6]|l_sw[7]|l_sw[8]|l_sw[9]|out|pad|padres|vc|vcp|vdd|vddr|vip|vss|z
+ sg13_lv_nmos L=0.13u W=0.74u AS=0.2516p AD=0.2849p PS=2.16u PD=2.25u rfmode=0
M$615 \$70962 \$71161
+ BOTTOM|TOP|VGND|VSS|anode|cathode|core|h_sw[0]|h_sw[10]|h_sw[1]|h_sw[2]|h_sw[3]|h_sw[4]|h_sw[5]|h_sw[6]|h_sw[7]|h_sw[8]|h_sw[9]|l_sw[0]|l_sw[10]|l_sw[1]|l_sw[2]|l_sw[3]|l_sw[4]|l_sw[5]|l_sw[6]|l_sw[7]|l_sw[8]|l_sw[9]|out|pad|padres|vc|vcp|vdd|vddr|vip|vss|z
+ BOTTOM|TOP|VGND|VSS|anode|cathode|core|h_sw[0]|h_sw[10]|h_sw[1]|h_sw[2]|h_sw[3]|h_sw[4]|h_sw[5]|h_sw[6]|h_sw[7]|h_sw[8]|h_sw[9]|l_sw[0]|l_sw[10]|l_sw[1]|l_sw[2]|l_sw[3]|l_sw[4]|l_sw[5]|l_sw[6]|l_sw[7]|l_sw[8]|l_sw[9]|out|pad|padres|vc|vcp|vdd|vddr|vip|vss|z
+ sg13_lv_nmos L=0.13u W=0.74u AS=0.2516p AD=0.1406p PS=2.16u PD=1.12u rfmode=0
M$616
+ BOTTOM|TOP|VGND|VSS|anode|cathode|core|h_sw[0]|h_sw[10]|h_sw[1]|h_sw[2]|h_sw[3]|h_sw[4]|h_sw[5]|h_sw[6]|h_sw[7]|h_sw[8]|h_sw[9]|l_sw[0]|l_sw[10]|l_sw[1]|l_sw[2]|l_sw[3]|l_sw[4]|l_sw[5]|l_sw[6]|l_sw[7]|l_sw[8]|l_sw[9]|out|pad|padres|vc|vcp|vdd|vddr|vip|vss|z
+ \$70962 A|B|B2|B_N|Q
+ BOTTOM|TOP|VGND|VSS|anode|cathode|core|h_sw[0]|h_sw[10]|h_sw[1]|h_sw[2]|h_sw[3]|h_sw[4]|h_sw[5]|h_sw[6]|h_sw[7]|h_sw[8]|h_sw[9]|l_sw[0]|l_sw[10]|l_sw[1]|l_sw[2]|l_sw[3]|l_sw[4]|l_sw[5]|l_sw[6]|l_sw[7]|l_sw[8]|l_sw[9]|out|pad|padres|vc|vcp|vdd|vddr|vip|vss|z
+ sg13_lv_nmos L=0.13u W=0.74u AS=0.1406p AD=0.2516p PS=1.12u PD=2.16u rfmode=0
M$617
+ BOTTOM|TOP|VGND|VSS|anode|cathode|core|h_sw[0]|h_sw[10]|h_sw[1]|h_sw[2]|h_sw[3]|h_sw[4]|h_sw[5]|h_sw[6]|h_sw[7]|h_sw[8]|h_sw[9]|l_sw[0]|l_sw[10]|l_sw[1]|l_sw[2]|l_sw[3]|l_sw[4]|l_sw[5]|l_sw[6]|l_sw[7]|l_sw[8]|l_sw[9]|out|pad|padres|vc|vcp|vdd|vddr|vip|vss|z
+ A2|B|B1|Y \$71307
+ BOTTOM|TOP|VGND|VSS|anode|cathode|core|h_sw[0]|h_sw[10]|h_sw[1]|h_sw[2]|h_sw[3]|h_sw[4]|h_sw[5]|h_sw[6]|h_sw[7]|h_sw[8]|h_sw[9]|l_sw[0]|l_sw[10]|l_sw[1]|l_sw[2]|l_sw[3]|l_sw[4]|l_sw[5]|l_sw[6]|l_sw[7]|l_sw[8]|l_sw[9]|out|pad|padres|vc|vcp|vdd|vddr|vip|vss|z
+ sg13_lv_nmos L=0.13u W=0.74u AS=0.2516p AD=0.0962p PS=2.16u PD=1u rfmode=0
M$618 \$71307 A1|Y$2 D|Y$5
+ BOTTOM|TOP|VGND|VSS|anode|cathode|core|h_sw[0]|h_sw[10]|h_sw[1]|h_sw[2]|h_sw[3]|h_sw[4]|h_sw[5]|h_sw[6]|h_sw[7]|h_sw[8]|h_sw[9]|l_sw[0]|l_sw[10]|l_sw[1]|l_sw[2]|l_sw[3]|l_sw[4]|l_sw[5]|l_sw[6]|l_sw[7]|l_sw[8]|l_sw[9]|out|pad|padres|vc|vcp|vdd|vddr|vip|vss|z
+ sg13_lv_nmos L=0.13u W=0.74u AS=0.0962p AD=0.2664p PS=1u PD=1.46u rfmode=0
M$619 D|Y$5 B2|Y$2 \$71310
+ BOTTOM|TOP|VGND|VSS|anode|cathode|core|h_sw[0]|h_sw[10]|h_sw[1]|h_sw[2]|h_sw[3]|h_sw[4]|h_sw[5]|h_sw[6]|h_sw[7]|h_sw[8]|h_sw[9]|l_sw[0]|l_sw[10]|l_sw[1]|l_sw[2]|l_sw[3]|l_sw[4]|l_sw[5]|l_sw[6]|l_sw[7]|l_sw[8]|l_sw[9]|out|pad|padres|vc|vcp|vdd|vddr|vip|vss|z
+ sg13_lv_nmos L=0.13u W=0.74u AS=0.2664p AD=0.13875p PS=1.46u PD=1.115u
+ rfmode=0
M$620 \$71310 B1|Y$3
+ BOTTOM|TOP|VGND|VSS|anode|cathode|core|h_sw[0]|h_sw[10]|h_sw[1]|h_sw[2]|h_sw[3]|h_sw[4]|h_sw[5]|h_sw[6]|h_sw[7]|h_sw[8]|h_sw[9]|l_sw[0]|l_sw[10]|l_sw[1]|l_sw[2]|l_sw[3]|l_sw[4]|l_sw[5]|l_sw[6]|l_sw[7]|l_sw[8]|l_sw[9]|out|pad|padres|vc|vcp|vdd|vddr|vip|vss|z
+ BOTTOM|TOP|VGND|VSS|anode|cathode|core|h_sw[0]|h_sw[10]|h_sw[1]|h_sw[2]|h_sw[3]|h_sw[4]|h_sw[5]|h_sw[6]|h_sw[7]|h_sw[8]|h_sw[9]|l_sw[0]|l_sw[10]|l_sw[1]|l_sw[2]|l_sw[3]|l_sw[4]|l_sw[5]|l_sw[6]|l_sw[7]|l_sw[8]|l_sw[9]|out|pad|padres|vc|vcp|vdd|vddr|vip|vss|z
+ sg13_lv_nmos L=0.13u W=0.74u AS=0.13875p AD=0.2553p PS=1.115u PD=2.17u
+ rfmode=0
M$621 C|Q \$70965
+ BOTTOM|TOP|VGND|VSS|anode|cathode|core|h_sw[0]|h_sw[10]|h_sw[1]|h_sw[2]|h_sw[3]|h_sw[4]|h_sw[5]|h_sw[6]|h_sw[7]|h_sw[8]|h_sw[9]|l_sw[0]|l_sw[10]|l_sw[1]|l_sw[2]|l_sw[3]|l_sw[4]|l_sw[5]|l_sw[6]|l_sw[7]|l_sw[8]|l_sw[9]|out|pad|padres|vc|vcp|vdd|vddr|vip|vss|z
+ BOTTOM|TOP|VGND|VSS|anode|cathode|core|h_sw[0]|h_sw[10]|h_sw[1]|h_sw[2]|h_sw[3]|h_sw[4]|h_sw[5]|h_sw[6]|h_sw[7]|h_sw[8]|h_sw[9]|l_sw[0]|l_sw[10]|l_sw[1]|l_sw[2]|l_sw[3]|l_sw[4]|l_sw[5]|l_sw[6]|l_sw[7]|l_sw[8]|l_sw[9]|out|pad|padres|vc|vcp|vdd|vddr|vip|vss|z
+ sg13_lv_nmos L=0.13u W=0.74u AS=0.2516p AD=0.1406p PS=2.16u PD=1.12u rfmode=0
M$622
+ BOTTOM|TOP|VGND|VSS|anode|cathode|core|h_sw[0]|h_sw[10]|h_sw[1]|h_sw[2]|h_sw[3]|h_sw[4]|h_sw[5]|h_sw[6]|h_sw[7]|h_sw[8]|h_sw[9]|l_sw[0]|l_sw[10]|l_sw[1]|l_sw[2]|l_sw[3]|l_sw[4]|l_sw[5]|l_sw[6]|l_sw[7]|l_sw[8]|l_sw[9]|out|pad|padres|vc|vcp|vdd|vddr|vip|vss|z
+ \$71163 \$70965
+ BOTTOM|TOP|VGND|VSS|anode|cathode|core|h_sw[0]|h_sw[10]|h_sw[1]|h_sw[2]|h_sw[3]|h_sw[4]|h_sw[5]|h_sw[6]|h_sw[7]|h_sw[8]|h_sw[9]|l_sw[0]|l_sw[10]|l_sw[1]|l_sw[2]|l_sw[3]|l_sw[4]|l_sw[5]|l_sw[6]|l_sw[7]|l_sw[8]|l_sw[9]|out|pad|padres|vc|vcp|vdd|vddr|vip|vss|z
+ sg13_lv_nmos L=0.13u W=0.74u AS=0.1406p AD=0.2516p PS=1.12u PD=2.16u rfmode=0
M$623 Q_N$12 \$71163
+ BOTTOM|TOP|VGND|VSS|anode|cathode|core|h_sw[0]|h_sw[10]|h_sw[1]|h_sw[2]|h_sw[3]|h_sw[4]|h_sw[5]|h_sw[6]|h_sw[7]|h_sw[8]|h_sw[9]|l_sw[0]|l_sw[10]|l_sw[1]|l_sw[2]|l_sw[3]|l_sw[4]|l_sw[5]|l_sw[6]|l_sw[7]|l_sw[8]|l_sw[9]|out|pad|padres|vc|vcp|vdd|vddr|vip|vss|z
+ BOTTOM|TOP|VGND|VSS|anode|cathode|core|h_sw[0]|h_sw[10]|h_sw[1]|h_sw[2]|h_sw[3]|h_sw[4]|h_sw[5]|h_sw[6]|h_sw[7]|h_sw[8]|h_sw[9]|l_sw[0]|l_sw[10]|l_sw[1]|l_sw[2]|l_sw[3]|l_sw[4]|l_sw[5]|l_sw[6]|l_sw[7]|l_sw[8]|l_sw[9]|out|pad|padres|vc|vcp|vdd|vddr|vip|vss|z
+ sg13_lv_nmos L=0.13u W=0.74u AS=0.2849p AD=0.2516p PS=2.25u PD=2.16u rfmode=0
M$624 \$70971 A|Q$5
+ BOTTOM|TOP|VGND|VSS|anode|cathode|core|h_sw[0]|h_sw[10]|h_sw[1]|h_sw[2]|h_sw[3]|h_sw[4]|h_sw[5]|h_sw[6]|h_sw[7]|h_sw[8]|h_sw[9]|l_sw[0]|l_sw[10]|l_sw[1]|l_sw[2]|l_sw[3]|l_sw[4]|l_sw[5]|l_sw[6]|l_sw[7]|l_sw[8]|l_sw[9]|out|pad|padres|vc|vcp|vdd|vddr|vip|vss|z
+ BOTTOM|TOP|VGND|VSS|anode|cathode|core|h_sw[0]|h_sw[10]|h_sw[1]|h_sw[2]|h_sw[3]|h_sw[4]|h_sw[5]|h_sw[6]|h_sw[7]|h_sw[8]|h_sw[9]|l_sw[0]|l_sw[10]|l_sw[1]|l_sw[2]|l_sw[3]|l_sw[4]|l_sw[5]|l_sw[6]|l_sw[7]|l_sw[8]|l_sw[9]|out|pad|padres|vc|vcp|vdd|vddr|vip|vss|z
+ sg13_lv_nmos L=0.13u W=0.55u AS=0.187p AD=0.14875p PS=1.78u PD=1.16u rfmode=0
M$625
+ BOTTOM|TOP|VGND|VSS|anode|cathode|core|h_sw[0]|h_sw[10]|h_sw[1]|h_sw[2]|h_sw[3]|h_sw[4]|h_sw[5]|h_sw[6]|h_sw[7]|h_sw[8]|h_sw[9]|l_sw[0]|l_sw[10]|l_sw[1]|l_sw[2]|l_sw[3]|l_sw[4]|l_sw[5]|l_sw[6]|l_sw[7]|l_sw[8]|l_sw[9]|out|pad|padres|vc|vcp|vdd|vddr|vip|vss|z
+ \$70971 X|anode|cathode|core|d_out[1]|dout[1]|pad|padres
+ BOTTOM|TOP|VGND|VSS|anode|cathode|core|h_sw[0]|h_sw[10]|h_sw[1]|h_sw[2]|h_sw[3]|h_sw[4]|h_sw[5]|h_sw[6]|h_sw[7]|h_sw[8]|h_sw[9]|l_sw[0]|l_sw[10]|l_sw[1]|l_sw[2]|l_sw[3]|l_sw[4]|l_sw[5]|l_sw[6]|l_sw[7]|l_sw[8]|l_sw[9]|out|pad|padres|vc|vcp|vdd|vddr|vip|vss|z
+ sg13_lv_nmos L=0.13u W=0.74u AS=0.14875p AD=0.2886p PS=1.16u PD=2.26u rfmode=0
M$626 \$70972 A|Q$6
+ BOTTOM|TOP|VGND|VSS|anode|cathode|core|h_sw[0]|h_sw[10]|h_sw[1]|h_sw[2]|h_sw[3]|h_sw[4]|h_sw[5]|h_sw[6]|h_sw[7]|h_sw[8]|h_sw[9]|l_sw[0]|l_sw[10]|l_sw[1]|l_sw[2]|l_sw[3]|l_sw[4]|l_sw[5]|l_sw[6]|l_sw[7]|l_sw[8]|l_sw[9]|out|pad|padres|vc|vcp|vdd|vddr|vip|vss|z
+ BOTTOM|TOP|VGND|VSS|anode|cathode|core|h_sw[0]|h_sw[10]|h_sw[1]|h_sw[2]|h_sw[3]|h_sw[4]|h_sw[5]|h_sw[6]|h_sw[7]|h_sw[8]|h_sw[9]|l_sw[0]|l_sw[10]|l_sw[1]|l_sw[2]|l_sw[3]|l_sw[4]|l_sw[5]|l_sw[6]|l_sw[7]|l_sw[8]|l_sw[9]|out|pad|padres|vc|vcp|vdd|vddr|vip|vss|z
+ sg13_lv_nmos L=0.13u W=0.55u AS=0.187p AD=0.14875p PS=1.78u PD=1.16u rfmode=0
M$627
+ BOTTOM|TOP|VGND|VSS|anode|cathode|core|h_sw[0]|h_sw[10]|h_sw[1]|h_sw[2]|h_sw[3]|h_sw[4]|h_sw[5]|h_sw[6]|h_sw[7]|h_sw[8]|h_sw[9]|l_sw[0]|l_sw[10]|l_sw[1]|l_sw[2]|l_sw[3]|l_sw[4]|l_sw[5]|l_sw[6]|l_sw[7]|l_sw[8]|l_sw[9]|out|pad|padres|vc|vcp|vdd|vddr|vip|vss|z
+ \$70972 X|anode|cathode|core|d_out[2]|dout[2]|pad|padres
+ BOTTOM|TOP|VGND|VSS|anode|cathode|core|h_sw[0]|h_sw[10]|h_sw[1]|h_sw[2]|h_sw[3]|h_sw[4]|h_sw[5]|h_sw[6]|h_sw[7]|h_sw[8]|h_sw[9]|l_sw[0]|l_sw[10]|l_sw[1]|l_sw[2]|l_sw[3]|l_sw[4]|l_sw[5]|l_sw[6]|l_sw[7]|l_sw[8]|l_sw[9]|out|pad|padres|vc|vcp|vdd|vddr|vip|vss|z
+ sg13_lv_nmos L=0.13u W=0.74u AS=0.14875p AD=0.2886p PS=1.16u PD=2.26u rfmode=0
M$628 \$71238 out|vcn|vin \$71239
+ BOTTOM|TOP|VGND|VSS|anode|cathode|core|h_sw[0]|h_sw[10]|h_sw[1]|h_sw[2]|h_sw[3]|h_sw[4]|h_sw[5]|h_sw[6]|h_sw[7]|h_sw[8]|h_sw[9]|l_sw[0]|l_sw[10]|l_sw[1]|l_sw[2]|l_sw[3]|l_sw[4]|l_sw[5]|l_sw[6]|l_sw[7]|l_sw[8]|l_sw[9]|out|pad|padres|vc|vcp|vdd|vddr|vip|vss|z
+ sg13_lv_nmos L=0.13u W=10u AS=2.65p AD=2.65p PS=16.06u PD=16.06u rfmode=0
M$630 \$71238 A|outn A|comp_p|outp
+ BOTTOM|TOP|VGND|VSS|anode|cathode|core|h_sw[0]|h_sw[10]|h_sw[1]|h_sw[2]|h_sw[3]|h_sw[4]|h_sw[5]|h_sw[6]|h_sw[7]|h_sw[8]|h_sw[9]|l_sw[0]|l_sw[10]|l_sw[1]|l_sw[2]|l_sw[3]|l_sw[4]|l_sw[5]|l_sw[6]|l_sw[7]|l_sw[8]|l_sw[9]|out|pad|padres|vc|vcp|vdd|vddr|vip|vss|z
+ sg13_lv_nmos L=0.13u W=10u AS=2.65p AD=2.65p PS=16.06u PD=16.06u rfmode=0
M$632 \$71239 X|ckc|clk
+ BOTTOM|TOP|VGND|VSS|anode|cathode|core|h_sw[0]|h_sw[10]|h_sw[1]|h_sw[2]|h_sw[3]|h_sw[4]|h_sw[5]|h_sw[6]|h_sw[7]|h_sw[8]|h_sw[9]|l_sw[0]|l_sw[10]|l_sw[1]|l_sw[2]|l_sw[3]|l_sw[4]|l_sw[5]|l_sw[6]|l_sw[7]|l_sw[8]|l_sw[9]|out|pad|padres|vc|vcp|vdd|vddr|vip|vss|z
+ BOTTOM|TOP|VGND|VSS|anode|cathode|core|h_sw[0]|h_sw[10]|h_sw[1]|h_sw[2]|h_sw[3]|h_sw[4]|h_sw[5]|h_sw[6]|h_sw[7]|h_sw[8]|h_sw[9]|l_sw[0]|l_sw[10]|l_sw[1]|l_sw[2]|l_sw[3]|l_sw[4]|l_sw[5]|l_sw[6]|l_sw[7]|l_sw[8]|l_sw[9]|out|pad|padres|vc|vcp|vdd|vddr|vip|vss|z
+ sg13_lv_nmos L=0.13u W=2u AS=0.455p AD=0.455p PS=4.32u PD=4.32u rfmode=0
M$636 \$71240 A|comp_p|outp A|outn
+ BOTTOM|TOP|VGND|VSS|anode|cathode|core|h_sw[0]|h_sw[10]|h_sw[1]|h_sw[2]|h_sw[3]|h_sw[4]|h_sw[5]|h_sw[6]|h_sw[7]|h_sw[8]|h_sw[9]|l_sw[0]|l_sw[10]|l_sw[1]|l_sw[2]|l_sw[3]|l_sw[4]|l_sw[5]|l_sw[6]|l_sw[7]|l_sw[8]|l_sw[9]|out|pad|padres|vc|vcp|vdd|vddr|vip|vss|z
+ sg13_lv_nmos L=0.13u W=10u AS=2.65p AD=2.65p PS=16.06u PD=16.06u rfmode=0
M$638 \$71240
+ BOTTOM|TOP|VGND|VSS|anode|cathode|core|h_sw[0]|h_sw[10]|h_sw[1]|h_sw[2]|h_sw[3]|h_sw[4]|h_sw[5]|h_sw[6]|h_sw[7]|h_sw[8]|h_sw[9]|l_sw[0]|l_sw[10]|l_sw[1]|l_sw[2]|l_sw[3]|l_sw[4]|l_sw[5]|l_sw[6]|l_sw[7]|l_sw[8]|l_sw[9]|out|pad|padres|vc|vcp|vdd|vddr|vip|vss|z
+ \$71239
+ BOTTOM|TOP|VGND|VSS|anode|cathode|core|h_sw[0]|h_sw[10]|h_sw[1]|h_sw[2]|h_sw[3]|h_sw[4]|h_sw[5]|h_sw[6]|h_sw[7]|h_sw[8]|h_sw[9]|l_sw[0]|l_sw[10]|l_sw[1]|l_sw[2]|l_sw[3]|l_sw[4]|l_sw[5]|l_sw[6]|l_sw[7]|l_sw[8]|l_sw[9]|out|pad|padres|vc|vcp|vdd|vddr|vip|vss|z
+ sg13_lv_nmos L=0.13u W=10u AS=2.65p AD=2.65p PS=16.06u PD=16.06u rfmode=0
M$640 X|ckc|clk \$71807
+ BOTTOM|TOP|VGND|VSS|anode|cathode|core|h_sw[0]|h_sw[10]|h_sw[1]|h_sw[2]|h_sw[3]|h_sw[4]|h_sw[5]|h_sw[6]|h_sw[7]|h_sw[8]|h_sw[9]|l_sw[0]|l_sw[10]|l_sw[1]|l_sw[2]|l_sw[3]|l_sw[4]|l_sw[5]|l_sw[6]|l_sw[7]|l_sw[8]|l_sw[9]|out|pad|padres|vc|vcp|vdd|vddr|vip|vss|z
+ BOTTOM|TOP|VGND|VSS|anode|cathode|core|h_sw[0]|h_sw[10]|h_sw[1]|h_sw[2]|h_sw[3]|h_sw[4]|h_sw[5]|h_sw[6]|h_sw[7]|h_sw[8]|h_sw[9]|l_sw[0]|l_sw[10]|l_sw[1]|l_sw[2]|l_sw[3]|l_sw[4]|l_sw[5]|l_sw[6]|l_sw[7]|l_sw[8]|l_sw[9]|out|pad|padres|vc|vcp|vdd|vddr|vip|vss|z
+ sg13_lv_nmos L=0.13u W=0.74u AS=0.2886p AD=0.14875p PS=2.26u PD=1.16u rfmode=0
M$641
+ BOTTOM|TOP|VGND|VSS|anode|cathode|core|h_sw[0]|h_sw[10]|h_sw[1]|h_sw[2]|h_sw[3]|h_sw[4]|h_sw[5]|h_sw[6]|h_sw[7]|h_sw[8]|h_sw[9]|l_sw[0]|l_sw[10]|l_sw[1]|l_sw[2]|l_sw[3]|l_sw[4]|l_sw[5]|l_sw[6]|l_sw[7]|l_sw[8]|l_sw[9]|out|pad|padres|vc|vcp|vdd|vddr|vip|vss|z
+ A|Y$11 \$71807
+ BOTTOM|TOP|VGND|VSS|anode|cathode|core|h_sw[0]|h_sw[10]|h_sw[1]|h_sw[2]|h_sw[3]|h_sw[4]|h_sw[5]|h_sw[6]|h_sw[7]|h_sw[8]|h_sw[9]|l_sw[0]|l_sw[10]|l_sw[1]|l_sw[2]|l_sw[3]|l_sw[4]|l_sw[5]|l_sw[6]|l_sw[7]|l_sw[8]|l_sw[9]|out|pad|padres|vc|vcp|vdd|vddr|vip|vss|z
+ sg13_lv_nmos L=0.13u W=0.55u AS=0.14875p AD=0.187p PS=1.16u PD=1.78u rfmode=0
M$642 \$70937 \$70938
+ BOTTOM|TOP|VGND|VSS|anode|cathode|core|h_sw[0]|h_sw[10]|h_sw[1]|h_sw[2]|h_sw[3]|h_sw[4]|h_sw[5]|h_sw[6]|h_sw[7]|h_sw[8]|h_sw[9]|l_sw[0]|l_sw[10]|l_sw[1]|l_sw[2]|l_sw[3]|l_sw[4]|l_sw[5]|l_sw[6]|l_sw[7]|l_sw[8]|l_sw[9]|out|pad|padres|vc|vcp|vdd|vddr|vip|vss|z
+ BOTTOM|TOP|VGND|VSS|anode|cathode|core|h_sw[0]|h_sw[10]|h_sw[1]|h_sw[2]|h_sw[3]|h_sw[4]|h_sw[5]|h_sw[6]|h_sw[7]|h_sw[8]|h_sw[9]|l_sw[0]|l_sw[10]|l_sw[1]|l_sw[2]|l_sw[3]|l_sw[4]|l_sw[5]|l_sw[6]|l_sw[7]|l_sw[8]|l_sw[9]|out|pad|padres|vc|vcp|vdd|vddr|vip|vss|z
+ sg13_lv_nmos L=0.5u W=0.42u AS=0.1428p AD=0.0798p PS=1.52u PD=0.8u rfmode=0
M$643
+ BOTTOM|TOP|VGND|VSS|anode|cathode|core|h_sw[0]|h_sw[10]|h_sw[1]|h_sw[2]|h_sw[3]|h_sw[4]|h_sw[5]|h_sw[6]|h_sw[7]|h_sw[8]|h_sw[9]|l_sw[0]|l_sw[10]|l_sw[1]|l_sw[2]|l_sw[3]|l_sw[4]|l_sw[5]|l_sw[6]|l_sw[7]|l_sw[8]|l_sw[9]|out|pad|padres|vc|vcp|vdd|vddr|vip|vss|z
+ A|X$36 \$70938
+ BOTTOM|TOP|VGND|VSS|anode|cathode|core|h_sw[0]|h_sw[10]|h_sw[1]|h_sw[2]|h_sw[3]|h_sw[4]|h_sw[5]|h_sw[6]|h_sw[7]|h_sw[8]|h_sw[9]|l_sw[0]|l_sw[10]|l_sw[1]|l_sw[2]|l_sw[3]|l_sw[4]|l_sw[5]|l_sw[6]|l_sw[7]|l_sw[8]|l_sw[9]|out|pad|padres|vc|vcp|vdd|vddr|vip|vss|z
+ sg13_lv_nmos L=0.13u W=0.42u AS=0.0798p AD=0.1428p PS=0.8u PD=1.52u rfmode=0
M$644
+ BOTTOM|TOP|VGND|VSS|anode|cathode|core|h_sw[0]|h_sw[10]|h_sw[1]|h_sw[2]|h_sw[3]|h_sw[4]|h_sw[5]|h_sw[6]|h_sw[7]|h_sw[8]|h_sw[9]|l_sw[0]|l_sw[10]|l_sw[1]|l_sw[2]|l_sw[3]|l_sw[4]|l_sw[5]|l_sw[6]|l_sw[7]|l_sw[8]|l_sw[9]|out|pad|padres|vc|vcp|vdd|vddr|vip|vss|z
+ \$70940 \$70976
+ BOTTOM|TOP|VGND|VSS|anode|cathode|core|h_sw[0]|h_sw[10]|h_sw[1]|h_sw[2]|h_sw[3]|h_sw[4]|h_sw[5]|h_sw[6]|h_sw[7]|h_sw[8]|h_sw[9]|l_sw[0]|l_sw[10]|l_sw[1]|l_sw[2]|l_sw[3]|l_sw[4]|l_sw[5]|l_sw[6]|l_sw[7]|l_sw[8]|l_sw[9]|out|pad|padres|vc|vcp|vdd|vddr|vip|vss|z
+ sg13_lv_nmos L=0.13u W=0.74u AS=0.1626p AD=0.2516p PS=1.415u PD=2.16u rfmode=0
M$645 \$70939 CLK|D|GATE|Q$2 \$71277
+ BOTTOM|TOP|VGND|VSS|anode|cathode|core|h_sw[0]|h_sw[10]|h_sw[1]|h_sw[2]|h_sw[3]|h_sw[4]|h_sw[5]|h_sw[6]|h_sw[7]|h_sw[8]|h_sw[9]|l_sw[0]|l_sw[10]|l_sw[1]|l_sw[2]|l_sw[3]|l_sw[4]|l_sw[5]|l_sw[6]|l_sw[7]|l_sw[8]|l_sw[9]|out|pad|padres|vc|vcp|vdd|vddr|vip|vss|z
+ sg13_lv_nmos L=0.13u W=0.42u AS=0.1428p AD=0.0609p PS=1.52u PD=0.71u rfmode=0
M$646
+ BOTTOM|TOP|VGND|VSS|anode|cathode|core|h_sw[0]|h_sw[10]|h_sw[1]|h_sw[2]|h_sw[3]|h_sw[4]|h_sw[5]|h_sw[6]|h_sw[7]|h_sw[8]|h_sw[9]|l_sw[0]|l_sw[10]|l_sw[1]|l_sw[2]|l_sw[3]|l_sw[4]|l_sw[5]|l_sw[6]|l_sw[7]|l_sw[8]|l_sw[9]|out|pad|padres|vc|vcp|vdd|vddr|vip|vss|z
+ RESET_B|Y$2 \$71277
+ BOTTOM|TOP|VGND|VSS|anode|cathode|core|h_sw[0]|h_sw[10]|h_sw[1]|h_sw[2]|h_sw[3]|h_sw[4]|h_sw[5]|h_sw[6]|h_sw[7]|h_sw[8]|h_sw[9]|l_sw[0]|l_sw[10]|l_sw[1]|l_sw[2]|l_sw[3]|l_sw[4]|l_sw[5]|l_sw[6]|l_sw[7]|l_sw[8]|l_sw[9]|out|pad|padres|vc|vcp|vdd|vddr|vip|vss|z
+ sg13_lv_nmos L=0.13u W=0.42u AS=0.1626p AD=0.0609p PS=1.415u PD=0.71u rfmode=0
M$647
+ BOTTOM|TOP|VGND|VSS|anode|cathode|core|h_sw[0]|h_sw[10]|h_sw[1]|h_sw[2]|h_sw[3]|h_sw[4]|h_sw[5]|h_sw[6]|h_sw[7]|h_sw[8]|h_sw[9]|l_sw[0]|l_sw[10]|l_sw[1]|l_sw[2]|l_sw[3]|l_sw[4]|l_sw[5]|l_sw[6]|l_sw[7]|l_sw[8]|l_sw[9]|out|pad|padres|vc|vcp|vdd|vddr|vip|vss|z
+ \$71808 \$71884
+ BOTTOM|TOP|VGND|VSS|anode|cathode|core|h_sw[0]|h_sw[10]|h_sw[1]|h_sw[2]|h_sw[3]|h_sw[4]|h_sw[5]|h_sw[6]|h_sw[7]|h_sw[8]|h_sw[9]|l_sw[0]|l_sw[10]|l_sw[1]|l_sw[2]|l_sw[3]|l_sw[4]|l_sw[5]|l_sw[6]|l_sw[7]|l_sw[8]|l_sw[9]|out|pad|padres|vc|vcp|vdd|vddr|vip|vss|z
+ sg13_lv_nmos L=0.13u W=0.64u AS=0.213425p AD=0.072p PS=1.62u PD=0.865u
+ rfmode=0
M$648 \$71884 \$71809 \$71787
+ BOTTOM|TOP|VGND|VSS|anode|cathode|core|h_sw[0]|h_sw[10]|h_sw[1]|h_sw[2]|h_sw[3]|h_sw[4]|h_sw[5]|h_sw[6]|h_sw[7]|h_sw[8]|h_sw[9]|l_sw[0]|l_sw[10]|l_sw[1]|l_sw[2]|l_sw[3]|l_sw[4]|l_sw[5]|l_sw[6]|l_sw[7]|l_sw[8]|l_sw[9]|out|pad|padres|vc|vcp|vdd|vddr|vip|vss|z
+ sg13_lv_nmos L=0.13u W=0.64u AS=0.072p AD=0.141p PS=0.865u PD=1.17u rfmode=0
M$649 \$71787 \$71313 \$71885
+ BOTTOM|TOP|VGND|VSS|anode|cathode|core|h_sw[0]|h_sw[10]|h_sw[1]|h_sw[2]|h_sw[3]|h_sw[4]|h_sw[5]|h_sw[6]|h_sw[7]|h_sw[8]|h_sw[9]|l_sw[0]|l_sw[10]|l_sw[1]|l_sw[2]|l_sw[3]|l_sw[4]|l_sw[5]|l_sw[6]|l_sw[7]|l_sw[8]|l_sw[9]|out|pad|padres|vc|vcp|vdd|vddr|vip|vss|z
+ sg13_lv_nmos L=0.13u W=0.42u AS=0.141p AD=0.04725p PS=1.17u PD=0.645u rfmode=0
M$650 \$71885 \$71314
+ BOTTOM|TOP|VGND|VSS|anode|cathode|core|h_sw[0]|h_sw[10]|h_sw[1]|h_sw[2]|h_sw[3]|h_sw[4]|h_sw[5]|h_sw[6]|h_sw[7]|h_sw[8]|h_sw[9]|l_sw[0]|l_sw[10]|l_sw[1]|l_sw[2]|l_sw[3]|l_sw[4]|l_sw[5]|l_sw[6]|l_sw[7]|l_sw[8]|l_sw[9]|out|pad|padres|vc|vcp|vdd|vddr|vip|vss|z
+ BOTTOM|TOP|VGND|VSS|anode|cathode|core|h_sw[0]|h_sw[10]|h_sw[1]|h_sw[2]|h_sw[3]|h_sw[4]|h_sw[5]|h_sw[6]|h_sw[7]|h_sw[8]|h_sw[9]|l_sw[0]|l_sw[10]|l_sw[1]|l_sw[2]|l_sw[3]|l_sw[4]|l_sw[5]|l_sw[6]|l_sw[7]|l_sw[8]|l_sw[9]|out|pad|padres|vc|vcp|vdd|vddr|vip|vss|z
+ sg13_lv_nmos L=0.13u W=0.42u AS=0.04725p AD=0.1428p PS=0.645u PD=1.52u
+ rfmode=0
M$651
+ BOTTOM|TOP|VGND|VSS|anode|cathode|core|h_sw[0]|h_sw[10]|h_sw[1]|h_sw[2]|h_sw[3]|h_sw[4]|h_sw[5]|h_sw[6]|h_sw[7]|h_sw[8]|h_sw[9]|l_sw[0]|l_sw[10]|l_sw[1]|l_sw[2]|l_sw[3]|l_sw[4]|l_sw[5]|l_sw[6]|l_sw[7]|l_sw[8]|l_sw[9]|out|pad|padres|vc|vcp|vdd|vddr|vip|vss|z
+ \$71313 \$71809
+ BOTTOM|TOP|VGND|VSS|anode|cathode|core|h_sw[0]|h_sw[10]|h_sw[1]|h_sw[2]|h_sw[3]|h_sw[4]|h_sw[5]|h_sw[6]|h_sw[7]|h_sw[8]|h_sw[9]|l_sw[0]|l_sw[10]|l_sw[1]|l_sw[2]|l_sw[3]|l_sw[4]|l_sw[5]|l_sw[6]|l_sw[7]|l_sw[8]|l_sw[9]|out|pad|padres|vc|vcp|vdd|vddr|vip|vss|z
+ sg13_lv_nmos L=0.13u W=0.74u AS=0.213425p AD=0.2775p PS=1.62u PD=2.23u
+ rfmode=0
M$652
+ BOTTOM|TOP|VGND|VSS|anode|cathode|core|h_sw[0]|h_sw[10]|h_sw[1]|h_sw[2]|h_sw[3]|h_sw[4]|h_sw[5]|h_sw[6]|h_sw[7]|h_sw[8]|h_sw[9]|l_sw[0]|l_sw[10]|l_sw[1]|l_sw[2]|l_sw[3]|l_sw[4]|l_sw[5]|l_sw[6]|l_sw[7]|l_sw[8]|l_sw[9]|out|pad|padres|vc|vcp|vdd|vddr|vip|vss|z
+ RESET_B|Y$2 \$71295
+ BOTTOM|TOP|VGND|VSS|anode|cathode|core|h_sw[0]|h_sw[10]|h_sw[1]|h_sw[2]|h_sw[3]|h_sw[4]|h_sw[5]|h_sw[6]|h_sw[7]|h_sw[8]|h_sw[9]|l_sw[0]|l_sw[10]|l_sw[1]|l_sw[2]|l_sw[3]|l_sw[4]|l_sw[5]|l_sw[6]|l_sw[7]|l_sw[8]|l_sw[9]|out|pad|padres|vc|vcp|vdd|vddr|vip|vss|z
+ sg13_lv_nmos L=0.13u W=0.42u AS=0.1701p AD=0.0378p PS=1.65u PD=0.6u rfmode=0
M$653 \$71295 \$70976 \$71154
+ BOTTOM|TOP|VGND|VSS|anode|cathode|core|h_sw[0]|h_sw[10]|h_sw[1]|h_sw[2]|h_sw[3]|h_sw[4]|h_sw[5]|h_sw[6]|h_sw[7]|h_sw[8]|h_sw[9]|l_sw[0]|l_sw[10]|l_sw[1]|l_sw[2]|l_sw[3]|l_sw[4]|l_sw[5]|l_sw[6]|l_sw[7]|l_sw[8]|l_sw[9]|out|pad|padres|vc|vcp|vdd|vddr|vip|vss|z
+ sg13_lv_nmos L=0.13u W=0.42u AS=0.0378p AD=0.1428p PS=0.6u PD=1.52u rfmode=0
M$654 \$71314 \$71787 \$71886
+ BOTTOM|TOP|VGND|VSS|anode|cathode|core|h_sw[0]|h_sw[10]|h_sw[1]|h_sw[2]|h_sw[3]|h_sw[4]|h_sw[5]|h_sw[6]|h_sw[7]|h_sw[8]|h_sw[9]|l_sw[0]|l_sw[10]|l_sw[1]|l_sw[2]|l_sw[3]|l_sw[4]|l_sw[5]|l_sw[6]|l_sw[7]|l_sw[8]|l_sw[9]|out|pad|padres|vc|vcp|vdd|vddr|vip|vss|z
+ sg13_lv_nmos L=0.13u W=0.74u AS=0.2516p AD=0.0777p PS=2.16u PD=0.95u rfmode=0
M$655 \$71886 RESET_B|Y$1
+ BOTTOM|TOP|VGND|VSS|anode|cathode|core|h_sw[0]|h_sw[10]|h_sw[1]|h_sw[2]|h_sw[3]|h_sw[4]|h_sw[5]|h_sw[6]|h_sw[7]|h_sw[8]|h_sw[9]|l_sw[0]|l_sw[10]|l_sw[1]|l_sw[2]|l_sw[3]|l_sw[4]|l_sw[5]|l_sw[6]|l_sw[7]|l_sw[8]|l_sw[9]|out|pad|padres|vc|vcp|vdd|vddr|vip|vss|z
+ BOTTOM|TOP|VGND|VSS|anode|cathode|core|h_sw[0]|h_sw[10]|h_sw[1]|h_sw[2]|h_sw[3]|h_sw[4]|h_sw[5]|h_sw[6]|h_sw[7]|h_sw[8]|h_sw[9]|l_sw[0]|l_sw[10]|l_sw[1]|l_sw[2]|l_sw[3]|l_sw[4]|l_sw[5]|l_sw[6]|l_sw[7]|l_sw[8]|l_sw[9]|out|pad|padres|vc|vcp|vdd|vddr|vip|vss|z
+ sg13_lv_nmos L=0.13u W=0.74u AS=0.0777p AD=0.1406p PS=0.95u PD=1.12u rfmode=0
M$656
+ BOTTOM|TOP|VGND|VSS|anode|cathode|core|h_sw[0]|h_sw[10]|h_sw[1]|h_sw[2]|h_sw[3]|h_sw[4]|h_sw[5]|h_sw[6]|h_sw[7]|h_sw[8]|h_sw[9]|l_sw[0]|l_sw[10]|l_sw[1]|l_sw[2]|l_sw[3]|l_sw[4]|l_sw[5]|l_sw[6]|l_sw[7]|l_sw[8]|l_sw[9]|out|pad|padres|vc|vcp|vdd|vddr|vip|vss|z
+ \$71314 A|Q$9
+ BOTTOM|TOP|VGND|VSS|anode|cathode|core|h_sw[0]|h_sw[10]|h_sw[1]|h_sw[2]|h_sw[3]|h_sw[4]|h_sw[5]|h_sw[6]|h_sw[7]|h_sw[8]|h_sw[9]|l_sw[0]|l_sw[10]|l_sw[1]|l_sw[2]|l_sw[3]|l_sw[4]|l_sw[5]|l_sw[6]|l_sw[7]|l_sw[8]|l_sw[9]|out|pad|padres|vc|vcp|vdd|vddr|vip|vss|z
+ sg13_lv_nmos L=0.13u W=0.74u AS=0.1406p AD=0.2516p PS=1.12u PD=2.16u rfmode=0
M$657
+ BOTTOM|TOP|VGND|VSS|anode|cathode|core|h_sw[0]|h_sw[10]|h_sw[1]|h_sw[2]|h_sw[3]|h_sw[4]|h_sw[5]|h_sw[6]|h_sw[7]|h_sw[8]|h_sw[9]|l_sw[0]|l_sw[10]|l_sw[1]|l_sw[2]|l_sw[3]|l_sw[4]|l_sw[5]|l_sw[6]|l_sw[7]|l_sw[8]|l_sw[9]|out|pad|padres|vc|vcp|vdd|vddr|vip|vss|z
+ \$71314 \$71316
+ BOTTOM|TOP|VGND|VSS|anode|cathode|core|h_sw[0]|h_sw[10]|h_sw[1]|h_sw[2]|h_sw[3]|h_sw[4]|h_sw[5]|h_sw[6]|h_sw[7]|h_sw[8]|h_sw[9]|l_sw[0]|l_sw[10]|l_sw[1]|l_sw[2]|l_sw[3]|l_sw[4]|l_sw[5]|l_sw[6]|l_sw[7]|l_sw[8]|l_sw[9]|out|pad|padres|vc|vcp|vdd|vddr|vip|vss|z
+ sg13_lv_nmos L=0.13u W=0.55u AS=0.1491p AD=0.187p PS=1.18u PD=1.78u rfmode=0
M$658
+ BOTTOM|TOP|VGND|VSS|anode|cathode|core|h_sw[0]|h_sw[10]|h_sw[1]|h_sw[2]|h_sw[3]|h_sw[4]|h_sw[5]|h_sw[6]|h_sw[7]|h_sw[8]|h_sw[9]|l_sw[0]|l_sw[10]|l_sw[1]|l_sw[2]|l_sw[3]|l_sw[4]|l_sw[5]|l_sw[6]|l_sw[7]|l_sw[8]|l_sw[9]|out|pad|padres|vc|vcp|vdd|vddr|vip|vss|z
+ \$71316 Q_N$13
+ BOTTOM|TOP|VGND|VSS|anode|cathode|core|h_sw[0]|h_sw[10]|h_sw[1]|h_sw[2]|h_sw[3]|h_sw[4]|h_sw[5]|h_sw[6]|h_sw[7]|h_sw[8]|h_sw[9]|l_sw[0]|l_sw[10]|l_sw[1]|l_sw[2]|l_sw[3]|l_sw[4]|l_sw[5]|l_sw[6]|l_sw[7]|l_sw[8]|l_sw[9]|out|pad|padres|vc|vcp|vdd|vddr|vip|vss|z
+ sg13_lv_nmos L=0.13u W=0.74u AS=0.1491p AD=0.2516p PS=1.18u PD=2.16u rfmode=0
M$659 \$71810 CLK|D|GATE|Q \$71801
+ BOTTOM|TOP|VGND|VSS|anode|cathode|core|h_sw[0]|h_sw[10]|h_sw[1]|h_sw[2]|h_sw[3]|h_sw[4]|h_sw[5]|h_sw[6]|h_sw[7]|h_sw[8]|h_sw[9]|l_sw[0]|l_sw[10]|l_sw[1]|l_sw[2]|l_sw[3]|l_sw[4]|l_sw[5]|l_sw[6]|l_sw[7]|l_sw[8]|l_sw[9]|out|pad|padres|vc|vcp|vdd|vddr|vip|vss|z
+ sg13_lv_nmos L=0.13u W=0.42u AS=0.1428p AD=0.0609p PS=1.52u PD=0.71u rfmode=0
M$660 \$71801 RESET_B|Y$2
+ BOTTOM|TOP|VGND|VSS|anode|cathode|core|h_sw[0]|h_sw[10]|h_sw[1]|h_sw[2]|h_sw[3]|h_sw[4]|h_sw[5]|h_sw[6]|h_sw[7]|h_sw[8]|h_sw[9]|l_sw[0]|l_sw[10]|l_sw[1]|l_sw[2]|l_sw[3]|l_sw[4]|l_sw[5]|l_sw[6]|l_sw[7]|l_sw[8]|l_sw[9]|out|pad|padres|vc|vcp|vdd|vddr|vip|vss|z
+ BOTTOM|TOP|VGND|VSS|anode|cathode|core|h_sw[0]|h_sw[10]|h_sw[1]|h_sw[2]|h_sw[3]|h_sw[4]|h_sw[5]|h_sw[6]|h_sw[7]|h_sw[8]|h_sw[9]|l_sw[0]|l_sw[10]|l_sw[1]|l_sw[2]|l_sw[3]|l_sw[4]|l_sw[5]|l_sw[6]|l_sw[7]|l_sw[8]|l_sw[9]|out|pad|padres|vc|vcp|vdd|vddr|vip|vss|z
+ sg13_lv_nmos L=0.13u W=0.42u AS=0.0609p AD=0.1626p PS=0.71u PD=1.415u rfmode=0
M$661
+ BOTTOM|TOP|VGND|VSS|anode|cathode|core|h_sw[0]|h_sw[10]|h_sw[1]|h_sw[2]|h_sw[3]|h_sw[4]|h_sw[5]|h_sw[6]|h_sw[7]|h_sw[8]|h_sw[9]|l_sw[0]|l_sw[10]|l_sw[1]|l_sw[2]|l_sw[3]|l_sw[4]|l_sw[5]|l_sw[6]|l_sw[7]|l_sw[8]|l_sw[9]|out|pad|padres|vc|vcp|vdd|vddr|vip|vss|z
+ \$71891 \$71318
+ BOTTOM|TOP|VGND|VSS|anode|cathode|core|h_sw[0]|h_sw[10]|h_sw[1]|h_sw[2]|h_sw[3]|h_sw[4]|h_sw[5]|h_sw[6]|h_sw[7]|h_sw[8]|h_sw[9]|l_sw[0]|l_sw[10]|l_sw[1]|l_sw[2]|l_sw[3]|l_sw[4]|l_sw[5]|l_sw[6]|l_sw[7]|l_sw[8]|l_sw[9]|out|pad|padres|vc|vcp|vdd|vddr|vip|vss|z
+ sg13_lv_nmos L=0.13u W=0.74u AS=0.1626p AD=0.2516p PS=1.415u PD=2.16u rfmode=0
M$662 \$71169 \$70978
+ BOTTOM|TOP|VGND|VSS|anode|cathode|core|h_sw[0]|h_sw[10]|h_sw[1]|h_sw[2]|h_sw[3]|h_sw[4]|h_sw[5]|h_sw[6]|h_sw[7]|h_sw[8]|h_sw[9]|l_sw[0]|l_sw[10]|l_sw[1]|l_sw[2]|l_sw[3]|l_sw[4]|l_sw[5]|l_sw[6]|l_sw[7]|l_sw[8]|l_sw[9]|out|pad|padres|vc|vcp|vdd|vddr|vip|vss|z
+ BOTTOM|TOP|VGND|VSS|anode|cathode|core|h_sw[0]|h_sw[10]|h_sw[1]|h_sw[2]|h_sw[3]|h_sw[4]|h_sw[5]|h_sw[6]|h_sw[7]|h_sw[8]|h_sw[9]|l_sw[0]|l_sw[10]|l_sw[1]|l_sw[2]|l_sw[3]|l_sw[4]|l_sw[5]|l_sw[6]|l_sw[7]|l_sw[8]|l_sw[9]|out|pad|padres|vc|vcp|vdd|vddr|vip|vss|z
+ sg13_lv_nmos L=0.13u W=0.42u AS=0.1428p AD=0.0798p PS=1.52u PD=0.8u rfmode=0
M$663
+ BOTTOM|TOP|VGND|VSS|anode|cathode|core|h_sw[0]|h_sw[10]|h_sw[1]|h_sw[2]|h_sw[3]|h_sw[4]|h_sw[5]|h_sw[6]|h_sw[7]|h_sw[8]|h_sw[9]|l_sw[0]|l_sw[10]|l_sw[1]|l_sw[2]|l_sw[3]|l_sw[4]|l_sw[5]|l_sw[6]|l_sw[7]|l_sw[8]|l_sw[9]|out|pad|padres|vc|vcp|vdd|vddr|vip|vss|z
+ RESET_B|Y$2 \$71296
+ BOTTOM|TOP|VGND|VSS|anode|cathode|core|h_sw[0]|h_sw[10]|h_sw[1]|h_sw[2]|h_sw[3]|h_sw[4]|h_sw[5]|h_sw[6]|h_sw[7]|h_sw[8]|h_sw[9]|l_sw[0]|l_sw[10]|l_sw[1]|l_sw[2]|l_sw[3]|l_sw[4]|l_sw[5]|l_sw[6]|l_sw[7]|l_sw[8]|l_sw[9]|out|pad|padres|vc|vcp|vdd|vddr|vip|vss|z
+ sg13_lv_nmos L=0.13u W=0.42u AS=0.0798p AD=0.0378p PS=0.8u PD=0.6u rfmode=0
M$664 \$71296 \$71155 \$70978
+ BOTTOM|TOP|VGND|VSS|anode|cathode|core|h_sw[0]|h_sw[10]|h_sw[1]|h_sw[2]|h_sw[3]|h_sw[4]|h_sw[5]|h_sw[6]|h_sw[7]|h_sw[8]|h_sw[9]|l_sw[0]|l_sw[10]|l_sw[1]|l_sw[2]|l_sw[3]|l_sw[4]|l_sw[5]|l_sw[6]|l_sw[7]|l_sw[8]|l_sw[9]|out|pad|padres|vc|vcp|vdd|vddr|vip|vss|z
+ sg13_lv_nmos L=0.13u W=0.42u AS=0.0378p AD=0.1428p PS=0.6u PD=1.52u rfmode=0
M$665 \$71320 \$71321
+ BOTTOM|TOP|VGND|VSS|anode|cathode|core|h_sw[0]|h_sw[10]|h_sw[1]|h_sw[2]|h_sw[3]|h_sw[4]|h_sw[5]|h_sw[6]|h_sw[7]|h_sw[8]|h_sw[9]|l_sw[0]|l_sw[10]|l_sw[1]|l_sw[2]|l_sw[3]|l_sw[4]|l_sw[5]|l_sw[6]|l_sw[7]|l_sw[8]|l_sw[9]|out|pad|padres|vc|vcp|vdd|vddr|vip|vss|z
+ BOTTOM|TOP|VGND|VSS|anode|cathode|core|h_sw[0]|h_sw[10]|h_sw[1]|h_sw[2]|h_sw[3]|h_sw[4]|h_sw[5]|h_sw[6]|h_sw[7]|h_sw[8]|h_sw[9]|l_sw[0]|l_sw[10]|l_sw[1]|l_sw[2]|l_sw[3]|l_sw[4]|l_sw[5]|l_sw[6]|l_sw[7]|l_sw[8]|l_sw[9]|out|pad|padres|vc|vcp|vdd|vddr|vip|vss|z
+ sg13_lv_nmos L=0.13u W=0.42u AS=0.1428p AD=0.0798p PS=1.52u PD=0.8u rfmode=0
M$666
+ BOTTOM|TOP|VGND|VSS|anode|cathode|core|h_sw[0]|h_sw[10]|h_sw[1]|h_sw[2]|h_sw[3]|h_sw[4]|h_sw[5]|h_sw[6]|h_sw[7]|h_sw[8]|h_sw[9]|l_sw[0]|l_sw[10]|l_sw[1]|l_sw[2]|l_sw[3]|l_sw[4]|l_sw[5]|l_sw[6]|l_sw[7]|l_sw[8]|l_sw[9]|out|pad|padres|vc|vcp|vdd|vddr|vip|vss|z
+ RESET_B|Y$2 \$71802
+ BOTTOM|TOP|VGND|VSS|anode|cathode|core|h_sw[0]|h_sw[10]|h_sw[1]|h_sw[2]|h_sw[3]|h_sw[4]|h_sw[5]|h_sw[6]|h_sw[7]|h_sw[8]|h_sw[9]|l_sw[0]|l_sw[10]|l_sw[1]|l_sw[2]|l_sw[3]|l_sw[4]|l_sw[5]|l_sw[6]|l_sw[7]|l_sw[8]|l_sw[9]|out|pad|padres|vc|vcp|vdd|vddr|vip|vss|z
+ sg13_lv_nmos L=0.13u W=0.42u AS=0.0798p AD=0.0378p PS=0.8u PD=0.6u rfmode=0
M$667 \$71802 \$71811 \$71321
+ BOTTOM|TOP|VGND|VSS|anode|cathode|core|h_sw[0]|h_sw[10]|h_sw[1]|h_sw[2]|h_sw[3]|h_sw[4]|h_sw[5]|h_sw[6]|h_sw[7]|h_sw[8]|h_sw[9]|l_sw[0]|l_sw[10]|l_sw[1]|l_sw[2]|l_sw[3]|l_sw[4]|l_sw[5]|l_sw[6]|l_sw[7]|l_sw[8]|l_sw[9]|out|pad|padres|vc|vcp|vdd|vddr|vip|vss|z
+ sg13_lv_nmos L=0.13u W=0.42u AS=0.0378p AD=0.1428p PS=0.6u PD=1.52u rfmode=0
M$668
+ BOTTOM|TOP|VGND|VSS|anode|cathode|core|h_sw[0]|h_sw[10]|h_sw[1]|h_sw[2]|h_sw[3]|h_sw[4]|h_sw[5]|h_sw[6]|h_sw[7]|h_sw[8]|h_sw[9]|l_sw[0]|l_sw[10]|l_sw[1]|l_sw[2]|l_sw[3]|l_sw[4]|l_sw[5]|l_sw[6]|l_sw[7]|l_sw[8]|l_sw[9]|out|pad|padres|vc|vcp|vdd|vddr|vip|vss|z
+ \$71811 Q_N$14
+ BOTTOM|TOP|VGND|VSS|anode|cathode|core|h_sw[0]|h_sw[10]|h_sw[1]|h_sw[2]|h_sw[3]|h_sw[4]|h_sw[5]|h_sw[6]|h_sw[7]|h_sw[8]|h_sw[9]|l_sw[0]|l_sw[10]|l_sw[1]|l_sw[2]|l_sw[3]|l_sw[4]|l_sw[5]|l_sw[6]|l_sw[7]|l_sw[8]|l_sw[9]|out|pad|padres|vc|vcp|vdd|vddr|vip|vss|z
+ sg13_lv_nmos L=0.13u W=0.74u AS=0.2516p AD=0.2849p PS=2.16u PD=2.25u rfmode=0
M$669
+ BOTTOM|TOP|VGND|VSS|anode|cathode|core|h_sw[0]|h_sw[10]|h_sw[1]|h_sw[2]|h_sw[3]|h_sw[4]|h_sw[5]|h_sw[6]|h_sw[7]|h_sw[8]|h_sw[9]|l_sw[0]|l_sw[10]|l_sw[1]|l_sw[2]|l_sw[3]|l_sw[4]|l_sw[5]|l_sw[6]|l_sw[7]|l_sw[8]|l_sw[9]|out|pad|padres|vc|vcp|vdd|vddr|vip|vss|z
+ \$70947 \$70979
+ BOTTOM|TOP|VGND|VSS|anode|cathode|core|h_sw[0]|h_sw[10]|h_sw[1]|h_sw[2]|h_sw[3]|h_sw[4]|h_sw[5]|h_sw[6]|h_sw[7]|h_sw[8]|h_sw[9]|l_sw[0]|l_sw[10]|l_sw[1]|l_sw[2]|l_sw[3]|l_sw[4]|l_sw[5]|l_sw[6]|l_sw[7]|l_sw[8]|l_sw[9]|out|pad|padres|vc|vcp|vdd|vddr|vip|vss|z
+ sg13_lv_nmos L=0.13u W=0.74u AS=0.1626p AD=0.2516p PS=1.415u PD=2.16u rfmode=0
M$670 \$70946 D|X \$71297
+ BOTTOM|TOP|VGND|VSS|anode|cathode|core|h_sw[0]|h_sw[10]|h_sw[1]|h_sw[2]|h_sw[3]|h_sw[4]|h_sw[5]|h_sw[6]|h_sw[7]|h_sw[8]|h_sw[9]|l_sw[0]|l_sw[10]|l_sw[1]|l_sw[2]|l_sw[3]|l_sw[4]|l_sw[5]|l_sw[6]|l_sw[7]|l_sw[8]|l_sw[9]|out|pad|padres|vc|vcp|vdd|vddr|vip|vss|z
+ sg13_lv_nmos L=0.13u W=0.42u AS=0.1428p AD=0.0609p PS=1.52u PD=0.71u rfmode=0
M$671
+ BOTTOM|TOP|VGND|VSS|anode|cathode|core|h_sw[0]|h_sw[10]|h_sw[1]|h_sw[2]|h_sw[3]|h_sw[4]|h_sw[5]|h_sw[6]|h_sw[7]|h_sw[8]|h_sw[9]|l_sw[0]|l_sw[10]|l_sw[1]|l_sw[2]|l_sw[3]|l_sw[4]|l_sw[5]|l_sw[6]|l_sw[7]|l_sw[8]|l_sw[9]|out|pad|padres|vc|vcp|vdd|vddr|vip|vss|z
+ RESET_B|Y$1 \$71297
+ BOTTOM|TOP|VGND|VSS|anode|cathode|core|h_sw[0]|h_sw[10]|h_sw[1]|h_sw[2]|h_sw[3]|h_sw[4]|h_sw[5]|h_sw[6]|h_sw[7]|h_sw[8]|h_sw[9]|l_sw[0]|l_sw[10]|l_sw[1]|l_sw[2]|l_sw[3]|l_sw[4]|l_sw[5]|l_sw[6]|l_sw[7]|l_sw[8]|l_sw[9]|out|pad|padres|vc|vcp|vdd|vddr|vip|vss|z
+ sg13_lv_nmos L=0.13u W=0.42u AS=0.1626p AD=0.0609p PS=1.415u PD=0.71u rfmode=0
M$672 \$71323 \$71811
+ BOTTOM|TOP|VGND|VSS|anode|cathode|core|h_sw[0]|h_sw[10]|h_sw[1]|h_sw[2]|h_sw[3]|h_sw[4]|h_sw[5]|h_sw[6]|h_sw[7]|h_sw[8]|h_sw[9]|l_sw[0]|l_sw[10]|l_sw[1]|l_sw[2]|l_sw[3]|l_sw[4]|l_sw[5]|l_sw[6]|l_sw[7]|l_sw[8]|l_sw[9]|out|pad|padres|vc|vcp|vdd|vddr|vip|vss|z
+ BOTTOM|TOP|VGND|VSS|anode|cathode|core|h_sw[0]|h_sw[10]|h_sw[1]|h_sw[2]|h_sw[3]|h_sw[4]|h_sw[5]|h_sw[6]|h_sw[7]|h_sw[8]|h_sw[9]|l_sw[0]|l_sw[10]|l_sw[1]|l_sw[2]|l_sw[3]|l_sw[4]|l_sw[5]|l_sw[6]|l_sw[7]|l_sw[8]|l_sw[9]|out|pad|padres|vc|vcp|vdd|vddr|vip|vss|z
+ sg13_lv_nmos L=0.13u W=0.74u AS=0.2516p AD=0.1406p PS=2.16u PD=1.12u rfmode=0
M$673
+ BOTTOM|TOP|VGND|VSS|anode|cathode|core|h_sw[0]|h_sw[10]|h_sw[1]|h_sw[2]|h_sw[3]|h_sw[4]|h_sw[5]|h_sw[6]|h_sw[7]|h_sw[8]|h_sw[9]|l_sw[0]|l_sw[10]|l_sw[1]|l_sw[2]|l_sw[3]|l_sw[4]|l_sw[5]|l_sw[6]|l_sw[7]|l_sw[8]|l_sw[9]|out|pad|padres|vc|vcp|vdd|vddr|vip|vss|z
+ \$71323 CLK|D|GATE|Q$1
+ BOTTOM|TOP|VGND|VSS|anode|cathode|core|h_sw[0]|h_sw[10]|h_sw[1]|h_sw[2]|h_sw[3]|h_sw[4]|h_sw[5]|h_sw[6]|h_sw[7]|h_sw[8]|h_sw[9]|l_sw[0]|l_sw[10]|l_sw[1]|l_sw[2]|l_sw[3]|l_sw[4]|l_sw[5]|l_sw[6]|l_sw[7]|l_sw[8]|l_sw[9]|out|pad|padres|vc|vcp|vdd|vddr|vip|vss|z
+ sg13_lv_nmos L=0.13u W=0.74u AS=0.1406p AD=0.2516p PS=1.12u PD=2.16u rfmode=0
M$674
+ BOTTOM|TOP|VGND|VSS|anode|cathode|core|h_sw[0]|h_sw[10]|h_sw[1]|h_sw[2]|h_sw[3]|h_sw[4]|h_sw[5]|h_sw[6]|h_sw[7]|h_sw[8]|h_sw[9]|l_sw[0]|l_sw[10]|l_sw[1]|l_sw[2]|l_sw[3]|l_sw[4]|l_sw[5]|l_sw[6]|l_sw[7]|l_sw[8]|l_sw[9]|out|pad|padres|vc|vcp|vdd|vddr|vip|vss|z
+ RESET_B|Y$1 \$71299
+ BOTTOM|TOP|VGND|VSS|anode|cathode|core|h_sw[0]|h_sw[10]|h_sw[1]|h_sw[2]|h_sw[3]|h_sw[4]|h_sw[5]|h_sw[6]|h_sw[7]|h_sw[8]|h_sw[9]|l_sw[0]|l_sw[10]|l_sw[1]|l_sw[2]|l_sw[3]|l_sw[4]|l_sw[5]|l_sw[6]|l_sw[7]|l_sw[8]|l_sw[9]|out|pad|padres|vc|vcp|vdd|vddr|vip|vss|z
+ sg13_lv_nmos L=0.13u W=0.42u AS=0.1701p AD=0.0378p PS=1.65u PD=0.6u rfmode=0
M$675 \$71299 \$70979 \$71156
+ BOTTOM|TOP|VGND|VSS|anode|cathode|core|h_sw[0]|h_sw[10]|h_sw[1]|h_sw[2]|h_sw[3]|h_sw[4]|h_sw[5]|h_sw[6]|h_sw[7]|h_sw[8]|h_sw[9]|l_sw[0]|l_sw[10]|l_sw[1]|l_sw[2]|l_sw[3]|l_sw[4]|l_sw[5]|l_sw[6]|l_sw[7]|l_sw[8]|l_sw[9]|out|pad|padres|vc|vcp|vdd|vddr|vip|vss|z
+ sg13_lv_nmos L=0.13u W=0.42u AS=0.0378p AD=0.1428p PS=0.6u PD=1.52u rfmode=0
M$676 \$71812 CLK|D|GATE|Q$1 \$71803
+ BOTTOM|TOP|VGND|VSS|anode|cathode|core|h_sw[0]|h_sw[10]|h_sw[1]|h_sw[2]|h_sw[3]|h_sw[4]|h_sw[5]|h_sw[6]|h_sw[7]|h_sw[8]|h_sw[9]|l_sw[0]|l_sw[10]|l_sw[1]|l_sw[2]|l_sw[3]|l_sw[4]|l_sw[5]|l_sw[6]|l_sw[7]|l_sw[8]|l_sw[9]|out|pad|padres|vc|vcp|vdd|vddr|vip|vss|z
+ sg13_lv_nmos L=0.13u W=0.42u AS=0.1428p AD=0.0609p PS=1.52u PD=0.71u rfmode=0
M$677 \$71803 RESET_B|Y$2
+ BOTTOM|TOP|VGND|VSS|anode|cathode|core|h_sw[0]|h_sw[10]|h_sw[1]|h_sw[2]|h_sw[3]|h_sw[4]|h_sw[5]|h_sw[6]|h_sw[7]|h_sw[8]|h_sw[9]|l_sw[0]|l_sw[10]|l_sw[1]|l_sw[2]|l_sw[3]|l_sw[4]|l_sw[5]|l_sw[6]|l_sw[7]|l_sw[8]|l_sw[9]|out|pad|padres|vc|vcp|vdd|vddr|vip|vss|z
+ BOTTOM|TOP|VGND|VSS|anode|cathode|core|h_sw[0]|h_sw[10]|h_sw[1]|h_sw[2]|h_sw[3]|h_sw[4]|h_sw[5]|h_sw[6]|h_sw[7]|h_sw[8]|h_sw[9]|l_sw[0]|l_sw[10]|l_sw[1]|l_sw[2]|l_sw[3]|l_sw[4]|l_sw[5]|l_sw[6]|l_sw[7]|l_sw[8]|l_sw[9]|out|pad|padres|vc|vcp|vdd|vddr|vip|vss|z
+ sg13_lv_nmos L=0.13u W=0.42u AS=0.0609p AD=0.1626p PS=0.71u PD=1.415u rfmode=0
M$678
+ BOTTOM|TOP|VGND|VSS|anode|cathode|core|h_sw[0]|h_sw[10]|h_sw[1]|h_sw[2]|h_sw[3]|h_sw[4]|h_sw[5]|h_sw[6]|h_sw[7]|h_sw[8]|h_sw[9]|l_sw[0]|l_sw[10]|l_sw[1]|l_sw[2]|l_sw[3]|l_sw[4]|l_sw[5]|l_sw[6]|l_sw[7]|l_sw[8]|l_sw[9]|out|pad|padres|vc|vcp|vdd|vddr|vip|vss|z
+ \$71892 \$71324
+ BOTTOM|TOP|VGND|VSS|anode|cathode|core|h_sw[0]|h_sw[10]|h_sw[1]|h_sw[2]|h_sw[3]|h_sw[4]|h_sw[5]|h_sw[6]|h_sw[7]|h_sw[8]|h_sw[9]|l_sw[0]|l_sw[10]|l_sw[1]|l_sw[2]|l_sw[3]|l_sw[4]|l_sw[5]|l_sw[6]|l_sw[7]|l_sw[8]|l_sw[9]|out|pad|padres|vc|vcp|vdd|vddr|vip|vss|z
+ sg13_lv_nmos L=0.13u W=0.74u AS=0.1626p AD=0.2516p PS=1.415u PD=2.16u rfmode=0
M$679 \$71170 \$70981
+ BOTTOM|TOP|VGND|VSS|anode|cathode|core|h_sw[0]|h_sw[10]|h_sw[1]|h_sw[2]|h_sw[3]|h_sw[4]|h_sw[5]|h_sw[6]|h_sw[7]|h_sw[8]|h_sw[9]|l_sw[0]|l_sw[10]|l_sw[1]|l_sw[2]|l_sw[3]|l_sw[4]|l_sw[5]|l_sw[6]|l_sw[7]|l_sw[8]|l_sw[9]|out|pad|padres|vc|vcp|vdd|vddr|vip|vss|z
+ BOTTOM|TOP|VGND|VSS|anode|cathode|core|h_sw[0]|h_sw[10]|h_sw[1]|h_sw[2]|h_sw[3]|h_sw[4]|h_sw[5]|h_sw[6]|h_sw[7]|h_sw[8]|h_sw[9]|l_sw[0]|l_sw[10]|l_sw[1]|l_sw[2]|l_sw[3]|l_sw[4]|l_sw[5]|l_sw[6]|l_sw[7]|l_sw[8]|l_sw[9]|out|pad|padres|vc|vcp|vdd|vddr|vip|vss|z
+ sg13_lv_nmos L=0.13u W=0.42u AS=0.1428p AD=0.0798p PS=1.52u PD=0.8u rfmode=0
M$680
+ BOTTOM|TOP|VGND|VSS|anode|cathode|core|h_sw[0]|h_sw[10]|h_sw[1]|h_sw[2]|h_sw[3]|h_sw[4]|h_sw[5]|h_sw[6]|h_sw[7]|h_sw[8]|h_sw[9]|l_sw[0]|l_sw[10]|l_sw[1]|l_sw[2]|l_sw[3]|l_sw[4]|l_sw[5]|l_sw[6]|l_sw[7]|l_sw[8]|l_sw[9]|out|pad|padres|vc|vcp|vdd|vddr|vip|vss|z
+ RESET_B|Y$1 \$71300
+ BOTTOM|TOP|VGND|VSS|anode|cathode|core|h_sw[0]|h_sw[10]|h_sw[1]|h_sw[2]|h_sw[3]|h_sw[4]|h_sw[5]|h_sw[6]|h_sw[7]|h_sw[8]|h_sw[9]|l_sw[0]|l_sw[10]|l_sw[1]|l_sw[2]|l_sw[3]|l_sw[4]|l_sw[5]|l_sw[6]|l_sw[7]|l_sw[8]|l_sw[9]|out|pad|padres|vc|vcp|vdd|vddr|vip|vss|z
+ sg13_lv_nmos L=0.13u W=0.42u AS=0.0798p AD=0.0378p PS=0.8u PD=0.6u rfmode=0
M$681 \$71300 \$71158 \$70981
+ BOTTOM|TOP|VGND|VSS|anode|cathode|core|h_sw[0]|h_sw[10]|h_sw[1]|h_sw[2]|h_sw[3]|h_sw[4]|h_sw[5]|h_sw[6]|h_sw[7]|h_sw[8]|h_sw[9]|l_sw[0]|l_sw[10]|l_sw[1]|l_sw[2]|l_sw[3]|l_sw[4]|l_sw[5]|l_sw[6]|l_sw[7]|l_sw[8]|l_sw[9]|out|pad|padres|vc|vcp|vdd|vddr|vip|vss|z
+ sg13_lv_nmos L=0.13u W=0.42u AS=0.0378p AD=0.1428p PS=0.6u PD=1.52u rfmode=0
M$682 \$71326 \$71327
+ BOTTOM|TOP|VGND|VSS|anode|cathode|core|h_sw[0]|h_sw[10]|h_sw[1]|h_sw[2]|h_sw[3]|h_sw[4]|h_sw[5]|h_sw[6]|h_sw[7]|h_sw[8]|h_sw[9]|l_sw[0]|l_sw[10]|l_sw[1]|l_sw[2]|l_sw[3]|l_sw[4]|l_sw[5]|l_sw[6]|l_sw[7]|l_sw[8]|l_sw[9]|out|pad|padres|vc|vcp|vdd|vddr|vip|vss|z
+ BOTTOM|TOP|VGND|VSS|anode|cathode|core|h_sw[0]|h_sw[10]|h_sw[1]|h_sw[2]|h_sw[3]|h_sw[4]|h_sw[5]|h_sw[6]|h_sw[7]|h_sw[8]|h_sw[9]|l_sw[0]|l_sw[10]|l_sw[1]|l_sw[2]|l_sw[3]|l_sw[4]|l_sw[5]|l_sw[6]|l_sw[7]|l_sw[8]|l_sw[9]|out|pad|padres|vc|vcp|vdd|vddr|vip|vss|z
+ sg13_lv_nmos L=0.13u W=0.42u AS=0.1428p AD=0.0798p PS=1.52u PD=0.8u rfmode=0
M$683
+ BOTTOM|TOP|VGND|VSS|anode|cathode|core|h_sw[0]|h_sw[10]|h_sw[1]|h_sw[2]|h_sw[3]|h_sw[4]|h_sw[5]|h_sw[6]|h_sw[7]|h_sw[8]|h_sw[9]|l_sw[0]|l_sw[10]|l_sw[1]|l_sw[2]|l_sw[3]|l_sw[4]|l_sw[5]|l_sw[6]|l_sw[7]|l_sw[8]|l_sw[9]|out|pad|padres|vc|vcp|vdd|vddr|vip|vss|z
+ RESET_B|Y$2 \$71804
+ BOTTOM|TOP|VGND|VSS|anode|cathode|core|h_sw[0]|h_sw[10]|h_sw[1]|h_sw[2]|h_sw[3]|h_sw[4]|h_sw[5]|h_sw[6]|h_sw[7]|h_sw[8]|h_sw[9]|l_sw[0]|l_sw[10]|l_sw[1]|l_sw[2]|l_sw[3]|l_sw[4]|l_sw[5]|l_sw[6]|l_sw[7]|l_sw[8]|l_sw[9]|out|pad|padres|vc|vcp|vdd|vddr|vip|vss|z
+ sg13_lv_nmos L=0.13u W=0.42u AS=0.0798p AD=0.0378p PS=0.8u PD=0.6u rfmode=0
M$684 \$71804 \$71813 \$71327
+ BOTTOM|TOP|VGND|VSS|anode|cathode|core|h_sw[0]|h_sw[10]|h_sw[1]|h_sw[2]|h_sw[3]|h_sw[4]|h_sw[5]|h_sw[6]|h_sw[7]|h_sw[8]|h_sw[9]|l_sw[0]|l_sw[10]|l_sw[1]|l_sw[2]|l_sw[3]|l_sw[4]|l_sw[5]|l_sw[6]|l_sw[7]|l_sw[8]|l_sw[9]|out|pad|padres|vc|vcp|vdd|vddr|vip|vss|z
+ sg13_lv_nmos L=0.13u W=0.42u AS=0.0378p AD=0.1428p PS=0.6u PD=1.52u rfmode=0
M$685
+ BOTTOM|TOP|VGND|VSS|anode|cathode|core|h_sw[0]|h_sw[10]|h_sw[1]|h_sw[2]|h_sw[3]|h_sw[4]|h_sw[5]|h_sw[6]|h_sw[7]|h_sw[8]|h_sw[9]|l_sw[0]|l_sw[10]|l_sw[1]|l_sw[2]|l_sw[3]|l_sw[4]|l_sw[5]|l_sw[6]|l_sw[7]|l_sw[8]|l_sw[9]|out|pad|padres|vc|vcp|vdd|vddr|vip|vss|z
+ \$71813 Q_N$15
+ BOTTOM|TOP|VGND|VSS|anode|cathode|core|h_sw[0]|h_sw[10]|h_sw[1]|h_sw[2]|h_sw[3]|h_sw[4]|h_sw[5]|h_sw[6]|h_sw[7]|h_sw[8]|h_sw[9]|l_sw[0]|l_sw[10]|l_sw[1]|l_sw[2]|l_sw[3]|l_sw[4]|l_sw[5]|l_sw[6]|l_sw[7]|l_sw[8]|l_sw[9]|out|pad|padres|vc|vcp|vdd|vddr|vip|vss|z
+ sg13_lv_nmos L=0.13u W=0.74u AS=0.2516p AD=0.2849p PS=2.16u PD=2.25u rfmode=0
M$686 \$71329 \$71813
+ BOTTOM|TOP|VGND|VSS|anode|cathode|core|h_sw[0]|h_sw[10]|h_sw[1]|h_sw[2]|h_sw[3]|h_sw[4]|h_sw[5]|h_sw[6]|h_sw[7]|h_sw[8]|h_sw[9]|l_sw[0]|l_sw[10]|l_sw[1]|l_sw[2]|l_sw[3]|l_sw[4]|l_sw[5]|l_sw[6]|l_sw[7]|l_sw[8]|l_sw[9]|out|pad|padres|vc|vcp|vdd|vddr|vip|vss|z
+ BOTTOM|TOP|VGND|VSS|anode|cathode|core|h_sw[0]|h_sw[10]|h_sw[1]|h_sw[2]|h_sw[3]|h_sw[4]|h_sw[5]|h_sw[6]|h_sw[7]|h_sw[8]|h_sw[9]|l_sw[0]|l_sw[10]|l_sw[1]|l_sw[2]|l_sw[3]|l_sw[4]|l_sw[5]|l_sw[6]|l_sw[7]|l_sw[8]|l_sw[9]|out|pad|padres|vc|vcp|vdd|vddr|vip|vss|z
+ sg13_lv_nmos L=0.13u W=0.74u AS=0.2516p AD=0.1406p PS=2.16u PD=1.12u rfmode=0
M$687
+ BOTTOM|TOP|VGND|VSS|anode|cathode|core|h_sw[0]|h_sw[10]|h_sw[1]|h_sw[2]|h_sw[3]|h_sw[4]|h_sw[5]|h_sw[6]|h_sw[7]|h_sw[8]|h_sw[9]|l_sw[0]|l_sw[10]|l_sw[1]|l_sw[2]|l_sw[3]|l_sw[4]|l_sw[5]|l_sw[6]|l_sw[7]|l_sw[8]|l_sw[9]|out|pad|padres|vc|vcp|vdd|vddr|vip|vss|z
+ \$71329 CLK|D|GATE|Q$3
+ BOTTOM|TOP|VGND|VSS|anode|cathode|core|h_sw[0]|h_sw[10]|h_sw[1]|h_sw[2]|h_sw[3]|h_sw[4]|h_sw[5]|h_sw[6]|h_sw[7]|h_sw[8]|h_sw[9]|l_sw[0]|l_sw[10]|l_sw[1]|l_sw[2]|l_sw[3]|l_sw[4]|l_sw[5]|l_sw[6]|l_sw[7]|l_sw[8]|l_sw[9]|out|pad|padres|vc|vcp|vdd|vddr|vip|vss|z
+ sg13_lv_nmos L=0.13u W=0.74u AS=0.1406p AD=0.2516p PS=1.12u PD=2.16u rfmode=0
M$690
+ BOTTOM|TOP|VGND|VSS|anode|cathode|core|h_sw[0]|h_sw[10]|h_sw[1]|h_sw[2]|h_sw[3]|h_sw[4]|h_sw[5]|h_sw[6]|h_sw[7]|h_sw[8]|h_sw[9]|l_sw[0]|l_sw[10]|l_sw[1]|l_sw[2]|l_sw[3]|l_sw[4]|l_sw[5]|l_sw[6]|l_sw[7]|l_sw[8]|l_sw[9]|out|pad|padres|vc|vcp|vdd|vddr|vip|vss|z
+ \$71814 \$71879
+ BOTTOM|TOP|VGND|VSS|anode|cathode|core|h_sw[0]|h_sw[10]|h_sw[1]|h_sw[2]|h_sw[3]|h_sw[4]|h_sw[5]|h_sw[6]|h_sw[7]|h_sw[8]|h_sw[9]|l_sw[0]|l_sw[10]|l_sw[1]|l_sw[2]|l_sw[3]|l_sw[4]|l_sw[5]|l_sw[6]|l_sw[7]|l_sw[8]|l_sw[9]|out|pad|padres|vc|vcp|vdd|vddr|vip|vss|z
+ sg13_lv_nmos L=0.13u W=0.64u AS=0.213425p AD=0.072p PS=1.62u PD=0.865u
+ rfmode=0
M$691 \$71879 \$71815 \$71793
+ BOTTOM|TOP|VGND|VSS|anode|cathode|core|h_sw[0]|h_sw[10]|h_sw[1]|h_sw[2]|h_sw[3]|h_sw[4]|h_sw[5]|h_sw[6]|h_sw[7]|h_sw[8]|h_sw[9]|l_sw[0]|l_sw[10]|l_sw[1]|l_sw[2]|l_sw[3]|l_sw[4]|l_sw[5]|l_sw[6]|l_sw[7]|l_sw[8]|l_sw[9]|out|pad|padres|vc|vcp|vdd|vddr|vip|vss|z
+ sg13_lv_nmos L=0.13u W=0.64u AS=0.072p AD=0.141p PS=0.865u PD=1.17u rfmode=0
M$692 \$71793 \$71330 \$71880
+ BOTTOM|TOP|VGND|VSS|anode|cathode|core|h_sw[0]|h_sw[10]|h_sw[1]|h_sw[2]|h_sw[3]|h_sw[4]|h_sw[5]|h_sw[6]|h_sw[7]|h_sw[8]|h_sw[9]|l_sw[0]|l_sw[10]|l_sw[1]|l_sw[2]|l_sw[3]|l_sw[4]|l_sw[5]|l_sw[6]|l_sw[7]|l_sw[8]|l_sw[9]|out|pad|padres|vc|vcp|vdd|vddr|vip|vss|z
+ sg13_lv_nmos L=0.13u W=0.42u AS=0.141p AD=0.04725p PS=1.17u PD=0.645u rfmode=0
M$693 \$71880 \$71331
+ BOTTOM|TOP|VGND|VSS|anode|cathode|core|h_sw[0]|h_sw[10]|h_sw[1]|h_sw[2]|h_sw[3]|h_sw[4]|h_sw[5]|h_sw[6]|h_sw[7]|h_sw[8]|h_sw[9]|l_sw[0]|l_sw[10]|l_sw[1]|l_sw[2]|l_sw[3]|l_sw[4]|l_sw[5]|l_sw[6]|l_sw[7]|l_sw[8]|l_sw[9]|out|pad|padres|vc|vcp|vdd|vddr|vip|vss|z
+ BOTTOM|TOP|VGND|VSS|anode|cathode|core|h_sw[0]|h_sw[10]|h_sw[1]|h_sw[2]|h_sw[3]|h_sw[4]|h_sw[5]|h_sw[6]|h_sw[7]|h_sw[8]|h_sw[9]|l_sw[0]|l_sw[10]|l_sw[1]|l_sw[2]|l_sw[3]|l_sw[4]|l_sw[5]|l_sw[6]|l_sw[7]|l_sw[8]|l_sw[9]|out|pad|padres|vc|vcp|vdd|vddr|vip|vss|z
+ sg13_lv_nmos L=0.13u W=0.42u AS=0.04725p AD=0.1428p PS=0.645u PD=1.52u
+ rfmode=0
M$694
+ BOTTOM|TOP|VGND|VSS|anode|cathode|core|h_sw[0]|h_sw[10]|h_sw[1]|h_sw[2]|h_sw[3]|h_sw[4]|h_sw[5]|h_sw[6]|h_sw[7]|h_sw[8]|h_sw[9]|l_sw[0]|l_sw[10]|l_sw[1]|l_sw[2]|l_sw[3]|l_sw[4]|l_sw[5]|l_sw[6]|l_sw[7]|l_sw[8]|l_sw[9]|out|pad|padres|vc|vcp|vdd|vddr|vip|vss|z
+ \$71330 \$71815
+ BOTTOM|TOP|VGND|VSS|anode|cathode|core|h_sw[0]|h_sw[10]|h_sw[1]|h_sw[2]|h_sw[3]|h_sw[4]|h_sw[5]|h_sw[6]|h_sw[7]|h_sw[8]|h_sw[9]|l_sw[0]|l_sw[10]|l_sw[1]|l_sw[2]|l_sw[3]|l_sw[4]|l_sw[5]|l_sw[6]|l_sw[7]|l_sw[8]|l_sw[9]|out|pad|padres|vc|vcp|vdd|vddr|vip|vss|z
+ sg13_lv_nmos L=0.13u W=0.74u AS=0.213425p AD=0.2775p PS=1.62u PD=2.23u
+ rfmode=0
M$695 \$71331 \$71793 \$71881
+ BOTTOM|TOP|VGND|VSS|anode|cathode|core|h_sw[0]|h_sw[10]|h_sw[1]|h_sw[2]|h_sw[3]|h_sw[4]|h_sw[5]|h_sw[6]|h_sw[7]|h_sw[8]|h_sw[9]|l_sw[0]|l_sw[10]|l_sw[1]|l_sw[2]|l_sw[3]|l_sw[4]|l_sw[5]|l_sw[6]|l_sw[7]|l_sw[8]|l_sw[9]|out|pad|padres|vc|vcp|vdd|vddr|vip|vss|z
+ sg13_lv_nmos L=0.13u W=0.74u AS=0.2516p AD=0.0777p PS=2.16u PD=0.95u rfmode=0
M$696 \$71881 RESET_B|Y$1
+ BOTTOM|TOP|VGND|VSS|anode|cathode|core|h_sw[0]|h_sw[10]|h_sw[1]|h_sw[2]|h_sw[3]|h_sw[4]|h_sw[5]|h_sw[6]|h_sw[7]|h_sw[8]|h_sw[9]|l_sw[0]|l_sw[10]|l_sw[1]|l_sw[2]|l_sw[3]|l_sw[4]|l_sw[5]|l_sw[6]|l_sw[7]|l_sw[8]|l_sw[9]|out|pad|padres|vc|vcp|vdd|vddr|vip|vss|z
+ BOTTOM|TOP|VGND|VSS|anode|cathode|core|h_sw[0]|h_sw[10]|h_sw[1]|h_sw[2]|h_sw[3]|h_sw[4]|h_sw[5]|h_sw[6]|h_sw[7]|h_sw[8]|h_sw[9]|l_sw[0]|l_sw[10]|l_sw[1]|l_sw[2]|l_sw[3]|l_sw[4]|l_sw[5]|l_sw[6]|l_sw[7]|l_sw[8]|l_sw[9]|out|pad|padres|vc|vcp|vdd|vddr|vip|vss|z
+ sg13_lv_nmos L=0.13u W=0.74u AS=0.0777p AD=0.1406p PS=0.95u PD=1.12u rfmode=0
M$697
+ BOTTOM|TOP|VGND|VSS|anode|cathode|core|h_sw[0]|h_sw[10]|h_sw[1]|h_sw[2]|h_sw[3]|h_sw[4]|h_sw[5]|h_sw[6]|h_sw[7]|h_sw[8]|h_sw[9]|l_sw[0]|l_sw[10]|l_sw[1]|l_sw[2]|l_sw[3]|l_sw[4]|l_sw[5]|l_sw[6]|l_sw[7]|l_sw[8]|l_sw[9]|out|pad|padres|vc|vcp|vdd|vddr|vip|vss|z
+ \$71331 A|Q$7
+ BOTTOM|TOP|VGND|VSS|anode|cathode|core|h_sw[0]|h_sw[10]|h_sw[1]|h_sw[2]|h_sw[3]|h_sw[4]|h_sw[5]|h_sw[6]|h_sw[7]|h_sw[8]|h_sw[9]|l_sw[0]|l_sw[10]|l_sw[1]|l_sw[2]|l_sw[3]|l_sw[4]|l_sw[5]|l_sw[6]|l_sw[7]|l_sw[8]|l_sw[9]|out|pad|padres|vc|vcp|vdd|vddr|vip|vss|z
+ sg13_lv_nmos L=0.13u W=0.74u AS=0.1406p AD=0.2516p PS=1.12u PD=2.16u rfmode=0
M$698
+ BOTTOM|TOP|VGND|VSS|anode|cathode|core|h_sw[0]|h_sw[10]|h_sw[1]|h_sw[2]|h_sw[3]|h_sw[4]|h_sw[5]|h_sw[6]|h_sw[7]|h_sw[8]|h_sw[9]|l_sw[0]|l_sw[10]|l_sw[1]|l_sw[2]|l_sw[3]|l_sw[4]|l_sw[5]|l_sw[6]|l_sw[7]|l_sw[8]|l_sw[9]|out|pad|padres|vc|vcp|vdd|vddr|vip|vss|z
+ \$71331 \$71332
+ BOTTOM|TOP|VGND|VSS|anode|cathode|core|h_sw[0]|h_sw[10]|h_sw[1]|h_sw[2]|h_sw[3]|h_sw[4]|h_sw[5]|h_sw[6]|h_sw[7]|h_sw[8]|h_sw[9]|l_sw[0]|l_sw[10]|l_sw[1]|l_sw[2]|l_sw[3]|l_sw[4]|l_sw[5]|l_sw[6]|l_sw[7]|l_sw[8]|l_sw[9]|out|pad|padres|vc|vcp|vdd|vddr|vip|vss|z
+ sg13_lv_nmos L=0.13u W=0.55u AS=0.1491p AD=0.187p PS=1.18u PD=1.78u rfmode=0
M$699
+ BOTTOM|TOP|VGND|VSS|anode|cathode|core|h_sw[0]|h_sw[10]|h_sw[1]|h_sw[2]|h_sw[3]|h_sw[4]|h_sw[5]|h_sw[6]|h_sw[7]|h_sw[8]|h_sw[9]|l_sw[0]|l_sw[10]|l_sw[1]|l_sw[2]|l_sw[3]|l_sw[4]|l_sw[5]|l_sw[6]|l_sw[7]|l_sw[8]|l_sw[9]|out|pad|padres|vc|vcp|vdd|vddr|vip|vss|z
+ \$71332 Q_N$16
+ BOTTOM|TOP|VGND|VSS|anode|cathode|core|h_sw[0]|h_sw[10]|h_sw[1]|h_sw[2]|h_sw[3]|h_sw[4]|h_sw[5]|h_sw[6]|h_sw[7]|h_sw[8]|h_sw[9]|l_sw[0]|l_sw[10]|l_sw[1]|l_sw[2]|l_sw[3]|l_sw[4]|l_sw[5]|l_sw[6]|l_sw[7]|l_sw[8]|l_sw[9]|out|pad|padres|vc|vcp|vdd|vddr|vip|vss|z
+ sg13_lv_nmos L=0.13u W=0.74u AS=0.1491p AD=0.2516p PS=1.18u PD=2.16u rfmode=0
M$700
+ BOTTOM|TOP|VGND|VSS|anode|cathode|core|h_sw[0]|h_sw[10]|h_sw[1]|h_sw[2]|h_sw[3]|h_sw[4]|h_sw[5]|h_sw[6]|h_sw[7]|h_sw[8]|h_sw[9]|l_sw[0]|l_sw[10]|l_sw[1]|l_sw[2]|l_sw[3]|l_sw[4]|l_sw[5]|l_sw[6]|l_sw[7]|l_sw[8]|l_sw[9]|out|pad|padres|vc|vcp|vdd|vddr|vip|vss|z
+ \$70958 \$70985
+ BOTTOM|TOP|VGND|VSS|anode|cathode|core|h_sw[0]|h_sw[10]|h_sw[1]|h_sw[2]|h_sw[3]|h_sw[4]|h_sw[5]|h_sw[6]|h_sw[7]|h_sw[8]|h_sw[9]|l_sw[0]|l_sw[10]|l_sw[1]|l_sw[2]|l_sw[3]|l_sw[4]|l_sw[5]|l_sw[6]|l_sw[7]|l_sw[8]|l_sw[9]|out|pad|padres|vc|vcp|vdd|vddr|vip|vss|z
+ sg13_lv_nmos L=0.13u W=0.74u AS=0.1626p AD=0.2516p PS=1.415u PD=2.16u rfmode=0
M$701 \$70957 D|Y$4 \$71308
+ BOTTOM|TOP|VGND|VSS|anode|cathode|core|h_sw[0]|h_sw[10]|h_sw[1]|h_sw[2]|h_sw[3]|h_sw[4]|h_sw[5]|h_sw[6]|h_sw[7]|h_sw[8]|h_sw[9]|l_sw[0]|l_sw[10]|l_sw[1]|l_sw[2]|l_sw[3]|l_sw[4]|l_sw[5]|l_sw[6]|l_sw[7]|l_sw[8]|l_sw[9]|out|pad|padres|vc|vcp|vdd|vddr|vip|vss|z
+ sg13_lv_nmos L=0.13u W=0.42u AS=0.1428p AD=0.0609p PS=1.52u PD=0.71u rfmode=0
M$702
+ BOTTOM|TOP|VGND|VSS|anode|cathode|core|h_sw[0]|h_sw[10]|h_sw[1]|h_sw[2]|h_sw[3]|h_sw[4]|h_sw[5]|h_sw[6]|h_sw[7]|h_sw[8]|h_sw[9]|l_sw[0]|l_sw[10]|l_sw[1]|l_sw[2]|l_sw[3]|l_sw[4]|l_sw[5]|l_sw[6]|l_sw[7]|l_sw[8]|l_sw[9]|out|pad|padres|vc|vcp|vdd|vddr|vip|vss|z
+ RESET_B|Y \$71308
+ BOTTOM|TOP|VGND|VSS|anode|cathode|core|h_sw[0]|h_sw[10]|h_sw[1]|h_sw[2]|h_sw[3]|h_sw[4]|h_sw[5]|h_sw[6]|h_sw[7]|h_sw[8]|h_sw[9]|l_sw[0]|l_sw[10]|l_sw[1]|l_sw[2]|l_sw[3]|l_sw[4]|l_sw[5]|l_sw[6]|l_sw[7]|l_sw[8]|l_sw[9]|out|pad|padres|vc|vcp|vdd|vddr|vip|vss|z
+ sg13_lv_nmos L=0.13u W=0.42u AS=0.1626p AD=0.0609p PS=1.415u PD=0.71u rfmode=0
M$703
+ BOTTOM|TOP|VGND|VSS|anode|cathode|core|h_sw[0]|h_sw[10]|h_sw[1]|h_sw[2]|h_sw[3]|h_sw[4]|h_sw[5]|h_sw[6]|h_sw[7]|h_sw[8]|h_sw[9]|l_sw[0]|l_sw[10]|l_sw[1]|l_sw[2]|l_sw[3]|l_sw[4]|l_sw[5]|l_sw[6]|l_sw[7]|l_sw[8]|l_sw[9]|out|pad|padres|vc|vcp|vdd|vddr|vip|vss|z
+ RESET_B|Y \$71306
+ BOTTOM|TOP|VGND|VSS|anode|cathode|core|h_sw[0]|h_sw[10]|h_sw[1]|h_sw[2]|h_sw[3]|h_sw[4]|h_sw[5]|h_sw[6]|h_sw[7]|h_sw[8]|h_sw[9]|l_sw[0]|l_sw[10]|l_sw[1]|l_sw[2]|l_sw[3]|l_sw[4]|l_sw[5]|l_sw[6]|l_sw[7]|l_sw[8]|l_sw[9]|out|pad|padres|vc|vcp|vdd|vddr|vip|vss|z
+ sg13_lv_nmos L=0.13u W=0.42u AS=0.1701p AD=0.0378p PS=1.65u PD=0.6u rfmode=0
M$704 \$71306 \$70985 \$71160
+ BOTTOM|TOP|VGND|VSS|anode|cathode|core|h_sw[0]|h_sw[10]|h_sw[1]|h_sw[2]|h_sw[3]|h_sw[4]|h_sw[5]|h_sw[6]|h_sw[7]|h_sw[8]|h_sw[9]|l_sw[0]|l_sw[10]|l_sw[1]|l_sw[2]|l_sw[3]|l_sw[4]|l_sw[5]|l_sw[6]|l_sw[7]|l_sw[8]|l_sw[9]|out|pad|padres|vc|vcp|vdd|vddr|vip|vss|z
+ sg13_lv_nmos L=0.13u W=0.42u AS=0.0378p AD=0.1428p PS=0.6u PD=1.52u rfmode=0
M$705 \$71171 \$70987
+ BOTTOM|TOP|VGND|VSS|anode|cathode|core|h_sw[0]|h_sw[10]|h_sw[1]|h_sw[2]|h_sw[3]|h_sw[4]|h_sw[5]|h_sw[6]|h_sw[7]|h_sw[8]|h_sw[9]|l_sw[0]|l_sw[10]|l_sw[1]|l_sw[2]|l_sw[3]|l_sw[4]|l_sw[5]|l_sw[6]|l_sw[7]|l_sw[8]|l_sw[9]|out|pad|padres|vc|vcp|vdd|vddr|vip|vss|z
+ BOTTOM|TOP|VGND|VSS|anode|cathode|core|h_sw[0]|h_sw[10]|h_sw[1]|h_sw[2]|h_sw[3]|h_sw[4]|h_sw[5]|h_sw[6]|h_sw[7]|h_sw[8]|h_sw[9]|l_sw[0]|l_sw[10]|l_sw[1]|l_sw[2]|l_sw[3]|l_sw[4]|l_sw[5]|l_sw[6]|l_sw[7]|l_sw[8]|l_sw[9]|out|pad|padres|vc|vcp|vdd|vddr|vip|vss|z
+ sg13_lv_nmos L=0.13u W=0.42u AS=0.1428p AD=0.0798p PS=1.52u PD=0.8u rfmode=0
M$706
+ BOTTOM|TOP|VGND|VSS|anode|cathode|core|h_sw[0]|h_sw[10]|h_sw[1]|h_sw[2]|h_sw[3]|h_sw[4]|h_sw[5]|h_sw[6]|h_sw[7]|h_sw[8]|h_sw[9]|l_sw[0]|l_sw[10]|l_sw[1]|l_sw[2]|l_sw[3]|l_sw[4]|l_sw[5]|l_sw[6]|l_sw[7]|l_sw[8]|l_sw[9]|out|pad|padres|vc|vcp|vdd|vddr|vip|vss|z
+ RESET_B|Y \$71311
+ BOTTOM|TOP|VGND|VSS|anode|cathode|core|h_sw[0]|h_sw[10]|h_sw[1]|h_sw[2]|h_sw[3]|h_sw[4]|h_sw[5]|h_sw[6]|h_sw[7]|h_sw[8]|h_sw[9]|l_sw[0]|l_sw[10]|l_sw[1]|l_sw[2]|l_sw[3]|l_sw[4]|l_sw[5]|l_sw[6]|l_sw[7]|l_sw[8]|l_sw[9]|out|pad|padres|vc|vcp|vdd|vddr|vip|vss|z
+ sg13_lv_nmos L=0.13u W=0.42u AS=0.0798p AD=0.0378p PS=0.8u PD=0.6u rfmode=0
M$707 \$71311 \$71161 \$70987
+ BOTTOM|TOP|VGND|VSS|anode|cathode|core|h_sw[0]|h_sw[10]|h_sw[1]|h_sw[2]|h_sw[3]|h_sw[4]|h_sw[5]|h_sw[6]|h_sw[7]|h_sw[8]|h_sw[9]|l_sw[0]|l_sw[10]|l_sw[1]|l_sw[2]|l_sw[3]|l_sw[4]|l_sw[5]|l_sw[6]|l_sw[7]|l_sw[8]|l_sw[9]|out|pad|padres|vc|vcp|vdd|vddr|vip|vss|z
+ sg13_lv_nmos L=0.13u W=0.42u AS=0.0378p AD=0.1428p PS=0.6u PD=1.52u rfmode=0
M$708 \$71818 CLK|D|GATE|Q$4 \$71805
+ BOTTOM|TOP|VGND|VSS|anode|cathode|core|h_sw[0]|h_sw[10]|h_sw[1]|h_sw[2]|h_sw[3]|h_sw[4]|h_sw[5]|h_sw[6]|h_sw[7]|h_sw[8]|h_sw[9]|l_sw[0]|l_sw[10]|l_sw[1]|l_sw[2]|l_sw[3]|l_sw[4]|l_sw[5]|l_sw[6]|l_sw[7]|l_sw[8]|l_sw[9]|out|pad|padres|vc|vcp|vdd|vddr|vip|vss|z
+ sg13_lv_nmos L=0.13u W=0.42u AS=0.1428p AD=0.0609p PS=1.52u PD=0.71u rfmode=0
M$709 \$71805 RESET_B|Y$2
+ BOTTOM|TOP|VGND|VSS|anode|cathode|core|h_sw[0]|h_sw[10]|h_sw[1]|h_sw[2]|h_sw[3]|h_sw[4]|h_sw[5]|h_sw[6]|h_sw[7]|h_sw[8]|h_sw[9]|l_sw[0]|l_sw[10]|l_sw[1]|l_sw[2]|l_sw[3]|l_sw[4]|l_sw[5]|l_sw[6]|l_sw[7]|l_sw[8]|l_sw[9]|out|pad|padres|vc|vcp|vdd|vddr|vip|vss|z
+ BOTTOM|TOP|VGND|VSS|anode|cathode|core|h_sw[0]|h_sw[10]|h_sw[1]|h_sw[2]|h_sw[3]|h_sw[4]|h_sw[5]|h_sw[6]|h_sw[7]|h_sw[8]|h_sw[9]|l_sw[0]|l_sw[10]|l_sw[1]|l_sw[2]|l_sw[3]|l_sw[4]|l_sw[5]|l_sw[6]|l_sw[7]|l_sw[8]|l_sw[9]|out|pad|padres|vc|vcp|vdd|vddr|vip|vss|z
+ sg13_lv_nmos L=0.13u W=0.42u AS=0.0609p AD=0.1626p PS=0.71u PD=1.415u rfmode=0
M$710
+ BOTTOM|TOP|VGND|VSS|anode|cathode|core|h_sw[0]|h_sw[10]|h_sw[1]|h_sw[2]|h_sw[3]|h_sw[4]|h_sw[5]|h_sw[6]|h_sw[7]|h_sw[8]|h_sw[9]|l_sw[0]|l_sw[10]|l_sw[1]|l_sw[2]|l_sw[3]|l_sw[4]|l_sw[5]|l_sw[6]|l_sw[7]|l_sw[8]|l_sw[9]|out|pad|padres|vc|vcp|vdd|vddr|vip|vss|z
+ \$71899 \$71334
+ BOTTOM|TOP|VGND|VSS|anode|cathode|core|h_sw[0]|h_sw[10]|h_sw[1]|h_sw[2]|h_sw[3]|h_sw[4]|h_sw[5]|h_sw[6]|h_sw[7]|h_sw[8]|h_sw[9]|l_sw[0]|l_sw[10]|l_sw[1]|l_sw[2]|l_sw[3]|l_sw[4]|l_sw[5]|l_sw[6]|l_sw[7]|l_sw[8]|l_sw[9]|out|pad|padres|vc|vcp|vdd|vddr|vip|vss|z
+ sg13_lv_nmos L=0.13u W=0.74u AS=0.1626p AD=0.2516p PS=1.415u PD=2.16u rfmode=0
M$711 \$70990 \$71163 \$71302
+ BOTTOM|TOP|VGND|VSS|anode|cathode|core|h_sw[0]|h_sw[10]|h_sw[1]|h_sw[2]|h_sw[3]|h_sw[4]|h_sw[5]|h_sw[6]|h_sw[7]|h_sw[8]|h_sw[9]|l_sw[0]|l_sw[10]|l_sw[1]|l_sw[2]|l_sw[3]|l_sw[4]|l_sw[5]|l_sw[6]|l_sw[7]|l_sw[8]|l_sw[9]|out|pad|padres|vc|vcp|vdd|vddr|vip|vss|z
+ sg13_lv_nmos L=0.13u W=0.42u AS=0.1428p AD=0.0378p PS=1.52u PD=0.6u rfmode=0
M$712 \$71302 RESET_B|Y$1
+ BOTTOM|TOP|VGND|VSS|anode|cathode|core|h_sw[0]|h_sw[10]|h_sw[1]|h_sw[2]|h_sw[3]|h_sw[4]|h_sw[5]|h_sw[6]|h_sw[7]|h_sw[8]|h_sw[9]|l_sw[0]|l_sw[10]|l_sw[1]|l_sw[2]|l_sw[3]|l_sw[4]|l_sw[5]|l_sw[6]|l_sw[7]|l_sw[8]|l_sw[9]|out|pad|padres|vc|vcp|vdd|vddr|vip|vss|z
+ BOTTOM|TOP|VGND|VSS|anode|cathode|core|h_sw[0]|h_sw[10]|h_sw[1]|h_sw[2]|h_sw[3]|h_sw[4]|h_sw[5]|h_sw[6]|h_sw[7]|h_sw[8]|h_sw[9]|l_sw[0]|l_sw[10]|l_sw[1]|l_sw[2]|l_sw[3]|l_sw[4]|l_sw[5]|l_sw[6]|l_sw[7]|l_sw[8]|l_sw[9]|out|pad|padres|vc|vcp|vdd|vddr|vip|vss|z
+ sg13_lv_nmos L=0.13u W=0.42u AS=0.0378p AD=0.0798p PS=0.6u PD=0.8u rfmode=0
M$713
+ BOTTOM|TOP|VGND|VSS|anode|cathode|core|h_sw[0]|h_sw[10]|h_sw[1]|h_sw[2]|h_sw[3]|h_sw[4]|h_sw[5]|h_sw[6]|h_sw[7]|h_sw[8]|h_sw[9]|l_sw[0]|l_sw[10]|l_sw[1]|l_sw[2]|l_sw[3]|l_sw[4]|l_sw[5]|l_sw[6]|l_sw[7]|l_sw[8]|l_sw[9]|out|pad|padres|vc|vcp|vdd|vddr|vip|vss|z
+ \$70990 \$71172
+ BOTTOM|TOP|VGND|VSS|anode|cathode|core|h_sw[0]|h_sw[10]|h_sw[1]|h_sw[2]|h_sw[3]|h_sw[4]|h_sw[5]|h_sw[6]|h_sw[7]|h_sw[8]|h_sw[9]|l_sw[0]|l_sw[10]|l_sw[1]|l_sw[2]|l_sw[3]|l_sw[4]|l_sw[5]|l_sw[6]|l_sw[7]|l_sw[8]|l_sw[9]|out|pad|padres|vc|vcp|vdd|vddr|vip|vss|z
+ sg13_lv_nmos L=0.13u W=0.42u AS=0.0798p AD=0.1428p PS=0.8u PD=1.52u rfmode=0
M$714 \$71336 \$71337
+ BOTTOM|TOP|VGND|VSS|anode|cathode|core|h_sw[0]|h_sw[10]|h_sw[1]|h_sw[2]|h_sw[3]|h_sw[4]|h_sw[5]|h_sw[6]|h_sw[7]|h_sw[8]|h_sw[9]|l_sw[0]|l_sw[10]|l_sw[1]|l_sw[2]|l_sw[3]|l_sw[4]|l_sw[5]|l_sw[6]|l_sw[7]|l_sw[8]|l_sw[9]|out|pad|padres|vc|vcp|vdd|vddr|vip|vss|z
+ BOTTOM|TOP|VGND|VSS|anode|cathode|core|h_sw[0]|h_sw[10]|h_sw[1]|h_sw[2]|h_sw[3]|h_sw[4]|h_sw[5]|h_sw[6]|h_sw[7]|h_sw[8]|h_sw[9]|l_sw[0]|l_sw[10]|l_sw[1]|l_sw[2]|l_sw[3]|l_sw[4]|l_sw[5]|l_sw[6]|l_sw[7]|l_sw[8]|l_sw[9]|out|pad|padres|vc|vcp|vdd|vddr|vip|vss|z
+ sg13_lv_nmos L=0.13u W=0.42u AS=0.1428p AD=0.0798p PS=1.52u PD=0.8u rfmode=0
M$715
+ BOTTOM|TOP|VGND|VSS|anode|cathode|core|h_sw[0]|h_sw[10]|h_sw[1]|h_sw[2]|h_sw[3]|h_sw[4]|h_sw[5]|h_sw[6]|h_sw[7]|h_sw[8]|h_sw[9]|l_sw[0]|l_sw[10]|l_sw[1]|l_sw[2]|l_sw[3]|l_sw[4]|l_sw[5]|l_sw[6]|l_sw[7]|l_sw[8]|l_sw[9]|out|pad|padres|vc|vcp|vdd|vddr|vip|vss|z
+ RESET_B|Y$2 \$71806
+ BOTTOM|TOP|VGND|VSS|anode|cathode|core|h_sw[0]|h_sw[10]|h_sw[1]|h_sw[2]|h_sw[3]|h_sw[4]|h_sw[5]|h_sw[6]|h_sw[7]|h_sw[8]|h_sw[9]|l_sw[0]|l_sw[10]|l_sw[1]|l_sw[2]|l_sw[3]|l_sw[4]|l_sw[5]|l_sw[6]|l_sw[7]|l_sw[8]|l_sw[9]|out|pad|padres|vc|vcp|vdd|vddr|vip|vss|z
+ sg13_lv_nmos L=0.13u W=0.42u AS=0.0798p AD=0.0378p PS=0.8u PD=0.6u rfmode=0
M$716 \$71806 \$71819 \$71337
+ BOTTOM|TOP|VGND|VSS|anode|cathode|core|h_sw[0]|h_sw[10]|h_sw[1]|h_sw[2]|h_sw[3]|h_sw[4]|h_sw[5]|h_sw[6]|h_sw[7]|h_sw[8]|h_sw[9]|l_sw[0]|l_sw[10]|l_sw[1]|l_sw[2]|l_sw[3]|l_sw[4]|l_sw[5]|l_sw[6]|l_sw[7]|l_sw[8]|l_sw[9]|out|pad|padres|vc|vcp|vdd|vddr|vip|vss|z
+ sg13_lv_nmos L=0.13u W=0.42u AS=0.0378p AD=0.1428p PS=0.6u PD=1.52u rfmode=0
M$717 \$71165 \$70992 \$71301
+ BOTTOM|TOP|VGND|VSS|anode|cathode|core|h_sw[0]|h_sw[10]|h_sw[1]|h_sw[2]|h_sw[3]|h_sw[4]|h_sw[5]|h_sw[6]|h_sw[7]|h_sw[8]|h_sw[9]|l_sw[0]|l_sw[10]|l_sw[1]|l_sw[2]|l_sw[3]|l_sw[4]|l_sw[5]|l_sw[6]|l_sw[7]|l_sw[8]|l_sw[9]|out|pad|padres|vc|vcp|vdd|vddr|vip|vss|z
+ sg13_lv_nmos L=0.13u W=0.42u AS=0.1428p AD=0.0378p PS=1.52u PD=0.6u rfmode=0
M$718 \$71301 RESET_B|Y$1
+ BOTTOM|TOP|VGND|VSS|anode|cathode|core|h_sw[0]|h_sw[10]|h_sw[1]|h_sw[2]|h_sw[3]|h_sw[4]|h_sw[5]|h_sw[6]|h_sw[7]|h_sw[8]|h_sw[9]|l_sw[0]|l_sw[10]|l_sw[1]|l_sw[2]|l_sw[3]|l_sw[4]|l_sw[5]|l_sw[6]|l_sw[7]|l_sw[8]|l_sw[9]|out|pad|padres|vc|vcp|vdd|vddr|vip|vss|z
+ BOTTOM|TOP|VGND|VSS|anode|cathode|core|h_sw[0]|h_sw[10]|h_sw[1]|h_sw[2]|h_sw[3]|h_sw[4]|h_sw[5]|h_sw[6]|h_sw[7]|h_sw[8]|h_sw[9]|l_sw[0]|l_sw[10]|l_sw[1]|l_sw[2]|l_sw[3]|l_sw[4]|l_sw[5]|l_sw[6]|l_sw[7]|l_sw[8]|l_sw[9]|out|pad|padres|vc|vcp|vdd|vddr|vip|vss|z
+ sg13_lv_nmos L=0.13u W=0.42u AS=0.0378p AD=0.1701p PS=0.6u PD=1.65u rfmode=0
M$719
+ BOTTOM|TOP|VGND|VSS|anode|cathode|core|h_sw[0]|h_sw[10]|h_sw[1]|h_sw[2]|h_sw[3]|h_sw[4]|h_sw[5]|h_sw[6]|h_sw[7]|h_sw[8]|h_sw[9]|l_sw[0]|l_sw[10]|l_sw[1]|l_sw[2]|l_sw[3]|l_sw[4]|l_sw[5]|l_sw[6]|l_sw[7]|l_sw[8]|l_sw[9]|out|pad|padres|vc|vcp|vdd|vddr|vip|vss|z
+ \$71819 Q_N$17
+ BOTTOM|TOP|VGND|VSS|anode|cathode|core|h_sw[0]|h_sw[10]|h_sw[1]|h_sw[2]|h_sw[3]|h_sw[4]|h_sw[5]|h_sw[6]|h_sw[7]|h_sw[8]|h_sw[9]|l_sw[0]|l_sw[10]|l_sw[1]|l_sw[2]|l_sw[3]|l_sw[4]|l_sw[5]|l_sw[6]|l_sw[7]|l_sw[8]|l_sw[9]|out|pad|padres|vc|vcp|vdd|vddr|vip|vss|z
+ sg13_lv_nmos L=0.13u W=0.74u AS=0.2516p AD=0.2849p PS=2.16u PD=2.25u rfmode=0
M$720 \$71339 \$71819
+ BOTTOM|TOP|VGND|VSS|anode|cathode|core|h_sw[0]|h_sw[10]|h_sw[1]|h_sw[2]|h_sw[3]|h_sw[4]|h_sw[5]|h_sw[6]|h_sw[7]|h_sw[8]|h_sw[9]|l_sw[0]|l_sw[10]|l_sw[1]|l_sw[2]|l_sw[3]|l_sw[4]|l_sw[5]|l_sw[6]|l_sw[7]|l_sw[8]|l_sw[9]|out|pad|padres|vc|vcp|vdd|vddr|vip|vss|z
+ BOTTOM|TOP|VGND|VSS|anode|cathode|core|h_sw[0]|h_sw[10]|h_sw[1]|h_sw[2]|h_sw[3]|h_sw[4]|h_sw[5]|h_sw[6]|h_sw[7]|h_sw[8]|h_sw[9]|l_sw[0]|l_sw[10]|l_sw[1]|l_sw[2]|l_sw[3]|l_sw[4]|l_sw[5]|l_sw[6]|l_sw[7]|l_sw[8]|l_sw[9]|out|pad|padres|vc|vcp|vdd|vddr|vip|vss|z
+ sg13_lv_nmos L=0.13u W=0.74u AS=0.2516p AD=0.1406p PS=2.16u PD=1.12u rfmode=0
M$721
+ BOTTOM|TOP|VGND|VSS|anode|cathode|core|h_sw[0]|h_sw[10]|h_sw[1]|h_sw[2]|h_sw[3]|h_sw[4]|h_sw[5]|h_sw[6]|h_sw[7]|h_sw[8]|h_sw[9]|l_sw[0]|l_sw[10]|l_sw[1]|l_sw[2]|l_sw[3]|l_sw[4]|l_sw[5]|l_sw[6]|l_sw[7]|l_sw[8]|l_sw[9]|out|pad|padres|vc|vcp|vdd|vddr|vip|vss|z
+ \$71339 A|CLK|Q
+ BOTTOM|TOP|VGND|VSS|anode|cathode|core|h_sw[0]|h_sw[10]|h_sw[1]|h_sw[2]|h_sw[3]|h_sw[4]|h_sw[5]|h_sw[6]|h_sw[7]|h_sw[8]|h_sw[9]|l_sw[0]|l_sw[10]|l_sw[1]|l_sw[2]|l_sw[3]|l_sw[4]|l_sw[5]|l_sw[6]|l_sw[7]|l_sw[8]|l_sw[9]|out|pad|padres|vc|vcp|vdd|vddr|vip|vss|z
+ sg13_lv_nmos L=0.13u W=0.74u AS=0.1406p AD=0.2516p PS=1.12u PD=2.16u rfmode=0
M$722
+ BOTTOM|TOP|VGND|VSS|anode|cathode|core|h_sw[0]|h_sw[10]|h_sw[1]|h_sw[2]|h_sw[3]|h_sw[4]|h_sw[5]|h_sw[6]|h_sw[7]|h_sw[8]|h_sw[9]|l_sw[0]|l_sw[10]|l_sw[1]|l_sw[2]|l_sw[3]|l_sw[4]|l_sw[5]|l_sw[6]|l_sw[7]|l_sw[8]|l_sw[9]|out|pad|padres|vc|vcp|vdd|vddr|vip|vss|z
+ B|D|Y \$71340
+ BOTTOM|TOP|VGND|VSS|anode|cathode|core|h_sw[0]|h_sw[10]|h_sw[1]|h_sw[2]|h_sw[3]|h_sw[4]|h_sw[5]|h_sw[6]|h_sw[7]|h_sw[8]|h_sw[9]|l_sw[0]|l_sw[10]|l_sw[1]|l_sw[2]|l_sw[3]|l_sw[4]|l_sw[5]|l_sw[6]|l_sw[7]|l_sw[8]|l_sw[9]|out|pad|padres|vc|vcp|vdd|vddr|vip|vss|z
+ sg13_lv_nmos L=0.13u W=0.55u AS=0.187p AD=0.1045p PS=1.78u PD=0.93u rfmode=0
M$723 \$71340 A|B|X
+ BOTTOM|TOP|VGND|VSS|anode|cathode|core|h_sw[0]|h_sw[10]|h_sw[1]|h_sw[2]|h_sw[3]|h_sw[4]|h_sw[5]|h_sw[6]|h_sw[7]|h_sw[8]|h_sw[9]|l_sw[0]|l_sw[10]|l_sw[1]|l_sw[2]|l_sw[3]|l_sw[4]|l_sw[5]|l_sw[6]|l_sw[7]|l_sw[8]|l_sw[9]|out|pad|padres|vc|vcp|vdd|vddr|vip|vss|z
+ BOTTOM|TOP|VGND|VSS|anode|cathode|core|h_sw[0]|h_sw[10]|h_sw[1]|h_sw[2]|h_sw[3]|h_sw[4]|h_sw[5]|h_sw[6]|h_sw[7]|h_sw[8]|h_sw[9]|l_sw[0]|l_sw[10]|l_sw[1]|l_sw[2]|l_sw[3]|l_sw[4]|l_sw[5]|l_sw[6]|l_sw[7]|l_sw[8]|l_sw[9]|out|pad|padres|vc|vcp|vdd|vddr|vip|vss|z
+ sg13_lv_nmos L=0.13u W=0.55u AS=0.1045p AD=0.1469p PS=0.93u PD=1.155u rfmode=0
M$724
+ BOTTOM|TOP|VGND|VSS|anode|cathode|core|h_sw[0]|h_sw[10]|h_sw[1]|h_sw[2]|h_sw[3]|h_sw[4]|h_sw[5]|h_sw[6]|h_sw[7]|h_sw[8]|h_sw[9]|l_sw[0]|l_sw[10]|l_sw[1]|l_sw[2]|l_sw[3]|l_sw[4]|l_sw[5]|l_sw[6]|l_sw[7]|l_sw[8]|l_sw[9]|out|pad|padres|vc|vcp|vdd|vddr|vip|vss|z
+ \$71340 A|X$41
+ BOTTOM|TOP|VGND|VSS|anode|cathode|core|h_sw[0]|h_sw[10]|h_sw[1]|h_sw[2]|h_sw[3]|h_sw[4]|h_sw[5]|h_sw[6]|h_sw[7]|h_sw[8]|h_sw[9]|l_sw[0]|l_sw[10]|l_sw[1]|l_sw[2]|l_sw[3]|l_sw[4]|l_sw[5]|l_sw[6]|l_sw[7]|l_sw[8]|l_sw[9]|out|pad|padres|vc|vcp|vdd|vddr|vip|vss|z
+ sg13_lv_nmos L=0.13u W=0.74u AS=0.1469p AD=0.2516p PS=1.155u PD=2.16u rfmode=0
M$725
+ BOTTOM|TOP|VGND|VSS|anode|cathode|core|h_sw[0]|h_sw[10]|h_sw[1]|h_sw[2]|h_sw[3]|h_sw[4]|h_sw[5]|h_sw[6]|h_sw[7]|h_sw[8]|h_sw[9]|l_sw[0]|l_sw[10]|l_sw[1]|l_sw[2]|l_sw[3]|l_sw[4]|l_sw[5]|l_sw[6]|l_sw[7]|l_sw[8]|l_sw[9]|out|pad|padres|vc|vcp|vdd|vddr|vip|vss|z
+ A|anode|cathode|ck|cks|core|pad|padres A|Y$14
+ BOTTOM|TOP|VGND|VSS|anode|cathode|core|h_sw[0]|h_sw[10]|h_sw[1]|h_sw[2]|h_sw[3]|h_sw[4]|h_sw[5]|h_sw[6]|h_sw[7]|h_sw[8]|h_sw[9]|l_sw[0]|l_sw[10]|l_sw[1]|l_sw[2]|l_sw[3]|l_sw[4]|l_sw[5]|l_sw[6]|l_sw[7]|l_sw[8]|l_sw[9]|out|pad|padres|vc|vcp|vdd|vddr|vip|vss|z
+ sg13_lv_nmos L=0.13u W=0.74u AS=0.2516p AD=0.2516p PS=2.16u PD=2.16u rfmode=0
M$726 A|Y$16 A|Y$15 \$71887
+ BOTTOM|TOP|VGND|VSS|anode|cathode|core|h_sw[0]|h_sw[10]|h_sw[1]|h_sw[2]|h_sw[3]|h_sw[4]|h_sw[5]|h_sw[6]|h_sw[7]|h_sw[8]|h_sw[9]|l_sw[0]|l_sw[10]|l_sw[1]|l_sw[2]|l_sw[3]|l_sw[4]|l_sw[5]|l_sw[6]|l_sw[7]|l_sw[8]|l_sw[9]|out|pad|padres|vc|vcp|vdd|vddr|vip|vss|z
+ sg13_lv_nmos L=0.13u W=0.74u AS=0.2516p AD=0.1406p PS=2.16u PD=1.12u rfmode=0
M$727 \$71887 B|Y$1
+ BOTTOM|TOP|VGND|VSS|anode|cathode|core|h_sw[0]|h_sw[10]|h_sw[1]|h_sw[2]|h_sw[3]|h_sw[4]|h_sw[5]|h_sw[6]|h_sw[7]|h_sw[8]|h_sw[9]|l_sw[0]|l_sw[10]|l_sw[1]|l_sw[2]|l_sw[3]|l_sw[4]|l_sw[5]|l_sw[6]|l_sw[7]|l_sw[8]|l_sw[9]|out|pad|padres|vc|vcp|vdd|vddr|vip|vss|z
+ BOTTOM|TOP|VGND|VSS|anode|cathode|core|h_sw[0]|h_sw[10]|h_sw[1]|h_sw[2]|h_sw[3]|h_sw[4]|h_sw[5]|h_sw[6]|h_sw[7]|h_sw[8]|h_sw[9]|l_sw[0]|l_sw[10]|l_sw[1]|l_sw[2]|l_sw[3]|l_sw[4]|l_sw[5]|l_sw[6]|l_sw[7]|l_sw[8]|l_sw[9]|out|pad|padres|vc|vcp|vdd|vddr|vip|vss|z
+ sg13_lv_nmos L=0.13u W=0.74u AS=0.1406p AD=0.2516p PS=1.12u PD=2.16u rfmode=0
M$728
+ BOTTOM|TOP|VGND|VSS|anode|cathode|core|h_sw[0]|h_sw[10]|h_sw[1]|h_sw[2]|h_sw[3]|h_sw[4]|h_sw[5]|h_sw[6]|h_sw[7]|h_sw[8]|h_sw[9]|l_sw[0]|l_sw[10]|l_sw[1]|l_sw[2]|l_sw[3]|l_sw[4]|l_sw[5]|l_sw[6]|l_sw[7]|l_sw[8]|l_sw[9]|out|pad|padres|vc|vcp|vdd|vddr|vip|vss|z
+ D|Q_N$3 \$71808
+ BOTTOM|TOP|VGND|VSS|anode|cathode|core|h_sw[0]|h_sw[10]|h_sw[1]|h_sw[2]|h_sw[3]|h_sw[4]|h_sw[5]|h_sw[6]|h_sw[7]|h_sw[8]|h_sw[9]|l_sw[0]|l_sw[10]|l_sw[1]|l_sw[2]|l_sw[3]|l_sw[4]|l_sw[5]|l_sw[6]|l_sw[7]|l_sw[8]|l_sw[9]|out|pad|padres|vc|vcp|vdd|vddr|vip|vss|z
+ sg13_lv_nmos L=0.13u W=0.55u AS=0.15055p AD=0.187p PS=1.17u PD=1.78u rfmode=0
M$729
+ BOTTOM|TOP|VGND|VSS|anode|cathode|core|h_sw[0]|h_sw[10]|h_sw[1]|h_sw[2]|h_sw[3]|h_sw[4]|h_sw[5]|h_sw[6]|h_sw[7]|h_sw[8]|h_sw[9]|l_sw[0]|l_sw[10]|l_sw[1]|l_sw[2]|l_sw[3]|l_sw[4]|l_sw[5]|l_sw[6]|l_sw[7]|l_sw[8]|l_sw[9]|out|pad|padres|vc|vcp|vdd|vddr|vip|vss|z
+ CLK|D|GATE|Q$2 \$71313
+ BOTTOM|TOP|VGND|VSS|anode|cathode|core|h_sw[0]|h_sw[10]|h_sw[1]|h_sw[2]|h_sw[3]|h_sw[4]|h_sw[5]|h_sw[6]|h_sw[7]|h_sw[8]|h_sw[9]|l_sw[0]|l_sw[10]|l_sw[1]|l_sw[2]|l_sw[3]|l_sw[4]|l_sw[5]|l_sw[6]|l_sw[7]|l_sw[8]|l_sw[9]|out|pad|padres|vc|vcp|vdd|vddr|vip|vss|z
+ sg13_lv_nmos L=0.13u W=0.74u AS=0.15055p AD=0.2516p PS=1.17u PD=2.16u rfmode=0
M$730
+ BOTTOM|TOP|VGND|VSS|anode|cathode|core|h_sw[0]|h_sw[10]|h_sw[1]|h_sw[2]|h_sw[3]|h_sw[4]|h_sw[5]|h_sw[6]|h_sw[7]|h_sw[8]|h_sw[9]|l_sw[0]|l_sw[10]|l_sw[1]|l_sw[2]|l_sw[3]|l_sw[4]|l_sw[5]|l_sw[6]|l_sw[7]|l_sw[8]|l_sw[9]|out|pad|padres|vc|vcp|vdd|vddr|vip|vss|z
+ RESET_B|Y$2 \$71883
+ BOTTOM|TOP|VGND|VSS|anode|cathode|core|h_sw[0]|h_sw[10]|h_sw[1]|h_sw[2]|h_sw[3]|h_sw[4]|h_sw[5]|h_sw[6]|h_sw[7]|h_sw[8]|h_sw[9]|l_sw[0]|l_sw[10]|l_sw[1]|l_sw[2]|l_sw[3]|l_sw[4]|l_sw[5]|l_sw[6]|l_sw[7]|l_sw[8]|l_sw[9]|out|pad|padres|vc|vcp|vdd|vddr|vip|vss|z
+ sg13_lv_nmos L=0.13u W=0.42u AS=0.1701p AD=0.0378p PS=1.65u PD=0.6u rfmode=0
M$731 \$71883 \$71318 \$71789
+ BOTTOM|TOP|VGND|VSS|anode|cathode|core|h_sw[0]|h_sw[10]|h_sw[1]|h_sw[2]|h_sw[3]|h_sw[4]|h_sw[5]|h_sw[6]|h_sw[7]|h_sw[8]|h_sw[9]|l_sw[0]|l_sw[10]|l_sw[1]|l_sw[2]|l_sw[3]|l_sw[4]|l_sw[5]|l_sw[6]|l_sw[7]|l_sw[8]|l_sw[9]|out|pad|padres|vc|vcp|vdd|vddr|vip|vss|z
+ sg13_lv_nmos L=0.13u W=0.42u AS=0.0378p AD=0.1428p PS=0.6u PD=1.52u rfmode=0
M$732
+ BOTTOM|TOP|VGND|VSS|anode|cathode|core|h_sw[0]|h_sw[10]|h_sw[1]|h_sw[2]|h_sw[3]|h_sw[4]|h_sw[5]|h_sw[6]|h_sw[7]|h_sw[8]|h_sw[9]|l_sw[0]|l_sw[10]|l_sw[1]|l_sw[2]|l_sw[3]|l_sw[4]|l_sw[5]|l_sw[6]|l_sw[7]|l_sw[8]|l_sw[9]|out|pad|padres|vc|vcp|vdd|vddr|vip|vss|z
+ \$71319 \$71790
+ BOTTOM|TOP|VGND|VSS|anode|cathode|core|h_sw[0]|h_sw[10]|h_sw[1]|h_sw[2]|h_sw[3]|h_sw[4]|h_sw[5]|h_sw[6]|h_sw[7]|h_sw[8]|h_sw[9]|l_sw[0]|l_sw[10]|l_sw[1]|l_sw[2]|l_sw[3]|l_sw[4]|l_sw[5]|l_sw[6]|l_sw[7]|l_sw[8]|l_sw[9]|out|pad|padres|vc|vcp|vdd|vddr|vip|vss|z
+ sg13_lv_nmos L=0.13u W=0.74u AS=0.317325p AD=0.2516p PS=1.805u PD=2.16u
+ rfmode=0
M$733
+ BOTTOM|TOP|VGND|VSS|anode|cathode|core|h_sw[0]|h_sw[10]|h_sw[1]|h_sw[2]|h_sw[3]|h_sw[4]|h_sw[5]|h_sw[6]|h_sw[7]|h_sw[8]|h_sw[9]|l_sw[0]|l_sw[10]|l_sw[1]|l_sw[2]|l_sw[3]|l_sw[4]|l_sw[5]|l_sw[6]|l_sw[7]|l_sw[8]|l_sw[9]|out|pad|padres|vc|vcp|vdd|vddr|vip|vss|z
+ A|CLK|X \$71319
+ BOTTOM|TOP|VGND|VSS|anode|cathode|core|h_sw[0]|h_sw[10]|h_sw[1]|h_sw[2]|h_sw[3]|h_sw[4]|h_sw[5]|h_sw[6]|h_sw[7]|h_sw[8]|h_sw[9]|l_sw[0]|l_sw[10]|l_sw[1]|l_sw[2]|l_sw[3]|l_sw[4]|l_sw[5]|l_sw[6]|l_sw[7]|l_sw[8]|l_sw[9]|out|pad|padres|vc|vcp|vdd|vddr|vip|vss|z
+ sg13_lv_nmos L=0.13u W=0.74u AS=0.317325p AD=0.2516p PS=1.805u PD=2.16u
+ rfmode=0
M$734 \$71811 \$71319 \$71320
+ BOTTOM|TOP|VGND|VSS|anode|cathode|core|h_sw[0]|h_sw[10]|h_sw[1]|h_sw[2]|h_sw[3]|h_sw[4]|h_sw[5]|h_sw[6]|h_sw[7]|h_sw[8]|h_sw[9]|l_sw[0]|l_sw[10]|l_sw[1]|l_sw[2]|l_sw[3]|l_sw[4]|l_sw[5]|l_sw[6]|l_sw[7]|l_sw[8]|l_sw[9]|out|pad|padres|vc|vcp|vdd|vddr|vip|vss|z
+ sg13_lv_nmos L=0.13u W=0.42u AS=0.12665p AD=0.1428p PS=1.145u PD=1.52u
+ rfmode=0
M$735 \$71318 \$71790 \$71811
+ BOTTOM|TOP|VGND|VSS|anode|cathode|core|h_sw[0]|h_sw[10]|h_sw[1]|h_sw[2]|h_sw[3]|h_sw[4]|h_sw[5]|h_sw[6]|h_sw[7]|h_sw[8]|h_sw[9]|l_sw[0]|l_sw[10]|l_sw[1]|l_sw[2]|l_sw[3]|l_sw[4]|l_sw[5]|l_sw[6]|l_sw[7]|l_sw[8]|l_sw[9]|out|pad|padres|vc|vcp|vdd|vddr|vip|vss|z
+ sg13_lv_nmos L=0.13u W=0.74u AS=0.3473p AD=0.12665p PS=2.71u PD=1.145u
+ rfmode=0
M$736
+ BOTTOM|TOP|VGND|VSS|anode|cathode|core|h_sw[0]|h_sw[10]|h_sw[1]|h_sw[2]|h_sw[3]|h_sw[4]|h_sw[5]|h_sw[6]|h_sw[7]|h_sw[8]|h_sw[9]|l_sw[0]|l_sw[10]|l_sw[1]|l_sw[2]|l_sw[3]|l_sw[4]|l_sw[5]|l_sw[6]|l_sw[7]|l_sw[8]|l_sw[9]|out|pad|padres|vc|vcp|vdd|vddr|vip|vss|z
+ RESET_B|Y$2 \$71882
+ BOTTOM|TOP|VGND|VSS|anode|cathode|core|h_sw[0]|h_sw[10]|h_sw[1]|h_sw[2]|h_sw[3]|h_sw[4]|h_sw[5]|h_sw[6]|h_sw[7]|h_sw[8]|h_sw[9]|l_sw[0]|l_sw[10]|l_sw[1]|l_sw[2]|l_sw[3]|l_sw[4]|l_sw[5]|l_sw[6]|l_sw[7]|l_sw[8]|l_sw[9]|out|pad|padres|vc|vcp|vdd|vddr|vip|vss|z
+ sg13_lv_nmos L=0.13u W=0.42u AS=0.1701p AD=0.0378p PS=1.65u PD=0.6u rfmode=0
M$737 \$71882 \$71324 \$71791
+ BOTTOM|TOP|VGND|VSS|anode|cathode|core|h_sw[0]|h_sw[10]|h_sw[1]|h_sw[2]|h_sw[3]|h_sw[4]|h_sw[5]|h_sw[6]|h_sw[7]|h_sw[8]|h_sw[9]|l_sw[0]|l_sw[10]|l_sw[1]|l_sw[2]|l_sw[3]|l_sw[4]|l_sw[5]|l_sw[6]|l_sw[7]|l_sw[8]|l_sw[9]|out|pad|padres|vc|vcp|vdd|vddr|vip|vss|z
+ sg13_lv_nmos L=0.13u W=0.42u AS=0.0378p AD=0.1428p PS=0.6u PD=1.52u rfmode=0
M$738
+ BOTTOM|TOP|VGND|VSS|anode|cathode|core|h_sw[0]|h_sw[10]|h_sw[1]|h_sw[2]|h_sw[3]|h_sw[4]|h_sw[5]|h_sw[6]|h_sw[7]|h_sw[8]|h_sw[9]|l_sw[0]|l_sw[10]|l_sw[1]|l_sw[2]|l_sw[3]|l_sw[4]|l_sw[5]|l_sw[6]|l_sw[7]|l_sw[8]|l_sw[9]|out|pad|padres|vc|vcp|vdd|vddr|vip|vss|z
+ \$71325 \$71792
+ BOTTOM|TOP|VGND|VSS|anode|cathode|core|h_sw[0]|h_sw[10]|h_sw[1]|h_sw[2]|h_sw[3]|h_sw[4]|h_sw[5]|h_sw[6]|h_sw[7]|h_sw[8]|h_sw[9]|l_sw[0]|l_sw[10]|l_sw[1]|l_sw[2]|l_sw[3]|l_sw[4]|l_sw[5]|l_sw[6]|l_sw[7]|l_sw[8]|l_sw[9]|out|pad|padres|vc|vcp|vdd|vddr|vip|vss|z
+ sg13_lv_nmos L=0.13u W=0.74u AS=0.317325p AD=0.2516p PS=1.805u PD=2.16u
+ rfmode=0
M$739
+ BOTTOM|TOP|VGND|VSS|anode|cathode|core|h_sw[0]|h_sw[10]|h_sw[1]|h_sw[2]|h_sw[3]|h_sw[4]|h_sw[5]|h_sw[6]|h_sw[7]|h_sw[8]|h_sw[9]|l_sw[0]|l_sw[10]|l_sw[1]|l_sw[2]|l_sw[3]|l_sw[4]|l_sw[5]|l_sw[6]|l_sw[7]|l_sw[8]|l_sw[9]|out|pad|padres|vc|vcp|vdd|vddr|vip|vss|z
+ A|CLK|X \$71325
+ BOTTOM|TOP|VGND|VSS|anode|cathode|core|h_sw[0]|h_sw[10]|h_sw[1]|h_sw[2]|h_sw[3]|h_sw[4]|h_sw[5]|h_sw[6]|h_sw[7]|h_sw[8]|h_sw[9]|l_sw[0]|l_sw[10]|l_sw[1]|l_sw[2]|l_sw[3]|l_sw[4]|l_sw[5]|l_sw[6]|l_sw[7]|l_sw[8]|l_sw[9]|out|pad|padres|vc|vcp|vdd|vddr|vip|vss|z
+ sg13_lv_nmos L=0.13u W=0.74u AS=0.317325p AD=0.2516p PS=1.805u PD=2.16u
+ rfmode=0
M$740 \$71813 \$71325 \$71326
+ BOTTOM|TOP|VGND|VSS|anode|cathode|core|h_sw[0]|h_sw[10]|h_sw[1]|h_sw[2]|h_sw[3]|h_sw[4]|h_sw[5]|h_sw[6]|h_sw[7]|h_sw[8]|h_sw[9]|l_sw[0]|l_sw[10]|l_sw[1]|l_sw[2]|l_sw[3]|l_sw[4]|l_sw[5]|l_sw[6]|l_sw[7]|l_sw[8]|l_sw[9]|out|pad|padres|vc|vcp|vdd|vddr|vip|vss|z
+ sg13_lv_nmos L=0.13u W=0.42u AS=0.12665p AD=0.1428p PS=1.145u PD=1.52u
+ rfmode=0
M$741 \$71324 \$71792 \$71813
+ BOTTOM|TOP|VGND|VSS|anode|cathode|core|h_sw[0]|h_sw[10]|h_sw[1]|h_sw[2]|h_sw[3]|h_sw[4]|h_sw[5]|h_sw[6]|h_sw[7]|h_sw[8]|h_sw[9]|l_sw[0]|l_sw[10]|l_sw[1]|l_sw[2]|l_sw[3]|l_sw[4]|l_sw[5]|l_sw[6]|l_sw[7]|l_sw[8]|l_sw[9]|out|pad|padres|vc|vcp|vdd|vddr|vip|vss|z
+ sg13_lv_nmos L=0.13u W=0.74u AS=0.3473p AD=0.12665p PS=2.71u PD=1.145u
+ rfmode=0
M$742
+ BOTTOM|TOP|VGND|VSS|anode|cathode|core|h_sw[0]|h_sw[10]|h_sw[1]|h_sw[2]|h_sw[3]|h_sw[4]|h_sw[5]|h_sw[6]|h_sw[7]|h_sw[8]|h_sw[9]|l_sw[0]|l_sw[10]|l_sw[1]|l_sw[2]|l_sw[3]|l_sw[4]|l_sw[5]|l_sw[6]|l_sw[7]|l_sw[8]|l_sw[9]|out|pad|padres|vc|vcp|vdd|vddr|vip|vss|z
+ D|Q_N$2 \$71814
+ BOTTOM|TOP|VGND|VSS|anode|cathode|core|h_sw[0]|h_sw[10]|h_sw[1]|h_sw[2]|h_sw[3]|h_sw[4]|h_sw[5]|h_sw[6]|h_sw[7]|h_sw[8]|h_sw[9]|l_sw[0]|l_sw[10]|l_sw[1]|l_sw[2]|l_sw[3]|l_sw[4]|l_sw[5]|l_sw[6]|l_sw[7]|l_sw[8]|l_sw[9]|out|pad|padres|vc|vcp|vdd|vddr|vip|vss|z
+ sg13_lv_nmos L=0.13u W=0.55u AS=0.15055p AD=0.187p PS=1.17u PD=1.78u rfmode=0
M$743
+ BOTTOM|TOP|VGND|VSS|anode|cathode|core|h_sw[0]|h_sw[10]|h_sw[1]|h_sw[2]|h_sw[3]|h_sw[4]|h_sw[5]|h_sw[6]|h_sw[7]|h_sw[8]|h_sw[9]|l_sw[0]|l_sw[10]|l_sw[1]|l_sw[2]|l_sw[3]|l_sw[4]|l_sw[5]|l_sw[6]|l_sw[7]|l_sw[8]|l_sw[9]|out|pad|padres|vc|vcp|vdd|vddr|vip|vss|z
+ CLK|D|GATE|Q$3 \$71330
+ BOTTOM|TOP|VGND|VSS|anode|cathode|core|h_sw[0]|h_sw[10]|h_sw[1]|h_sw[2]|h_sw[3]|h_sw[4]|h_sw[5]|h_sw[6]|h_sw[7]|h_sw[8]|h_sw[9]|l_sw[0]|l_sw[10]|l_sw[1]|l_sw[2]|l_sw[3]|l_sw[4]|l_sw[5]|l_sw[6]|l_sw[7]|l_sw[8]|l_sw[9]|out|pad|padres|vc|vcp|vdd|vddr|vip|vss|z
+ sg13_lv_nmos L=0.13u W=0.74u AS=0.15055p AD=0.2516p PS=1.17u PD=2.16u rfmode=0
M$744
+ BOTTOM|TOP|VGND|VSS|anode|cathode|core|h_sw[0]|h_sw[10]|h_sw[1]|h_sw[2]|h_sw[3]|h_sw[4]|h_sw[5]|h_sw[6]|h_sw[7]|h_sw[8]|h_sw[9]|l_sw[0]|l_sw[10]|l_sw[1]|l_sw[2]|l_sw[3]|l_sw[4]|l_sw[5]|l_sw[6]|l_sw[7]|l_sw[8]|l_sw[9]|out|pad|padres|vc|vcp|vdd|vddr|vip|vss|z
+ A_N|D|Q \$71794
+ BOTTOM|TOP|VGND|VSS|anode|cathode|core|h_sw[0]|h_sw[10]|h_sw[1]|h_sw[2]|h_sw[3]|h_sw[4]|h_sw[5]|h_sw[6]|h_sw[7]|h_sw[8]|h_sw[9]|l_sw[0]|l_sw[10]|l_sw[1]|l_sw[2]|l_sw[3]|l_sw[4]|l_sw[5]|l_sw[6]|l_sw[7]|l_sw[8]|l_sw[9]|out|pad|padres|vc|vcp|vdd|vddr|vip|vss|z
+ sg13_lv_nmos L=0.13u W=0.55u AS=0.14505p AD=0.187p PS=1.15u PD=1.78u rfmode=0
M$745
+ BOTTOM|TOP|VGND|VSS|anode|cathode|core|h_sw[0]|h_sw[10]|h_sw[1]|h_sw[2]|h_sw[3]|h_sw[4]|h_sw[5]|h_sw[6]|h_sw[7]|h_sw[8]|h_sw[9]|l_sw[0]|l_sw[10]|l_sw[1]|l_sw[2]|l_sw[3]|l_sw[4]|l_sw[5]|l_sw[6]|l_sw[7]|l_sw[8]|l_sw[9]|out|pad|padres|vc|vcp|vdd|vddr|vip|vss|z
+ A2|B|B1|C1|Y \$71878
+ BOTTOM|TOP|VGND|VSS|anode|cathode|core|h_sw[0]|h_sw[10]|h_sw[1]|h_sw[2]|h_sw[3]|h_sw[4]|h_sw[5]|h_sw[6]|h_sw[7]|h_sw[8]|h_sw[9]|l_sw[0]|l_sw[10]|l_sw[1]|l_sw[2]|l_sw[3]|l_sw[4]|l_sw[5]|l_sw[6]|l_sw[7]|l_sw[8]|l_sw[9]|out|pad|padres|vc|vcp|vdd|vddr|vip|vss|z
+ sg13_lv_nmos L=0.13u W=0.74u AS=0.14505p AD=0.1406p PS=1.15u PD=1.12u rfmode=0
M$746 \$71878 \$71794 B|Y
+ BOTTOM|TOP|VGND|VSS|anode|cathode|core|h_sw[0]|h_sw[10]|h_sw[1]|h_sw[2]|h_sw[3]|h_sw[4]|h_sw[5]|h_sw[6]|h_sw[7]|h_sw[8]|h_sw[9]|l_sw[0]|l_sw[10]|l_sw[1]|l_sw[2]|l_sw[3]|l_sw[4]|l_sw[5]|l_sw[6]|l_sw[7]|l_sw[8]|l_sw[9]|out|pad|padres|vc|vcp|vdd|vddr|vip|vss|z
+ sg13_lv_nmos L=0.13u W=0.74u AS=0.1406p AD=0.333p PS=1.12u PD=2.38u rfmode=0
M$747
+ BOTTOM|TOP|VGND|VSS|anode|cathode|core|h_sw[0]|h_sw[10]|h_sw[1]|h_sw[2]|h_sw[3]|h_sw[4]|h_sw[5]|h_sw[6]|h_sw[7]|h_sw[8]|h_sw[9]|l_sw[0]|l_sw[10]|l_sw[1]|l_sw[2]|l_sw[3]|l_sw[4]|l_sw[5]|l_sw[6]|l_sw[7]|l_sw[8]|l_sw[9]|out|pad|padres|vc|vcp|vdd|vddr|vip|vss|z
+ A2|D|Q \$71874
+ BOTTOM|TOP|VGND|VSS|anode|cathode|core|h_sw[0]|h_sw[10]|h_sw[1]|h_sw[2]|h_sw[3]|h_sw[4]|h_sw[5]|h_sw[6]|h_sw[7]|h_sw[8]|h_sw[9]|l_sw[0]|l_sw[10]|l_sw[1]|l_sw[2]|l_sw[3]|l_sw[4]|l_sw[5]|l_sw[6]|l_sw[7]|l_sw[8]|l_sw[9]|out|pad|padres|vc|vcp|vdd|vddr|vip|vss|z
+ sg13_lv_nmos L=0.13u W=0.74u AS=0.2516p AD=0.1406p PS=2.16u PD=1.12u rfmode=0
M$748 \$71874 A1|Y$3 A1|Y$1
+ BOTTOM|TOP|VGND|VSS|anode|cathode|core|h_sw[0]|h_sw[10]|h_sw[1]|h_sw[2]|h_sw[3]|h_sw[4]|h_sw[5]|h_sw[6]|h_sw[7]|h_sw[8]|h_sw[9]|l_sw[0]|l_sw[10]|l_sw[1]|l_sw[2]|l_sw[3]|l_sw[4]|l_sw[5]|l_sw[6]|l_sw[7]|l_sw[8]|l_sw[9]|out|pad|padres|vc|vcp|vdd|vddr|vip|vss|z
+ sg13_lv_nmos L=0.13u W=0.74u AS=0.1406p AD=0.2516p PS=1.12u PD=2.16u rfmode=0
M$749 A1|Y$1 B1|X \$71875
+ BOTTOM|TOP|VGND|VSS|anode|cathode|core|h_sw[0]|h_sw[10]|h_sw[1]|h_sw[2]|h_sw[3]|h_sw[4]|h_sw[5]|h_sw[6]|h_sw[7]|h_sw[8]|h_sw[9]|l_sw[0]|l_sw[10]|l_sw[1]|l_sw[2]|l_sw[3]|l_sw[4]|l_sw[5]|l_sw[6]|l_sw[7]|l_sw[8]|l_sw[9]|out|pad|padres|vc|vcp|vdd|vddr|vip|vss|z
+ sg13_lv_nmos L=0.13u W=0.74u AS=0.2516p AD=0.1406p PS=2.16u PD=1.12u rfmode=0
M$750 \$71875 B2|Y$1
+ BOTTOM|TOP|VGND|VSS|anode|cathode|core|h_sw[0]|h_sw[10]|h_sw[1]|h_sw[2]|h_sw[3]|h_sw[4]|h_sw[5]|h_sw[6]|h_sw[7]|h_sw[8]|h_sw[9]|l_sw[0]|l_sw[10]|l_sw[1]|l_sw[2]|l_sw[3]|l_sw[4]|l_sw[5]|l_sw[6]|l_sw[7]|l_sw[8]|l_sw[9]|out|pad|padres|vc|vcp|vdd|vddr|vip|vss|z
+ BOTTOM|TOP|VGND|VSS|anode|cathode|core|h_sw[0]|h_sw[10]|h_sw[1]|h_sw[2]|h_sw[3]|h_sw[4]|h_sw[5]|h_sw[6]|h_sw[7]|h_sw[8]|h_sw[9]|l_sw[0]|l_sw[10]|l_sw[1]|l_sw[2]|l_sw[3]|l_sw[4]|l_sw[5]|l_sw[6]|l_sw[7]|l_sw[8]|l_sw[9]|out|pad|padres|vc|vcp|vdd|vddr|vip|vss|z
+ sg13_lv_nmos L=0.13u W=0.74u AS=0.1406p AD=0.1406p PS=1.12u PD=1.12u rfmode=0
M$751
+ BOTTOM|TOP|VGND|VSS|anode|cathode|core|h_sw[0]|h_sw[10]|h_sw[1]|h_sw[2]|h_sw[3]|h_sw[4]|h_sw[5]|h_sw[6]|h_sw[7]|h_sw[8]|h_sw[9]|l_sw[0]|l_sw[10]|l_sw[1]|l_sw[2]|l_sw[3]|l_sw[4]|l_sw[5]|l_sw[6]|l_sw[7]|l_sw[8]|l_sw[9]|out|pad|padres|vc|vcp|vdd|vddr|vip|vss|z
+ A2|B|B1|C1|Y A1|Y$1
+ BOTTOM|TOP|VGND|VSS|anode|cathode|core|h_sw[0]|h_sw[10]|h_sw[1]|h_sw[2]|h_sw[3]|h_sw[4]|h_sw[5]|h_sw[6]|h_sw[7]|h_sw[8]|h_sw[9]|l_sw[0]|l_sw[10]|l_sw[1]|l_sw[2]|l_sw[3]|l_sw[4]|l_sw[5]|l_sw[6]|l_sw[7]|l_sw[8]|l_sw[9]|out|pad|padres|vc|vcp|vdd|vddr|vip|vss|z
+ sg13_lv_nmos L=0.13u W=0.74u AS=0.1406p AD=0.2516p PS=1.12u PD=2.16u rfmode=0
M$752
+ BOTTOM|TOP|VGND|VSS|anode|cathode|core|h_sw[0]|h_sw[10]|h_sw[1]|h_sw[2]|h_sw[3]|h_sw[4]|h_sw[5]|h_sw[6]|h_sw[7]|h_sw[8]|h_sw[9]|l_sw[0]|l_sw[10]|l_sw[1]|l_sw[2]|l_sw[3]|l_sw[4]|l_sw[5]|l_sw[6]|l_sw[7]|l_sw[8]|l_sw[9]|out|pad|padres|vc|vcp|vdd|vddr|vip|vss|z
+ A|B|B2|B_N|Q A2|B|B1|C1|Y
+ BOTTOM|TOP|VGND|VSS|anode|cathode|core|h_sw[0]|h_sw[10]|h_sw[1]|h_sw[2]|h_sw[3]|h_sw[4]|h_sw[5]|h_sw[6]|h_sw[7]|h_sw[8]|h_sw[9]|l_sw[0]|l_sw[10]|l_sw[1]|l_sw[2]|l_sw[3]|l_sw[4]|l_sw[5]|l_sw[6]|l_sw[7]|l_sw[8]|l_sw[9]|out|pad|padres|vc|vcp|vdd|vddr|vip|vss|z
+ sg13_lv_nmos L=0.13u W=0.74u AS=0.2516p AD=0.1406p PS=2.16u PD=1.12u rfmode=0
M$753 A2|B|B1|C1|Y A|B_N|Q
+ BOTTOM|TOP|VGND|VSS|anode|cathode|core|h_sw[0]|h_sw[10]|h_sw[1]|h_sw[2]|h_sw[3]|h_sw[4]|h_sw[5]|h_sw[6]|h_sw[7]|h_sw[8]|h_sw[9]|l_sw[0]|l_sw[10]|l_sw[1]|l_sw[2]|l_sw[3]|l_sw[4]|l_sw[5]|l_sw[6]|l_sw[7]|l_sw[8]|l_sw[9]|out|pad|padres|vc|vcp|vdd|vddr|vip|vss|z
+ BOTTOM|TOP|VGND|VSS|anode|cathode|core|h_sw[0]|h_sw[10]|h_sw[1]|h_sw[2]|h_sw[3]|h_sw[4]|h_sw[5]|h_sw[6]|h_sw[7]|h_sw[8]|h_sw[9]|l_sw[0]|l_sw[10]|l_sw[1]|l_sw[2]|l_sw[3]|l_sw[4]|l_sw[5]|l_sw[6]|l_sw[7]|l_sw[8]|l_sw[9]|out|pad|padres|vc|vcp|vdd|vddr|vip|vss|z
+ sg13_lv_nmos L=0.13u W=0.74u AS=0.1406p AD=0.2516p PS=1.12u PD=2.16u rfmode=0
M$754 A1|Y$3 A|B|B2|B_N|Q
+ BOTTOM|TOP|VGND|VSS|anode|cathode|core|h_sw[0]|h_sw[10]|h_sw[1]|h_sw[2]|h_sw[3]|h_sw[4]|h_sw[5]|h_sw[6]|h_sw[7]|h_sw[8]|h_sw[9]|l_sw[0]|l_sw[10]|l_sw[1]|l_sw[2]|l_sw[3]|l_sw[4]|l_sw[5]|l_sw[6]|l_sw[7]|l_sw[8]|l_sw[9]|out|pad|padres|vc|vcp|vdd|vddr|vip|vss|z
+ BOTTOM|TOP|VGND|VSS|anode|cathode|core|h_sw[0]|h_sw[10]|h_sw[1]|h_sw[2]|h_sw[3]|h_sw[4]|h_sw[5]|h_sw[6]|h_sw[7]|h_sw[8]|h_sw[9]|l_sw[0]|l_sw[10]|l_sw[1]|l_sw[2]|l_sw[3]|l_sw[4]|l_sw[5]|l_sw[6]|l_sw[7]|l_sw[8]|l_sw[9]|out|pad|padres|vc|vcp|vdd|vddr|vip|vss|z
+ sg13_lv_nmos L=0.13u W=0.74u AS=0.2516p AD=0.2516p PS=2.16u PD=2.16u rfmode=0
M$755
+ BOTTOM|TOP|VGND|VSS|anode|cathode|core|h_sw[0]|h_sw[10]|h_sw[1]|h_sw[2]|h_sw[3]|h_sw[4]|h_sw[5]|h_sw[6]|h_sw[7]|h_sw[8]|h_sw[9]|l_sw[0]|l_sw[10]|l_sw[1]|l_sw[2]|l_sw[3]|l_sw[4]|l_sw[5]|l_sw[6]|l_sw[7]|l_sw[8]|l_sw[9]|out|pad|padres|vc|vcp|vdd|vddr|vip|vss|z
+ A|B_N|Q \$71816
+ BOTTOM|TOP|VGND|VSS|anode|cathode|core|h_sw[0]|h_sw[10]|h_sw[1]|h_sw[2]|h_sw[3]|h_sw[4]|h_sw[5]|h_sw[6]|h_sw[7]|h_sw[8]|h_sw[9]|l_sw[0]|l_sw[10]|l_sw[1]|l_sw[2]|l_sw[3]|l_sw[4]|l_sw[5]|l_sw[6]|l_sw[7]|l_sw[8]|l_sw[9]|out|pad|padres|vc|vcp|vdd|vddr|vip|vss|z
+ sg13_lv_nmos L=0.13u W=0.55u AS=0.17255p AD=0.187p PS=1.25u PD=1.78u rfmode=0
M$756
+ BOTTOM|TOP|VGND|VSS|anode|cathode|core|h_sw[0]|h_sw[10]|h_sw[1]|h_sw[2]|h_sw[3]|h_sw[4]|h_sw[5]|h_sw[6]|h_sw[7]|h_sw[8]|h_sw[9]|l_sw[0]|l_sw[10]|l_sw[1]|l_sw[2]|l_sw[3]|l_sw[4]|l_sw[5]|l_sw[6]|l_sw[7]|l_sw[8]|l_sw[9]|out|pad|padres|vc|vcp|vdd|vddr|vip|vss|z
+ \$71816 A2|B1|Y
+ BOTTOM|TOP|VGND|VSS|anode|cathode|core|h_sw[0]|h_sw[10]|h_sw[1]|h_sw[2]|h_sw[3]|h_sw[4]|h_sw[5]|h_sw[6]|h_sw[7]|h_sw[8]|h_sw[9]|l_sw[0]|l_sw[10]|l_sw[1]|l_sw[2]|l_sw[3]|l_sw[4]|l_sw[5]|l_sw[6]|l_sw[7]|l_sw[8]|l_sw[9]|out|pad|padres|vc|vcp|vdd|vddr|vip|vss|z
+ sg13_lv_nmos L=0.13u W=0.74u AS=0.17255p AD=0.1406p PS=1.25u PD=1.12u rfmode=0
M$757 A2|B1|Y A|B|B2|B_N|Q
+ BOTTOM|TOP|VGND|VSS|anode|cathode|core|h_sw[0]|h_sw[10]|h_sw[1]|h_sw[2]|h_sw[3]|h_sw[4]|h_sw[5]|h_sw[6]|h_sw[7]|h_sw[8]|h_sw[9]|l_sw[0]|l_sw[10]|l_sw[1]|l_sw[2]|l_sw[3]|l_sw[4]|l_sw[5]|l_sw[6]|l_sw[7]|l_sw[8]|l_sw[9]|out|pad|padres|vc|vcp|vdd|vddr|vip|vss|z
+ BOTTOM|TOP|VGND|VSS|anode|cathode|core|h_sw[0]|h_sw[10]|h_sw[1]|h_sw[2]|h_sw[3]|h_sw[4]|h_sw[5]|h_sw[6]|h_sw[7]|h_sw[8]|h_sw[9]|l_sw[0]|l_sw[10]|l_sw[1]|l_sw[2]|l_sw[3]|l_sw[4]|l_sw[5]|l_sw[6]|l_sw[7]|l_sw[8]|l_sw[9]|out|pad|padres|vc|vcp|vdd|vddr|vip|vss|z
+ sg13_lv_nmos L=0.13u W=0.74u AS=0.1406p AD=0.2516p PS=1.12u PD=2.16u rfmode=0
M$762 A|Y$9 A|X$43
+ BOTTOM|TOP|VGND|VSS|anode|cathode|core|h_sw[0]|h_sw[10]|h_sw[1]|h_sw[2]|h_sw[3]|h_sw[4]|h_sw[5]|h_sw[6]|h_sw[7]|h_sw[8]|h_sw[9]|l_sw[0]|l_sw[10]|l_sw[1]|l_sw[2]|l_sw[3]|l_sw[4]|l_sw[5]|l_sw[6]|l_sw[7]|l_sw[8]|l_sw[9]|out|pad|padres|vc|vcp|vdd|vddr|vip|vss|z
+ BOTTOM|TOP|VGND|VSS|anode|cathode|core|h_sw[0]|h_sw[10]|h_sw[1]|h_sw[2]|h_sw[3]|h_sw[4]|h_sw[5]|h_sw[6]|h_sw[7]|h_sw[8]|h_sw[9]|l_sw[0]|l_sw[10]|l_sw[1]|l_sw[2]|l_sw[3]|l_sw[4]|l_sw[5]|l_sw[6]|l_sw[7]|l_sw[8]|l_sw[9]|out|pad|padres|vc|vcp|vdd|vddr|vip|vss|z
+ sg13_lv_nmos L=0.13u W=0.74u AS=0.2516p AD=0.2516p PS=2.16u PD=2.16u rfmode=0
M$763
+ BOTTOM|TOP|VGND|VSS|anode|cathode|core|h_sw[0]|h_sw[10]|h_sw[1]|h_sw[2]|h_sw[3]|h_sw[4]|h_sw[5]|h_sw[6]|h_sw[7]|h_sw[8]|h_sw[9]|l_sw[0]|l_sw[10]|l_sw[1]|l_sw[2]|l_sw[3]|l_sw[4]|l_sw[5]|l_sw[6]|l_sw[7]|l_sw[8]|l_sw[9]|out|pad|padres|vc|vcp|vdd|vddr|vip|vss|z
+ RESET_B|Y$2 \$71871
+ BOTTOM|TOP|VGND|VSS|anode|cathode|core|h_sw[0]|h_sw[10]|h_sw[1]|h_sw[2]|h_sw[3]|h_sw[4]|h_sw[5]|h_sw[6]|h_sw[7]|h_sw[8]|h_sw[9]|l_sw[0]|l_sw[10]|l_sw[1]|l_sw[2]|l_sw[3]|l_sw[4]|l_sw[5]|l_sw[6]|l_sw[7]|l_sw[8]|l_sw[9]|out|pad|padres|vc|vcp|vdd|vddr|vip|vss|z
+ sg13_lv_nmos L=0.13u W=0.42u AS=0.1701p AD=0.0378p PS=1.65u PD=0.6u rfmode=0
M$764 \$71871 \$71334 \$71797
+ BOTTOM|TOP|VGND|VSS|anode|cathode|core|h_sw[0]|h_sw[10]|h_sw[1]|h_sw[2]|h_sw[3]|h_sw[4]|h_sw[5]|h_sw[6]|h_sw[7]|h_sw[8]|h_sw[9]|l_sw[0]|l_sw[10]|l_sw[1]|l_sw[2]|l_sw[3]|l_sw[4]|l_sw[5]|l_sw[6]|l_sw[7]|l_sw[8]|l_sw[9]|out|pad|padres|vc|vcp|vdd|vddr|vip|vss|z
+ sg13_lv_nmos L=0.13u W=0.42u AS=0.0378p AD=0.1428p PS=0.6u PD=1.52u rfmode=0
M$765
+ BOTTOM|TOP|VGND|VSS|anode|cathode|core|h_sw[0]|h_sw[10]|h_sw[1]|h_sw[2]|h_sw[3]|h_sw[4]|h_sw[5]|h_sw[6]|h_sw[7]|h_sw[8]|h_sw[9]|l_sw[0]|l_sw[10]|l_sw[1]|l_sw[2]|l_sw[3]|l_sw[4]|l_sw[5]|l_sw[6]|l_sw[7]|l_sw[8]|l_sw[9]|out|pad|padres|vc|vcp|vdd|vddr|vip|vss|z
+ \$71335 \$71798
+ BOTTOM|TOP|VGND|VSS|anode|cathode|core|h_sw[0]|h_sw[10]|h_sw[1]|h_sw[2]|h_sw[3]|h_sw[4]|h_sw[5]|h_sw[6]|h_sw[7]|h_sw[8]|h_sw[9]|l_sw[0]|l_sw[10]|l_sw[1]|l_sw[2]|l_sw[3]|l_sw[4]|l_sw[5]|l_sw[6]|l_sw[7]|l_sw[8]|l_sw[9]|out|pad|padres|vc|vcp|vdd|vddr|vip|vss|z
+ sg13_lv_nmos L=0.13u W=0.74u AS=0.317325p AD=0.2516p PS=1.805u PD=2.16u
+ rfmode=0
M$766
+ BOTTOM|TOP|VGND|VSS|anode|cathode|core|h_sw[0]|h_sw[10]|h_sw[1]|h_sw[2]|h_sw[3]|h_sw[4]|h_sw[5]|h_sw[6]|h_sw[7]|h_sw[8]|h_sw[9]|l_sw[0]|l_sw[10]|l_sw[1]|l_sw[2]|l_sw[3]|l_sw[4]|l_sw[5]|l_sw[6]|l_sw[7]|l_sw[8]|l_sw[9]|out|pad|padres|vc|vcp|vdd|vddr|vip|vss|z
+ A|CLK|X$1 \$71335
+ BOTTOM|TOP|VGND|VSS|anode|cathode|core|h_sw[0]|h_sw[10]|h_sw[1]|h_sw[2]|h_sw[3]|h_sw[4]|h_sw[5]|h_sw[6]|h_sw[7]|h_sw[8]|h_sw[9]|l_sw[0]|l_sw[10]|l_sw[1]|l_sw[2]|l_sw[3]|l_sw[4]|l_sw[5]|l_sw[6]|l_sw[7]|l_sw[8]|l_sw[9]|out|pad|padres|vc|vcp|vdd|vddr|vip|vss|z
+ sg13_lv_nmos L=0.13u W=0.74u AS=0.317325p AD=0.2516p PS=1.805u PD=2.16u
+ rfmode=0
M$767 \$71819 \$71335 \$71336
+ BOTTOM|TOP|VGND|VSS|anode|cathode|core|h_sw[0]|h_sw[10]|h_sw[1]|h_sw[2]|h_sw[3]|h_sw[4]|h_sw[5]|h_sw[6]|h_sw[7]|h_sw[8]|h_sw[9]|l_sw[0]|l_sw[10]|l_sw[1]|l_sw[2]|l_sw[3]|l_sw[4]|l_sw[5]|l_sw[6]|l_sw[7]|l_sw[8]|l_sw[9]|out|pad|padres|vc|vcp|vdd|vddr|vip|vss|z
+ sg13_lv_nmos L=0.13u W=0.42u AS=0.12665p AD=0.1428p PS=1.145u PD=1.52u
+ rfmode=0
M$768 \$71334 \$71798 \$71819
+ BOTTOM|TOP|VGND|VSS|anode|cathode|core|h_sw[0]|h_sw[10]|h_sw[1]|h_sw[2]|h_sw[3]|h_sw[4]|h_sw[5]|h_sw[6]|h_sw[7]|h_sw[8]|h_sw[9]|l_sw[0]|l_sw[10]|l_sw[1]|l_sw[2]|l_sw[3]|l_sw[4]|l_sw[5]|l_sw[6]|l_sw[7]|l_sw[8]|l_sw[9]|out|pad|padres|vc|vcp|vdd|vddr|vip|vss|z
+ sg13_lv_nmos L=0.13u W=0.74u AS=0.3473p AD=0.12665p PS=2.71u PD=1.145u
+ rfmode=0
M$769 A|Y$10 A|X$44
+ BOTTOM|TOP|VGND|VSS|anode|cathode|core|h_sw[0]|h_sw[10]|h_sw[1]|h_sw[2]|h_sw[3]|h_sw[4]|h_sw[5]|h_sw[6]|h_sw[7]|h_sw[8]|h_sw[9]|l_sw[0]|l_sw[10]|l_sw[1]|l_sw[2]|l_sw[3]|l_sw[4]|l_sw[5]|l_sw[6]|l_sw[7]|l_sw[8]|l_sw[9]|out|pad|padres|vc|vcp|vdd|vddr|vip|vss|z
+ BOTTOM|TOP|VGND|VSS|anode|cathode|core|h_sw[0]|h_sw[10]|h_sw[1]|h_sw[2]|h_sw[3]|h_sw[4]|h_sw[5]|h_sw[6]|h_sw[7]|h_sw[8]|h_sw[9]|l_sw[0]|l_sw[10]|l_sw[1]|l_sw[2]|l_sw[3]|l_sw[4]|l_sw[5]|l_sw[6]|l_sw[7]|l_sw[8]|l_sw[9]|out|pad|padres|vc|vcp|vdd|vddr|vip|vss|z
+ sg13_lv_nmos L=0.13u W=0.74u AS=0.2516p AD=0.2516p PS=2.16u PD=2.16u rfmode=0
M$770 \$71799 A|X$41
+ BOTTOM|TOP|VGND|VSS|anode|cathode|core|h_sw[0]|h_sw[10]|h_sw[1]|h_sw[2]|h_sw[3]|h_sw[4]|h_sw[5]|h_sw[6]|h_sw[7]|h_sw[8]|h_sw[9]|l_sw[0]|l_sw[10]|l_sw[1]|l_sw[2]|l_sw[3]|l_sw[4]|l_sw[5]|l_sw[6]|l_sw[7]|l_sw[8]|l_sw[9]|out|pad|padres|vc|vcp|vdd|vddr|vip|vss|z
+ BOTTOM|TOP|VGND|VSS|anode|cathode|core|h_sw[0]|h_sw[10]|h_sw[1]|h_sw[2]|h_sw[3]|h_sw[4]|h_sw[5]|h_sw[6]|h_sw[7]|h_sw[8]|h_sw[9]|l_sw[0]|l_sw[10]|l_sw[1]|l_sw[2]|l_sw[3]|l_sw[4]|l_sw[5]|l_sw[6]|l_sw[7]|l_sw[8]|l_sw[9]|out|pad|padres|vc|vcp|vdd|vddr|vip|vss|z
+ sg13_lv_nmos L=0.13u W=2.22u AS=0.5365p AD=0.4218p PS=4.41u PD=3.36u rfmode=0
M$773
+ BOTTOM|TOP|VGND|VSS|anode|cathode|core|h_sw[0]|h_sw[10]|h_sw[1]|h_sw[2]|h_sw[3]|h_sw[4]|h_sw[5]|h_sw[6]|h_sw[7]|h_sw[8]|h_sw[9]|l_sw[0]|l_sw[10]|l_sw[1]|l_sw[2]|l_sw[3]|l_sw[4]|l_sw[5]|l_sw[6]|l_sw[7]|l_sw[8]|l_sw[9]|out|pad|padres|vc|vcp|vdd|vddr|vip|vss|z
+ \$71799 A|X$42
+ BOTTOM|TOP|VGND|VSS|anode|cathode|core|h_sw[0]|h_sw[10]|h_sw[1]|h_sw[2]|h_sw[3]|h_sw[4]|h_sw[5]|h_sw[6]|h_sw[7]|h_sw[8]|h_sw[9]|l_sw[0]|l_sw[10]|l_sw[1]|l_sw[2]|l_sw[3]|l_sw[4]|l_sw[5]|l_sw[6]|l_sw[7]|l_sw[8]|l_sw[9]|out|pad|padres|vc|vcp|vdd|vddr|vip|vss|z
+ sg13_lv_nmos L=0.13u W=5.92u AS=1.1248p AD=1.2358p PS=8.96u PD=10u rfmode=0
M$781 \$67905 \$67908 VDD|VPWR|vdd
+ BOTTOM|TOP|VGND|VSS|anode|cathode|core|h_sw[0]|h_sw[10]|h_sw[1]|h_sw[2]|h_sw[3]|h_sw[4]|h_sw[5]|h_sw[6]|h_sw[7]|h_sw[8]|h_sw[9]|l_sw[0]|l_sw[10]|l_sw[1]|l_sw[2]|l_sw[3]|l_sw[4]|l_sw[5]|l_sw[6]|l_sw[7]|l_sw[8]|l_sw[9]|out|pad|padres|vc|vcp|vdd|vddr|vip|vss|z
+ sg13_lv_nmos L=0.13u W=1.3u AS=0.442p AD=0.442p PS=3.28u PD=3.28u rfmode=0
M$782 VDD|VPWR|vdd \$67905 \$67908
+ BOTTOM|TOP|VGND|VSS|anode|cathode|core|h_sw[0]|h_sw[10]|h_sw[1]|h_sw[2]|h_sw[3]|h_sw[4]|h_sw[5]|h_sw[6]|h_sw[7]|h_sw[8]|h_sw[9]|l_sw[0]|l_sw[10]|l_sw[1]|l_sw[2]|l_sw[3]|l_sw[4]|l_sw[5]|l_sw[6]|l_sw[7]|l_sw[8]|l_sw[9]|out|pad|padres|vc|vcp|vdd|vddr|vip|vss|z
+ sg13_lv_nmos L=0.13u W=1.3u AS=0.442p AD=0.442p PS=3.28u PD=3.28u rfmode=0
M$783 VDD|VPWR|vdd \$67905 \$66428
+ BOTTOM|TOP|VGND|VSS|anode|cathode|core|h_sw[0]|h_sw[10]|h_sw[1]|h_sw[2]|h_sw[3]|h_sw[4]|h_sw[5]|h_sw[6]|h_sw[7]|h_sw[8]|h_sw[9]|l_sw[0]|l_sw[10]|l_sw[1]|l_sw[2]|l_sw[3]|l_sw[4]|l_sw[5]|l_sw[6]|l_sw[7]|l_sw[8]|l_sw[9]|out|pad|padres|vc|vcp|vdd|vddr|vip|vss|z
+ sg13_lv_nmos L=0.13u W=1.3u AS=0.442p AD=0.442p PS=3.28u PD=3.28u rfmode=0
M$784
+ BOTTOM|TOP|VGND|VSS|anode|cathode|core|h_sw[0]|h_sw[10]|h_sw[1]|h_sw[2]|h_sw[3]|h_sw[4]|h_sw[5]|h_sw[6]|h_sw[7]|h_sw[8]|h_sw[9]|l_sw[0]|l_sw[10]|l_sw[1]|l_sw[2]|l_sw[3]|l_sw[4]|l_sw[5]|l_sw[6]|l_sw[7]|l_sw[8]|l_sw[9]|out|pad|padres|vc|vcp|vdd|vddr|vip|vss|z
+ A Y$1
+ BOTTOM|TOP|VGND|VSS|anode|cathode|core|h_sw[0]|h_sw[10]|h_sw[1]|h_sw[2]|h_sw[3]|h_sw[4]|h_sw[5]|h_sw[6]|h_sw[7]|h_sw[8]|h_sw[9]|l_sw[0]|l_sw[10]|l_sw[1]|l_sw[2]|l_sw[3]|l_sw[4]|l_sw[5]|l_sw[6]|l_sw[7]|l_sw[8]|l_sw[9]|out|pad|padres|vc|vcp|vdd|vddr|vip|vss|z
+ sg13_lv_nmos L=0.13u W=0.74u AS=0.2516p AD=0.2516p PS=2.16u PD=2.16u rfmode=0
M$786
+ BOTTOM|TOP|VGND|VSS|anode|cathode|core|h_sw[0]|h_sw[10]|h_sw[1]|h_sw[2]|h_sw[3]|h_sw[4]|h_sw[5]|h_sw[6]|h_sw[7]|h_sw[8]|h_sw[9]|l_sw[0]|l_sw[10]|l_sw[1]|l_sw[2]|l_sw[3]|l_sw[4]|l_sw[5]|l_sw[6]|l_sw[7]|l_sw[8]|l_sw[9]|out|pad|padres|vc|vcp|vdd|vddr|vip|vss|z
+ A|comp_p|outp A|Y$18
+ BOTTOM|TOP|VGND|VSS|anode|cathode|core|h_sw[0]|h_sw[10]|h_sw[1]|h_sw[2]|h_sw[3]|h_sw[4]|h_sw[5]|h_sw[6]|h_sw[7]|h_sw[8]|h_sw[9]|l_sw[0]|l_sw[10]|l_sw[1]|l_sw[2]|l_sw[3]|l_sw[4]|l_sw[5]|l_sw[6]|l_sw[7]|l_sw[8]|l_sw[9]|out|pad|padres|vc|vcp|vdd|vddr|vip|vss|z
+ sg13_lv_nmos L=0.13u W=0.74u AS=0.2516p AD=0.2516p PS=2.16u PD=2.16u rfmode=0
M$787
+ BOTTOM|TOP|VGND|VSS|anode|cathode|core|h_sw[0]|h_sw[10]|h_sw[1]|h_sw[2]|h_sw[3]|h_sw[4]|h_sw[5]|h_sw[6]|h_sw[7]|h_sw[8]|h_sw[9]|l_sw[0]|l_sw[10]|l_sw[1]|l_sw[2]|l_sw[3]|l_sw[4]|l_sw[5]|l_sw[6]|l_sw[7]|l_sw[8]|l_sw[9]|out|pad|padres|vc|vcp|vdd|vddr|vip|vss|z
+ A|outn B|Y$2
+ BOTTOM|TOP|VGND|VSS|anode|cathode|core|h_sw[0]|h_sw[10]|h_sw[1]|h_sw[2]|h_sw[3]|h_sw[4]|h_sw[5]|h_sw[6]|h_sw[7]|h_sw[8]|h_sw[9]|l_sw[0]|l_sw[10]|l_sw[1]|l_sw[2]|l_sw[3]|l_sw[4]|l_sw[5]|l_sw[6]|l_sw[7]|l_sw[8]|l_sw[9]|out|pad|padres|vc|vcp|vdd|vddr|vip|vss|z
+ sg13_lv_nmos L=0.13u W=0.74u AS=0.2516p AD=0.2516p PS=2.16u PD=2.16u rfmode=0
M$788
+ BOTTOM|TOP|VGND|VSS|anode|cathode|core|h_sw[0]|h_sw[10]|h_sw[1]|h_sw[2]|h_sw[3]|h_sw[4]|h_sw[5]|h_sw[6]|h_sw[7]|h_sw[8]|h_sw[9]|l_sw[0]|l_sw[10]|l_sw[1]|l_sw[2]|l_sw[3]|l_sw[4]|l_sw[5]|l_sw[6]|l_sw[7]|l_sw[8]|l_sw[9]|out|pad|padres|vc|vcp|vdd|vddr|vip|vss|z
+ B|Y$2 \$72151
+ BOTTOM|TOP|VGND|VSS|anode|cathode|core|h_sw[0]|h_sw[10]|h_sw[1]|h_sw[2]|h_sw[3]|h_sw[4]|h_sw[5]|h_sw[6]|h_sw[7]|h_sw[8]|h_sw[9]|l_sw[0]|l_sw[10]|l_sw[1]|l_sw[2]|l_sw[3]|l_sw[4]|l_sw[5]|l_sw[6]|l_sw[7]|l_sw[8]|l_sw[9]|out|pad|padres|vc|vcp|vdd|vddr|vip|vss|z
+ sg13_lv_nmos L=0.13u W=0.55u AS=0.187p AD=0.1045p PS=1.78u PD=0.93u rfmode=0
M$789 \$72151 A|Y$18
+ BOTTOM|TOP|VGND|VSS|anode|cathode|core|h_sw[0]|h_sw[10]|h_sw[1]|h_sw[2]|h_sw[3]|h_sw[4]|h_sw[5]|h_sw[6]|h_sw[7]|h_sw[8]|h_sw[9]|l_sw[0]|l_sw[10]|l_sw[1]|l_sw[2]|l_sw[3]|l_sw[4]|l_sw[5]|l_sw[6]|l_sw[7]|l_sw[8]|l_sw[9]|out|pad|padres|vc|vcp|vdd|vddr|vip|vss|z
+ BOTTOM|TOP|VGND|VSS|anode|cathode|core|h_sw[0]|h_sw[10]|h_sw[1]|h_sw[2]|h_sw[3]|h_sw[4]|h_sw[5]|h_sw[6]|h_sw[7]|h_sw[8]|h_sw[9]|l_sw[0]|l_sw[10]|l_sw[1]|l_sw[2]|l_sw[3]|l_sw[4]|l_sw[5]|l_sw[6]|l_sw[7]|l_sw[8]|l_sw[9]|out|pad|padres|vc|vcp|vdd|vddr|vip|vss|z
+ sg13_lv_nmos L=0.13u W=0.55u AS=0.1045p AD=0.1469p PS=0.93u PD=1.155u rfmode=0
M$790
+ BOTTOM|TOP|VGND|VSS|anode|cathode|core|h_sw[0]|h_sw[10]|h_sw[1]|h_sw[2]|h_sw[3]|h_sw[4]|h_sw[5]|h_sw[6]|h_sw[7]|h_sw[8]|h_sw[9]|l_sw[0]|l_sw[10]|l_sw[1]|l_sw[2]|l_sw[3]|l_sw[4]|l_sw[5]|l_sw[6]|l_sw[7]|l_sw[8]|l_sw[9]|out|pad|padres|vc|vcp|vdd|vddr|vip|vss|z
+ \$72151 A|X$45
+ BOTTOM|TOP|VGND|VSS|anode|cathode|core|h_sw[0]|h_sw[10]|h_sw[1]|h_sw[2]|h_sw[3]|h_sw[4]|h_sw[5]|h_sw[6]|h_sw[7]|h_sw[8]|h_sw[9]|l_sw[0]|l_sw[10]|l_sw[1]|l_sw[2]|l_sw[3]|l_sw[4]|l_sw[5]|l_sw[6]|l_sw[7]|l_sw[8]|l_sw[9]|out|pad|padres|vc|vcp|vdd|vddr|vip|vss|z
+ sg13_lv_nmos L=0.13u W=0.74u AS=0.1469p AD=0.2516p PS=1.155u PD=2.16u rfmode=0
M$791 \$72153 A|X$45
+ BOTTOM|TOP|VGND|VSS|anode|cathode|core|h_sw[0]|h_sw[10]|h_sw[1]|h_sw[2]|h_sw[3]|h_sw[4]|h_sw[5]|h_sw[6]|h_sw[7]|h_sw[8]|h_sw[9]|l_sw[0]|l_sw[10]|l_sw[1]|l_sw[2]|l_sw[3]|l_sw[4]|l_sw[5]|l_sw[6]|l_sw[7]|l_sw[8]|l_sw[9]|out|pad|padres|vc|vcp|vdd|vddr|vip|vss|z
+ BOTTOM|TOP|VGND|VSS|anode|cathode|core|h_sw[0]|h_sw[10]|h_sw[1]|h_sw[2]|h_sw[3]|h_sw[4]|h_sw[5]|h_sw[6]|h_sw[7]|h_sw[8]|h_sw[9]|l_sw[0]|l_sw[10]|l_sw[1]|l_sw[2]|l_sw[3]|l_sw[4]|l_sw[5]|l_sw[6]|l_sw[7]|l_sw[8]|l_sw[9]|out|pad|padres|vc|vcp|vdd|vddr|vip|vss|z
+ sg13_lv_nmos L=0.13u W=0.42u AS=0.1428p AD=0.0798p PS=1.52u PD=0.8u rfmode=0
M$792
+ BOTTOM|TOP|VGND|VSS|anode|cathode|core|h_sw[0]|h_sw[10]|h_sw[1]|h_sw[2]|h_sw[3]|h_sw[4]|h_sw[5]|h_sw[6]|h_sw[7]|h_sw[8]|h_sw[9]|l_sw[0]|l_sw[10]|l_sw[1]|l_sw[2]|l_sw[3]|l_sw[4]|l_sw[5]|l_sw[6]|l_sw[7]|l_sw[8]|l_sw[9]|out|pad|padres|vc|vcp|vdd|vddr|vip|vss|z
+ \$72153 \$72154
+ BOTTOM|TOP|VGND|VSS|anode|cathode|core|h_sw[0]|h_sw[10]|h_sw[1]|h_sw[2]|h_sw[3]|h_sw[4]|h_sw[5]|h_sw[6]|h_sw[7]|h_sw[8]|h_sw[9]|l_sw[0]|l_sw[10]|l_sw[1]|l_sw[2]|l_sw[3]|l_sw[4]|l_sw[5]|l_sw[6]|l_sw[7]|l_sw[8]|l_sw[9]|out|pad|padres|vc|vcp|vdd|vddr|vip|vss|z
+ sg13_lv_nmos L=0.5u W=0.42u AS=0.0798p AD=0.1428p PS=0.8u PD=1.52u rfmode=0
M$793
+ BOTTOM|TOP|VGND|VSS|anode|cathode|core|h_sw[0]|h_sw[10]|h_sw[1]|h_sw[2]|h_sw[3]|h_sw[4]|h_sw[5]|h_sw[6]|h_sw[7]|h_sw[8]|h_sw[9]|l_sw[0]|l_sw[10]|l_sw[1]|l_sw[2]|l_sw[3]|l_sw[4]|l_sw[5]|l_sw[6]|l_sw[7]|l_sw[8]|l_sw[9]|out|pad|padres|vc|vcp|vdd|vddr|vip|vss|z
+ \$72154 \$72250
+ BOTTOM|TOP|VGND|VSS|anode|cathode|core|h_sw[0]|h_sw[10]|h_sw[1]|h_sw[2]|h_sw[3]|h_sw[4]|h_sw[5]|h_sw[6]|h_sw[7]|h_sw[8]|h_sw[9]|l_sw[0]|l_sw[10]|l_sw[1]|l_sw[2]|l_sw[3]|l_sw[4]|l_sw[5]|l_sw[6]|l_sw[7]|l_sw[8]|l_sw[9]|out|pad|padres|vc|vcp|vdd|vddr|vip|vss|z
+ sg13_lv_nmos L=0.5u W=0.42u AS=0.1426p AD=0.1428p PS=1.16u PD=1.52u rfmode=0
M$794
+ BOTTOM|TOP|VGND|VSS|anode|cathode|core|h_sw[0]|h_sw[10]|h_sw[1]|h_sw[2]|h_sw[3]|h_sw[4]|h_sw[5]|h_sw[6]|h_sw[7]|h_sw[8]|h_sw[9]|l_sw[0]|l_sw[10]|l_sw[1]|l_sw[2]|l_sw[3]|l_sw[4]|l_sw[5]|l_sw[6]|l_sw[7]|l_sw[8]|l_sw[9]|out|pad|padres|vc|vcp|vdd|vddr|vip|vss|z
+ \$72250 A|X|rdy
+ BOTTOM|TOP|VGND|VSS|anode|cathode|core|h_sw[0]|h_sw[10]|h_sw[1]|h_sw[2]|h_sw[3]|h_sw[4]|h_sw[5]|h_sw[6]|h_sw[7]|h_sw[8]|h_sw[9]|l_sw[0]|l_sw[10]|l_sw[1]|l_sw[2]|l_sw[3]|l_sw[4]|l_sw[5]|l_sw[6]|l_sw[7]|l_sw[8]|l_sw[9]|out|pad|padres|vc|vcp|vdd|vddr|vip|vss|z
+ sg13_lv_nmos L=0.13u W=0.74u AS=0.1426p AD=0.2516p PS=1.16u PD=2.16u rfmode=0
M$795 \$71810 \$71319 \$71891
+ BOTTOM|TOP|VGND|VSS|anode|cathode|core|h_sw[0]|h_sw[10]|h_sw[1]|h_sw[2]|h_sw[3]|h_sw[4]|h_sw[5]|h_sw[6]|h_sw[7]|h_sw[8]|h_sw[9]|l_sw[0]|l_sw[10]|l_sw[1]|l_sw[2]|l_sw[3]|l_sw[4]|l_sw[5]|l_sw[6]|l_sw[7]|l_sw[8]|l_sw[9]|out|pad|padres|vc|vcp|vdd|vddr|vip|vss|z
+ sg13_lv_nmos L=0.13u W=0.42u AS=0.1296p AD=0.0798p PS=1.52u PD=0.8u rfmode=0
M$796 \$71891 \$71790 \$71789
+ BOTTOM|TOP|VGND|VSS|anode|cathode|core|h_sw[0]|h_sw[10]|h_sw[1]|h_sw[2]|h_sw[3]|h_sw[4]|h_sw[5]|h_sw[6]|h_sw[7]|h_sw[8]|h_sw[9]|l_sw[0]|l_sw[10]|l_sw[1]|l_sw[2]|l_sw[3]|l_sw[4]|l_sw[5]|l_sw[6]|l_sw[7]|l_sw[8]|l_sw[9]|out|pad|padres|vc|vcp|vdd|vddr|vip|vss|z
+ sg13_lv_nmos L=0.13u W=0.42u AS=0.0798p AD=0.2373p PS=0.8u PD=1.97u rfmode=0
M$797 \$71812 \$71325 \$71892
+ BOTTOM|TOP|VGND|VSS|anode|cathode|core|h_sw[0]|h_sw[10]|h_sw[1]|h_sw[2]|h_sw[3]|h_sw[4]|h_sw[5]|h_sw[6]|h_sw[7]|h_sw[8]|h_sw[9]|l_sw[0]|l_sw[10]|l_sw[1]|l_sw[2]|l_sw[3]|l_sw[4]|l_sw[5]|l_sw[6]|l_sw[7]|l_sw[8]|l_sw[9]|out|pad|padres|vc|vcp|vdd|vddr|vip|vss|z
+ sg13_lv_nmos L=0.13u W=0.42u AS=0.1296p AD=0.0798p PS=1.52u PD=0.8u rfmode=0
M$798 \$71892 \$71792 \$71791
+ BOTTOM|TOP|VGND|VSS|anode|cathode|core|h_sw[0]|h_sw[10]|h_sw[1]|h_sw[2]|h_sw[3]|h_sw[4]|h_sw[5]|h_sw[6]|h_sw[7]|h_sw[8]|h_sw[9]|l_sw[0]|l_sw[10]|l_sw[1]|l_sw[2]|l_sw[3]|l_sw[4]|l_sw[5]|l_sw[6]|l_sw[7]|l_sw[8]|l_sw[9]|out|pad|padres|vc|vcp|vdd|vddr|vip|vss|z
+ sg13_lv_nmos L=0.13u W=0.42u AS=0.0798p AD=0.2373p PS=0.8u PD=1.97u rfmode=0
M$799 \$71817 A|B_N|Q \$71872
+ BOTTOM|TOP|VGND|VSS|anode|cathode|core|h_sw[0]|h_sw[10]|h_sw[1]|h_sw[2]|h_sw[3]|h_sw[4]|h_sw[5]|h_sw[6]|h_sw[7]|h_sw[8]|h_sw[9]|l_sw[0]|l_sw[10]|l_sw[1]|l_sw[2]|l_sw[3]|l_sw[4]|l_sw[5]|l_sw[6]|l_sw[7]|l_sw[8]|l_sw[9]|out|pad|padres|vc|vcp|vdd|vddr|vip|vss|z
+ sg13_lv_nmos L=0.13u W=0.64u AS=0.2176p AD=0.1216p PS=1.96u PD=1.02u rfmode=0
M$800 \$71872 A|B|B2|B_N|Q \$71873
+ BOTTOM|TOP|VGND|VSS|anode|cathode|core|h_sw[0]|h_sw[10]|h_sw[1]|h_sw[2]|h_sw[3]|h_sw[4]|h_sw[5]|h_sw[6]|h_sw[7]|h_sw[8]|h_sw[9]|l_sw[0]|l_sw[10]|l_sw[1]|l_sw[2]|l_sw[3]|l_sw[4]|l_sw[5]|l_sw[6]|l_sw[7]|l_sw[8]|l_sw[9]|out|pad|padres|vc|vcp|vdd|vddr|vip|vss|z
+ sg13_lv_nmos L=0.13u W=0.64u AS=0.1216p AD=0.1216p PS=1.02u PD=1.02u rfmode=0
M$801
+ BOTTOM|TOP|VGND|VSS|anode|cathode|core|h_sw[0]|h_sw[10]|h_sw[1]|h_sw[2]|h_sw[3]|h_sw[4]|h_sw[5]|h_sw[6]|h_sw[7]|h_sw[8]|h_sw[9]|l_sw[0]|l_sw[10]|l_sw[1]|l_sw[2]|l_sw[3]|l_sw[4]|l_sw[5]|l_sw[6]|l_sw[7]|l_sw[8]|l_sw[9]|out|pad|padres|vc|vcp|vdd|vddr|vip|vss|z
+ C|Q \$71873
+ BOTTOM|TOP|VGND|VSS|anode|cathode|core|h_sw[0]|h_sw[10]|h_sw[1]|h_sw[2]|h_sw[3]|h_sw[4]|h_sw[5]|h_sw[6]|h_sw[7]|h_sw[8]|h_sw[9]|l_sw[0]|l_sw[10]|l_sw[1]|l_sw[2]|l_sw[3]|l_sw[4]|l_sw[5]|l_sw[6]|l_sw[7]|l_sw[8]|l_sw[9]|out|pad|padres|vc|vcp|vdd|vddr|vip|vss|z
+ sg13_lv_nmos L=0.13u W=0.64u AS=0.1371p AD=0.1216p PS=1.12u PD=1.02u rfmode=0
M$802
+ BOTTOM|TOP|VGND|VSS|anode|cathode|core|h_sw[0]|h_sw[10]|h_sw[1]|h_sw[2]|h_sw[3]|h_sw[4]|h_sw[5]|h_sw[6]|h_sw[7]|h_sw[8]|h_sw[9]|l_sw[0]|l_sw[10]|l_sw[1]|l_sw[2]|l_sw[3]|l_sw[4]|l_sw[5]|l_sw[6]|l_sw[7]|l_sw[8]|l_sw[9]|out|pad|padres|vc|vcp|vdd|vddr|vip|vss|z
+ \$71817 C1|X
+ BOTTOM|TOP|VGND|VSS|anode|cathode|core|h_sw[0]|h_sw[10]|h_sw[1]|h_sw[2]|h_sw[3]|h_sw[4]|h_sw[5]|h_sw[6]|h_sw[7]|h_sw[8]|h_sw[9]|l_sw[0]|l_sw[10]|l_sw[1]|l_sw[2]|l_sw[3]|l_sw[4]|l_sw[5]|l_sw[6]|l_sw[7]|l_sw[8]|l_sw[9]|out|pad|padres|vc|vcp|vdd|vddr|vip|vss|z
+ sg13_lv_nmos L=0.13u W=0.74u AS=0.1371p AD=0.2516p PS=1.12u PD=2.16u rfmode=0
M$803 \$71818 \$71335 \$71899
+ BOTTOM|TOP|VGND|VSS|anode|cathode|core|h_sw[0]|h_sw[10]|h_sw[1]|h_sw[2]|h_sw[3]|h_sw[4]|h_sw[5]|h_sw[6]|h_sw[7]|h_sw[8]|h_sw[9]|l_sw[0]|l_sw[10]|l_sw[1]|l_sw[2]|l_sw[3]|l_sw[4]|l_sw[5]|l_sw[6]|l_sw[7]|l_sw[8]|l_sw[9]|out|pad|padres|vc|vcp|vdd|vddr|vip|vss|z
+ sg13_lv_nmos L=0.13u W=0.42u AS=0.1296p AD=0.0798p PS=1.52u PD=0.8u rfmode=0
M$804 \$71899 \$71798 \$71797
+ BOTTOM|TOP|VGND|VSS|anode|cathode|core|h_sw[0]|h_sw[10]|h_sw[1]|h_sw[2]|h_sw[3]|h_sw[4]|h_sw[5]|h_sw[6]|h_sw[7]|h_sw[8]|h_sw[9]|l_sw[0]|l_sw[10]|l_sw[1]|l_sw[2]|l_sw[3]|l_sw[4]|l_sw[5]|l_sw[6]|l_sw[7]|l_sw[8]|l_sw[9]|out|pad|padres|vc|vcp|vdd|vddr|vip|vss|z
+ sg13_lv_nmos L=0.13u W=0.42u AS=0.0798p AD=0.2373p PS=0.8u PD=1.97u rfmode=0
M$807 \$72156 \$72252 \$72157
+ BOTTOM|TOP|VGND|VSS|anode|cathode|core|h_sw[0]|h_sw[10]|h_sw[1]|h_sw[2]|h_sw[3]|h_sw[4]|h_sw[5]|h_sw[6]|h_sw[7]|h_sw[8]|h_sw[9]|l_sw[0]|l_sw[10]|l_sw[1]|l_sw[2]|l_sw[3]|l_sw[4]|l_sw[5]|l_sw[6]|l_sw[7]|l_sw[8]|l_sw[9]|out|pad|padres|vc|vcp|vdd|vddr|vip|vss|z
+ sg13_lv_nmos L=0.13u W=0.42u AS=0.1296p AD=0.0798p PS=1.52u PD=0.8u rfmode=0
M$808 \$72157 \$72158 \$72601
+ BOTTOM|TOP|VGND|VSS|anode|cathode|core|h_sw[0]|h_sw[10]|h_sw[1]|h_sw[2]|h_sw[3]|h_sw[4]|h_sw[5]|h_sw[6]|h_sw[7]|h_sw[8]|h_sw[9]|l_sw[0]|l_sw[10]|l_sw[1]|l_sw[2]|l_sw[3]|l_sw[4]|l_sw[5]|l_sw[6]|l_sw[7]|l_sw[8]|l_sw[9]|out|pad|padres|vc|vcp|vdd|vddr|vip|vss|z
+ sg13_lv_nmos L=0.13u W=0.42u AS=0.0798p AD=0.2373p PS=0.8u PD=1.97u rfmode=0
M$809 \$72158 \$72252
+ BOTTOM|TOP|VGND|VSS|anode|cathode|core|h_sw[0]|h_sw[10]|h_sw[1]|h_sw[2]|h_sw[3]|h_sw[4]|h_sw[5]|h_sw[6]|h_sw[7]|h_sw[8]|h_sw[9]|l_sw[0]|l_sw[10]|l_sw[1]|l_sw[2]|l_sw[3]|l_sw[4]|l_sw[5]|l_sw[6]|l_sw[7]|l_sw[8]|l_sw[9]|out|pad|padres|vc|vcp|vdd|vddr|vip|vss|z
+ BOTTOM|TOP|VGND|VSS|anode|cathode|core|h_sw[0]|h_sw[10]|h_sw[1]|h_sw[2]|h_sw[3]|h_sw[4]|h_sw[5]|h_sw[6]|h_sw[7]|h_sw[8]|h_sw[9]|l_sw[0]|l_sw[10]|l_sw[1]|l_sw[2]|l_sw[3]|l_sw[4]|l_sw[5]|l_sw[6]|l_sw[7]|l_sw[8]|l_sw[9]|out|pad|padres|vc|vcp|vdd|vddr|vip|vss|z
+ sg13_lv_nmos L=0.13u W=0.74u AS=0.2516p AD=0.317325p PS=2.16u PD=1.805u
+ rfmode=0
M$810
+ BOTTOM|TOP|VGND|VSS|anode|cathode|core|h_sw[0]|h_sw[10]|h_sw[1]|h_sw[2]|h_sw[3]|h_sw[4]|h_sw[5]|h_sw[6]|h_sw[7]|h_sw[8]|h_sw[9]|l_sw[0]|l_sw[10]|l_sw[1]|l_sw[2]|l_sw[3]|l_sw[4]|l_sw[5]|l_sw[6]|l_sw[7]|l_sw[8]|l_sw[9]|out|pad|padres|vc|vcp|vdd|vddr|vip|vss|z
+ CLK|D|GATE|Q$2 \$72252
+ BOTTOM|TOP|VGND|VSS|anode|cathode|core|h_sw[0]|h_sw[10]|h_sw[1]|h_sw[2]|h_sw[3]|h_sw[4]|h_sw[5]|h_sw[6]|h_sw[7]|h_sw[8]|h_sw[9]|l_sw[0]|l_sw[10]|l_sw[1]|l_sw[2]|l_sw[3]|l_sw[4]|l_sw[5]|l_sw[6]|l_sw[7]|l_sw[8]|l_sw[9]|out|pad|padres|vc|vcp|vdd|vddr|vip|vss|z
+ sg13_lv_nmos L=0.13u W=0.74u AS=0.317325p AD=0.2516p PS=1.805u PD=2.16u
+ rfmode=0
M$811 \$72602 \$72252 \$72253
+ BOTTOM|TOP|VGND|VSS|anode|cathode|core|h_sw[0]|h_sw[10]|h_sw[1]|h_sw[2]|h_sw[3]|h_sw[4]|h_sw[5]|h_sw[6]|h_sw[7]|h_sw[8]|h_sw[9]|l_sw[0]|l_sw[10]|l_sw[1]|l_sw[2]|l_sw[3]|l_sw[4]|l_sw[5]|l_sw[6]|l_sw[7]|l_sw[8]|l_sw[9]|out|pad|padres|vc|vcp|vdd|vddr|vip|vss|z
+ sg13_lv_nmos L=0.13u W=0.42u AS=0.1428p AD=0.12665p PS=1.52u PD=1.145u
+ rfmode=0
M$812 \$72253 \$72158 \$72251
+ BOTTOM|TOP|VGND|VSS|anode|cathode|core|h_sw[0]|h_sw[10]|h_sw[1]|h_sw[2]|h_sw[3]|h_sw[4]|h_sw[5]|h_sw[6]|h_sw[7]|h_sw[8]|h_sw[9]|l_sw[0]|l_sw[10]|l_sw[1]|l_sw[2]|l_sw[3]|l_sw[4]|l_sw[5]|l_sw[6]|l_sw[7]|l_sw[8]|l_sw[9]|out|pad|padres|vc|vcp|vdd|vddr|vip|vss|z
+ sg13_lv_nmos L=0.13u W=0.74u AS=0.12665p AD=0.3473p PS=1.145u PD=2.71u
+ rfmode=0
M$813
+ BOTTOM|TOP|VGND|VSS|anode|cathode|core|h_sw[0]|h_sw[10]|h_sw[1]|h_sw[2]|h_sw[3]|h_sw[4]|h_sw[5]|h_sw[6]|h_sw[7]|h_sw[8]|h_sw[9]|l_sw[0]|l_sw[10]|l_sw[1]|l_sw[2]|l_sw[3]|l_sw[4]|l_sw[5]|l_sw[6]|l_sw[7]|l_sw[8]|l_sw[9]|out|pad|padres|vc|vcp|vdd|vddr|vip|vss|z
+ \$72253 D|Q_N$3
+ BOTTOM|TOP|VGND|VSS|anode|cathode|core|h_sw[0]|h_sw[10]|h_sw[1]|h_sw[2]|h_sw[3]|h_sw[4]|h_sw[5]|h_sw[6]|h_sw[7]|h_sw[8]|h_sw[9]|l_sw[0]|l_sw[10]|l_sw[1]|l_sw[2]|l_sw[3]|l_sw[4]|l_sw[5]|l_sw[6]|l_sw[7]|l_sw[8]|l_sw[9]|out|pad|padres|vc|vcp|vdd|vddr|vip|vss|z
+ sg13_lv_nmos L=0.13u W=0.74u AS=0.2516p AD=0.2849p PS=2.16u PD=2.25u rfmode=0
M$814 \$72159 \$72253
+ BOTTOM|TOP|VGND|VSS|anode|cathode|core|h_sw[0]|h_sw[10]|h_sw[1]|h_sw[2]|h_sw[3]|h_sw[4]|h_sw[5]|h_sw[6]|h_sw[7]|h_sw[8]|h_sw[9]|l_sw[0]|l_sw[10]|l_sw[1]|l_sw[2]|l_sw[3]|l_sw[4]|l_sw[5]|l_sw[6]|l_sw[7]|l_sw[8]|l_sw[9]|out|pad|padres|vc|vcp|vdd|vddr|vip|vss|z
+ BOTTOM|TOP|VGND|VSS|anode|cathode|core|h_sw[0]|h_sw[10]|h_sw[1]|h_sw[2]|h_sw[3]|h_sw[4]|h_sw[5]|h_sw[6]|h_sw[7]|h_sw[8]|h_sw[9]|l_sw[0]|l_sw[10]|l_sw[1]|l_sw[2]|l_sw[3]|l_sw[4]|l_sw[5]|l_sw[6]|l_sw[7]|l_sw[8]|l_sw[9]|out|pad|padres|vc|vcp|vdd|vddr|vip|vss|z
+ sg13_lv_nmos L=0.13u W=0.74u AS=0.2516p AD=0.1406p PS=2.16u PD=1.12u rfmode=0
M$815
+ BOTTOM|TOP|VGND|VSS|anode|cathode|core|h_sw[0]|h_sw[10]|h_sw[1]|h_sw[2]|h_sw[3]|h_sw[4]|h_sw[5]|h_sw[6]|h_sw[7]|h_sw[8]|h_sw[9]|l_sw[0]|l_sw[10]|l_sw[1]|l_sw[2]|l_sw[3]|l_sw[4]|l_sw[5]|l_sw[6]|l_sw[7]|l_sw[8]|l_sw[9]|out|pad|padres|vc|vcp|vdd|vddr|vip|vss|z
+ \$72159 A_N|D|Q
+ BOTTOM|TOP|VGND|VSS|anode|cathode|core|h_sw[0]|h_sw[10]|h_sw[1]|h_sw[2]|h_sw[3]|h_sw[4]|h_sw[5]|h_sw[6]|h_sw[7]|h_sw[8]|h_sw[9]|l_sw[0]|l_sw[10]|l_sw[1]|l_sw[2]|l_sw[3]|l_sw[4]|l_sw[5]|l_sw[6]|l_sw[7]|l_sw[8]|l_sw[9]|out|pad|padres|vc|vcp|vdd|vddr|vip|vss|z
+ sg13_lv_nmos L=0.13u W=0.74u AS=0.1406p AD=0.2516p PS=1.12u PD=2.16u rfmode=0
M$816
+ BOTTOM|TOP|VGND|VSS|anode|cathode|core|h_sw[0]|h_sw[10]|h_sw[1]|h_sw[2]|h_sw[3]|h_sw[4]|h_sw[5]|h_sw[6]|h_sw[7]|h_sw[8]|h_sw[9]|l_sw[0]|l_sw[10]|l_sw[1]|l_sw[2]|l_sw[3]|l_sw[4]|l_sw[5]|l_sw[6]|l_sw[7]|l_sw[8]|l_sw[9]|out|pad|padres|vc|vcp|vdd|vddr|vip|vss|z
+ A|Q$9 \$72160
+ BOTTOM|TOP|VGND|VSS|anode|cathode|core|h_sw[0]|h_sw[10]|h_sw[1]|h_sw[2]|h_sw[3]|h_sw[4]|h_sw[5]|h_sw[6]|h_sw[7]|h_sw[8]|h_sw[9]|l_sw[0]|l_sw[10]|l_sw[1]|l_sw[2]|l_sw[3]|l_sw[4]|l_sw[5]|l_sw[6]|l_sw[7]|l_sw[8]|l_sw[9]|out|pad|padres|vc|vcp|vdd|vddr|vip|vss|z
+ sg13_lv_nmos L=0.13u W=0.55u AS=0.14875p AD=0.187p PS=1.16u PD=1.78u rfmode=0
M$817 A|X$19 \$72160
+ BOTTOM|TOP|VGND|VSS|anode|cathode|core|h_sw[0]|h_sw[10]|h_sw[1]|h_sw[2]|h_sw[3]|h_sw[4]|h_sw[5]|h_sw[6]|h_sw[7]|h_sw[8]|h_sw[9]|l_sw[0]|l_sw[10]|l_sw[1]|l_sw[2]|l_sw[3]|l_sw[4]|l_sw[5]|l_sw[6]|l_sw[7]|l_sw[8]|l_sw[9]|out|pad|padres|vc|vcp|vdd|vddr|vip|vss|z
+ BOTTOM|TOP|VGND|VSS|anode|cathode|core|h_sw[0]|h_sw[10]|h_sw[1]|h_sw[2]|h_sw[3]|h_sw[4]|h_sw[5]|h_sw[6]|h_sw[7]|h_sw[8]|h_sw[9]|l_sw[0]|l_sw[10]|l_sw[1]|l_sw[2]|l_sw[3]|l_sw[4]|l_sw[5]|l_sw[6]|l_sw[7]|l_sw[8]|l_sw[9]|out|pad|padres|vc|vcp|vdd|vddr|vip|vss|z
+ sg13_lv_nmos L=0.13u W=0.74u AS=0.2886p AD=0.14875p PS=2.26u PD=1.16u rfmode=0
M$818
+ BOTTOM|TOP|VGND|VSS|anode|cathode|core|h_sw[0]|h_sw[10]|h_sw[1]|h_sw[2]|h_sw[3]|h_sw[4]|h_sw[5]|h_sw[6]|h_sw[7]|h_sw[8]|h_sw[9]|l_sw[0]|l_sw[10]|l_sw[1]|l_sw[2]|l_sw[3]|l_sw[4]|l_sw[5]|l_sw[6]|l_sw[7]|l_sw[8]|l_sw[9]|out|pad|padres|vc|vcp|vdd|vddr|vip|vss|z
+ A|Q$20 \$72161
+ BOTTOM|TOP|VGND|VSS|anode|cathode|core|h_sw[0]|h_sw[10]|h_sw[1]|h_sw[2]|h_sw[3]|h_sw[4]|h_sw[5]|h_sw[6]|h_sw[7]|h_sw[8]|h_sw[9]|l_sw[0]|l_sw[10]|l_sw[1]|l_sw[2]|l_sw[3]|l_sw[4]|l_sw[5]|l_sw[6]|l_sw[7]|l_sw[8]|l_sw[9]|out|pad|padres|vc|vcp|vdd|vddr|vip|vss|z
+ sg13_lv_nmos L=0.13u W=0.55u AS=0.14875p AD=0.187p PS=1.16u PD=1.78u rfmode=0
M$819 A|X$34 \$72161
+ BOTTOM|TOP|VGND|VSS|anode|cathode|core|h_sw[0]|h_sw[10]|h_sw[1]|h_sw[2]|h_sw[3]|h_sw[4]|h_sw[5]|h_sw[6]|h_sw[7]|h_sw[8]|h_sw[9]|l_sw[0]|l_sw[10]|l_sw[1]|l_sw[2]|l_sw[3]|l_sw[4]|l_sw[5]|l_sw[6]|l_sw[7]|l_sw[8]|l_sw[9]|out|pad|padres|vc|vcp|vdd|vddr|vip|vss|z
+ BOTTOM|TOP|VGND|VSS|anode|cathode|core|h_sw[0]|h_sw[10]|h_sw[1]|h_sw[2]|h_sw[3]|h_sw[4]|h_sw[5]|h_sw[6]|h_sw[7]|h_sw[8]|h_sw[9]|l_sw[0]|l_sw[10]|l_sw[1]|l_sw[2]|l_sw[3]|l_sw[4]|l_sw[5]|l_sw[6]|l_sw[7]|l_sw[8]|l_sw[9]|out|pad|padres|vc|vcp|vdd|vddr|vip|vss|z
+ sg13_lv_nmos L=0.13u W=0.74u AS=0.2886p AD=0.14875p PS=2.26u PD=1.16u rfmode=0
M$820 CLK|D|GATE|Q$5 \$72163
+ BOTTOM|TOP|VGND|VSS|anode|cathode|core|h_sw[0]|h_sw[10]|h_sw[1]|h_sw[2]|h_sw[3]|h_sw[4]|h_sw[5]|h_sw[6]|h_sw[7]|h_sw[8]|h_sw[9]|l_sw[0]|l_sw[10]|l_sw[1]|l_sw[2]|l_sw[3]|l_sw[4]|l_sw[5]|l_sw[6]|l_sw[7]|l_sw[8]|l_sw[9]|out|pad|padres|vc|vcp|vdd|vddr|vip|vss|z
+ BOTTOM|TOP|VGND|VSS|anode|cathode|core|h_sw[0]|h_sw[10]|h_sw[1]|h_sw[2]|h_sw[3]|h_sw[4]|h_sw[5]|h_sw[6]|h_sw[7]|h_sw[8]|h_sw[9]|l_sw[0]|l_sw[10]|l_sw[1]|l_sw[2]|l_sw[3]|l_sw[4]|l_sw[5]|l_sw[6]|l_sw[7]|l_sw[8]|l_sw[9]|out|pad|padres|vc|vcp|vdd|vddr|vip|vss|z
+ sg13_lv_nmos L=0.13u W=0.74u AS=0.2516p AD=0.1406p PS=2.16u PD=1.12u rfmode=0
M$821
+ BOTTOM|TOP|VGND|VSS|anode|cathode|core|h_sw[0]|h_sw[10]|h_sw[1]|h_sw[2]|h_sw[3]|h_sw[4]|h_sw[5]|h_sw[6]|h_sw[7]|h_sw[8]|h_sw[9]|l_sw[0]|l_sw[10]|l_sw[1]|l_sw[2]|l_sw[3]|l_sw[4]|l_sw[5]|l_sw[6]|l_sw[7]|l_sw[8]|l_sw[9]|out|pad|padres|vc|vcp|vdd|vddr|vip|vss|z
+ \$72603 \$72163
+ BOTTOM|TOP|VGND|VSS|anode|cathode|core|h_sw[0]|h_sw[10]|h_sw[1]|h_sw[2]|h_sw[3]|h_sw[4]|h_sw[5]|h_sw[6]|h_sw[7]|h_sw[8]|h_sw[9]|l_sw[0]|l_sw[10]|l_sw[1]|l_sw[2]|l_sw[3]|l_sw[4]|l_sw[5]|l_sw[6]|l_sw[7]|l_sw[8]|l_sw[9]|out|pad|padres|vc|vcp|vdd|vddr|vip|vss|z
+ sg13_lv_nmos L=0.13u W=0.74u AS=0.1406p AD=0.2516p PS=1.12u PD=2.16u rfmode=0
M$822 Q_N$18 \$72603
+ BOTTOM|TOP|VGND|VSS|anode|cathode|core|h_sw[0]|h_sw[10]|h_sw[1]|h_sw[2]|h_sw[3]|h_sw[4]|h_sw[5]|h_sw[6]|h_sw[7]|h_sw[8]|h_sw[9]|l_sw[0]|l_sw[10]|l_sw[1]|l_sw[2]|l_sw[3]|l_sw[4]|l_sw[5]|l_sw[6]|l_sw[7]|l_sw[8]|l_sw[9]|out|pad|padres|vc|vcp|vdd|vddr|vip|vss|z
+ BOTTOM|TOP|VGND|VSS|anode|cathode|core|h_sw[0]|h_sw[10]|h_sw[1]|h_sw[2]|h_sw[3]|h_sw[4]|h_sw[5]|h_sw[6]|h_sw[7]|h_sw[8]|h_sw[9]|l_sw[0]|l_sw[10]|l_sw[1]|l_sw[2]|l_sw[3]|l_sw[4]|l_sw[5]|l_sw[6]|l_sw[7]|l_sw[8]|l_sw[9]|out|pad|padres|vc|vcp|vdd|vddr|vip|vss|z
+ sg13_lv_nmos L=0.13u W=0.74u AS=0.2849p AD=0.2516p PS=2.25u PD=2.16u rfmode=0
M$823 \$72603 \$72256 \$72604
+ BOTTOM|TOP|VGND|VSS|anode|cathode|core|h_sw[0]|h_sw[10]|h_sw[1]|h_sw[2]|h_sw[3]|h_sw[4]|h_sw[5]|h_sw[6]|h_sw[7]|h_sw[8]|h_sw[9]|l_sw[0]|l_sw[10]|l_sw[1]|l_sw[2]|l_sw[3]|l_sw[4]|l_sw[5]|l_sw[6]|l_sw[7]|l_sw[8]|l_sw[9]|out|pad|padres|vc|vcp|vdd|vddr|vip|vss|z
+ sg13_lv_nmos L=0.13u W=0.42u AS=0.12665p AD=0.1428p PS=1.145u PD=1.52u
+ rfmode=0
M$824 \$72257 \$72165 \$72603
+ BOTTOM|TOP|VGND|VSS|anode|cathode|core|h_sw[0]|h_sw[10]|h_sw[1]|h_sw[2]|h_sw[3]|h_sw[4]|h_sw[5]|h_sw[6]|h_sw[7]|h_sw[8]|h_sw[9]|l_sw[0]|l_sw[10]|l_sw[1]|l_sw[2]|l_sw[3]|l_sw[4]|l_sw[5]|l_sw[6]|l_sw[7]|l_sw[8]|l_sw[9]|out|pad|padres|vc|vcp|vdd|vddr|vip|vss|z
+ sg13_lv_nmos L=0.13u W=0.74u AS=0.3473p AD=0.12665p PS=2.71u PD=1.145u
+ rfmode=0
M$825 \$72256 A|CLK|X
+ BOTTOM|TOP|VGND|VSS|anode|cathode|core|h_sw[0]|h_sw[10]|h_sw[1]|h_sw[2]|h_sw[3]|h_sw[4]|h_sw[5]|h_sw[6]|h_sw[7]|h_sw[8]|h_sw[9]|l_sw[0]|l_sw[10]|l_sw[1]|l_sw[2]|l_sw[3]|l_sw[4]|l_sw[5]|l_sw[6]|l_sw[7]|l_sw[8]|l_sw[9]|out|pad|padres|vc|vcp|vdd|vddr|vip|vss|z
+ BOTTOM|TOP|VGND|VSS|anode|cathode|core|h_sw[0]|h_sw[10]|h_sw[1]|h_sw[2]|h_sw[3]|h_sw[4]|h_sw[5]|h_sw[6]|h_sw[7]|h_sw[8]|h_sw[9]|l_sw[0]|l_sw[10]|l_sw[1]|l_sw[2]|l_sw[3]|l_sw[4]|l_sw[5]|l_sw[6]|l_sw[7]|l_sw[8]|l_sw[9]|out|pad|padres|vc|vcp|vdd|vddr|vip|vss|z
+ sg13_lv_nmos L=0.13u W=0.74u AS=0.2516p AD=0.317325p PS=2.16u PD=1.805u
+ rfmode=0
M$826
+ BOTTOM|TOP|VGND|VSS|anode|cathode|core|h_sw[0]|h_sw[10]|h_sw[1]|h_sw[2]|h_sw[3]|h_sw[4]|h_sw[5]|h_sw[6]|h_sw[7]|h_sw[8]|h_sw[9]|l_sw[0]|l_sw[10]|l_sw[1]|l_sw[2]|l_sw[3]|l_sw[4]|l_sw[5]|l_sw[6]|l_sw[7]|l_sw[8]|l_sw[9]|out|pad|padres|vc|vcp|vdd|vddr|vip|vss|z
+ \$72256 \$72165
+ BOTTOM|TOP|VGND|VSS|anode|cathode|core|h_sw[0]|h_sw[10]|h_sw[1]|h_sw[2]|h_sw[3]|h_sw[4]|h_sw[5]|h_sw[6]|h_sw[7]|h_sw[8]|h_sw[9]|l_sw[0]|l_sw[10]|l_sw[1]|l_sw[2]|l_sw[3]|l_sw[4]|l_sw[5]|l_sw[6]|l_sw[7]|l_sw[8]|l_sw[9]|out|pad|padres|vc|vcp|vdd|vddr|vip|vss|z
+ sg13_lv_nmos L=0.13u W=0.74u AS=0.317325p AD=0.2516p PS=1.805u PD=2.16u
+ rfmode=0
M$827 \$72605 \$72165 \$72167
+ BOTTOM|TOP|VGND|VSS|anode|cathode|core|h_sw[0]|h_sw[10]|h_sw[1]|h_sw[2]|h_sw[3]|h_sw[4]|h_sw[5]|h_sw[6]|h_sw[7]|h_sw[8]|h_sw[9]|l_sw[0]|l_sw[10]|l_sw[1]|l_sw[2]|l_sw[3]|l_sw[4]|l_sw[5]|l_sw[6]|l_sw[7]|l_sw[8]|l_sw[9]|out|pad|padres|vc|vcp|vdd|vddr|vip|vss|z
+ sg13_lv_nmos L=0.13u W=0.42u AS=0.2373p AD=0.0798p PS=1.97u PD=0.8u rfmode=0
M$828 \$72167 \$72256 \$72166
+ BOTTOM|TOP|VGND|VSS|anode|cathode|core|h_sw[0]|h_sw[10]|h_sw[1]|h_sw[2]|h_sw[3]|h_sw[4]|h_sw[5]|h_sw[6]|h_sw[7]|h_sw[8]|h_sw[9]|l_sw[0]|l_sw[10]|l_sw[1]|l_sw[2]|l_sw[3]|l_sw[4]|l_sw[5]|l_sw[6]|l_sw[7]|l_sw[8]|l_sw[9]|out|pad|padres|vc|vcp|vdd|vddr|vip|vss|z
+ sg13_lv_nmos L=0.13u W=0.42u AS=0.0798p AD=0.1296p PS=0.8u PD=1.52u rfmode=0
M$829 \$72257 \$72167
+ BOTTOM|TOP|VGND|VSS|anode|cathode|core|h_sw[0]|h_sw[10]|h_sw[1]|h_sw[2]|h_sw[3]|h_sw[4]|h_sw[5]|h_sw[6]|h_sw[7]|h_sw[8]|h_sw[9]|l_sw[0]|l_sw[10]|l_sw[1]|l_sw[2]|l_sw[3]|l_sw[4]|l_sw[5]|l_sw[6]|l_sw[7]|l_sw[8]|l_sw[9]|out|pad|padres|vc|vcp|vdd|vddr|vip|vss|z
+ BOTTOM|TOP|VGND|VSS|anode|cathode|core|h_sw[0]|h_sw[10]|h_sw[1]|h_sw[2]|h_sw[3]|h_sw[4]|h_sw[5]|h_sw[6]|h_sw[7]|h_sw[8]|h_sw[9]|l_sw[0]|l_sw[10]|l_sw[1]|l_sw[2]|l_sw[3]|l_sw[4]|l_sw[5]|l_sw[6]|l_sw[7]|l_sw[8]|l_sw[9]|out|pad|padres|vc|vcp|vdd|vddr|vip|vss|z
+ sg13_lv_nmos L=0.13u W=0.74u AS=0.2516p AD=0.1626p PS=2.16u PD=1.415u rfmode=0
M$830
+ BOTTOM|TOP|VGND|VSS|anode|cathode|core|h_sw[0]|h_sw[10]|h_sw[1]|h_sw[2]|h_sw[3]|h_sw[4]|h_sw[5]|h_sw[6]|h_sw[7]|h_sw[8]|h_sw[9]|l_sw[0]|l_sw[10]|l_sw[1]|l_sw[2]|l_sw[3]|l_sw[4]|l_sw[5]|l_sw[6]|l_sw[7]|l_sw[8]|l_sw[9]|out|pad|padres|vc|vcp|vdd|vddr|vip|vss|z
+ RESET_B|Y$2 \$72945
+ BOTTOM|TOP|VGND|VSS|anode|cathode|core|h_sw[0]|h_sw[10]|h_sw[1]|h_sw[2]|h_sw[3]|h_sw[4]|h_sw[5]|h_sw[6]|h_sw[7]|h_sw[8]|h_sw[9]|l_sw[0]|l_sw[10]|l_sw[1]|l_sw[2]|l_sw[3]|l_sw[4]|l_sw[5]|l_sw[6]|l_sw[7]|l_sw[8]|l_sw[9]|out|pad|padres|vc|vcp|vdd|vddr|vip|vss|z
+ sg13_lv_nmos L=0.13u W=0.42u AS=0.1626p AD=0.0609p PS=1.415u PD=0.71u rfmode=0
M$831 \$72945 CLK|D|GATE|Q$3 \$72166
+ BOTTOM|TOP|VGND|VSS|anode|cathode|core|h_sw[0]|h_sw[10]|h_sw[1]|h_sw[2]|h_sw[3]|h_sw[4]|h_sw[5]|h_sw[6]|h_sw[7]|h_sw[8]|h_sw[9]|l_sw[0]|l_sw[10]|l_sw[1]|l_sw[2]|l_sw[3]|l_sw[4]|l_sw[5]|l_sw[6]|l_sw[7]|l_sw[8]|l_sw[9]|out|pad|padres|vc|vcp|vdd|vddr|vip|vss|z
+ sg13_lv_nmos L=0.13u W=0.42u AS=0.0609p AD=0.1428p PS=0.71u PD=1.52u rfmode=0
M$832 \$72168 A2|D|Q
+ BOTTOM|TOP|VGND|VSS|anode|cathode|core|h_sw[0]|h_sw[10]|h_sw[1]|h_sw[2]|h_sw[3]|h_sw[4]|h_sw[5]|h_sw[6]|h_sw[7]|h_sw[8]|h_sw[9]|l_sw[0]|l_sw[10]|l_sw[1]|l_sw[2]|l_sw[3]|l_sw[4]|l_sw[5]|l_sw[6]|l_sw[7]|l_sw[8]|l_sw[9]|out|pad|padres|vc|vcp|vdd|vddr|vip|vss|z
+ BOTTOM|TOP|VGND|VSS|anode|cathode|core|h_sw[0]|h_sw[10]|h_sw[1]|h_sw[2]|h_sw[3]|h_sw[4]|h_sw[5]|h_sw[6]|h_sw[7]|h_sw[8]|h_sw[9]|l_sw[0]|l_sw[10]|l_sw[1]|l_sw[2]|l_sw[3]|l_sw[4]|l_sw[5]|l_sw[6]|l_sw[7]|l_sw[8]|l_sw[9]|out|pad|padres|vc|vcp|vdd|vddr|vip|vss|z
+ sg13_lv_nmos L=0.13u W=0.55u AS=0.187p AD=0.15055p PS=1.78u PD=1.17u rfmode=0
M$833
+ BOTTOM|TOP|VGND|VSS|anode|cathode|core|h_sw[0]|h_sw[10]|h_sw[1]|h_sw[2]|h_sw[3]|h_sw[4]|h_sw[5]|h_sw[6]|h_sw[7]|h_sw[8]|h_sw[9]|l_sw[0]|l_sw[10]|l_sw[1]|l_sw[2]|l_sw[3]|l_sw[4]|l_sw[5]|l_sw[6]|l_sw[7]|l_sw[8]|l_sw[9]|out|pad|padres|vc|vcp|vdd|vddr|vip|vss|z
+ CLK|D|GATE|Q$3 \$72258
+ BOTTOM|TOP|VGND|VSS|anode|cathode|core|h_sw[0]|h_sw[10]|h_sw[1]|h_sw[2]|h_sw[3]|h_sw[4]|h_sw[5]|h_sw[6]|h_sw[7]|h_sw[8]|h_sw[9]|l_sw[0]|l_sw[10]|l_sw[1]|l_sw[2]|l_sw[3]|l_sw[4]|l_sw[5]|l_sw[6]|l_sw[7]|l_sw[8]|l_sw[9]|out|pad|padres|vc|vcp|vdd|vddr|vip|vss|z
+ sg13_lv_nmos L=0.13u W=0.74u AS=0.15055p AD=0.2516p PS=1.17u PD=2.16u rfmode=0
M$834 \$72169 \$72258 \$72946
+ BOTTOM|TOP|VGND|VSS|anode|cathode|core|h_sw[0]|h_sw[10]|h_sw[1]|h_sw[2]|h_sw[3]|h_sw[4]|h_sw[5]|h_sw[6]|h_sw[7]|h_sw[8]|h_sw[9]|l_sw[0]|l_sw[10]|l_sw[1]|l_sw[2]|l_sw[3]|l_sw[4]|l_sw[5]|l_sw[6]|l_sw[7]|l_sw[8]|l_sw[9]|out|pad|padres|vc|vcp|vdd|vddr|vip|vss|z
+ sg13_lv_nmos L=0.13u W=0.42u AS=0.141p AD=0.04725p PS=1.17u PD=0.645u rfmode=0
M$835 \$72946 \$72170
+ BOTTOM|TOP|VGND|VSS|anode|cathode|core|h_sw[0]|h_sw[10]|h_sw[1]|h_sw[2]|h_sw[3]|h_sw[4]|h_sw[5]|h_sw[6]|h_sw[7]|h_sw[8]|h_sw[9]|l_sw[0]|l_sw[10]|l_sw[1]|l_sw[2]|l_sw[3]|l_sw[4]|l_sw[5]|l_sw[6]|l_sw[7]|l_sw[8]|l_sw[9]|out|pad|padres|vc|vcp|vdd|vddr|vip|vss|z
+ BOTTOM|TOP|VGND|VSS|anode|cathode|core|h_sw[0]|h_sw[10]|h_sw[1]|h_sw[2]|h_sw[3]|h_sw[4]|h_sw[5]|h_sw[6]|h_sw[7]|h_sw[8]|h_sw[9]|l_sw[0]|l_sw[10]|l_sw[1]|l_sw[2]|l_sw[3]|l_sw[4]|l_sw[5]|l_sw[6]|l_sw[7]|l_sw[8]|l_sw[9]|out|pad|padres|vc|vcp|vdd|vddr|vip|vss|z
+ sg13_lv_nmos L=0.13u W=0.42u AS=0.04725p AD=0.1428p PS=0.645u PD=1.52u
+ rfmode=0
M$836 \$72259 \$72258
+ BOTTOM|TOP|VGND|VSS|anode|cathode|core|h_sw[0]|h_sw[10]|h_sw[1]|h_sw[2]|h_sw[3]|h_sw[4]|h_sw[5]|h_sw[6]|h_sw[7]|h_sw[8]|h_sw[9]|l_sw[0]|l_sw[10]|l_sw[1]|l_sw[2]|l_sw[3]|l_sw[4]|l_sw[5]|l_sw[6]|l_sw[7]|l_sw[8]|l_sw[9]|out|pad|padres|vc|vcp|vdd|vddr|vip|vss|z
+ BOTTOM|TOP|VGND|VSS|anode|cathode|core|h_sw[0]|h_sw[10]|h_sw[1]|h_sw[2]|h_sw[3]|h_sw[4]|h_sw[5]|h_sw[6]|h_sw[7]|h_sw[8]|h_sw[9]|l_sw[0]|l_sw[10]|l_sw[1]|l_sw[2]|l_sw[3]|l_sw[4]|l_sw[5]|l_sw[6]|l_sw[7]|l_sw[8]|l_sw[9]|out|pad|padres|vc|vcp|vdd|vddr|vip|vss|z
+ sg13_lv_nmos L=0.13u W=0.74u AS=0.2775p AD=0.213425p PS=2.23u PD=1.62u
+ rfmode=0
M$837
+ BOTTOM|TOP|VGND|VSS|anode|cathode|core|h_sw[0]|h_sw[10]|h_sw[1]|h_sw[2]|h_sw[3]|h_sw[4]|h_sw[5]|h_sw[6]|h_sw[7]|h_sw[8]|h_sw[9]|l_sw[0]|l_sw[10]|l_sw[1]|l_sw[2]|l_sw[3]|l_sw[4]|l_sw[5]|l_sw[6]|l_sw[7]|l_sw[8]|l_sw[9]|out|pad|padres|vc|vcp|vdd|vddr|vip|vss|z
+ \$72168 \$72947
+ BOTTOM|TOP|VGND|VSS|anode|cathode|core|h_sw[0]|h_sw[10]|h_sw[1]|h_sw[2]|h_sw[3]|h_sw[4]|h_sw[5]|h_sw[6]|h_sw[7]|h_sw[8]|h_sw[9]|l_sw[0]|l_sw[10]|l_sw[1]|l_sw[2]|l_sw[3]|l_sw[4]|l_sw[5]|l_sw[6]|l_sw[7]|l_sw[8]|l_sw[9]|out|pad|padres|vc|vcp|vdd|vddr|vip|vss|z
+ sg13_lv_nmos L=0.13u W=0.64u AS=0.213425p AD=0.072p PS=1.62u PD=0.865u
+ rfmode=0
M$838 \$72947 \$72259 \$72169
+ BOTTOM|TOP|VGND|VSS|anode|cathode|core|h_sw[0]|h_sw[10]|h_sw[1]|h_sw[2]|h_sw[3]|h_sw[4]|h_sw[5]|h_sw[6]|h_sw[7]|h_sw[8]|h_sw[9]|l_sw[0]|l_sw[10]|l_sw[1]|l_sw[2]|l_sw[3]|l_sw[4]|l_sw[5]|l_sw[6]|l_sw[7]|l_sw[8]|l_sw[9]|out|pad|padres|vc|vcp|vdd|vddr|vip|vss|z
+ sg13_lv_nmos L=0.13u W=0.64u AS=0.072p AD=0.141p PS=0.865u PD=1.17u rfmode=0
M$839 A|Y$19 A|X$25
+ BOTTOM|TOP|VGND|VSS|anode|cathode|core|h_sw[0]|h_sw[10]|h_sw[1]|h_sw[2]|h_sw[3]|h_sw[4]|h_sw[5]|h_sw[6]|h_sw[7]|h_sw[8]|h_sw[9]|l_sw[0]|l_sw[10]|l_sw[1]|l_sw[2]|l_sw[3]|l_sw[4]|l_sw[5]|l_sw[6]|l_sw[7]|l_sw[8]|l_sw[9]|out|pad|padres|vc|vcp|vdd|vddr|vip|vss|z
+ BOTTOM|TOP|VGND|VSS|anode|cathode|core|h_sw[0]|h_sw[10]|h_sw[1]|h_sw[2]|h_sw[3]|h_sw[4]|h_sw[5]|h_sw[6]|h_sw[7]|h_sw[8]|h_sw[9]|l_sw[0]|l_sw[10]|l_sw[1]|l_sw[2]|l_sw[3]|l_sw[4]|l_sw[5]|l_sw[6]|l_sw[7]|l_sw[8]|l_sw[9]|out|pad|padres|vc|vcp|vdd|vddr|vip|vss|z
+ sg13_lv_nmos L=0.13u W=0.74u AS=0.2516p AD=0.2516p PS=2.16u PD=2.16u rfmode=0
M$840 B2|Y C1|X$1
+ BOTTOM|TOP|VGND|VSS|anode|cathode|core|h_sw[0]|h_sw[10]|h_sw[1]|h_sw[2]|h_sw[3]|h_sw[4]|h_sw[5]|h_sw[6]|h_sw[7]|h_sw[8]|h_sw[9]|l_sw[0]|l_sw[10]|l_sw[1]|l_sw[2]|l_sw[3]|l_sw[4]|l_sw[5]|l_sw[6]|l_sw[7]|l_sw[8]|l_sw[9]|out|pad|padres|vc|vcp|vdd|vddr|vip|vss|z
+ BOTTOM|TOP|VGND|VSS|anode|cathode|core|h_sw[0]|h_sw[10]|h_sw[1]|h_sw[2]|h_sw[3]|h_sw[4]|h_sw[5]|h_sw[6]|h_sw[7]|h_sw[8]|h_sw[9]|l_sw[0]|l_sw[10]|l_sw[1]|l_sw[2]|l_sw[3]|l_sw[4]|l_sw[5]|l_sw[6]|l_sw[7]|l_sw[8]|l_sw[9]|out|pad|padres|vc|vcp|vdd|vddr|vip|vss|z
+ sg13_lv_nmos L=0.13u W=0.74u AS=0.2516p AD=0.1406p PS=2.16u PD=1.12u rfmode=0
M$841
+ BOTTOM|TOP|VGND|VSS|anode|cathode|core|h_sw[0]|h_sw[10]|h_sw[1]|h_sw[2]|h_sw[3]|h_sw[4]|h_sw[5]|h_sw[6]|h_sw[7]|h_sw[8]|h_sw[9]|l_sw[0]|l_sw[10]|l_sw[1]|l_sw[2]|l_sw[3]|l_sw[4]|l_sw[5]|l_sw[6]|l_sw[7]|l_sw[8]|l_sw[9]|out|pad|padres|vc|vcp|vdd|vddr|vip|vss|z
+ B2|D|Q \$72949
+ BOTTOM|TOP|VGND|VSS|anode|cathode|core|h_sw[0]|h_sw[10]|h_sw[1]|h_sw[2]|h_sw[3]|h_sw[4]|h_sw[5]|h_sw[6]|h_sw[7]|h_sw[8]|h_sw[9]|l_sw[0]|l_sw[10]|l_sw[1]|l_sw[2]|l_sw[3]|l_sw[4]|l_sw[5]|l_sw[6]|l_sw[7]|l_sw[8]|l_sw[9]|out|pad|padres|vc|vcp|vdd|vddr|vip|vss|z
+ sg13_lv_nmos L=0.13u W=0.74u AS=0.1406p AD=0.1406p PS=1.12u PD=1.12u rfmode=0
M$842 \$72949 A2|B|B1|C1|Y B2|Y
+ BOTTOM|TOP|VGND|VSS|anode|cathode|core|h_sw[0]|h_sw[10]|h_sw[1]|h_sw[2]|h_sw[3]|h_sw[4]|h_sw[5]|h_sw[6]|h_sw[7]|h_sw[8]|h_sw[9]|l_sw[0]|l_sw[10]|l_sw[1]|l_sw[2]|l_sw[3]|l_sw[4]|l_sw[5]|l_sw[6]|l_sw[7]|l_sw[8]|l_sw[9]|out|pad|padres|vc|vcp|vdd|vddr|vip|vss|z
+ sg13_lv_nmos L=0.13u W=0.74u AS=0.1406p AD=0.2516p PS=1.12u PD=2.16u rfmode=0
M$843 B2|Y A1|D|Q$3 \$72952
+ BOTTOM|TOP|VGND|VSS|anode|cathode|core|h_sw[0]|h_sw[10]|h_sw[1]|h_sw[2]|h_sw[3]|h_sw[4]|h_sw[5]|h_sw[6]|h_sw[7]|h_sw[8]|h_sw[9]|l_sw[0]|l_sw[10]|l_sw[1]|l_sw[2]|l_sw[3]|l_sw[4]|l_sw[5]|l_sw[6]|l_sw[7]|l_sw[8]|l_sw[9]|out|pad|padres|vc|vcp|vdd|vddr|vip|vss|z
+ sg13_lv_nmos L=0.13u W=0.74u AS=0.2516p AD=0.1406p PS=2.16u PD=1.12u rfmode=0
M$844 \$72952 A2|B|B1|Y$1
+ BOTTOM|TOP|VGND|VSS|anode|cathode|core|h_sw[0]|h_sw[10]|h_sw[1]|h_sw[2]|h_sw[3]|h_sw[4]|h_sw[5]|h_sw[6]|h_sw[7]|h_sw[8]|h_sw[9]|l_sw[0]|l_sw[10]|l_sw[1]|l_sw[2]|l_sw[3]|l_sw[4]|l_sw[5]|l_sw[6]|l_sw[7]|l_sw[8]|l_sw[9]|out|pad|padres|vc|vcp|vdd|vddr|vip|vss|z
+ BOTTOM|TOP|VGND|VSS|anode|cathode|core|h_sw[0]|h_sw[10]|h_sw[1]|h_sw[2]|h_sw[3]|h_sw[4]|h_sw[5]|h_sw[6]|h_sw[7]|h_sw[8]|h_sw[9]|l_sw[0]|l_sw[10]|l_sw[1]|l_sw[2]|l_sw[3]|l_sw[4]|l_sw[5]|l_sw[6]|l_sw[7]|l_sw[8]|l_sw[9]|out|pad|padres|vc|vcp|vdd|vddr|vip|vss|z
+ sg13_lv_nmos L=0.13u W=0.74u AS=0.1406p AD=0.2516p PS=1.12u PD=2.16u rfmode=0
M$845
+ BOTTOM|TOP|VGND|VSS|anode|cathode|core|h_sw[0]|h_sw[10]|h_sw[1]|h_sw[2]|h_sw[3]|h_sw[4]|h_sw[5]|h_sw[6]|h_sw[7]|h_sw[8]|h_sw[9]|l_sw[0]|l_sw[10]|l_sw[1]|l_sw[2]|l_sw[3]|l_sw[4]|l_sw[5]|l_sw[6]|l_sw[7]|l_sw[8]|l_sw[9]|out|pad|padres|vc|vcp|vdd|vddr|vip|vss|z
+ C|D|Q \$72951
+ BOTTOM|TOP|VGND|VSS|anode|cathode|core|h_sw[0]|h_sw[10]|h_sw[1]|h_sw[2]|h_sw[3]|h_sw[4]|h_sw[5]|h_sw[6]|h_sw[7]|h_sw[8]|h_sw[9]|l_sw[0]|l_sw[10]|l_sw[1]|l_sw[2]|l_sw[3]|l_sw[4]|l_sw[5]|l_sw[6]|l_sw[7]|l_sw[8]|l_sw[9]|out|pad|padres|vc|vcp|vdd|vddr|vip|vss|z
+ sg13_lv_nmos L=0.13u W=0.64u AS=0.1371p AD=0.1216p PS=1.12u PD=1.02u rfmode=0
M$846 \$72951 A|B|B2|B_N|Q \$72950
+ BOTTOM|TOP|VGND|VSS|anode|cathode|core|h_sw[0]|h_sw[10]|h_sw[1]|h_sw[2]|h_sw[3]|h_sw[4]|h_sw[5]|h_sw[6]|h_sw[7]|h_sw[8]|h_sw[9]|l_sw[0]|l_sw[10]|l_sw[1]|l_sw[2]|l_sw[3]|l_sw[4]|l_sw[5]|l_sw[6]|l_sw[7]|l_sw[8]|l_sw[9]|out|pad|padres|vc|vcp|vdd|vddr|vip|vss|z
+ sg13_lv_nmos L=0.13u W=0.64u AS=0.1216p AD=0.1216p PS=1.02u PD=1.02u rfmode=0
M$847 \$72950 A|B_N|Q \$72177
+ BOTTOM|TOP|VGND|VSS|anode|cathode|core|h_sw[0]|h_sw[10]|h_sw[1]|h_sw[2]|h_sw[3]|h_sw[4]|h_sw[5]|h_sw[6]|h_sw[7]|h_sw[8]|h_sw[9]|l_sw[0]|l_sw[10]|l_sw[1]|l_sw[2]|l_sw[3]|l_sw[4]|l_sw[5]|l_sw[6]|l_sw[7]|l_sw[8]|l_sw[9]|out|pad|padres|vc|vcp|vdd|vddr|vip|vss|z
+ sg13_lv_nmos L=0.13u W=0.64u AS=0.1216p AD=0.2176p PS=1.02u PD=1.96u rfmode=0
M$848 C1|X$1 \$72177
+ BOTTOM|TOP|VGND|VSS|anode|cathode|core|h_sw[0]|h_sw[10]|h_sw[1]|h_sw[2]|h_sw[3]|h_sw[4]|h_sw[5]|h_sw[6]|h_sw[7]|h_sw[8]|h_sw[9]|l_sw[0]|l_sw[10]|l_sw[1]|l_sw[2]|l_sw[3]|l_sw[4]|l_sw[5]|l_sw[6]|l_sw[7]|l_sw[8]|l_sw[9]|out|pad|padres|vc|vcp|vdd|vddr|vip|vss|z
+ BOTTOM|TOP|VGND|VSS|anode|cathode|core|h_sw[0]|h_sw[10]|h_sw[1]|h_sw[2]|h_sw[3]|h_sw[4]|h_sw[5]|h_sw[6]|h_sw[7]|h_sw[8]|h_sw[9]|l_sw[0]|l_sw[10]|l_sw[1]|l_sw[2]|l_sw[3]|l_sw[4]|l_sw[5]|l_sw[6]|l_sw[7]|l_sw[8]|l_sw[9]|out|pad|padres|vc|vcp|vdd|vddr|vip|vss|z
+ sg13_lv_nmos L=0.13u W=0.74u AS=0.2516p AD=0.1371p PS=2.16u PD=1.12u rfmode=0
M$849
+ BOTTOM|TOP|VGND|VSS|anode|cathode|core|h_sw[0]|h_sw[10]|h_sw[1]|h_sw[2]|h_sw[3]|h_sw[4]|h_sw[5]|h_sw[6]|h_sw[7]|h_sw[8]|h_sw[9]|l_sw[0]|l_sw[10]|l_sw[1]|l_sw[2]|l_sw[3]|l_sw[4]|l_sw[5]|l_sw[6]|l_sw[7]|l_sw[8]|l_sw[9]|out|pad|padres|vc|vcp|vdd|vddr|vip|vss|z
+ A2|B1|Y B2|Y$1
+ BOTTOM|TOP|VGND|VSS|anode|cathode|core|h_sw[0]|h_sw[10]|h_sw[1]|h_sw[2]|h_sw[3]|h_sw[4]|h_sw[5]|h_sw[6]|h_sw[7]|h_sw[8]|h_sw[9]|l_sw[0]|l_sw[10]|l_sw[1]|l_sw[2]|l_sw[3]|l_sw[4]|l_sw[5]|l_sw[6]|l_sw[7]|l_sw[8]|l_sw[9]|out|pad|padres|vc|vcp|vdd|vddr|vip|vss|z
+ sg13_lv_nmos L=0.13u W=0.74u AS=0.2516p AD=0.1406p PS=2.16u PD=1.12u rfmode=0
M$850 B2|Y$1 A1|Y$4 \$72953
+ BOTTOM|TOP|VGND|VSS|anode|cathode|core|h_sw[0]|h_sw[10]|h_sw[1]|h_sw[2]|h_sw[3]|h_sw[4]|h_sw[5]|h_sw[6]|h_sw[7]|h_sw[8]|h_sw[9]|l_sw[0]|l_sw[10]|l_sw[1]|l_sw[2]|l_sw[3]|l_sw[4]|l_sw[5]|l_sw[6]|l_sw[7]|l_sw[8]|l_sw[9]|out|pad|padres|vc|vcp|vdd|vddr|vip|vss|z
+ sg13_lv_nmos L=0.13u W=0.74u AS=0.1406p AD=0.1406p PS=1.12u PD=1.12u rfmode=0
M$851 \$72953 A2|B|B1|Y$1
+ BOTTOM|TOP|VGND|VSS|anode|cathode|core|h_sw[0]|h_sw[10]|h_sw[1]|h_sw[2]|h_sw[3]|h_sw[4]|h_sw[5]|h_sw[6]|h_sw[7]|h_sw[8]|h_sw[9]|l_sw[0]|l_sw[10]|l_sw[1]|l_sw[2]|l_sw[3]|l_sw[4]|l_sw[5]|l_sw[6]|l_sw[7]|l_sw[8]|l_sw[9]|out|pad|padres|vc|vcp|vdd|vddr|vip|vss|z
+ BOTTOM|TOP|VGND|VSS|anode|cathode|core|h_sw[0]|h_sw[10]|h_sw[1]|h_sw[2]|h_sw[3]|h_sw[4]|h_sw[5]|h_sw[6]|h_sw[7]|h_sw[8]|h_sw[9]|l_sw[0]|l_sw[10]|l_sw[1]|l_sw[2]|l_sw[3]|l_sw[4]|l_sw[5]|l_sw[6]|l_sw[7]|l_sw[8]|l_sw[9]|out|pad|padres|vc|vcp|vdd|vddr|vip|vss|z
+ sg13_lv_nmos L=0.13u W=0.74u AS=0.1406p AD=0.2516p PS=1.12u PD=2.16u rfmode=0
M$852
+ BOTTOM|TOP|VGND|VSS|anode|cathode|core|h_sw[0]|h_sw[10]|h_sw[1]|h_sw[2]|h_sw[3]|h_sw[4]|h_sw[5]|h_sw[6]|h_sw[7]|h_sw[8]|h_sw[9]|l_sw[0]|l_sw[10]|l_sw[1]|l_sw[2]|l_sw[3]|l_sw[4]|l_sw[5]|l_sw[6]|l_sw[7]|l_sw[8]|l_sw[9]|out|pad|padres|vc|vcp|vdd|vddr|vip|vss|z
+ A|B|B2|B_N|Q \$72181
+ BOTTOM|TOP|VGND|VSS|anode|cathode|core|h_sw[0]|h_sw[10]|h_sw[1]|h_sw[2]|h_sw[3]|h_sw[4]|h_sw[5]|h_sw[6]|h_sw[7]|h_sw[8]|h_sw[9]|l_sw[0]|l_sw[10]|l_sw[1]|l_sw[2]|l_sw[3]|l_sw[4]|l_sw[5]|l_sw[6]|l_sw[7]|l_sw[8]|l_sw[9]|out|pad|padres|vc|vcp|vdd|vddr|vip|vss|z
+ sg13_lv_nmos L=0.13u W=0.55u AS=0.17255p AD=0.187p PS=1.25u PD=1.78u rfmode=0
M$853
+ BOTTOM|TOP|VGND|VSS|anode|cathode|core|h_sw[0]|h_sw[10]|h_sw[1]|h_sw[2]|h_sw[3]|h_sw[4]|h_sw[5]|h_sw[6]|h_sw[7]|h_sw[8]|h_sw[9]|l_sw[0]|l_sw[10]|l_sw[1]|l_sw[2]|l_sw[3]|l_sw[4]|l_sw[5]|l_sw[6]|l_sw[7]|l_sw[8]|l_sw[9]|out|pad|padres|vc|vcp|vdd|vddr|vip|vss|z
+ A|B_N|Q A2|B|B1|Y$1
+ BOTTOM|TOP|VGND|VSS|anode|cathode|core|h_sw[0]|h_sw[10]|h_sw[1]|h_sw[2]|h_sw[3]|h_sw[4]|h_sw[5]|h_sw[6]|h_sw[7]|h_sw[8]|h_sw[9]|l_sw[0]|l_sw[10]|l_sw[1]|l_sw[2]|l_sw[3]|l_sw[4]|l_sw[5]|l_sw[6]|l_sw[7]|l_sw[8]|l_sw[9]|out|pad|padres|vc|vcp|vdd|vddr|vip|vss|z
+ sg13_lv_nmos L=0.13u W=0.74u AS=0.2516p AD=0.1406p PS=2.16u PD=1.12u rfmode=0
M$854 A2|B|B1|Y$1 \$72181
+ BOTTOM|TOP|VGND|VSS|anode|cathode|core|h_sw[0]|h_sw[10]|h_sw[1]|h_sw[2]|h_sw[3]|h_sw[4]|h_sw[5]|h_sw[6]|h_sw[7]|h_sw[8]|h_sw[9]|l_sw[0]|l_sw[10]|l_sw[1]|l_sw[2]|l_sw[3]|l_sw[4]|l_sw[5]|l_sw[6]|l_sw[7]|l_sw[8]|l_sw[9]|out|pad|padres|vc|vcp|vdd|vddr|vip|vss|z
+ BOTTOM|TOP|VGND|VSS|anode|cathode|core|h_sw[0]|h_sw[10]|h_sw[1]|h_sw[2]|h_sw[3]|h_sw[4]|h_sw[5]|h_sw[6]|h_sw[7]|h_sw[8]|h_sw[9]|l_sw[0]|l_sw[10]|l_sw[1]|l_sw[2]|l_sw[3]|l_sw[4]|l_sw[5]|l_sw[6]|l_sw[7]|l_sw[8]|l_sw[9]|out|pad|padres|vc|vcp|vdd|vddr|vip|vss|z
+ sg13_lv_nmos L=0.13u W=0.74u AS=0.1406p AD=0.17255p PS=1.12u PD=1.25u rfmode=0
M$855
+ BOTTOM|TOP|VGND|VSS|anode|cathode|core|h_sw[0]|h_sw[10]|h_sw[1]|h_sw[2]|h_sw[3]|h_sw[4]|h_sw[5]|h_sw[6]|h_sw[7]|h_sw[8]|h_sw[9]|l_sw[0]|l_sw[10]|l_sw[1]|l_sw[2]|l_sw[3]|l_sw[4]|l_sw[5]|l_sw[6]|l_sw[7]|l_sw[8]|l_sw[9]|out|pad|padres|vc|vcp|vdd|vddr|vip|vss|z
+ A2|B1|Y \$72955
+ BOTTOM|TOP|VGND|VSS|anode|cathode|core|h_sw[0]|h_sw[10]|h_sw[1]|h_sw[2]|h_sw[3]|h_sw[4]|h_sw[5]|h_sw[6]|h_sw[7]|h_sw[8]|h_sw[9]|l_sw[0]|l_sw[10]|l_sw[1]|l_sw[2]|l_sw[3]|l_sw[4]|l_sw[5]|l_sw[6]|l_sw[7]|l_sw[8]|l_sw[9]|out|pad|padres|vc|vcp|vdd|vddr|vip|vss|z
+ sg13_lv_nmos L=0.13u W=0.74u AS=0.2516p AD=0.1406p PS=2.16u PD=1.12u rfmode=0
M$856 \$72955 A1|D|Q$2 B2|Y$2
+ BOTTOM|TOP|VGND|VSS|anode|cathode|core|h_sw[0]|h_sw[10]|h_sw[1]|h_sw[2]|h_sw[3]|h_sw[4]|h_sw[5]|h_sw[6]|h_sw[7]|h_sw[8]|h_sw[9]|l_sw[0]|l_sw[10]|l_sw[1]|l_sw[2]|l_sw[3]|l_sw[4]|l_sw[5]|l_sw[6]|l_sw[7]|l_sw[8]|l_sw[9]|out|pad|padres|vc|vcp|vdd|vddr|vip|vss|z
+ sg13_lv_nmos L=0.13u W=0.74u AS=0.1406p AD=0.2516p PS=1.12u PD=2.16u rfmode=0
M$857 B2|Y$2 A2|B|B1|Y$1 \$72954
+ BOTTOM|TOP|VGND|VSS|anode|cathode|core|h_sw[0]|h_sw[10]|h_sw[1]|h_sw[2]|h_sw[3]|h_sw[4]|h_sw[5]|h_sw[6]|h_sw[7]|h_sw[8]|h_sw[9]|l_sw[0]|l_sw[10]|l_sw[1]|l_sw[2]|l_sw[3]|l_sw[4]|l_sw[5]|l_sw[6]|l_sw[7]|l_sw[8]|l_sw[9]|out|pad|padres|vc|vcp|vdd|vddr|vip|vss|z
+ sg13_lv_nmos L=0.13u W=0.74u AS=0.2516p AD=0.1406p PS=2.16u PD=1.12u rfmode=0
M$858 \$72954 B2|D|Q$1
+ BOTTOM|TOP|VGND|VSS|anode|cathode|core|h_sw[0]|h_sw[10]|h_sw[1]|h_sw[2]|h_sw[3]|h_sw[4]|h_sw[5]|h_sw[6]|h_sw[7]|h_sw[8]|h_sw[9]|l_sw[0]|l_sw[10]|l_sw[1]|l_sw[2]|l_sw[3]|l_sw[4]|l_sw[5]|l_sw[6]|l_sw[7]|l_sw[8]|l_sw[9]|out|pad|padres|vc|vcp|vdd|vddr|vip|vss|z
+ BOTTOM|TOP|VGND|VSS|anode|cathode|core|h_sw[0]|h_sw[10]|h_sw[1]|h_sw[2]|h_sw[3]|h_sw[4]|h_sw[5]|h_sw[6]|h_sw[7]|h_sw[8]|h_sw[9]|l_sw[0]|l_sw[10]|l_sw[1]|l_sw[2]|l_sw[3]|l_sw[4]|l_sw[5]|l_sw[6]|l_sw[7]|l_sw[8]|l_sw[9]|out|pad|padres|vc|vcp|vdd|vddr|vip|vss|z
+ sg13_lv_nmos L=0.13u W=0.74u AS=0.1406p AD=0.1406p PS=1.12u PD=1.12u rfmode=0
M$859
+ BOTTOM|TOP|VGND|VSS|anode|cathode|core|h_sw[0]|h_sw[10]|h_sw[1]|h_sw[2]|h_sw[3]|h_sw[4]|h_sw[5]|h_sw[6]|h_sw[7]|h_sw[8]|h_sw[9]|l_sw[0]|l_sw[10]|l_sw[1]|l_sw[2]|l_sw[3]|l_sw[4]|l_sw[5]|l_sw[6]|l_sw[7]|l_sw[8]|l_sw[9]|out|pad|padres|vc|vcp|vdd|vddr|vip|vss|z
+ C1|X B2|Y$2
+ BOTTOM|TOP|VGND|VSS|anode|cathode|core|h_sw[0]|h_sw[10]|h_sw[1]|h_sw[2]|h_sw[3]|h_sw[4]|h_sw[5]|h_sw[6]|h_sw[7]|h_sw[8]|h_sw[9]|l_sw[0]|l_sw[10]|l_sw[1]|l_sw[2]|l_sw[3]|l_sw[4]|l_sw[5]|l_sw[6]|l_sw[7]|l_sw[8]|l_sw[9]|out|pad|padres|vc|vcp|vdd|vddr|vip|vss|z
+ sg13_lv_nmos L=0.13u W=0.74u AS=0.1406p AD=0.2516p PS=1.12u PD=2.16u rfmode=0
M$860 \$72185 D|Q_N$4
+ BOTTOM|TOP|VGND|VSS|anode|cathode|core|h_sw[0]|h_sw[10]|h_sw[1]|h_sw[2]|h_sw[3]|h_sw[4]|h_sw[5]|h_sw[6]|h_sw[7]|h_sw[8]|h_sw[9]|l_sw[0]|l_sw[10]|l_sw[1]|l_sw[2]|l_sw[3]|l_sw[4]|l_sw[5]|l_sw[6]|l_sw[7]|l_sw[8]|l_sw[9]|out|pad|padres|vc|vcp|vdd|vddr|vip|vss|z
+ BOTTOM|TOP|VGND|VSS|anode|cathode|core|h_sw[0]|h_sw[10]|h_sw[1]|h_sw[2]|h_sw[3]|h_sw[4]|h_sw[5]|h_sw[6]|h_sw[7]|h_sw[8]|h_sw[9]|l_sw[0]|l_sw[10]|l_sw[1]|l_sw[2]|l_sw[3]|l_sw[4]|l_sw[5]|l_sw[6]|l_sw[7]|l_sw[8]|l_sw[9]|out|pad|padres|vc|vcp|vdd|vddr|vip|vss|z
+ sg13_lv_nmos L=0.13u W=0.55u AS=0.187p AD=0.15055p PS=1.78u PD=1.17u rfmode=0
M$861
+ BOTTOM|TOP|VGND|VSS|anode|cathode|core|h_sw[0]|h_sw[10]|h_sw[1]|h_sw[2]|h_sw[3]|h_sw[4]|h_sw[5]|h_sw[6]|h_sw[7]|h_sw[8]|h_sw[9]|l_sw[0]|l_sw[10]|l_sw[1]|l_sw[2]|l_sw[3]|l_sw[4]|l_sw[5]|l_sw[6]|l_sw[7]|l_sw[8]|l_sw[9]|out|pad|padres|vc|vcp|vdd|vddr|vip|vss|z
+ CLK|D|GATE|Q$7 \$72266
+ BOTTOM|TOP|VGND|VSS|anode|cathode|core|h_sw[0]|h_sw[10]|h_sw[1]|h_sw[2]|h_sw[3]|h_sw[4]|h_sw[5]|h_sw[6]|h_sw[7]|h_sw[8]|h_sw[9]|l_sw[0]|l_sw[10]|l_sw[1]|l_sw[2]|l_sw[3]|l_sw[4]|l_sw[5]|l_sw[6]|l_sw[7]|l_sw[8]|l_sw[9]|out|pad|padres|vc|vcp|vdd|vddr|vip|vss|z
+ sg13_lv_nmos L=0.13u W=0.74u AS=0.15055p AD=0.2516p PS=1.17u PD=2.16u rfmode=0
M$862 \$72186 \$72266 \$72957
+ BOTTOM|TOP|VGND|VSS|anode|cathode|core|h_sw[0]|h_sw[10]|h_sw[1]|h_sw[2]|h_sw[3]|h_sw[4]|h_sw[5]|h_sw[6]|h_sw[7]|h_sw[8]|h_sw[9]|l_sw[0]|l_sw[10]|l_sw[1]|l_sw[2]|l_sw[3]|l_sw[4]|l_sw[5]|l_sw[6]|l_sw[7]|l_sw[8]|l_sw[9]|out|pad|padres|vc|vcp|vdd|vddr|vip|vss|z
+ sg13_lv_nmos L=0.13u W=0.42u AS=0.141p AD=0.04725p PS=1.17u PD=0.645u rfmode=0
M$863 \$72957 \$72187
+ BOTTOM|TOP|VGND|VSS|anode|cathode|core|h_sw[0]|h_sw[10]|h_sw[1]|h_sw[2]|h_sw[3]|h_sw[4]|h_sw[5]|h_sw[6]|h_sw[7]|h_sw[8]|h_sw[9]|l_sw[0]|l_sw[10]|l_sw[1]|l_sw[2]|l_sw[3]|l_sw[4]|l_sw[5]|l_sw[6]|l_sw[7]|l_sw[8]|l_sw[9]|out|pad|padres|vc|vcp|vdd|vddr|vip|vss|z
+ BOTTOM|TOP|VGND|VSS|anode|cathode|core|h_sw[0]|h_sw[10]|h_sw[1]|h_sw[2]|h_sw[3]|h_sw[4]|h_sw[5]|h_sw[6]|h_sw[7]|h_sw[8]|h_sw[9]|l_sw[0]|l_sw[10]|l_sw[1]|l_sw[2]|l_sw[3]|l_sw[4]|l_sw[5]|l_sw[6]|l_sw[7]|l_sw[8]|l_sw[9]|out|pad|padres|vc|vcp|vdd|vddr|vip|vss|z
+ sg13_lv_nmos L=0.13u W=0.42u AS=0.04725p AD=0.1428p PS=0.645u PD=1.52u
+ rfmode=0
M$864 \$72267 \$72266
+ BOTTOM|TOP|VGND|VSS|anode|cathode|core|h_sw[0]|h_sw[10]|h_sw[1]|h_sw[2]|h_sw[3]|h_sw[4]|h_sw[5]|h_sw[6]|h_sw[7]|h_sw[8]|h_sw[9]|l_sw[0]|l_sw[10]|l_sw[1]|l_sw[2]|l_sw[3]|l_sw[4]|l_sw[5]|l_sw[6]|l_sw[7]|l_sw[8]|l_sw[9]|out|pad|padres|vc|vcp|vdd|vddr|vip|vss|z
+ BOTTOM|TOP|VGND|VSS|anode|cathode|core|h_sw[0]|h_sw[10]|h_sw[1]|h_sw[2]|h_sw[3]|h_sw[4]|h_sw[5]|h_sw[6]|h_sw[7]|h_sw[8]|h_sw[9]|l_sw[0]|l_sw[10]|l_sw[1]|l_sw[2]|l_sw[3]|l_sw[4]|l_sw[5]|l_sw[6]|l_sw[7]|l_sw[8]|l_sw[9]|out|pad|padres|vc|vcp|vdd|vddr|vip|vss|z
+ sg13_lv_nmos L=0.13u W=0.74u AS=0.2775p AD=0.213425p PS=2.23u PD=1.62u
+ rfmode=0
M$865
+ BOTTOM|TOP|VGND|VSS|anode|cathode|core|h_sw[0]|h_sw[10]|h_sw[1]|h_sw[2]|h_sw[3]|h_sw[4]|h_sw[5]|h_sw[6]|h_sw[7]|h_sw[8]|h_sw[9]|l_sw[0]|l_sw[10]|l_sw[1]|l_sw[2]|l_sw[3]|l_sw[4]|l_sw[5]|l_sw[6]|l_sw[7]|l_sw[8]|l_sw[9]|out|pad|padres|vc|vcp|vdd|vddr|vip|vss|z
+ \$72185 \$72958
+ BOTTOM|TOP|VGND|VSS|anode|cathode|core|h_sw[0]|h_sw[10]|h_sw[1]|h_sw[2]|h_sw[3]|h_sw[4]|h_sw[5]|h_sw[6]|h_sw[7]|h_sw[8]|h_sw[9]|l_sw[0]|l_sw[10]|l_sw[1]|l_sw[2]|l_sw[3]|l_sw[4]|l_sw[5]|l_sw[6]|l_sw[7]|l_sw[8]|l_sw[9]|out|pad|padres|vc|vcp|vdd|vddr|vip|vss|z
+ sg13_lv_nmos L=0.13u W=0.64u AS=0.213425p AD=0.072p PS=1.62u PD=0.865u
+ rfmode=0
M$866 \$72958 \$72267 \$72186
+ BOTTOM|TOP|VGND|VSS|anode|cathode|core|h_sw[0]|h_sw[10]|h_sw[1]|h_sw[2]|h_sw[3]|h_sw[4]|h_sw[5]|h_sw[6]|h_sw[7]|h_sw[8]|h_sw[9]|l_sw[0]|l_sw[10]|l_sw[1]|l_sw[2]|l_sw[3]|l_sw[4]|l_sw[5]|l_sw[6]|l_sw[7]|l_sw[8]|l_sw[9]|out|pad|padres|vc|vcp|vdd|vddr|vip|vss|z
+ sg13_lv_nmos L=0.13u W=0.64u AS=0.072p AD=0.141p PS=0.865u PD=1.17u rfmode=0
M$867 A|Y$20 A|X$27
+ BOTTOM|TOP|VGND|VSS|anode|cathode|core|h_sw[0]|h_sw[10]|h_sw[1]|h_sw[2]|h_sw[3]|h_sw[4]|h_sw[5]|h_sw[6]|h_sw[7]|h_sw[8]|h_sw[9]|l_sw[0]|l_sw[10]|l_sw[1]|l_sw[2]|l_sw[3]|l_sw[4]|l_sw[5]|l_sw[6]|l_sw[7]|l_sw[8]|l_sw[9]|out|pad|padres|vc|vcp|vdd|vddr|vip|vss|z
+ BOTTOM|TOP|VGND|VSS|anode|cathode|core|h_sw[0]|h_sw[10]|h_sw[1]|h_sw[2]|h_sw[3]|h_sw[4]|h_sw[5]|h_sw[6]|h_sw[7]|h_sw[8]|h_sw[9]|l_sw[0]|l_sw[10]|l_sw[1]|l_sw[2]|l_sw[3]|l_sw[4]|l_sw[5]|l_sw[6]|l_sw[7]|l_sw[8]|l_sw[9]|out|pad|padres|vc|vcp|vdd|vddr|vip|vss|z
+ sg13_lv_nmos L=0.13u W=0.74u AS=0.2516p AD=0.2516p PS=2.16u PD=2.16u rfmode=0
M$868 \$72192 A|D|Q
+ BOTTOM|TOP|VGND|VSS|anode|cathode|core|h_sw[0]|h_sw[10]|h_sw[1]|h_sw[2]|h_sw[3]|h_sw[4]|h_sw[5]|h_sw[6]|h_sw[7]|h_sw[8]|h_sw[9]|l_sw[0]|l_sw[10]|l_sw[1]|l_sw[2]|l_sw[3]|l_sw[4]|l_sw[5]|l_sw[6]|l_sw[7]|l_sw[8]|l_sw[9]|out|pad|padres|vc|vcp|vdd|vddr|vip|vss|z
+ BOTTOM|TOP|VGND|VSS|anode|cathode|core|h_sw[0]|h_sw[10]|h_sw[1]|h_sw[2]|h_sw[3]|h_sw[4]|h_sw[5]|h_sw[6]|h_sw[7]|h_sw[8]|h_sw[9]|l_sw[0]|l_sw[10]|l_sw[1]|l_sw[2]|l_sw[3]|l_sw[4]|l_sw[5]|l_sw[6]|l_sw[7]|l_sw[8]|l_sw[9]|out|pad|padres|vc|vcp|vdd|vddr|vip|vss|z
+ sg13_lv_nmos L=0.13u W=0.55u AS=0.187p AD=0.15055p PS=1.78u PD=1.17u rfmode=0
M$869
+ BOTTOM|TOP|VGND|VSS|anode|cathode|core|h_sw[0]|h_sw[10]|h_sw[1]|h_sw[2]|h_sw[3]|h_sw[4]|h_sw[5]|h_sw[6]|h_sw[7]|h_sw[8]|h_sw[9]|l_sw[0]|l_sw[10]|l_sw[1]|l_sw[2]|l_sw[3]|l_sw[4]|l_sw[5]|l_sw[6]|l_sw[7]|l_sw[8]|l_sw[9]|out|pad|padres|vc|vcp|vdd|vddr|vip|vss|z
+ CLK|D|GATE|Q$4 \$72268
+ BOTTOM|TOP|VGND|VSS|anode|cathode|core|h_sw[0]|h_sw[10]|h_sw[1]|h_sw[2]|h_sw[3]|h_sw[4]|h_sw[5]|h_sw[6]|h_sw[7]|h_sw[8]|h_sw[9]|l_sw[0]|l_sw[10]|l_sw[1]|l_sw[2]|l_sw[3]|l_sw[4]|l_sw[5]|l_sw[6]|l_sw[7]|l_sw[8]|l_sw[9]|out|pad|padres|vc|vcp|vdd|vddr|vip|vss|z
+ sg13_lv_nmos L=0.13u W=0.74u AS=0.15055p AD=0.2516p PS=1.17u PD=2.16u rfmode=0
M$870 \$72193 \$72268 \$72960
+ BOTTOM|TOP|VGND|VSS|anode|cathode|core|h_sw[0]|h_sw[10]|h_sw[1]|h_sw[2]|h_sw[3]|h_sw[4]|h_sw[5]|h_sw[6]|h_sw[7]|h_sw[8]|h_sw[9]|l_sw[0]|l_sw[10]|l_sw[1]|l_sw[2]|l_sw[3]|l_sw[4]|l_sw[5]|l_sw[6]|l_sw[7]|l_sw[8]|l_sw[9]|out|pad|padres|vc|vcp|vdd|vddr|vip|vss|z
+ sg13_lv_nmos L=0.13u W=0.42u AS=0.141p AD=0.04725p PS=1.17u PD=0.645u rfmode=0
M$871 \$72960 \$72194
+ BOTTOM|TOP|VGND|VSS|anode|cathode|core|h_sw[0]|h_sw[10]|h_sw[1]|h_sw[2]|h_sw[3]|h_sw[4]|h_sw[5]|h_sw[6]|h_sw[7]|h_sw[8]|h_sw[9]|l_sw[0]|l_sw[10]|l_sw[1]|l_sw[2]|l_sw[3]|l_sw[4]|l_sw[5]|l_sw[6]|l_sw[7]|l_sw[8]|l_sw[9]|out|pad|padres|vc|vcp|vdd|vddr|vip|vss|z
+ BOTTOM|TOP|VGND|VSS|anode|cathode|core|h_sw[0]|h_sw[10]|h_sw[1]|h_sw[2]|h_sw[3]|h_sw[4]|h_sw[5]|h_sw[6]|h_sw[7]|h_sw[8]|h_sw[9]|l_sw[0]|l_sw[10]|l_sw[1]|l_sw[2]|l_sw[3]|l_sw[4]|l_sw[5]|l_sw[6]|l_sw[7]|l_sw[8]|l_sw[9]|out|pad|padres|vc|vcp|vdd|vddr|vip|vss|z
+ sg13_lv_nmos L=0.13u W=0.42u AS=0.04725p AD=0.1428p PS=0.645u PD=1.52u
+ rfmode=0
M$872 \$72269 \$72268
+ BOTTOM|TOP|VGND|VSS|anode|cathode|core|h_sw[0]|h_sw[10]|h_sw[1]|h_sw[2]|h_sw[3]|h_sw[4]|h_sw[5]|h_sw[6]|h_sw[7]|h_sw[8]|h_sw[9]|l_sw[0]|l_sw[10]|l_sw[1]|l_sw[2]|l_sw[3]|l_sw[4]|l_sw[5]|l_sw[6]|l_sw[7]|l_sw[8]|l_sw[9]|out|pad|padres|vc|vcp|vdd|vddr|vip|vss|z
+ BOTTOM|TOP|VGND|VSS|anode|cathode|core|h_sw[0]|h_sw[10]|h_sw[1]|h_sw[2]|h_sw[3]|h_sw[4]|h_sw[5]|h_sw[6]|h_sw[7]|h_sw[8]|h_sw[9]|l_sw[0]|l_sw[10]|l_sw[1]|l_sw[2]|l_sw[3]|l_sw[4]|l_sw[5]|l_sw[6]|l_sw[7]|l_sw[8]|l_sw[9]|out|pad|padres|vc|vcp|vdd|vddr|vip|vss|z
+ sg13_lv_nmos L=0.13u W=0.74u AS=0.2775p AD=0.213425p PS=2.23u PD=1.62u
+ rfmode=0
M$873
+ BOTTOM|TOP|VGND|VSS|anode|cathode|core|h_sw[0]|h_sw[10]|h_sw[1]|h_sw[2]|h_sw[3]|h_sw[4]|h_sw[5]|h_sw[6]|h_sw[7]|h_sw[8]|h_sw[9]|l_sw[0]|l_sw[10]|l_sw[1]|l_sw[2]|l_sw[3]|l_sw[4]|l_sw[5]|l_sw[6]|l_sw[7]|l_sw[8]|l_sw[9]|out|pad|padres|vc|vcp|vdd|vddr|vip|vss|z
+ \$72192 \$72961
+ BOTTOM|TOP|VGND|VSS|anode|cathode|core|h_sw[0]|h_sw[10]|h_sw[1]|h_sw[2]|h_sw[3]|h_sw[4]|h_sw[5]|h_sw[6]|h_sw[7]|h_sw[8]|h_sw[9]|l_sw[0]|l_sw[10]|l_sw[1]|l_sw[2]|l_sw[3]|l_sw[4]|l_sw[5]|l_sw[6]|l_sw[7]|l_sw[8]|l_sw[9]|out|pad|padres|vc|vcp|vdd|vddr|vip|vss|z
+ sg13_lv_nmos L=0.13u W=0.64u AS=0.213425p AD=0.072p PS=1.62u PD=0.865u
+ rfmode=0
M$874 \$72961 \$72269 \$72193
+ BOTTOM|TOP|VGND|VSS|anode|cathode|core|h_sw[0]|h_sw[10]|h_sw[1]|h_sw[2]|h_sw[3]|h_sw[4]|h_sw[5]|h_sw[6]|h_sw[7]|h_sw[8]|h_sw[9]|l_sw[0]|l_sw[10]|l_sw[1]|l_sw[2]|l_sw[3]|l_sw[4]|l_sw[5]|l_sw[6]|l_sw[7]|l_sw[8]|l_sw[9]|out|pad|padres|vc|vcp|vdd|vddr|vip|vss|z
+ sg13_lv_nmos L=0.13u W=0.64u AS=0.072p AD=0.141p PS=0.865u PD=1.17u rfmode=0
M$875
+ BOTTOM|TOP|VGND|VSS|anode|cathode|core|h_sw[0]|h_sw[10]|h_sw[1]|h_sw[2]|h_sw[3]|h_sw[4]|h_sw[5]|h_sw[6]|h_sw[7]|h_sw[8]|h_sw[9]|l_sw[0]|l_sw[10]|l_sw[1]|l_sw[2]|l_sw[3]|l_sw[4]|l_sw[5]|l_sw[6]|l_sw[7]|l_sw[8]|l_sw[9]|out|pad|padres|vc|vcp|vdd|vddr|vip|vss|z
+ A|Q$11 \$72198
+ BOTTOM|TOP|VGND|VSS|anode|cathode|core|h_sw[0]|h_sw[10]|h_sw[1]|h_sw[2]|h_sw[3]|h_sw[4]|h_sw[5]|h_sw[6]|h_sw[7]|h_sw[8]|h_sw[9]|l_sw[0]|l_sw[10]|l_sw[1]|l_sw[2]|l_sw[3]|l_sw[4]|l_sw[5]|l_sw[6]|l_sw[7]|l_sw[8]|l_sw[9]|out|pad|padres|vc|vcp|vdd|vddr|vip|vss|z
+ sg13_lv_nmos L=0.13u W=0.55u AS=0.14875p AD=0.187p PS=1.16u PD=1.78u rfmode=0
M$876 A|X$44 \$72198
+ BOTTOM|TOP|VGND|VSS|anode|cathode|core|h_sw[0]|h_sw[10]|h_sw[1]|h_sw[2]|h_sw[3]|h_sw[4]|h_sw[5]|h_sw[6]|h_sw[7]|h_sw[8]|h_sw[9]|l_sw[0]|l_sw[10]|l_sw[1]|l_sw[2]|l_sw[3]|l_sw[4]|l_sw[5]|l_sw[6]|l_sw[7]|l_sw[8]|l_sw[9]|out|pad|padres|vc|vcp|vdd|vddr|vip|vss|z
+ BOTTOM|TOP|VGND|VSS|anode|cathode|core|h_sw[0]|h_sw[10]|h_sw[1]|h_sw[2]|h_sw[3]|h_sw[4]|h_sw[5]|h_sw[6]|h_sw[7]|h_sw[8]|h_sw[9]|l_sw[0]|l_sw[10]|l_sw[1]|l_sw[2]|l_sw[3]|l_sw[4]|l_sw[5]|l_sw[6]|l_sw[7]|l_sw[8]|l_sw[9]|out|pad|padres|vc|vcp|vdd|vddr|vip|vss|z
+ sg13_lv_nmos L=0.13u W=0.74u AS=0.2886p AD=0.14875p PS=2.26u PD=1.16u rfmode=0
M$877
+ BOTTOM|TOP|VGND|VSS|anode|cathode|core|h_sw[0]|h_sw[10]|h_sw[1]|h_sw[2]|h_sw[3]|h_sw[4]|h_sw[5]|h_sw[6]|h_sw[7]|h_sw[8]|h_sw[9]|l_sw[0]|l_sw[10]|l_sw[1]|l_sw[2]|l_sw[3]|l_sw[4]|l_sw[5]|l_sw[6]|l_sw[7]|l_sw[8]|l_sw[9]|out|pad|padres|vc|vcp|vdd|vddr|vip|vss|z
+ RESET_B|Y$1 \$72941
+ BOTTOM|TOP|VGND|VSS|anode|cathode|core|h_sw[0]|h_sw[10]|h_sw[1]|h_sw[2]|h_sw[3]|h_sw[4]|h_sw[5]|h_sw[6]|h_sw[7]|h_sw[8]|h_sw[9]|l_sw[0]|l_sw[10]|l_sw[1]|l_sw[2]|l_sw[3]|l_sw[4]|l_sw[5]|l_sw[6]|l_sw[7]|l_sw[8]|l_sw[9]|out|pad|padres|vc|vcp|vdd|vddr|vip|vss|z
+ sg13_lv_nmos L=0.13u W=0.42u AS=0.1701p AD=0.0378p PS=1.65u PD=0.6u rfmode=0
M$878 \$72941 \$72251 \$72601
+ BOTTOM|TOP|VGND|VSS|anode|cathode|core|h_sw[0]|h_sw[10]|h_sw[1]|h_sw[2]|h_sw[3]|h_sw[4]|h_sw[5]|h_sw[6]|h_sw[7]|h_sw[8]|h_sw[9]|l_sw[0]|l_sw[10]|l_sw[1]|l_sw[2]|l_sw[3]|l_sw[4]|l_sw[5]|l_sw[6]|l_sw[7]|l_sw[8]|l_sw[9]|out|pad|padres|vc|vcp|vdd|vddr|vip|vss|z
+ sg13_lv_nmos L=0.13u W=0.42u AS=0.0378p AD=0.1428p PS=0.6u PD=1.52u rfmode=0
M$881 \$72605 \$72257 \$72944
+ BOTTOM|TOP|VGND|VSS|anode|cathode|core|h_sw[0]|h_sw[10]|h_sw[1]|h_sw[2]|h_sw[3]|h_sw[4]|h_sw[5]|h_sw[6]|h_sw[7]|h_sw[8]|h_sw[9]|l_sw[0]|l_sw[10]|l_sw[1]|l_sw[2]|l_sw[3]|l_sw[4]|l_sw[5]|l_sw[6]|l_sw[7]|l_sw[8]|l_sw[9]|out|pad|padres|vc|vcp|vdd|vddr|vip|vss|z
+ sg13_lv_nmos L=0.13u W=0.42u AS=0.1428p AD=0.0378p PS=1.52u PD=0.6u rfmode=0
M$882 \$72944 RESET_B|Y$2
+ BOTTOM|TOP|VGND|VSS|anode|cathode|core|h_sw[0]|h_sw[10]|h_sw[1]|h_sw[2]|h_sw[3]|h_sw[4]|h_sw[5]|h_sw[6]|h_sw[7]|h_sw[8]|h_sw[9]|l_sw[0]|l_sw[10]|l_sw[1]|l_sw[2]|l_sw[3]|l_sw[4]|l_sw[5]|l_sw[6]|l_sw[7]|l_sw[8]|l_sw[9]|out|pad|padres|vc|vcp|vdd|vddr|vip|vss|z
+ BOTTOM|TOP|VGND|VSS|anode|cathode|core|h_sw[0]|h_sw[10]|h_sw[1]|h_sw[2]|h_sw[3]|h_sw[4]|h_sw[5]|h_sw[6]|h_sw[7]|h_sw[8]|h_sw[9]|l_sw[0]|l_sw[10]|l_sw[1]|l_sw[2]|l_sw[3]|l_sw[4]|l_sw[5]|l_sw[6]|l_sw[7]|l_sw[8]|l_sw[9]|out|pad|padres|vc|vcp|vdd|vddr|vip|vss|z
+ sg13_lv_nmos L=0.13u W=0.42u AS=0.0378p AD=0.1701p PS=0.6u PD=1.65u rfmode=0
M$884 \$72170 \$72169 \$72948
+ BOTTOM|TOP|VGND|VSS|anode|cathode|core|h_sw[0]|h_sw[10]|h_sw[1]|h_sw[2]|h_sw[3]|h_sw[4]|h_sw[5]|h_sw[6]|h_sw[7]|h_sw[8]|h_sw[9]|l_sw[0]|l_sw[10]|l_sw[1]|l_sw[2]|l_sw[3]|l_sw[4]|l_sw[5]|l_sw[6]|l_sw[7]|l_sw[8]|l_sw[9]|out|pad|padres|vc|vcp|vdd|vddr|vip|vss|z
+ sg13_lv_nmos L=0.13u W=0.74u AS=0.2516p AD=0.0777p PS=2.16u PD=0.95u rfmode=0
M$885 \$72948 RESET_B|Y$1
+ BOTTOM|TOP|VGND|VSS|anode|cathode|core|h_sw[0]|h_sw[10]|h_sw[1]|h_sw[2]|h_sw[3]|h_sw[4]|h_sw[5]|h_sw[6]|h_sw[7]|h_sw[8]|h_sw[9]|l_sw[0]|l_sw[10]|l_sw[1]|l_sw[2]|l_sw[3]|l_sw[4]|l_sw[5]|l_sw[6]|l_sw[7]|l_sw[8]|l_sw[9]|out|pad|padres|vc|vcp|vdd|vddr|vip|vss|z
+ BOTTOM|TOP|VGND|VSS|anode|cathode|core|h_sw[0]|h_sw[10]|h_sw[1]|h_sw[2]|h_sw[3]|h_sw[4]|h_sw[5]|h_sw[6]|h_sw[7]|h_sw[8]|h_sw[9]|l_sw[0]|l_sw[10]|l_sw[1]|l_sw[2]|l_sw[3]|l_sw[4]|l_sw[5]|l_sw[6]|l_sw[7]|l_sw[8]|l_sw[9]|out|pad|padres|vc|vcp|vdd|vddr|vip|vss|z
+ sg13_lv_nmos L=0.13u W=0.74u AS=0.0777p AD=0.1406p PS=0.95u PD=1.12u rfmode=0
M$886
+ BOTTOM|TOP|VGND|VSS|anode|cathode|core|h_sw[0]|h_sw[10]|h_sw[1]|h_sw[2]|h_sw[3]|h_sw[4]|h_sw[5]|h_sw[6]|h_sw[7]|h_sw[8]|h_sw[9]|l_sw[0]|l_sw[10]|l_sw[1]|l_sw[2]|l_sw[3]|l_sw[4]|l_sw[5]|l_sw[6]|l_sw[7]|l_sw[8]|l_sw[9]|out|pad|padres|vc|vcp|vdd|vddr|vip|vss|z
+ \$72170 A|Q$8
+ BOTTOM|TOP|VGND|VSS|anode|cathode|core|h_sw[0]|h_sw[10]|h_sw[1]|h_sw[2]|h_sw[3]|h_sw[4]|h_sw[5]|h_sw[6]|h_sw[7]|h_sw[8]|h_sw[9]|l_sw[0]|l_sw[10]|l_sw[1]|l_sw[2]|l_sw[3]|l_sw[4]|l_sw[5]|l_sw[6]|l_sw[7]|l_sw[8]|l_sw[9]|out|pad|padres|vc|vcp|vdd|vddr|vip|vss|z
+ sg13_lv_nmos L=0.13u W=0.74u AS=0.1406p AD=0.2516p PS=1.12u PD=2.16u rfmode=0
M$887
+ BOTTOM|TOP|VGND|VSS|anode|cathode|core|h_sw[0]|h_sw[10]|h_sw[1]|h_sw[2]|h_sw[3]|h_sw[4]|h_sw[5]|h_sw[6]|h_sw[7]|h_sw[8]|h_sw[9]|l_sw[0]|l_sw[10]|l_sw[1]|l_sw[2]|l_sw[3]|l_sw[4]|l_sw[5]|l_sw[6]|l_sw[7]|l_sw[8]|l_sw[9]|out|pad|padres|vc|vcp|vdd|vddr|vip|vss|z
+ \$72170 \$72171
+ BOTTOM|TOP|VGND|VSS|anode|cathode|core|h_sw[0]|h_sw[10]|h_sw[1]|h_sw[2]|h_sw[3]|h_sw[4]|h_sw[5]|h_sw[6]|h_sw[7]|h_sw[8]|h_sw[9]|l_sw[0]|l_sw[10]|l_sw[1]|l_sw[2]|l_sw[3]|l_sw[4]|l_sw[5]|l_sw[6]|l_sw[7]|l_sw[8]|l_sw[9]|out|pad|padres|vc|vcp|vdd|vddr|vip|vss|z
+ sg13_lv_nmos L=0.13u W=0.55u AS=0.1491p AD=0.187p PS=1.18u PD=1.78u rfmode=0
M$888
+ BOTTOM|TOP|VGND|VSS|anode|cathode|core|h_sw[0]|h_sw[10]|h_sw[1]|h_sw[2]|h_sw[3]|h_sw[4]|h_sw[5]|h_sw[6]|h_sw[7]|h_sw[8]|h_sw[9]|l_sw[0]|l_sw[10]|l_sw[1]|l_sw[2]|l_sw[3]|l_sw[4]|l_sw[5]|l_sw[6]|l_sw[7]|l_sw[8]|l_sw[9]|out|pad|padres|vc|vcp|vdd|vddr|vip|vss|z
+ \$72171 Q_N$19
+ BOTTOM|TOP|VGND|VSS|anode|cathode|core|h_sw[0]|h_sw[10]|h_sw[1]|h_sw[2]|h_sw[3]|h_sw[4]|h_sw[5]|h_sw[6]|h_sw[7]|h_sw[8]|h_sw[9]|l_sw[0]|l_sw[10]|l_sw[1]|l_sw[2]|l_sw[3]|l_sw[4]|l_sw[5]|l_sw[6]|l_sw[7]|l_sw[8]|l_sw[9]|out|pad|padres|vc|vcp|vdd|vddr|vip|vss|z
+ sg13_lv_nmos L=0.13u W=0.74u AS=0.1491p AD=0.2516p PS=1.18u PD=2.16u rfmode=0
M$889 B1|X \$72180
+ BOTTOM|TOP|VGND|VSS|anode|cathode|core|h_sw[0]|h_sw[10]|h_sw[1]|h_sw[2]|h_sw[3]|h_sw[4]|h_sw[5]|h_sw[6]|h_sw[7]|h_sw[8]|h_sw[9]|l_sw[0]|l_sw[10]|l_sw[1]|l_sw[2]|l_sw[3]|l_sw[4]|l_sw[5]|l_sw[6]|l_sw[7]|l_sw[8]|l_sw[9]|out|pad|padres|vc|vcp|vdd|vddr|vip|vss|z
+ BOTTOM|TOP|VGND|VSS|anode|cathode|core|h_sw[0]|h_sw[10]|h_sw[1]|h_sw[2]|h_sw[3]|h_sw[4]|h_sw[5]|h_sw[6]|h_sw[7]|h_sw[8]|h_sw[9]|l_sw[0]|l_sw[10]|l_sw[1]|l_sw[2]|l_sw[3]|l_sw[4]|l_sw[5]|l_sw[6]|l_sw[7]|l_sw[8]|l_sw[9]|out|pad|padres|vc|vcp|vdd|vddr|vip|vss|z
+ sg13_lv_nmos L=0.13u W=0.74u AS=0.2516p AD=0.1469p PS=2.16u PD=1.155u rfmode=0
M$890
+ BOTTOM|TOP|VGND|VSS|anode|cathode|core|h_sw[0]|h_sw[10]|h_sw[1]|h_sw[2]|h_sw[3]|h_sw[4]|h_sw[5]|h_sw[6]|h_sw[7]|h_sw[8]|h_sw[9]|l_sw[0]|l_sw[10]|l_sw[1]|l_sw[2]|l_sw[3]|l_sw[4]|l_sw[5]|l_sw[6]|l_sw[7]|l_sw[8]|l_sw[9]|out|pad|padres|vc|vcp|vdd|vddr|vip|vss|z
+ A|D|Q \$72180
+ BOTTOM|TOP|VGND|VSS|anode|cathode|core|h_sw[0]|h_sw[10]|h_sw[1]|h_sw[2]|h_sw[3]|h_sw[4]|h_sw[5]|h_sw[6]|h_sw[7]|h_sw[8]|h_sw[9]|l_sw[0]|l_sw[10]|l_sw[1]|l_sw[2]|l_sw[3]|l_sw[4]|l_sw[5]|l_sw[6]|l_sw[7]|l_sw[8]|l_sw[9]|out|pad|padres|vc|vcp|vdd|vddr|vip|vss|z
+ sg13_lv_nmos L=0.13u W=0.55u AS=0.1469p AD=0.1045p PS=1.155u PD=0.93u rfmode=0
M$891 \$72180 A2|B|B1|Y$1
+ BOTTOM|TOP|VGND|VSS|anode|cathode|core|h_sw[0]|h_sw[10]|h_sw[1]|h_sw[2]|h_sw[3]|h_sw[4]|h_sw[5]|h_sw[6]|h_sw[7]|h_sw[8]|h_sw[9]|l_sw[0]|l_sw[10]|l_sw[1]|l_sw[2]|l_sw[3]|l_sw[4]|l_sw[5]|l_sw[6]|l_sw[7]|l_sw[8]|l_sw[9]|out|pad|padres|vc|vcp|vdd|vddr|vip|vss|z
+ BOTTOM|TOP|VGND|VSS|anode|cathode|core|h_sw[0]|h_sw[10]|h_sw[1]|h_sw[2]|h_sw[3]|h_sw[4]|h_sw[5]|h_sw[6]|h_sw[7]|h_sw[8]|h_sw[9]|l_sw[0]|l_sw[10]|l_sw[1]|l_sw[2]|l_sw[3]|l_sw[4]|l_sw[5]|l_sw[6]|l_sw[7]|l_sw[8]|l_sw[9]|out|pad|padres|vc|vcp|vdd|vddr|vip|vss|z
+ sg13_lv_nmos L=0.13u W=0.55u AS=0.1045p AD=0.187p PS=0.93u PD=1.78u rfmode=0
M$892 \$72187 \$72186 \$72956
+ BOTTOM|TOP|VGND|VSS|anode|cathode|core|h_sw[0]|h_sw[10]|h_sw[1]|h_sw[2]|h_sw[3]|h_sw[4]|h_sw[5]|h_sw[6]|h_sw[7]|h_sw[8]|h_sw[9]|l_sw[0]|l_sw[10]|l_sw[1]|l_sw[2]|l_sw[3]|l_sw[4]|l_sw[5]|l_sw[6]|l_sw[7]|l_sw[8]|l_sw[9]|out|pad|padres|vc|vcp|vdd|vddr|vip|vss|z
+ sg13_lv_nmos L=0.13u W=0.74u AS=0.2516p AD=0.0777p PS=2.16u PD=0.95u rfmode=0
M$893 \$72956 RESET_B|Y$1
+ BOTTOM|TOP|VGND|VSS|anode|cathode|core|h_sw[0]|h_sw[10]|h_sw[1]|h_sw[2]|h_sw[3]|h_sw[4]|h_sw[5]|h_sw[6]|h_sw[7]|h_sw[8]|h_sw[9]|l_sw[0]|l_sw[10]|l_sw[1]|l_sw[2]|l_sw[3]|l_sw[4]|l_sw[5]|l_sw[6]|l_sw[7]|l_sw[8]|l_sw[9]|out|pad|padres|vc|vcp|vdd|vddr|vip|vss|z
+ BOTTOM|TOP|VGND|VSS|anode|cathode|core|h_sw[0]|h_sw[10]|h_sw[1]|h_sw[2]|h_sw[3]|h_sw[4]|h_sw[5]|h_sw[6]|h_sw[7]|h_sw[8]|h_sw[9]|l_sw[0]|l_sw[10]|l_sw[1]|l_sw[2]|l_sw[3]|l_sw[4]|l_sw[5]|l_sw[6]|l_sw[7]|l_sw[8]|l_sw[9]|out|pad|padres|vc|vcp|vdd|vddr|vip|vss|z
+ sg13_lv_nmos L=0.13u W=0.74u AS=0.0777p AD=0.1406p PS=0.95u PD=1.12u rfmode=0
M$894
+ BOTTOM|TOP|VGND|VSS|anode|cathode|core|h_sw[0]|h_sw[10]|h_sw[1]|h_sw[2]|h_sw[3]|h_sw[4]|h_sw[5]|h_sw[6]|h_sw[7]|h_sw[8]|h_sw[9]|l_sw[0]|l_sw[10]|l_sw[1]|l_sw[2]|l_sw[3]|l_sw[4]|l_sw[5]|l_sw[6]|l_sw[7]|l_sw[8]|l_sw[9]|out|pad|padres|vc|vcp|vdd|vddr|vip|vss|z
+ \$72187 A|Q$10
+ BOTTOM|TOP|VGND|VSS|anode|cathode|core|h_sw[0]|h_sw[10]|h_sw[1]|h_sw[2]|h_sw[3]|h_sw[4]|h_sw[5]|h_sw[6]|h_sw[7]|h_sw[8]|h_sw[9]|l_sw[0]|l_sw[10]|l_sw[1]|l_sw[2]|l_sw[3]|l_sw[4]|l_sw[5]|l_sw[6]|l_sw[7]|l_sw[8]|l_sw[9]|out|pad|padres|vc|vcp|vdd|vddr|vip|vss|z
+ sg13_lv_nmos L=0.13u W=0.74u AS=0.1406p AD=0.2516p PS=1.12u PD=2.16u rfmode=0
M$895
+ BOTTOM|TOP|VGND|VSS|anode|cathode|core|h_sw[0]|h_sw[10]|h_sw[1]|h_sw[2]|h_sw[3]|h_sw[4]|h_sw[5]|h_sw[6]|h_sw[7]|h_sw[8]|h_sw[9]|l_sw[0]|l_sw[10]|l_sw[1]|l_sw[2]|l_sw[3]|l_sw[4]|l_sw[5]|l_sw[6]|l_sw[7]|l_sw[8]|l_sw[9]|out|pad|padres|vc|vcp|vdd|vddr|vip|vss|z
+ \$72187 \$72189
+ BOTTOM|TOP|VGND|VSS|anode|cathode|core|h_sw[0]|h_sw[10]|h_sw[1]|h_sw[2]|h_sw[3]|h_sw[4]|h_sw[5]|h_sw[6]|h_sw[7]|h_sw[8]|h_sw[9]|l_sw[0]|l_sw[10]|l_sw[1]|l_sw[2]|l_sw[3]|l_sw[4]|l_sw[5]|l_sw[6]|l_sw[7]|l_sw[8]|l_sw[9]|out|pad|padres|vc|vcp|vdd|vddr|vip|vss|z
+ sg13_lv_nmos L=0.13u W=0.55u AS=0.1491p AD=0.187p PS=1.18u PD=1.78u rfmode=0
M$896
+ BOTTOM|TOP|VGND|VSS|anode|cathode|core|h_sw[0]|h_sw[10]|h_sw[1]|h_sw[2]|h_sw[3]|h_sw[4]|h_sw[5]|h_sw[6]|h_sw[7]|h_sw[8]|h_sw[9]|l_sw[0]|l_sw[10]|l_sw[1]|l_sw[2]|l_sw[3]|l_sw[4]|l_sw[5]|l_sw[6]|l_sw[7]|l_sw[8]|l_sw[9]|out|pad|padres|vc|vcp|vdd|vddr|vip|vss|z
+ \$72189 Q_N$20
+ BOTTOM|TOP|VGND|VSS|anode|cathode|core|h_sw[0]|h_sw[10]|h_sw[1]|h_sw[2]|h_sw[3]|h_sw[4]|h_sw[5]|h_sw[6]|h_sw[7]|h_sw[8]|h_sw[9]|l_sw[0]|l_sw[10]|l_sw[1]|l_sw[2]|l_sw[3]|l_sw[4]|l_sw[5]|l_sw[6]|l_sw[7]|l_sw[8]|l_sw[9]|out|pad|padres|vc|vcp|vdd|vddr|vip|vss|z
+ sg13_lv_nmos L=0.13u W=0.74u AS=0.1491p AD=0.2516p PS=1.18u PD=2.16u rfmode=0
M$903 \$72194 \$72193 \$72962
+ BOTTOM|TOP|VGND|VSS|anode|cathode|core|h_sw[0]|h_sw[10]|h_sw[1]|h_sw[2]|h_sw[3]|h_sw[4]|h_sw[5]|h_sw[6]|h_sw[7]|h_sw[8]|h_sw[9]|l_sw[0]|l_sw[10]|l_sw[1]|l_sw[2]|l_sw[3]|l_sw[4]|l_sw[5]|l_sw[6]|l_sw[7]|l_sw[8]|l_sw[9]|out|pad|padres|vc|vcp|vdd|vddr|vip|vss|z
+ sg13_lv_nmos L=0.13u W=0.74u AS=0.2516p AD=0.0777p PS=2.16u PD=0.95u rfmode=0
M$904 \$72962 RESET_B|Y$1
+ BOTTOM|TOP|VGND|VSS|anode|cathode|core|h_sw[0]|h_sw[10]|h_sw[1]|h_sw[2]|h_sw[3]|h_sw[4]|h_sw[5]|h_sw[6]|h_sw[7]|h_sw[8]|h_sw[9]|l_sw[0]|l_sw[10]|l_sw[1]|l_sw[2]|l_sw[3]|l_sw[4]|l_sw[5]|l_sw[6]|l_sw[7]|l_sw[8]|l_sw[9]|out|pad|padres|vc|vcp|vdd|vddr|vip|vss|z
+ BOTTOM|TOP|VGND|VSS|anode|cathode|core|h_sw[0]|h_sw[10]|h_sw[1]|h_sw[2]|h_sw[3]|h_sw[4]|h_sw[5]|h_sw[6]|h_sw[7]|h_sw[8]|h_sw[9]|l_sw[0]|l_sw[10]|l_sw[1]|l_sw[2]|l_sw[3]|l_sw[4]|l_sw[5]|l_sw[6]|l_sw[7]|l_sw[8]|l_sw[9]|out|pad|padres|vc|vcp|vdd|vddr|vip|vss|z
+ sg13_lv_nmos L=0.13u W=0.74u AS=0.0777p AD=0.1406p PS=0.95u PD=1.12u rfmode=0
M$905
+ BOTTOM|TOP|VGND|VSS|anode|cathode|core|h_sw[0]|h_sw[10]|h_sw[1]|h_sw[2]|h_sw[3]|h_sw[4]|h_sw[5]|h_sw[6]|h_sw[7]|h_sw[8]|h_sw[9]|l_sw[0]|l_sw[10]|l_sw[1]|l_sw[2]|l_sw[3]|l_sw[4]|l_sw[5]|l_sw[6]|l_sw[7]|l_sw[8]|l_sw[9]|out|pad|padres|vc|vcp|vdd|vddr|vip|vss|z
+ \$72194 A|Q$11
+ BOTTOM|TOP|VGND|VSS|anode|cathode|core|h_sw[0]|h_sw[10]|h_sw[1]|h_sw[2]|h_sw[3]|h_sw[4]|h_sw[5]|h_sw[6]|h_sw[7]|h_sw[8]|h_sw[9]|l_sw[0]|l_sw[10]|l_sw[1]|l_sw[2]|l_sw[3]|l_sw[4]|l_sw[5]|l_sw[6]|l_sw[7]|l_sw[8]|l_sw[9]|out|pad|padres|vc|vcp|vdd|vddr|vip|vss|z
+ sg13_lv_nmos L=0.13u W=0.74u AS=0.1406p AD=0.2516p PS=1.12u PD=2.16u rfmode=0
M$906
+ BOTTOM|TOP|VGND|VSS|anode|cathode|core|h_sw[0]|h_sw[10]|h_sw[1]|h_sw[2]|h_sw[3]|h_sw[4]|h_sw[5]|h_sw[6]|h_sw[7]|h_sw[8]|h_sw[9]|l_sw[0]|l_sw[10]|l_sw[1]|l_sw[2]|l_sw[3]|l_sw[4]|l_sw[5]|l_sw[6]|l_sw[7]|l_sw[8]|l_sw[9]|out|pad|padres|vc|vcp|vdd|vddr|vip|vss|z
+ \$72194 \$72196
+ BOTTOM|TOP|VGND|VSS|anode|cathode|core|h_sw[0]|h_sw[10]|h_sw[1]|h_sw[2]|h_sw[3]|h_sw[4]|h_sw[5]|h_sw[6]|h_sw[7]|h_sw[8]|h_sw[9]|l_sw[0]|l_sw[10]|l_sw[1]|l_sw[2]|l_sw[3]|l_sw[4]|l_sw[5]|l_sw[6]|l_sw[7]|l_sw[8]|l_sw[9]|out|pad|padres|vc|vcp|vdd|vddr|vip|vss|z
+ sg13_lv_nmos L=0.13u W=0.55u AS=0.1491p AD=0.187p PS=1.18u PD=1.78u rfmode=0
M$907
+ BOTTOM|TOP|VGND|VSS|anode|cathode|core|h_sw[0]|h_sw[10]|h_sw[1]|h_sw[2]|h_sw[3]|h_sw[4]|h_sw[5]|h_sw[6]|h_sw[7]|h_sw[8]|h_sw[9]|l_sw[0]|l_sw[10]|l_sw[1]|l_sw[2]|l_sw[3]|l_sw[4]|l_sw[5]|l_sw[6]|l_sw[7]|l_sw[8]|l_sw[9]|out|pad|padres|vc|vcp|vdd|vddr|vip|vss|z
+ \$72196 Q_N$21
+ BOTTOM|TOP|VGND|VSS|anode|cathode|core|h_sw[0]|h_sw[10]|h_sw[1]|h_sw[2]|h_sw[3]|h_sw[4]|h_sw[5]|h_sw[6]|h_sw[7]|h_sw[8]|h_sw[9]|l_sw[0]|l_sw[10]|l_sw[1]|l_sw[2]|l_sw[3]|l_sw[4]|l_sw[5]|l_sw[6]|l_sw[7]|l_sw[8]|l_sw[9]|out|pad|padres|vc|vcp|vdd|vddr|vip|vss|z
+ sg13_lv_nmos L=0.13u W=0.74u AS=0.1491p AD=0.2516p PS=1.18u PD=2.16u rfmode=0
M$910
+ BOTTOM|TOP|VGND|VSS|anode|cathode|core|h_sw[0]|h_sw[10]|h_sw[1]|h_sw[2]|h_sw[3]|h_sw[4]|h_sw[5]|h_sw[6]|h_sw[7]|h_sw[8]|h_sw[9]|l_sw[0]|l_sw[10]|l_sw[1]|l_sw[2]|l_sw[3]|l_sw[4]|l_sw[5]|l_sw[6]|l_sw[7]|l_sw[8]|l_sw[9]|out|pad|padres|vc|vcp|vdd|vddr|vip|vss|z
+ \$72157 \$72251
+ BOTTOM|TOP|VGND|VSS|anode|cathode|core|h_sw[0]|h_sw[10]|h_sw[1]|h_sw[2]|h_sw[3]|h_sw[4]|h_sw[5]|h_sw[6]|h_sw[7]|h_sw[8]|h_sw[9]|l_sw[0]|l_sw[10]|l_sw[1]|l_sw[2]|l_sw[3]|l_sw[4]|l_sw[5]|l_sw[6]|l_sw[7]|l_sw[8]|l_sw[9]|out|pad|padres|vc|vcp|vdd|vddr|vip|vss|z
+ sg13_lv_nmos L=0.13u W=0.74u AS=0.1626p AD=0.2516p PS=1.415u PD=2.16u rfmode=0
M$911 \$72156 D|X \$72940
+ BOTTOM|TOP|VGND|VSS|anode|cathode|core|h_sw[0]|h_sw[10]|h_sw[1]|h_sw[2]|h_sw[3]|h_sw[4]|h_sw[5]|h_sw[6]|h_sw[7]|h_sw[8]|h_sw[9]|l_sw[0]|l_sw[10]|l_sw[1]|l_sw[2]|l_sw[3]|l_sw[4]|l_sw[5]|l_sw[6]|l_sw[7]|l_sw[8]|l_sw[9]|out|pad|padres|vc|vcp|vdd|vddr|vip|vss|z
+ sg13_lv_nmos L=0.13u W=0.42u AS=0.1428p AD=0.0609p PS=1.52u PD=0.71u rfmode=0
M$912
+ BOTTOM|TOP|VGND|VSS|anode|cathode|core|h_sw[0]|h_sw[10]|h_sw[1]|h_sw[2]|h_sw[3]|h_sw[4]|h_sw[5]|h_sw[6]|h_sw[7]|h_sw[8]|h_sw[9]|l_sw[0]|l_sw[10]|l_sw[1]|l_sw[2]|l_sw[3]|l_sw[4]|l_sw[5]|l_sw[6]|l_sw[7]|l_sw[8]|l_sw[9]|out|pad|padres|vc|vcp|vdd|vddr|vip|vss|z
+ RESET_B|Y$1 \$72940
+ BOTTOM|TOP|VGND|VSS|anode|cathode|core|h_sw[0]|h_sw[10]|h_sw[1]|h_sw[2]|h_sw[3]|h_sw[4]|h_sw[5]|h_sw[6]|h_sw[7]|h_sw[8]|h_sw[9]|l_sw[0]|l_sw[10]|l_sw[1]|l_sw[2]|l_sw[3]|l_sw[4]|l_sw[5]|l_sw[6]|l_sw[7]|l_sw[8]|l_sw[9]|out|pad|padres|vc|vcp|vdd|vddr|vip|vss|z
+ sg13_lv_nmos L=0.13u W=0.42u AS=0.1626p AD=0.0609p PS=1.415u PD=0.71u rfmode=0
M$913 A|X$17 \$73057
+ BOTTOM|TOP|VGND|VSS|anode|cathode|core|h_sw[0]|h_sw[10]|h_sw[1]|h_sw[2]|h_sw[3]|h_sw[4]|h_sw[5]|h_sw[6]|h_sw[7]|h_sw[8]|h_sw[9]|l_sw[0]|l_sw[10]|l_sw[1]|l_sw[2]|l_sw[3]|l_sw[4]|l_sw[5]|l_sw[6]|l_sw[7]|l_sw[8]|l_sw[9]|out|pad|padres|vc|vcp|vdd|vddr|vip|vss|z
+ BOTTOM|TOP|VGND|VSS|anode|cathode|core|h_sw[0]|h_sw[10]|h_sw[1]|h_sw[2]|h_sw[3]|h_sw[4]|h_sw[5]|h_sw[6]|h_sw[7]|h_sw[8]|h_sw[9]|l_sw[0]|l_sw[10]|l_sw[1]|l_sw[2]|l_sw[3]|l_sw[4]|l_sw[5]|l_sw[6]|l_sw[7]|l_sw[8]|l_sw[9]|out|pad|padres|vc|vcp|vdd|vddr|vip|vss|z
+ sg13_lv_nmos L=0.13u W=0.74u AS=0.2886p AD=0.14875p PS=2.26u PD=1.16u rfmode=0
M$914
+ BOTTOM|TOP|VGND|VSS|anode|cathode|core|h_sw[0]|h_sw[10]|h_sw[1]|h_sw[2]|h_sw[3]|h_sw[4]|h_sw[5]|h_sw[6]|h_sw[7]|h_sw[8]|h_sw[9]|l_sw[0]|l_sw[10]|l_sw[1]|l_sw[2]|l_sw[3]|l_sw[4]|l_sw[5]|l_sw[6]|l_sw[7]|l_sw[8]|l_sw[9]|out|pad|padres|vc|vcp|vdd|vddr|vip|vss|z
+ A|Q$14 \$73057
+ BOTTOM|TOP|VGND|VSS|anode|cathode|core|h_sw[0]|h_sw[10]|h_sw[1]|h_sw[2]|h_sw[3]|h_sw[4]|h_sw[5]|h_sw[6]|h_sw[7]|h_sw[8]|h_sw[9]|l_sw[0]|l_sw[10]|l_sw[1]|l_sw[2]|l_sw[3]|l_sw[4]|l_sw[5]|l_sw[6]|l_sw[7]|l_sw[8]|l_sw[9]|out|pad|padres|vc|vcp|vdd|vddr|vip|vss|z
+ sg13_lv_nmos L=0.13u W=0.55u AS=0.14875p AD=0.187p PS=1.16u PD=1.78u rfmode=0
M$915 CLK|D|GATE|Q$2 \$73013
+ BOTTOM|TOP|VGND|VSS|anode|cathode|core|h_sw[0]|h_sw[10]|h_sw[1]|h_sw[2]|h_sw[3]|h_sw[4]|h_sw[5]|h_sw[6]|h_sw[7]|h_sw[8]|h_sw[9]|l_sw[0]|l_sw[10]|l_sw[1]|l_sw[2]|l_sw[3]|l_sw[4]|l_sw[5]|l_sw[6]|l_sw[7]|l_sw[8]|l_sw[9]|out|pad|padres|vc|vcp|vdd|vddr|vip|vss|z
+ BOTTOM|TOP|VGND|VSS|anode|cathode|core|h_sw[0]|h_sw[10]|h_sw[1]|h_sw[2]|h_sw[3]|h_sw[4]|h_sw[5]|h_sw[6]|h_sw[7]|h_sw[8]|h_sw[9]|l_sw[0]|l_sw[10]|l_sw[1]|l_sw[2]|l_sw[3]|l_sw[4]|l_sw[5]|l_sw[6]|l_sw[7]|l_sw[8]|l_sw[9]|out|pad|padres|vc|vcp|vdd|vddr|vip|vss|z
+ sg13_lv_nmos L=0.13u W=0.74u AS=0.2516p AD=0.1406p PS=2.16u PD=1.12u rfmode=0
M$916
+ BOTTOM|TOP|VGND|VSS|anode|cathode|core|h_sw[0]|h_sw[10]|h_sw[1]|h_sw[2]|h_sw[3]|h_sw[4]|h_sw[5]|h_sw[6]|h_sw[7]|h_sw[8]|h_sw[9]|l_sw[0]|l_sw[10]|l_sw[1]|l_sw[2]|l_sw[3]|l_sw[4]|l_sw[5]|l_sw[6]|l_sw[7]|l_sw[8]|l_sw[9]|out|pad|padres|vc|vcp|vdd|vddr|vip|vss|z
+ \$73058 \$73013
+ BOTTOM|TOP|VGND|VSS|anode|cathode|core|h_sw[0]|h_sw[10]|h_sw[1]|h_sw[2]|h_sw[3]|h_sw[4]|h_sw[5]|h_sw[6]|h_sw[7]|h_sw[8]|h_sw[9]|l_sw[0]|l_sw[10]|l_sw[1]|l_sw[2]|l_sw[3]|l_sw[4]|l_sw[5]|l_sw[6]|l_sw[7]|l_sw[8]|l_sw[9]|out|pad|padres|vc|vcp|vdd|vddr|vip|vss|z
+ sg13_lv_nmos L=0.13u W=0.74u AS=0.1406p AD=0.2516p PS=1.12u PD=2.16u rfmode=0
M$917 Q_N$22 \$73058
+ BOTTOM|TOP|VGND|VSS|anode|cathode|core|h_sw[0]|h_sw[10]|h_sw[1]|h_sw[2]|h_sw[3]|h_sw[4]|h_sw[5]|h_sw[6]|h_sw[7]|h_sw[8]|h_sw[9]|l_sw[0]|l_sw[10]|l_sw[1]|l_sw[2]|l_sw[3]|l_sw[4]|l_sw[5]|l_sw[6]|l_sw[7]|l_sw[8]|l_sw[9]|out|pad|padres|vc|vcp|vdd|vddr|vip|vss|z
+ BOTTOM|TOP|VGND|VSS|anode|cathode|core|h_sw[0]|h_sw[10]|h_sw[1]|h_sw[2]|h_sw[3]|h_sw[4]|h_sw[5]|h_sw[6]|h_sw[7]|h_sw[8]|h_sw[9]|l_sw[0]|l_sw[10]|l_sw[1]|l_sw[2]|l_sw[3]|l_sw[4]|l_sw[5]|l_sw[6]|l_sw[7]|l_sw[8]|l_sw[9]|out|pad|padres|vc|vcp|vdd|vddr|vip|vss|z
+ sg13_lv_nmos L=0.13u W=0.74u AS=0.2849p AD=0.2516p PS=2.25u PD=2.16u rfmode=0
M$918 \$72602 \$72254
+ BOTTOM|TOP|VGND|VSS|anode|cathode|core|h_sw[0]|h_sw[10]|h_sw[1]|h_sw[2]|h_sw[3]|h_sw[4]|h_sw[5]|h_sw[6]|h_sw[7]|h_sw[8]|h_sw[9]|l_sw[0]|l_sw[10]|l_sw[1]|l_sw[2]|l_sw[3]|l_sw[4]|l_sw[5]|l_sw[6]|l_sw[7]|l_sw[8]|l_sw[9]|out|pad|padres|vc|vcp|vdd|vddr|vip|vss|z
+ BOTTOM|TOP|VGND|VSS|anode|cathode|core|h_sw[0]|h_sw[10]|h_sw[1]|h_sw[2]|h_sw[3]|h_sw[4]|h_sw[5]|h_sw[6]|h_sw[7]|h_sw[8]|h_sw[9]|l_sw[0]|l_sw[10]|l_sw[1]|l_sw[2]|l_sw[3]|l_sw[4]|l_sw[5]|l_sw[6]|l_sw[7]|l_sw[8]|l_sw[9]|out|pad|padres|vc|vcp|vdd|vddr|vip|vss|z
+ sg13_lv_nmos L=0.13u W=0.42u AS=0.1428p AD=0.0798p PS=1.52u PD=0.8u rfmode=0
M$919
+ BOTTOM|TOP|VGND|VSS|anode|cathode|core|h_sw[0]|h_sw[10]|h_sw[1]|h_sw[2]|h_sw[3]|h_sw[4]|h_sw[5]|h_sw[6]|h_sw[7]|h_sw[8]|h_sw[9]|l_sw[0]|l_sw[10]|l_sw[1]|l_sw[2]|l_sw[3]|l_sw[4]|l_sw[5]|l_sw[6]|l_sw[7]|l_sw[8]|l_sw[9]|out|pad|padres|vc|vcp|vdd|vddr|vip|vss|z
+ RESET_B|Y$1 \$72942
+ BOTTOM|TOP|VGND|VSS|anode|cathode|core|h_sw[0]|h_sw[10]|h_sw[1]|h_sw[2]|h_sw[3]|h_sw[4]|h_sw[5]|h_sw[6]|h_sw[7]|h_sw[8]|h_sw[9]|l_sw[0]|l_sw[10]|l_sw[1]|l_sw[2]|l_sw[3]|l_sw[4]|l_sw[5]|l_sw[6]|l_sw[7]|l_sw[8]|l_sw[9]|out|pad|padres|vc|vcp|vdd|vddr|vip|vss|z
+ sg13_lv_nmos L=0.13u W=0.42u AS=0.0798p AD=0.0378p PS=0.8u PD=0.6u rfmode=0
M$920 \$72942 \$72253 \$72254
+ BOTTOM|TOP|VGND|VSS|anode|cathode|core|h_sw[0]|h_sw[10]|h_sw[1]|h_sw[2]|h_sw[3]|h_sw[4]|h_sw[5]|h_sw[6]|h_sw[7]|h_sw[8]|h_sw[9]|l_sw[0]|l_sw[10]|l_sw[1]|l_sw[2]|l_sw[3]|l_sw[4]|l_sw[5]|l_sw[6]|l_sw[7]|l_sw[8]|l_sw[9]|out|pad|padres|vc|vcp|vdd|vddr|vip|vss|z
+ sg13_lv_nmos L=0.13u W=0.42u AS=0.0378p AD=0.1428p PS=0.6u PD=1.52u rfmode=0
M$921 \$73015 \$73058 \$73105
+ BOTTOM|TOP|VGND|VSS|anode|cathode|core|h_sw[0]|h_sw[10]|h_sw[1]|h_sw[2]|h_sw[3]|h_sw[4]|h_sw[5]|h_sw[6]|h_sw[7]|h_sw[8]|h_sw[9]|l_sw[0]|l_sw[10]|l_sw[1]|l_sw[2]|l_sw[3]|l_sw[4]|l_sw[5]|l_sw[6]|l_sw[7]|l_sw[8]|l_sw[9]|out|pad|padres|vc|vcp|vdd|vddr|vip|vss|z
+ sg13_lv_nmos L=0.13u W=0.42u AS=0.1428p AD=0.0378p PS=1.52u PD=0.6u rfmode=0
M$922 \$73105 RESET_B|Y$2
+ BOTTOM|TOP|VGND|VSS|anode|cathode|core|h_sw[0]|h_sw[10]|h_sw[1]|h_sw[2]|h_sw[3]|h_sw[4]|h_sw[5]|h_sw[6]|h_sw[7]|h_sw[8]|h_sw[9]|l_sw[0]|l_sw[10]|l_sw[1]|l_sw[2]|l_sw[3]|l_sw[4]|l_sw[5]|l_sw[6]|l_sw[7]|l_sw[8]|l_sw[9]|out|pad|padres|vc|vcp|vdd|vddr|vip|vss|z
+ BOTTOM|TOP|VGND|VSS|anode|cathode|core|h_sw[0]|h_sw[10]|h_sw[1]|h_sw[2]|h_sw[3]|h_sw[4]|h_sw[5]|h_sw[6]|h_sw[7]|h_sw[8]|h_sw[9]|l_sw[0]|l_sw[10]|l_sw[1]|l_sw[2]|l_sw[3]|l_sw[4]|l_sw[5]|l_sw[6]|l_sw[7]|l_sw[8]|l_sw[9]|out|pad|padres|vc|vcp|vdd|vddr|vip|vss|z
+ sg13_lv_nmos L=0.13u W=0.42u AS=0.0378p AD=0.0798p PS=0.6u PD=0.8u rfmode=0
M$923
+ BOTTOM|TOP|VGND|VSS|anode|cathode|core|h_sw[0]|h_sw[10]|h_sw[1]|h_sw[2]|h_sw[3]|h_sw[4]|h_sw[5]|h_sw[6]|h_sw[7]|h_sw[8]|h_sw[9]|l_sw[0]|l_sw[10]|l_sw[1]|l_sw[2]|l_sw[3]|l_sw[4]|l_sw[5]|l_sw[6]|l_sw[7]|l_sw[8]|l_sw[9]|out|pad|padres|vc|vcp|vdd|vddr|vip|vss|z
+ \$73015 \$73016
+ BOTTOM|TOP|VGND|VSS|anode|cathode|core|h_sw[0]|h_sw[10]|h_sw[1]|h_sw[2]|h_sw[3]|h_sw[4]|h_sw[5]|h_sw[6]|h_sw[7]|h_sw[8]|h_sw[9]|l_sw[0]|l_sw[10]|l_sw[1]|l_sw[2]|l_sw[3]|l_sw[4]|l_sw[5]|l_sw[6]|l_sw[7]|l_sw[8]|l_sw[9]|out|pad|padres|vc|vcp|vdd|vddr|vip|vss|z
+ sg13_lv_nmos L=0.13u W=0.42u AS=0.0798p AD=0.1428p PS=0.8u PD=1.52u rfmode=0
M$924 \$73017 \$73148 \$73058
+ BOTTOM|TOP|VGND|VSS|anode|cathode|core|h_sw[0]|h_sw[10]|h_sw[1]|h_sw[2]|h_sw[3]|h_sw[4]|h_sw[5]|h_sw[6]|h_sw[7]|h_sw[8]|h_sw[9]|l_sw[0]|l_sw[10]|l_sw[1]|l_sw[2]|l_sw[3]|l_sw[4]|l_sw[5]|l_sw[6]|l_sw[7]|l_sw[8]|l_sw[9]|out|pad|padres|vc|vcp|vdd|vddr|vip|vss|z
+ sg13_lv_nmos L=0.13u W=0.74u AS=0.3473p AD=0.12665p PS=2.71u PD=1.145u
+ rfmode=0
M$925 \$73058 \$73149 \$73016
+ BOTTOM|TOP|VGND|VSS|anode|cathode|core|h_sw[0]|h_sw[10]|h_sw[1]|h_sw[2]|h_sw[3]|h_sw[4]|h_sw[5]|h_sw[6]|h_sw[7]|h_sw[8]|h_sw[9]|l_sw[0]|l_sw[10]|l_sw[1]|l_sw[2]|l_sw[3]|l_sw[4]|l_sw[5]|l_sw[6]|l_sw[7]|l_sw[8]|l_sw[9]|out|pad|padres|vc|vcp|vdd|vddr|vip|vss|z
+ sg13_lv_nmos L=0.13u W=0.42u AS=0.12665p AD=0.1428p PS=1.145u PD=1.52u
+ rfmode=0
M$926 \$73018 \$73017 \$73107
+ BOTTOM|TOP|VGND|VSS|anode|cathode|core|h_sw[0]|h_sw[10]|h_sw[1]|h_sw[2]|h_sw[3]|h_sw[4]|h_sw[5]|h_sw[6]|h_sw[7]|h_sw[8]|h_sw[9]|l_sw[0]|l_sw[10]|l_sw[1]|l_sw[2]|l_sw[3]|l_sw[4]|l_sw[5]|l_sw[6]|l_sw[7]|l_sw[8]|l_sw[9]|out|pad|padres|vc|vcp|vdd|vddr|vip|vss|z
+ sg13_lv_nmos L=0.13u W=0.42u AS=0.1428p AD=0.0378p PS=1.52u PD=0.6u rfmode=0
M$927 \$73107 RESET_B|Y$2
+ BOTTOM|TOP|VGND|VSS|anode|cathode|core|h_sw[0]|h_sw[10]|h_sw[1]|h_sw[2]|h_sw[3]|h_sw[4]|h_sw[5]|h_sw[6]|h_sw[7]|h_sw[8]|h_sw[9]|l_sw[0]|l_sw[10]|l_sw[1]|l_sw[2]|l_sw[3]|l_sw[4]|l_sw[5]|l_sw[6]|l_sw[7]|l_sw[8]|l_sw[9]|out|pad|padres|vc|vcp|vdd|vddr|vip|vss|z
+ BOTTOM|TOP|VGND|VSS|anode|cathode|core|h_sw[0]|h_sw[10]|h_sw[1]|h_sw[2]|h_sw[3]|h_sw[4]|h_sw[5]|h_sw[6]|h_sw[7]|h_sw[8]|h_sw[9]|l_sw[0]|l_sw[10]|l_sw[1]|l_sw[2]|l_sw[3]|l_sw[4]|l_sw[5]|l_sw[6]|l_sw[7]|l_sw[8]|l_sw[9]|out|pad|padres|vc|vcp|vdd|vddr|vip|vss|z
+ sg13_lv_nmos L=0.13u W=0.42u AS=0.0378p AD=0.1701p PS=0.6u PD=1.65u rfmode=0
M$928
+ BOTTOM|TOP|VGND|VSS|anode|cathode|core|h_sw[0]|h_sw[10]|h_sw[1]|h_sw[2]|h_sw[3]|h_sw[4]|h_sw[5]|h_sw[6]|h_sw[7]|h_sw[8]|h_sw[9]|l_sw[0]|l_sw[10]|l_sw[1]|l_sw[2]|l_sw[3]|l_sw[4]|l_sw[5]|l_sw[6]|l_sw[7]|l_sw[8]|l_sw[9]|out|pad|padres|vc|vcp|vdd|vddr|vip|vss|z
+ RESET_B|Y$2 \$73106
+ BOTTOM|TOP|VGND|VSS|anode|cathode|core|h_sw[0]|h_sw[10]|h_sw[1]|h_sw[2]|h_sw[3]|h_sw[4]|h_sw[5]|h_sw[6]|h_sw[7]|h_sw[8]|h_sw[9]|l_sw[0]|l_sw[10]|l_sw[1]|l_sw[2]|l_sw[3]|l_sw[4]|l_sw[5]|l_sw[6]|l_sw[7]|l_sw[8]|l_sw[9]|out|pad|padres|vc|vcp|vdd|vddr|vip|vss|z
+ sg13_lv_nmos L=0.13u W=0.42u AS=0.1626p AD=0.0609p PS=1.415u PD=0.71u rfmode=0
M$929 \$73106 CLK|D|GATE|Q$6 \$73059
+ BOTTOM|TOP|VGND|VSS|anode|cathode|core|h_sw[0]|h_sw[10]|h_sw[1]|h_sw[2]|h_sw[3]|h_sw[4]|h_sw[5]|h_sw[6]|h_sw[7]|h_sw[8]|h_sw[9]|l_sw[0]|l_sw[10]|l_sw[1]|l_sw[2]|l_sw[3]|l_sw[4]|l_sw[5]|l_sw[6]|l_sw[7]|l_sw[8]|l_sw[9]|out|pad|padres|vc|vcp|vdd|vddr|vip|vss|z
+ sg13_lv_nmos L=0.13u W=0.42u AS=0.0609p AD=0.1428p PS=0.71u PD=1.52u rfmode=0
M$930
+ BOTTOM|TOP|VGND|VSS|anode|cathode|core|h_sw[0]|h_sw[10]|h_sw[1]|h_sw[2]|h_sw[3]|h_sw[4]|h_sw[5]|h_sw[6]|h_sw[7]|h_sw[8]|h_sw[9]|l_sw[0]|l_sw[10]|l_sw[1]|l_sw[2]|l_sw[3]|l_sw[4]|l_sw[5]|l_sw[6]|l_sw[7]|l_sw[8]|l_sw[9]|out|pad|padres|vc|vcp|vdd|vddr|vip|vss|z
+ \$73150 \$73017
+ BOTTOM|TOP|VGND|VSS|anode|cathode|core|h_sw[0]|h_sw[10]|h_sw[1]|h_sw[2]|h_sw[3]|h_sw[4]|h_sw[5]|h_sw[6]|h_sw[7]|h_sw[8]|h_sw[9]|l_sw[0]|l_sw[10]|l_sw[1]|l_sw[2]|l_sw[3]|l_sw[4]|l_sw[5]|l_sw[6]|l_sw[7]|l_sw[8]|l_sw[9]|out|pad|padres|vc|vcp|vdd|vddr|vip|vss|z
+ sg13_lv_nmos L=0.13u W=0.74u AS=0.1626p AD=0.2516p PS=1.415u PD=2.16u rfmode=0
M$931 A|X$33 \$73060
+ BOTTOM|TOP|VGND|VSS|anode|cathode|core|h_sw[0]|h_sw[10]|h_sw[1]|h_sw[2]|h_sw[3]|h_sw[4]|h_sw[5]|h_sw[6]|h_sw[7]|h_sw[8]|h_sw[9]|l_sw[0]|l_sw[10]|l_sw[1]|l_sw[2]|l_sw[3]|l_sw[4]|l_sw[5]|l_sw[6]|l_sw[7]|l_sw[8]|l_sw[9]|out|pad|padres|vc|vcp|vdd|vddr|vip|vss|z
+ BOTTOM|TOP|VGND|VSS|anode|cathode|core|h_sw[0]|h_sw[10]|h_sw[1]|h_sw[2]|h_sw[3]|h_sw[4]|h_sw[5]|h_sw[6]|h_sw[7]|h_sw[8]|h_sw[9]|l_sw[0]|l_sw[10]|l_sw[1]|l_sw[2]|l_sw[3]|l_sw[4]|l_sw[5]|l_sw[6]|l_sw[7]|l_sw[8]|l_sw[9]|out|pad|padres|vc|vcp|vdd|vddr|vip|vss|z
+ sg13_lv_nmos L=0.13u W=0.74u AS=0.2886p AD=0.14875p PS=2.26u PD=1.16u rfmode=0
M$932
+ BOTTOM|TOP|VGND|VSS|anode|cathode|core|h_sw[0]|h_sw[10]|h_sw[1]|h_sw[2]|h_sw[3]|h_sw[4]|h_sw[5]|h_sw[6]|h_sw[7]|h_sw[8]|h_sw[9]|l_sw[0]|l_sw[10]|l_sw[1]|l_sw[2]|l_sw[3]|l_sw[4]|l_sw[5]|l_sw[6]|l_sw[7]|l_sw[8]|l_sw[9]|out|pad|padres|vc|vcp|vdd|vddr|vip|vss|z
+ A|Q$15 \$73060
+ BOTTOM|TOP|VGND|VSS|anode|cathode|core|h_sw[0]|h_sw[10]|h_sw[1]|h_sw[2]|h_sw[3]|h_sw[4]|h_sw[5]|h_sw[6]|h_sw[7]|h_sw[8]|h_sw[9]|l_sw[0]|l_sw[10]|l_sw[1]|l_sw[2]|l_sw[3]|l_sw[4]|l_sw[5]|l_sw[6]|l_sw[7]|l_sw[8]|l_sw[9]|out|pad|padres|vc|vcp|vdd|vddr|vip|vss|z
+ sg13_lv_nmos L=0.13u W=0.55u AS=0.14875p AD=0.187p PS=1.16u PD=1.78u rfmode=0
M$934 \$73019 D|X \$73109
+ BOTTOM|TOP|VGND|VSS|anode|cathode|core|h_sw[0]|h_sw[10]|h_sw[1]|h_sw[2]|h_sw[3]|h_sw[4]|h_sw[5]|h_sw[6]|h_sw[7]|h_sw[8]|h_sw[9]|l_sw[0]|l_sw[10]|l_sw[1]|l_sw[2]|l_sw[3]|l_sw[4]|l_sw[5]|l_sw[6]|l_sw[7]|l_sw[8]|l_sw[9]|out|pad|padres|vc|vcp|vdd|vddr|vip|vss|z
+ sg13_lv_nmos L=0.13u W=0.42u AS=0.1428p AD=0.0609p PS=1.52u PD=0.71u rfmode=0
M$935 \$73109 RESET_B|Y$1
+ BOTTOM|TOP|VGND|VSS|anode|cathode|core|h_sw[0]|h_sw[10]|h_sw[1]|h_sw[2]|h_sw[3]|h_sw[4]|h_sw[5]|h_sw[6]|h_sw[7]|h_sw[8]|h_sw[9]|l_sw[0]|l_sw[10]|l_sw[1]|l_sw[2]|l_sw[3]|l_sw[4]|l_sw[5]|l_sw[6]|l_sw[7]|l_sw[8]|l_sw[9]|out|pad|padres|vc|vcp|vdd|vddr|vip|vss|z
+ BOTTOM|TOP|VGND|VSS|anode|cathode|core|h_sw[0]|h_sw[10]|h_sw[1]|h_sw[2]|h_sw[3]|h_sw[4]|h_sw[5]|h_sw[6]|h_sw[7]|h_sw[8]|h_sw[9]|l_sw[0]|l_sw[10]|l_sw[1]|l_sw[2]|l_sw[3]|l_sw[4]|l_sw[5]|l_sw[6]|l_sw[7]|l_sw[8]|l_sw[9]|out|pad|padres|vc|vcp|vdd|vddr|vip|vss|z
+ sg13_lv_nmos L=0.13u W=0.42u AS=0.0609p AD=0.1626p PS=0.71u PD=1.415u rfmode=0
M$936
+ BOTTOM|TOP|VGND|VSS|anode|cathode|core|h_sw[0]|h_sw[10]|h_sw[1]|h_sw[2]|h_sw[3]|h_sw[4]|h_sw[5]|h_sw[6]|h_sw[7]|h_sw[8]|h_sw[9]|l_sw[0]|l_sw[10]|l_sw[1]|l_sw[2]|l_sw[3]|l_sw[4]|l_sw[5]|l_sw[6]|l_sw[7]|l_sw[8]|l_sw[9]|out|pad|padres|vc|vcp|vdd|vddr|vip|vss|z
+ \$73152 \$73021
+ BOTTOM|TOP|VGND|VSS|anode|cathode|core|h_sw[0]|h_sw[10]|h_sw[1]|h_sw[2]|h_sw[3]|h_sw[4]|h_sw[5]|h_sw[6]|h_sw[7]|h_sw[8]|h_sw[9]|l_sw[0]|l_sw[10]|l_sw[1]|l_sw[2]|l_sw[3]|l_sw[4]|l_sw[5]|l_sw[6]|l_sw[7]|l_sw[8]|l_sw[9]|out|pad|padres|vc|vcp|vdd|vddr|vip|vss|z
+ sg13_lv_nmos L=0.13u W=0.74u AS=0.1626p AD=0.2516p PS=1.415u PD=2.16u rfmode=0
M$937 \$72255 \$72603 \$72943
+ BOTTOM|TOP|VGND|VSS|anode|cathode|core|h_sw[0]|h_sw[10]|h_sw[1]|h_sw[2]|h_sw[3]|h_sw[4]|h_sw[5]|h_sw[6]|h_sw[7]|h_sw[8]|h_sw[9]|l_sw[0]|l_sw[10]|l_sw[1]|l_sw[2]|l_sw[3]|l_sw[4]|l_sw[5]|l_sw[6]|l_sw[7]|l_sw[8]|l_sw[9]|out|pad|padres|vc|vcp|vdd|vddr|vip|vss|z
+ sg13_lv_nmos L=0.13u W=0.42u AS=0.1428p AD=0.0378p PS=1.52u PD=0.6u rfmode=0
M$938 \$72943 RESET_B|Y$2
+ BOTTOM|TOP|VGND|VSS|anode|cathode|core|h_sw[0]|h_sw[10]|h_sw[1]|h_sw[2]|h_sw[3]|h_sw[4]|h_sw[5]|h_sw[6]|h_sw[7]|h_sw[8]|h_sw[9]|l_sw[0]|l_sw[10]|l_sw[1]|l_sw[2]|l_sw[3]|l_sw[4]|l_sw[5]|l_sw[6]|l_sw[7]|l_sw[8]|l_sw[9]|out|pad|padres|vc|vcp|vdd|vddr|vip|vss|z
+ BOTTOM|TOP|VGND|VSS|anode|cathode|core|h_sw[0]|h_sw[10]|h_sw[1]|h_sw[2]|h_sw[3]|h_sw[4]|h_sw[5]|h_sw[6]|h_sw[7]|h_sw[8]|h_sw[9]|l_sw[0]|l_sw[10]|l_sw[1]|l_sw[2]|l_sw[3]|l_sw[4]|l_sw[5]|l_sw[6]|l_sw[7]|l_sw[8]|l_sw[9]|out|pad|padres|vc|vcp|vdd|vddr|vip|vss|z
+ sg13_lv_nmos L=0.13u W=0.42u AS=0.0378p AD=0.0798p PS=0.6u PD=0.8u rfmode=0
M$939
+ BOTTOM|TOP|VGND|VSS|anode|cathode|core|h_sw[0]|h_sw[10]|h_sw[1]|h_sw[2]|h_sw[3]|h_sw[4]|h_sw[5]|h_sw[6]|h_sw[7]|h_sw[8]|h_sw[9]|l_sw[0]|l_sw[10]|l_sw[1]|l_sw[2]|l_sw[3]|l_sw[4]|l_sw[5]|l_sw[6]|l_sw[7]|l_sw[8]|l_sw[9]|out|pad|padres|vc|vcp|vdd|vddr|vip|vss|z
+ \$72255 \$72604
+ BOTTOM|TOP|VGND|VSS|anode|cathode|core|h_sw[0]|h_sw[10]|h_sw[1]|h_sw[2]|h_sw[3]|h_sw[4]|h_sw[5]|h_sw[6]|h_sw[7]|h_sw[8]|h_sw[9]|l_sw[0]|l_sw[10]|l_sw[1]|l_sw[2]|l_sw[3]|l_sw[4]|l_sw[5]|l_sw[6]|l_sw[7]|l_sw[8]|l_sw[9]|out|pad|padres|vc|vcp|vdd|vddr|vip|vss|z
+ sg13_lv_nmos L=0.13u W=0.42u AS=0.0798p AD=0.1428p PS=0.8u PD=1.52u rfmode=0
M$940
+ BOTTOM|TOP|VGND|VSS|anode|cathode|core|h_sw[0]|h_sw[10]|h_sw[1]|h_sw[2]|h_sw[3]|h_sw[4]|h_sw[5]|h_sw[6]|h_sw[7]|h_sw[8]|h_sw[9]|l_sw[0]|l_sw[10]|l_sw[1]|l_sw[2]|l_sw[3]|l_sw[4]|l_sw[5]|l_sw[6]|l_sw[7]|l_sw[8]|l_sw[9]|out|pad|padres|vc|vcp|vdd|vddr|vip|vss|z
+ RESET_B|Y$1 \$73108
+ BOTTOM|TOP|VGND|VSS|anode|cathode|core|h_sw[0]|h_sw[10]|h_sw[1]|h_sw[2]|h_sw[3]|h_sw[4]|h_sw[5]|h_sw[6]|h_sw[7]|h_sw[8]|h_sw[9]|l_sw[0]|l_sw[10]|l_sw[1]|l_sw[2]|l_sw[3]|l_sw[4]|l_sw[5]|l_sw[6]|l_sw[7]|l_sw[8]|l_sw[9]|out|pad|padres|vc|vcp|vdd|vddr|vip|vss|z
+ sg13_lv_nmos L=0.13u W=0.42u AS=0.1701p AD=0.0378p PS=1.65u PD=0.6u rfmode=0
M$941 \$73108 \$73021 \$73020
+ BOTTOM|TOP|VGND|VSS|anode|cathode|core|h_sw[0]|h_sw[10]|h_sw[1]|h_sw[2]|h_sw[3]|h_sw[4]|h_sw[5]|h_sw[6]|h_sw[7]|h_sw[8]|h_sw[9]|l_sw[0]|l_sw[10]|l_sw[1]|l_sw[2]|l_sw[3]|l_sw[4]|l_sw[5]|l_sw[6]|l_sw[7]|l_sw[8]|l_sw[9]|out|pad|padres|vc|vcp|vdd|vddr|vip|vss|z
+ sg13_lv_nmos L=0.13u W=0.42u AS=0.0378p AD=0.1428p PS=0.6u PD=1.52u rfmode=0
M$942 \$73062 \$73022 \$73023
+ BOTTOM|TOP|VGND|VSS|anode|cathode|core|h_sw[0]|h_sw[10]|h_sw[1]|h_sw[2]|h_sw[3]|h_sw[4]|h_sw[5]|h_sw[6]|h_sw[7]|h_sw[8]|h_sw[9]|l_sw[0]|l_sw[10]|l_sw[1]|l_sw[2]|l_sw[3]|l_sw[4]|l_sw[5]|l_sw[6]|l_sw[7]|l_sw[8]|l_sw[9]|out|pad|padres|vc|vcp|vdd|vddr|vip|vss|z
+ sg13_lv_nmos L=0.13u W=0.42u AS=0.12665p AD=0.1428p PS=1.145u PD=1.52u
+ rfmode=0
M$943 \$73021 \$73061 \$73062
+ BOTTOM|TOP|VGND|VSS|anode|cathode|core|h_sw[0]|h_sw[10]|h_sw[1]|h_sw[2]|h_sw[3]|h_sw[4]|h_sw[5]|h_sw[6]|h_sw[7]|h_sw[8]|h_sw[9]|l_sw[0]|l_sw[10]|l_sw[1]|l_sw[2]|l_sw[3]|l_sw[4]|l_sw[5]|l_sw[6]|l_sw[7]|l_sw[8]|l_sw[9]|out|pad|padres|vc|vcp|vdd|vddr|vip|vss|z
+ sg13_lv_nmos L=0.13u W=0.74u AS=0.3473p AD=0.12665p PS=2.71u PD=1.145u
+ rfmode=0
M$944 \$73023 \$73024
+ BOTTOM|TOP|VGND|VSS|anode|cathode|core|h_sw[0]|h_sw[10]|h_sw[1]|h_sw[2]|h_sw[3]|h_sw[4]|h_sw[5]|h_sw[6]|h_sw[7]|h_sw[8]|h_sw[9]|l_sw[0]|l_sw[10]|l_sw[1]|l_sw[2]|l_sw[3]|l_sw[4]|l_sw[5]|l_sw[6]|l_sw[7]|l_sw[8]|l_sw[9]|out|pad|padres|vc|vcp|vdd|vddr|vip|vss|z
+ BOTTOM|TOP|VGND|VSS|anode|cathode|core|h_sw[0]|h_sw[10]|h_sw[1]|h_sw[2]|h_sw[3]|h_sw[4]|h_sw[5]|h_sw[6]|h_sw[7]|h_sw[8]|h_sw[9]|l_sw[0]|l_sw[10]|l_sw[1]|l_sw[2]|l_sw[3]|l_sw[4]|l_sw[5]|l_sw[6]|l_sw[7]|l_sw[8]|l_sw[9]|out|pad|padres|vc|vcp|vdd|vddr|vip|vss|z
+ sg13_lv_nmos L=0.13u W=0.42u AS=0.1428p AD=0.0798p PS=1.52u PD=0.8u rfmode=0
M$945
+ BOTTOM|TOP|VGND|VSS|anode|cathode|core|h_sw[0]|h_sw[10]|h_sw[1]|h_sw[2]|h_sw[3]|h_sw[4]|h_sw[5]|h_sw[6]|h_sw[7]|h_sw[8]|h_sw[9]|l_sw[0]|l_sw[10]|l_sw[1]|l_sw[2]|l_sw[3]|l_sw[4]|l_sw[5]|l_sw[6]|l_sw[7]|l_sw[8]|l_sw[9]|out|pad|padres|vc|vcp|vdd|vddr|vip|vss|z
+ RESET_B|Y$1 \$73124
+ BOTTOM|TOP|VGND|VSS|anode|cathode|core|h_sw[0]|h_sw[10]|h_sw[1]|h_sw[2]|h_sw[3]|h_sw[4]|h_sw[5]|h_sw[6]|h_sw[7]|h_sw[8]|h_sw[9]|l_sw[0]|l_sw[10]|l_sw[1]|l_sw[2]|l_sw[3]|l_sw[4]|l_sw[5]|l_sw[6]|l_sw[7]|l_sw[8]|l_sw[9]|out|pad|padres|vc|vcp|vdd|vddr|vip|vss|z
+ sg13_lv_nmos L=0.13u W=0.42u AS=0.0798p AD=0.0378p PS=0.8u PD=0.6u rfmode=0
M$946 \$73124 \$73062 \$73024
+ BOTTOM|TOP|VGND|VSS|anode|cathode|core|h_sw[0]|h_sw[10]|h_sw[1]|h_sw[2]|h_sw[3]|h_sw[4]|h_sw[5]|h_sw[6]|h_sw[7]|h_sw[8]|h_sw[9]|l_sw[0]|l_sw[10]|l_sw[1]|l_sw[2]|l_sw[3]|l_sw[4]|l_sw[5]|l_sw[6]|l_sw[7]|l_sw[8]|l_sw[9]|out|pad|padres|vc|vcp|vdd|vddr|vip|vss|z
+ sg13_lv_nmos L=0.13u W=0.42u AS=0.0378p AD=0.1428p PS=0.6u PD=1.52u rfmode=0
M$947
+ BOTTOM|TOP|VGND|VSS|anode|cathode|core|h_sw[0]|h_sw[10]|h_sw[1]|h_sw[2]|h_sw[3]|h_sw[4]|h_sw[5]|h_sw[6]|h_sw[7]|h_sw[8]|h_sw[9]|l_sw[0]|l_sw[10]|l_sw[1]|l_sw[2]|l_sw[3]|l_sw[4]|l_sw[5]|l_sw[6]|l_sw[7]|l_sw[8]|l_sw[9]|out|pad|padres|vc|vcp|vdd|vddr|vip|vss|z
+ \$73062 D|Q_N$5
+ BOTTOM|TOP|VGND|VSS|anode|cathode|core|h_sw[0]|h_sw[10]|h_sw[1]|h_sw[2]|h_sw[3]|h_sw[4]|h_sw[5]|h_sw[6]|h_sw[7]|h_sw[8]|h_sw[9]|l_sw[0]|l_sw[10]|l_sw[1]|l_sw[2]|l_sw[3]|l_sw[4]|l_sw[5]|l_sw[6]|l_sw[7]|l_sw[8]|l_sw[9]|out|pad|padres|vc|vcp|vdd|vddr|vip|vss|z
+ sg13_lv_nmos L=0.13u W=0.74u AS=0.2516p AD=0.2849p PS=2.16u PD=2.25u rfmode=0
M$948 \$73026 \$73062
+ BOTTOM|TOP|VGND|VSS|anode|cathode|core|h_sw[0]|h_sw[10]|h_sw[1]|h_sw[2]|h_sw[3]|h_sw[4]|h_sw[5]|h_sw[6]|h_sw[7]|h_sw[8]|h_sw[9]|l_sw[0]|l_sw[10]|l_sw[1]|l_sw[2]|l_sw[3]|l_sw[4]|l_sw[5]|l_sw[6]|l_sw[7]|l_sw[8]|l_sw[9]|out|pad|padres|vc|vcp|vdd|vddr|vip|vss|z
+ BOTTOM|TOP|VGND|VSS|anode|cathode|core|h_sw[0]|h_sw[10]|h_sw[1]|h_sw[2]|h_sw[3]|h_sw[4]|h_sw[5]|h_sw[6]|h_sw[7]|h_sw[8]|h_sw[9]|l_sw[0]|l_sw[10]|l_sw[1]|l_sw[2]|l_sw[3]|l_sw[4]|l_sw[5]|l_sw[6]|l_sw[7]|l_sw[8]|l_sw[9]|out|pad|padres|vc|vcp|vdd|vddr|vip|vss|z
+ sg13_lv_nmos L=0.13u W=0.74u AS=0.2516p AD=0.1406p PS=2.16u PD=1.12u rfmode=0
M$949
+ BOTTOM|TOP|VGND|VSS|anode|cathode|core|h_sw[0]|h_sw[10]|h_sw[1]|h_sw[2]|h_sw[3]|h_sw[4]|h_sw[5]|h_sw[6]|h_sw[7]|h_sw[8]|h_sw[9]|l_sw[0]|l_sw[10]|l_sw[1]|l_sw[2]|l_sw[3]|l_sw[4]|l_sw[5]|l_sw[6]|l_sw[7]|l_sw[8]|l_sw[9]|out|pad|padres|vc|vcp|vdd|vddr|vip|vss|z
+ \$73026 A1|D|Q$2
+ BOTTOM|TOP|VGND|VSS|anode|cathode|core|h_sw[0]|h_sw[10]|h_sw[1]|h_sw[2]|h_sw[3]|h_sw[4]|h_sw[5]|h_sw[6]|h_sw[7]|h_sw[8]|h_sw[9]|l_sw[0]|l_sw[10]|l_sw[1]|l_sw[2]|l_sw[3]|l_sw[4]|l_sw[5]|l_sw[6]|l_sw[7]|l_sw[8]|l_sw[9]|out|pad|padres|vc|vcp|vdd|vddr|vip|vss|z
+ sg13_lv_nmos L=0.13u W=0.74u AS=0.1406p AD=0.2516p PS=1.12u PD=2.16u rfmode=0
M$950
+ BOTTOM|TOP|VGND|VSS|anode|cathode|core|h_sw[0]|h_sw[10]|h_sw[1]|h_sw[2]|h_sw[3]|h_sw[4]|h_sw[5]|h_sw[6]|h_sw[7]|h_sw[8]|h_sw[9]|l_sw[0]|l_sw[10]|l_sw[1]|l_sw[2]|l_sw[3]|l_sw[4]|l_sw[5]|l_sw[6]|l_sw[7]|l_sw[8]|l_sw[9]|out|pad|padres|vc|vcp|vdd|vddr|vip|vss|z
+ A1|D|Q$2 \$73063
+ BOTTOM|TOP|VGND|VSS|anode|cathode|core|h_sw[0]|h_sw[10]|h_sw[1]|h_sw[2]|h_sw[3]|h_sw[4]|h_sw[5]|h_sw[6]|h_sw[7]|h_sw[8]|h_sw[9]|l_sw[0]|l_sw[10]|l_sw[1]|l_sw[2]|l_sw[3]|l_sw[4]|l_sw[5]|l_sw[6]|l_sw[7]|l_sw[8]|l_sw[9]|out|pad|padres|vc|vcp|vdd|vddr|vip|vss|z
+ sg13_lv_nmos L=0.13u W=0.55u AS=0.15055p AD=0.187p PS=1.17u PD=1.78u rfmode=0
M$951
+ BOTTOM|TOP|VGND|VSS|anode|cathode|core|h_sw[0]|h_sw[10]|h_sw[1]|h_sw[2]|h_sw[3]|h_sw[4]|h_sw[5]|h_sw[6]|h_sw[7]|h_sw[8]|h_sw[9]|l_sw[0]|l_sw[10]|l_sw[1]|l_sw[2]|l_sw[3]|l_sw[4]|l_sw[5]|l_sw[6]|l_sw[7]|l_sw[8]|l_sw[9]|out|pad|padres|vc|vcp|vdd|vddr|vip|vss|z
+ CLK|D|GATE|Q$5 \$73028
+ BOTTOM|TOP|VGND|VSS|anode|cathode|core|h_sw[0]|h_sw[10]|h_sw[1]|h_sw[2]|h_sw[3]|h_sw[4]|h_sw[5]|h_sw[6]|h_sw[7]|h_sw[8]|h_sw[9]|l_sw[0]|l_sw[10]|l_sw[1]|l_sw[2]|l_sw[3]|l_sw[4]|l_sw[5]|l_sw[6]|l_sw[7]|l_sw[8]|l_sw[9]|out|pad|padres|vc|vcp|vdd|vddr|vip|vss|z
+ sg13_lv_nmos L=0.13u W=0.74u AS=0.15055p AD=0.2516p PS=1.17u PD=2.16u rfmode=0
M$952
+ BOTTOM|TOP|VGND|VSS|anode|cathode|core|h_sw[0]|h_sw[10]|h_sw[1]|h_sw[2]|h_sw[3]|h_sw[4]|h_sw[5]|h_sw[6]|h_sw[7]|h_sw[8]|h_sw[9]|l_sw[0]|l_sw[10]|l_sw[1]|l_sw[2]|l_sw[3]|l_sw[4]|l_sw[5]|l_sw[6]|l_sw[7]|l_sw[8]|l_sw[9]|out|pad|padres|vc|vcp|vdd|vddr|vip|vss|z
+ \$73063 \$73132
+ BOTTOM|TOP|VGND|VSS|anode|cathode|core|h_sw[0]|h_sw[10]|h_sw[1]|h_sw[2]|h_sw[3]|h_sw[4]|h_sw[5]|h_sw[6]|h_sw[7]|h_sw[8]|h_sw[9]|l_sw[0]|l_sw[10]|l_sw[1]|l_sw[2]|l_sw[3]|l_sw[4]|l_sw[5]|l_sw[6]|l_sw[7]|l_sw[8]|l_sw[9]|out|pad|padres|vc|vcp|vdd|vddr|vip|vss|z
+ sg13_lv_nmos L=0.13u W=0.64u AS=0.213425p AD=0.072p PS=1.62u PD=0.865u
+ rfmode=0
M$953 \$73132 \$73064 \$73065
+ BOTTOM|TOP|VGND|VSS|anode|cathode|core|h_sw[0]|h_sw[10]|h_sw[1]|h_sw[2]|h_sw[3]|h_sw[4]|h_sw[5]|h_sw[6]|h_sw[7]|h_sw[8]|h_sw[9]|l_sw[0]|l_sw[10]|l_sw[1]|l_sw[2]|l_sw[3]|l_sw[4]|l_sw[5]|l_sw[6]|l_sw[7]|l_sw[8]|l_sw[9]|out|pad|padres|vc|vcp|vdd|vddr|vip|vss|z
+ sg13_lv_nmos L=0.13u W=0.64u AS=0.072p AD=0.141p PS=0.865u PD=1.17u rfmode=0
M$954 \$73065 \$73028 \$73130
+ BOTTOM|TOP|VGND|VSS|anode|cathode|core|h_sw[0]|h_sw[10]|h_sw[1]|h_sw[2]|h_sw[3]|h_sw[4]|h_sw[5]|h_sw[6]|h_sw[7]|h_sw[8]|h_sw[9]|l_sw[0]|l_sw[10]|l_sw[1]|l_sw[2]|l_sw[3]|l_sw[4]|l_sw[5]|l_sw[6]|l_sw[7]|l_sw[8]|l_sw[9]|out|pad|padres|vc|vcp|vdd|vddr|vip|vss|z
+ sg13_lv_nmos L=0.13u W=0.42u AS=0.141p AD=0.04725p PS=1.17u PD=0.645u rfmode=0
M$955 \$73130 \$73029
+ BOTTOM|TOP|VGND|VSS|anode|cathode|core|h_sw[0]|h_sw[10]|h_sw[1]|h_sw[2]|h_sw[3]|h_sw[4]|h_sw[5]|h_sw[6]|h_sw[7]|h_sw[8]|h_sw[9]|l_sw[0]|l_sw[10]|l_sw[1]|l_sw[2]|l_sw[3]|l_sw[4]|l_sw[5]|l_sw[6]|l_sw[7]|l_sw[8]|l_sw[9]|out|pad|padres|vc|vcp|vdd|vddr|vip|vss|z
+ BOTTOM|TOP|VGND|VSS|anode|cathode|core|h_sw[0]|h_sw[10]|h_sw[1]|h_sw[2]|h_sw[3]|h_sw[4]|h_sw[5]|h_sw[6]|h_sw[7]|h_sw[8]|h_sw[9]|l_sw[0]|l_sw[10]|l_sw[1]|l_sw[2]|l_sw[3]|l_sw[4]|l_sw[5]|l_sw[6]|l_sw[7]|l_sw[8]|l_sw[9]|out|pad|padres|vc|vcp|vdd|vddr|vip|vss|z
+ sg13_lv_nmos L=0.13u W=0.42u AS=0.04725p AD=0.1428p PS=0.645u PD=1.52u
+ rfmode=0
M$956
+ BOTTOM|TOP|VGND|VSS|anode|cathode|core|h_sw[0]|h_sw[10]|h_sw[1]|h_sw[2]|h_sw[3]|h_sw[4]|h_sw[5]|h_sw[6]|h_sw[7]|h_sw[8]|h_sw[9]|l_sw[0]|l_sw[10]|l_sw[1]|l_sw[2]|l_sw[3]|l_sw[4]|l_sw[5]|l_sw[6]|l_sw[7]|l_sw[8]|l_sw[9]|out|pad|padres|vc|vcp|vdd|vddr|vip|vss|z
+ \$73028 \$73064
+ BOTTOM|TOP|VGND|VSS|anode|cathode|core|h_sw[0]|h_sw[10]|h_sw[1]|h_sw[2]|h_sw[3]|h_sw[4]|h_sw[5]|h_sw[6]|h_sw[7]|h_sw[8]|h_sw[9]|l_sw[0]|l_sw[10]|l_sw[1]|l_sw[2]|l_sw[3]|l_sw[4]|l_sw[5]|l_sw[6]|l_sw[7]|l_sw[8]|l_sw[9]|out|pad|padres|vc|vcp|vdd|vddr|vip|vss|z
+ sg13_lv_nmos L=0.13u W=0.74u AS=0.213425p AD=0.2775p PS=1.62u PD=2.23u
+ rfmode=0
M$957 \$73029 \$73065 \$73138
+ BOTTOM|TOP|VGND|VSS|anode|cathode|core|h_sw[0]|h_sw[10]|h_sw[1]|h_sw[2]|h_sw[3]|h_sw[4]|h_sw[5]|h_sw[6]|h_sw[7]|h_sw[8]|h_sw[9]|l_sw[0]|l_sw[10]|l_sw[1]|l_sw[2]|l_sw[3]|l_sw[4]|l_sw[5]|l_sw[6]|l_sw[7]|l_sw[8]|l_sw[9]|out|pad|padres|vc|vcp|vdd|vddr|vip|vss|z
+ sg13_lv_nmos L=0.13u W=0.74u AS=0.2516p AD=0.0777p PS=2.16u PD=0.95u rfmode=0
M$958 \$73138 RESET_B|Y$1
+ BOTTOM|TOP|VGND|VSS|anode|cathode|core|h_sw[0]|h_sw[10]|h_sw[1]|h_sw[2]|h_sw[3]|h_sw[4]|h_sw[5]|h_sw[6]|h_sw[7]|h_sw[8]|h_sw[9]|l_sw[0]|l_sw[10]|l_sw[1]|l_sw[2]|l_sw[3]|l_sw[4]|l_sw[5]|l_sw[6]|l_sw[7]|l_sw[8]|l_sw[9]|out|pad|padres|vc|vcp|vdd|vddr|vip|vss|z
+ BOTTOM|TOP|VGND|VSS|anode|cathode|core|h_sw[0]|h_sw[10]|h_sw[1]|h_sw[2]|h_sw[3]|h_sw[4]|h_sw[5]|h_sw[6]|h_sw[7]|h_sw[8]|h_sw[9]|l_sw[0]|l_sw[10]|l_sw[1]|l_sw[2]|l_sw[3]|l_sw[4]|l_sw[5]|l_sw[6]|l_sw[7]|l_sw[8]|l_sw[9]|out|pad|padres|vc|vcp|vdd|vddr|vip|vss|z
+ sg13_lv_nmos L=0.13u W=0.74u AS=0.0777p AD=0.1406p PS=0.95u PD=1.12u rfmode=0
M$959
+ BOTTOM|TOP|VGND|VSS|anode|cathode|core|h_sw[0]|h_sw[10]|h_sw[1]|h_sw[2]|h_sw[3]|h_sw[4]|h_sw[5]|h_sw[6]|h_sw[7]|h_sw[8]|h_sw[9]|l_sw[0]|l_sw[10]|l_sw[1]|l_sw[2]|l_sw[3]|l_sw[4]|l_sw[5]|l_sw[6]|l_sw[7]|l_sw[8]|l_sw[9]|out|pad|padres|vc|vcp|vdd|vddr|vip|vss|z
+ \$73029 A|Q$12
+ BOTTOM|TOP|VGND|VSS|anode|cathode|core|h_sw[0]|h_sw[10]|h_sw[1]|h_sw[2]|h_sw[3]|h_sw[4]|h_sw[5]|h_sw[6]|h_sw[7]|h_sw[8]|h_sw[9]|l_sw[0]|l_sw[10]|l_sw[1]|l_sw[2]|l_sw[3]|l_sw[4]|l_sw[5]|l_sw[6]|l_sw[7]|l_sw[8]|l_sw[9]|out|pad|padres|vc|vcp|vdd|vddr|vip|vss|z
+ sg13_lv_nmos L=0.13u W=0.74u AS=0.1406p AD=0.2516p PS=1.12u PD=2.16u rfmode=0
M$960
+ BOTTOM|TOP|VGND|VSS|anode|cathode|core|h_sw[0]|h_sw[10]|h_sw[1]|h_sw[2]|h_sw[3]|h_sw[4]|h_sw[5]|h_sw[6]|h_sw[7]|h_sw[8]|h_sw[9]|l_sw[0]|l_sw[10]|l_sw[1]|l_sw[2]|l_sw[3]|l_sw[4]|l_sw[5]|l_sw[6]|l_sw[7]|l_sw[8]|l_sw[9]|out|pad|padres|vc|vcp|vdd|vddr|vip|vss|z
+ \$73029 \$73031
+ BOTTOM|TOP|VGND|VSS|anode|cathode|core|h_sw[0]|h_sw[10]|h_sw[1]|h_sw[2]|h_sw[3]|h_sw[4]|h_sw[5]|h_sw[6]|h_sw[7]|h_sw[8]|h_sw[9]|l_sw[0]|l_sw[10]|l_sw[1]|l_sw[2]|l_sw[3]|l_sw[4]|l_sw[5]|l_sw[6]|l_sw[7]|l_sw[8]|l_sw[9]|out|pad|padres|vc|vcp|vdd|vddr|vip|vss|z
+ sg13_lv_nmos L=0.13u W=0.55u AS=0.1491p AD=0.187p PS=1.18u PD=1.78u rfmode=0
M$961
+ BOTTOM|TOP|VGND|VSS|anode|cathode|core|h_sw[0]|h_sw[10]|h_sw[1]|h_sw[2]|h_sw[3]|h_sw[4]|h_sw[5]|h_sw[6]|h_sw[7]|h_sw[8]|h_sw[9]|l_sw[0]|l_sw[10]|l_sw[1]|l_sw[2]|l_sw[3]|l_sw[4]|l_sw[5]|l_sw[6]|l_sw[7]|l_sw[8]|l_sw[9]|out|pad|padres|vc|vcp|vdd|vddr|vip|vss|z
+ \$73031 Q_N$23
+ BOTTOM|TOP|VGND|VSS|anode|cathode|core|h_sw[0]|h_sw[10]|h_sw[1]|h_sw[2]|h_sw[3]|h_sw[4]|h_sw[5]|h_sw[6]|h_sw[7]|h_sw[8]|h_sw[9]|l_sw[0]|l_sw[10]|l_sw[1]|l_sw[2]|l_sw[3]|l_sw[4]|l_sw[5]|l_sw[6]|l_sw[7]|l_sw[8]|l_sw[9]|out|pad|padres|vc|vcp|vdd|vddr|vip|vss|z
+ sg13_lv_nmos L=0.13u W=0.74u AS=0.1491p AD=0.2516p PS=1.18u PD=2.16u rfmode=0
M$962 A|X$35 \$73066
+ BOTTOM|TOP|VGND|VSS|anode|cathode|core|h_sw[0]|h_sw[10]|h_sw[1]|h_sw[2]|h_sw[3]|h_sw[4]|h_sw[5]|h_sw[6]|h_sw[7]|h_sw[8]|h_sw[9]|l_sw[0]|l_sw[10]|l_sw[1]|l_sw[2]|l_sw[3]|l_sw[4]|l_sw[5]|l_sw[6]|l_sw[7]|l_sw[8]|l_sw[9]|out|pad|padres|vc|vcp|vdd|vddr|vip|vss|z
+ BOTTOM|TOP|VGND|VSS|anode|cathode|core|h_sw[0]|h_sw[10]|h_sw[1]|h_sw[2]|h_sw[3]|h_sw[4]|h_sw[5]|h_sw[6]|h_sw[7]|h_sw[8]|h_sw[9]|l_sw[0]|l_sw[10]|l_sw[1]|l_sw[2]|l_sw[3]|l_sw[4]|l_sw[5]|l_sw[6]|l_sw[7]|l_sw[8]|l_sw[9]|out|pad|padres|vc|vcp|vdd|vddr|vip|vss|z
+ sg13_lv_nmos L=0.13u W=0.74u AS=0.2886p AD=0.14875p PS=2.26u PD=1.16u rfmode=0
M$963
+ BOTTOM|TOP|VGND|VSS|anode|cathode|core|h_sw[0]|h_sw[10]|h_sw[1]|h_sw[2]|h_sw[3]|h_sw[4]|h_sw[5]|h_sw[6]|h_sw[7]|h_sw[8]|h_sw[9]|l_sw[0]|l_sw[10]|l_sw[1]|l_sw[2]|l_sw[3]|l_sw[4]|l_sw[5]|l_sw[6]|l_sw[7]|l_sw[8]|l_sw[9]|out|pad|padres|vc|vcp|vdd|vddr|vip|vss|z
+ A|Q$12 \$73066
+ BOTTOM|TOP|VGND|VSS|anode|cathode|core|h_sw[0]|h_sw[10]|h_sw[1]|h_sw[2]|h_sw[3]|h_sw[4]|h_sw[5]|h_sw[6]|h_sw[7]|h_sw[8]|h_sw[9]|l_sw[0]|l_sw[10]|l_sw[1]|l_sw[2]|l_sw[3]|l_sw[4]|l_sw[5]|l_sw[6]|l_sw[7]|l_sw[8]|l_sw[9]|out|pad|padres|vc|vcp|vdd|vddr|vip|vss|z
+ sg13_lv_nmos L=0.13u W=0.55u AS=0.14875p AD=0.187p PS=1.16u PD=1.78u rfmode=0
M$964 A|X$25 \$73067
+ BOTTOM|TOP|VGND|VSS|anode|cathode|core|h_sw[0]|h_sw[10]|h_sw[1]|h_sw[2]|h_sw[3]|h_sw[4]|h_sw[5]|h_sw[6]|h_sw[7]|h_sw[8]|h_sw[9]|l_sw[0]|l_sw[10]|l_sw[1]|l_sw[2]|l_sw[3]|l_sw[4]|l_sw[5]|l_sw[6]|l_sw[7]|l_sw[8]|l_sw[9]|out|pad|padres|vc|vcp|vdd|vddr|vip|vss|z
+ BOTTOM|TOP|VGND|VSS|anode|cathode|core|h_sw[0]|h_sw[10]|h_sw[1]|h_sw[2]|h_sw[3]|h_sw[4]|h_sw[5]|h_sw[6]|h_sw[7]|h_sw[8]|h_sw[9]|l_sw[0]|l_sw[10]|l_sw[1]|l_sw[2]|l_sw[3]|l_sw[4]|l_sw[5]|l_sw[6]|l_sw[7]|l_sw[8]|l_sw[9]|out|pad|padres|vc|vcp|vdd|vddr|vip|vss|z
+ sg13_lv_nmos L=0.13u W=0.74u AS=0.2886p AD=0.14875p PS=2.26u PD=1.16u rfmode=0
M$965
+ BOTTOM|TOP|VGND|VSS|anode|cathode|core|h_sw[0]|h_sw[10]|h_sw[1]|h_sw[2]|h_sw[3]|h_sw[4]|h_sw[5]|h_sw[6]|h_sw[7]|h_sw[8]|h_sw[9]|l_sw[0]|l_sw[10]|l_sw[1]|l_sw[2]|l_sw[3]|l_sw[4]|l_sw[5]|l_sw[6]|l_sw[7]|l_sw[8]|l_sw[9]|out|pad|padres|vc|vcp|vdd|vddr|vip|vss|z
+ A|Q$16 \$73067
+ BOTTOM|TOP|VGND|VSS|anode|cathode|core|h_sw[0]|h_sw[10]|h_sw[1]|h_sw[2]|h_sw[3]|h_sw[4]|h_sw[5]|h_sw[6]|h_sw[7]|h_sw[8]|h_sw[9]|l_sw[0]|l_sw[10]|l_sw[1]|l_sw[2]|l_sw[3]|l_sw[4]|l_sw[5]|l_sw[6]|l_sw[7]|l_sw[8]|l_sw[9]|out|pad|padres|vc|vcp|vdd|vddr|vip|vss|z
+ sg13_lv_nmos L=0.13u W=0.55u AS=0.14875p AD=0.187p PS=1.16u PD=1.78u rfmode=0
M$969 A1|Y$4 A|D|Q$1
+ BOTTOM|TOP|VGND|VSS|anode|cathode|core|h_sw[0]|h_sw[10]|h_sw[1]|h_sw[2]|h_sw[3]|h_sw[4]|h_sw[5]|h_sw[6]|h_sw[7]|h_sw[8]|h_sw[9]|l_sw[0]|l_sw[10]|l_sw[1]|l_sw[2]|l_sw[3]|l_sw[4]|l_sw[5]|l_sw[6]|l_sw[7]|l_sw[8]|l_sw[9]|out|pad|padres|vc|vcp|vdd|vddr|vip|vss|z
+ BOTTOM|TOP|VGND|VSS|anode|cathode|core|h_sw[0]|h_sw[10]|h_sw[1]|h_sw[2]|h_sw[3]|h_sw[4]|h_sw[5]|h_sw[6]|h_sw[7]|h_sw[8]|h_sw[9]|l_sw[0]|l_sw[10]|l_sw[1]|l_sw[2]|l_sw[3]|l_sw[4]|l_sw[5]|l_sw[6]|l_sw[7]|l_sw[8]|l_sw[9]|out|pad|padres|vc|vcp|vdd|vddr|vip|vss|z
+ sg13_lv_nmos L=0.13u W=0.74u AS=0.2516p AD=0.2516p PS=2.16u PD=2.16u rfmode=0
M$970 \$73033 D|X$1 \$73139
+ BOTTOM|TOP|VGND|VSS|anode|cathode|core|h_sw[0]|h_sw[10]|h_sw[1]|h_sw[2]|h_sw[3]|h_sw[4]|h_sw[5]|h_sw[6]|h_sw[7]|h_sw[8]|h_sw[9]|l_sw[0]|l_sw[10]|l_sw[1]|l_sw[2]|l_sw[3]|l_sw[4]|l_sw[5]|l_sw[6]|l_sw[7]|l_sw[8]|l_sw[9]|out|pad|padres|vc|vcp|vdd|vddr|vip|vss|z
+ sg13_lv_nmos L=0.13u W=0.42u AS=0.1428p AD=0.0609p PS=1.52u PD=0.71u rfmode=0
M$971 \$73139 RESET_B|Y$1
+ BOTTOM|TOP|VGND|VSS|anode|cathode|core|h_sw[0]|h_sw[10]|h_sw[1]|h_sw[2]|h_sw[3]|h_sw[4]|h_sw[5]|h_sw[6]|h_sw[7]|h_sw[8]|h_sw[9]|l_sw[0]|l_sw[10]|l_sw[1]|l_sw[2]|l_sw[3]|l_sw[4]|l_sw[5]|l_sw[6]|l_sw[7]|l_sw[8]|l_sw[9]|out|pad|padres|vc|vcp|vdd|vddr|vip|vss|z
+ BOTTOM|TOP|VGND|VSS|anode|cathode|core|h_sw[0]|h_sw[10]|h_sw[1]|h_sw[2]|h_sw[3]|h_sw[4]|h_sw[5]|h_sw[6]|h_sw[7]|h_sw[8]|h_sw[9]|l_sw[0]|l_sw[10]|l_sw[1]|l_sw[2]|l_sw[3]|l_sw[4]|l_sw[5]|l_sw[6]|l_sw[7]|l_sw[8]|l_sw[9]|out|pad|padres|vc|vcp|vdd|vddr|vip|vss|z
+ sg13_lv_nmos L=0.13u W=0.42u AS=0.0609p AD=0.1626p PS=0.71u PD=1.415u rfmode=0
M$972
+ BOTTOM|TOP|VGND|VSS|anode|cathode|core|h_sw[0]|h_sw[10]|h_sw[1]|h_sw[2]|h_sw[3]|h_sw[4]|h_sw[5]|h_sw[6]|h_sw[7]|h_sw[8]|h_sw[9]|l_sw[0]|l_sw[10]|l_sw[1]|l_sw[2]|l_sw[3]|l_sw[4]|l_sw[5]|l_sw[6]|l_sw[7]|l_sw[8]|l_sw[9]|out|pad|padres|vc|vcp|vdd|vddr|vip|vss|z
+ \$73156 \$73035
+ BOTTOM|TOP|VGND|VSS|anode|cathode|core|h_sw[0]|h_sw[10]|h_sw[1]|h_sw[2]|h_sw[3]|h_sw[4]|h_sw[5]|h_sw[6]|h_sw[7]|h_sw[8]|h_sw[9]|l_sw[0]|l_sw[10]|l_sw[1]|l_sw[2]|l_sw[3]|l_sw[4]|l_sw[5]|l_sw[6]|l_sw[7]|l_sw[8]|l_sw[9]|out|pad|padres|vc|vcp|vdd|vddr|vip|vss|z
+ sg13_lv_nmos L=0.13u W=0.74u AS=0.1626p AD=0.2516p PS=1.415u PD=2.16u rfmode=0
M$973
+ BOTTOM|TOP|VGND|VSS|anode|cathode|core|h_sw[0]|h_sw[10]|h_sw[1]|h_sw[2]|h_sw[3]|h_sw[4]|h_sw[5]|h_sw[6]|h_sw[7]|h_sw[8]|h_sw[9]|l_sw[0]|l_sw[10]|l_sw[1]|l_sw[2]|l_sw[3]|l_sw[4]|l_sw[5]|l_sw[6]|l_sw[7]|l_sw[8]|l_sw[9]|out|pad|padres|vc|vcp|vdd|vddr|vip|vss|z
+ RESET_B|Y$1 \$73141
+ BOTTOM|TOP|VGND|VSS|anode|cathode|core|h_sw[0]|h_sw[10]|h_sw[1]|h_sw[2]|h_sw[3]|h_sw[4]|h_sw[5]|h_sw[6]|h_sw[7]|h_sw[8]|h_sw[9]|l_sw[0]|l_sw[10]|l_sw[1]|l_sw[2]|l_sw[3]|l_sw[4]|l_sw[5]|l_sw[6]|l_sw[7]|l_sw[8]|l_sw[9]|out|pad|padres|vc|vcp|vdd|vddr|vip|vss|z
+ sg13_lv_nmos L=0.13u W=0.42u AS=0.1701p AD=0.0378p PS=1.65u PD=0.6u rfmode=0
M$974 \$73141 \$73035 \$73034
+ BOTTOM|TOP|VGND|VSS|anode|cathode|core|h_sw[0]|h_sw[10]|h_sw[1]|h_sw[2]|h_sw[3]|h_sw[4]|h_sw[5]|h_sw[6]|h_sw[7]|h_sw[8]|h_sw[9]|l_sw[0]|l_sw[10]|l_sw[1]|l_sw[2]|l_sw[3]|l_sw[4]|l_sw[5]|l_sw[6]|l_sw[7]|l_sw[8]|l_sw[9]|out|pad|padres|vc|vcp|vdd|vddr|vip|vss|z
+ sg13_lv_nmos L=0.13u W=0.42u AS=0.0378p AD=0.1428p PS=0.6u PD=1.52u rfmode=0
M$975 \$73069 \$73036 \$73037
+ BOTTOM|TOP|VGND|VSS|anode|cathode|core|h_sw[0]|h_sw[10]|h_sw[1]|h_sw[2]|h_sw[3]|h_sw[4]|h_sw[5]|h_sw[6]|h_sw[7]|h_sw[8]|h_sw[9]|l_sw[0]|l_sw[10]|l_sw[1]|l_sw[2]|l_sw[3]|l_sw[4]|l_sw[5]|l_sw[6]|l_sw[7]|l_sw[8]|l_sw[9]|out|pad|padres|vc|vcp|vdd|vddr|vip|vss|z
+ sg13_lv_nmos L=0.13u W=0.42u AS=0.12665p AD=0.1428p PS=1.145u PD=1.52u
+ rfmode=0
M$976 \$73035 \$73068 \$73069
+ BOTTOM|TOP|VGND|VSS|anode|cathode|core|h_sw[0]|h_sw[10]|h_sw[1]|h_sw[2]|h_sw[3]|h_sw[4]|h_sw[5]|h_sw[6]|h_sw[7]|h_sw[8]|h_sw[9]|l_sw[0]|l_sw[10]|l_sw[1]|l_sw[2]|l_sw[3]|l_sw[4]|l_sw[5]|l_sw[6]|l_sw[7]|l_sw[8]|l_sw[9]|out|pad|padres|vc|vcp|vdd|vddr|vip|vss|z
+ sg13_lv_nmos L=0.13u W=0.74u AS=0.3473p AD=0.12665p PS=2.71u PD=1.145u
+ rfmode=0
M$977 \$73037 \$73038
+ BOTTOM|TOP|VGND|VSS|anode|cathode|core|h_sw[0]|h_sw[10]|h_sw[1]|h_sw[2]|h_sw[3]|h_sw[4]|h_sw[5]|h_sw[6]|h_sw[7]|h_sw[8]|h_sw[9]|l_sw[0]|l_sw[10]|l_sw[1]|l_sw[2]|l_sw[3]|l_sw[4]|l_sw[5]|l_sw[6]|l_sw[7]|l_sw[8]|l_sw[9]|out|pad|padres|vc|vcp|vdd|vddr|vip|vss|z
+ BOTTOM|TOP|VGND|VSS|anode|cathode|core|h_sw[0]|h_sw[10]|h_sw[1]|h_sw[2]|h_sw[3]|h_sw[4]|h_sw[5]|h_sw[6]|h_sw[7]|h_sw[8]|h_sw[9]|l_sw[0]|l_sw[10]|l_sw[1]|l_sw[2]|l_sw[3]|l_sw[4]|l_sw[5]|l_sw[6]|l_sw[7]|l_sw[8]|l_sw[9]|out|pad|padres|vc|vcp|vdd|vddr|vip|vss|z
+ sg13_lv_nmos L=0.13u W=0.42u AS=0.1428p AD=0.0798p PS=1.52u PD=0.8u rfmode=0
M$978
+ BOTTOM|TOP|VGND|VSS|anode|cathode|core|h_sw[0]|h_sw[10]|h_sw[1]|h_sw[2]|h_sw[3]|h_sw[4]|h_sw[5]|h_sw[6]|h_sw[7]|h_sw[8]|h_sw[9]|l_sw[0]|l_sw[10]|l_sw[1]|l_sw[2]|l_sw[3]|l_sw[4]|l_sw[5]|l_sw[6]|l_sw[7]|l_sw[8]|l_sw[9]|out|pad|padres|vc|vcp|vdd|vddr|vip|vss|z
+ RESET_B|Y$1 \$73142
+ BOTTOM|TOP|VGND|VSS|anode|cathode|core|h_sw[0]|h_sw[10]|h_sw[1]|h_sw[2]|h_sw[3]|h_sw[4]|h_sw[5]|h_sw[6]|h_sw[7]|h_sw[8]|h_sw[9]|l_sw[0]|l_sw[10]|l_sw[1]|l_sw[2]|l_sw[3]|l_sw[4]|l_sw[5]|l_sw[6]|l_sw[7]|l_sw[8]|l_sw[9]|out|pad|padres|vc|vcp|vdd|vddr|vip|vss|z
+ sg13_lv_nmos L=0.13u W=0.42u AS=0.0798p AD=0.0378p PS=0.8u PD=0.6u rfmode=0
M$979 \$73142 \$73069 \$73038
+ BOTTOM|TOP|VGND|VSS|anode|cathode|core|h_sw[0]|h_sw[10]|h_sw[1]|h_sw[2]|h_sw[3]|h_sw[4]|h_sw[5]|h_sw[6]|h_sw[7]|h_sw[8]|h_sw[9]|l_sw[0]|l_sw[10]|l_sw[1]|l_sw[2]|l_sw[3]|l_sw[4]|l_sw[5]|l_sw[6]|l_sw[7]|l_sw[8]|l_sw[9]|out|pad|padres|vc|vcp|vdd|vddr|vip|vss|z
+ sg13_lv_nmos L=0.13u W=0.42u AS=0.0378p AD=0.1428p PS=0.6u PD=1.52u rfmode=0
M$980
+ BOTTOM|TOP|VGND|VSS|anode|cathode|core|h_sw[0]|h_sw[10]|h_sw[1]|h_sw[2]|h_sw[3]|h_sw[4]|h_sw[5]|h_sw[6]|h_sw[7]|h_sw[8]|h_sw[9]|l_sw[0]|l_sw[10]|l_sw[1]|l_sw[2]|l_sw[3]|l_sw[4]|l_sw[5]|l_sw[6]|l_sw[7]|l_sw[8]|l_sw[9]|out|pad|padres|vc|vcp|vdd|vddr|vip|vss|z
+ \$73069 D|Q_N$4
+ BOTTOM|TOP|VGND|VSS|anode|cathode|core|h_sw[0]|h_sw[10]|h_sw[1]|h_sw[2]|h_sw[3]|h_sw[4]|h_sw[5]|h_sw[6]|h_sw[7]|h_sw[8]|h_sw[9]|l_sw[0]|l_sw[10]|l_sw[1]|l_sw[2]|l_sw[3]|l_sw[4]|l_sw[5]|l_sw[6]|l_sw[7]|l_sw[8]|l_sw[9]|out|pad|padres|vc|vcp|vdd|vddr|vip|vss|z
+ sg13_lv_nmos L=0.13u W=0.74u AS=0.2516p AD=0.2849p PS=2.16u PD=2.25u rfmode=0
M$981 \$73039 \$73069
+ BOTTOM|TOP|VGND|VSS|anode|cathode|core|h_sw[0]|h_sw[10]|h_sw[1]|h_sw[2]|h_sw[3]|h_sw[4]|h_sw[5]|h_sw[6]|h_sw[7]|h_sw[8]|h_sw[9]|l_sw[0]|l_sw[10]|l_sw[1]|l_sw[2]|l_sw[3]|l_sw[4]|l_sw[5]|l_sw[6]|l_sw[7]|l_sw[8]|l_sw[9]|out|pad|padres|vc|vcp|vdd|vddr|vip|vss|z
+ BOTTOM|TOP|VGND|VSS|anode|cathode|core|h_sw[0]|h_sw[10]|h_sw[1]|h_sw[2]|h_sw[3]|h_sw[4]|h_sw[5]|h_sw[6]|h_sw[7]|h_sw[8]|h_sw[9]|l_sw[0]|l_sw[10]|l_sw[1]|l_sw[2]|l_sw[3]|l_sw[4]|l_sw[5]|l_sw[6]|l_sw[7]|l_sw[8]|l_sw[9]|out|pad|padres|vc|vcp|vdd|vddr|vip|vss|z
+ sg13_lv_nmos L=0.13u W=0.74u AS=0.2516p AD=0.1406p PS=2.16u PD=1.12u rfmode=0
M$982
+ BOTTOM|TOP|VGND|VSS|anode|cathode|core|h_sw[0]|h_sw[10]|h_sw[1]|h_sw[2]|h_sw[3]|h_sw[4]|h_sw[5]|h_sw[6]|h_sw[7]|h_sw[8]|h_sw[9]|l_sw[0]|l_sw[10]|l_sw[1]|l_sw[2]|l_sw[3]|l_sw[4]|l_sw[5]|l_sw[6]|l_sw[7]|l_sw[8]|l_sw[9]|out|pad|padres|vc|vcp|vdd|vddr|vip|vss|z
+ \$73039 B2|D|Q$1
+ BOTTOM|TOP|VGND|VSS|anode|cathode|core|h_sw[0]|h_sw[10]|h_sw[1]|h_sw[2]|h_sw[3]|h_sw[4]|h_sw[5]|h_sw[6]|h_sw[7]|h_sw[8]|h_sw[9]|l_sw[0]|l_sw[10]|l_sw[1]|l_sw[2]|l_sw[3]|l_sw[4]|l_sw[5]|l_sw[6]|l_sw[7]|l_sw[8]|l_sw[9]|out|pad|padres|vc|vcp|vdd|vddr|vip|vss|z
+ sg13_lv_nmos L=0.13u W=0.74u AS=0.1406p AD=0.2516p PS=1.12u PD=2.16u rfmode=0
M$983
+ BOTTOM|TOP|VGND|VSS|anode|cathode|core|h_sw[0]|h_sw[10]|h_sw[1]|h_sw[2]|h_sw[3]|h_sw[4]|h_sw[5]|h_sw[6]|h_sw[7]|h_sw[8]|h_sw[9]|l_sw[0]|l_sw[10]|l_sw[1]|l_sw[2]|l_sw[3]|l_sw[4]|l_sw[5]|l_sw[6]|l_sw[7]|l_sw[8]|l_sw[9]|out|pad|padres|vc|vcp|vdd|vddr|vip|vss|z
+ A|Q$17 \$73070
+ BOTTOM|TOP|VGND|VSS|anode|cathode|core|h_sw[0]|h_sw[10]|h_sw[1]|h_sw[2]|h_sw[3]|h_sw[4]|h_sw[5]|h_sw[6]|h_sw[7]|h_sw[8]|h_sw[9]|l_sw[0]|l_sw[10]|l_sw[1]|l_sw[2]|l_sw[3]|l_sw[4]|l_sw[5]|l_sw[6]|l_sw[7]|l_sw[8]|l_sw[9]|out|pad|padres|vc|vcp|vdd|vddr|vip|vss|z
+ sg13_lv_nmos L=0.13u W=0.55u AS=0.14875p AD=0.187p PS=1.16u PD=1.78u rfmode=0
M$984
+ BOTTOM|TOP|VGND|VSS|anode|cathode|core|h_sw[0]|h_sw[10]|h_sw[1]|h_sw[2]|h_sw[3]|h_sw[4]|h_sw[5]|h_sw[6]|h_sw[7]|h_sw[8]|h_sw[9]|l_sw[0]|l_sw[10]|l_sw[1]|l_sw[2]|l_sw[3]|l_sw[4]|l_sw[5]|l_sw[6]|l_sw[7]|l_sw[8]|l_sw[9]|out|pad|padres|vc|vcp|vdd|vddr|vip|vss|z
+ \$73070 A|X$43
+ BOTTOM|TOP|VGND|VSS|anode|cathode|core|h_sw[0]|h_sw[10]|h_sw[1]|h_sw[2]|h_sw[3]|h_sw[4]|h_sw[5]|h_sw[6]|h_sw[7]|h_sw[8]|h_sw[9]|l_sw[0]|l_sw[10]|l_sw[1]|l_sw[2]|l_sw[3]|l_sw[4]|l_sw[5]|l_sw[6]|l_sw[7]|l_sw[8]|l_sw[9]|out|pad|padres|vc|vcp|vdd|vddr|vip|vss|z
+ sg13_lv_nmos L=0.13u W=0.74u AS=0.14875p AD=0.2886p PS=1.16u PD=2.26u rfmode=0
M$985
+ BOTTOM|TOP|VGND|VSS|anode|cathode|core|h_sw[0]|h_sw[10]|h_sw[1]|h_sw[2]|h_sw[3]|h_sw[4]|h_sw[5]|h_sw[6]|h_sw[7]|h_sw[8]|h_sw[9]|l_sw[0]|l_sw[10]|l_sw[1]|l_sw[2]|l_sw[3]|l_sw[4]|l_sw[5]|l_sw[6]|l_sw[7]|l_sw[8]|l_sw[9]|out|pad|padres|vc|vcp|vdd|vddr|vip|vss|z
+ A|Q$10 \$73071
+ BOTTOM|TOP|VGND|VSS|anode|cathode|core|h_sw[0]|h_sw[10]|h_sw[1]|h_sw[2]|h_sw[3]|h_sw[4]|h_sw[5]|h_sw[6]|h_sw[7]|h_sw[8]|h_sw[9]|l_sw[0]|l_sw[10]|l_sw[1]|l_sw[2]|l_sw[3]|l_sw[4]|l_sw[5]|l_sw[6]|l_sw[7]|l_sw[8]|l_sw[9]|out|pad|padres|vc|vcp|vdd|vddr|vip|vss|z
+ sg13_lv_nmos L=0.13u W=0.55u AS=0.14875p AD=0.187p PS=1.16u PD=1.78u rfmode=0
M$986
+ BOTTOM|TOP|VGND|VSS|anode|cathode|core|h_sw[0]|h_sw[10]|h_sw[1]|h_sw[2]|h_sw[3]|h_sw[4]|h_sw[5]|h_sw[6]|h_sw[7]|h_sw[8]|h_sw[9]|l_sw[0]|l_sw[10]|l_sw[1]|l_sw[2]|l_sw[3]|l_sw[4]|l_sw[5]|l_sw[6]|l_sw[7]|l_sw[8]|l_sw[9]|out|pad|padres|vc|vcp|vdd|vddr|vip|vss|z
+ \$73071 A|X$27
+ BOTTOM|TOP|VGND|VSS|anode|cathode|core|h_sw[0]|h_sw[10]|h_sw[1]|h_sw[2]|h_sw[3]|h_sw[4]|h_sw[5]|h_sw[6]|h_sw[7]|h_sw[8]|h_sw[9]|l_sw[0]|l_sw[10]|l_sw[1]|l_sw[2]|l_sw[3]|l_sw[4]|l_sw[5]|l_sw[6]|l_sw[7]|l_sw[8]|l_sw[9]|out|pad|padres|vc|vcp|vdd|vddr|vip|vss|z
+ sg13_lv_nmos L=0.13u W=0.74u AS=0.14875p AD=0.2886p PS=1.16u PD=2.26u rfmode=0
M$987 \$73040 D|X$1 \$73143
+ BOTTOM|TOP|VGND|VSS|anode|cathode|core|h_sw[0]|h_sw[10]|h_sw[1]|h_sw[2]|h_sw[3]|h_sw[4]|h_sw[5]|h_sw[6]|h_sw[7]|h_sw[8]|h_sw[9]|l_sw[0]|l_sw[10]|l_sw[1]|l_sw[2]|l_sw[3]|l_sw[4]|l_sw[5]|l_sw[6]|l_sw[7]|l_sw[8]|l_sw[9]|out|pad|padres|vc|vcp|vdd|vddr|vip|vss|z
+ sg13_lv_nmos L=0.13u W=0.42u AS=0.1428p AD=0.0609p PS=1.52u PD=0.71u rfmode=0
M$988 \$73143 RESET_B|Y$1
+ BOTTOM|TOP|VGND|VSS|anode|cathode|core|h_sw[0]|h_sw[10]|h_sw[1]|h_sw[2]|h_sw[3]|h_sw[4]|h_sw[5]|h_sw[6]|h_sw[7]|h_sw[8]|h_sw[9]|l_sw[0]|l_sw[10]|l_sw[1]|l_sw[2]|l_sw[3]|l_sw[4]|l_sw[5]|l_sw[6]|l_sw[7]|l_sw[8]|l_sw[9]|out|pad|padres|vc|vcp|vdd|vddr|vip|vss|z
+ BOTTOM|TOP|VGND|VSS|anode|cathode|core|h_sw[0]|h_sw[10]|h_sw[1]|h_sw[2]|h_sw[3]|h_sw[4]|h_sw[5]|h_sw[6]|h_sw[7]|h_sw[8]|h_sw[9]|l_sw[0]|l_sw[10]|l_sw[1]|l_sw[2]|l_sw[3]|l_sw[4]|l_sw[5]|l_sw[6]|l_sw[7]|l_sw[8]|l_sw[9]|out|pad|padres|vc|vcp|vdd|vddr|vip|vss|z
+ sg13_lv_nmos L=0.13u W=0.42u AS=0.0609p AD=0.1626p PS=0.71u PD=1.415u rfmode=0
M$989
+ BOTTOM|TOP|VGND|VSS|anode|cathode|core|h_sw[0]|h_sw[10]|h_sw[1]|h_sw[2]|h_sw[3]|h_sw[4]|h_sw[5]|h_sw[6]|h_sw[7]|h_sw[8]|h_sw[9]|l_sw[0]|l_sw[10]|l_sw[1]|l_sw[2]|l_sw[3]|l_sw[4]|l_sw[5]|l_sw[6]|l_sw[7]|l_sw[8]|l_sw[9]|out|pad|padres|vc|vcp|vdd|vddr|vip|vss|z
+ \$73158 \$73042
+ BOTTOM|TOP|VGND|VSS|anode|cathode|core|h_sw[0]|h_sw[10]|h_sw[1]|h_sw[2]|h_sw[3]|h_sw[4]|h_sw[5]|h_sw[6]|h_sw[7]|h_sw[8]|h_sw[9]|l_sw[0]|l_sw[10]|l_sw[1]|l_sw[2]|l_sw[3]|l_sw[4]|l_sw[5]|l_sw[6]|l_sw[7]|l_sw[8]|l_sw[9]|out|pad|padres|vc|vcp|vdd|vddr|vip|vss|z
+ sg13_lv_nmos L=0.13u W=0.74u AS=0.1626p AD=0.2516p PS=1.415u PD=2.16u rfmode=0
M$990
+ BOTTOM|TOP|VGND|VSS|anode|cathode|core|h_sw[0]|h_sw[10]|h_sw[1]|h_sw[2]|h_sw[3]|h_sw[4]|h_sw[5]|h_sw[6]|h_sw[7]|h_sw[8]|h_sw[9]|l_sw[0]|l_sw[10]|l_sw[1]|l_sw[2]|l_sw[3]|l_sw[4]|l_sw[5]|l_sw[6]|l_sw[7]|l_sw[8]|l_sw[9]|out|pad|padres|vc|vcp|vdd|vddr|vip|vss|z
+ RESET_B|Y$1 \$73144
+ BOTTOM|TOP|VGND|VSS|anode|cathode|core|h_sw[0]|h_sw[10]|h_sw[1]|h_sw[2]|h_sw[3]|h_sw[4]|h_sw[5]|h_sw[6]|h_sw[7]|h_sw[8]|h_sw[9]|l_sw[0]|l_sw[10]|l_sw[1]|l_sw[2]|l_sw[3]|l_sw[4]|l_sw[5]|l_sw[6]|l_sw[7]|l_sw[8]|l_sw[9]|out|pad|padres|vc|vcp|vdd|vddr|vip|vss|z
+ sg13_lv_nmos L=0.13u W=0.42u AS=0.1701p AD=0.0378p PS=1.65u PD=0.6u rfmode=0
M$991 \$73144 \$73042 \$73041
+ BOTTOM|TOP|VGND|VSS|anode|cathode|core|h_sw[0]|h_sw[10]|h_sw[1]|h_sw[2]|h_sw[3]|h_sw[4]|h_sw[5]|h_sw[6]|h_sw[7]|h_sw[8]|h_sw[9]|l_sw[0]|l_sw[10]|l_sw[1]|l_sw[2]|l_sw[3]|l_sw[4]|l_sw[5]|l_sw[6]|l_sw[7]|l_sw[8]|l_sw[9]|out|pad|padres|vc|vcp|vdd|vddr|vip|vss|z
+ sg13_lv_nmos L=0.13u W=0.42u AS=0.0378p AD=0.1428p PS=0.6u PD=1.52u rfmode=0
M$992 \$73073 \$73043 \$73044
+ BOTTOM|TOP|VGND|VSS|anode|cathode|core|h_sw[0]|h_sw[10]|h_sw[1]|h_sw[2]|h_sw[3]|h_sw[4]|h_sw[5]|h_sw[6]|h_sw[7]|h_sw[8]|h_sw[9]|l_sw[0]|l_sw[10]|l_sw[1]|l_sw[2]|l_sw[3]|l_sw[4]|l_sw[5]|l_sw[6]|l_sw[7]|l_sw[8]|l_sw[9]|out|pad|padres|vc|vcp|vdd|vddr|vip|vss|z
+ sg13_lv_nmos L=0.13u W=0.42u AS=0.12665p AD=0.1428p PS=1.145u PD=1.52u
+ rfmode=0
M$993 \$73042 \$73072 \$73073
+ BOTTOM|TOP|VGND|VSS|anode|cathode|core|h_sw[0]|h_sw[10]|h_sw[1]|h_sw[2]|h_sw[3]|h_sw[4]|h_sw[5]|h_sw[6]|h_sw[7]|h_sw[8]|h_sw[9]|l_sw[0]|l_sw[10]|l_sw[1]|l_sw[2]|l_sw[3]|l_sw[4]|l_sw[5]|l_sw[6]|l_sw[7]|l_sw[8]|l_sw[9]|out|pad|padres|vc|vcp|vdd|vddr|vip|vss|z
+ sg13_lv_nmos L=0.13u W=0.74u AS=0.3473p AD=0.12665p PS=2.71u PD=1.145u
+ rfmode=0
M$994 \$73044 \$73045
+ BOTTOM|TOP|VGND|VSS|anode|cathode|core|h_sw[0]|h_sw[10]|h_sw[1]|h_sw[2]|h_sw[3]|h_sw[4]|h_sw[5]|h_sw[6]|h_sw[7]|h_sw[8]|h_sw[9]|l_sw[0]|l_sw[10]|l_sw[1]|l_sw[2]|l_sw[3]|l_sw[4]|l_sw[5]|l_sw[6]|l_sw[7]|l_sw[8]|l_sw[9]|out|pad|padres|vc|vcp|vdd|vddr|vip|vss|z
+ BOTTOM|TOP|VGND|VSS|anode|cathode|core|h_sw[0]|h_sw[10]|h_sw[1]|h_sw[2]|h_sw[3]|h_sw[4]|h_sw[5]|h_sw[6]|h_sw[7]|h_sw[8]|h_sw[9]|l_sw[0]|l_sw[10]|l_sw[1]|l_sw[2]|l_sw[3]|l_sw[4]|l_sw[5]|l_sw[6]|l_sw[7]|l_sw[8]|l_sw[9]|out|pad|padres|vc|vcp|vdd|vddr|vip|vss|z
+ sg13_lv_nmos L=0.13u W=0.42u AS=0.1428p AD=0.0798p PS=1.52u PD=0.8u rfmode=0
M$995
+ BOTTOM|TOP|VGND|VSS|anode|cathode|core|h_sw[0]|h_sw[10]|h_sw[1]|h_sw[2]|h_sw[3]|h_sw[4]|h_sw[5]|h_sw[6]|h_sw[7]|h_sw[8]|h_sw[9]|l_sw[0]|l_sw[10]|l_sw[1]|l_sw[2]|l_sw[3]|l_sw[4]|l_sw[5]|l_sw[6]|l_sw[7]|l_sw[8]|l_sw[9]|out|pad|padres|vc|vcp|vdd|vddr|vip|vss|z
+ RESET_B|Y$1 \$73140
+ BOTTOM|TOP|VGND|VSS|anode|cathode|core|h_sw[0]|h_sw[10]|h_sw[1]|h_sw[2]|h_sw[3]|h_sw[4]|h_sw[5]|h_sw[6]|h_sw[7]|h_sw[8]|h_sw[9]|l_sw[0]|l_sw[10]|l_sw[1]|l_sw[2]|l_sw[3]|l_sw[4]|l_sw[5]|l_sw[6]|l_sw[7]|l_sw[8]|l_sw[9]|out|pad|padres|vc|vcp|vdd|vddr|vip|vss|z
+ sg13_lv_nmos L=0.13u W=0.42u AS=0.0798p AD=0.0378p PS=0.8u PD=0.6u rfmode=0
M$996 \$73140 \$73073 \$73045
+ BOTTOM|TOP|VGND|VSS|anode|cathode|core|h_sw[0]|h_sw[10]|h_sw[1]|h_sw[2]|h_sw[3]|h_sw[4]|h_sw[5]|h_sw[6]|h_sw[7]|h_sw[8]|h_sw[9]|l_sw[0]|l_sw[10]|l_sw[1]|l_sw[2]|l_sw[3]|l_sw[4]|l_sw[5]|l_sw[6]|l_sw[7]|l_sw[8]|l_sw[9]|out|pad|padres|vc|vcp|vdd|vddr|vip|vss|z
+ sg13_lv_nmos L=0.13u W=0.42u AS=0.0378p AD=0.1428p PS=0.6u PD=1.52u rfmode=0
M$997
+ BOTTOM|TOP|VGND|VSS|anode|cathode|core|h_sw[0]|h_sw[10]|h_sw[1]|h_sw[2]|h_sw[3]|h_sw[4]|h_sw[5]|h_sw[6]|h_sw[7]|h_sw[8]|h_sw[9]|l_sw[0]|l_sw[10]|l_sw[1]|l_sw[2]|l_sw[3]|l_sw[4]|l_sw[5]|l_sw[6]|l_sw[7]|l_sw[8]|l_sw[9]|out|pad|padres|vc|vcp|vdd|vddr|vip|vss|z
+ \$73073 D|Q_N$6
+ BOTTOM|TOP|VGND|VSS|anode|cathode|core|h_sw[0]|h_sw[10]|h_sw[1]|h_sw[2]|h_sw[3]|h_sw[4]|h_sw[5]|h_sw[6]|h_sw[7]|h_sw[8]|h_sw[9]|l_sw[0]|l_sw[10]|l_sw[1]|l_sw[2]|l_sw[3]|l_sw[4]|l_sw[5]|l_sw[6]|l_sw[7]|l_sw[8]|l_sw[9]|out|pad|padres|vc|vcp|vdd|vddr|vip|vss|z
+ sg13_lv_nmos L=0.13u W=0.74u AS=0.2516p AD=0.2849p PS=2.16u PD=2.25u rfmode=0
M$998 \$73047 \$73073
+ BOTTOM|TOP|VGND|VSS|anode|cathode|core|h_sw[0]|h_sw[10]|h_sw[1]|h_sw[2]|h_sw[3]|h_sw[4]|h_sw[5]|h_sw[6]|h_sw[7]|h_sw[8]|h_sw[9]|l_sw[0]|l_sw[10]|l_sw[1]|l_sw[2]|l_sw[3]|l_sw[4]|l_sw[5]|l_sw[6]|l_sw[7]|l_sw[8]|l_sw[9]|out|pad|padres|vc|vcp|vdd|vddr|vip|vss|z
+ BOTTOM|TOP|VGND|VSS|anode|cathode|core|h_sw[0]|h_sw[10]|h_sw[1]|h_sw[2]|h_sw[3]|h_sw[4]|h_sw[5]|h_sw[6]|h_sw[7]|h_sw[8]|h_sw[9]|l_sw[0]|l_sw[10]|l_sw[1]|l_sw[2]|l_sw[3]|l_sw[4]|l_sw[5]|l_sw[6]|l_sw[7]|l_sw[8]|l_sw[9]|out|pad|padres|vc|vcp|vdd|vddr|vip|vss|z
+ sg13_lv_nmos L=0.13u W=0.74u AS=0.2516p AD=0.1406p PS=2.16u PD=1.12u rfmode=0
M$999
+ BOTTOM|TOP|VGND|VSS|anode|cathode|core|h_sw[0]|h_sw[10]|h_sw[1]|h_sw[2]|h_sw[3]|h_sw[4]|h_sw[5]|h_sw[6]|h_sw[7]|h_sw[8]|h_sw[9]|l_sw[0]|l_sw[10]|l_sw[1]|l_sw[2]|l_sw[3]|l_sw[4]|l_sw[5]|l_sw[6]|l_sw[7]|l_sw[8]|l_sw[9]|out|pad|padres|vc|vcp|vdd|vddr|vip|vss|z
+ \$73047 A|D|Q
+ BOTTOM|TOP|VGND|VSS|anode|cathode|core|h_sw[0]|h_sw[10]|h_sw[1]|h_sw[2]|h_sw[3]|h_sw[4]|h_sw[5]|h_sw[6]|h_sw[7]|h_sw[8]|h_sw[9]|l_sw[0]|l_sw[10]|l_sw[1]|l_sw[2]|l_sw[3]|l_sw[4]|l_sw[5]|l_sw[6]|l_sw[7]|l_sw[8]|l_sw[9]|out|pad|padres|vc|vcp|vdd|vddr|vip|vss|z
+ sg13_lv_nmos L=0.13u W=0.74u AS=0.1406p AD=0.2516p PS=1.12u PD=2.16u rfmode=0
M$1000
+ BOTTOM|TOP|VGND|VSS|anode|cathode|core|h_sw[0]|h_sw[10]|h_sw[1]|h_sw[2]|h_sw[3]|h_sw[4]|h_sw[5]|h_sw[6]|h_sw[7]|h_sw[8]|h_sw[9]|l_sw[0]|l_sw[10]|l_sw[1]|l_sw[2]|l_sw[3]|l_sw[4]|l_sw[5]|l_sw[6]|l_sw[7]|l_sw[8]|l_sw[9]|out|pad|padres|vc|vcp|vdd|vddr|vip|vss|z
+ D|Q_N$6 \$73074
+ BOTTOM|TOP|VGND|VSS|anode|cathode|core|h_sw[0]|h_sw[10]|h_sw[1]|h_sw[2]|h_sw[3]|h_sw[4]|h_sw[5]|h_sw[6]|h_sw[7]|h_sw[8]|h_sw[9]|l_sw[0]|l_sw[10]|l_sw[1]|l_sw[2]|l_sw[3]|l_sw[4]|l_sw[5]|l_sw[6]|l_sw[7]|l_sw[8]|l_sw[9]|out|pad|padres|vc|vcp|vdd|vddr|vip|vss|z
+ sg13_lv_nmos L=0.13u W=0.55u AS=0.15055p AD=0.187p PS=1.17u PD=1.78u rfmode=0
M$1001
+ BOTTOM|TOP|VGND|VSS|anode|cathode|core|h_sw[0]|h_sw[10]|h_sw[1]|h_sw[2]|h_sw[3]|h_sw[4]|h_sw[5]|h_sw[6]|h_sw[7]|h_sw[8]|h_sw[9]|l_sw[0]|l_sw[10]|l_sw[1]|l_sw[2]|l_sw[3]|l_sw[4]|l_sw[5]|l_sw[6]|l_sw[7]|l_sw[8]|l_sw[9]|out|pad|padres|vc|vcp|vdd|vddr|vip|vss|z
+ CLK|D|GATE|Q$4 \$73048
+ BOTTOM|TOP|VGND|VSS|anode|cathode|core|h_sw[0]|h_sw[10]|h_sw[1]|h_sw[2]|h_sw[3]|h_sw[4]|h_sw[5]|h_sw[6]|h_sw[7]|h_sw[8]|h_sw[9]|l_sw[0]|l_sw[10]|l_sw[1]|l_sw[2]|l_sw[3]|l_sw[4]|l_sw[5]|l_sw[6]|l_sw[7]|l_sw[8]|l_sw[9]|out|pad|padres|vc|vcp|vdd|vddr|vip|vss|z
+ sg13_lv_nmos L=0.13u W=0.74u AS=0.15055p AD=0.2516p PS=1.17u PD=2.16u rfmode=0
M$1002
+ BOTTOM|TOP|VGND|VSS|anode|cathode|core|h_sw[0]|h_sw[10]|h_sw[1]|h_sw[2]|h_sw[3]|h_sw[4]|h_sw[5]|h_sw[6]|h_sw[7]|h_sw[8]|h_sw[9]|l_sw[0]|l_sw[10]|l_sw[1]|l_sw[2]|l_sw[3]|l_sw[4]|l_sw[5]|l_sw[6]|l_sw[7]|l_sw[8]|l_sw[9]|out|pad|padres|vc|vcp|vdd|vddr|vip|vss|z
+ \$73074 \$73135
+ BOTTOM|TOP|VGND|VSS|anode|cathode|core|h_sw[0]|h_sw[10]|h_sw[1]|h_sw[2]|h_sw[3]|h_sw[4]|h_sw[5]|h_sw[6]|h_sw[7]|h_sw[8]|h_sw[9]|l_sw[0]|l_sw[10]|l_sw[1]|l_sw[2]|l_sw[3]|l_sw[4]|l_sw[5]|l_sw[6]|l_sw[7]|l_sw[8]|l_sw[9]|out|pad|padres|vc|vcp|vdd|vddr|vip|vss|z
+ sg13_lv_nmos L=0.13u W=0.64u AS=0.213425p AD=0.072p PS=1.62u PD=0.865u
+ rfmode=0
M$1003 \$73135 \$73075 \$73076
+ BOTTOM|TOP|VGND|VSS|anode|cathode|core|h_sw[0]|h_sw[10]|h_sw[1]|h_sw[2]|h_sw[3]|h_sw[4]|h_sw[5]|h_sw[6]|h_sw[7]|h_sw[8]|h_sw[9]|l_sw[0]|l_sw[10]|l_sw[1]|l_sw[2]|l_sw[3]|l_sw[4]|l_sw[5]|l_sw[6]|l_sw[7]|l_sw[8]|l_sw[9]|out|pad|padres|vc|vcp|vdd|vddr|vip|vss|z
+ sg13_lv_nmos L=0.13u W=0.64u AS=0.072p AD=0.141p PS=0.865u PD=1.17u rfmode=0
M$1004 \$73076 \$73048 \$73136
+ BOTTOM|TOP|VGND|VSS|anode|cathode|core|h_sw[0]|h_sw[10]|h_sw[1]|h_sw[2]|h_sw[3]|h_sw[4]|h_sw[5]|h_sw[6]|h_sw[7]|h_sw[8]|h_sw[9]|l_sw[0]|l_sw[10]|l_sw[1]|l_sw[2]|l_sw[3]|l_sw[4]|l_sw[5]|l_sw[6]|l_sw[7]|l_sw[8]|l_sw[9]|out|pad|padres|vc|vcp|vdd|vddr|vip|vss|z
+ sg13_lv_nmos L=0.13u W=0.42u AS=0.141p AD=0.04725p PS=1.17u PD=0.645u rfmode=0
M$1005 \$73136 \$73049
+ BOTTOM|TOP|VGND|VSS|anode|cathode|core|h_sw[0]|h_sw[10]|h_sw[1]|h_sw[2]|h_sw[3]|h_sw[4]|h_sw[5]|h_sw[6]|h_sw[7]|h_sw[8]|h_sw[9]|l_sw[0]|l_sw[10]|l_sw[1]|l_sw[2]|l_sw[3]|l_sw[4]|l_sw[5]|l_sw[6]|l_sw[7]|l_sw[8]|l_sw[9]|out|pad|padres|vc|vcp|vdd|vddr|vip|vss|z
+ BOTTOM|TOP|VGND|VSS|anode|cathode|core|h_sw[0]|h_sw[10]|h_sw[1]|h_sw[2]|h_sw[3]|h_sw[4]|h_sw[5]|h_sw[6]|h_sw[7]|h_sw[8]|h_sw[9]|l_sw[0]|l_sw[10]|l_sw[1]|l_sw[2]|l_sw[3]|l_sw[4]|l_sw[5]|l_sw[6]|l_sw[7]|l_sw[8]|l_sw[9]|out|pad|padres|vc|vcp|vdd|vddr|vip|vss|z
+ sg13_lv_nmos L=0.13u W=0.42u AS=0.04725p AD=0.1428p PS=0.645u PD=1.52u
+ rfmode=0
M$1006
+ BOTTOM|TOP|VGND|VSS|anode|cathode|core|h_sw[0]|h_sw[10]|h_sw[1]|h_sw[2]|h_sw[3]|h_sw[4]|h_sw[5]|h_sw[6]|h_sw[7]|h_sw[8]|h_sw[9]|l_sw[0]|l_sw[10]|l_sw[1]|l_sw[2]|l_sw[3]|l_sw[4]|l_sw[5]|l_sw[6]|l_sw[7]|l_sw[8]|l_sw[9]|out|pad|padres|vc|vcp|vdd|vddr|vip|vss|z
+ \$73048 \$73075
+ BOTTOM|TOP|VGND|VSS|anode|cathode|core|h_sw[0]|h_sw[10]|h_sw[1]|h_sw[2]|h_sw[3]|h_sw[4]|h_sw[5]|h_sw[6]|h_sw[7]|h_sw[8]|h_sw[9]|l_sw[0]|l_sw[10]|l_sw[1]|l_sw[2]|l_sw[3]|l_sw[4]|l_sw[5]|l_sw[6]|l_sw[7]|l_sw[8]|l_sw[9]|out|pad|padres|vc|vcp|vdd|vddr|vip|vss|z
+ sg13_lv_nmos L=0.13u W=0.74u AS=0.213425p AD=0.2775p PS=1.62u PD=2.23u
+ rfmode=0
M$1007 \$73049 \$73076 \$73137
+ BOTTOM|TOP|VGND|VSS|anode|cathode|core|h_sw[0]|h_sw[10]|h_sw[1]|h_sw[2]|h_sw[3]|h_sw[4]|h_sw[5]|h_sw[6]|h_sw[7]|h_sw[8]|h_sw[9]|l_sw[0]|l_sw[10]|l_sw[1]|l_sw[2]|l_sw[3]|l_sw[4]|l_sw[5]|l_sw[6]|l_sw[7]|l_sw[8]|l_sw[9]|out|pad|padres|vc|vcp|vdd|vddr|vip|vss|z
+ sg13_lv_nmos L=0.13u W=0.74u AS=0.2516p AD=0.0777p PS=2.16u PD=0.95u rfmode=0
M$1008 \$73137 RESET_B|Y$1
+ BOTTOM|TOP|VGND|VSS|anode|cathode|core|h_sw[0]|h_sw[10]|h_sw[1]|h_sw[2]|h_sw[3]|h_sw[4]|h_sw[5]|h_sw[6]|h_sw[7]|h_sw[8]|h_sw[9]|l_sw[0]|l_sw[10]|l_sw[1]|l_sw[2]|l_sw[3]|l_sw[4]|l_sw[5]|l_sw[6]|l_sw[7]|l_sw[8]|l_sw[9]|out|pad|padres|vc|vcp|vdd|vddr|vip|vss|z
+ BOTTOM|TOP|VGND|VSS|anode|cathode|core|h_sw[0]|h_sw[10]|h_sw[1]|h_sw[2]|h_sw[3]|h_sw[4]|h_sw[5]|h_sw[6]|h_sw[7]|h_sw[8]|h_sw[9]|l_sw[0]|l_sw[10]|l_sw[1]|l_sw[2]|l_sw[3]|l_sw[4]|l_sw[5]|l_sw[6]|l_sw[7]|l_sw[8]|l_sw[9]|out|pad|padres|vc|vcp|vdd|vddr|vip|vss|z
+ sg13_lv_nmos L=0.13u W=0.74u AS=0.0777p AD=0.1406p PS=0.95u PD=1.12u rfmode=0
M$1009
+ BOTTOM|TOP|VGND|VSS|anode|cathode|core|h_sw[0]|h_sw[10]|h_sw[1]|h_sw[2]|h_sw[3]|h_sw[4]|h_sw[5]|h_sw[6]|h_sw[7]|h_sw[8]|h_sw[9]|l_sw[0]|l_sw[10]|l_sw[1]|l_sw[2]|l_sw[3]|l_sw[4]|l_sw[5]|l_sw[6]|l_sw[7]|l_sw[8]|l_sw[9]|out|pad|padres|vc|vcp|vdd|vddr|vip|vss|z
+ \$73049 A|Q$13
+ BOTTOM|TOP|VGND|VSS|anode|cathode|core|h_sw[0]|h_sw[10]|h_sw[1]|h_sw[2]|h_sw[3]|h_sw[4]|h_sw[5]|h_sw[6]|h_sw[7]|h_sw[8]|h_sw[9]|l_sw[0]|l_sw[10]|l_sw[1]|l_sw[2]|l_sw[3]|l_sw[4]|l_sw[5]|l_sw[6]|l_sw[7]|l_sw[8]|l_sw[9]|out|pad|padres|vc|vcp|vdd|vddr|vip|vss|z
+ sg13_lv_nmos L=0.13u W=0.74u AS=0.1406p AD=0.2516p PS=1.12u PD=2.16u rfmode=0
M$1010
+ BOTTOM|TOP|VGND|VSS|anode|cathode|core|h_sw[0]|h_sw[10]|h_sw[1]|h_sw[2]|h_sw[3]|h_sw[4]|h_sw[5]|h_sw[6]|h_sw[7]|h_sw[8]|h_sw[9]|l_sw[0]|l_sw[10]|l_sw[1]|l_sw[2]|l_sw[3]|l_sw[4]|l_sw[5]|l_sw[6]|l_sw[7]|l_sw[8]|l_sw[9]|out|pad|padres|vc|vcp|vdd|vddr|vip|vss|z
+ \$73049 \$73051
+ BOTTOM|TOP|VGND|VSS|anode|cathode|core|h_sw[0]|h_sw[10]|h_sw[1]|h_sw[2]|h_sw[3]|h_sw[4]|h_sw[5]|h_sw[6]|h_sw[7]|h_sw[8]|h_sw[9]|l_sw[0]|l_sw[10]|l_sw[1]|l_sw[2]|l_sw[3]|l_sw[4]|l_sw[5]|l_sw[6]|l_sw[7]|l_sw[8]|l_sw[9]|out|pad|padres|vc|vcp|vdd|vddr|vip|vss|z
+ sg13_lv_nmos L=0.13u W=0.55u AS=0.1491p AD=0.187p PS=1.18u PD=1.78u rfmode=0
M$1011
+ BOTTOM|TOP|VGND|VSS|anode|cathode|core|h_sw[0]|h_sw[10]|h_sw[1]|h_sw[2]|h_sw[3]|h_sw[4]|h_sw[5]|h_sw[6]|h_sw[7]|h_sw[8]|h_sw[9]|l_sw[0]|l_sw[10]|l_sw[1]|l_sw[2]|l_sw[3]|l_sw[4]|l_sw[5]|l_sw[6]|l_sw[7]|l_sw[8]|l_sw[9]|out|pad|padres|vc|vcp|vdd|vddr|vip|vss|z
+ \$73051 Q_N$24
+ BOTTOM|TOP|VGND|VSS|anode|cathode|core|h_sw[0]|h_sw[10]|h_sw[1]|h_sw[2]|h_sw[3]|h_sw[4]|h_sw[5]|h_sw[6]|h_sw[7]|h_sw[8]|h_sw[9]|l_sw[0]|l_sw[10]|l_sw[1]|l_sw[2]|l_sw[3]|l_sw[4]|l_sw[5]|l_sw[6]|l_sw[7]|l_sw[8]|l_sw[9]|out|pad|padres|vc|vcp|vdd|vddr|vip|vss|z
+ sg13_lv_nmos L=0.13u W=0.74u AS=0.1491p AD=0.2516p PS=1.18u PD=2.16u rfmode=0
M$1012 \$73055 \$73056 VDD|VPWR|vdd
+ BOTTOM|TOP|VGND|VSS|anode|cathode|core|h_sw[0]|h_sw[10]|h_sw[1]|h_sw[2]|h_sw[3]|h_sw[4]|h_sw[5]|h_sw[6]|h_sw[7]|h_sw[8]|h_sw[9]|l_sw[0]|l_sw[10]|l_sw[1]|l_sw[2]|l_sw[3]|l_sw[4]|l_sw[5]|l_sw[6]|l_sw[7]|l_sw[8]|l_sw[9]|out|pad|padres|vc|vcp|vdd|vddr|vip|vss|z
+ sg13_lv_nmos L=0.13u W=1.3u AS=0.442p AD=0.442p PS=3.28u PD=3.28u rfmode=0
M$1013 VDD|VPWR|vdd \$73055 \$73056
+ BOTTOM|TOP|VGND|VSS|anode|cathode|core|h_sw[0]|h_sw[10]|h_sw[1]|h_sw[2]|h_sw[3]|h_sw[4]|h_sw[5]|h_sw[6]|h_sw[7]|h_sw[8]|h_sw[9]|l_sw[0]|l_sw[10]|l_sw[1]|l_sw[2]|l_sw[3]|l_sw[4]|l_sw[5]|l_sw[6]|l_sw[7]|l_sw[8]|l_sw[9]|out|pad|padres|vc|vcp|vdd|vddr|vip|vss|z
+ sg13_lv_nmos L=0.13u W=1.3u AS=0.442p AD=0.442p PS=3.28u PD=3.28u rfmode=0
M$1014 VDD|VPWR|vdd \$73055 \$73904
+ BOTTOM|TOP|VGND|VSS|anode|cathode|core|h_sw[0]|h_sw[10]|h_sw[1]|h_sw[2]|h_sw[3]|h_sw[4]|h_sw[5]|h_sw[6]|h_sw[7]|h_sw[8]|h_sw[9]|l_sw[0]|l_sw[10]|l_sw[1]|l_sw[2]|l_sw[3]|l_sw[4]|l_sw[5]|l_sw[6]|l_sw[7]|l_sw[8]|l_sw[9]|out|pad|padres|vc|vcp|vdd|vddr|vip|vss|z
+ sg13_lv_nmos L=0.13u W=1.3u AS=0.442p AD=0.442p PS=3.28u PD=3.28u rfmode=0
M$1015
+ BOTTOM|TOP|VGND|VSS|anode|cathode|core|h_sw[0]|h_sw[10]|h_sw[1]|h_sw[2]|h_sw[3]|h_sw[4]|h_sw[5]|h_sw[6]|h_sw[7]|h_sw[8]|h_sw[9]|l_sw[0]|l_sw[10]|l_sw[1]|l_sw[2]|l_sw[3]|l_sw[4]|l_sw[5]|l_sw[6]|l_sw[7]|l_sw[8]|l_sw[9]|out|pad|padres|vc|vcp|vdd|vddr|vip|vss|z
+ A$1 Y$2
+ BOTTOM|TOP|VGND|VSS|anode|cathode|core|h_sw[0]|h_sw[10]|h_sw[1]|h_sw[2]|h_sw[3]|h_sw[4]|h_sw[5]|h_sw[6]|h_sw[7]|h_sw[8]|h_sw[9]|l_sw[0]|l_sw[10]|l_sw[1]|l_sw[2]|l_sw[3]|l_sw[4]|l_sw[5]|l_sw[6]|l_sw[7]|l_sw[8]|l_sw[9]|out|pad|padres|vc|vcp|vdd|vddr|vip|vss|z
+ sg13_lv_nmos L=0.13u W=0.74u AS=0.2516p AD=0.2516p PS=2.16u PD=2.16u rfmode=0
M$1017
+ BOTTOM|TOP|VGND|VSS|anode|cathode|core|h_sw[0]|h_sw[10]|h_sw[1]|h_sw[2]|h_sw[3]|h_sw[4]|h_sw[5]|h_sw[6]|h_sw[7]|h_sw[8]|h_sw[9]|l_sw[0]|l_sw[10]|l_sw[1]|l_sw[2]|l_sw[3]|l_sw[4]|l_sw[5]|l_sw[6]|l_sw[7]|l_sw[8]|l_sw[9]|out|pad|padres|vc|vcp|vdd|vddr|vip|vss|z
+ A|CLK|X \$73149
+ BOTTOM|TOP|VGND|VSS|anode|cathode|core|h_sw[0]|h_sw[10]|h_sw[1]|h_sw[2]|h_sw[3]|h_sw[4]|h_sw[5]|h_sw[6]|h_sw[7]|h_sw[8]|h_sw[9]|l_sw[0]|l_sw[10]|l_sw[1]|l_sw[2]|l_sw[3]|l_sw[4]|l_sw[5]|l_sw[6]|l_sw[7]|l_sw[8]|l_sw[9]|out|pad|padres|vc|vcp|vdd|vddr|vip|vss|z
+ sg13_lv_nmos L=0.13u W=0.74u AS=0.317325p AD=0.2516p PS=1.805u PD=2.16u
+ rfmode=0
M$1018
+ BOTTOM|TOP|VGND|VSS|anode|cathode|core|h_sw[0]|h_sw[10]|h_sw[1]|h_sw[2]|h_sw[3]|h_sw[4]|h_sw[5]|h_sw[6]|h_sw[7]|h_sw[8]|h_sw[9]|l_sw[0]|l_sw[10]|l_sw[1]|l_sw[2]|l_sw[3]|l_sw[4]|l_sw[5]|l_sw[6]|l_sw[7]|l_sw[8]|l_sw[9]|out|pad|padres|vc|vcp|vdd|vddr|vip|vss|z
+ \$73149 \$73148
+ BOTTOM|TOP|VGND|VSS|anode|cathode|core|h_sw[0]|h_sw[10]|h_sw[1]|h_sw[2]|h_sw[3]|h_sw[4]|h_sw[5]|h_sw[6]|h_sw[7]|h_sw[8]|h_sw[9]|l_sw[0]|l_sw[10]|l_sw[1]|l_sw[2]|l_sw[3]|l_sw[4]|l_sw[5]|l_sw[6]|l_sw[7]|l_sw[8]|l_sw[9]|out|pad|padres|vc|vcp|vdd|vddr|vip|vss|z
+ sg13_lv_nmos L=0.13u W=0.74u AS=0.317325p AD=0.2516p PS=1.805u PD=2.16u
+ rfmode=0
M$1019 \$73018 \$73148 \$73150
+ BOTTOM|TOP|VGND|VSS|anode|cathode|core|h_sw[0]|h_sw[10]|h_sw[1]|h_sw[2]|h_sw[3]|h_sw[4]|h_sw[5]|h_sw[6]|h_sw[7]|h_sw[8]|h_sw[9]|l_sw[0]|l_sw[10]|l_sw[1]|l_sw[2]|l_sw[3]|l_sw[4]|l_sw[5]|l_sw[6]|l_sw[7]|l_sw[8]|l_sw[9]|out|pad|padres|vc|vcp|vdd|vddr|vip|vss|z
+ sg13_lv_nmos L=0.13u W=0.42u AS=0.2373p AD=0.0798p PS=1.97u PD=0.8u rfmode=0
M$1020 \$73150 \$73149 \$73059
+ BOTTOM|TOP|VGND|VSS|anode|cathode|core|h_sw[0]|h_sw[10]|h_sw[1]|h_sw[2]|h_sw[3]|h_sw[4]|h_sw[5]|h_sw[6]|h_sw[7]|h_sw[8]|h_sw[9]|l_sw[0]|l_sw[10]|l_sw[1]|l_sw[2]|l_sw[3]|l_sw[4]|l_sw[5]|l_sw[6]|l_sw[7]|l_sw[8]|l_sw[9]|out|pad|padres|vc|vcp|vdd|vddr|vip|vss|z
+ sg13_lv_nmos L=0.13u W=0.42u AS=0.0798p AD=0.1296p PS=0.8u PD=1.52u rfmode=0
M$1021 \$73019 \$73022 \$73152
+ BOTTOM|TOP|VGND|VSS|anode|cathode|core|h_sw[0]|h_sw[10]|h_sw[1]|h_sw[2]|h_sw[3]|h_sw[4]|h_sw[5]|h_sw[6]|h_sw[7]|h_sw[8]|h_sw[9]|l_sw[0]|l_sw[10]|l_sw[1]|l_sw[2]|l_sw[3]|l_sw[4]|l_sw[5]|l_sw[6]|l_sw[7]|l_sw[8]|l_sw[9]|out|pad|padres|vc|vcp|vdd|vddr|vip|vss|z
+ sg13_lv_nmos L=0.13u W=0.42u AS=0.1296p AD=0.0798p PS=1.52u PD=0.8u rfmode=0
M$1022 \$73152 \$73061 \$73020
+ BOTTOM|TOP|VGND|VSS|anode|cathode|core|h_sw[0]|h_sw[10]|h_sw[1]|h_sw[2]|h_sw[3]|h_sw[4]|h_sw[5]|h_sw[6]|h_sw[7]|h_sw[8]|h_sw[9]|l_sw[0]|l_sw[10]|l_sw[1]|l_sw[2]|l_sw[3]|l_sw[4]|l_sw[5]|l_sw[6]|l_sw[7]|l_sw[8]|l_sw[9]|out|pad|padres|vc|vcp|vdd|vddr|vip|vss|z
+ sg13_lv_nmos L=0.13u W=0.42u AS=0.0798p AD=0.2373p PS=0.8u PD=1.97u rfmode=0
M$1023
+ BOTTOM|TOP|VGND|VSS|anode|cathode|core|h_sw[0]|h_sw[10]|h_sw[1]|h_sw[2]|h_sw[3]|h_sw[4]|h_sw[5]|h_sw[6]|h_sw[7]|h_sw[8]|h_sw[9]|l_sw[0]|l_sw[10]|l_sw[1]|l_sw[2]|l_sw[3]|l_sw[4]|l_sw[5]|l_sw[6]|l_sw[7]|l_sw[8]|l_sw[9]|out|pad|padres|vc|vcp|vdd|vddr|vip|vss|z
+ \$73022 \$73061
+ BOTTOM|TOP|VGND|VSS|anode|cathode|core|h_sw[0]|h_sw[10]|h_sw[1]|h_sw[2]|h_sw[3]|h_sw[4]|h_sw[5]|h_sw[6]|h_sw[7]|h_sw[8]|h_sw[9]|l_sw[0]|l_sw[10]|l_sw[1]|l_sw[2]|l_sw[3]|l_sw[4]|l_sw[5]|l_sw[6]|l_sw[7]|l_sw[8]|l_sw[9]|out|pad|padres|vc|vcp|vdd|vddr|vip|vss|z
+ sg13_lv_nmos L=0.13u W=0.74u AS=0.317325p AD=0.2516p PS=1.805u PD=2.16u
+ rfmode=0
M$1024
+ BOTTOM|TOP|VGND|VSS|anode|cathode|core|h_sw[0]|h_sw[10]|h_sw[1]|h_sw[2]|h_sw[3]|h_sw[4]|h_sw[5]|h_sw[6]|h_sw[7]|h_sw[8]|h_sw[9]|l_sw[0]|l_sw[10]|l_sw[1]|l_sw[2]|l_sw[3]|l_sw[4]|l_sw[5]|l_sw[6]|l_sw[7]|l_sw[8]|l_sw[9]|out|pad|padres|vc|vcp|vdd|vddr|vip|vss|z
+ CLK|D|GATE|Q$5 \$73022
+ BOTTOM|TOP|VGND|VSS|anode|cathode|core|h_sw[0]|h_sw[10]|h_sw[1]|h_sw[2]|h_sw[3]|h_sw[4]|h_sw[5]|h_sw[6]|h_sw[7]|h_sw[8]|h_sw[9]|l_sw[0]|l_sw[10]|l_sw[1]|l_sw[2]|l_sw[3]|l_sw[4]|l_sw[5]|l_sw[6]|l_sw[7]|l_sw[8]|l_sw[9]|out|pad|padres|vc|vcp|vdd|vddr|vip|vss|z
+ sg13_lv_nmos L=0.13u W=0.74u AS=0.317325p AD=0.2516p PS=1.805u PD=2.16u
+ rfmode=0
M$1025 \$73033 \$73036 \$73156
+ BOTTOM|TOP|VGND|VSS|anode|cathode|core|h_sw[0]|h_sw[10]|h_sw[1]|h_sw[2]|h_sw[3]|h_sw[4]|h_sw[5]|h_sw[6]|h_sw[7]|h_sw[8]|h_sw[9]|l_sw[0]|l_sw[10]|l_sw[1]|l_sw[2]|l_sw[3]|l_sw[4]|l_sw[5]|l_sw[6]|l_sw[7]|l_sw[8]|l_sw[9]|out|pad|padres|vc|vcp|vdd|vddr|vip|vss|z
+ sg13_lv_nmos L=0.13u W=0.42u AS=0.1296p AD=0.0798p PS=1.52u PD=0.8u rfmode=0
M$1026 \$73156 \$73068 \$73034
+ BOTTOM|TOP|VGND|VSS|anode|cathode|core|h_sw[0]|h_sw[10]|h_sw[1]|h_sw[2]|h_sw[3]|h_sw[4]|h_sw[5]|h_sw[6]|h_sw[7]|h_sw[8]|h_sw[9]|l_sw[0]|l_sw[10]|l_sw[1]|l_sw[2]|l_sw[3]|l_sw[4]|l_sw[5]|l_sw[6]|l_sw[7]|l_sw[8]|l_sw[9]|out|pad|padres|vc|vcp|vdd|vddr|vip|vss|z
+ sg13_lv_nmos L=0.13u W=0.42u AS=0.0798p AD=0.2373p PS=0.8u PD=1.97u rfmode=0
M$1027
+ BOTTOM|TOP|VGND|VSS|anode|cathode|core|h_sw[0]|h_sw[10]|h_sw[1]|h_sw[2]|h_sw[3]|h_sw[4]|h_sw[5]|h_sw[6]|h_sw[7]|h_sw[8]|h_sw[9]|l_sw[0]|l_sw[10]|l_sw[1]|l_sw[2]|l_sw[3]|l_sw[4]|l_sw[5]|l_sw[6]|l_sw[7]|l_sw[8]|l_sw[9]|out|pad|padres|vc|vcp|vdd|vddr|vip|vss|z
+ \$73036 \$73068
+ BOTTOM|TOP|VGND|VSS|anode|cathode|core|h_sw[0]|h_sw[10]|h_sw[1]|h_sw[2]|h_sw[3]|h_sw[4]|h_sw[5]|h_sw[6]|h_sw[7]|h_sw[8]|h_sw[9]|l_sw[0]|l_sw[10]|l_sw[1]|l_sw[2]|l_sw[3]|l_sw[4]|l_sw[5]|l_sw[6]|l_sw[7]|l_sw[8]|l_sw[9]|out|pad|padres|vc|vcp|vdd|vddr|vip|vss|z
+ sg13_lv_nmos L=0.13u W=0.74u AS=0.317325p AD=0.2516p PS=1.805u PD=2.16u
+ rfmode=0
M$1028
+ BOTTOM|TOP|VGND|VSS|anode|cathode|core|h_sw[0]|h_sw[10]|h_sw[1]|h_sw[2]|h_sw[3]|h_sw[4]|h_sw[5]|h_sw[6]|h_sw[7]|h_sw[8]|h_sw[9]|l_sw[0]|l_sw[10]|l_sw[1]|l_sw[2]|l_sw[3]|l_sw[4]|l_sw[5]|l_sw[6]|l_sw[7]|l_sw[8]|l_sw[9]|out|pad|padres|vc|vcp|vdd|vddr|vip|vss|z
+ CLK|D|GATE|Q$7 \$73036
+ BOTTOM|TOP|VGND|VSS|anode|cathode|core|h_sw[0]|h_sw[10]|h_sw[1]|h_sw[2]|h_sw[3]|h_sw[4]|h_sw[5]|h_sw[6]|h_sw[7]|h_sw[8]|h_sw[9]|l_sw[0]|l_sw[10]|l_sw[1]|l_sw[2]|l_sw[3]|l_sw[4]|l_sw[5]|l_sw[6]|l_sw[7]|l_sw[8]|l_sw[9]|out|pad|padres|vc|vcp|vdd|vddr|vip|vss|z
+ sg13_lv_nmos L=0.13u W=0.74u AS=0.317325p AD=0.2516p PS=1.805u PD=2.16u
+ rfmode=0
M$1029 \$73040 \$73043 \$73158
+ BOTTOM|TOP|VGND|VSS|anode|cathode|core|h_sw[0]|h_sw[10]|h_sw[1]|h_sw[2]|h_sw[3]|h_sw[4]|h_sw[5]|h_sw[6]|h_sw[7]|h_sw[8]|h_sw[9]|l_sw[0]|l_sw[10]|l_sw[1]|l_sw[2]|l_sw[3]|l_sw[4]|l_sw[5]|l_sw[6]|l_sw[7]|l_sw[8]|l_sw[9]|out|pad|padres|vc|vcp|vdd|vddr|vip|vss|z
+ sg13_lv_nmos L=0.13u W=0.42u AS=0.1296p AD=0.0798p PS=1.52u PD=0.8u rfmode=0
M$1030 \$73158 \$73072 \$73041
+ BOTTOM|TOP|VGND|VSS|anode|cathode|core|h_sw[0]|h_sw[10]|h_sw[1]|h_sw[2]|h_sw[3]|h_sw[4]|h_sw[5]|h_sw[6]|h_sw[7]|h_sw[8]|h_sw[9]|l_sw[0]|l_sw[10]|l_sw[1]|l_sw[2]|l_sw[3]|l_sw[4]|l_sw[5]|l_sw[6]|l_sw[7]|l_sw[8]|l_sw[9]|out|pad|padres|vc|vcp|vdd|vddr|vip|vss|z
+ sg13_lv_nmos L=0.13u W=0.42u AS=0.0798p AD=0.2373p PS=0.8u PD=1.97u rfmode=0
M$1031
+ BOTTOM|TOP|VGND|VSS|anode|cathode|core|h_sw[0]|h_sw[10]|h_sw[1]|h_sw[2]|h_sw[3]|h_sw[4]|h_sw[5]|h_sw[6]|h_sw[7]|h_sw[8]|h_sw[9]|l_sw[0]|l_sw[10]|l_sw[1]|l_sw[2]|l_sw[3]|l_sw[4]|l_sw[5]|l_sw[6]|l_sw[7]|l_sw[8]|l_sw[9]|out|pad|padres|vc|vcp|vdd|vddr|vip|vss|z
+ \$73043 \$73072
+ BOTTOM|TOP|VGND|VSS|anode|cathode|core|h_sw[0]|h_sw[10]|h_sw[1]|h_sw[2]|h_sw[3]|h_sw[4]|h_sw[5]|h_sw[6]|h_sw[7]|h_sw[8]|h_sw[9]|l_sw[0]|l_sw[10]|l_sw[1]|l_sw[2]|l_sw[3]|l_sw[4]|l_sw[5]|l_sw[6]|l_sw[7]|l_sw[8]|l_sw[9]|out|pad|padres|vc|vcp|vdd|vddr|vip|vss|z
+ sg13_lv_nmos L=0.13u W=0.74u AS=0.317325p AD=0.2516p PS=1.805u PD=2.16u
+ rfmode=0
M$1032
+ BOTTOM|TOP|VGND|VSS|anode|cathode|core|h_sw[0]|h_sw[10]|h_sw[1]|h_sw[2]|h_sw[3]|h_sw[4]|h_sw[5]|h_sw[6]|h_sw[7]|h_sw[8]|h_sw[9]|l_sw[0]|l_sw[10]|l_sw[1]|l_sw[2]|l_sw[3]|l_sw[4]|l_sw[5]|l_sw[6]|l_sw[7]|l_sw[8]|l_sw[9]|out|pad|padres|vc|vcp|vdd|vddr|vip|vss|z
+ CLK|D|GATE|Q$4 \$73043
+ BOTTOM|TOP|VGND|VSS|anode|cathode|core|h_sw[0]|h_sw[10]|h_sw[1]|h_sw[2]|h_sw[3]|h_sw[4]|h_sw[5]|h_sw[6]|h_sw[7]|h_sw[8]|h_sw[9]|l_sw[0]|l_sw[10]|l_sw[1]|l_sw[2]|l_sw[3]|l_sw[4]|l_sw[5]|l_sw[6]|l_sw[7]|l_sw[8]|l_sw[9]|out|pad|padres|vc|vcp|vdd|vddr|vip|vss|z
+ sg13_lv_nmos L=0.13u W=0.74u AS=0.317325p AD=0.2516p PS=1.805u PD=2.16u
+ rfmode=0
M$1033
+ BOTTOM|TOP|VGND|VSS|anode|cathode|core|h_sw[0]|h_sw[10]|h_sw[1]|h_sw[2]|h_sw[3]|h_sw[4]|h_sw[5]|h_sw[6]|h_sw[7]|h_sw[8]|h_sw[9]|l_sw[0]|l_sw[10]|l_sw[1]|l_sw[2]|l_sw[3]|l_sw[4]|l_sw[5]|l_sw[6]|l_sw[7]|l_sw[8]|l_sw[9]|out|pad|padres|vc|vcp|vdd|vddr|vip|vss|z
+ \$74050 anode|cathode|core|in|pad|padres|vip
+ BOTTOM|TOP|VGND|VSS|anode|cathode|core|h_sw[0]|h_sw[10]|h_sw[1]|h_sw[2]|h_sw[3]|h_sw[4]|h_sw[5]|h_sw[6]|h_sw[7]|h_sw[8]|h_sw[9]|l_sw[0]|l_sw[10]|l_sw[1]|l_sw[2]|l_sw[3]|l_sw[4]|l_sw[5]|l_sw[6]|l_sw[7]|l_sw[8]|l_sw[9]|out|pad|padres|vc|vcp|vdd|vddr|vip|vss|z
+ sg13_lv_nmos L=0.13u W=2.5u AS=0.85p AD=0.85p PS=5.68u PD=5.68u rfmode=0
M$1034 \$73607 \$73905 \$73647
+ BOTTOM|TOP|VGND|VSS|anode|cathode|core|h_sw[0]|h_sw[10]|h_sw[1]|h_sw[2]|h_sw[3]|h_sw[4]|h_sw[5]|h_sw[6]|h_sw[7]|h_sw[8]|h_sw[9]|l_sw[0]|l_sw[10]|l_sw[1]|l_sw[2]|l_sw[3]|l_sw[4]|l_sw[5]|l_sw[6]|l_sw[7]|l_sw[8]|l_sw[9]|out|pad|padres|vc|vcp|vdd|vddr|vip|vss|z
+ sg13_lv_nmos L=0.13u W=0.42u AS=0.1296p AD=0.0798p PS=1.52u PD=0.8u rfmode=0
M$1035 \$73647 \$73648 \$73977
+ BOTTOM|TOP|VGND|VSS|anode|cathode|core|h_sw[0]|h_sw[10]|h_sw[1]|h_sw[2]|h_sw[3]|h_sw[4]|h_sw[5]|h_sw[6]|h_sw[7]|h_sw[8]|h_sw[9]|l_sw[0]|l_sw[10]|l_sw[1]|l_sw[2]|l_sw[3]|l_sw[4]|l_sw[5]|l_sw[6]|l_sw[7]|l_sw[8]|l_sw[9]|out|pad|padres|vc|vcp|vdd|vddr|vip|vss|z
+ sg13_lv_nmos L=0.13u W=0.42u AS=0.0798p AD=0.2373p PS=0.8u PD=1.97u rfmode=0
M$1036 \$73648 \$73905
+ BOTTOM|TOP|VGND|VSS|anode|cathode|core|h_sw[0]|h_sw[10]|h_sw[1]|h_sw[2]|h_sw[3]|h_sw[4]|h_sw[5]|h_sw[6]|h_sw[7]|h_sw[8]|h_sw[9]|l_sw[0]|l_sw[10]|l_sw[1]|l_sw[2]|l_sw[3]|l_sw[4]|l_sw[5]|l_sw[6]|l_sw[7]|l_sw[8]|l_sw[9]|out|pad|padres|vc|vcp|vdd|vddr|vip|vss|z
+ BOTTOM|TOP|VGND|VSS|anode|cathode|core|h_sw[0]|h_sw[10]|h_sw[1]|h_sw[2]|h_sw[3]|h_sw[4]|h_sw[5]|h_sw[6]|h_sw[7]|h_sw[8]|h_sw[9]|l_sw[0]|l_sw[10]|l_sw[1]|l_sw[2]|l_sw[3]|l_sw[4]|l_sw[5]|l_sw[6]|l_sw[7]|l_sw[8]|l_sw[9]|out|pad|padres|vc|vcp|vdd|vddr|vip|vss|z
+ sg13_lv_nmos L=0.13u W=0.74u AS=0.2516p AD=0.317325p PS=2.16u PD=1.805u
+ rfmode=0
M$1037
+ BOTTOM|TOP|VGND|VSS|anode|cathode|core|h_sw[0]|h_sw[10]|h_sw[1]|h_sw[2]|h_sw[3]|h_sw[4]|h_sw[5]|h_sw[6]|h_sw[7]|h_sw[8]|h_sw[9]|l_sw[0]|l_sw[10]|l_sw[1]|l_sw[2]|l_sw[3]|l_sw[4]|l_sw[5]|l_sw[6]|l_sw[7]|l_sw[8]|l_sw[9]|out|pad|padres|vc|vcp|vdd|vddr|vip|vss|z
+ CLK|D|GATE|Q$6 \$73905
+ BOTTOM|TOP|VGND|VSS|anode|cathode|core|h_sw[0]|h_sw[10]|h_sw[1]|h_sw[2]|h_sw[3]|h_sw[4]|h_sw[5]|h_sw[6]|h_sw[7]|h_sw[8]|h_sw[9]|l_sw[0]|l_sw[10]|l_sw[1]|l_sw[2]|l_sw[3]|l_sw[4]|l_sw[5]|l_sw[6]|l_sw[7]|l_sw[8]|l_sw[9]|out|pad|padres|vc|vcp|vdd|vddr|vip|vss|z
+ sg13_lv_nmos L=0.13u W=0.74u AS=0.317325p AD=0.2516p PS=1.805u PD=2.16u
+ rfmode=0
M$1038 \$73978 \$73905 \$73907
+ BOTTOM|TOP|VGND|VSS|anode|cathode|core|h_sw[0]|h_sw[10]|h_sw[1]|h_sw[2]|h_sw[3]|h_sw[4]|h_sw[5]|h_sw[6]|h_sw[7]|h_sw[8]|h_sw[9]|l_sw[0]|l_sw[10]|l_sw[1]|l_sw[2]|l_sw[3]|l_sw[4]|l_sw[5]|l_sw[6]|l_sw[7]|l_sw[8]|l_sw[9]|out|pad|padres|vc|vcp|vdd|vddr|vip|vss|z
+ sg13_lv_nmos L=0.13u W=0.42u AS=0.1428p AD=0.12665p PS=1.52u PD=1.145u
+ rfmode=0
M$1039 \$73907 \$73648 \$73646
+ BOTTOM|TOP|VGND|VSS|anode|cathode|core|h_sw[0]|h_sw[10]|h_sw[1]|h_sw[2]|h_sw[3]|h_sw[4]|h_sw[5]|h_sw[6]|h_sw[7]|h_sw[8]|h_sw[9]|l_sw[0]|l_sw[10]|l_sw[1]|l_sw[2]|l_sw[3]|l_sw[4]|l_sw[5]|l_sw[6]|l_sw[7]|l_sw[8]|l_sw[9]|out|pad|padres|vc|vcp|vdd|vddr|vip|vss|z
+ sg13_lv_nmos L=0.13u W=0.74u AS=0.12665p AD=0.3473p PS=1.145u PD=2.71u
+ rfmode=0
M$1040
+ BOTTOM|TOP|VGND|VSS|anode|cathode|core|h_sw[0]|h_sw[10]|h_sw[1]|h_sw[2]|h_sw[3]|h_sw[4]|h_sw[5]|h_sw[6]|h_sw[7]|h_sw[8]|h_sw[9]|l_sw[0]|l_sw[10]|l_sw[1]|l_sw[2]|l_sw[3]|l_sw[4]|l_sw[5]|l_sw[6]|l_sw[7]|l_sw[8]|l_sw[9]|out|pad|padres|vc|vcp|vdd|vddr|vip|vss|z
+ \$73907 D|Q_N$7
+ BOTTOM|TOP|VGND|VSS|anode|cathode|core|h_sw[0]|h_sw[10]|h_sw[1]|h_sw[2]|h_sw[3]|h_sw[4]|h_sw[5]|h_sw[6]|h_sw[7]|h_sw[8]|h_sw[9]|l_sw[0]|l_sw[10]|l_sw[1]|l_sw[2]|l_sw[3]|l_sw[4]|l_sw[5]|l_sw[6]|l_sw[7]|l_sw[8]|l_sw[9]|out|pad|padres|vc|vcp|vdd|vddr|vip|vss|z
+ sg13_lv_nmos L=0.13u W=0.74u AS=0.2516p AD=0.2849p PS=2.16u PD=2.25u rfmode=0
M$1041 \$73609 \$73907
+ BOTTOM|TOP|VGND|VSS|anode|cathode|core|h_sw[0]|h_sw[10]|h_sw[1]|h_sw[2]|h_sw[3]|h_sw[4]|h_sw[5]|h_sw[6]|h_sw[7]|h_sw[8]|h_sw[9]|l_sw[0]|l_sw[10]|l_sw[1]|l_sw[2]|l_sw[3]|l_sw[4]|l_sw[5]|l_sw[6]|l_sw[7]|l_sw[8]|l_sw[9]|out|pad|padres|vc|vcp|vdd|vddr|vip|vss|z
+ BOTTOM|TOP|VGND|VSS|anode|cathode|core|h_sw[0]|h_sw[10]|h_sw[1]|h_sw[2]|h_sw[3]|h_sw[4]|h_sw[5]|h_sw[6]|h_sw[7]|h_sw[8]|h_sw[9]|l_sw[0]|l_sw[10]|l_sw[1]|l_sw[2]|l_sw[3]|l_sw[4]|l_sw[5]|l_sw[6]|l_sw[7]|l_sw[8]|l_sw[9]|out|pad|padres|vc|vcp|vdd|vddr|vip|vss|z
+ sg13_lv_nmos L=0.13u W=0.74u AS=0.2516p AD=0.1406p PS=2.16u PD=1.12u rfmode=0
M$1042
+ BOTTOM|TOP|VGND|VSS|anode|cathode|core|h_sw[0]|h_sw[10]|h_sw[1]|h_sw[2]|h_sw[3]|h_sw[4]|h_sw[5]|h_sw[6]|h_sw[7]|h_sw[8]|h_sw[9]|l_sw[0]|l_sw[10]|l_sw[1]|l_sw[2]|l_sw[3]|l_sw[4]|l_sw[5]|l_sw[6]|l_sw[7]|l_sw[8]|l_sw[9]|out|pad|padres|vc|vcp|vdd|vddr|vip|vss|z
+ \$73609 B2|D|Q
+ BOTTOM|TOP|VGND|VSS|anode|cathode|core|h_sw[0]|h_sw[10]|h_sw[1]|h_sw[2]|h_sw[3]|h_sw[4]|h_sw[5]|h_sw[6]|h_sw[7]|h_sw[8]|h_sw[9]|l_sw[0]|l_sw[10]|l_sw[1]|l_sw[2]|l_sw[3]|l_sw[4]|l_sw[5]|l_sw[6]|l_sw[7]|l_sw[8]|l_sw[9]|out|pad|padres|vc|vcp|vdd|vddr|vip|vss|z
+ sg13_lv_nmos L=0.13u W=0.74u AS=0.1406p AD=0.2516p PS=1.12u PD=2.16u rfmode=0
M$1043
+ BOTTOM|TOP|VGND|VSS|anode|cathode|core|h_sw[0]|h_sw[10]|h_sw[1]|h_sw[2]|h_sw[3]|h_sw[4]|h_sw[5]|h_sw[6]|h_sw[7]|h_sw[8]|h_sw[9]|l_sw[0]|l_sw[10]|l_sw[1]|l_sw[2]|l_sw[3]|l_sw[4]|l_sw[5]|l_sw[6]|l_sw[7]|l_sw[8]|l_sw[9]|out|pad|padres|vc|vcp|vdd|vddr|vip|vss|z
+ A|X$19 A|Y$21
+ BOTTOM|TOP|VGND|VSS|anode|cathode|core|h_sw[0]|h_sw[10]|h_sw[1]|h_sw[2]|h_sw[3]|h_sw[4]|h_sw[5]|h_sw[6]|h_sw[7]|h_sw[8]|h_sw[9]|l_sw[0]|l_sw[10]|l_sw[1]|l_sw[2]|l_sw[3]|l_sw[4]|l_sw[5]|l_sw[6]|l_sw[7]|l_sw[8]|l_sw[9]|out|pad|padres|vc|vcp|vdd|vddr|vip|vss|z
+ sg13_lv_nmos L=0.13u W=0.74u AS=0.2516p AD=0.2516p PS=2.16u PD=2.16u rfmode=0
M$1044 \$73649 B2|D|Q
+ BOTTOM|TOP|VGND|VSS|anode|cathode|core|h_sw[0]|h_sw[10]|h_sw[1]|h_sw[2]|h_sw[3]|h_sw[4]|h_sw[5]|h_sw[6]|h_sw[7]|h_sw[8]|h_sw[9]|l_sw[0]|l_sw[10]|l_sw[1]|l_sw[2]|l_sw[3]|l_sw[4]|l_sw[5]|l_sw[6]|l_sw[7]|l_sw[8]|l_sw[9]|out|pad|padres|vc|vcp|vdd|vddr|vip|vss|z
+ BOTTOM|TOP|VGND|VSS|anode|cathode|core|h_sw[0]|h_sw[10]|h_sw[1]|h_sw[2]|h_sw[3]|h_sw[4]|h_sw[5]|h_sw[6]|h_sw[7]|h_sw[8]|h_sw[9]|l_sw[0]|l_sw[10]|l_sw[1]|l_sw[2]|l_sw[3]|l_sw[4]|l_sw[5]|l_sw[6]|l_sw[7]|l_sw[8]|l_sw[9]|out|pad|padres|vc|vcp|vdd|vddr|vip|vss|z
+ sg13_lv_nmos L=0.13u W=0.55u AS=0.187p AD=0.15055p PS=1.78u PD=1.17u rfmode=0
M$1045
+ BOTTOM|TOP|VGND|VSS|anode|cathode|core|h_sw[0]|h_sw[10]|h_sw[1]|h_sw[2]|h_sw[3]|h_sw[4]|h_sw[5]|h_sw[6]|h_sw[7]|h_sw[8]|h_sw[9]|l_sw[0]|l_sw[10]|l_sw[1]|l_sw[2]|l_sw[3]|l_sw[4]|l_sw[5]|l_sw[6]|l_sw[7]|l_sw[8]|l_sw[9]|out|pad|padres|vc|vcp|vdd|vddr|vip|vss|z
+ CLK|D|GATE|Q$6 \$73909
+ BOTTOM|TOP|VGND|VSS|anode|cathode|core|h_sw[0]|h_sw[10]|h_sw[1]|h_sw[2]|h_sw[3]|h_sw[4]|h_sw[5]|h_sw[6]|h_sw[7]|h_sw[8]|h_sw[9]|l_sw[0]|l_sw[10]|l_sw[1]|l_sw[2]|l_sw[3]|l_sw[4]|l_sw[5]|l_sw[6]|l_sw[7]|l_sw[8]|l_sw[9]|out|pad|padres|vc|vcp|vdd|vddr|vip|vss|z
+ sg13_lv_nmos L=0.13u W=0.74u AS=0.15055p AD=0.2516p PS=1.17u PD=2.16u rfmode=0
M$1046 \$73650 \$73909 \$74088
+ BOTTOM|TOP|VGND|VSS|anode|cathode|core|h_sw[0]|h_sw[10]|h_sw[1]|h_sw[2]|h_sw[3]|h_sw[4]|h_sw[5]|h_sw[6]|h_sw[7]|h_sw[8]|h_sw[9]|l_sw[0]|l_sw[10]|l_sw[1]|l_sw[2]|l_sw[3]|l_sw[4]|l_sw[5]|l_sw[6]|l_sw[7]|l_sw[8]|l_sw[9]|out|pad|padres|vc|vcp|vdd|vddr|vip|vss|z
+ sg13_lv_nmos L=0.13u W=0.42u AS=0.141p AD=0.04725p PS=1.17u PD=0.645u rfmode=0
M$1047 \$74088 \$73611
+ BOTTOM|TOP|VGND|VSS|anode|cathode|core|h_sw[0]|h_sw[10]|h_sw[1]|h_sw[2]|h_sw[3]|h_sw[4]|h_sw[5]|h_sw[6]|h_sw[7]|h_sw[8]|h_sw[9]|l_sw[0]|l_sw[10]|l_sw[1]|l_sw[2]|l_sw[3]|l_sw[4]|l_sw[5]|l_sw[6]|l_sw[7]|l_sw[8]|l_sw[9]|out|pad|padres|vc|vcp|vdd|vddr|vip|vss|z
+ BOTTOM|TOP|VGND|VSS|anode|cathode|core|h_sw[0]|h_sw[10]|h_sw[1]|h_sw[2]|h_sw[3]|h_sw[4]|h_sw[5]|h_sw[6]|h_sw[7]|h_sw[8]|h_sw[9]|l_sw[0]|l_sw[10]|l_sw[1]|l_sw[2]|l_sw[3]|l_sw[4]|l_sw[5]|l_sw[6]|l_sw[7]|l_sw[8]|l_sw[9]|out|pad|padres|vc|vcp|vdd|vddr|vip|vss|z
+ sg13_lv_nmos L=0.13u W=0.42u AS=0.04725p AD=0.1428p PS=0.645u PD=1.52u
+ rfmode=0
M$1048 \$73910 \$73909
+ BOTTOM|TOP|VGND|VSS|anode|cathode|core|h_sw[0]|h_sw[10]|h_sw[1]|h_sw[2]|h_sw[3]|h_sw[4]|h_sw[5]|h_sw[6]|h_sw[7]|h_sw[8]|h_sw[9]|l_sw[0]|l_sw[10]|l_sw[1]|l_sw[2]|l_sw[3]|l_sw[4]|l_sw[5]|l_sw[6]|l_sw[7]|l_sw[8]|l_sw[9]|out|pad|padres|vc|vcp|vdd|vddr|vip|vss|z
+ BOTTOM|TOP|VGND|VSS|anode|cathode|core|h_sw[0]|h_sw[10]|h_sw[1]|h_sw[2]|h_sw[3]|h_sw[4]|h_sw[5]|h_sw[6]|h_sw[7]|h_sw[8]|h_sw[9]|l_sw[0]|l_sw[10]|l_sw[1]|l_sw[2]|l_sw[3]|l_sw[4]|l_sw[5]|l_sw[6]|l_sw[7]|l_sw[8]|l_sw[9]|out|pad|padres|vc|vcp|vdd|vddr|vip|vss|z
+ sg13_lv_nmos L=0.13u W=0.74u AS=0.2775p AD=0.213425p PS=2.23u PD=1.62u
+ rfmode=0
M$1049
+ BOTTOM|TOP|VGND|VSS|anode|cathode|core|h_sw[0]|h_sw[10]|h_sw[1]|h_sw[2]|h_sw[3]|h_sw[4]|h_sw[5]|h_sw[6]|h_sw[7]|h_sw[8]|h_sw[9]|l_sw[0]|l_sw[10]|l_sw[1]|l_sw[2]|l_sw[3]|l_sw[4]|l_sw[5]|l_sw[6]|l_sw[7]|l_sw[8]|l_sw[9]|out|pad|padres|vc|vcp|vdd|vddr|vip|vss|z
+ \$73649 \$74086
+ BOTTOM|TOP|VGND|VSS|anode|cathode|core|h_sw[0]|h_sw[10]|h_sw[1]|h_sw[2]|h_sw[3]|h_sw[4]|h_sw[5]|h_sw[6]|h_sw[7]|h_sw[8]|h_sw[9]|l_sw[0]|l_sw[10]|l_sw[1]|l_sw[2]|l_sw[3]|l_sw[4]|l_sw[5]|l_sw[6]|l_sw[7]|l_sw[8]|l_sw[9]|out|pad|padres|vc|vcp|vdd|vddr|vip|vss|z
+ sg13_lv_nmos L=0.13u W=0.64u AS=0.213425p AD=0.072p PS=1.62u PD=0.865u
+ rfmode=0
M$1050 \$74086 \$73910 \$73650
+ BOTTOM|TOP|VGND|VSS|anode|cathode|core|h_sw[0]|h_sw[10]|h_sw[1]|h_sw[2]|h_sw[3]|h_sw[4]|h_sw[5]|h_sw[6]|h_sw[7]|h_sw[8]|h_sw[9]|l_sw[0]|l_sw[10]|l_sw[1]|l_sw[2]|l_sw[3]|l_sw[4]|l_sw[5]|l_sw[6]|l_sw[7]|l_sw[8]|l_sw[9]|out|pad|padres|vc|vcp|vdd|vddr|vip|vss|z
+ sg13_lv_nmos L=0.13u W=0.64u AS=0.072p AD=0.141p PS=0.865u PD=1.17u rfmode=0
M$1051 \$73651 D|Q_N$5
+ BOTTOM|TOP|VGND|VSS|anode|cathode|core|h_sw[0]|h_sw[10]|h_sw[1]|h_sw[2]|h_sw[3]|h_sw[4]|h_sw[5]|h_sw[6]|h_sw[7]|h_sw[8]|h_sw[9]|l_sw[0]|l_sw[10]|l_sw[1]|l_sw[2]|l_sw[3]|l_sw[4]|l_sw[5]|l_sw[6]|l_sw[7]|l_sw[8]|l_sw[9]|out|pad|padres|vc|vcp|vdd|vddr|vip|vss|z
+ BOTTOM|TOP|VGND|VSS|anode|cathode|core|h_sw[0]|h_sw[10]|h_sw[1]|h_sw[2]|h_sw[3]|h_sw[4]|h_sw[5]|h_sw[6]|h_sw[7]|h_sw[8]|h_sw[9]|l_sw[0]|l_sw[10]|l_sw[1]|l_sw[2]|l_sw[3]|l_sw[4]|l_sw[5]|l_sw[6]|l_sw[7]|l_sw[8]|l_sw[9]|out|pad|padres|vc|vcp|vdd|vddr|vip|vss|z
+ sg13_lv_nmos L=0.13u W=0.55u AS=0.187p AD=0.15055p PS=1.78u PD=1.17u rfmode=0
M$1052
+ BOTTOM|TOP|VGND|VSS|anode|cathode|core|h_sw[0]|h_sw[10]|h_sw[1]|h_sw[2]|h_sw[3]|h_sw[4]|h_sw[5]|h_sw[6]|h_sw[7]|h_sw[8]|h_sw[9]|l_sw[0]|l_sw[10]|l_sw[1]|l_sw[2]|l_sw[3]|l_sw[4]|l_sw[5]|l_sw[6]|l_sw[7]|l_sw[8]|l_sw[9]|out|pad|padres|vc|vcp|vdd|vddr|vip|vss|z
+ CLK|D|GATE|Q$5 \$73911
+ BOTTOM|TOP|VGND|VSS|anode|cathode|core|h_sw[0]|h_sw[10]|h_sw[1]|h_sw[2]|h_sw[3]|h_sw[4]|h_sw[5]|h_sw[6]|h_sw[7]|h_sw[8]|h_sw[9]|l_sw[0]|l_sw[10]|l_sw[1]|l_sw[2]|l_sw[3]|l_sw[4]|l_sw[5]|l_sw[6]|l_sw[7]|l_sw[8]|l_sw[9]|out|pad|padres|vc|vcp|vdd|vddr|vip|vss|z
+ sg13_lv_nmos L=0.13u W=0.74u AS=0.15055p AD=0.2516p PS=1.17u PD=2.16u rfmode=0
M$1053 \$73652 \$73911 \$74090
+ BOTTOM|TOP|VGND|VSS|anode|cathode|core|h_sw[0]|h_sw[10]|h_sw[1]|h_sw[2]|h_sw[3]|h_sw[4]|h_sw[5]|h_sw[6]|h_sw[7]|h_sw[8]|h_sw[9]|l_sw[0]|l_sw[10]|l_sw[1]|l_sw[2]|l_sw[3]|l_sw[4]|l_sw[5]|l_sw[6]|l_sw[7]|l_sw[8]|l_sw[9]|out|pad|padres|vc|vcp|vdd|vddr|vip|vss|z
+ sg13_lv_nmos L=0.13u W=0.42u AS=0.141p AD=0.04725p PS=1.17u PD=0.645u rfmode=0
M$1054 \$74090 \$73614
+ BOTTOM|TOP|VGND|VSS|anode|cathode|core|h_sw[0]|h_sw[10]|h_sw[1]|h_sw[2]|h_sw[3]|h_sw[4]|h_sw[5]|h_sw[6]|h_sw[7]|h_sw[8]|h_sw[9]|l_sw[0]|l_sw[10]|l_sw[1]|l_sw[2]|l_sw[3]|l_sw[4]|l_sw[5]|l_sw[6]|l_sw[7]|l_sw[8]|l_sw[9]|out|pad|padres|vc|vcp|vdd|vddr|vip|vss|z
+ BOTTOM|TOP|VGND|VSS|anode|cathode|core|h_sw[0]|h_sw[10]|h_sw[1]|h_sw[2]|h_sw[3]|h_sw[4]|h_sw[5]|h_sw[6]|h_sw[7]|h_sw[8]|h_sw[9]|l_sw[0]|l_sw[10]|l_sw[1]|l_sw[2]|l_sw[3]|l_sw[4]|l_sw[5]|l_sw[6]|l_sw[7]|l_sw[8]|l_sw[9]|out|pad|padres|vc|vcp|vdd|vddr|vip|vss|z
+ sg13_lv_nmos L=0.13u W=0.42u AS=0.04725p AD=0.1428p PS=0.645u PD=1.52u
+ rfmode=0
M$1055 \$73912 \$73911
+ BOTTOM|TOP|VGND|VSS|anode|cathode|core|h_sw[0]|h_sw[10]|h_sw[1]|h_sw[2]|h_sw[3]|h_sw[4]|h_sw[5]|h_sw[6]|h_sw[7]|h_sw[8]|h_sw[9]|l_sw[0]|l_sw[10]|l_sw[1]|l_sw[2]|l_sw[3]|l_sw[4]|l_sw[5]|l_sw[6]|l_sw[7]|l_sw[8]|l_sw[9]|out|pad|padres|vc|vcp|vdd|vddr|vip|vss|z
+ BOTTOM|TOP|VGND|VSS|anode|cathode|core|h_sw[0]|h_sw[10]|h_sw[1]|h_sw[2]|h_sw[3]|h_sw[4]|h_sw[5]|h_sw[6]|h_sw[7]|h_sw[8]|h_sw[9]|l_sw[0]|l_sw[10]|l_sw[1]|l_sw[2]|l_sw[3]|l_sw[4]|l_sw[5]|l_sw[6]|l_sw[7]|l_sw[8]|l_sw[9]|out|pad|padres|vc|vcp|vdd|vddr|vip|vss|z
+ sg13_lv_nmos L=0.13u W=0.74u AS=0.2775p AD=0.213425p PS=2.23u PD=1.62u
+ rfmode=0
M$1056
+ BOTTOM|TOP|VGND|VSS|anode|cathode|core|h_sw[0]|h_sw[10]|h_sw[1]|h_sw[2]|h_sw[3]|h_sw[4]|h_sw[5]|h_sw[6]|h_sw[7]|h_sw[8]|h_sw[9]|l_sw[0]|l_sw[10]|l_sw[1]|l_sw[2]|l_sw[3]|l_sw[4]|l_sw[5]|l_sw[6]|l_sw[7]|l_sw[8]|l_sw[9]|out|pad|padres|vc|vcp|vdd|vddr|vip|vss|z
+ \$73651 \$74091
+ BOTTOM|TOP|VGND|VSS|anode|cathode|core|h_sw[0]|h_sw[10]|h_sw[1]|h_sw[2]|h_sw[3]|h_sw[4]|h_sw[5]|h_sw[6]|h_sw[7]|h_sw[8]|h_sw[9]|l_sw[0]|l_sw[10]|l_sw[1]|l_sw[2]|l_sw[3]|l_sw[4]|l_sw[5]|l_sw[6]|l_sw[7]|l_sw[8]|l_sw[9]|out|pad|padres|vc|vcp|vdd|vddr|vip|vss|z
+ sg13_lv_nmos L=0.13u W=0.64u AS=0.213425p AD=0.072p PS=1.62u PD=0.865u
+ rfmode=0
M$1057 \$74091 \$73912 \$73652
+ BOTTOM|TOP|VGND|VSS|anode|cathode|core|h_sw[0]|h_sw[10]|h_sw[1]|h_sw[2]|h_sw[3]|h_sw[4]|h_sw[5]|h_sw[6]|h_sw[7]|h_sw[8]|h_sw[9]|l_sw[0]|l_sw[10]|l_sw[1]|l_sw[2]|l_sw[3]|l_sw[4]|l_sw[5]|l_sw[6]|l_sw[7]|l_sw[8]|l_sw[9]|out|pad|padres|vc|vcp|vdd|vddr|vip|vss|z
+ sg13_lv_nmos L=0.13u W=0.64u AS=0.072p AD=0.141p PS=0.865u PD=1.17u rfmode=0
M$1058 \$73617 A|X
+ BOTTOM|TOP|VGND|VSS|anode|cathode|core|h_sw[0]|h_sw[10]|h_sw[1]|h_sw[2]|h_sw[3]|h_sw[4]|h_sw[5]|h_sw[6]|h_sw[7]|h_sw[8]|h_sw[9]|l_sw[0]|l_sw[10]|l_sw[1]|l_sw[2]|l_sw[3]|l_sw[4]|l_sw[5]|l_sw[6]|l_sw[7]|l_sw[8]|l_sw[9]|out|pad|padres|vc|vcp|vdd|vddr|vip|vss|z
+ BOTTOM|TOP|VGND|VSS|anode|cathode|core|h_sw[0]|h_sw[10]|h_sw[1]|h_sw[2]|h_sw[3]|h_sw[4]|h_sw[5]|h_sw[6]|h_sw[7]|h_sw[8]|h_sw[9]|l_sw[0]|l_sw[10]|l_sw[1]|l_sw[2]|l_sw[3]|l_sw[4]|l_sw[5]|l_sw[6]|l_sw[7]|l_sw[8]|l_sw[9]|out|pad|padres|vc|vcp|vdd|vddr|vip|vss|z
+ sg13_lv_nmos L=0.13u W=0.55u AS=0.187p AD=0.14875p PS=1.78u PD=1.16u rfmode=0
M$1059
+ BOTTOM|TOP|VGND|VSS|anode|cathode|core|h_sw[0]|h_sw[10]|h_sw[1]|h_sw[2]|h_sw[3]|h_sw[4]|h_sw[5]|h_sw[6]|h_sw[7]|h_sw[8]|h_sw[9]|l_sw[0]|l_sw[10]|l_sw[1]|l_sw[2]|l_sw[3]|l_sw[4]|l_sw[5]|l_sw[6]|l_sw[7]|l_sw[8]|l_sw[9]|out|pad|padres|vc|vcp|vdd|vddr|vip|vss|z
+ \$73617 D|X$1
+ BOTTOM|TOP|VGND|VSS|anode|cathode|core|h_sw[0]|h_sw[10]|h_sw[1]|h_sw[2]|h_sw[3]|h_sw[4]|h_sw[5]|h_sw[6]|h_sw[7]|h_sw[8]|h_sw[9]|l_sw[0]|l_sw[10]|l_sw[1]|l_sw[2]|l_sw[3]|l_sw[4]|l_sw[5]|l_sw[6]|l_sw[7]|l_sw[8]|l_sw[9]|out|pad|padres|vc|vcp|vdd|vddr|vip|vss|z
+ sg13_lv_nmos L=0.13u W=0.74u AS=0.14875p AD=0.2886p PS=1.16u PD=2.26u rfmode=0
M$1060 \$73653 A1|D|Q$3
+ BOTTOM|TOP|VGND|VSS|anode|cathode|core|h_sw[0]|h_sw[10]|h_sw[1]|h_sw[2]|h_sw[3]|h_sw[4]|h_sw[5]|h_sw[6]|h_sw[7]|h_sw[8]|h_sw[9]|l_sw[0]|l_sw[10]|l_sw[1]|l_sw[2]|l_sw[3]|l_sw[4]|l_sw[5]|l_sw[6]|l_sw[7]|l_sw[8]|l_sw[9]|out|pad|padres|vc|vcp|vdd|vddr|vip|vss|z
+ BOTTOM|TOP|VGND|VSS|anode|cathode|core|h_sw[0]|h_sw[10]|h_sw[1]|h_sw[2]|h_sw[3]|h_sw[4]|h_sw[5]|h_sw[6]|h_sw[7]|h_sw[8]|h_sw[9]|l_sw[0]|l_sw[10]|l_sw[1]|l_sw[2]|l_sw[3]|l_sw[4]|l_sw[5]|l_sw[6]|l_sw[7]|l_sw[8]|l_sw[9]|out|pad|padres|vc|vcp|vdd|vddr|vip|vss|z
+ sg13_lv_nmos L=0.13u W=0.55u AS=0.187p AD=0.15055p PS=1.78u PD=1.17u rfmode=0
M$1061
+ BOTTOM|TOP|VGND|VSS|anode|cathode|core|h_sw[0]|h_sw[10]|h_sw[1]|h_sw[2]|h_sw[3]|h_sw[4]|h_sw[5]|h_sw[6]|h_sw[7]|h_sw[8]|h_sw[9]|l_sw[0]|l_sw[10]|l_sw[1]|l_sw[2]|l_sw[3]|l_sw[4]|l_sw[5]|l_sw[6]|l_sw[7]|l_sw[8]|l_sw[9]|out|pad|padres|vc|vcp|vdd|vddr|vip|vss|z
+ CLK|D|GATE|Q$9 \$73914
+ BOTTOM|TOP|VGND|VSS|anode|cathode|core|h_sw[0]|h_sw[10]|h_sw[1]|h_sw[2]|h_sw[3]|h_sw[4]|h_sw[5]|h_sw[6]|h_sw[7]|h_sw[8]|h_sw[9]|l_sw[0]|l_sw[10]|l_sw[1]|l_sw[2]|l_sw[3]|l_sw[4]|l_sw[5]|l_sw[6]|l_sw[7]|l_sw[8]|l_sw[9]|out|pad|padres|vc|vcp|vdd|vddr|vip|vss|z
+ sg13_lv_nmos L=0.13u W=0.74u AS=0.15055p AD=0.2516p PS=1.17u PD=2.16u rfmode=0
M$1062 \$73654 \$73914 \$74093
+ BOTTOM|TOP|VGND|VSS|anode|cathode|core|h_sw[0]|h_sw[10]|h_sw[1]|h_sw[2]|h_sw[3]|h_sw[4]|h_sw[5]|h_sw[6]|h_sw[7]|h_sw[8]|h_sw[9]|l_sw[0]|l_sw[10]|l_sw[1]|l_sw[2]|l_sw[3]|l_sw[4]|l_sw[5]|l_sw[6]|l_sw[7]|l_sw[8]|l_sw[9]|out|pad|padres|vc|vcp|vdd|vddr|vip|vss|z
+ sg13_lv_nmos L=0.13u W=0.42u AS=0.141p AD=0.04725p PS=1.17u PD=0.645u rfmode=0
M$1063 \$74093 \$73618
+ BOTTOM|TOP|VGND|VSS|anode|cathode|core|h_sw[0]|h_sw[10]|h_sw[1]|h_sw[2]|h_sw[3]|h_sw[4]|h_sw[5]|h_sw[6]|h_sw[7]|h_sw[8]|h_sw[9]|l_sw[0]|l_sw[10]|l_sw[1]|l_sw[2]|l_sw[3]|l_sw[4]|l_sw[5]|l_sw[6]|l_sw[7]|l_sw[8]|l_sw[9]|out|pad|padres|vc|vcp|vdd|vddr|vip|vss|z
+ BOTTOM|TOP|VGND|VSS|anode|cathode|core|h_sw[0]|h_sw[10]|h_sw[1]|h_sw[2]|h_sw[3]|h_sw[4]|h_sw[5]|h_sw[6]|h_sw[7]|h_sw[8]|h_sw[9]|l_sw[0]|l_sw[10]|l_sw[1]|l_sw[2]|l_sw[3]|l_sw[4]|l_sw[5]|l_sw[6]|l_sw[7]|l_sw[8]|l_sw[9]|out|pad|padres|vc|vcp|vdd|vddr|vip|vss|z
+ sg13_lv_nmos L=0.13u W=0.42u AS=0.04725p AD=0.1428p PS=0.645u PD=1.52u
+ rfmode=0
M$1064 \$73915 \$73914
+ BOTTOM|TOP|VGND|VSS|anode|cathode|core|h_sw[0]|h_sw[10]|h_sw[1]|h_sw[2]|h_sw[3]|h_sw[4]|h_sw[5]|h_sw[6]|h_sw[7]|h_sw[8]|h_sw[9]|l_sw[0]|l_sw[10]|l_sw[1]|l_sw[2]|l_sw[3]|l_sw[4]|l_sw[5]|l_sw[6]|l_sw[7]|l_sw[8]|l_sw[9]|out|pad|padres|vc|vcp|vdd|vddr|vip|vss|z
+ BOTTOM|TOP|VGND|VSS|anode|cathode|core|h_sw[0]|h_sw[10]|h_sw[1]|h_sw[2]|h_sw[3]|h_sw[4]|h_sw[5]|h_sw[6]|h_sw[7]|h_sw[8]|h_sw[9]|l_sw[0]|l_sw[10]|l_sw[1]|l_sw[2]|l_sw[3]|l_sw[4]|l_sw[5]|l_sw[6]|l_sw[7]|l_sw[8]|l_sw[9]|out|pad|padres|vc|vcp|vdd|vddr|vip|vss|z
+ sg13_lv_nmos L=0.13u W=0.74u AS=0.2775p AD=0.213425p PS=2.23u PD=1.62u
+ rfmode=0
M$1065
+ BOTTOM|TOP|VGND|VSS|anode|cathode|core|h_sw[0]|h_sw[10]|h_sw[1]|h_sw[2]|h_sw[3]|h_sw[4]|h_sw[5]|h_sw[6]|h_sw[7]|h_sw[8]|h_sw[9]|l_sw[0]|l_sw[10]|l_sw[1]|l_sw[2]|l_sw[3]|l_sw[4]|l_sw[5]|l_sw[6]|l_sw[7]|l_sw[8]|l_sw[9]|out|pad|padres|vc|vcp|vdd|vddr|vip|vss|z
+ \$73653 \$74094
+ BOTTOM|TOP|VGND|VSS|anode|cathode|core|h_sw[0]|h_sw[10]|h_sw[1]|h_sw[2]|h_sw[3]|h_sw[4]|h_sw[5]|h_sw[6]|h_sw[7]|h_sw[8]|h_sw[9]|l_sw[0]|l_sw[10]|l_sw[1]|l_sw[2]|l_sw[3]|l_sw[4]|l_sw[5]|l_sw[6]|l_sw[7]|l_sw[8]|l_sw[9]|out|pad|padres|vc|vcp|vdd|vddr|vip|vss|z
+ sg13_lv_nmos L=0.13u W=0.64u AS=0.213425p AD=0.072p PS=1.62u PD=0.865u
+ rfmode=0
M$1066 \$74094 \$73915 \$73654
+ BOTTOM|TOP|VGND|VSS|anode|cathode|core|h_sw[0]|h_sw[10]|h_sw[1]|h_sw[2]|h_sw[3]|h_sw[4]|h_sw[5]|h_sw[6]|h_sw[7]|h_sw[8]|h_sw[9]|l_sw[0]|l_sw[10]|l_sw[1]|l_sw[2]|l_sw[3]|l_sw[4]|l_sw[5]|l_sw[6]|l_sw[7]|l_sw[8]|l_sw[9]|out|pad|padres|vc|vcp|vdd|vddr|vip|vss|z
+ sg13_lv_nmos L=0.13u W=0.64u AS=0.072p AD=0.141p PS=0.865u PD=1.17u rfmode=0
M$1067 A|Y$22 A|X$38
+ BOTTOM|TOP|VGND|VSS|anode|cathode|core|h_sw[0]|h_sw[10]|h_sw[1]|h_sw[2]|h_sw[3]|h_sw[4]|h_sw[5]|h_sw[6]|h_sw[7]|h_sw[8]|h_sw[9]|l_sw[0]|l_sw[10]|l_sw[1]|l_sw[2]|l_sw[3]|l_sw[4]|l_sw[5]|l_sw[6]|l_sw[7]|l_sw[8]|l_sw[9]|out|pad|padres|vc|vcp|vdd|vddr|vip|vss|z
+ BOTTOM|TOP|VGND|VSS|anode|cathode|core|h_sw[0]|h_sw[10]|h_sw[1]|h_sw[2]|h_sw[3]|h_sw[4]|h_sw[5]|h_sw[6]|h_sw[7]|h_sw[8]|h_sw[9]|l_sw[0]|l_sw[10]|l_sw[1]|l_sw[2]|l_sw[3]|l_sw[4]|l_sw[5]|l_sw[6]|l_sw[7]|l_sw[8]|l_sw[9]|out|pad|padres|vc|vcp|vdd|vddr|vip|vss|z
+ sg13_lv_nmos L=0.13u W=0.74u AS=0.2516p AD=0.2516p PS=2.16u PD=2.16u rfmode=0
M$1068 A|Y$23 A|X$46
+ BOTTOM|TOP|VGND|VSS|anode|cathode|core|h_sw[0]|h_sw[10]|h_sw[1]|h_sw[2]|h_sw[3]|h_sw[4]|h_sw[5]|h_sw[6]|h_sw[7]|h_sw[8]|h_sw[9]|l_sw[0]|l_sw[10]|l_sw[1]|l_sw[2]|l_sw[3]|l_sw[4]|l_sw[5]|l_sw[6]|l_sw[7]|l_sw[8]|l_sw[9]|out|pad|padres|vc|vcp|vdd|vddr|vip|vss|z
+ BOTTOM|TOP|VGND|VSS|anode|cathode|core|h_sw[0]|h_sw[10]|h_sw[1]|h_sw[2]|h_sw[3]|h_sw[4]|h_sw[5]|h_sw[6]|h_sw[7]|h_sw[8]|h_sw[9]|l_sw[0]|l_sw[10]|l_sw[1]|l_sw[2]|l_sw[3]|l_sw[4]|l_sw[5]|l_sw[6]|l_sw[7]|l_sw[8]|l_sw[9]|out|pad|padres|vc|vcp|vdd|vddr|vip|vss|z
+ sg13_lv_nmos L=0.13u W=0.74u AS=0.2516p AD=0.2516p PS=2.16u PD=2.16u rfmode=0
M$1069 \$73655 D|Q_N$8
+ BOTTOM|TOP|VGND|VSS|anode|cathode|core|h_sw[0]|h_sw[10]|h_sw[1]|h_sw[2]|h_sw[3]|h_sw[4]|h_sw[5]|h_sw[6]|h_sw[7]|h_sw[8]|h_sw[9]|l_sw[0]|l_sw[10]|l_sw[1]|l_sw[2]|l_sw[3]|l_sw[4]|l_sw[5]|l_sw[6]|l_sw[7]|l_sw[8]|l_sw[9]|out|pad|padres|vc|vcp|vdd|vddr|vip|vss|z
+ BOTTOM|TOP|VGND|VSS|anode|cathode|core|h_sw[0]|h_sw[10]|h_sw[1]|h_sw[2]|h_sw[3]|h_sw[4]|h_sw[5]|h_sw[6]|h_sw[7]|h_sw[8]|h_sw[9]|l_sw[0]|l_sw[10]|l_sw[1]|l_sw[2]|l_sw[3]|l_sw[4]|l_sw[5]|l_sw[6]|l_sw[7]|l_sw[8]|l_sw[9]|out|pad|padres|vc|vcp|vdd|vddr|vip|vss|z
+ sg13_lv_nmos L=0.13u W=0.55u AS=0.187p AD=0.15055p PS=1.78u PD=1.17u rfmode=0
M$1070
+ BOTTOM|TOP|VGND|VSS|anode|cathode|core|h_sw[0]|h_sw[10]|h_sw[1]|h_sw[2]|h_sw[3]|h_sw[4]|h_sw[5]|h_sw[6]|h_sw[7]|h_sw[8]|h_sw[9]|l_sw[0]|l_sw[10]|l_sw[1]|l_sw[2]|l_sw[3]|l_sw[4]|l_sw[5]|l_sw[6]|l_sw[7]|l_sw[8]|l_sw[9]|out|pad|padres|vc|vcp|vdd|vddr|vip|vss|z
+ CLK|D|GATE|Q$10 \$73918
+ BOTTOM|TOP|VGND|VSS|anode|cathode|core|h_sw[0]|h_sw[10]|h_sw[1]|h_sw[2]|h_sw[3]|h_sw[4]|h_sw[5]|h_sw[6]|h_sw[7]|h_sw[8]|h_sw[9]|l_sw[0]|l_sw[10]|l_sw[1]|l_sw[2]|l_sw[3]|l_sw[4]|l_sw[5]|l_sw[6]|l_sw[7]|l_sw[8]|l_sw[9]|out|pad|padres|vc|vcp|vdd|vddr|vip|vss|z
+ sg13_lv_nmos L=0.13u W=0.74u AS=0.15055p AD=0.2516p PS=1.17u PD=2.16u rfmode=0
M$1071 \$73656 \$73918 \$74096
+ BOTTOM|TOP|VGND|VSS|anode|cathode|core|h_sw[0]|h_sw[10]|h_sw[1]|h_sw[2]|h_sw[3]|h_sw[4]|h_sw[5]|h_sw[6]|h_sw[7]|h_sw[8]|h_sw[9]|l_sw[0]|l_sw[10]|l_sw[1]|l_sw[2]|l_sw[3]|l_sw[4]|l_sw[5]|l_sw[6]|l_sw[7]|l_sw[8]|l_sw[9]|out|pad|padres|vc|vcp|vdd|vddr|vip|vss|z
+ sg13_lv_nmos L=0.13u W=0.42u AS=0.141p AD=0.04725p PS=1.17u PD=0.645u rfmode=0
M$1072 \$74096 \$73624
+ BOTTOM|TOP|VGND|VSS|anode|cathode|core|h_sw[0]|h_sw[10]|h_sw[1]|h_sw[2]|h_sw[3]|h_sw[4]|h_sw[5]|h_sw[6]|h_sw[7]|h_sw[8]|h_sw[9]|l_sw[0]|l_sw[10]|l_sw[1]|l_sw[2]|l_sw[3]|l_sw[4]|l_sw[5]|l_sw[6]|l_sw[7]|l_sw[8]|l_sw[9]|out|pad|padres|vc|vcp|vdd|vddr|vip|vss|z
+ BOTTOM|TOP|VGND|VSS|anode|cathode|core|h_sw[0]|h_sw[10]|h_sw[1]|h_sw[2]|h_sw[3]|h_sw[4]|h_sw[5]|h_sw[6]|h_sw[7]|h_sw[8]|h_sw[9]|l_sw[0]|l_sw[10]|l_sw[1]|l_sw[2]|l_sw[3]|l_sw[4]|l_sw[5]|l_sw[6]|l_sw[7]|l_sw[8]|l_sw[9]|out|pad|padres|vc|vcp|vdd|vddr|vip|vss|z
+ sg13_lv_nmos L=0.13u W=0.42u AS=0.04725p AD=0.1428p PS=0.645u PD=1.52u
+ rfmode=0
M$1073 \$73919 \$73918
+ BOTTOM|TOP|VGND|VSS|anode|cathode|core|h_sw[0]|h_sw[10]|h_sw[1]|h_sw[2]|h_sw[3]|h_sw[4]|h_sw[5]|h_sw[6]|h_sw[7]|h_sw[8]|h_sw[9]|l_sw[0]|l_sw[10]|l_sw[1]|l_sw[2]|l_sw[3]|l_sw[4]|l_sw[5]|l_sw[6]|l_sw[7]|l_sw[8]|l_sw[9]|out|pad|padres|vc|vcp|vdd|vddr|vip|vss|z
+ BOTTOM|TOP|VGND|VSS|anode|cathode|core|h_sw[0]|h_sw[10]|h_sw[1]|h_sw[2]|h_sw[3]|h_sw[4]|h_sw[5]|h_sw[6]|h_sw[7]|h_sw[8]|h_sw[9]|l_sw[0]|l_sw[10]|l_sw[1]|l_sw[2]|l_sw[3]|l_sw[4]|l_sw[5]|l_sw[6]|l_sw[7]|l_sw[8]|l_sw[9]|out|pad|padres|vc|vcp|vdd|vddr|vip|vss|z
+ sg13_lv_nmos L=0.13u W=0.74u AS=0.2775p AD=0.213425p PS=2.23u PD=1.62u
+ rfmode=0
M$1074
+ BOTTOM|TOP|VGND|VSS|anode|cathode|core|h_sw[0]|h_sw[10]|h_sw[1]|h_sw[2]|h_sw[3]|h_sw[4]|h_sw[5]|h_sw[6]|h_sw[7]|h_sw[8]|h_sw[9]|l_sw[0]|l_sw[10]|l_sw[1]|l_sw[2]|l_sw[3]|l_sw[4]|l_sw[5]|l_sw[6]|l_sw[7]|l_sw[8]|l_sw[9]|out|pad|padres|vc|vcp|vdd|vddr|vip|vss|z
+ \$73655 \$74097
+ BOTTOM|TOP|VGND|VSS|anode|cathode|core|h_sw[0]|h_sw[10]|h_sw[1]|h_sw[2]|h_sw[3]|h_sw[4]|h_sw[5]|h_sw[6]|h_sw[7]|h_sw[8]|h_sw[9]|l_sw[0]|l_sw[10]|l_sw[1]|l_sw[2]|l_sw[3]|l_sw[4]|l_sw[5]|l_sw[6]|l_sw[7]|l_sw[8]|l_sw[9]|out|pad|padres|vc|vcp|vdd|vddr|vip|vss|z
+ sg13_lv_nmos L=0.13u W=0.64u AS=0.213425p AD=0.072p PS=1.62u PD=0.865u
+ rfmode=0
M$1075 \$74097 \$73919 \$73656
+ BOTTOM|TOP|VGND|VSS|anode|cathode|core|h_sw[0]|h_sw[10]|h_sw[1]|h_sw[2]|h_sw[3]|h_sw[4]|h_sw[5]|h_sw[6]|h_sw[7]|h_sw[8]|h_sw[9]|l_sw[0]|l_sw[10]|l_sw[1]|l_sw[2]|l_sw[3]|l_sw[4]|l_sw[5]|l_sw[6]|l_sw[7]|l_sw[8]|l_sw[9]|out|pad|padres|vc|vcp|vdd|vddr|vip|vss|z
+ sg13_lv_nmos L=0.13u W=0.64u AS=0.072p AD=0.141p PS=0.865u PD=1.17u rfmode=0
M$1076 \$73657 B2|D|Q$1
+ BOTTOM|TOP|VGND|VSS|anode|cathode|core|h_sw[0]|h_sw[10]|h_sw[1]|h_sw[2]|h_sw[3]|h_sw[4]|h_sw[5]|h_sw[6]|h_sw[7]|h_sw[8]|h_sw[9]|l_sw[0]|l_sw[10]|l_sw[1]|l_sw[2]|l_sw[3]|l_sw[4]|l_sw[5]|l_sw[6]|l_sw[7]|l_sw[8]|l_sw[9]|out|pad|padres|vc|vcp|vdd|vddr|vip|vss|z
+ BOTTOM|TOP|VGND|VSS|anode|cathode|core|h_sw[0]|h_sw[10]|h_sw[1]|h_sw[2]|h_sw[3]|h_sw[4]|h_sw[5]|h_sw[6]|h_sw[7]|h_sw[8]|h_sw[9]|l_sw[0]|l_sw[10]|l_sw[1]|l_sw[2]|l_sw[3]|l_sw[4]|l_sw[5]|l_sw[6]|l_sw[7]|l_sw[8]|l_sw[9]|out|pad|padres|vc|vcp|vdd|vddr|vip|vss|z
+ sg13_lv_nmos L=0.13u W=0.55u AS=0.187p AD=0.15055p PS=1.78u PD=1.17u rfmode=0
M$1077
+ BOTTOM|TOP|VGND|VSS|anode|cathode|core|h_sw[0]|h_sw[10]|h_sw[1]|h_sw[2]|h_sw[3]|h_sw[4]|h_sw[5]|h_sw[6]|h_sw[7]|h_sw[8]|h_sw[9]|l_sw[0]|l_sw[10]|l_sw[1]|l_sw[2]|l_sw[3]|l_sw[4]|l_sw[5]|l_sw[6]|l_sw[7]|l_sw[8]|l_sw[9]|out|pad|padres|vc|vcp|vdd|vddr|vip|vss|z
+ CLK|D|GATE|Q$7 \$73921
+ BOTTOM|TOP|VGND|VSS|anode|cathode|core|h_sw[0]|h_sw[10]|h_sw[1]|h_sw[2]|h_sw[3]|h_sw[4]|h_sw[5]|h_sw[6]|h_sw[7]|h_sw[8]|h_sw[9]|l_sw[0]|l_sw[10]|l_sw[1]|l_sw[2]|l_sw[3]|l_sw[4]|l_sw[5]|l_sw[6]|l_sw[7]|l_sw[8]|l_sw[9]|out|pad|padres|vc|vcp|vdd|vddr|vip|vss|z
+ sg13_lv_nmos L=0.13u W=0.74u AS=0.15055p AD=0.2516p PS=1.17u PD=2.16u rfmode=0
M$1078 \$73658 \$73921 \$74099
+ BOTTOM|TOP|VGND|VSS|anode|cathode|core|h_sw[0]|h_sw[10]|h_sw[1]|h_sw[2]|h_sw[3]|h_sw[4]|h_sw[5]|h_sw[6]|h_sw[7]|h_sw[8]|h_sw[9]|l_sw[0]|l_sw[10]|l_sw[1]|l_sw[2]|l_sw[3]|l_sw[4]|l_sw[5]|l_sw[6]|l_sw[7]|l_sw[8]|l_sw[9]|out|pad|padres|vc|vcp|vdd|vddr|vip|vss|z
+ sg13_lv_nmos L=0.13u W=0.42u AS=0.141p AD=0.04725p PS=1.17u PD=0.645u rfmode=0
M$1079 \$74099 \$73628
+ BOTTOM|TOP|VGND|VSS|anode|cathode|core|h_sw[0]|h_sw[10]|h_sw[1]|h_sw[2]|h_sw[3]|h_sw[4]|h_sw[5]|h_sw[6]|h_sw[7]|h_sw[8]|h_sw[9]|l_sw[0]|l_sw[10]|l_sw[1]|l_sw[2]|l_sw[3]|l_sw[4]|l_sw[5]|l_sw[6]|l_sw[7]|l_sw[8]|l_sw[9]|out|pad|padres|vc|vcp|vdd|vddr|vip|vss|z
+ BOTTOM|TOP|VGND|VSS|anode|cathode|core|h_sw[0]|h_sw[10]|h_sw[1]|h_sw[2]|h_sw[3]|h_sw[4]|h_sw[5]|h_sw[6]|h_sw[7]|h_sw[8]|h_sw[9]|l_sw[0]|l_sw[10]|l_sw[1]|l_sw[2]|l_sw[3]|l_sw[4]|l_sw[5]|l_sw[6]|l_sw[7]|l_sw[8]|l_sw[9]|out|pad|padres|vc|vcp|vdd|vddr|vip|vss|z
+ sg13_lv_nmos L=0.13u W=0.42u AS=0.04725p AD=0.1428p PS=0.645u PD=1.52u
+ rfmode=0
M$1080 \$73922 \$73921
+ BOTTOM|TOP|VGND|VSS|anode|cathode|core|h_sw[0]|h_sw[10]|h_sw[1]|h_sw[2]|h_sw[3]|h_sw[4]|h_sw[5]|h_sw[6]|h_sw[7]|h_sw[8]|h_sw[9]|l_sw[0]|l_sw[10]|l_sw[1]|l_sw[2]|l_sw[3]|l_sw[4]|l_sw[5]|l_sw[6]|l_sw[7]|l_sw[8]|l_sw[9]|out|pad|padres|vc|vcp|vdd|vddr|vip|vss|z
+ BOTTOM|TOP|VGND|VSS|anode|cathode|core|h_sw[0]|h_sw[10]|h_sw[1]|h_sw[2]|h_sw[3]|h_sw[4]|h_sw[5]|h_sw[6]|h_sw[7]|h_sw[8]|h_sw[9]|l_sw[0]|l_sw[10]|l_sw[1]|l_sw[2]|l_sw[3]|l_sw[4]|l_sw[5]|l_sw[6]|l_sw[7]|l_sw[8]|l_sw[9]|out|pad|padres|vc|vcp|vdd|vddr|vip|vss|z
+ sg13_lv_nmos L=0.13u W=0.74u AS=0.2775p AD=0.213425p PS=2.23u PD=1.62u
+ rfmode=0
M$1081
+ BOTTOM|TOP|VGND|VSS|anode|cathode|core|h_sw[0]|h_sw[10]|h_sw[1]|h_sw[2]|h_sw[3]|h_sw[4]|h_sw[5]|h_sw[6]|h_sw[7]|h_sw[8]|h_sw[9]|l_sw[0]|l_sw[10]|l_sw[1]|l_sw[2]|l_sw[3]|l_sw[4]|l_sw[5]|l_sw[6]|l_sw[7]|l_sw[8]|l_sw[9]|out|pad|padres|vc|vcp|vdd|vddr|vip|vss|z
+ \$73657 \$74100
+ BOTTOM|TOP|VGND|VSS|anode|cathode|core|h_sw[0]|h_sw[10]|h_sw[1]|h_sw[2]|h_sw[3]|h_sw[4]|h_sw[5]|h_sw[6]|h_sw[7]|h_sw[8]|h_sw[9]|l_sw[0]|l_sw[10]|l_sw[1]|l_sw[2]|l_sw[3]|l_sw[4]|l_sw[5]|l_sw[6]|l_sw[7]|l_sw[8]|l_sw[9]|out|pad|padres|vc|vcp|vdd|vddr|vip|vss|z
+ sg13_lv_nmos L=0.13u W=0.64u AS=0.213425p AD=0.072p PS=1.62u PD=0.865u
+ rfmode=0
M$1082 \$74100 \$73922 \$73658
+ BOTTOM|TOP|VGND|VSS|anode|cathode|core|h_sw[0]|h_sw[10]|h_sw[1]|h_sw[2]|h_sw[3]|h_sw[4]|h_sw[5]|h_sw[6]|h_sw[7]|h_sw[8]|h_sw[9]|l_sw[0]|l_sw[10]|l_sw[1]|l_sw[2]|l_sw[3]|l_sw[4]|l_sw[5]|l_sw[6]|l_sw[7]|l_sw[8]|l_sw[9]|out|pad|padres|vc|vcp|vdd|vddr|vip|vss|z
+ sg13_lv_nmos L=0.13u W=0.64u AS=0.072p AD=0.141p PS=0.865u PD=1.17u rfmode=0
M$1083 \$73631 \$73923 \$73660
+ BOTTOM|TOP|VGND|VSS|anode|cathode|core|h_sw[0]|h_sw[10]|h_sw[1]|h_sw[2]|h_sw[3]|h_sw[4]|h_sw[5]|h_sw[6]|h_sw[7]|h_sw[8]|h_sw[9]|l_sw[0]|l_sw[10]|l_sw[1]|l_sw[2]|l_sw[3]|l_sw[4]|l_sw[5]|l_sw[6]|l_sw[7]|l_sw[8]|l_sw[9]|out|pad|padres|vc|vcp|vdd|vddr|vip|vss|z
+ sg13_lv_nmos L=0.13u W=0.42u AS=0.1296p AD=0.0798p PS=1.52u PD=0.8u rfmode=0
M$1084 \$73660 \$73661 \$73980
+ BOTTOM|TOP|VGND|VSS|anode|cathode|core|h_sw[0]|h_sw[10]|h_sw[1]|h_sw[2]|h_sw[3]|h_sw[4]|h_sw[5]|h_sw[6]|h_sw[7]|h_sw[8]|h_sw[9]|l_sw[0]|l_sw[10]|l_sw[1]|l_sw[2]|l_sw[3]|l_sw[4]|l_sw[5]|l_sw[6]|l_sw[7]|l_sw[8]|l_sw[9]|out|pad|padres|vc|vcp|vdd|vddr|vip|vss|z
+ sg13_lv_nmos L=0.13u W=0.42u AS=0.0798p AD=0.2373p PS=0.8u PD=1.97u rfmode=0
M$1085 \$73661 \$73923
+ BOTTOM|TOP|VGND|VSS|anode|cathode|core|h_sw[0]|h_sw[10]|h_sw[1]|h_sw[2]|h_sw[3]|h_sw[4]|h_sw[5]|h_sw[6]|h_sw[7]|h_sw[8]|h_sw[9]|l_sw[0]|l_sw[10]|l_sw[1]|l_sw[2]|l_sw[3]|l_sw[4]|l_sw[5]|l_sw[6]|l_sw[7]|l_sw[8]|l_sw[9]|out|pad|padres|vc|vcp|vdd|vddr|vip|vss|z
+ BOTTOM|TOP|VGND|VSS|anode|cathode|core|h_sw[0]|h_sw[10]|h_sw[1]|h_sw[2]|h_sw[3]|h_sw[4]|h_sw[5]|h_sw[6]|h_sw[7]|h_sw[8]|h_sw[9]|l_sw[0]|l_sw[10]|l_sw[1]|l_sw[2]|l_sw[3]|l_sw[4]|l_sw[5]|l_sw[6]|l_sw[7]|l_sw[8]|l_sw[9]|out|pad|padres|vc|vcp|vdd|vddr|vip|vss|z
+ sg13_lv_nmos L=0.13u W=0.74u AS=0.2516p AD=0.317325p PS=2.16u PD=1.805u
+ rfmode=0
M$1086
+ BOTTOM|TOP|VGND|VSS|anode|cathode|core|h_sw[0]|h_sw[10]|h_sw[1]|h_sw[2]|h_sw[3]|h_sw[4]|h_sw[5]|h_sw[6]|h_sw[7]|h_sw[8]|h_sw[9]|l_sw[0]|l_sw[10]|l_sw[1]|l_sw[2]|l_sw[3]|l_sw[4]|l_sw[5]|l_sw[6]|l_sw[7]|l_sw[8]|l_sw[9]|out|pad|padres|vc|vcp|vdd|vddr|vip|vss|z
+ A|CLK|X$1 \$73923
+ BOTTOM|TOP|VGND|VSS|anode|cathode|core|h_sw[0]|h_sw[10]|h_sw[1]|h_sw[2]|h_sw[3]|h_sw[4]|h_sw[5]|h_sw[6]|h_sw[7]|h_sw[8]|h_sw[9]|l_sw[0]|l_sw[10]|l_sw[1]|l_sw[2]|l_sw[3]|l_sw[4]|l_sw[5]|l_sw[6]|l_sw[7]|l_sw[8]|l_sw[9]|out|pad|padres|vc|vcp|vdd|vddr|vip|vss|z
+ sg13_lv_nmos L=0.13u W=0.74u AS=0.317325p AD=0.2516p PS=1.805u PD=2.16u
+ rfmode=0
M$1087 \$73981 \$73923 \$73924
+ BOTTOM|TOP|VGND|VSS|anode|cathode|core|h_sw[0]|h_sw[10]|h_sw[1]|h_sw[2]|h_sw[3]|h_sw[4]|h_sw[5]|h_sw[6]|h_sw[7]|h_sw[8]|h_sw[9]|l_sw[0]|l_sw[10]|l_sw[1]|l_sw[2]|l_sw[3]|l_sw[4]|l_sw[5]|l_sw[6]|l_sw[7]|l_sw[8]|l_sw[9]|out|pad|padres|vc|vcp|vdd|vddr|vip|vss|z
+ sg13_lv_nmos L=0.13u W=0.42u AS=0.1428p AD=0.12665p PS=1.52u PD=1.145u
+ rfmode=0
M$1088 \$73924 \$73661 \$73659
+ BOTTOM|TOP|VGND|VSS|anode|cathode|core|h_sw[0]|h_sw[10]|h_sw[1]|h_sw[2]|h_sw[3]|h_sw[4]|h_sw[5]|h_sw[6]|h_sw[7]|h_sw[8]|h_sw[9]|l_sw[0]|l_sw[10]|l_sw[1]|l_sw[2]|l_sw[3]|l_sw[4]|l_sw[5]|l_sw[6]|l_sw[7]|l_sw[8]|l_sw[9]|out|pad|padres|vc|vcp|vdd|vddr|vip|vss|z
+ sg13_lv_nmos L=0.13u W=0.74u AS=0.12665p AD=0.3473p PS=1.145u PD=2.71u
+ rfmode=0
M$1089
+ BOTTOM|TOP|VGND|VSS|anode|cathode|core|h_sw[0]|h_sw[10]|h_sw[1]|h_sw[2]|h_sw[3]|h_sw[4]|h_sw[5]|h_sw[6]|h_sw[7]|h_sw[8]|h_sw[9]|l_sw[0]|l_sw[10]|l_sw[1]|l_sw[2]|l_sw[3]|l_sw[4]|l_sw[5]|l_sw[6]|l_sw[7]|l_sw[8]|l_sw[9]|out|pad|padres|vc|vcp|vdd|vddr|vip|vss|z
+ \$73924 Q_N$30
+ BOTTOM|TOP|VGND|VSS|anode|cathode|core|h_sw[0]|h_sw[10]|h_sw[1]|h_sw[2]|h_sw[3]|h_sw[4]|h_sw[5]|h_sw[6]|h_sw[7]|h_sw[8]|h_sw[9]|l_sw[0]|l_sw[10]|l_sw[1]|l_sw[2]|l_sw[3]|l_sw[4]|l_sw[5]|l_sw[6]|l_sw[7]|l_sw[8]|l_sw[9]|out|pad|padres|vc|vcp|vdd|vddr|vip|vss|z
+ sg13_lv_nmos L=0.13u W=0.74u AS=0.2516p AD=0.2849p PS=2.16u PD=2.25u rfmode=0
M$1090 \$73633 \$73924
+ BOTTOM|TOP|VGND|VSS|anode|cathode|core|h_sw[0]|h_sw[10]|h_sw[1]|h_sw[2]|h_sw[3]|h_sw[4]|h_sw[5]|h_sw[6]|h_sw[7]|h_sw[8]|h_sw[9]|l_sw[0]|l_sw[10]|l_sw[1]|l_sw[2]|l_sw[3]|l_sw[4]|l_sw[5]|l_sw[6]|l_sw[7]|l_sw[8]|l_sw[9]|out|pad|padres|vc|vcp|vdd|vddr|vip|vss|z
+ BOTTOM|TOP|VGND|VSS|anode|cathode|core|h_sw[0]|h_sw[10]|h_sw[1]|h_sw[2]|h_sw[3]|h_sw[4]|h_sw[5]|h_sw[6]|h_sw[7]|h_sw[8]|h_sw[9]|l_sw[0]|l_sw[10]|l_sw[1]|l_sw[2]|l_sw[3]|l_sw[4]|l_sw[5]|l_sw[6]|l_sw[7]|l_sw[8]|l_sw[9]|out|pad|padres|vc|vcp|vdd|vddr|vip|vss|z
+ sg13_lv_nmos L=0.13u W=0.74u AS=0.2516p AD=0.1406p PS=2.16u PD=1.12u rfmode=0
M$1091
+ BOTTOM|TOP|VGND|VSS|anode|cathode|core|h_sw[0]|h_sw[10]|h_sw[1]|h_sw[2]|h_sw[3]|h_sw[4]|h_sw[5]|h_sw[6]|h_sw[7]|h_sw[8]|h_sw[9]|l_sw[0]|l_sw[10]|l_sw[1]|l_sw[2]|l_sw[3]|l_sw[4]|l_sw[5]|l_sw[6]|l_sw[7]|l_sw[8]|l_sw[9]|out|pad|padres|vc|vcp|vdd|vddr|vip|vss|z
+ \$73633 CLK|D|GATE|Q$4
+ BOTTOM|TOP|VGND|VSS|anode|cathode|core|h_sw[0]|h_sw[10]|h_sw[1]|h_sw[2]|h_sw[3]|h_sw[4]|h_sw[5]|h_sw[6]|h_sw[7]|h_sw[8]|h_sw[9]|l_sw[0]|l_sw[10]|l_sw[1]|l_sw[2]|l_sw[3]|l_sw[4]|l_sw[5]|l_sw[6]|l_sw[7]|l_sw[8]|l_sw[9]|out|pad|padres|vc|vcp|vdd|vddr|vip|vss|z
+ sg13_lv_nmos L=0.13u W=0.74u AS=0.1406p AD=0.2516p PS=1.12u PD=2.16u rfmode=0
M$1092
+ BOTTOM|TOP|VGND|VSS|anode|cathode|core|h_sw[0]|h_sw[10]|h_sw[1]|h_sw[2]|h_sw[3]|h_sw[4]|h_sw[5]|h_sw[6]|h_sw[7]|h_sw[8]|h_sw[9]|l_sw[0]|l_sw[10]|l_sw[1]|l_sw[2]|l_sw[3]|l_sw[4]|l_sw[5]|l_sw[6]|l_sw[7]|l_sw[8]|l_sw[9]|out|pad|padres|vc|vcp|vdd|vddr|vip|vss|z
+ A|X$47 \$73635
+ BOTTOM|TOP|VGND|VSS|anode|cathode|core|h_sw[0]|h_sw[10]|h_sw[1]|h_sw[2]|h_sw[3]|h_sw[4]|h_sw[5]|h_sw[6]|h_sw[7]|h_sw[8]|h_sw[9]|l_sw[0]|l_sw[10]|l_sw[1]|l_sw[2]|l_sw[3]|l_sw[4]|l_sw[5]|l_sw[6]|l_sw[7]|l_sw[8]|l_sw[9]|out|pad|padres|vc|vcp|vdd|vddr|vip|vss|z
+ sg13_lv_nmos L=0.13u W=0.55u AS=0.14875p AD=0.187p PS=1.16u PD=1.78u rfmode=0
M$1093 X|in_h_sw[9]|ph_sw[9]|x \$73635
+ BOTTOM|TOP|VGND|VSS|anode|cathode|core|h_sw[0]|h_sw[10]|h_sw[1]|h_sw[2]|h_sw[3]|h_sw[4]|h_sw[5]|h_sw[6]|h_sw[7]|h_sw[8]|h_sw[9]|l_sw[0]|l_sw[10]|l_sw[1]|l_sw[2]|l_sw[3]|l_sw[4]|l_sw[5]|l_sw[6]|l_sw[7]|l_sw[8]|l_sw[9]|out|pad|padres|vc|vcp|vdd|vddr|vip|vss|z
+ BOTTOM|TOP|VGND|VSS|anode|cathode|core|h_sw[0]|h_sw[10]|h_sw[1]|h_sw[2]|h_sw[3]|h_sw[4]|h_sw[5]|h_sw[6]|h_sw[7]|h_sw[8]|h_sw[9]|l_sw[0]|l_sw[10]|l_sw[1]|l_sw[2]|l_sw[3]|l_sw[4]|l_sw[5]|l_sw[6]|l_sw[7]|l_sw[8]|l_sw[9]|out|pad|padres|vc|vcp|vdd|vddr|vip|vss|z
+ sg13_lv_nmos L=0.13u W=0.74u AS=0.2886p AD=0.14875p PS=2.26u PD=1.16u rfmode=0
M$1094
+ BOTTOM|TOP|VGND|VSS|anode|cathode|core|h_sw[0]|h_sw[10]|h_sw[1]|h_sw[2]|h_sw[3]|h_sw[4]|h_sw[5]|h_sw[6]|h_sw[7]|h_sw[8]|h_sw[9]|l_sw[0]|l_sw[10]|l_sw[1]|l_sw[2]|l_sw[3]|l_sw[4]|l_sw[5]|l_sw[6]|l_sw[7]|l_sw[8]|l_sw[9]|out|pad|padres|vc|vcp|vdd|vddr|vip|vss|z
+ A|X$32 A|Y$24
+ BOTTOM|TOP|VGND|VSS|anode|cathode|core|h_sw[0]|h_sw[10]|h_sw[1]|h_sw[2]|h_sw[3]|h_sw[4]|h_sw[5]|h_sw[6]|h_sw[7]|h_sw[8]|h_sw[9]|l_sw[0]|l_sw[10]|l_sw[1]|l_sw[2]|l_sw[3]|l_sw[4]|l_sw[5]|l_sw[6]|l_sw[7]|l_sw[8]|l_sw[9]|out|pad|padres|vc|vcp|vdd|vddr|vip|vss|z
+ sg13_lv_nmos L=0.13u W=0.74u AS=0.2516p AD=0.2516p PS=2.16u PD=2.16u rfmode=0
M$1095 \$73637 A|Q$13
+ BOTTOM|TOP|VGND|VSS|anode|cathode|core|h_sw[0]|h_sw[10]|h_sw[1]|h_sw[2]|h_sw[3]|h_sw[4]|h_sw[5]|h_sw[6]|h_sw[7]|h_sw[8]|h_sw[9]|l_sw[0]|l_sw[10]|l_sw[1]|l_sw[2]|l_sw[3]|l_sw[4]|l_sw[5]|l_sw[6]|l_sw[7]|l_sw[8]|l_sw[9]|out|pad|padres|vc|vcp|vdd|vddr|vip|vss|z
+ BOTTOM|TOP|VGND|VSS|anode|cathode|core|h_sw[0]|h_sw[10]|h_sw[1]|h_sw[2]|h_sw[3]|h_sw[4]|h_sw[5]|h_sw[6]|h_sw[7]|h_sw[8]|h_sw[9]|l_sw[0]|l_sw[10]|l_sw[1]|l_sw[2]|l_sw[3]|l_sw[4]|l_sw[5]|l_sw[6]|l_sw[7]|l_sw[8]|l_sw[9]|out|pad|padres|vc|vcp|vdd|vddr|vip|vss|z
+ sg13_lv_nmos L=0.13u W=0.55u AS=0.187p AD=0.14875p PS=1.78u PD=1.16u rfmode=0
M$1096
+ BOTTOM|TOP|VGND|VSS|anode|cathode|core|h_sw[0]|h_sw[10]|h_sw[1]|h_sw[2]|h_sw[3]|h_sw[4]|h_sw[5]|h_sw[6]|h_sw[7]|h_sw[8]|h_sw[9]|l_sw[0]|l_sw[10]|l_sw[1]|l_sw[2]|l_sw[3]|l_sw[4]|l_sw[5]|l_sw[6]|l_sw[7]|l_sw[8]|l_sw[9]|out|pad|padres|vc|vcp|vdd|vddr|vip|vss|z
+ \$73637 A|X$28
+ BOTTOM|TOP|VGND|VSS|anode|cathode|core|h_sw[0]|h_sw[10]|h_sw[1]|h_sw[2]|h_sw[3]|h_sw[4]|h_sw[5]|h_sw[6]|h_sw[7]|h_sw[8]|h_sw[9]|l_sw[0]|l_sw[10]|l_sw[1]|l_sw[2]|l_sw[3]|l_sw[4]|l_sw[5]|l_sw[6]|l_sw[7]|l_sw[8]|l_sw[9]|out|pad|padres|vc|vcp|vdd|vddr|vip|vss|z
+ sg13_lv_nmos L=0.13u W=0.74u AS=0.14875p AD=0.2886p PS=1.16u PD=2.26u rfmode=0
M$1097 \$73638 A|X$48
+ BOTTOM|TOP|VGND|VSS|anode|cathode|core|h_sw[0]|h_sw[10]|h_sw[1]|h_sw[2]|h_sw[3]|h_sw[4]|h_sw[5]|h_sw[6]|h_sw[7]|h_sw[8]|h_sw[9]|l_sw[0]|l_sw[10]|l_sw[1]|l_sw[2]|l_sw[3]|l_sw[4]|l_sw[5]|l_sw[6]|l_sw[7]|l_sw[8]|l_sw[9]|out|pad|padres|vc|vcp|vdd|vddr|vip|vss|z
+ BOTTOM|TOP|VGND|VSS|anode|cathode|core|h_sw[0]|h_sw[10]|h_sw[1]|h_sw[2]|h_sw[3]|h_sw[4]|h_sw[5]|h_sw[6]|h_sw[7]|h_sw[8]|h_sw[9]|l_sw[0]|l_sw[10]|l_sw[1]|l_sw[2]|l_sw[3]|l_sw[4]|l_sw[5]|l_sw[6]|l_sw[7]|l_sw[8]|l_sw[9]|out|pad|padres|vc|vcp|vdd|vddr|vip|vss|z
+ sg13_lv_nmos L=0.13u W=0.55u AS=0.187p AD=0.14875p PS=1.78u PD=1.16u rfmode=0
M$1098
+ BOTTOM|TOP|VGND|VSS|anode|cathode|core|h_sw[0]|h_sw[10]|h_sw[1]|h_sw[2]|h_sw[3]|h_sw[4]|h_sw[5]|h_sw[6]|h_sw[7]|h_sw[8]|h_sw[9]|l_sw[0]|l_sw[10]|l_sw[1]|l_sw[2]|l_sw[3]|l_sw[4]|l_sw[5]|l_sw[6]|l_sw[7]|l_sw[8]|l_sw[9]|out|pad|padres|vc|vcp|vdd|vddr|vip|vss|z
+ \$73638 X|in_h_sw[10]|ph_sw[10]|x
+ BOTTOM|TOP|VGND|VSS|anode|cathode|core|h_sw[0]|h_sw[10]|h_sw[1]|h_sw[2]|h_sw[3]|h_sw[4]|h_sw[5]|h_sw[6]|h_sw[7]|h_sw[8]|h_sw[9]|l_sw[0]|l_sw[10]|l_sw[1]|l_sw[2]|l_sw[3]|l_sw[4]|l_sw[5]|l_sw[6]|l_sw[7]|l_sw[8]|l_sw[9]|out|pad|padres|vc|vcp|vdd|vddr|vip|vss|z
+ sg13_lv_nmos L=0.13u W=0.74u AS=0.14875p AD=0.2886p PS=1.16u PD=2.26u rfmode=0
M$1099 \$73611 \$73650 \$74087
+ BOTTOM|TOP|VGND|VSS|anode|cathode|core|h_sw[0]|h_sw[10]|h_sw[1]|h_sw[2]|h_sw[3]|h_sw[4]|h_sw[5]|h_sw[6]|h_sw[7]|h_sw[8]|h_sw[9]|l_sw[0]|l_sw[10]|l_sw[1]|l_sw[2]|l_sw[3]|l_sw[4]|l_sw[5]|l_sw[6]|l_sw[7]|l_sw[8]|l_sw[9]|out|pad|padres|vc|vcp|vdd|vddr|vip|vss|z
+ sg13_lv_nmos L=0.13u W=0.74u AS=0.2516p AD=0.0777p PS=2.16u PD=0.95u rfmode=0
M$1100 \$74087 RESET_B|Y$1
+ BOTTOM|TOP|VGND|VSS|anode|cathode|core|h_sw[0]|h_sw[10]|h_sw[1]|h_sw[2]|h_sw[3]|h_sw[4]|h_sw[5]|h_sw[6]|h_sw[7]|h_sw[8]|h_sw[9]|l_sw[0]|l_sw[10]|l_sw[1]|l_sw[2]|l_sw[3]|l_sw[4]|l_sw[5]|l_sw[6]|l_sw[7]|l_sw[8]|l_sw[9]|out|pad|padres|vc|vcp|vdd|vddr|vip|vss|z
+ BOTTOM|TOP|VGND|VSS|anode|cathode|core|h_sw[0]|h_sw[10]|h_sw[1]|h_sw[2]|h_sw[3]|h_sw[4]|h_sw[5]|h_sw[6]|h_sw[7]|h_sw[8]|h_sw[9]|l_sw[0]|l_sw[10]|l_sw[1]|l_sw[2]|l_sw[3]|l_sw[4]|l_sw[5]|l_sw[6]|l_sw[7]|l_sw[8]|l_sw[9]|out|pad|padres|vc|vcp|vdd|vddr|vip|vss|z
+ sg13_lv_nmos L=0.13u W=0.74u AS=0.0777p AD=0.1406p PS=0.95u PD=1.12u rfmode=0
M$1101
+ BOTTOM|TOP|VGND|VSS|anode|cathode|core|h_sw[0]|h_sw[10]|h_sw[1]|h_sw[2]|h_sw[3]|h_sw[4]|h_sw[5]|h_sw[6]|h_sw[7]|h_sw[8]|h_sw[9]|l_sw[0]|l_sw[10]|l_sw[1]|l_sw[2]|l_sw[3]|l_sw[4]|l_sw[5]|l_sw[6]|l_sw[7]|l_sw[8]|l_sw[9]|out|pad|padres|vc|vcp|vdd|vddr|vip|vss|z
+ \$73611 A|Q$15
+ BOTTOM|TOP|VGND|VSS|anode|cathode|core|h_sw[0]|h_sw[10]|h_sw[1]|h_sw[2]|h_sw[3]|h_sw[4]|h_sw[5]|h_sw[6]|h_sw[7]|h_sw[8]|h_sw[9]|l_sw[0]|l_sw[10]|l_sw[1]|l_sw[2]|l_sw[3]|l_sw[4]|l_sw[5]|l_sw[6]|l_sw[7]|l_sw[8]|l_sw[9]|out|pad|padres|vc|vcp|vdd|vddr|vip|vss|z
+ sg13_lv_nmos L=0.13u W=0.74u AS=0.1406p AD=0.2516p PS=1.12u PD=2.16u rfmode=0
M$1102
+ BOTTOM|TOP|VGND|VSS|anode|cathode|core|h_sw[0]|h_sw[10]|h_sw[1]|h_sw[2]|h_sw[3]|h_sw[4]|h_sw[5]|h_sw[6]|h_sw[7]|h_sw[8]|h_sw[9]|l_sw[0]|l_sw[10]|l_sw[1]|l_sw[2]|l_sw[3]|l_sw[4]|l_sw[5]|l_sw[6]|l_sw[7]|l_sw[8]|l_sw[9]|out|pad|padres|vc|vcp|vdd|vddr|vip|vss|z
+ \$73611 \$73612
+ BOTTOM|TOP|VGND|VSS|anode|cathode|core|h_sw[0]|h_sw[10]|h_sw[1]|h_sw[2]|h_sw[3]|h_sw[4]|h_sw[5]|h_sw[6]|h_sw[7]|h_sw[8]|h_sw[9]|l_sw[0]|l_sw[10]|l_sw[1]|l_sw[2]|l_sw[3]|l_sw[4]|l_sw[5]|l_sw[6]|l_sw[7]|l_sw[8]|l_sw[9]|out|pad|padres|vc|vcp|vdd|vddr|vip|vss|z
+ sg13_lv_nmos L=0.13u W=0.55u AS=0.1491p AD=0.187p PS=1.18u PD=1.78u rfmode=0
M$1103
+ BOTTOM|TOP|VGND|VSS|anode|cathode|core|h_sw[0]|h_sw[10]|h_sw[1]|h_sw[2]|h_sw[3]|h_sw[4]|h_sw[5]|h_sw[6]|h_sw[7]|h_sw[8]|h_sw[9]|l_sw[0]|l_sw[10]|l_sw[1]|l_sw[2]|l_sw[3]|l_sw[4]|l_sw[5]|l_sw[6]|l_sw[7]|l_sw[8]|l_sw[9]|out|pad|padres|vc|vcp|vdd|vddr|vip|vss|z
+ \$73612 Q_N$25
+ BOTTOM|TOP|VGND|VSS|anode|cathode|core|h_sw[0]|h_sw[10]|h_sw[1]|h_sw[2]|h_sw[3]|h_sw[4]|h_sw[5]|h_sw[6]|h_sw[7]|h_sw[8]|h_sw[9]|l_sw[0]|l_sw[10]|l_sw[1]|l_sw[2]|l_sw[3]|l_sw[4]|l_sw[5]|l_sw[6]|l_sw[7]|l_sw[8]|l_sw[9]|out|pad|padres|vc|vcp|vdd|vddr|vip|vss|z
+ sg13_lv_nmos L=0.13u W=0.74u AS=0.1491p AD=0.2516p PS=1.18u PD=2.16u rfmode=0
M$1104 \$73614 \$73652 \$74089
+ BOTTOM|TOP|VGND|VSS|anode|cathode|core|h_sw[0]|h_sw[10]|h_sw[1]|h_sw[2]|h_sw[3]|h_sw[4]|h_sw[5]|h_sw[6]|h_sw[7]|h_sw[8]|h_sw[9]|l_sw[0]|l_sw[10]|l_sw[1]|l_sw[2]|l_sw[3]|l_sw[4]|l_sw[5]|l_sw[6]|l_sw[7]|l_sw[8]|l_sw[9]|out|pad|padres|vc|vcp|vdd|vddr|vip|vss|z
+ sg13_lv_nmos L=0.13u W=0.74u AS=0.2516p AD=0.0777p PS=2.16u PD=0.95u rfmode=0
M$1105 \$74089 RESET_B|Y$1
+ BOTTOM|TOP|VGND|VSS|anode|cathode|core|h_sw[0]|h_sw[10]|h_sw[1]|h_sw[2]|h_sw[3]|h_sw[4]|h_sw[5]|h_sw[6]|h_sw[7]|h_sw[8]|h_sw[9]|l_sw[0]|l_sw[10]|l_sw[1]|l_sw[2]|l_sw[3]|l_sw[4]|l_sw[5]|l_sw[6]|l_sw[7]|l_sw[8]|l_sw[9]|out|pad|padres|vc|vcp|vdd|vddr|vip|vss|z
+ BOTTOM|TOP|VGND|VSS|anode|cathode|core|h_sw[0]|h_sw[10]|h_sw[1]|h_sw[2]|h_sw[3]|h_sw[4]|h_sw[5]|h_sw[6]|h_sw[7]|h_sw[8]|h_sw[9]|l_sw[0]|l_sw[10]|l_sw[1]|l_sw[2]|l_sw[3]|l_sw[4]|l_sw[5]|l_sw[6]|l_sw[7]|l_sw[8]|l_sw[9]|out|pad|padres|vc|vcp|vdd|vddr|vip|vss|z
+ sg13_lv_nmos L=0.13u W=0.74u AS=0.0777p AD=0.1406p PS=0.95u PD=1.12u rfmode=0
M$1106
+ BOTTOM|TOP|VGND|VSS|anode|cathode|core|h_sw[0]|h_sw[10]|h_sw[1]|h_sw[2]|h_sw[3]|h_sw[4]|h_sw[5]|h_sw[6]|h_sw[7]|h_sw[8]|h_sw[9]|l_sw[0]|l_sw[10]|l_sw[1]|l_sw[2]|l_sw[3]|l_sw[4]|l_sw[5]|l_sw[6]|l_sw[7]|l_sw[8]|l_sw[9]|out|pad|padres|vc|vcp|vdd|vddr|vip|vss|z
+ \$73614 A|Q$16
+ BOTTOM|TOP|VGND|VSS|anode|cathode|core|h_sw[0]|h_sw[10]|h_sw[1]|h_sw[2]|h_sw[3]|h_sw[4]|h_sw[5]|h_sw[6]|h_sw[7]|h_sw[8]|h_sw[9]|l_sw[0]|l_sw[10]|l_sw[1]|l_sw[2]|l_sw[3]|l_sw[4]|l_sw[5]|l_sw[6]|l_sw[7]|l_sw[8]|l_sw[9]|out|pad|padres|vc|vcp|vdd|vddr|vip|vss|z
+ sg13_lv_nmos L=0.13u W=0.74u AS=0.1406p AD=0.2516p PS=1.12u PD=2.16u rfmode=0
M$1107
+ BOTTOM|TOP|VGND|VSS|anode|cathode|core|h_sw[0]|h_sw[10]|h_sw[1]|h_sw[2]|h_sw[3]|h_sw[4]|h_sw[5]|h_sw[6]|h_sw[7]|h_sw[8]|h_sw[9]|l_sw[0]|l_sw[10]|l_sw[1]|l_sw[2]|l_sw[3]|l_sw[4]|l_sw[5]|l_sw[6]|l_sw[7]|l_sw[8]|l_sw[9]|out|pad|padres|vc|vcp|vdd|vddr|vip|vss|z
+ \$73614 \$73615
+ BOTTOM|TOP|VGND|VSS|anode|cathode|core|h_sw[0]|h_sw[10]|h_sw[1]|h_sw[2]|h_sw[3]|h_sw[4]|h_sw[5]|h_sw[6]|h_sw[7]|h_sw[8]|h_sw[9]|l_sw[0]|l_sw[10]|l_sw[1]|l_sw[2]|l_sw[3]|l_sw[4]|l_sw[5]|l_sw[6]|l_sw[7]|l_sw[8]|l_sw[9]|out|pad|padres|vc|vcp|vdd|vddr|vip|vss|z
+ sg13_lv_nmos L=0.13u W=0.55u AS=0.1491p AD=0.187p PS=1.18u PD=1.78u rfmode=0
M$1108
+ BOTTOM|TOP|VGND|VSS|anode|cathode|core|h_sw[0]|h_sw[10]|h_sw[1]|h_sw[2]|h_sw[3]|h_sw[4]|h_sw[5]|h_sw[6]|h_sw[7]|h_sw[8]|h_sw[9]|l_sw[0]|l_sw[10]|l_sw[1]|l_sw[2]|l_sw[3]|l_sw[4]|l_sw[5]|l_sw[6]|l_sw[7]|l_sw[8]|l_sw[9]|out|pad|padres|vc|vcp|vdd|vddr|vip|vss|z
+ \$73615 Q_N$26
+ BOTTOM|TOP|VGND|VSS|anode|cathode|core|h_sw[0]|h_sw[10]|h_sw[1]|h_sw[2]|h_sw[3]|h_sw[4]|h_sw[5]|h_sw[6]|h_sw[7]|h_sw[8]|h_sw[9]|l_sw[0]|l_sw[10]|l_sw[1]|l_sw[2]|l_sw[3]|l_sw[4]|l_sw[5]|l_sw[6]|l_sw[7]|l_sw[8]|l_sw[9]|out|pad|padres|vc|vcp|vdd|vddr|vip|vss|z
+ sg13_lv_nmos L=0.13u W=0.74u AS=0.1491p AD=0.2516p PS=1.18u PD=2.16u rfmode=0
M$1109 \$73618 \$73654 \$74092
+ BOTTOM|TOP|VGND|VSS|anode|cathode|core|h_sw[0]|h_sw[10]|h_sw[1]|h_sw[2]|h_sw[3]|h_sw[4]|h_sw[5]|h_sw[6]|h_sw[7]|h_sw[8]|h_sw[9]|l_sw[0]|l_sw[10]|l_sw[1]|l_sw[2]|l_sw[3]|l_sw[4]|l_sw[5]|l_sw[6]|l_sw[7]|l_sw[8]|l_sw[9]|out|pad|padres|vc|vcp|vdd|vddr|vip|vss|z
+ sg13_lv_nmos L=0.13u W=0.74u AS=0.2516p AD=0.0777p PS=2.16u PD=0.95u rfmode=0
M$1110 \$74092 RESET_B|Y$1
+ BOTTOM|TOP|VGND|VSS|anode|cathode|core|h_sw[0]|h_sw[10]|h_sw[1]|h_sw[2]|h_sw[3]|h_sw[4]|h_sw[5]|h_sw[6]|h_sw[7]|h_sw[8]|h_sw[9]|l_sw[0]|l_sw[10]|l_sw[1]|l_sw[2]|l_sw[3]|l_sw[4]|l_sw[5]|l_sw[6]|l_sw[7]|l_sw[8]|l_sw[9]|out|pad|padres|vc|vcp|vdd|vddr|vip|vss|z
+ BOTTOM|TOP|VGND|VSS|anode|cathode|core|h_sw[0]|h_sw[10]|h_sw[1]|h_sw[2]|h_sw[3]|h_sw[4]|h_sw[5]|h_sw[6]|h_sw[7]|h_sw[8]|h_sw[9]|l_sw[0]|l_sw[10]|l_sw[1]|l_sw[2]|l_sw[3]|l_sw[4]|l_sw[5]|l_sw[6]|l_sw[7]|l_sw[8]|l_sw[9]|out|pad|padres|vc|vcp|vdd|vddr|vip|vss|z
+ sg13_lv_nmos L=0.13u W=0.74u AS=0.0777p AD=0.1406p PS=0.95u PD=1.12u rfmode=0
M$1111
+ BOTTOM|TOP|VGND|VSS|anode|cathode|core|h_sw[0]|h_sw[10]|h_sw[1]|h_sw[2]|h_sw[3]|h_sw[4]|h_sw[5]|h_sw[6]|h_sw[7]|h_sw[8]|h_sw[9]|l_sw[0]|l_sw[10]|l_sw[1]|l_sw[2]|l_sw[3]|l_sw[4]|l_sw[5]|l_sw[6]|l_sw[7]|l_sw[8]|l_sw[9]|out|pad|padres|vc|vcp|vdd|vddr|vip|vss|z
+ \$73618 A|Q$18
+ BOTTOM|TOP|VGND|VSS|anode|cathode|core|h_sw[0]|h_sw[10]|h_sw[1]|h_sw[2]|h_sw[3]|h_sw[4]|h_sw[5]|h_sw[6]|h_sw[7]|h_sw[8]|h_sw[9]|l_sw[0]|l_sw[10]|l_sw[1]|l_sw[2]|l_sw[3]|l_sw[4]|l_sw[5]|l_sw[6]|l_sw[7]|l_sw[8]|l_sw[9]|out|pad|padres|vc|vcp|vdd|vddr|vip|vss|z
+ sg13_lv_nmos L=0.13u W=0.74u AS=0.1406p AD=0.2516p PS=1.12u PD=2.16u rfmode=0
M$1112
+ BOTTOM|TOP|VGND|VSS|anode|cathode|core|h_sw[0]|h_sw[10]|h_sw[1]|h_sw[2]|h_sw[3]|h_sw[4]|h_sw[5]|h_sw[6]|h_sw[7]|h_sw[8]|h_sw[9]|l_sw[0]|l_sw[10]|l_sw[1]|l_sw[2]|l_sw[3]|l_sw[4]|l_sw[5]|l_sw[6]|l_sw[7]|l_sw[8]|l_sw[9]|out|pad|padres|vc|vcp|vdd|vddr|vip|vss|z
+ \$73618 \$73620
+ BOTTOM|TOP|VGND|VSS|anode|cathode|core|h_sw[0]|h_sw[10]|h_sw[1]|h_sw[2]|h_sw[3]|h_sw[4]|h_sw[5]|h_sw[6]|h_sw[7]|h_sw[8]|h_sw[9]|l_sw[0]|l_sw[10]|l_sw[1]|l_sw[2]|l_sw[3]|l_sw[4]|l_sw[5]|l_sw[6]|l_sw[7]|l_sw[8]|l_sw[9]|out|pad|padres|vc|vcp|vdd|vddr|vip|vss|z
+ sg13_lv_nmos L=0.13u W=0.55u AS=0.1491p AD=0.187p PS=1.18u PD=1.78u rfmode=0
M$1113
+ BOTTOM|TOP|VGND|VSS|anode|cathode|core|h_sw[0]|h_sw[10]|h_sw[1]|h_sw[2]|h_sw[3]|h_sw[4]|h_sw[5]|h_sw[6]|h_sw[7]|h_sw[8]|h_sw[9]|l_sw[0]|l_sw[10]|l_sw[1]|l_sw[2]|l_sw[3]|l_sw[4]|l_sw[5]|l_sw[6]|l_sw[7]|l_sw[8]|l_sw[9]|out|pad|padres|vc|vcp|vdd|vddr|vip|vss|z
+ \$73620 Q_N$27
+ BOTTOM|TOP|VGND|VSS|anode|cathode|core|h_sw[0]|h_sw[10]|h_sw[1]|h_sw[2]|h_sw[3]|h_sw[4]|h_sw[5]|h_sw[6]|h_sw[7]|h_sw[8]|h_sw[9]|l_sw[0]|l_sw[10]|l_sw[1]|l_sw[2]|l_sw[3]|l_sw[4]|l_sw[5]|l_sw[6]|l_sw[7]|l_sw[8]|l_sw[9]|out|pad|padres|vc|vcp|vdd|vddr|vip|vss|z
+ sg13_lv_nmos L=0.13u W=0.74u AS=0.1491p AD=0.2516p PS=1.18u PD=2.16u rfmode=0
M$1114 \$73624 \$73656 \$74095
+ BOTTOM|TOP|VGND|VSS|anode|cathode|core|h_sw[0]|h_sw[10]|h_sw[1]|h_sw[2]|h_sw[3]|h_sw[4]|h_sw[5]|h_sw[6]|h_sw[7]|h_sw[8]|h_sw[9]|l_sw[0]|l_sw[10]|l_sw[1]|l_sw[2]|l_sw[3]|l_sw[4]|l_sw[5]|l_sw[6]|l_sw[7]|l_sw[8]|l_sw[9]|out|pad|padres|vc|vcp|vdd|vddr|vip|vss|z
+ sg13_lv_nmos L=0.13u W=0.74u AS=0.2516p AD=0.0777p PS=2.16u PD=0.95u rfmode=0
M$1115 \$74095 RESET_B|Y$1
+ BOTTOM|TOP|VGND|VSS|anode|cathode|core|h_sw[0]|h_sw[10]|h_sw[1]|h_sw[2]|h_sw[3]|h_sw[4]|h_sw[5]|h_sw[6]|h_sw[7]|h_sw[8]|h_sw[9]|l_sw[0]|l_sw[10]|l_sw[1]|l_sw[2]|l_sw[3]|l_sw[4]|l_sw[5]|l_sw[6]|l_sw[7]|l_sw[8]|l_sw[9]|out|pad|padres|vc|vcp|vdd|vddr|vip|vss|z
+ BOTTOM|TOP|VGND|VSS|anode|cathode|core|h_sw[0]|h_sw[10]|h_sw[1]|h_sw[2]|h_sw[3]|h_sw[4]|h_sw[5]|h_sw[6]|h_sw[7]|h_sw[8]|h_sw[9]|l_sw[0]|l_sw[10]|l_sw[1]|l_sw[2]|l_sw[3]|l_sw[4]|l_sw[5]|l_sw[6]|l_sw[7]|l_sw[8]|l_sw[9]|out|pad|padres|vc|vcp|vdd|vddr|vip|vss|z
+ sg13_lv_nmos L=0.13u W=0.74u AS=0.0777p AD=0.1406p PS=0.95u PD=1.12u rfmode=0
M$1116
+ BOTTOM|TOP|VGND|VSS|anode|cathode|core|h_sw[0]|h_sw[10]|h_sw[1]|h_sw[2]|h_sw[3]|h_sw[4]|h_sw[5]|h_sw[6]|h_sw[7]|h_sw[8]|h_sw[9]|l_sw[0]|l_sw[10]|l_sw[1]|l_sw[2]|l_sw[3]|l_sw[4]|l_sw[5]|l_sw[6]|l_sw[7]|l_sw[8]|l_sw[9]|out|pad|padres|vc|vcp|vdd|vddr|vip|vss|z
+ \$73624 A|Q$19
+ BOTTOM|TOP|VGND|VSS|anode|cathode|core|h_sw[0]|h_sw[10]|h_sw[1]|h_sw[2]|h_sw[3]|h_sw[4]|h_sw[5]|h_sw[6]|h_sw[7]|h_sw[8]|h_sw[9]|l_sw[0]|l_sw[10]|l_sw[1]|l_sw[2]|l_sw[3]|l_sw[4]|l_sw[5]|l_sw[6]|l_sw[7]|l_sw[8]|l_sw[9]|out|pad|padres|vc|vcp|vdd|vddr|vip|vss|z
+ sg13_lv_nmos L=0.13u W=0.74u AS=0.1406p AD=0.2516p PS=1.12u PD=2.16u rfmode=0
M$1117
+ BOTTOM|TOP|VGND|VSS|anode|cathode|core|h_sw[0]|h_sw[10]|h_sw[1]|h_sw[2]|h_sw[3]|h_sw[4]|h_sw[5]|h_sw[6]|h_sw[7]|h_sw[8]|h_sw[9]|l_sw[0]|l_sw[10]|l_sw[1]|l_sw[2]|l_sw[3]|l_sw[4]|l_sw[5]|l_sw[6]|l_sw[7]|l_sw[8]|l_sw[9]|out|pad|padres|vc|vcp|vdd|vddr|vip|vss|z
+ \$73624 \$73626
+ BOTTOM|TOP|VGND|VSS|anode|cathode|core|h_sw[0]|h_sw[10]|h_sw[1]|h_sw[2]|h_sw[3]|h_sw[4]|h_sw[5]|h_sw[6]|h_sw[7]|h_sw[8]|h_sw[9]|l_sw[0]|l_sw[10]|l_sw[1]|l_sw[2]|l_sw[3]|l_sw[4]|l_sw[5]|l_sw[6]|l_sw[7]|l_sw[8]|l_sw[9]|out|pad|padres|vc|vcp|vdd|vddr|vip|vss|z
+ sg13_lv_nmos L=0.13u W=0.55u AS=0.1491p AD=0.187p PS=1.18u PD=1.78u rfmode=0
M$1118
+ BOTTOM|TOP|VGND|VSS|anode|cathode|core|h_sw[0]|h_sw[10]|h_sw[1]|h_sw[2]|h_sw[3]|h_sw[4]|h_sw[5]|h_sw[6]|h_sw[7]|h_sw[8]|h_sw[9]|l_sw[0]|l_sw[10]|l_sw[1]|l_sw[2]|l_sw[3]|l_sw[4]|l_sw[5]|l_sw[6]|l_sw[7]|l_sw[8]|l_sw[9]|out|pad|padres|vc|vcp|vdd|vddr|vip|vss|z
+ \$73626 Q_N$28
+ BOTTOM|TOP|VGND|VSS|anode|cathode|core|h_sw[0]|h_sw[10]|h_sw[1]|h_sw[2]|h_sw[3]|h_sw[4]|h_sw[5]|h_sw[6]|h_sw[7]|h_sw[8]|h_sw[9]|l_sw[0]|l_sw[10]|l_sw[1]|l_sw[2]|l_sw[3]|l_sw[4]|l_sw[5]|l_sw[6]|l_sw[7]|l_sw[8]|l_sw[9]|out|pad|padres|vc|vcp|vdd|vddr|vip|vss|z
+ sg13_lv_nmos L=0.13u W=0.74u AS=0.1491p AD=0.2516p PS=1.18u PD=2.16u rfmode=0
M$1119 \$73628 \$73658 \$74098
+ BOTTOM|TOP|VGND|VSS|anode|cathode|core|h_sw[0]|h_sw[10]|h_sw[1]|h_sw[2]|h_sw[3]|h_sw[4]|h_sw[5]|h_sw[6]|h_sw[7]|h_sw[8]|h_sw[9]|l_sw[0]|l_sw[10]|l_sw[1]|l_sw[2]|l_sw[3]|l_sw[4]|l_sw[5]|l_sw[6]|l_sw[7]|l_sw[8]|l_sw[9]|out|pad|padres|vc|vcp|vdd|vddr|vip|vss|z
+ sg13_lv_nmos L=0.13u W=0.74u AS=0.2516p AD=0.0777p PS=2.16u PD=0.95u rfmode=0
M$1120 \$74098 RESET_B|Y$1
+ BOTTOM|TOP|VGND|VSS|anode|cathode|core|h_sw[0]|h_sw[10]|h_sw[1]|h_sw[2]|h_sw[3]|h_sw[4]|h_sw[5]|h_sw[6]|h_sw[7]|h_sw[8]|h_sw[9]|l_sw[0]|l_sw[10]|l_sw[1]|l_sw[2]|l_sw[3]|l_sw[4]|l_sw[5]|l_sw[6]|l_sw[7]|l_sw[8]|l_sw[9]|out|pad|padres|vc|vcp|vdd|vddr|vip|vss|z
+ BOTTOM|TOP|VGND|VSS|anode|cathode|core|h_sw[0]|h_sw[10]|h_sw[1]|h_sw[2]|h_sw[3]|h_sw[4]|h_sw[5]|h_sw[6]|h_sw[7]|h_sw[8]|h_sw[9]|l_sw[0]|l_sw[10]|l_sw[1]|l_sw[2]|l_sw[3]|l_sw[4]|l_sw[5]|l_sw[6]|l_sw[7]|l_sw[8]|l_sw[9]|out|pad|padres|vc|vcp|vdd|vddr|vip|vss|z
+ sg13_lv_nmos L=0.13u W=0.74u AS=0.0777p AD=0.1406p PS=0.95u PD=1.12u rfmode=0
M$1121
+ BOTTOM|TOP|VGND|VSS|anode|cathode|core|h_sw[0]|h_sw[10]|h_sw[1]|h_sw[2]|h_sw[3]|h_sw[4]|h_sw[5]|h_sw[6]|h_sw[7]|h_sw[8]|h_sw[9]|l_sw[0]|l_sw[10]|l_sw[1]|l_sw[2]|l_sw[3]|l_sw[4]|l_sw[5]|l_sw[6]|l_sw[7]|l_sw[8]|l_sw[9]|out|pad|padres|vc|vcp|vdd|vddr|vip|vss|z
+ \$73628 A|Q$17
+ BOTTOM|TOP|VGND|VSS|anode|cathode|core|h_sw[0]|h_sw[10]|h_sw[1]|h_sw[2]|h_sw[3]|h_sw[4]|h_sw[5]|h_sw[6]|h_sw[7]|h_sw[8]|h_sw[9]|l_sw[0]|l_sw[10]|l_sw[1]|l_sw[2]|l_sw[3]|l_sw[4]|l_sw[5]|l_sw[6]|l_sw[7]|l_sw[8]|l_sw[9]|out|pad|padres|vc|vcp|vdd|vddr|vip|vss|z
+ sg13_lv_nmos L=0.13u W=0.74u AS=0.1406p AD=0.2516p PS=1.12u PD=2.16u rfmode=0
M$1122
+ BOTTOM|TOP|VGND|VSS|anode|cathode|core|h_sw[0]|h_sw[10]|h_sw[1]|h_sw[2]|h_sw[3]|h_sw[4]|h_sw[5]|h_sw[6]|h_sw[7]|h_sw[8]|h_sw[9]|l_sw[0]|l_sw[10]|l_sw[1]|l_sw[2]|l_sw[3]|l_sw[4]|l_sw[5]|l_sw[6]|l_sw[7]|l_sw[8]|l_sw[9]|out|pad|padres|vc|vcp|vdd|vddr|vip|vss|z
+ \$73628 \$73629
+ BOTTOM|TOP|VGND|VSS|anode|cathode|core|h_sw[0]|h_sw[10]|h_sw[1]|h_sw[2]|h_sw[3]|h_sw[4]|h_sw[5]|h_sw[6]|h_sw[7]|h_sw[8]|h_sw[9]|l_sw[0]|l_sw[10]|l_sw[1]|l_sw[2]|l_sw[3]|l_sw[4]|l_sw[5]|l_sw[6]|l_sw[7]|l_sw[8]|l_sw[9]|out|pad|padres|vc|vcp|vdd|vddr|vip|vss|z
+ sg13_lv_nmos L=0.13u W=0.55u AS=0.1491p AD=0.187p PS=1.18u PD=1.78u rfmode=0
M$1123
+ BOTTOM|TOP|VGND|VSS|anode|cathode|core|h_sw[0]|h_sw[10]|h_sw[1]|h_sw[2]|h_sw[3]|h_sw[4]|h_sw[5]|h_sw[6]|h_sw[7]|h_sw[8]|h_sw[9]|l_sw[0]|l_sw[10]|l_sw[1]|l_sw[2]|l_sw[3]|l_sw[4]|l_sw[5]|l_sw[6]|l_sw[7]|l_sw[8]|l_sw[9]|out|pad|padres|vc|vcp|vdd|vddr|vip|vss|z
+ \$73629 Q_N$29
+ BOTTOM|TOP|VGND|VSS|anode|cathode|core|h_sw[0]|h_sw[10]|h_sw[1]|h_sw[2]|h_sw[3]|h_sw[4]|h_sw[5]|h_sw[6]|h_sw[7]|h_sw[8]|h_sw[9]|l_sw[0]|l_sw[10]|l_sw[1]|l_sw[2]|l_sw[3]|l_sw[4]|l_sw[5]|l_sw[6]|l_sw[7]|l_sw[8]|l_sw[9]|out|pad|padres|vc|vcp|vdd|vddr|vip|vss|z
+ sg13_lv_nmos L=0.13u W=0.74u AS=0.1491p AD=0.2516p PS=1.18u PD=2.16u rfmode=0
M$1124
+ BOTTOM|TOP|VGND|VSS|anode|cathode|core|h_sw[0]|h_sw[10]|h_sw[1]|h_sw[2]|h_sw[3]|h_sw[4]|h_sw[5]|h_sw[6]|h_sw[7]|h_sw[8]|h_sw[9]|l_sw[0]|l_sw[10]|l_sw[1]|l_sw[2]|l_sw[3]|l_sw[4]|l_sw[5]|l_sw[6]|l_sw[7]|l_sw[8]|l_sw[9]|out|pad|padres|vc|vcp|vdd|vddr|vip|vss|z
+ \$73647 \$73646
+ BOTTOM|TOP|VGND|VSS|anode|cathode|core|h_sw[0]|h_sw[10]|h_sw[1]|h_sw[2]|h_sw[3]|h_sw[4]|h_sw[5]|h_sw[6]|h_sw[7]|h_sw[8]|h_sw[9]|l_sw[0]|l_sw[10]|l_sw[1]|l_sw[2]|l_sw[3]|l_sw[4]|l_sw[5]|l_sw[6]|l_sw[7]|l_sw[8]|l_sw[9]|out|pad|padres|vc|vcp|vdd|vddr|vip|vss|z
+ sg13_lv_nmos L=0.13u W=0.74u AS=0.1626p AD=0.2516p PS=1.415u PD=2.16u rfmode=0
M$1125 \$73607 D|X \$74084
+ BOTTOM|TOP|VGND|VSS|anode|cathode|core|h_sw[0]|h_sw[10]|h_sw[1]|h_sw[2]|h_sw[3]|h_sw[4]|h_sw[5]|h_sw[6]|h_sw[7]|h_sw[8]|h_sw[9]|l_sw[0]|l_sw[10]|l_sw[1]|l_sw[2]|l_sw[3]|l_sw[4]|l_sw[5]|l_sw[6]|l_sw[7]|l_sw[8]|l_sw[9]|out|pad|padres|vc|vcp|vdd|vddr|vip|vss|z
+ sg13_lv_nmos L=0.13u W=0.42u AS=0.1428p AD=0.0609p PS=1.52u PD=0.71u rfmode=0
M$1126
+ BOTTOM|TOP|VGND|VSS|anode|cathode|core|h_sw[0]|h_sw[10]|h_sw[1]|h_sw[2]|h_sw[3]|h_sw[4]|h_sw[5]|h_sw[6]|h_sw[7]|h_sw[8]|h_sw[9]|l_sw[0]|l_sw[10]|l_sw[1]|l_sw[2]|l_sw[3]|l_sw[4]|l_sw[5]|l_sw[6]|l_sw[7]|l_sw[8]|l_sw[9]|out|pad|padres|vc|vcp|vdd|vddr|vip|vss|z
+ RESET_B|Y$1 \$74084
+ BOTTOM|TOP|VGND|VSS|anode|cathode|core|h_sw[0]|h_sw[10]|h_sw[1]|h_sw[2]|h_sw[3]|h_sw[4]|h_sw[5]|h_sw[6]|h_sw[7]|h_sw[8]|h_sw[9]|l_sw[0]|l_sw[10]|l_sw[1]|l_sw[2]|l_sw[3]|l_sw[4]|l_sw[5]|l_sw[6]|l_sw[7]|l_sw[8]|l_sw[9]|out|pad|padres|vc|vcp|vdd|vddr|vip|vss|z
+ sg13_lv_nmos L=0.13u W=0.42u AS=0.1626p AD=0.0609p PS=1.415u PD=0.71u rfmode=0
M$1127 X|in_l_sw[0]|pl_sw[0]|x \$74495
+ BOTTOM|TOP|VGND|VSS|anode|cathode|core|h_sw[0]|h_sw[10]|h_sw[1]|h_sw[2]|h_sw[3]|h_sw[4]|h_sw[5]|h_sw[6]|h_sw[7]|h_sw[8]|h_sw[9]|l_sw[0]|l_sw[10]|l_sw[1]|l_sw[2]|l_sw[3]|l_sw[4]|l_sw[5]|l_sw[6]|l_sw[7]|l_sw[8]|l_sw[9]|out|pad|padres|vc|vcp|vdd|vddr|vip|vss|z
+ BOTTOM|TOP|VGND|VSS|anode|cathode|core|h_sw[0]|h_sw[10]|h_sw[1]|h_sw[2]|h_sw[3]|h_sw[4]|h_sw[5]|h_sw[6]|h_sw[7]|h_sw[8]|h_sw[9]|l_sw[0]|l_sw[10]|l_sw[1]|l_sw[2]|l_sw[3]|l_sw[4]|l_sw[5]|l_sw[6]|l_sw[7]|l_sw[8]|l_sw[9]|out|pad|padres|vc|vcp|vdd|vddr|vip|vss|z
+ sg13_lv_nmos L=0.13u W=0.74u AS=0.2886p AD=0.14875p PS=2.26u PD=1.16u rfmode=0
M$1128
+ BOTTOM|TOP|VGND|VSS|anode|cathode|core|h_sw[0]|h_sw[10]|h_sw[1]|h_sw[2]|h_sw[3]|h_sw[4]|h_sw[5]|h_sw[6]|h_sw[7]|h_sw[8]|h_sw[9]|l_sw[0]|l_sw[10]|l_sw[1]|l_sw[2]|l_sw[3]|l_sw[4]|l_sw[5]|l_sw[6]|l_sw[7]|l_sw[8]|l_sw[9]|out|pad|padres|vc|vcp|vdd|vddr|vip|vss|z
+ A|X$53 \$74495
+ BOTTOM|TOP|VGND|VSS|anode|cathode|core|h_sw[0]|h_sw[10]|h_sw[1]|h_sw[2]|h_sw[3]|h_sw[4]|h_sw[5]|h_sw[6]|h_sw[7]|h_sw[8]|h_sw[9]|l_sw[0]|l_sw[10]|l_sw[1]|l_sw[2]|l_sw[3]|l_sw[4]|l_sw[5]|l_sw[6]|l_sw[7]|l_sw[8]|l_sw[9]|out|pad|padres|vc|vcp|vdd|vddr|vip|vss|z
+ sg13_lv_nmos L=0.13u W=0.55u AS=0.14875p AD=0.187p PS=1.16u PD=1.78u rfmode=0
M$1129
+ BOTTOM|TOP|VGND|VSS|anode|cathode|core|h_sw[0]|h_sw[10]|h_sw[1]|h_sw[2]|h_sw[3]|h_sw[4]|h_sw[5]|h_sw[6]|h_sw[7]|h_sw[8]|h_sw[9]|l_sw[0]|l_sw[10]|l_sw[1]|l_sw[2]|l_sw[3]|l_sw[4]|l_sw[5]|l_sw[6]|l_sw[7]|l_sw[8]|l_sw[9]|out|pad|padres|vc|vcp|vdd|vddr|vip|vss|z
+ RESET_B|Y$1 \$74083
+ BOTTOM|TOP|VGND|VSS|anode|cathode|core|h_sw[0]|h_sw[10]|h_sw[1]|h_sw[2]|h_sw[3]|h_sw[4]|h_sw[5]|h_sw[6]|h_sw[7]|h_sw[8]|h_sw[9]|l_sw[0]|l_sw[10]|l_sw[1]|l_sw[2]|l_sw[3]|l_sw[4]|l_sw[5]|l_sw[6]|l_sw[7]|l_sw[8]|l_sw[9]|out|pad|padres|vc|vcp|vdd|vddr|vip|vss|z
+ sg13_lv_nmos L=0.13u W=0.42u AS=0.1701p AD=0.0378p PS=1.65u PD=0.6u rfmode=0
M$1130 \$74083 \$73646 \$73977
+ BOTTOM|TOP|VGND|VSS|anode|cathode|core|h_sw[0]|h_sw[10]|h_sw[1]|h_sw[2]|h_sw[3]|h_sw[4]|h_sw[5]|h_sw[6]|h_sw[7]|h_sw[8]|h_sw[9]|l_sw[0]|l_sw[10]|l_sw[1]|l_sw[2]|l_sw[3]|l_sw[4]|l_sw[5]|l_sw[6]|l_sw[7]|l_sw[8]|l_sw[9]|out|pad|padres|vc|vcp|vdd|vddr|vip|vss|z
+ sg13_lv_nmos L=0.13u W=0.42u AS=0.0378p AD=0.1428p PS=0.6u PD=1.52u rfmode=0
M$1131
+ BOTTOM|TOP|VGND|VSS|anode|cathode|core|h_sw[0]|h_sw[10]|h_sw[1]|h_sw[2]|h_sw[3]|h_sw[4]|h_sw[5]|h_sw[6]|h_sw[7]|h_sw[8]|h_sw[9]|l_sw[0]|l_sw[10]|l_sw[1]|l_sw[2]|l_sw[3]|l_sw[4]|l_sw[5]|l_sw[6]|l_sw[7]|l_sw[8]|l_sw[9]|out|pad|padres|vc|vcp|vdd|vddr|vip|vss|z
+ \$74593 \$74457
+ BOTTOM|TOP|VGND|VSS|anode|cathode|core|h_sw[0]|h_sw[10]|h_sw[1]|h_sw[2]|h_sw[3]|h_sw[4]|h_sw[5]|h_sw[6]|h_sw[7]|h_sw[8]|h_sw[9]|l_sw[0]|l_sw[10]|l_sw[1]|l_sw[2]|l_sw[3]|l_sw[4]|l_sw[5]|l_sw[6]|l_sw[7]|l_sw[8]|l_sw[9]|out|pad|padres|vc|vcp|vdd|vddr|vip|vss|z
+ sg13_lv_nmos L=0.13u W=0.55u AS=0.1491p AD=0.187p PS=1.18u PD=1.78u rfmode=0
M$1132
+ BOTTOM|TOP|VGND|VSS|anode|cathode|core|h_sw[0]|h_sw[10]|h_sw[1]|h_sw[2]|h_sw[3]|h_sw[4]|h_sw[5]|h_sw[6]|h_sw[7]|h_sw[8]|h_sw[9]|l_sw[0]|l_sw[10]|l_sw[1]|l_sw[2]|l_sw[3]|l_sw[4]|l_sw[5]|l_sw[6]|l_sw[7]|l_sw[8]|l_sw[9]|out|pad|padres|vc|vcp|vdd|vddr|vip|vss|z
+ \$74457 Q_N$31
+ BOTTOM|TOP|VGND|VSS|anode|cathode|core|h_sw[0]|h_sw[10]|h_sw[1]|h_sw[2]|h_sw[3]|h_sw[4]|h_sw[5]|h_sw[6]|h_sw[7]|h_sw[8]|h_sw[9]|l_sw[0]|l_sw[10]|l_sw[1]|l_sw[2]|l_sw[3]|l_sw[4]|l_sw[5]|l_sw[6]|l_sw[7]|l_sw[8]|l_sw[9]|out|pad|padres|vc|vcp|vdd|vddr|vip|vss|z
+ sg13_lv_nmos L=0.13u W=0.74u AS=0.1491p AD=0.2516p PS=1.18u PD=2.16u rfmode=0
M$1133 A|Q$14 \$74593
+ BOTTOM|TOP|VGND|VSS|anode|cathode|core|h_sw[0]|h_sw[10]|h_sw[1]|h_sw[2]|h_sw[3]|h_sw[4]|h_sw[5]|h_sw[6]|h_sw[7]|h_sw[8]|h_sw[9]|l_sw[0]|l_sw[10]|l_sw[1]|l_sw[2]|l_sw[3]|l_sw[4]|l_sw[5]|l_sw[6]|l_sw[7]|l_sw[8]|l_sw[9]|out|pad|padres|vc|vcp|vdd|vddr|vip|vss|z
+ BOTTOM|TOP|VGND|VSS|anode|cathode|core|h_sw[0]|h_sw[10]|h_sw[1]|h_sw[2]|h_sw[3]|h_sw[4]|h_sw[5]|h_sw[6]|h_sw[7]|h_sw[8]|h_sw[9]|l_sw[0]|l_sw[10]|l_sw[1]|l_sw[2]|l_sw[3]|l_sw[4]|l_sw[5]|l_sw[6]|l_sw[7]|l_sw[8]|l_sw[9]|out|pad|padres|vc|vcp|vdd|vddr|vip|vss|z
+ sg13_lv_nmos L=0.13u W=0.74u AS=0.2516p AD=0.1406p PS=2.16u PD=1.12u rfmode=0
M$1134
+ BOTTOM|TOP|VGND|VSS|anode|cathode|core|h_sw[0]|h_sw[10]|h_sw[1]|h_sw[2]|h_sw[3]|h_sw[4]|h_sw[5]|h_sw[6]|h_sw[7]|h_sw[8]|h_sw[9]|l_sw[0]|l_sw[10]|l_sw[1]|l_sw[2]|l_sw[3]|l_sw[4]|l_sw[5]|l_sw[6]|l_sw[7]|l_sw[8]|l_sw[9]|out|pad|padres|vc|vcp|vdd|vddr|vip|vss|z
+ RESET_B|Y$1 \$74570
+ BOTTOM|TOP|VGND|VSS|anode|cathode|core|h_sw[0]|h_sw[10]|h_sw[1]|h_sw[2]|h_sw[3]|h_sw[4]|h_sw[5]|h_sw[6]|h_sw[7]|h_sw[8]|h_sw[9]|l_sw[0]|l_sw[10]|l_sw[1]|l_sw[2]|l_sw[3]|l_sw[4]|l_sw[5]|l_sw[6]|l_sw[7]|l_sw[8]|l_sw[9]|out|pad|padres|vc|vcp|vdd|vddr|vip|vss|z
+ sg13_lv_nmos L=0.13u W=0.74u AS=0.1406p AD=0.0777p PS=1.12u PD=0.95u rfmode=0
M$1135 \$74570 \$74594 \$74593
+ BOTTOM|TOP|VGND|VSS|anode|cathode|core|h_sw[0]|h_sw[10]|h_sw[1]|h_sw[2]|h_sw[3]|h_sw[4]|h_sw[5]|h_sw[6]|h_sw[7]|h_sw[8]|h_sw[9]|l_sw[0]|l_sw[10]|l_sw[1]|l_sw[2]|l_sw[3]|l_sw[4]|l_sw[5]|l_sw[6]|l_sw[7]|l_sw[8]|l_sw[9]|out|pad|padres|vc|vcp|vdd|vddr|vip|vss|z
+ sg13_lv_nmos L=0.13u W=0.74u AS=0.0777p AD=0.2516p PS=0.95u PD=2.16u rfmode=0
M$1136 \$73978 \$73908
+ BOTTOM|TOP|VGND|VSS|anode|cathode|core|h_sw[0]|h_sw[10]|h_sw[1]|h_sw[2]|h_sw[3]|h_sw[4]|h_sw[5]|h_sw[6]|h_sw[7]|h_sw[8]|h_sw[9]|l_sw[0]|l_sw[10]|l_sw[1]|l_sw[2]|l_sw[3]|l_sw[4]|l_sw[5]|l_sw[6]|l_sw[7]|l_sw[8]|l_sw[9]|out|pad|padres|vc|vcp|vdd|vddr|vip|vss|z
+ BOTTOM|TOP|VGND|VSS|anode|cathode|core|h_sw[0]|h_sw[10]|h_sw[1]|h_sw[2]|h_sw[3]|h_sw[4]|h_sw[5]|h_sw[6]|h_sw[7]|h_sw[8]|h_sw[9]|l_sw[0]|l_sw[10]|l_sw[1]|l_sw[2]|l_sw[3]|l_sw[4]|l_sw[5]|l_sw[6]|l_sw[7]|l_sw[8]|l_sw[9]|out|pad|padres|vc|vcp|vdd|vddr|vip|vss|z
+ sg13_lv_nmos L=0.13u W=0.42u AS=0.1428p AD=0.0798p PS=1.52u PD=0.8u rfmode=0
M$1137
+ BOTTOM|TOP|VGND|VSS|anode|cathode|core|h_sw[0]|h_sw[10]|h_sw[1]|h_sw[2]|h_sw[3]|h_sw[4]|h_sw[5]|h_sw[6]|h_sw[7]|h_sw[8]|h_sw[9]|l_sw[0]|l_sw[10]|l_sw[1]|l_sw[2]|l_sw[3]|l_sw[4]|l_sw[5]|l_sw[6]|l_sw[7]|l_sw[8]|l_sw[9]|out|pad|padres|vc|vcp|vdd|vddr|vip|vss|z
+ RESET_B|Y$1 \$74085
+ BOTTOM|TOP|VGND|VSS|anode|cathode|core|h_sw[0]|h_sw[10]|h_sw[1]|h_sw[2]|h_sw[3]|h_sw[4]|h_sw[5]|h_sw[6]|h_sw[7]|h_sw[8]|h_sw[9]|l_sw[0]|l_sw[10]|l_sw[1]|l_sw[2]|l_sw[3]|l_sw[4]|l_sw[5]|l_sw[6]|l_sw[7]|l_sw[8]|l_sw[9]|out|pad|padres|vc|vcp|vdd|vddr|vip|vss|z
+ sg13_lv_nmos L=0.13u W=0.42u AS=0.0798p AD=0.0378p PS=0.8u PD=0.6u rfmode=0
M$1138 \$74085 \$73907 \$73908
+ BOTTOM|TOP|VGND|VSS|anode|cathode|core|h_sw[0]|h_sw[10]|h_sw[1]|h_sw[2]|h_sw[3]|h_sw[4]|h_sw[5]|h_sw[6]|h_sw[7]|h_sw[8]|h_sw[9]|l_sw[0]|l_sw[10]|l_sw[1]|l_sw[2]|l_sw[3]|l_sw[4]|l_sw[5]|l_sw[6]|l_sw[7]|l_sw[8]|l_sw[9]|out|pad|padres|vc|vcp|vdd|vddr|vip|vss|z
+ sg13_lv_nmos L=0.13u W=0.42u AS=0.0378p AD=0.1428p PS=0.6u PD=1.52u rfmode=0
M$1139
+ BOTTOM|TOP|VGND|VSS|anode|cathode|core|h_sw[0]|h_sw[10]|h_sw[1]|h_sw[2]|h_sw[3]|h_sw[4]|h_sw[5]|h_sw[6]|h_sw[7]|h_sw[8]|h_sw[9]|l_sw[0]|l_sw[10]|l_sw[1]|l_sw[2]|l_sw[3]|l_sw[4]|l_sw[5]|l_sw[6]|l_sw[7]|l_sw[8]|l_sw[9]|out|pad|padres|vc|vcp|vdd|vddr|vip|vss|z
+ \$74593 \$74569
+ BOTTOM|TOP|VGND|VSS|anode|cathode|core|h_sw[0]|h_sw[10]|h_sw[1]|h_sw[2]|h_sw[3]|h_sw[4]|h_sw[5]|h_sw[6]|h_sw[7]|h_sw[8]|h_sw[9]|l_sw[0]|l_sw[10]|l_sw[1]|l_sw[2]|l_sw[3]|l_sw[4]|l_sw[5]|l_sw[6]|l_sw[7]|l_sw[8]|l_sw[9]|out|pad|padres|vc|vcp|vdd|vddr|vip|vss|z
+ sg13_lv_nmos L=0.13u W=0.42u AS=0.1428p AD=0.04725p PS=1.52u PD=0.645u
+ rfmode=0
M$1140 \$74594 \$74458 \$74569
+ BOTTOM|TOP|VGND|VSS|anode|cathode|core|h_sw[0]|h_sw[10]|h_sw[1]|h_sw[2]|h_sw[3]|h_sw[4]|h_sw[5]|h_sw[6]|h_sw[7]|h_sw[8]|h_sw[9]|l_sw[0]|l_sw[10]|l_sw[1]|l_sw[2]|l_sw[3]|l_sw[4]|l_sw[5]|l_sw[6]|l_sw[7]|l_sw[8]|l_sw[9]|out|pad|padres|vc|vcp|vdd|vddr|vip|vss|z
+ sg13_lv_nmos L=0.13u W=0.42u AS=0.141p AD=0.04725p PS=1.17u PD=0.645u rfmode=0
M$1141 \$74594 \$74496 \$74567
+ BOTTOM|TOP|VGND|VSS|anode|cathode|core|h_sw[0]|h_sw[10]|h_sw[1]|h_sw[2]|h_sw[3]|h_sw[4]|h_sw[5]|h_sw[6]|h_sw[7]|h_sw[8]|h_sw[9]|l_sw[0]|l_sw[10]|l_sw[1]|l_sw[2]|l_sw[3]|l_sw[4]|l_sw[5]|l_sw[6]|l_sw[7]|l_sw[8]|l_sw[9]|out|pad|padres|vc|vcp|vdd|vddr|vip|vss|z
+ sg13_lv_nmos L=0.13u W=0.64u AS=0.141p AD=0.072p PS=1.17u PD=0.865u rfmode=0
M$1142
+ BOTTOM|TOP|VGND|VSS|anode|cathode|core|h_sw[0]|h_sw[10]|h_sw[1]|h_sw[2]|h_sw[3]|h_sw[4]|h_sw[5]|h_sw[6]|h_sw[7]|h_sw[8]|h_sw[9]|l_sw[0]|l_sw[10]|l_sw[1]|l_sw[2]|l_sw[3]|l_sw[4]|l_sw[5]|l_sw[6]|l_sw[7]|l_sw[8]|l_sw[9]|out|pad|padres|vc|vcp|vdd|vddr|vip|vss|z
+ \$74600 \$74567
+ BOTTOM|TOP|VGND|VSS|anode|cathode|core|h_sw[0]|h_sw[10]|h_sw[1]|h_sw[2]|h_sw[3]|h_sw[4]|h_sw[5]|h_sw[6]|h_sw[7]|h_sw[8]|h_sw[9]|l_sw[0]|l_sw[10]|l_sw[1]|l_sw[2]|l_sw[3]|l_sw[4]|l_sw[5]|l_sw[6]|l_sw[7]|l_sw[8]|l_sw[9]|out|pad|padres|vc|vcp|vdd|vddr|vip|vss|z
+ sg13_lv_nmos L=0.13u W=0.64u AS=0.213425p AD=0.072p PS=1.62u PD=0.865u
+ rfmode=0
M$1143
+ BOTTOM|TOP|VGND|VSS|anode|cathode|core|h_sw[0]|h_sw[10]|h_sw[1]|h_sw[2]|h_sw[3]|h_sw[4]|h_sw[5]|h_sw[6]|h_sw[7]|h_sw[8]|h_sw[9]|l_sw[0]|l_sw[10]|l_sw[1]|l_sw[2]|l_sw[3]|l_sw[4]|l_sw[5]|l_sw[6]|l_sw[7]|l_sw[8]|l_sw[9]|out|pad|padres|vc|vcp|vdd|vddr|vip|vss|z
+ \$74458 \$74496
+ BOTTOM|TOP|VGND|VSS|anode|cathode|core|h_sw[0]|h_sw[10]|h_sw[1]|h_sw[2]|h_sw[3]|h_sw[4]|h_sw[5]|h_sw[6]|h_sw[7]|h_sw[8]|h_sw[9]|l_sw[0]|l_sw[10]|l_sw[1]|l_sw[2]|l_sw[3]|l_sw[4]|l_sw[5]|l_sw[6]|l_sw[7]|l_sw[8]|l_sw[9]|out|pad|padres|vc|vcp|vdd|vddr|vip|vss|z
+ sg13_lv_nmos L=0.13u W=0.74u AS=0.213425p AD=0.2775p PS=1.62u PD=2.23u
+ rfmode=0
M$1144
+ BOTTOM|TOP|VGND|VSS|anode|cathode|core|h_sw[0]|h_sw[10]|h_sw[1]|h_sw[2]|h_sw[3]|h_sw[4]|h_sw[5]|h_sw[6]|h_sw[7]|h_sw[8]|h_sw[9]|l_sw[0]|l_sw[10]|l_sw[1]|l_sw[2]|l_sw[3]|l_sw[4]|l_sw[5]|l_sw[6]|l_sw[7]|l_sw[8]|l_sw[9]|out|pad|padres|vc|vcp|vdd|vddr|vip|vss|z
+ \$74595 \$74460
+ BOTTOM|TOP|VGND|VSS|anode|cathode|core|h_sw[0]|h_sw[10]|h_sw[1]|h_sw[2]|h_sw[3]|h_sw[4]|h_sw[5]|h_sw[6]|h_sw[7]|h_sw[8]|h_sw[9]|l_sw[0]|l_sw[10]|l_sw[1]|l_sw[2]|l_sw[3]|l_sw[4]|l_sw[5]|l_sw[6]|l_sw[7]|l_sw[8]|l_sw[9]|out|pad|padres|vc|vcp|vdd|vddr|vip|vss|z
+ sg13_lv_nmos L=0.13u W=0.55u AS=0.1491p AD=0.187p PS=1.18u PD=1.78u rfmode=0
M$1145
+ BOTTOM|TOP|VGND|VSS|anode|cathode|core|h_sw[0]|h_sw[10]|h_sw[1]|h_sw[2]|h_sw[3]|h_sw[4]|h_sw[5]|h_sw[6]|h_sw[7]|h_sw[8]|h_sw[9]|l_sw[0]|l_sw[10]|l_sw[1]|l_sw[2]|l_sw[3]|l_sw[4]|l_sw[5]|l_sw[6]|l_sw[7]|l_sw[8]|l_sw[9]|out|pad|padres|vc|vcp|vdd|vddr|vip|vss|z
+ \$74460 Q_N$32
+ BOTTOM|TOP|VGND|VSS|anode|cathode|core|h_sw[0]|h_sw[10]|h_sw[1]|h_sw[2]|h_sw[3]|h_sw[4]|h_sw[5]|h_sw[6]|h_sw[7]|h_sw[8]|h_sw[9]|l_sw[0]|l_sw[10]|l_sw[1]|l_sw[2]|l_sw[3]|l_sw[4]|l_sw[5]|l_sw[6]|l_sw[7]|l_sw[8]|l_sw[9]|out|pad|padres|vc|vcp|vdd|vddr|vip|vss|z
+ sg13_lv_nmos L=0.13u W=0.74u AS=0.1491p AD=0.2516p PS=1.18u PD=2.16u rfmode=0
M$1146 A|Q$20 \$74595
+ BOTTOM|TOP|VGND|VSS|anode|cathode|core|h_sw[0]|h_sw[10]|h_sw[1]|h_sw[2]|h_sw[3]|h_sw[4]|h_sw[5]|h_sw[6]|h_sw[7]|h_sw[8]|h_sw[9]|l_sw[0]|l_sw[10]|l_sw[1]|l_sw[2]|l_sw[3]|l_sw[4]|l_sw[5]|l_sw[6]|l_sw[7]|l_sw[8]|l_sw[9]|out|pad|padres|vc|vcp|vdd|vddr|vip|vss|z
+ BOTTOM|TOP|VGND|VSS|anode|cathode|core|h_sw[0]|h_sw[10]|h_sw[1]|h_sw[2]|h_sw[3]|h_sw[4]|h_sw[5]|h_sw[6]|h_sw[7]|h_sw[8]|h_sw[9]|l_sw[0]|l_sw[10]|l_sw[1]|l_sw[2]|l_sw[3]|l_sw[4]|l_sw[5]|l_sw[6]|l_sw[7]|l_sw[8]|l_sw[9]|out|pad|padres|vc|vcp|vdd|vddr|vip|vss|z
+ sg13_lv_nmos L=0.13u W=0.74u AS=0.2516p AD=0.1406p PS=2.16u PD=1.12u rfmode=0
M$1147
+ BOTTOM|TOP|VGND|VSS|anode|cathode|core|h_sw[0]|h_sw[10]|h_sw[1]|h_sw[2]|h_sw[3]|h_sw[4]|h_sw[5]|h_sw[6]|h_sw[7]|h_sw[8]|h_sw[9]|l_sw[0]|l_sw[10]|l_sw[1]|l_sw[2]|l_sw[3]|l_sw[4]|l_sw[5]|l_sw[6]|l_sw[7]|l_sw[8]|l_sw[9]|out|pad|padres|vc|vcp|vdd|vddr|vip|vss|z
+ RESET_B|Y$1 \$74573
+ BOTTOM|TOP|VGND|VSS|anode|cathode|core|h_sw[0]|h_sw[10]|h_sw[1]|h_sw[2]|h_sw[3]|h_sw[4]|h_sw[5]|h_sw[6]|h_sw[7]|h_sw[8]|h_sw[9]|l_sw[0]|l_sw[10]|l_sw[1]|l_sw[2]|l_sw[3]|l_sw[4]|l_sw[5]|l_sw[6]|l_sw[7]|l_sw[8]|l_sw[9]|out|pad|padres|vc|vcp|vdd|vddr|vip|vss|z
+ sg13_lv_nmos L=0.13u W=0.74u AS=0.1406p AD=0.0777p PS=1.12u PD=0.95u rfmode=0
M$1148 \$74573 \$74596 \$74595
+ BOTTOM|TOP|VGND|VSS|anode|cathode|core|h_sw[0]|h_sw[10]|h_sw[1]|h_sw[2]|h_sw[3]|h_sw[4]|h_sw[5]|h_sw[6]|h_sw[7]|h_sw[8]|h_sw[9]|l_sw[0]|l_sw[10]|l_sw[1]|l_sw[2]|l_sw[3]|l_sw[4]|l_sw[5]|l_sw[6]|l_sw[7]|l_sw[8]|l_sw[9]|out|pad|padres|vc|vcp|vdd|vddr|vip|vss|z
+ sg13_lv_nmos L=0.13u W=0.74u AS=0.0777p AD=0.2516p PS=0.95u PD=2.16u rfmode=0
M$1149
+ BOTTOM|TOP|VGND|VSS|anode|cathode|core|h_sw[0]|h_sw[10]|h_sw[1]|h_sw[2]|h_sw[3]|h_sw[4]|h_sw[5]|h_sw[6]|h_sw[7]|h_sw[8]|h_sw[9]|l_sw[0]|l_sw[10]|l_sw[1]|l_sw[2]|l_sw[3]|l_sw[4]|l_sw[5]|l_sw[6]|l_sw[7]|l_sw[8]|l_sw[9]|out|pad|padres|vc|vcp|vdd|vddr|vip|vss|z
+ \$74595 \$74578
+ BOTTOM|TOP|VGND|VSS|anode|cathode|core|h_sw[0]|h_sw[10]|h_sw[1]|h_sw[2]|h_sw[3]|h_sw[4]|h_sw[5]|h_sw[6]|h_sw[7]|h_sw[8]|h_sw[9]|l_sw[0]|l_sw[10]|l_sw[1]|l_sw[2]|l_sw[3]|l_sw[4]|l_sw[5]|l_sw[6]|l_sw[7]|l_sw[8]|l_sw[9]|out|pad|padres|vc|vcp|vdd|vddr|vip|vss|z
+ sg13_lv_nmos L=0.13u W=0.42u AS=0.1428p AD=0.04725p PS=1.52u PD=0.645u
+ rfmode=0
M$1150 \$74596 \$74462 \$74578
+ BOTTOM|TOP|VGND|VSS|anode|cathode|core|h_sw[0]|h_sw[10]|h_sw[1]|h_sw[2]|h_sw[3]|h_sw[4]|h_sw[5]|h_sw[6]|h_sw[7]|h_sw[8]|h_sw[9]|l_sw[0]|l_sw[10]|l_sw[1]|l_sw[2]|l_sw[3]|l_sw[4]|l_sw[5]|l_sw[6]|l_sw[7]|l_sw[8]|l_sw[9]|out|pad|padres|vc|vcp|vdd|vddr|vip|vss|z
+ sg13_lv_nmos L=0.13u W=0.42u AS=0.141p AD=0.04725p PS=1.17u PD=0.645u rfmode=0
M$1151 \$74596 \$74497 \$74577
+ BOTTOM|TOP|VGND|VSS|anode|cathode|core|h_sw[0]|h_sw[10]|h_sw[1]|h_sw[2]|h_sw[3]|h_sw[4]|h_sw[5]|h_sw[6]|h_sw[7]|h_sw[8]|h_sw[9]|l_sw[0]|l_sw[10]|l_sw[1]|l_sw[2]|l_sw[3]|l_sw[4]|l_sw[5]|l_sw[6]|l_sw[7]|l_sw[8]|l_sw[9]|out|pad|padres|vc|vcp|vdd|vddr|vip|vss|z
+ sg13_lv_nmos L=0.13u W=0.64u AS=0.141p AD=0.072p PS=1.17u PD=0.865u rfmode=0
M$1152
+ BOTTOM|TOP|VGND|VSS|anode|cathode|core|h_sw[0]|h_sw[10]|h_sw[1]|h_sw[2]|h_sw[3]|h_sw[4]|h_sw[5]|h_sw[6]|h_sw[7]|h_sw[8]|h_sw[9]|l_sw[0]|l_sw[10]|l_sw[1]|l_sw[2]|l_sw[3]|l_sw[4]|l_sw[5]|l_sw[6]|l_sw[7]|l_sw[8]|l_sw[9]|out|pad|padres|vc|vcp|vdd|vddr|vip|vss|z
+ \$74601 \$74577
+ BOTTOM|TOP|VGND|VSS|anode|cathode|core|h_sw[0]|h_sw[10]|h_sw[1]|h_sw[2]|h_sw[3]|h_sw[4]|h_sw[5]|h_sw[6]|h_sw[7]|h_sw[8]|h_sw[9]|l_sw[0]|l_sw[10]|l_sw[1]|l_sw[2]|l_sw[3]|l_sw[4]|l_sw[5]|l_sw[6]|l_sw[7]|l_sw[8]|l_sw[9]|out|pad|padres|vc|vcp|vdd|vddr|vip|vss|z
+ sg13_lv_nmos L=0.13u W=0.64u AS=0.213425p AD=0.072p PS=1.62u PD=0.865u
+ rfmode=0
M$1153
+ BOTTOM|TOP|VGND|VSS|anode|cathode|core|h_sw[0]|h_sw[10]|h_sw[1]|h_sw[2]|h_sw[3]|h_sw[4]|h_sw[5]|h_sw[6]|h_sw[7]|h_sw[8]|h_sw[9]|l_sw[0]|l_sw[10]|l_sw[1]|l_sw[2]|l_sw[3]|l_sw[4]|l_sw[5]|l_sw[6]|l_sw[7]|l_sw[8]|l_sw[9]|out|pad|padres|vc|vcp|vdd|vddr|vip|vss|z
+ \$74462 \$74497
+ BOTTOM|TOP|VGND|VSS|anode|cathode|core|h_sw[0]|h_sw[10]|h_sw[1]|h_sw[2]|h_sw[3]|h_sw[4]|h_sw[5]|h_sw[6]|h_sw[7]|h_sw[8]|h_sw[9]|l_sw[0]|l_sw[10]|l_sw[1]|l_sw[2]|l_sw[3]|l_sw[4]|l_sw[5]|l_sw[6]|l_sw[7]|l_sw[8]|l_sw[9]|out|pad|padres|vc|vcp|vdd|vddr|vip|vss|z
+ sg13_lv_nmos L=0.13u W=0.74u AS=0.213425p AD=0.2775p PS=1.62u PD=2.23u
+ rfmode=0
M$1158 X|in_l_sw[3]|pl_sw[3]|x \$74499
+ BOTTOM|TOP|VGND|VSS|anode|cathode|core|h_sw[0]|h_sw[10]|h_sw[1]|h_sw[2]|h_sw[3]|h_sw[4]|h_sw[5]|h_sw[6]|h_sw[7]|h_sw[8]|h_sw[9]|l_sw[0]|l_sw[10]|l_sw[1]|l_sw[2]|l_sw[3]|l_sw[4]|l_sw[5]|l_sw[6]|l_sw[7]|l_sw[8]|l_sw[9]|out|pad|padres|vc|vcp|vdd|vddr|vip|vss|z
+ BOTTOM|TOP|VGND|VSS|anode|cathode|core|h_sw[0]|h_sw[10]|h_sw[1]|h_sw[2]|h_sw[3]|h_sw[4]|h_sw[5]|h_sw[6]|h_sw[7]|h_sw[8]|h_sw[9]|l_sw[0]|l_sw[10]|l_sw[1]|l_sw[2]|l_sw[3]|l_sw[4]|l_sw[5]|l_sw[6]|l_sw[7]|l_sw[8]|l_sw[9]|out|pad|padres|vc|vcp|vdd|vddr|vip|vss|z
+ sg13_lv_nmos L=0.13u W=0.74u AS=0.2886p AD=0.14875p PS=2.26u PD=1.16u rfmode=0
M$1159
+ BOTTOM|TOP|VGND|VSS|anode|cathode|core|h_sw[0]|h_sw[10]|h_sw[1]|h_sw[2]|h_sw[3]|h_sw[4]|h_sw[5]|h_sw[6]|h_sw[7]|h_sw[8]|h_sw[9]|l_sw[0]|l_sw[10]|l_sw[1]|l_sw[2]|l_sw[3]|l_sw[4]|l_sw[5]|l_sw[6]|l_sw[7]|l_sw[8]|l_sw[9]|out|pad|padres|vc|vcp|vdd|vddr|vip|vss|z
+ A|X$50 \$74499
+ BOTTOM|TOP|VGND|VSS|anode|cathode|core|h_sw[0]|h_sw[10]|h_sw[1]|h_sw[2]|h_sw[3]|h_sw[4]|h_sw[5]|h_sw[6]|h_sw[7]|h_sw[8]|h_sw[9]|l_sw[0]|l_sw[10]|l_sw[1]|l_sw[2]|l_sw[3]|l_sw[4]|l_sw[5]|l_sw[6]|l_sw[7]|l_sw[8]|l_sw[9]|out|pad|padres|vc|vcp|vdd|vddr|vip|vss|z
+ sg13_lv_nmos L=0.13u W=0.55u AS=0.14875p AD=0.187p PS=1.16u PD=1.78u rfmode=0
M$1162 \$74500 D|X \$74582
+ BOTTOM|TOP|VGND|VSS|anode|cathode|core|h_sw[0]|h_sw[10]|h_sw[1]|h_sw[2]|h_sw[3]|h_sw[4]|h_sw[5]|h_sw[6]|h_sw[7]|h_sw[8]|h_sw[9]|l_sw[0]|l_sw[10]|l_sw[1]|l_sw[2]|l_sw[3]|l_sw[4]|l_sw[5]|l_sw[6]|l_sw[7]|l_sw[8]|l_sw[9]|out|pad|padres|vc|vcp|vdd|vddr|vip|vss|z
+ sg13_lv_nmos L=0.13u W=0.42u AS=0.1428p AD=0.0609p PS=1.52u PD=0.71u rfmode=0
M$1163 \$74582 RESET_B|Y$1
+ BOTTOM|TOP|VGND|VSS|anode|cathode|core|h_sw[0]|h_sw[10]|h_sw[1]|h_sw[2]|h_sw[3]|h_sw[4]|h_sw[5]|h_sw[6]|h_sw[7]|h_sw[8]|h_sw[9]|l_sw[0]|l_sw[10]|l_sw[1]|l_sw[2]|l_sw[3]|l_sw[4]|l_sw[5]|l_sw[6]|l_sw[7]|l_sw[8]|l_sw[9]|out|pad|padres|vc|vcp|vdd|vddr|vip|vss|z
+ BOTTOM|TOP|VGND|VSS|anode|cathode|core|h_sw[0]|h_sw[10]|h_sw[1]|h_sw[2]|h_sw[3]|h_sw[4]|h_sw[5]|h_sw[6]|h_sw[7]|h_sw[8]|h_sw[9]|l_sw[0]|l_sw[10]|l_sw[1]|l_sw[2]|l_sw[3]|l_sw[4]|l_sw[5]|l_sw[6]|l_sw[7]|l_sw[8]|l_sw[9]|out|pad|padres|vc|vcp|vdd|vddr|vip|vss|z
+ sg13_lv_nmos L=0.13u W=0.42u AS=0.0609p AD=0.1626p PS=0.71u PD=1.415u rfmode=0
M$1164
+ BOTTOM|TOP|VGND|VSS|anode|cathode|core|h_sw[0]|h_sw[10]|h_sw[1]|h_sw[2]|h_sw[3]|h_sw[4]|h_sw[5]|h_sw[6]|h_sw[7]|h_sw[8]|h_sw[9]|l_sw[0]|l_sw[10]|l_sw[1]|l_sw[2]|l_sw[3]|l_sw[4]|l_sw[5]|l_sw[6]|l_sw[7]|l_sw[8]|l_sw[9]|out|pad|padres|vc|vcp|vdd|vddr|vip|vss|z
+ \$74603 \$74429
+ BOTTOM|TOP|VGND|VSS|anode|cathode|core|h_sw[0]|h_sw[10]|h_sw[1]|h_sw[2]|h_sw[3]|h_sw[4]|h_sw[5]|h_sw[6]|h_sw[7]|h_sw[8]|h_sw[9]|l_sw[0]|l_sw[10]|l_sw[1]|l_sw[2]|l_sw[3]|l_sw[4]|l_sw[5]|l_sw[6]|l_sw[7]|l_sw[8]|l_sw[9]|out|pad|padres|vc|vcp|vdd|vddr|vip|vss|z
+ sg13_lv_nmos L=0.13u W=0.74u AS=0.1626p AD=0.2516p PS=1.415u PD=2.16u rfmode=0
M$1165 \$74467 \$74468
+ BOTTOM|TOP|VGND|VSS|anode|cathode|core|h_sw[0]|h_sw[10]|h_sw[1]|h_sw[2]|h_sw[3]|h_sw[4]|h_sw[5]|h_sw[6]|h_sw[7]|h_sw[8]|h_sw[9]|l_sw[0]|l_sw[10]|l_sw[1]|l_sw[2]|l_sw[3]|l_sw[4]|l_sw[5]|l_sw[6]|l_sw[7]|l_sw[8]|l_sw[9]|out|pad|padres|vc|vcp|vdd|vddr|vip|vss|z
+ BOTTOM|TOP|VGND|VSS|anode|cathode|core|h_sw[0]|h_sw[10]|h_sw[1]|h_sw[2]|h_sw[3]|h_sw[4]|h_sw[5]|h_sw[6]|h_sw[7]|h_sw[8]|h_sw[9]|l_sw[0]|l_sw[10]|l_sw[1]|l_sw[2]|l_sw[3]|l_sw[4]|l_sw[5]|l_sw[6]|l_sw[7]|l_sw[8]|l_sw[9]|out|pad|padres|vc|vcp|vdd|vddr|vip|vss|z
+ sg13_lv_nmos L=0.13u W=0.42u AS=0.1428p AD=0.0798p PS=1.52u PD=0.8u rfmode=0
M$1166
+ BOTTOM|TOP|VGND|VSS|anode|cathode|core|h_sw[0]|h_sw[10]|h_sw[1]|h_sw[2]|h_sw[3]|h_sw[4]|h_sw[5]|h_sw[6]|h_sw[7]|h_sw[8]|h_sw[9]|l_sw[0]|l_sw[10]|l_sw[1]|l_sw[2]|l_sw[3]|l_sw[4]|l_sw[5]|l_sw[6]|l_sw[7]|l_sw[8]|l_sw[9]|out|pad|padres|vc|vcp|vdd|vddr|vip|vss|z
+ RESET_B|Y$1 \$74589
+ BOTTOM|TOP|VGND|VSS|anode|cathode|core|h_sw[0]|h_sw[10]|h_sw[1]|h_sw[2]|h_sw[3]|h_sw[4]|h_sw[5]|h_sw[6]|h_sw[7]|h_sw[8]|h_sw[9]|l_sw[0]|l_sw[10]|l_sw[1]|l_sw[2]|l_sw[3]|l_sw[4]|l_sw[5]|l_sw[6]|l_sw[7]|l_sw[8]|l_sw[9]|out|pad|padres|vc|vcp|vdd|vddr|vip|vss|z
+ sg13_lv_nmos L=0.13u W=0.42u AS=0.0798p AD=0.0378p PS=0.8u PD=0.6u rfmode=0
M$1167 \$74589 \$74502 \$74468
+ BOTTOM|TOP|VGND|VSS|anode|cathode|core|h_sw[0]|h_sw[10]|h_sw[1]|h_sw[2]|h_sw[3]|h_sw[4]|h_sw[5]|h_sw[6]|h_sw[7]|h_sw[8]|h_sw[9]|l_sw[0]|l_sw[10]|l_sw[1]|l_sw[2]|l_sw[3]|l_sw[4]|l_sw[5]|l_sw[6]|l_sw[7]|l_sw[8]|l_sw[9]|out|pad|padres|vc|vcp|vdd|vddr|vip|vss|z
+ sg13_lv_nmos L=0.13u W=0.42u AS=0.0378p AD=0.1428p PS=0.6u PD=1.52u rfmode=0
M$1168
+ BOTTOM|TOP|VGND|VSS|anode|cathode|core|h_sw[0]|h_sw[10]|h_sw[1]|h_sw[2]|h_sw[3]|h_sw[4]|h_sw[5]|h_sw[6]|h_sw[7]|h_sw[8]|h_sw[9]|l_sw[0]|l_sw[10]|l_sw[1]|l_sw[2]|l_sw[3]|l_sw[4]|l_sw[5]|l_sw[6]|l_sw[7]|l_sw[8]|l_sw[9]|out|pad|padres|vc|vcp|vdd|vddr|vip|vss|z
+ \$74502 D|Q_N$9
+ BOTTOM|TOP|VGND|VSS|anode|cathode|core|h_sw[0]|h_sw[10]|h_sw[1]|h_sw[2]|h_sw[3]|h_sw[4]|h_sw[5]|h_sw[6]|h_sw[7]|h_sw[8]|h_sw[9]|l_sw[0]|l_sw[10]|l_sw[1]|l_sw[2]|l_sw[3]|l_sw[4]|l_sw[5]|l_sw[6]|l_sw[7]|l_sw[8]|l_sw[9]|out|pad|padres|vc|vcp|vdd|vddr|vip|vss|z
+ sg13_lv_nmos L=0.13u W=0.74u AS=0.2516p AD=0.2849p PS=2.16u PD=2.25u rfmode=0
M$1169 \$74470 \$74502
+ BOTTOM|TOP|VGND|VSS|anode|cathode|core|h_sw[0]|h_sw[10]|h_sw[1]|h_sw[2]|h_sw[3]|h_sw[4]|h_sw[5]|h_sw[6]|h_sw[7]|h_sw[8]|h_sw[9]|l_sw[0]|l_sw[10]|l_sw[1]|l_sw[2]|l_sw[3]|l_sw[4]|l_sw[5]|l_sw[6]|l_sw[7]|l_sw[8]|l_sw[9]|out|pad|padres|vc|vcp|vdd|vddr|vip|vss|z
+ BOTTOM|TOP|VGND|VSS|anode|cathode|core|h_sw[0]|h_sw[10]|h_sw[1]|h_sw[2]|h_sw[3]|h_sw[4]|h_sw[5]|h_sw[6]|h_sw[7]|h_sw[8]|h_sw[9]|l_sw[0]|l_sw[10]|l_sw[1]|l_sw[2]|l_sw[3]|l_sw[4]|l_sw[5]|l_sw[6]|l_sw[7]|l_sw[8]|l_sw[9]|out|pad|padres|vc|vcp|vdd|vddr|vip|vss|z
+ sg13_lv_nmos L=0.13u W=0.74u AS=0.2516p AD=0.1406p PS=2.16u PD=1.12u rfmode=0
M$1170
+ BOTTOM|TOP|VGND|VSS|anode|cathode|core|h_sw[0]|h_sw[10]|h_sw[1]|h_sw[2]|h_sw[3]|h_sw[4]|h_sw[5]|h_sw[6]|h_sw[7]|h_sw[8]|h_sw[9]|l_sw[0]|l_sw[10]|l_sw[1]|l_sw[2]|l_sw[3]|l_sw[4]|l_sw[5]|l_sw[6]|l_sw[7]|l_sw[8]|l_sw[9]|out|pad|padres|vc|vcp|vdd|vddr|vip|vss|z
+ \$74470 A1|D|Q$3
+ BOTTOM|TOP|VGND|VSS|anode|cathode|core|h_sw[0]|h_sw[10]|h_sw[1]|h_sw[2]|h_sw[3]|h_sw[4]|h_sw[5]|h_sw[6]|h_sw[7]|h_sw[8]|h_sw[9]|l_sw[0]|l_sw[10]|l_sw[1]|l_sw[2]|l_sw[3]|l_sw[4]|l_sw[5]|l_sw[6]|l_sw[7]|l_sw[8]|l_sw[9]|out|pad|padres|vc|vcp|vdd|vddr|vip|vss|z
+ sg13_lv_nmos L=0.13u W=0.74u AS=0.1406p AD=0.2516p PS=1.12u PD=2.16u rfmode=0
M$1171 \$74503 D|X$1 \$74592
+ BOTTOM|TOP|VGND|VSS|anode|cathode|core|h_sw[0]|h_sw[10]|h_sw[1]|h_sw[2]|h_sw[3]|h_sw[4]|h_sw[5]|h_sw[6]|h_sw[7]|h_sw[8]|h_sw[9]|l_sw[0]|l_sw[10]|l_sw[1]|l_sw[2]|l_sw[3]|l_sw[4]|l_sw[5]|l_sw[6]|l_sw[7]|l_sw[8]|l_sw[9]|out|pad|padres|vc|vcp|vdd|vddr|vip|vss|z
+ sg13_lv_nmos L=0.13u W=0.42u AS=0.1428p AD=0.0609p PS=1.52u PD=0.71u rfmode=0
M$1172 \$74592 RESET_B|Y$1
+ BOTTOM|TOP|VGND|VSS|anode|cathode|core|h_sw[0]|h_sw[10]|h_sw[1]|h_sw[2]|h_sw[3]|h_sw[4]|h_sw[5]|h_sw[6]|h_sw[7]|h_sw[8]|h_sw[9]|l_sw[0]|l_sw[10]|l_sw[1]|l_sw[2]|l_sw[3]|l_sw[4]|l_sw[5]|l_sw[6]|l_sw[7]|l_sw[8]|l_sw[9]|out|pad|padres|vc|vcp|vdd|vddr|vip|vss|z
+ BOTTOM|TOP|VGND|VSS|anode|cathode|core|h_sw[0]|h_sw[10]|h_sw[1]|h_sw[2]|h_sw[3]|h_sw[4]|h_sw[5]|h_sw[6]|h_sw[7]|h_sw[8]|h_sw[9]|l_sw[0]|l_sw[10]|l_sw[1]|l_sw[2]|l_sw[3]|l_sw[4]|l_sw[5]|l_sw[6]|l_sw[7]|l_sw[8]|l_sw[9]|out|pad|padres|vc|vcp|vdd|vddr|vip|vss|z
+ sg13_lv_nmos L=0.13u W=0.42u AS=0.0609p AD=0.1626p PS=0.71u PD=1.415u rfmode=0
M$1173
+ BOTTOM|TOP|VGND|VSS|anode|cathode|core|h_sw[0]|h_sw[10]|h_sw[1]|h_sw[2]|h_sw[3]|h_sw[4]|h_sw[5]|h_sw[6]|h_sw[7]|h_sw[8]|h_sw[9]|l_sw[0]|l_sw[10]|l_sw[1]|l_sw[2]|l_sw[3]|l_sw[4]|l_sw[5]|l_sw[6]|l_sw[7]|l_sw[8]|l_sw[9]|out|pad|padres|vc|vcp|vdd|vddr|vip|vss|z
+ \$74604 \$74431
+ BOTTOM|TOP|VGND|VSS|anode|cathode|core|h_sw[0]|h_sw[10]|h_sw[1]|h_sw[2]|h_sw[3]|h_sw[4]|h_sw[5]|h_sw[6]|h_sw[7]|h_sw[8]|h_sw[9]|l_sw[0]|l_sw[10]|l_sw[1]|l_sw[2]|l_sw[3]|l_sw[4]|l_sw[5]|l_sw[6]|l_sw[7]|l_sw[8]|l_sw[9]|out|pad|padres|vc|vcp|vdd|vddr|vip|vss|z
+ sg13_lv_nmos L=0.13u W=0.74u AS=0.1626p AD=0.2516p PS=1.415u PD=2.16u rfmode=0
M$1174 \$74473 \$74474
+ BOTTOM|TOP|VGND|VSS|anode|cathode|core|h_sw[0]|h_sw[10]|h_sw[1]|h_sw[2]|h_sw[3]|h_sw[4]|h_sw[5]|h_sw[6]|h_sw[7]|h_sw[8]|h_sw[9]|l_sw[0]|l_sw[10]|l_sw[1]|l_sw[2]|l_sw[3]|l_sw[4]|l_sw[5]|l_sw[6]|l_sw[7]|l_sw[8]|l_sw[9]|out|pad|padres|vc|vcp|vdd|vddr|vip|vss|z
+ BOTTOM|TOP|VGND|VSS|anode|cathode|core|h_sw[0]|h_sw[10]|h_sw[1]|h_sw[2]|h_sw[3]|h_sw[4]|h_sw[5]|h_sw[6]|h_sw[7]|h_sw[8]|h_sw[9]|l_sw[0]|l_sw[10]|l_sw[1]|l_sw[2]|l_sw[3]|l_sw[4]|l_sw[5]|l_sw[6]|l_sw[7]|l_sw[8]|l_sw[9]|out|pad|padres|vc|vcp|vdd|vddr|vip|vss|z
+ sg13_lv_nmos L=0.13u W=0.42u AS=0.1428p AD=0.0798p PS=1.52u PD=0.8u rfmode=0
M$1175
+ BOTTOM|TOP|VGND|VSS|anode|cathode|core|h_sw[0]|h_sw[10]|h_sw[1]|h_sw[2]|h_sw[3]|h_sw[4]|h_sw[5]|h_sw[6]|h_sw[7]|h_sw[8]|h_sw[9]|l_sw[0]|l_sw[10]|l_sw[1]|l_sw[2]|l_sw[3]|l_sw[4]|l_sw[5]|l_sw[6]|l_sw[7]|l_sw[8]|l_sw[9]|out|pad|padres|vc|vcp|vdd|vddr|vip|vss|z
+ RESET_B|Y$1 \$74590
+ BOTTOM|TOP|VGND|VSS|anode|cathode|core|h_sw[0]|h_sw[10]|h_sw[1]|h_sw[2]|h_sw[3]|h_sw[4]|h_sw[5]|h_sw[6]|h_sw[7]|h_sw[8]|h_sw[9]|l_sw[0]|l_sw[10]|l_sw[1]|l_sw[2]|l_sw[3]|l_sw[4]|l_sw[5]|l_sw[6]|l_sw[7]|l_sw[8]|l_sw[9]|out|pad|padres|vc|vcp|vdd|vddr|vip|vss|z
+ sg13_lv_nmos L=0.13u W=0.42u AS=0.0798p AD=0.0378p PS=0.8u PD=0.6u rfmode=0
M$1176 \$74590 \$74505 \$74474
+ BOTTOM|TOP|VGND|VSS|anode|cathode|core|h_sw[0]|h_sw[10]|h_sw[1]|h_sw[2]|h_sw[3]|h_sw[4]|h_sw[5]|h_sw[6]|h_sw[7]|h_sw[8]|h_sw[9]|l_sw[0]|l_sw[10]|l_sw[1]|l_sw[2]|l_sw[3]|l_sw[4]|l_sw[5]|l_sw[6]|l_sw[7]|l_sw[8]|l_sw[9]|out|pad|padres|vc|vcp|vdd|vddr|vip|vss|z
+ sg13_lv_nmos L=0.13u W=0.42u AS=0.0378p AD=0.1428p PS=0.6u PD=1.52u rfmode=0
M$1177
+ BOTTOM|TOP|VGND|VSS|anode|cathode|core|h_sw[0]|h_sw[10]|h_sw[1]|h_sw[2]|h_sw[3]|h_sw[4]|h_sw[5]|h_sw[6]|h_sw[7]|h_sw[8]|h_sw[9]|l_sw[0]|l_sw[10]|l_sw[1]|l_sw[2]|l_sw[3]|l_sw[4]|l_sw[5]|l_sw[6]|l_sw[7]|l_sw[8]|l_sw[9]|out|pad|padres|vc|vcp|vdd|vddr|vip|vss|z
+ \$74505 D|Q_N$8
+ BOTTOM|TOP|VGND|VSS|anode|cathode|core|h_sw[0]|h_sw[10]|h_sw[1]|h_sw[2]|h_sw[3]|h_sw[4]|h_sw[5]|h_sw[6]|h_sw[7]|h_sw[8]|h_sw[9]|l_sw[0]|l_sw[10]|l_sw[1]|l_sw[2]|l_sw[3]|l_sw[4]|l_sw[5]|l_sw[6]|l_sw[7]|l_sw[8]|l_sw[9]|out|pad|padres|vc|vcp|vdd|vddr|vip|vss|z
+ sg13_lv_nmos L=0.13u W=0.74u AS=0.2516p AD=0.2849p PS=2.16u PD=2.25u rfmode=0
M$1178 \$74475 \$74505
+ BOTTOM|TOP|VGND|VSS|anode|cathode|core|h_sw[0]|h_sw[10]|h_sw[1]|h_sw[2]|h_sw[3]|h_sw[4]|h_sw[5]|h_sw[6]|h_sw[7]|h_sw[8]|h_sw[9]|l_sw[0]|l_sw[10]|l_sw[1]|l_sw[2]|l_sw[3]|l_sw[4]|l_sw[5]|l_sw[6]|l_sw[7]|l_sw[8]|l_sw[9]|out|pad|padres|vc|vcp|vdd|vddr|vip|vss|z
+ BOTTOM|TOP|VGND|VSS|anode|cathode|core|h_sw[0]|h_sw[10]|h_sw[1]|h_sw[2]|h_sw[3]|h_sw[4]|h_sw[5]|h_sw[6]|h_sw[7]|h_sw[8]|h_sw[9]|l_sw[0]|l_sw[10]|l_sw[1]|l_sw[2]|l_sw[3]|l_sw[4]|l_sw[5]|l_sw[6]|l_sw[7]|l_sw[8]|l_sw[9]|out|pad|padres|vc|vcp|vdd|vddr|vip|vss|z
+ sg13_lv_nmos L=0.13u W=0.74u AS=0.2516p AD=0.1406p PS=2.16u PD=1.12u rfmode=0
M$1179
+ BOTTOM|TOP|VGND|VSS|anode|cathode|core|h_sw[0]|h_sw[10]|h_sw[1]|h_sw[2]|h_sw[3]|h_sw[4]|h_sw[5]|h_sw[6]|h_sw[7]|h_sw[8]|h_sw[9]|l_sw[0]|l_sw[10]|l_sw[1]|l_sw[2]|l_sw[3]|l_sw[4]|l_sw[5]|l_sw[6]|l_sw[7]|l_sw[8]|l_sw[9]|out|pad|padres|vc|vcp|vdd|vddr|vip|vss|z
+ \$74475 A|D|Q$1
+ BOTTOM|TOP|VGND|VSS|anode|cathode|core|h_sw[0]|h_sw[10]|h_sw[1]|h_sw[2]|h_sw[3]|h_sw[4]|h_sw[5]|h_sw[6]|h_sw[7]|h_sw[8]|h_sw[9]|l_sw[0]|l_sw[10]|l_sw[1]|l_sw[2]|l_sw[3]|l_sw[4]|l_sw[5]|l_sw[6]|l_sw[7]|l_sw[8]|l_sw[9]|out|pad|padres|vc|vcp|vdd|vddr|vip|vss|z
+ sg13_lv_nmos L=0.13u W=0.74u AS=0.1406p AD=0.2516p PS=1.12u PD=2.16u rfmode=0
M$1180
+ BOTTOM|TOP|VGND|VSS|anode|cathode|core|h_sw[0]|h_sw[10]|h_sw[1]|h_sw[2]|h_sw[3]|h_sw[4]|h_sw[5]|h_sw[6]|h_sw[7]|h_sw[8]|h_sw[9]|l_sw[0]|l_sw[10]|l_sw[1]|l_sw[2]|l_sw[3]|l_sw[4]|l_sw[5]|l_sw[6]|l_sw[7]|l_sw[8]|l_sw[9]|out|pad|padres|vc|vcp|vdd|vddr|vip|vss|z
+ \$74506 \$74585
+ BOTTOM|TOP|VGND|VSS|anode|cathode|core|h_sw[0]|h_sw[10]|h_sw[1]|h_sw[2]|h_sw[3]|h_sw[4]|h_sw[5]|h_sw[6]|h_sw[7]|h_sw[8]|h_sw[9]|l_sw[0]|l_sw[10]|l_sw[1]|l_sw[2]|l_sw[3]|l_sw[4]|l_sw[5]|l_sw[6]|l_sw[7]|l_sw[8]|l_sw[9]|out|pad|padres|vc|vcp|vdd|vddr|vip|vss|z
+ sg13_lv_nmos L=0.13u W=0.64u AS=0.213425p AD=0.072p PS=1.62u PD=0.865u
+ rfmode=0
M$1181 \$74585 \$74507 \$74477
+ BOTTOM|TOP|VGND|VSS|anode|cathode|core|h_sw[0]|h_sw[10]|h_sw[1]|h_sw[2]|h_sw[3]|h_sw[4]|h_sw[5]|h_sw[6]|h_sw[7]|h_sw[8]|h_sw[9]|l_sw[0]|l_sw[10]|l_sw[1]|l_sw[2]|l_sw[3]|l_sw[4]|l_sw[5]|l_sw[6]|l_sw[7]|l_sw[8]|l_sw[9]|out|pad|padres|vc|vcp|vdd|vddr|vip|vss|z
+ sg13_lv_nmos L=0.13u W=0.64u AS=0.072p AD=0.141p PS=0.865u PD=1.17u rfmode=0
M$1182 \$74477 \$74476 \$74586
+ BOTTOM|TOP|VGND|VSS|anode|cathode|core|h_sw[0]|h_sw[10]|h_sw[1]|h_sw[2]|h_sw[3]|h_sw[4]|h_sw[5]|h_sw[6]|h_sw[7]|h_sw[8]|h_sw[9]|l_sw[0]|l_sw[10]|l_sw[1]|l_sw[2]|l_sw[3]|l_sw[4]|l_sw[5]|l_sw[6]|l_sw[7]|l_sw[8]|l_sw[9]|out|pad|padres|vc|vcp|vdd|vddr|vip|vss|z
+ sg13_lv_nmos L=0.13u W=0.42u AS=0.141p AD=0.04725p PS=1.17u PD=0.645u rfmode=0
M$1183 \$74586 \$74478
+ BOTTOM|TOP|VGND|VSS|anode|cathode|core|h_sw[0]|h_sw[10]|h_sw[1]|h_sw[2]|h_sw[3]|h_sw[4]|h_sw[5]|h_sw[6]|h_sw[7]|h_sw[8]|h_sw[9]|l_sw[0]|l_sw[10]|l_sw[1]|l_sw[2]|l_sw[3]|l_sw[4]|l_sw[5]|l_sw[6]|l_sw[7]|l_sw[8]|l_sw[9]|out|pad|padres|vc|vcp|vdd|vddr|vip|vss|z
+ BOTTOM|TOP|VGND|VSS|anode|cathode|core|h_sw[0]|h_sw[10]|h_sw[1]|h_sw[2]|h_sw[3]|h_sw[4]|h_sw[5]|h_sw[6]|h_sw[7]|h_sw[8]|h_sw[9]|l_sw[0]|l_sw[10]|l_sw[1]|l_sw[2]|l_sw[3]|l_sw[4]|l_sw[5]|l_sw[6]|l_sw[7]|l_sw[8]|l_sw[9]|out|pad|padres|vc|vcp|vdd|vddr|vip|vss|z
+ sg13_lv_nmos L=0.13u W=0.42u AS=0.04725p AD=0.1428p PS=0.645u PD=1.52u
+ rfmode=0
M$1184
+ BOTTOM|TOP|VGND|VSS|anode|cathode|core|h_sw[0]|h_sw[10]|h_sw[1]|h_sw[2]|h_sw[3]|h_sw[4]|h_sw[5]|h_sw[6]|h_sw[7]|h_sw[8]|h_sw[9]|l_sw[0]|l_sw[10]|l_sw[1]|l_sw[2]|l_sw[3]|l_sw[4]|l_sw[5]|l_sw[6]|l_sw[7]|l_sw[8]|l_sw[9]|out|pad|padres|vc|vcp|vdd|vddr|vip|vss|z
+ \$74476 \$74507
+ BOTTOM|TOP|VGND|VSS|anode|cathode|core|h_sw[0]|h_sw[10]|h_sw[1]|h_sw[2]|h_sw[3]|h_sw[4]|h_sw[5]|h_sw[6]|h_sw[7]|h_sw[8]|h_sw[9]|l_sw[0]|l_sw[10]|l_sw[1]|l_sw[2]|l_sw[3]|l_sw[4]|l_sw[5]|l_sw[6]|l_sw[7]|l_sw[8]|l_sw[9]|out|pad|padres|vc|vcp|vdd|vddr|vip|vss|z
+ sg13_lv_nmos L=0.13u W=0.74u AS=0.213425p AD=0.2775p PS=1.62u PD=2.23u
+ rfmode=0
M$1185 \$74478 \$74477 \$74587
+ BOTTOM|TOP|VGND|VSS|anode|cathode|core|h_sw[0]|h_sw[10]|h_sw[1]|h_sw[2]|h_sw[3]|h_sw[4]|h_sw[5]|h_sw[6]|h_sw[7]|h_sw[8]|h_sw[9]|l_sw[0]|l_sw[10]|l_sw[1]|l_sw[2]|l_sw[3]|l_sw[4]|l_sw[5]|l_sw[6]|l_sw[7]|l_sw[8]|l_sw[9]|out|pad|padres|vc|vcp|vdd|vddr|vip|vss|z
+ sg13_lv_nmos L=0.13u W=0.74u AS=0.2516p AD=0.0777p PS=2.16u PD=0.95u rfmode=0
M$1186 \$74587 RESET_B|Y$1
+ BOTTOM|TOP|VGND|VSS|anode|cathode|core|h_sw[0]|h_sw[10]|h_sw[1]|h_sw[2]|h_sw[3]|h_sw[4]|h_sw[5]|h_sw[6]|h_sw[7]|h_sw[8]|h_sw[9]|l_sw[0]|l_sw[10]|l_sw[1]|l_sw[2]|l_sw[3]|l_sw[4]|l_sw[5]|l_sw[6]|l_sw[7]|l_sw[8]|l_sw[9]|out|pad|padres|vc|vcp|vdd|vddr|vip|vss|z
+ BOTTOM|TOP|VGND|VSS|anode|cathode|core|h_sw[0]|h_sw[10]|h_sw[1]|h_sw[2]|h_sw[3]|h_sw[4]|h_sw[5]|h_sw[6]|h_sw[7]|h_sw[8]|h_sw[9]|l_sw[0]|l_sw[10]|l_sw[1]|l_sw[2]|l_sw[3]|l_sw[4]|l_sw[5]|l_sw[6]|l_sw[7]|l_sw[8]|l_sw[9]|out|pad|padres|vc|vcp|vdd|vddr|vip|vss|z
+ sg13_lv_nmos L=0.13u W=0.74u AS=0.0777p AD=0.1406p PS=0.95u PD=1.12u rfmode=0
M$1187
+ BOTTOM|TOP|VGND|VSS|anode|cathode|core|h_sw[0]|h_sw[10]|h_sw[1]|h_sw[2]|h_sw[3]|h_sw[4]|h_sw[5]|h_sw[6]|h_sw[7]|h_sw[8]|h_sw[9]|l_sw[0]|l_sw[10]|l_sw[1]|l_sw[2]|l_sw[3]|l_sw[4]|l_sw[5]|l_sw[6]|l_sw[7]|l_sw[8]|l_sw[9]|out|pad|padres|vc|vcp|vdd|vddr|vip|vss|z
+ \$74478 A|Q$21
+ BOTTOM|TOP|VGND|VSS|anode|cathode|core|h_sw[0]|h_sw[10]|h_sw[1]|h_sw[2]|h_sw[3]|h_sw[4]|h_sw[5]|h_sw[6]|h_sw[7]|h_sw[8]|h_sw[9]|l_sw[0]|l_sw[10]|l_sw[1]|l_sw[2]|l_sw[3]|l_sw[4]|l_sw[5]|l_sw[6]|l_sw[7]|l_sw[8]|l_sw[9]|out|pad|padres|vc|vcp|vdd|vddr|vip|vss|z
+ sg13_lv_nmos L=0.13u W=0.74u AS=0.1406p AD=0.2516p PS=1.12u PD=2.16u rfmode=0
M$1188
+ BOTTOM|TOP|VGND|VSS|anode|cathode|core|h_sw[0]|h_sw[10]|h_sw[1]|h_sw[2]|h_sw[3]|h_sw[4]|h_sw[5]|h_sw[6]|h_sw[7]|h_sw[8]|h_sw[9]|l_sw[0]|l_sw[10]|l_sw[1]|l_sw[2]|l_sw[3]|l_sw[4]|l_sw[5]|l_sw[6]|l_sw[7]|l_sw[8]|l_sw[9]|out|pad|padres|vc|vcp|vdd|vddr|vip|vss|z
+ \$74478 \$74480
+ BOTTOM|TOP|VGND|VSS|anode|cathode|core|h_sw[0]|h_sw[10]|h_sw[1]|h_sw[2]|h_sw[3]|h_sw[4]|h_sw[5]|h_sw[6]|h_sw[7]|h_sw[8]|h_sw[9]|l_sw[0]|l_sw[10]|l_sw[1]|l_sw[2]|l_sw[3]|l_sw[4]|l_sw[5]|l_sw[6]|l_sw[7]|l_sw[8]|l_sw[9]|out|pad|padres|vc|vcp|vdd|vddr|vip|vss|z
+ sg13_lv_nmos L=0.13u W=0.55u AS=0.1491p AD=0.187p PS=1.18u PD=1.78u rfmode=0
M$1189
+ BOTTOM|TOP|VGND|VSS|anode|cathode|core|h_sw[0]|h_sw[10]|h_sw[1]|h_sw[2]|h_sw[3]|h_sw[4]|h_sw[5]|h_sw[6]|h_sw[7]|h_sw[8]|h_sw[9]|l_sw[0]|l_sw[10]|l_sw[1]|l_sw[2]|l_sw[3]|l_sw[4]|l_sw[5]|l_sw[6]|l_sw[7]|l_sw[8]|l_sw[9]|out|pad|padres|vc|vcp|vdd|vddr|vip|vss|z
+ \$74480 Q_N$33
+ BOTTOM|TOP|VGND|VSS|anode|cathode|core|h_sw[0]|h_sw[10]|h_sw[1]|h_sw[2]|h_sw[3]|h_sw[4]|h_sw[5]|h_sw[6]|h_sw[7]|h_sw[8]|h_sw[9]|l_sw[0]|l_sw[10]|l_sw[1]|l_sw[2]|l_sw[3]|l_sw[4]|l_sw[5]|l_sw[6]|l_sw[7]|l_sw[8]|l_sw[9]|out|pad|padres|vc|vcp|vdd|vddr|vip|vss|z
+ sg13_lv_nmos L=0.13u W=0.74u AS=0.1491p AD=0.2516p PS=1.18u PD=2.16u rfmode=0
M$1190 \$74508 D|X$1 \$74583
+ BOTTOM|TOP|VGND|VSS|anode|cathode|core|h_sw[0]|h_sw[10]|h_sw[1]|h_sw[2]|h_sw[3]|h_sw[4]|h_sw[5]|h_sw[6]|h_sw[7]|h_sw[8]|h_sw[9]|l_sw[0]|l_sw[10]|l_sw[1]|l_sw[2]|l_sw[3]|l_sw[4]|l_sw[5]|l_sw[6]|l_sw[7]|l_sw[8]|l_sw[9]|out|pad|padres|vc|vcp|vdd|vddr|vip|vss|z
+ sg13_lv_nmos L=0.13u W=0.42u AS=0.1428p AD=0.0609p PS=1.52u PD=0.71u rfmode=0
M$1191 \$74583 RESET_B|Y$1
+ BOTTOM|TOP|VGND|VSS|anode|cathode|core|h_sw[0]|h_sw[10]|h_sw[1]|h_sw[2]|h_sw[3]|h_sw[4]|h_sw[5]|h_sw[6]|h_sw[7]|h_sw[8]|h_sw[9]|l_sw[0]|l_sw[10]|l_sw[1]|l_sw[2]|l_sw[3]|l_sw[4]|l_sw[5]|l_sw[6]|l_sw[7]|l_sw[8]|l_sw[9]|out|pad|padres|vc|vcp|vdd|vddr|vip|vss|z
+ BOTTOM|TOP|VGND|VSS|anode|cathode|core|h_sw[0]|h_sw[10]|h_sw[1]|h_sw[2]|h_sw[3]|h_sw[4]|h_sw[5]|h_sw[6]|h_sw[7]|h_sw[8]|h_sw[9]|l_sw[0]|l_sw[10]|l_sw[1]|l_sw[2]|l_sw[3]|l_sw[4]|l_sw[5]|l_sw[6]|l_sw[7]|l_sw[8]|l_sw[9]|out|pad|padres|vc|vcp|vdd|vddr|vip|vss|z
+ sg13_lv_nmos L=0.13u W=0.42u AS=0.0609p AD=0.1626p PS=0.71u PD=1.415u rfmode=0
M$1192
+ BOTTOM|TOP|VGND|VSS|anode|cathode|core|h_sw[0]|h_sw[10]|h_sw[1]|h_sw[2]|h_sw[3]|h_sw[4]|h_sw[5]|h_sw[6]|h_sw[7]|h_sw[8]|h_sw[9]|l_sw[0]|l_sw[10]|l_sw[1]|l_sw[2]|l_sw[3]|l_sw[4]|l_sw[5]|l_sw[6]|l_sw[7]|l_sw[8]|l_sw[9]|out|pad|padres|vc|vcp|vdd|vddr|vip|vss|z
+ \$74605 \$74432
+ BOTTOM|TOP|VGND|VSS|anode|cathode|core|h_sw[0]|h_sw[10]|h_sw[1]|h_sw[2]|h_sw[3]|h_sw[4]|h_sw[5]|h_sw[6]|h_sw[7]|h_sw[8]|h_sw[9]|l_sw[0]|l_sw[10]|l_sw[1]|l_sw[2]|l_sw[3]|l_sw[4]|l_sw[5]|l_sw[6]|l_sw[7]|l_sw[8]|l_sw[9]|out|pad|padres|vc|vcp|vdd|vddr|vip|vss|z
+ sg13_lv_nmos L=0.13u W=0.74u AS=0.1626p AD=0.2516p PS=1.415u PD=2.16u rfmode=0
M$1193
+ BOTTOM|TOP|VGND|VSS|anode|cathode|core|h_sw[0]|h_sw[10]|h_sw[1]|h_sw[2]|h_sw[3]|h_sw[4]|h_sw[5]|h_sw[6]|h_sw[7]|h_sw[8]|h_sw[9]|l_sw[0]|l_sw[10]|l_sw[1]|l_sw[2]|l_sw[3]|l_sw[4]|l_sw[5]|l_sw[6]|l_sw[7]|l_sw[8]|l_sw[9]|out|pad|padres|vc|vcp|vdd|vddr|vip|vss|z
+ \$73660 \$73659
+ BOTTOM|TOP|VGND|VSS|anode|cathode|core|h_sw[0]|h_sw[10]|h_sw[1]|h_sw[2]|h_sw[3]|h_sw[4]|h_sw[5]|h_sw[6]|h_sw[7]|h_sw[8]|h_sw[9]|l_sw[0]|l_sw[10]|l_sw[1]|l_sw[2]|l_sw[3]|l_sw[4]|l_sw[5]|l_sw[6]|l_sw[7]|l_sw[8]|l_sw[9]|out|pad|padres|vc|vcp|vdd|vddr|vip|vss|z
+ sg13_lv_nmos L=0.13u W=0.74u AS=0.1626p AD=0.2516p PS=1.415u PD=2.16u rfmode=0
M$1194 \$73631 CLK|D|GATE|Q$8 \$74101
+ BOTTOM|TOP|VGND|VSS|anode|cathode|core|h_sw[0]|h_sw[10]|h_sw[1]|h_sw[2]|h_sw[3]|h_sw[4]|h_sw[5]|h_sw[6]|h_sw[7]|h_sw[8]|h_sw[9]|l_sw[0]|l_sw[10]|l_sw[1]|l_sw[2]|l_sw[3]|l_sw[4]|l_sw[5]|l_sw[6]|l_sw[7]|l_sw[8]|l_sw[9]|out|pad|padres|vc|vcp|vdd|vddr|vip|vss|z
+ sg13_lv_nmos L=0.13u W=0.42u AS=0.1428p AD=0.0609p PS=1.52u PD=0.71u rfmode=0
M$1195
+ BOTTOM|TOP|VGND|VSS|anode|cathode|core|h_sw[0]|h_sw[10]|h_sw[1]|h_sw[2]|h_sw[3]|h_sw[4]|h_sw[5]|h_sw[6]|h_sw[7]|h_sw[8]|h_sw[9]|l_sw[0]|l_sw[10]|l_sw[1]|l_sw[2]|l_sw[3]|l_sw[4]|l_sw[5]|l_sw[6]|l_sw[7]|l_sw[8]|l_sw[9]|out|pad|padres|vc|vcp|vdd|vddr|vip|vss|z
+ RESET_B|Y$2 \$74101
+ BOTTOM|TOP|VGND|VSS|anode|cathode|core|h_sw[0]|h_sw[10]|h_sw[1]|h_sw[2]|h_sw[3]|h_sw[4]|h_sw[5]|h_sw[6]|h_sw[7]|h_sw[8]|h_sw[9]|l_sw[0]|l_sw[10]|l_sw[1]|l_sw[2]|l_sw[3]|l_sw[4]|l_sw[5]|l_sw[6]|l_sw[7]|l_sw[8]|l_sw[9]|out|pad|padres|vc|vcp|vdd|vddr|vip|vss|z
+ sg13_lv_nmos L=0.13u W=0.42u AS=0.1626p AD=0.0609p PS=1.415u PD=0.71u rfmode=0
M$1196
+ BOTTOM|TOP|VGND|VSS|anode|cathode|core|h_sw[0]|h_sw[10]|h_sw[1]|h_sw[2]|h_sw[3]|h_sw[4]|h_sw[5]|h_sw[6]|h_sw[7]|h_sw[8]|h_sw[9]|l_sw[0]|l_sw[10]|l_sw[1]|l_sw[2]|l_sw[3]|l_sw[4]|l_sw[5]|l_sw[6]|l_sw[7]|l_sw[8]|l_sw[9]|out|pad|padres|vc|vcp|vdd|vddr|vip|vss|z
+ RESET_B|Y$2 \$74102
+ BOTTOM|TOP|VGND|VSS|anode|cathode|core|h_sw[0]|h_sw[10]|h_sw[1]|h_sw[2]|h_sw[3]|h_sw[4]|h_sw[5]|h_sw[6]|h_sw[7]|h_sw[8]|h_sw[9]|l_sw[0]|l_sw[10]|l_sw[1]|l_sw[2]|l_sw[3]|l_sw[4]|l_sw[5]|l_sw[6]|l_sw[7]|l_sw[8]|l_sw[9]|out|pad|padres|vc|vcp|vdd|vddr|vip|vss|z
+ sg13_lv_nmos L=0.13u W=0.42u AS=0.1701p AD=0.0378p PS=1.65u PD=0.6u rfmode=0
M$1197 \$74102 \$73659 \$73980
+ BOTTOM|TOP|VGND|VSS|anode|cathode|core|h_sw[0]|h_sw[10]|h_sw[1]|h_sw[2]|h_sw[3]|h_sw[4]|h_sw[5]|h_sw[6]|h_sw[7]|h_sw[8]|h_sw[9]|l_sw[0]|l_sw[10]|l_sw[1]|l_sw[2]|l_sw[3]|l_sw[4]|l_sw[5]|l_sw[6]|l_sw[7]|l_sw[8]|l_sw[9]|out|pad|padres|vc|vcp|vdd|vddr|vip|vss|z
+ sg13_lv_nmos L=0.13u W=0.42u AS=0.0378p AD=0.1428p PS=0.6u PD=1.52u rfmode=0
M$1198 \$74484 \$74485
+ BOTTOM|TOP|VGND|VSS|anode|cathode|core|h_sw[0]|h_sw[10]|h_sw[1]|h_sw[2]|h_sw[3]|h_sw[4]|h_sw[5]|h_sw[6]|h_sw[7]|h_sw[8]|h_sw[9]|l_sw[0]|l_sw[10]|l_sw[1]|l_sw[2]|l_sw[3]|l_sw[4]|l_sw[5]|l_sw[6]|l_sw[7]|l_sw[8]|l_sw[9]|out|pad|padres|vc|vcp|vdd|vddr|vip|vss|z
+ BOTTOM|TOP|VGND|VSS|anode|cathode|core|h_sw[0]|h_sw[10]|h_sw[1]|h_sw[2]|h_sw[3]|h_sw[4]|h_sw[5]|h_sw[6]|h_sw[7]|h_sw[8]|h_sw[9]|l_sw[0]|l_sw[10]|l_sw[1]|l_sw[2]|l_sw[3]|l_sw[4]|l_sw[5]|l_sw[6]|l_sw[7]|l_sw[8]|l_sw[9]|out|pad|padres|vc|vcp|vdd|vddr|vip|vss|z
+ sg13_lv_nmos L=0.13u W=0.42u AS=0.1428p AD=0.0798p PS=1.52u PD=0.8u rfmode=0
M$1199
+ BOTTOM|TOP|VGND|VSS|anode|cathode|core|h_sw[0]|h_sw[10]|h_sw[1]|h_sw[2]|h_sw[3]|h_sw[4]|h_sw[5]|h_sw[6]|h_sw[7]|h_sw[8]|h_sw[9]|l_sw[0]|l_sw[10]|l_sw[1]|l_sw[2]|l_sw[3]|l_sw[4]|l_sw[5]|l_sw[6]|l_sw[7]|l_sw[8]|l_sw[9]|out|pad|padres|vc|vcp|vdd|vddr|vip|vss|z
+ RESET_B|Y$1 \$74581
+ BOTTOM|TOP|VGND|VSS|anode|cathode|core|h_sw[0]|h_sw[10]|h_sw[1]|h_sw[2]|h_sw[3]|h_sw[4]|h_sw[5]|h_sw[6]|h_sw[7]|h_sw[8]|h_sw[9]|l_sw[0]|l_sw[10]|l_sw[1]|l_sw[2]|l_sw[3]|l_sw[4]|l_sw[5]|l_sw[6]|l_sw[7]|l_sw[8]|l_sw[9]|out|pad|padres|vc|vcp|vdd|vddr|vip|vss|z
+ sg13_lv_nmos L=0.13u W=0.42u AS=0.0798p AD=0.0378p PS=0.8u PD=0.6u rfmode=0
M$1200 \$74581 \$74510 \$74485
+ BOTTOM|TOP|VGND|VSS|anode|cathode|core|h_sw[0]|h_sw[10]|h_sw[1]|h_sw[2]|h_sw[3]|h_sw[4]|h_sw[5]|h_sw[6]|h_sw[7]|h_sw[8]|h_sw[9]|l_sw[0]|l_sw[10]|l_sw[1]|l_sw[2]|l_sw[3]|l_sw[4]|l_sw[5]|l_sw[6]|l_sw[7]|l_sw[8]|l_sw[9]|out|pad|padres|vc|vcp|vdd|vddr|vip|vss|z
+ sg13_lv_nmos L=0.13u W=0.42u AS=0.0378p AD=0.1428p PS=0.6u PD=1.52u rfmode=0
M$1201
+ BOTTOM|TOP|VGND|VSS|anode|cathode|core|h_sw[0]|h_sw[10]|h_sw[1]|h_sw[2]|h_sw[3]|h_sw[4]|h_sw[5]|h_sw[6]|h_sw[7]|h_sw[8]|h_sw[9]|l_sw[0]|l_sw[10]|l_sw[1]|l_sw[2]|l_sw[3]|l_sw[4]|l_sw[5]|l_sw[6]|l_sw[7]|l_sw[8]|l_sw[9]|out|pad|padres|vc|vcp|vdd|vddr|vip|vss|z
+ \$74510 D|Q_N$10
+ BOTTOM|TOP|VGND|VSS|anode|cathode|core|h_sw[0]|h_sw[10]|h_sw[1]|h_sw[2]|h_sw[3]|h_sw[4]|h_sw[5]|h_sw[6]|h_sw[7]|h_sw[8]|h_sw[9]|l_sw[0]|l_sw[10]|l_sw[1]|l_sw[2]|l_sw[3]|l_sw[4]|l_sw[5]|l_sw[6]|l_sw[7]|l_sw[8]|l_sw[9]|out|pad|padres|vc|vcp|vdd|vddr|vip|vss|z
+ sg13_lv_nmos L=0.13u W=0.74u AS=0.2516p AD=0.2849p PS=2.16u PD=2.25u rfmode=0
M$1202 \$74487 \$74510
+ BOTTOM|TOP|VGND|VSS|anode|cathode|core|h_sw[0]|h_sw[10]|h_sw[1]|h_sw[2]|h_sw[3]|h_sw[4]|h_sw[5]|h_sw[6]|h_sw[7]|h_sw[8]|h_sw[9]|l_sw[0]|l_sw[10]|l_sw[1]|l_sw[2]|l_sw[3]|l_sw[4]|l_sw[5]|l_sw[6]|l_sw[7]|l_sw[8]|l_sw[9]|out|pad|padres|vc|vcp|vdd|vddr|vip|vss|z
+ BOTTOM|TOP|VGND|VSS|anode|cathode|core|h_sw[0]|h_sw[10]|h_sw[1]|h_sw[2]|h_sw[3]|h_sw[4]|h_sw[5]|h_sw[6]|h_sw[7]|h_sw[8]|h_sw[9]|l_sw[0]|l_sw[10]|l_sw[1]|l_sw[2]|l_sw[3]|l_sw[4]|l_sw[5]|l_sw[6]|l_sw[7]|l_sw[8]|l_sw[9]|out|pad|padres|vc|vcp|vdd|vddr|vip|vss|z
+ sg13_lv_nmos L=0.13u W=0.74u AS=0.2516p AD=0.1406p PS=2.16u PD=1.12u rfmode=0
M$1203
+ BOTTOM|TOP|VGND|VSS|anode|cathode|core|h_sw[0]|h_sw[10]|h_sw[1]|h_sw[2]|h_sw[3]|h_sw[4]|h_sw[5]|h_sw[6]|h_sw[7]|h_sw[8]|h_sw[9]|l_sw[0]|l_sw[10]|l_sw[1]|l_sw[2]|l_sw[3]|l_sw[4]|l_sw[5]|l_sw[6]|l_sw[7]|l_sw[8]|l_sw[9]|out|pad|padres|vc|vcp|vdd|vddr|vip|vss|z
+ \$74487 C|D|Q
+ BOTTOM|TOP|VGND|VSS|anode|cathode|core|h_sw[0]|h_sw[10]|h_sw[1]|h_sw[2]|h_sw[3]|h_sw[4]|h_sw[5]|h_sw[6]|h_sw[7]|h_sw[8]|h_sw[9]|l_sw[0]|l_sw[10]|l_sw[1]|l_sw[2]|l_sw[3]|l_sw[4]|l_sw[5]|l_sw[6]|l_sw[7]|l_sw[8]|l_sw[9]|out|pad|padres|vc|vcp|vdd|vddr|vip|vss|z
+ sg13_lv_nmos L=0.13u W=0.74u AS=0.1406p AD=0.2516p PS=1.12u PD=2.16u rfmode=0
M$1204 \$73981 \$73925
+ BOTTOM|TOP|VGND|VSS|anode|cathode|core|h_sw[0]|h_sw[10]|h_sw[1]|h_sw[2]|h_sw[3]|h_sw[4]|h_sw[5]|h_sw[6]|h_sw[7]|h_sw[8]|h_sw[9]|l_sw[0]|l_sw[10]|l_sw[1]|l_sw[2]|l_sw[3]|l_sw[4]|l_sw[5]|l_sw[6]|l_sw[7]|l_sw[8]|l_sw[9]|out|pad|padres|vc|vcp|vdd|vddr|vip|vss|z
+ BOTTOM|TOP|VGND|VSS|anode|cathode|core|h_sw[0]|h_sw[10]|h_sw[1]|h_sw[2]|h_sw[3]|h_sw[4]|h_sw[5]|h_sw[6]|h_sw[7]|h_sw[8]|h_sw[9]|l_sw[0]|l_sw[10]|l_sw[1]|l_sw[2]|l_sw[3]|l_sw[4]|l_sw[5]|l_sw[6]|l_sw[7]|l_sw[8]|l_sw[9]|out|pad|padres|vc|vcp|vdd|vddr|vip|vss|z
+ sg13_lv_nmos L=0.13u W=0.42u AS=0.1428p AD=0.0798p PS=1.52u PD=0.8u rfmode=0
M$1205
+ BOTTOM|TOP|VGND|VSS|anode|cathode|core|h_sw[0]|h_sw[10]|h_sw[1]|h_sw[2]|h_sw[3]|h_sw[4]|h_sw[5]|h_sw[6]|h_sw[7]|h_sw[8]|h_sw[9]|l_sw[0]|l_sw[10]|l_sw[1]|l_sw[2]|l_sw[3]|l_sw[4]|l_sw[5]|l_sw[6]|l_sw[7]|l_sw[8]|l_sw[9]|out|pad|padres|vc|vcp|vdd|vddr|vip|vss|z
+ RESET_B|Y$2 \$74103
+ BOTTOM|TOP|VGND|VSS|anode|cathode|core|h_sw[0]|h_sw[10]|h_sw[1]|h_sw[2]|h_sw[3]|h_sw[4]|h_sw[5]|h_sw[6]|h_sw[7]|h_sw[8]|h_sw[9]|l_sw[0]|l_sw[10]|l_sw[1]|l_sw[2]|l_sw[3]|l_sw[4]|l_sw[5]|l_sw[6]|l_sw[7]|l_sw[8]|l_sw[9]|out|pad|padres|vc|vcp|vdd|vddr|vip|vss|z
+ sg13_lv_nmos L=0.13u W=0.42u AS=0.0798p AD=0.0378p PS=0.8u PD=0.6u rfmode=0
M$1206 \$74103 \$73924 \$73925
+ BOTTOM|TOP|VGND|VSS|anode|cathode|core|h_sw[0]|h_sw[10]|h_sw[1]|h_sw[2]|h_sw[3]|h_sw[4]|h_sw[5]|h_sw[6]|h_sw[7]|h_sw[8]|h_sw[9]|l_sw[0]|l_sw[10]|l_sw[1]|l_sw[2]|l_sw[3]|l_sw[4]|l_sw[5]|l_sw[6]|l_sw[7]|l_sw[8]|l_sw[9]|out|pad|padres|vc|vcp|vdd|vddr|vip|vss|z
+ sg13_lv_nmos L=0.13u W=0.42u AS=0.0378p AD=0.1428p PS=0.6u PD=1.52u rfmode=0
M$1207
+ BOTTOM|TOP|VGND|VSS|anode|cathode|core|h_sw[0]|h_sw[10]|h_sw[1]|h_sw[2]|h_sw[3]|h_sw[4]|h_sw[5]|h_sw[6]|h_sw[7]|h_sw[8]|h_sw[9]|l_sw[0]|l_sw[10]|l_sw[1]|l_sw[2]|l_sw[3]|l_sw[4]|l_sw[5]|l_sw[6]|l_sw[7]|l_sw[8]|l_sw[9]|out|pad|padres|vc|vcp|vdd|vddr|vip|vss|z
+ \$74511 \$74579
+ BOTTOM|TOP|VGND|VSS|anode|cathode|core|h_sw[0]|h_sw[10]|h_sw[1]|h_sw[2]|h_sw[3]|h_sw[4]|h_sw[5]|h_sw[6]|h_sw[7]|h_sw[8]|h_sw[9]|l_sw[0]|l_sw[10]|l_sw[1]|l_sw[2]|l_sw[3]|l_sw[4]|l_sw[5]|l_sw[6]|l_sw[7]|l_sw[8]|l_sw[9]|out|pad|padres|vc|vcp|vdd|vddr|vip|vss|z
+ sg13_lv_nmos L=0.13u W=0.64u AS=0.213425p AD=0.072p PS=1.62u PD=0.865u
+ rfmode=0
M$1208 \$74579 \$74512 \$74489
+ BOTTOM|TOP|VGND|VSS|anode|cathode|core|h_sw[0]|h_sw[10]|h_sw[1]|h_sw[2]|h_sw[3]|h_sw[4]|h_sw[5]|h_sw[6]|h_sw[7]|h_sw[8]|h_sw[9]|l_sw[0]|l_sw[10]|l_sw[1]|l_sw[2]|l_sw[3]|l_sw[4]|l_sw[5]|l_sw[6]|l_sw[7]|l_sw[8]|l_sw[9]|out|pad|padres|vc|vcp|vdd|vddr|vip|vss|z
+ sg13_lv_nmos L=0.13u W=0.64u AS=0.072p AD=0.141p PS=0.865u PD=1.17u rfmode=0
M$1209 \$74489 \$74488 \$74580
+ BOTTOM|TOP|VGND|VSS|anode|cathode|core|h_sw[0]|h_sw[10]|h_sw[1]|h_sw[2]|h_sw[3]|h_sw[4]|h_sw[5]|h_sw[6]|h_sw[7]|h_sw[8]|h_sw[9]|l_sw[0]|l_sw[10]|l_sw[1]|l_sw[2]|l_sw[3]|l_sw[4]|l_sw[5]|l_sw[6]|l_sw[7]|l_sw[8]|l_sw[9]|out|pad|padres|vc|vcp|vdd|vddr|vip|vss|z
+ sg13_lv_nmos L=0.13u W=0.42u AS=0.141p AD=0.04725p PS=1.17u PD=0.645u rfmode=0
M$1210 \$74580 \$74490
+ BOTTOM|TOP|VGND|VSS|anode|cathode|core|h_sw[0]|h_sw[10]|h_sw[1]|h_sw[2]|h_sw[3]|h_sw[4]|h_sw[5]|h_sw[6]|h_sw[7]|h_sw[8]|h_sw[9]|l_sw[0]|l_sw[10]|l_sw[1]|l_sw[2]|l_sw[3]|l_sw[4]|l_sw[5]|l_sw[6]|l_sw[7]|l_sw[8]|l_sw[9]|out|pad|padres|vc|vcp|vdd|vddr|vip|vss|z
+ BOTTOM|TOP|VGND|VSS|anode|cathode|core|h_sw[0]|h_sw[10]|h_sw[1]|h_sw[2]|h_sw[3]|h_sw[4]|h_sw[5]|h_sw[6]|h_sw[7]|h_sw[8]|h_sw[9]|l_sw[0]|l_sw[10]|l_sw[1]|l_sw[2]|l_sw[3]|l_sw[4]|l_sw[5]|l_sw[6]|l_sw[7]|l_sw[8]|l_sw[9]|out|pad|padres|vc|vcp|vdd|vddr|vip|vss|z
+ sg13_lv_nmos L=0.13u W=0.42u AS=0.04725p AD=0.1428p PS=0.645u PD=1.52u
+ rfmode=0
M$1211
+ BOTTOM|TOP|VGND|VSS|anode|cathode|core|h_sw[0]|h_sw[10]|h_sw[1]|h_sw[2]|h_sw[3]|h_sw[4]|h_sw[5]|h_sw[6]|h_sw[7]|h_sw[8]|h_sw[9]|l_sw[0]|l_sw[10]|l_sw[1]|l_sw[2]|l_sw[3]|l_sw[4]|l_sw[5]|l_sw[6]|l_sw[7]|l_sw[8]|l_sw[9]|out|pad|padres|vc|vcp|vdd|vddr|vip|vss|z
+ \$74488 \$74512
+ BOTTOM|TOP|VGND|VSS|anode|cathode|core|h_sw[0]|h_sw[10]|h_sw[1]|h_sw[2]|h_sw[3]|h_sw[4]|h_sw[5]|h_sw[6]|h_sw[7]|h_sw[8]|h_sw[9]|l_sw[0]|l_sw[10]|l_sw[1]|l_sw[2]|l_sw[3]|l_sw[4]|l_sw[5]|l_sw[6]|l_sw[7]|l_sw[8]|l_sw[9]|out|pad|padres|vc|vcp|vdd|vddr|vip|vss|z
+ sg13_lv_nmos L=0.13u W=0.74u AS=0.213425p AD=0.2775p PS=1.62u PD=2.23u
+ rfmode=0
M$1212 \$74490 \$74489 \$74576
+ BOTTOM|TOP|VGND|VSS|anode|cathode|core|h_sw[0]|h_sw[10]|h_sw[1]|h_sw[2]|h_sw[3]|h_sw[4]|h_sw[5]|h_sw[6]|h_sw[7]|h_sw[8]|h_sw[9]|l_sw[0]|l_sw[10]|l_sw[1]|l_sw[2]|l_sw[3]|l_sw[4]|l_sw[5]|l_sw[6]|l_sw[7]|l_sw[8]|l_sw[9]|out|pad|padres|vc|vcp|vdd|vddr|vip|vss|z
+ sg13_lv_nmos L=0.13u W=0.74u AS=0.2516p AD=0.0777p PS=2.16u PD=0.95u rfmode=0
M$1213 \$74576 RESET_B|Y$1
+ BOTTOM|TOP|VGND|VSS|anode|cathode|core|h_sw[0]|h_sw[10]|h_sw[1]|h_sw[2]|h_sw[3]|h_sw[4]|h_sw[5]|h_sw[6]|h_sw[7]|h_sw[8]|h_sw[9]|l_sw[0]|l_sw[10]|l_sw[1]|l_sw[2]|l_sw[3]|l_sw[4]|l_sw[5]|l_sw[6]|l_sw[7]|l_sw[8]|l_sw[9]|out|pad|padres|vc|vcp|vdd|vddr|vip|vss|z
+ BOTTOM|TOP|VGND|VSS|anode|cathode|core|h_sw[0]|h_sw[10]|h_sw[1]|h_sw[2]|h_sw[3]|h_sw[4]|h_sw[5]|h_sw[6]|h_sw[7]|h_sw[8]|h_sw[9]|l_sw[0]|l_sw[10]|l_sw[1]|l_sw[2]|l_sw[3]|l_sw[4]|l_sw[5]|l_sw[6]|l_sw[7]|l_sw[8]|l_sw[9]|out|pad|padres|vc|vcp|vdd|vddr|vip|vss|z
+ sg13_lv_nmos L=0.13u W=0.74u AS=0.0777p AD=0.1406p PS=0.95u PD=1.12u rfmode=0
M$1214
+ BOTTOM|TOP|VGND|VSS|anode|cathode|core|h_sw[0]|h_sw[10]|h_sw[1]|h_sw[2]|h_sw[3]|h_sw[4]|h_sw[5]|h_sw[6]|h_sw[7]|h_sw[8]|h_sw[9]|l_sw[0]|l_sw[10]|l_sw[1]|l_sw[2]|l_sw[3]|l_sw[4]|l_sw[5]|l_sw[6]|l_sw[7]|l_sw[8]|l_sw[9]|out|pad|padres|vc|vcp|vdd|vddr|vip|vss|z
+ \$74490 A|Q$22
+ BOTTOM|TOP|VGND|VSS|anode|cathode|core|h_sw[0]|h_sw[10]|h_sw[1]|h_sw[2]|h_sw[3]|h_sw[4]|h_sw[5]|h_sw[6]|h_sw[7]|h_sw[8]|h_sw[9]|l_sw[0]|l_sw[10]|l_sw[1]|l_sw[2]|l_sw[3]|l_sw[4]|l_sw[5]|l_sw[6]|l_sw[7]|l_sw[8]|l_sw[9]|out|pad|padres|vc|vcp|vdd|vddr|vip|vss|z
+ sg13_lv_nmos L=0.13u W=0.74u AS=0.1406p AD=0.2516p PS=1.12u PD=2.16u rfmode=0
M$1215
+ BOTTOM|TOP|VGND|VSS|anode|cathode|core|h_sw[0]|h_sw[10]|h_sw[1]|h_sw[2]|h_sw[3]|h_sw[4]|h_sw[5]|h_sw[6]|h_sw[7]|h_sw[8]|h_sw[9]|l_sw[0]|l_sw[10]|l_sw[1]|l_sw[2]|l_sw[3]|l_sw[4]|l_sw[5]|l_sw[6]|l_sw[7]|l_sw[8]|l_sw[9]|out|pad|padres|vc|vcp|vdd|vddr|vip|vss|z
+ \$74490 \$74491
+ BOTTOM|TOP|VGND|VSS|anode|cathode|core|h_sw[0]|h_sw[10]|h_sw[1]|h_sw[2]|h_sw[3]|h_sw[4]|h_sw[5]|h_sw[6]|h_sw[7]|h_sw[8]|h_sw[9]|l_sw[0]|l_sw[10]|l_sw[1]|l_sw[2]|l_sw[3]|l_sw[4]|l_sw[5]|l_sw[6]|l_sw[7]|l_sw[8]|l_sw[9]|out|pad|padres|vc|vcp|vdd|vddr|vip|vss|z
+ sg13_lv_nmos L=0.13u W=0.55u AS=0.1491p AD=0.187p PS=1.18u PD=1.78u rfmode=0
M$1216
+ BOTTOM|TOP|VGND|VSS|anode|cathode|core|h_sw[0]|h_sw[10]|h_sw[1]|h_sw[2]|h_sw[3]|h_sw[4]|h_sw[5]|h_sw[6]|h_sw[7]|h_sw[8]|h_sw[9]|l_sw[0]|l_sw[10]|l_sw[1]|l_sw[2]|l_sw[3]|l_sw[4]|l_sw[5]|l_sw[6]|l_sw[7]|l_sw[8]|l_sw[9]|out|pad|padres|vc|vcp|vdd|vddr|vip|vss|z
+ \$74491 Q_N$34
+ BOTTOM|TOP|VGND|VSS|anode|cathode|core|h_sw[0]|h_sw[10]|h_sw[1]|h_sw[2]|h_sw[3]|h_sw[4]|h_sw[5]|h_sw[6]|h_sw[7]|h_sw[8]|h_sw[9]|l_sw[0]|l_sw[10]|l_sw[1]|l_sw[2]|l_sw[3]|l_sw[4]|l_sw[5]|l_sw[6]|l_sw[7]|l_sw[8]|l_sw[9]|out|pad|padres|vc|vcp|vdd|vddr|vip|vss|z
+ sg13_lv_nmos L=0.13u W=0.74u AS=0.1491p AD=0.2516p PS=1.18u PD=2.16u rfmode=0
M$1217
+ BOTTOM|TOP|VGND|VSS|anode|cathode|core|h_sw[0]|h_sw[10]|h_sw[1]|h_sw[2]|h_sw[3]|h_sw[4]|h_sw[5]|h_sw[6]|h_sw[7]|h_sw[8]|h_sw[9]|l_sw[0]|l_sw[10]|l_sw[1]|l_sw[2]|l_sw[3]|l_sw[4]|l_sw[5]|l_sw[6]|l_sw[7]|l_sw[8]|l_sw[9]|out|pad|padres|vc|vcp|vdd|vddr|vip|vss|z
+ A|Q$22 \$74513
+ BOTTOM|TOP|VGND|VSS|anode|cathode|core|h_sw[0]|h_sw[10]|h_sw[1]|h_sw[2]|h_sw[3]|h_sw[4]|h_sw[5]|h_sw[6]|h_sw[7]|h_sw[8]|h_sw[9]|l_sw[0]|l_sw[10]|l_sw[1]|l_sw[2]|l_sw[3]|l_sw[4]|l_sw[5]|l_sw[6]|l_sw[7]|l_sw[8]|l_sw[9]|out|pad|padres|vc|vcp|vdd|vddr|vip|vss|z
+ sg13_lv_nmos L=0.13u W=0.55u AS=0.14875p AD=0.187p PS=1.16u PD=1.78u rfmode=0
M$1218
+ BOTTOM|TOP|VGND|VSS|anode|cathode|core|h_sw[0]|h_sw[10]|h_sw[1]|h_sw[2]|h_sw[3]|h_sw[4]|h_sw[5]|h_sw[6]|h_sw[7]|h_sw[8]|h_sw[9]|l_sw[0]|l_sw[10]|l_sw[1]|l_sw[2]|l_sw[3]|l_sw[4]|l_sw[5]|l_sw[6]|l_sw[7]|l_sw[8]|l_sw[9]|out|pad|padres|vc|vcp|vdd|vddr|vip|vss|z
+ \$74513 A|X$49
+ BOTTOM|TOP|VGND|VSS|anode|cathode|core|h_sw[0]|h_sw[10]|h_sw[1]|h_sw[2]|h_sw[3]|h_sw[4]|h_sw[5]|h_sw[6]|h_sw[7]|h_sw[8]|h_sw[9]|l_sw[0]|l_sw[10]|l_sw[1]|l_sw[2]|l_sw[3]|l_sw[4]|l_sw[5]|l_sw[6]|l_sw[7]|l_sw[8]|l_sw[9]|out|pad|padres|vc|vcp|vdd|vddr|vip|vss|z
+ sg13_lv_nmos L=0.13u W=0.74u AS=0.14875p AD=0.2886p PS=1.16u PD=2.26u rfmode=0
M$1220
+ BOTTOM|TOP|VGND|VSS|anode|cathode|core|h_sw[0]|h_sw[10]|h_sw[1]|h_sw[2]|h_sw[3]|h_sw[4]|h_sw[5]|h_sw[6]|h_sw[7]|h_sw[8]|h_sw[9]|l_sw[0]|l_sw[10]|l_sw[1]|l_sw[2]|l_sw[3]|l_sw[4]|l_sw[5]|l_sw[6]|l_sw[7]|l_sw[8]|l_sw[9]|out|pad|padres|vc|vcp|vdd|vddr|vip|vss|z
+ A|X$51 \$74514
+ BOTTOM|TOP|VGND|VSS|anode|cathode|core|h_sw[0]|h_sw[10]|h_sw[1]|h_sw[2]|h_sw[3]|h_sw[4]|h_sw[5]|h_sw[6]|h_sw[7]|h_sw[8]|h_sw[9]|l_sw[0]|l_sw[10]|l_sw[1]|l_sw[2]|l_sw[3]|l_sw[4]|l_sw[5]|l_sw[6]|l_sw[7]|l_sw[8]|l_sw[9]|out|pad|padres|vc|vcp|vdd|vddr|vip|vss|z
+ sg13_lv_nmos L=0.13u W=0.55u AS=0.14875p AD=0.187p PS=1.16u PD=1.78u rfmode=0
M$1221
+ BOTTOM|TOP|VGND|VSS|anode|cathode|core|h_sw[0]|h_sw[10]|h_sw[1]|h_sw[2]|h_sw[3]|h_sw[4]|h_sw[5]|h_sw[6]|h_sw[7]|h_sw[8]|h_sw[9]|l_sw[0]|l_sw[10]|l_sw[1]|l_sw[2]|l_sw[3]|l_sw[4]|l_sw[5]|l_sw[6]|l_sw[7]|l_sw[8]|l_sw[9]|out|pad|padres|vc|vcp|vdd|vddr|vip|vss|z
+ \$74514 X|anode|cathode|core|frame|pad|padres
+ BOTTOM|TOP|VGND|VSS|anode|cathode|core|h_sw[0]|h_sw[10]|h_sw[1]|h_sw[2]|h_sw[3]|h_sw[4]|h_sw[5]|h_sw[6]|h_sw[7]|h_sw[8]|h_sw[9]|l_sw[0]|l_sw[10]|l_sw[1]|l_sw[2]|l_sw[3]|l_sw[4]|l_sw[5]|l_sw[6]|l_sw[7]|l_sw[8]|l_sw[9]|out|pad|padres|vc|vcp|vdd|vddr|vip|vss|z
+ sg13_lv_nmos L=0.13u W=0.74u AS=0.14875p AD=0.2886p PS=1.16u PD=2.26u rfmode=0
M$1222
+ BOTTOM|TOP|VGND|VSS|anode|cathode|core|h_sw[0]|h_sw[10]|h_sw[1]|h_sw[2]|h_sw[3]|h_sw[4]|h_sw[5]|h_sw[6]|h_sw[7]|h_sw[8]|h_sw[9]|l_sw[0]|l_sw[10]|l_sw[1]|l_sw[2]|l_sw[3]|l_sw[4]|l_sw[5]|l_sw[6]|l_sw[7]|l_sw[8]|l_sw[9]|out|pad|padres|vc|vcp|vdd|vddr|vip|vss|z
+ A|X$42 \$74515
+ BOTTOM|TOP|VGND|VSS|anode|cathode|core|h_sw[0]|h_sw[10]|h_sw[1]|h_sw[2]|h_sw[3]|h_sw[4]|h_sw[5]|h_sw[6]|h_sw[7]|h_sw[8]|h_sw[9]|l_sw[0]|l_sw[10]|l_sw[1]|l_sw[2]|l_sw[3]|l_sw[4]|l_sw[5]|l_sw[6]|l_sw[7]|l_sw[8]|l_sw[9]|out|pad|padres|vc|vcp|vdd|vddr|vip|vss|z
+ sg13_lv_nmos L=0.13u W=0.55u AS=0.14875p AD=0.187p PS=1.16u PD=1.78u rfmode=0
M$1223
+ BOTTOM|TOP|VGND|VSS|anode|cathode|core|h_sw[0]|h_sw[10]|h_sw[1]|h_sw[2]|h_sw[3]|h_sw[4]|h_sw[5]|h_sw[6]|h_sw[7]|h_sw[8]|h_sw[9]|l_sw[0]|l_sw[10]|l_sw[1]|l_sw[2]|l_sw[3]|l_sw[4]|l_sw[5]|l_sw[6]|l_sw[7]|l_sw[8]|l_sw[9]|out|pad|padres|vc|vcp|vdd|vddr|vip|vss|z
+ \$74515 X|anode|cathode|cko|core|pad|padres
+ BOTTOM|TOP|VGND|VSS|anode|cathode|core|h_sw[0]|h_sw[10]|h_sw[1]|h_sw[2]|h_sw[3]|h_sw[4]|h_sw[5]|h_sw[6]|h_sw[7]|h_sw[8]|h_sw[9]|l_sw[0]|l_sw[10]|l_sw[1]|l_sw[2]|l_sw[3]|l_sw[4]|l_sw[5]|l_sw[6]|l_sw[7]|l_sw[8]|l_sw[9]|out|pad|padres|vc|vcp|vdd|vddr|vip|vss|z
+ sg13_lv_nmos L=0.13u W=0.74u AS=0.14875p AD=0.2886p PS=1.16u PD=2.26u rfmode=0
M$1224 A|Y$25 A|X$17
+ BOTTOM|TOP|VGND|VSS|anode|cathode|core|h_sw[0]|h_sw[10]|h_sw[1]|h_sw[2]|h_sw[3]|h_sw[4]|h_sw[5]|h_sw[6]|h_sw[7]|h_sw[8]|h_sw[9]|l_sw[0]|l_sw[10]|l_sw[1]|l_sw[2]|l_sw[3]|l_sw[4]|l_sw[5]|l_sw[6]|l_sw[7]|l_sw[8]|l_sw[9]|out|pad|padres|vc|vcp|vdd|vddr|vip|vss|z
+ BOTTOM|TOP|VGND|VSS|anode|cathode|core|h_sw[0]|h_sw[10]|h_sw[1]|h_sw[2]|h_sw[3]|h_sw[4]|h_sw[5]|h_sw[6]|h_sw[7]|h_sw[8]|h_sw[9]|l_sw[0]|l_sw[10]|l_sw[1]|l_sw[2]|l_sw[3]|l_sw[4]|l_sw[5]|l_sw[6]|l_sw[7]|l_sw[8]|l_sw[9]|out|pad|padres|vc|vcp|vdd|vddr|vip|vss|z
+ sg13_lv_nmos L=0.13u W=0.74u AS=0.2516p AD=0.2516p PS=2.16u PD=2.16u rfmode=0
M$1225 \$74458 CLK|D|GATE|Q$6
+ BOTTOM|TOP|VGND|VSS|anode|cathode|core|h_sw[0]|h_sw[10]|h_sw[1]|h_sw[2]|h_sw[3]|h_sw[4]|h_sw[5]|h_sw[6]|h_sw[7]|h_sw[8]|h_sw[9]|l_sw[0]|l_sw[10]|l_sw[1]|l_sw[2]|l_sw[3]|l_sw[4]|l_sw[5]|l_sw[6]|l_sw[7]|l_sw[8]|l_sw[9]|out|pad|padres|vc|vcp|vdd|vddr|vip|vss|z
+ BOTTOM|TOP|VGND|VSS|anode|cathode|core|h_sw[0]|h_sw[10]|h_sw[1]|h_sw[2]|h_sw[3]|h_sw[4]|h_sw[5]|h_sw[6]|h_sw[7]|h_sw[8]|h_sw[9]|l_sw[0]|l_sw[10]|l_sw[1]|l_sw[2]|l_sw[3]|l_sw[4]|l_sw[5]|l_sw[6]|l_sw[7]|l_sw[8]|l_sw[9]|out|pad|padres|vc|vcp|vdd|vddr|vip|vss|z
+ sg13_lv_nmos L=0.13u W=0.74u AS=0.2516p AD=0.15055p PS=2.16u PD=1.17u rfmode=0
M$1226
+ BOTTOM|TOP|VGND|VSS|anode|cathode|core|h_sw[0]|h_sw[10]|h_sw[1]|h_sw[2]|h_sw[3]|h_sw[4]|h_sw[5]|h_sw[6]|h_sw[7]|h_sw[8]|h_sw[9]|l_sw[0]|l_sw[10]|l_sw[1]|l_sw[2]|l_sw[3]|l_sw[4]|l_sw[5]|l_sw[6]|l_sw[7]|l_sw[8]|l_sw[9]|out|pad|padres|vc|vcp|vdd|vddr|vip|vss|z
+ D|Q_N$7 \$74600
+ BOTTOM|TOP|VGND|VSS|anode|cathode|core|h_sw[0]|h_sw[10]|h_sw[1]|h_sw[2]|h_sw[3]|h_sw[4]|h_sw[5]|h_sw[6]|h_sw[7]|h_sw[8]|h_sw[9]|l_sw[0]|l_sw[10]|l_sw[1]|l_sw[2]|l_sw[3]|l_sw[4]|l_sw[5]|l_sw[6]|l_sw[7]|l_sw[8]|l_sw[9]|out|pad|padres|vc|vcp|vdd|vddr|vip|vss|z
+ sg13_lv_nmos L=0.13u W=0.55u AS=0.15055p AD=0.187p PS=1.17u PD=1.78u rfmode=0
M$1227 \$74462 CLK|D|GATE|Q$2
+ BOTTOM|TOP|VGND|VSS|anode|cathode|core|h_sw[0]|h_sw[10]|h_sw[1]|h_sw[2]|h_sw[3]|h_sw[4]|h_sw[5]|h_sw[6]|h_sw[7]|h_sw[8]|h_sw[9]|l_sw[0]|l_sw[10]|l_sw[1]|l_sw[2]|l_sw[3]|l_sw[4]|l_sw[5]|l_sw[6]|l_sw[7]|l_sw[8]|l_sw[9]|out|pad|padres|vc|vcp|vdd|vddr|vip|vss|z
+ BOTTOM|TOP|VGND|VSS|anode|cathode|core|h_sw[0]|h_sw[10]|h_sw[1]|h_sw[2]|h_sw[3]|h_sw[4]|h_sw[5]|h_sw[6]|h_sw[7]|h_sw[8]|h_sw[9]|l_sw[0]|l_sw[10]|l_sw[1]|l_sw[2]|l_sw[3]|l_sw[4]|l_sw[5]|l_sw[6]|l_sw[7]|l_sw[8]|l_sw[9]|out|pad|padres|vc|vcp|vdd|vddr|vip|vss|z
+ sg13_lv_nmos L=0.13u W=0.74u AS=0.2516p AD=0.15055p PS=2.16u PD=1.17u rfmode=0
M$1228
+ BOTTOM|TOP|VGND|VSS|anode|cathode|core|h_sw[0]|h_sw[10]|h_sw[1]|h_sw[2]|h_sw[3]|h_sw[4]|h_sw[5]|h_sw[6]|h_sw[7]|h_sw[8]|h_sw[9]|l_sw[0]|l_sw[10]|l_sw[1]|l_sw[2]|l_sw[3]|l_sw[4]|l_sw[5]|l_sw[6]|l_sw[7]|l_sw[8]|l_sw[9]|out|pad|padres|vc|vcp|vdd|vddr|vip|vss|z
+ A_N|D|Q \$74601
+ BOTTOM|TOP|VGND|VSS|anode|cathode|core|h_sw[0]|h_sw[10]|h_sw[1]|h_sw[2]|h_sw[3]|h_sw[4]|h_sw[5]|h_sw[6]|h_sw[7]|h_sw[8]|h_sw[9]|l_sw[0]|l_sw[10]|l_sw[1]|l_sw[2]|l_sw[3]|l_sw[4]|l_sw[5]|l_sw[6]|l_sw[7]|l_sw[8]|l_sw[9]|out|pad|padres|vc|vcp|vdd|vddr|vip|vss|z
+ sg13_lv_nmos L=0.13u W=0.55u AS=0.15055p AD=0.187p PS=1.17u PD=1.78u rfmode=0
M$1232 A|Y$27 A|X$23
+ BOTTOM|TOP|VGND|VSS|anode|cathode|core|h_sw[0]|h_sw[10]|h_sw[1]|h_sw[2]|h_sw[3]|h_sw[4]|h_sw[5]|h_sw[6]|h_sw[7]|h_sw[8]|h_sw[9]|l_sw[0]|l_sw[10]|l_sw[1]|l_sw[2]|l_sw[3]|l_sw[4]|l_sw[5]|l_sw[6]|l_sw[7]|l_sw[8]|l_sw[9]|out|pad|padres|vc|vcp|vdd|vddr|vip|vss|z
+ BOTTOM|TOP|VGND|VSS|anode|cathode|core|h_sw[0]|h_sw[10]|h_sw[1]|h_sw[2]|h_sw[3]|h_sw[4]|h_sw[5]|h_sw[6]|h_sw[7]|h_sw[8]|h_sw[9]|l_sw[0]|l_sw[10]|l_sw[1]|l_sw[2]|l_sw[3]|l_sw[4]|l_sw[5]|l_sw[6]|l_sw[7]|l_sw[8]|l_sw[9]|out|pad|padres|vc|vcp|vdd|vddr|vip|vss|z
+ sg13_lv_nmos L=0.13u W=0.74u AS=0.2516p AD=0.2516p PS=2.16u PD=2.16u rfmode=0
M$1233 A|Y$26 A|X$24
+ BOTTOM|TOP|VGND|VSS|anode|cathode|core|h_sw[0]|h_sw[10]|h_sw[1]|h_sw[2]|h_sw[3]|h_sw[4]|h_sw[5]|h_sw[6]|h_sw[7]|h_sw[8]|h_sw[9]|l_sw[0]|l_sw[10]|l_sw[1]|l_sw[2]|l_sw[3]|l_sw[4]|l_sw[5]|l_sw[6]|l_sw[7]|l_sw[8]|l_sw[9]|out|pad|padres|vc|vcp|vdd|vddr|vip|vss|z
+ BOTTOM|TOP|VGND|VSS|anode|cathode|core|h_sw[0]|h_sw[10]|h_sw[1]|h_sw[2]|h_sw[3]|h_sw[4]|h_sw[5]|h_sw[6]|h_sw[7]|h_sw[8]|h_sw[9]|l_sw[0]|l_sw[10]|l_sw[1]|l_sw[2]|l_sw[3]|l_sw[4]|l_sw[5]|l_sw[6]|l_sw[7]|l_sw[8]|l_sw[9]|out|pad|padres|vc|vcp|vdd|vddr|vip|vss|z
+ sg13_lv_nmos L=0.13u W=0.74u AS=0.2516p AD=0.2516p PS=2.16u PD=2.16u rfmode=0
M$1234
+ BOTTOM|TOP|VGND|VSS|anode|cathode|core|h_sw[0]|h_sw[10]|h_sw[1]|h_sw[2]|h_sw[3]|h_sw[4]|h_sw[5]|h_sw[6]|h_sw[7]|h_sw[8]|h_sw[9]|l_sw[0]|l_sw[10]|l_sw[1]|l_sw[2]|l_sw[3]|l_sw[4]|l_sw[5]|l_sw[6]|l_sw[7]|l_sw[8]|l_sw[9]|out|pad|padres|vc|vcp|vdd|vddr|vip|vss|z
+ RESET_B|Y$1 \$74588
+ BOTTOM|TOP|VGND|VSS|anode|cathode|core|h_sw[0]|h_sw[10]|h_sw[1]|h_sw[2]|h_sw[3]|h_sw[4]|h_sw[5]|h_sw[6]|h_sw[7]|h_sw[8]|h_sw[9]|l_sw[0]|l_sw[10]|l_sw[1]|l_sw[2]|l_sw[3]|l_sw[4]|l_sw[5]|l_sw[6]|l_sw[7]|l_sw[8]|l_sw[9]|out|pad|padres|vc|vcp|vdd|vddr|vip|vss|z
+ sg13_lv_nmos L=0.13u W=0.42u AS=0.1701p AD=0.0378p PS=1.65u PD=0.6u rfmode=0
M$1235 \$74588 \$74429 \$74465
+ BOTTOM|TOP|VGND|VSS|anode|cathode|core|h_sw[0]|h_sw[10]|h_sw[1]|h_sw[2]|h_sw[3]|h_sw[4]|h_sw[5]|h_sw[6]|h_sw[7]|h_sw[8]|h_sw[9]|l_sw[0]|l_sw[10]|l_sw[1]|l_sw[2]|l_sw[3]|l_sw[4]|l_sw[5]|l_sw[6]|l_sw[7]|l_sw[8]|l_sw[9]|out|pad|padres|vc|vcp|vdd|vddr|vip|vss|z
+ sg13_lv_nmos L=0.13u W=0.42u AS=0.0378p AD=0.1428p PS=0.6u PD=1.52u rfmode=0
M$1236
+ BOTTOM|TOP|VGND|VSS|anode|cathode|core|h_sw[0]|h_sw[10]|h_sw[1]|h_sw[2]|h_sw[3]|h_sw[4]|h_sw[5]|h_sw[6]|h_sw[7]|h_sw[8]|h_sw[9]|l_sw[0]|l_sw[10]|l_sw[1]|l_sw[2]|l_sw[3]|l_sw[4]|l_sw[5]|l_sw[6]|l_sw[7]|l_sw[8]|l_sw[9]|out|pad|padres|vc|vcp|vdd|vddr|vip|vss|z
+ \$74466 \$74501
+ BOTTOM|TOP|VGND|VSS|anode|cathode|core|h_sw[0]|h_sw[10]|h_sw[1]|h_sw[2]|h_sw[3]|h_sw[4]|h_sw[5]|h_sw[6]|h_sw[7]|h_sw[8]|h_sw[9]|l_sw[0]|l_sw[10]|l_sw[1]|l_sw[2]|l_sw[3]|l_sw[4]|l_sw[5]|l_sw[6]|l_sw[7]|l_sw[8]|l_sw[9]|out|pad|padres|vc|vcp|vdd|vddr|vip|vss|z
+ sg13_lv_nmos L=0.13u W=0.74u AS=0.317325p AD=0.2516p PS=1.805u PD=2.16u
+ rfmode=0
M$1237
+ BOTTOM|TOP|VGND|VSS|anode|cathode|core|h_sw[0]|h_sw[10]|h_sw[1]|h_sw[2]|h_sw[3]|h_sw[4]|h_sw[5]|h_sw[6]|h_sw[7]|h_sw[8]|h_sw[9]|l_sw[0]|l_sw[10]|l_sw[1]|l_sw[2]|l_sw[3]|l_sw[4]|l_sw[5]|l_sw[6]|l_sw[7]|l_sw[8]|l_sw[9]|out|pad|padres|vc|vcp|vdd|vddr|vip|vss|z
+ CLK|D|GATE|Q$9 \$74466
+ BOTTOM|TOP|VGND|VSS|anode|cathode|core|h_sw[0]|h_sw[10]|h_sw[1]|h_sw[2]|h_sw[3]|h_sw[4]|h_sw[5]|h_sw[6]|h_sw[7]|h_sw[8]|h_sw[9]|l_sw[0]|l_sw[10]|l_sw[1]|l_sw[2]|l_sw[3]|l_sw[4]|l_sw[5]|l_sw[6]|l_sw[7]|l_sw[8]|l_sw[9]|out|pad|padres|vc|vcp|vdd|vddr|vip|vss|z
+ sg13_lv_nmos L=0.13u W=0.74u AS=0.317325p AD=0.2516p PS=1.805u PD=2.16u
+ rfmode=0
M$1238 \$74502 \$74466 \$74467
+ BOTTOM|TOP|VGND|VSS|anode|cathode|core|h_sw[0]|h_sw[10]|h_sw[1]|h_sw[2]|h_sw[3]|h_sw[4]|h_sw[5]|h_sw[6]|h_sw[7]|h_sw[8]|h_sw[9]|l_sw[0]|l_sw[10]|l_sw[1]|l_sw[2]|l_sw[3]|l_sw[4]|l_sw[5]|l_sw[6]|l_sw[7]|l_sw[8]|l_sw[9]|out|pad|padres|vc|vcp|vdd|vddr|vip|vss|z
+ sg13_lv_nmos L=0.13u W=0.42u AS=0.12665p AD=0.1428p PS=1.145u PD=1.52u
+ rfmode=0
M$1239 \$74429 \$74501 \$74502
+ BOTTOM|TOP|VGND|VSS|anode|cathode|core|h_sw[0]|h_sw[10]|h_sw[1]|h_sw[2]|h_sw[3]|h_sw[4]|h_sw[5]|h_sw[6]|h_sw[7]|h_sw[8]|h_sw[9]|l_sw[0]|l_sw[10]|l_sw[1]|l_sw[2]|l_sw[3]|l_sw[4]|l_sw[5]|l_sw[6]|l_sw[7]|l_sw[8]|l_sw[9]|out|pad|padres|vc|vcp|vdd|vddr|vip|vss|z
+ sg13_lv_nmos L=0.13u W=0.74u AS=0.3473p AD=0.12665p PS=2.71u PD=1.145u
+ rfmode=0
M$1240
+ BOTTOM|TOP|VGND|VSS|anode|cathode|core|h_sw[0]|h_sw[10]|h_sw[1]|h_sw[2]|h_sw[3]|h_sw[4]|h_sw[5]|h_sw[6]|h_sw[7]|h_sw[8]|h_sw[9]|l_sw[0]|l_sw[10]|l_sw[1]|l_sw[2]|l_sw[3]|l_sw[4]|l_sw[5]|l_sw[6]|l_sw[7]|l_sw[8]|l_sw[9]|out|pad|padres|vc|vcp|vdd|vddr|vip|vss|z
+ RESET_B|Y$1 \$74591
+ BOTTOM|TOP|VGND|VSS|anode|cathode|core|h_sw[0]|h_sw[10]|h_sw[1]|h_sw[2]|h_sw[3]|h_sw[4]|h_sw[5]|h_sw[6]|h_sw[7]|h_sw[8]|h_sw[9]|l_sw[0]|l_sw[10]|l_sw[1]|l_sw[2]|l_sw[3]|l_sw[4]|l_sw[5]|l_sw[6]|l_sw[7]|l_sw[8]|l_sw[9]|out|pad|padres|vc|vcp|vdd|vddr|vip|vss|z
+ sg13_lv_nmos L=0.13u W=0.42u AS=0.1701p AD=0.0378p PS=1.65u PD=0.6u rfmode=0
M$1241 \$74591 \$74431 \$74471
+ BOTTOM|TOP|VGND|VSS|anode|cathode|core|h_sw[0]|h_sw[10]|h_sw[1]|h_sw[2]|h_sw[3]|h_sw[4]|h_sw[5]|h_sw[6]|h_sw[7]|h_sw[8]|h_sw[9]|l_sw[0]|l_sw[10]|l_sw[1]|l_sw[2]|l_sw[3]|l_sw[4]|l_sw[5]|l_sw[6]|l_sw[7]|l_sw[8]|l_sw[9]|out|pad|padres|vc|vcp|vdd|vddr|vip|vss|z
+ sg13_lv_nmos L=0.13u W=0.42u AS=0.0378p AD=0.1428p PS=0.6u PD=1.52u rfmode=0
M$1242
+ BOTTOM|TOP|VGND|VSS|anode|cathode|core|h_sw[0]|h_sw[10]|h_sw[1]|h_sw[2]|h_sw[3]|h_sw[4]|h_sw[5]|h_sw[6]|h_sw[7]|h_sw[8]|h_sw[9]|l_sw[0]|l_sw[10]|l_sw[1]|l_sw[2]|l_sw[3]|l_sw[4]|l_sw[5]|l_sw[6]|l_sw[7]|l_sw[8]|l_sw[9]|out|pad|padres|vc|vcp|vdd|vddr|vip|vss|z
+ \$74472 \$74504
+ BOTTOM|TOP|VGND|VSS|anode|cathode|core|h_sw[0]|h_sw[10]|h_sw[1]|h_sw[2]|h_sw[3]|h_sw[4]|h_sw[5]|h_sw[6]|h_sw[7]|h_sw[8]|h_sw[9]|l_sw[0]|l_sw[10]|l_sw[1]|l_sw[2]|l_sw[3]|l_sw[4]|l_sw[5]|l_sw[6]|l_sw[7]|l_sw[8]|l_sw[9]|out|pad|padres|vc|vcp|vdd|vddr|vip|vss|z
+ sg13_lv_nmos L=0.13u W=0.74u AS=0.317325p AD=0.2516p PS=1.805u PD=2.16u
+ rfmode=0
M$1243
+ BOTTOM|TOP|VGND|VSS|anode|cathode|core|h_sw[0]|h_sw[10]|h_sw[1]|h_sw[2]|h_sw[3]|h_sw[4]|h_sw[5]|h_sw[6]|h_sw[7]|h_sw[8]|h_sw[9]|l_sw[0]|l_sw[10]|l_sw[1]|l_sw[2]|l_sw[3]|l_sw[4]|l_sw[5]|l_sw[6]|l_sw[7]|l_sw[8]|l_sw[9]|out|pad|padres|vc|vcp|vdd|vddr|vip|vss|z
+ CLK|D|GATE|Q$10 \$74472
+ BOTTOM|TOP|VGND|VSS|anode|cathode|core|h_sw[0]|h_sw[10]|h_sw[1]|h_sw[2]|h_sw[3]|h_sw[4]|h_sw[5]|h_sw[6]|h_sw[7]|h_sw[8]|h_sw[9]|l_sw[0]|l_sw[10]|l_sw[1]|l_sw[2]|l_sw[3]|l_sw[4]|l_sw[5]|l_sw[6]|l_sw[7]|l_sw[8]|l_sw[9]|out|pad|padres|vc|vcp|vdd|vddr|vip|vss|z
+ sg13_lv_nmos L=0.13u W=0.74u AS=0.317325p AD=0.2516p PS=1.805u PD=2.16u
+ rfmode=0
M$1244 \$74505 \$74472 \$74473
+ BOTTOM|TOP|VGND|VSS|anode|cathode|core|h_sw[0]|h_sw[10]|h_sw[1]|h_sw[2]|h_sw[3]|h_sw[4]|h_sw[5]|h_sw[6]|h_sw[7]|h_sw[8]|h_sw[9]|l_sw[0]|l_sw[10]|l_sw[1]|l_sw[2]|l_sw[3]|l_sw[4]|l_sw[5]|l_sw[6]|l_sw[7]|l_sw[8]|l_sw[9]|out|pad|padres|vc|vcp|vdd|vddr|vip|vss|z
+ sg13_lv_nmos L=0.13u W=0.42u AS=0.12665p AD=0.1428p PS=1.145u PD=1.52u
+ rfmode=0
M$1245 \$74431 \$74504 \$74505
+ BOTTOM|TOP|VGND|VSS|anode|cathode|core|h_sw[0]|h_sw[10]|h_sw[1]|h_sw[2]|h_sw[3]|h_sw[4]|h_sw[5]|h_sw[6]|h_sw[7]|h_sw[8]|h_sw[9]|l_sw[0]|l_sw[10]|l_sw[1]|l_sw[2]|l_sw[3]|l_sw[4]|l_sw[5]|l_sw[6]|l_sw[7]|l_sw[8]|l_sw[9]|out|pad|padres|vc|vcp|vdd|vddr|vip|vss|z
+ sg13_lv_nmos L=0.13u W=0.74u AS=0.3473p AD=0.12665p PS=2.71u PD=1.145u
+ rfmode=0
M$1246
+ BOTTOM|TOP|VGND|VSS|anode|cathode|core|h_sw[0]|h_sw[10]|h_sw[1]|h_sw[2]|h_sw[3]|h_sw[4]|h_sw[5]|h_sw[6]|h_sw[7]|h_sw[8]|h_sw[9]|l_sw[0]|l_sw[10]|l_sw[1]|l_sw[2]|l_sw[3]|l_sw[4]|l_sw[5]|l_sw[6]|l_sw[7]|l_sw[8]|l_sw[9]|out|pad|padres|vc|vcp|vdd|vddr|vip|vss|z
+ A|D|Q$1 \$74506
+ BOTTOM|TOP|VGND|VSS|anode|cathode|core|h_sw[0]|h_sw[10]|h_sw[1]|h_sw[2]|h_sw[3]|h_sw[4]|h_sw[5]|h_sw[6]|h_sw[7]|h_sw[8]|h_sw[9]|l_sw[0]|l_sw[10]|l_sw[1]|l_sw[2]|l_sw[3]|l_sw[4]|l_sw[5]|l_sw[6]|l_sw[7]|l_sw[8]|l_sw[9]|out|pad|padres|vc|vcp|vdd|vddr|vip|vss|z
+ sg13_lv_nmos L=0.13u W=0.55u AS=0.15055p AD=0.187p PS=1.17u PD=1.78u rfmode=0
M$1247
+ BOTTOM|TOP|VGND|VSS|anode|cathode|core|h_sw[0]|h_sw[10]|h_sw[1]|h_sw[2]|h_sw[3]|h_sw[4]|h_sw[5]|h_sw[6]|h_sw[7]|h_sw[8]|h_sw[9]|l_sw[0]|l_sw[10]|l_sw[1]|l_sw[2]|l_sw[3]|l_sw[4]|l_sw[5]|l_sw[6]|l_sw[7]|l_sw[8]|l_sw[9]|out|pad|padres|vc|vcp|vdd|vddr|vip|vss|z
+ CLK|D|GATE|Q$10 \$74476
+ BOTTOM|TOP|VGND|VSS|anode|cathode|core|h_sw[0]|h_sw[10]|h_sw[1]|h_sw[2]|h_sw[3]|h_sw[4]|h_sw[5]|h_sw[6]|h_sw[7]|h_sw[8]|h_sw[9]|l_sw[0]|l_sw[10]|l_sw[1]|l_sw[2]|l_sw[3]|l_sw[4]|l_sw[5]|l_sw[6]|l_sw[7]|l_sw[8]|l_sw[9]|out|pad|padres|vc|vcp|vdd|vddr|vip|vss|z
+ sg13_lv_nmos L=0.13u W=0.74u AS=0.15055p AD=0.2516p PS=1.17u PD=2.16u rfmode=0
M$1248
+ BOTTOM|TOP|VGND|VSS|anode|cathode|core|h_sw[0]|h_sw[10]|h_sw[1]|h_sw[2]|h_sw[3]|h_sw[4]|h_sw[5]|h_sw[6]|h_sw[7]|h_sw[8]|h_sw[9]|l_sw[0]|l_sw[10]|l_sw[1]|l_sw[2]|l_sw[3]|l_sw[4]|l_sw[5]|l_sw[6]|l_sw[7]|l_sw[8]|l_sw[9]|out|pad|padres|vc|vcp|vdd|vddr|vip|vss|z
+ RESET_B|Y$1 \$74584
+ BOTTOM|TOP|VGND|VSS|anode|cathode|core|h_sw[0]|h_sw[10]|h_sw[1]|h_sw[2]|h_sw[3]|h_sw[4]|h_sw[5]|h_sw[6]|h_sw[7]|h_sw[8]|h_sw[9]|l_sw[0]|l_sw[10]|l_sw[1]|l_sw[2]|l_sw[3]|l_sw[4]|l_sw[5]|l_sw[6]|l_sw[7]|l_sw[8]|l_sw[9]|out|pad|padres|vc|vcp|vdd|vddr|vip|vss|z
+ sg13_lv_nmos L=0.13u W=0.42u AS=0.1701p AD=0.0378p PS=1.65u PD=0.6u rfmode=0
M$1249 \$74584 \$74432 \$74482
+ BOTTOM|TOP|VGND|VSS|anode|cathode|core|h_sw[0]|h_sw[10]|h_sw[1]|h_sw[2]|h_sw[3]|h_sw[4]|h_sw[5]|h_sw[6]|h_sw[7]|h_sw[8]|h_sw[9]|l_sw[0]|l_sw[10]|l_sw[1]|l_sw[2]|l_sw[3]|l_sw[4]|l_sw[5]|l_sw[6]|l_sw[7]|l_sw[8]|l_sw[9]|out|pad|padres|vc|vcp|vdd|vddr|vip|vss|z
+ sg13_lv_nmos L=0.13u W=0.42u AS=0.0378p AD=0.1428p PS=0.6u PD=1.52u rfmode=0
M$1250
+ BOTTOM|TOP|VGND|VSS|anode|cathode|core|h_sw[0]|h_sw[10]|h_sw[1]|h_sw[2]|h_sw[3]|h_sw[4]|h_sw[5]|h_sw[6]|h_sw[7]|h_sw[8]|h_sw[9]|l_sw[0]|l_sw[10]|l_sw[1]|l_sw[2]|l_sw[3]|l_sw[4]|l_sw[5]|l_sw[6]|l_sw[7]|l_sw[8]|l_sw[9]|out|pad|padres|vc|vcp|vdd|vddr|vip|vss|z
+ \$74483 \$74509
+ BOTTOM|TOP|VGND|VSS|anode|cathode|core|h_sw[0]|h_sw[10]|h_sw[1]|h_sw[2]|h_sw[3]|h_sw[4]|h_sw[5]|h_sw[6]|h_sw[7]|h_sw[8]|h_sw[9]|l_sw[0]|l_sw[10]|l_sw[1]|l_sw[2]|l_sw[3]|l_sw[4]|l_sw[5]|l_sw[6]|l_sw[7]|l_sw[8]|l_sw[9]|out|pad|padres|vc|vcp|vdd|vddr|vip|vss|z
+ sg13_lv_nmos L=0.13u W=0.74u AS=0.317325p AD=0.2516p PS=1.805u PD=2.16u
+ rfmode=0
M$1251
+ BOTTOM|TOP|VGND|VSS|anode|cathode|core|h_sw[0]|h_sw[10]|h_sw[1]|h_sw[2]|h_sw[3]|h_sw[4]|h_sw[5]|h_sw[6]|h_sw[7]|h_sw[8]|h_sw[9]|l_sw[0]|l_sw[10]|l_sw[1]|l_sw[2]|l_sw[3]|l_sw[4]|l_sw[5]|l_sw[6]|l_sw[7]|l_sw[8]|l_sw[9]|out|pad|padres|vc|vcp|vdd|vddr|vip|vss|z
+ CLK|D|GATE|Q$8 \$74483
+ BOTTOM|TOP|VGND|VSS|anode|cathode|core|h_sw[0]|h_sw[10]|h_sw[1]|h_sw[2]|h_sw[3]|h_sw[4]|h_sw[5]|h_sw[6]|h_sw[7]|h_sw[8]|h_sw[9]|l_sw[0]|l_sw[10]|l_sw[1]|l_sw[2]|l_sw[3]|l_sw[4]|l_sw[5]|l_sw[6]|l_sw[7]|l_sw[8]|l_sw[9]|out|pad|padres|vc|vcp|vdd|vddr|vip|vss|z
+ sg13_lv_nmos L=0.13u W=0.74u AS=0.317325p AD=0.2516p PS=1.805u PD=2.16u
+ rfmode=0
M$1252 \$74510 \$74483 \$74484
+ BOTTOM|TOP|VGND|VSS|anode|cathode|core|h_sw[0]|h_sw[10]|h_sw[1]|h_sw[2]|h_sw[3]|h_sw[4]|h_sw[5]|h_sw[6]|h_sw[7]|h_sw[8]|h_sw[9]|l_sw[0]|l_sw[10]|l_sw[1]|l_sw[2]|l_sw[3]|l_sw[4]|l_sw[5]|l_sw[6]|l_sw[7]|l_sw[8]|l_sw[9]|out|pad|padres|vc|vcp|vdd|vddr|vip|vss|z
+ sg13_lv_nmos L=0.13u W=0.42u AS=0.12665p AD=0.1428p PS=1.145u PD=1.52u
+ rfmode=0
M$1253 \$74432 \$74509 \$74510
+ BOTTOM|TOP|VGND|VSS|anode|cathode|core|h_sw[0]|h_sw[10]|h_sw[1]|h_sw[2]|h_sw[3]|h_sw[4]|h_sw[5]|h_sw[6]|h_sw[7]|h_sw[8]|h_sw[9]|l_sw[0]|l_sw[10]|l_sw[1]|l_sw[2]|l_sw[3]|l_sw[4]|l_sw[5]|l_sw[6]|l_sw[7]|l_sw[8]|l_sw[9]|out|pad|padres|vc|vcp|vdd|vddr|vip|vss|z
+ sg13_lv_nmos L=0.13u W=0.74u AS=0.3473p AD=0.12665p PS=2.71u PD=1.145u
+ rfmode=0
M$1254
+ BOTTOM|TOP|VGND|VSS|anode|cathode|core|h_sw[0]|h_sw[10]|h_sw[1]|h_sw[2]|h_sw[3]|h_sw[4]|h_sw[5]|h_sw[6]|h_sw[7]|h_sw[8]|h_sw[9]|l_sw[0]|l_sw[10]|l_sw[1]|l_sw[2]|l_sw[3]|l_sw[4]|l_sw[5]|l_sw[6]|l_sw[7]|l_sw[8]|l_sw[9]|out|pad|padres|vc|vcp|vdd|vddr|vip|vss|z
+ C|D|Q \$74511
+ BOTTOM|TOP|VGND|VSS|anode|cathode|core|h_sw[0]|h_sw[10]|h_sw[1]|h_sw[2]|h_sw[3]|h_sw[4]|h_sw[5]|h_sw[6]|h_sw[7]|h_sw[8]|h_sw[9]|l_sw[0]|l_sw[10]|l_sw[1]|l_sw[2]|l_sw[3]|l_sw[4]|l_sw[5]|l_sw[6]|l_sw[7]|l_sw[8]|l_sw[9]|out|pad|padres|vc|vcp|vdd|vddr|vip|vss|z
+ sg13_lv_nmos L=0.13u W=0.55u AS=0.15055p AD=0.187p PS=1.17u PD=1.78u rfmode=0
M$1255
+ BOTTOM|TOP|VGND|VSS|anode|cathode|core|h_sw[0]|h_sw[10]|h_sw[1]|h_sw[2]|h_sw[3]|h_sw[4]|h_sw[5]|h_sw[6]|h_sw[7]|h_sw[8]|h_sw[9]|l_sw[0]|l_sw[10]|l_sw[1]|l_sw[2]|l_sw[3]|l_sw[4]|l_sw[5]|l_sw[6]|l_sw[7]|l_sw[8]|l_sw[9]|out|pad|padres|vc|vcp|vdd|vddr|vip|vss|z
+ CLK|D|GATE|Q$8 \$74488
+ BOTTOM|TOP|VGND|VSS|anode|cathode|core|h_sw[0]|h_sw[10]|h_sw[1]|h_sw[2]|h_sw[3]|h_sw[4]|h_sw[5]|h_sw[6]|h_sw[7]|h_sw[8]|h_sw[9]|l_sw[0]|l_sw[10]|l_sw[1]|l_sw[2]|l_sw[3]|l_sw[4]|l_sw[5]|l_sw[6]|l_sw[7]|l_sw[8]|l_sw[9]|out|pad|padres|vc|vcp|vdd|vddr|vip|vss|z
+ sg13_lv_nmos L=0.13u W=0.74u AS=0.15055p AD=0.2516p PS=1.17u PD=2.16u rfmode=0
M$1256
+ BOTTOM|TOP|VGND|VSS|anode|cathode|core|h_sw[0]|h_sw[10]|h_sw[1]|h_sw[2]|h_sw[3]|h_sw[4]|h_sw[5]|h_sw[6]|h_sw[7]|h_sw[8]|h_sw[9]|l_sw[0]|l_sw[10]|l_sw[1]|l_sw[2]|l_sw[3]|l_sw[4]|l_sw[5]|l_sw[6]|l_sw[7]|l_sw[8]|l_sw[9]|out|pad|padres|vc|vcp|vdd|vddr|vip|vss|z
+ A|X$49 A|Y$13
+ BOTTOM|TOP|VGND|VSS|anode|cathode|core|h_sw[0]|h_sw[10]|h_sw[1]|h_sw[2]|h_sw[3]|h_sw[4]|h_sw[5]|h_sw[6]|h_sw[7]|h_sw[8]|h_sw[9]|l_sw[0]|l_sw[10]|l_sw[1]|l_sw[2]|l_sw[3]|l_sw[4]|l_sw[5]|l_sw[6]|l_sw[7]|l_sw[8]|l_sw[9]|out|pad|padres|vc|vcp|vdd|vddr|vip|vss|z
+ sg13_lv_nmos L=0.13u W=0.74u AS=0.2516p AD=0.2516p PS=2.16u PD=2.16u rfmode=0
M$1257
+ BOTTOM|TOP|VGND|VSS|anode|cathode|core|h_sw[0]|h_sw[10]|h_sw[1]|h_sw[2]|h_sw[3]|h_sw[4]|h_sw[5]|h_sw[6]|h_sw[7]|h_sw[8]|h_sw[9]|l_sw[0]|l_sw[10]|l_sw[1]|l_sw[2]|l_sw[3]|l_sw[4]|l_sw[5]|l_sw[6]|l_sw[7]|l_sw[8]|l_sw[9]|out|pad|padres|vc|vcp|vdd|vddr|vip|vss|z
+ A|Y$28 \$77595
+ BOTTOM|TOP|VGND|VSS|anode|cathode|core|h_sw[0]|h_sw[10]|h_sw[1]|h_sw[2]|h_sw[3]|h_sw[4]|h_sw[5]|h_sw[6]|h_sw[7]|h_sw[8]|h_sw[9]|l_sw[0]|l_sw[10]|l_sw[1]|l_sw[2]|l_sw[3]|l_sw[4]|l_sw[5]|l_sw[6]|l_sw[7]|l_sw[8]|l_sw[9]|out|pad|padres|vc|vcp|vdd|vddr|vip|vss|z
+ sg13_lv_nmos L=0.4u W=1.3u AS=0.442p AD=0.442p PS=3.28u PD=3.28u rfmode=0
M$1258 \$73145 VDD|VPWR|vdd \$74599
+ BOTTOM|TOP|VGND|VSS|anode|cathode|core|h_sw[0]|h_sw[10]|h_sw[1]|h_sw[2]|h_sw[3]|h_sw[4]|h_sw[5]|h_sw[6]|h_sw[7]|h_sw[8]|h_sw[9]|l_sw[0]|l_sw[10]|l_sw[1]|l_sw[2]|l_sw[3]|l_sw[4]|l_sw[5]|l_sw[6]|l_sw[7]|l_sw[8]|l_sw[9]|out|pad|padres|vc|vcp|vdd|vddr|vip|vss|z
+ sg13_lv_nmos L=0.13u W=3u AS=1.02p AD=0.57p PS=6.68u PD=3.38u rfmode=0
M$1259 \$74599 A|Y$28
+ BOTTOM|TOP|VGND|VSS|anode|cathode|core|h_sw[0]|h_sw[10]|h_sw[1]|h_sw[2]|h_sw[3]|h_sw[4]|h_sw[5]|h_sw[6]|h_sw[7]|h_sw[8]|h_sw[9]|l_sw[0]|l_sw[10]|l_sw[1]|l_sw[2]|l_sw[3]|l_sw[4]|l_sw[5]|l_sw[6]|l_sw[7]|l_sw[8]|l_sw[9]|out|pad|padres|vc|vcp|vdd|vddr|vip|vss|z
+ BOTTOM|TOP|VGND|VSS|anode|cathode|core|h_sw[0]|h_sw[10]|h_sw[1]|h_sw[2]|h_sw[3]|h_sw[4]|h_sw[5]|h_sw[6]|h_sw[7]|h_sw[8]|h_sw[9]|l_sw[0]|l_sw[10]|l_sw[1]|l_sw[2]|l_sw[3]|l_sw[4]|l_sw[5]|l_sw[6]|l_sw[7]|l_sw[8]|l_sw[9]|out|pad|padres|vc|vcp|vdd|vddr|vip|vss|z
+ sg13_lv_nmos L=0.13u W=3u AS=0.57p AD=1.02p PS=3.38u PD=6.68u rfmode=0
M$1260 \$77595 \$73145 anode|cathode|core|in|pad|padres|vip
+ BOTTOM|TOP|VGND|VSS|anode|cathode|core|h_sw[0]|h_sw[10]|h_sw[1]|h_sw[2]|h_sw[3]|h_sw[4]|h_sw[5]|h_sw[6]|h_sw[7]|h_sw[8]|h_sw[9]|l_sw[0]|l_sw[10]|l_sw[1]|l_sw[2]|l_sw[3]|l_sw[4]|l_sw[5]|l_sw[6]|l_sw[7]|l_sw[8]|l_sw[9]|out|pad|padres|vc|vcp|vdd|vddr|vip|vss|z
+ sg13_lv_nmos L=0.13u W=3u AS=1.02p AD=1.02p PS=6.68u PD=6.68u rfmode=0
M$1261 \$74500 \$74466 \$74603
+ BOTTOM|TOP|VGND|VSS|anode|cathode|core|h_sw[0]|h_sw[10]|h_sw[1]|h_sw[2]|h_sw[3]|h_sw[4]|h_sw[5]|h_sw[6]|h_sw[7]|h_sw[8]|h_sw[9]|l_sw[0]|l_sw[10]|l_sw[1]|l_sw[2]|l_sw[3]|l_sw[4]|l_sw[5]|l_sw[6]|l_sw[7]|l_sw[8]|l_sw[9]|out|pad|padres|vc|vcp|vdd|vddr|vip|vss|z
+ sg13_lv_nmos L=0.13u W=0.42u AS=0.1296p AD=0.0798p PS=1.52u PD=0.8u rfmode=0
M$1262 \$74603 \$74501 \$74465
+ BOTTOM|TOP|VGND|VSS|anode|cathode|core|h_sw[0]|h_sw[10]|h_sw[1]|h_sw[2]|h_sw[3]|h_sw[4]|h_sw[5]|h_sw[6]|h_sw[7]|h_sw[8]|h_sw[9]|l_sw[0]|l_sw[10]|l_sw[1]|l_sw[2]|l_sw[3]|l_sw[4]|l_sw[5]|l_sw[6]|l_sw[7]|l_sw[8]|l_sw[9]|out|pad|padres|vc|vcp|vdd|vddr|vip|vss|z
+ sg13_lv_nmos L=0.13u W=0.42u AS=0.0798p AD=0.2373p PS=0.8u PD=1.97u rfmode=0
M$1263 \$74503 \$74472 \$74604
+ BOTTOM|TOP|VGND|VSS|anode|cathode|core|h_sw[0]|h_sw[10]|h_sw[1]|h_sw[2]|h_sw[3]|h_sw[4]|h_sw[5]|h_sw[6]|h_sw[7]|h_sw[8]|h_sw[9]|l_sw[0]|l_sw[10]|l_sw[1]|l_sw[2]|l_sw[3]|l_sw[4]|l_sw[5]|l_sw[6]|l_sw[7]|l_sw[8]|l_sw[9]|out|pad|padres|vc|vcp|vdd|vddr|vip|vss|z
+ sg13_lv_nmos L=0.13u W=0.42u AS=0.1296p AD=0.0798p PS=1.52u PD=0.8u rfmode=0
M$1264 \$74604 \$74504 \$74471
+ BOTTOM|TOP|VGND|VSS|anode|cathode|core|h_sw[0]|h_sw[10]|h_sw[1]|h_sw[2]|h_sw[3]|h_sw[4]|h_sw[5]|h_sw[6]|h_sw[7]|h_sw[8]|h_sw[9]|l_sw[0]|l_sw[10]|l_sw[1]|l_sw[2]|l_sw[3]|l_sw[4]|l_sw[5]|l_sw[6]|l_sw[7]|l_sw[8]|l_sw[9]|out|pad|padres|vc|vcp|vdd|vddr|vip|vss|z
+ sg13_lv_nmos L=0.13u W=0.42u AS=0.0798p AD=0.2373p PS=0.8u PD=1.97u rfmode=0
M$1265 \$74508 \$74483 \$74605
+ BOTTOM|TOP|VGND|VSS|anode|cathode|core|h_sw[0]|h_sw[10]|h_sw[1]|h_sw[2]|h_sw[3]|h_sw[4]|h_sw[5]|h_sw[6]|h_sw[7]|h_sw[8]|h_sw[9]|l_sw[0]|l_sw[10]|l_sw[1]|l_sw[2]|l_sw[3]|l_sw[4]|l_sw[5]|l_sw[6]|l_sw[7]|l_sw[8]|l_sw[9]|out|pad|padres|vc|vcp|vdd|vddr|vip|vss|z
+ sg13_lv_nmos L=0.13u W=0.42u AS=0.1296p AD=0.0798p PS=1.52u PD=0.8u rfmode=0
M$1266 \$74605 \$74509 \$74482
+ BOTTOM|TOP|VGND|VSS|anode|cathode|core|h_sw[0]|h_sw[10]|h_sw[1]|h_sw[2]|h_sw[3]|h_sw[4]|h_sw[5]|h_sw[6]|h_sw[7]|h_sw[8]|h_sw[9]|l_sw[0]|l_sw[10]|l_sw[1]|l_sw[2]|l_sw[3]|l_sw[4]|l_sw[5]|l_sw[6]|l_sw[7]|l_sw[8]|l_sw[9]|out|pad|padres|vc|vcp|vdd|vddr|vip|vss|z
+ sg13_lv_nmos L=0.13u W=0.42u AS=0.0798p AD=0.2373p PS=0.8u PD=1.97u rfmode=0
M$1268
+ BOTTOM|TOP|VGND|VSS|anode|cathode|core|h_sw[0]|h_sw[10]|h_sw[1]|h_sw[2]|h_sw[3]|h_sw[4]|h_sw[5]|h_sw[6]|h_sw[7]|h_sw[8]|h_sw[9]|l_sw[0]|l_sw[10]|l_sw[1]|l_sw[2]|l_sw[3]|l_sw[4]|l_sw[5]|l_sw[6]|l_sw[7]|l_sw[8]|l_sw[9]|out|pad|padres|vc|vcp|vdd|vddr|vip|vss|z
+ A|anode|cathode|ck|cks|core|pad|padres A|Y$28
+ BOTTOM|TOP|VGND|VSS|anode|cathode|core|h_sw[0]|h_sw[10]|h_sw[1]|h_sw[2]|h_sw[3]|h_sw[4]|h_sw[5]|h_sw[6]|h_sw[7]|h_sw[8]|h_sw[9]|l_sw[0]|l_sw[10]|l_sw[1]|l_sw[2]|l_sw[3]|l_sw[4]|l_sw[5]|l_sw[6]|l_sw[7]|l_sw[8]|l_sw[9]|out|pad|padres|vc|vcp|vdd|vddr|vip|vss|z
+ sg13_lv_nmos L=0.13u W=0.74u AS=0.2516p AD=0.2516p PS=2.16u PD=2.16u rfmode=0
M$1269
+ BOTTOM|TOP|VGND|VSS|anode|cathode|core|h_sw[0]|h_sw[10]|h_sw[1]|h_sw[2]|h_sw[3]|h_sw[4]|h_sw[5]|h_sw[6]|h_sw[7]|h_sw[8]|h_sw[9]|l_sw[0]|l_sw[10]|l_sw[1]|l_sw[2]|l_sw[3]|l_sw[4]|l_sw[5]|l_sw[6]|l_sw[7]|l_sw[8]|l_sw[9]|out|pad|padres|vc|vcp|vdd|vddr|vip|vss|z
+ A|Y$28 Y$3
+ BOTTOM|TOP|VGND|VSS|anode|cathode|core|h_sw[0]|h_sw[10]|h_sw[1]|h_sw[2]|h_sw[3]|h_sw[4]|h_sw[5]|h_sw[6]|h_sw[7]|h_sw[8]|h_sw[9]|l_sw[0]|l_sw[10]|l_sw[1]|l_sw[2]|l_sw[3]|l_sw[4]|l_sw[5]|l_sw[6]|l_sw[7]|l_sw[8]|l_sw[9]|out|pad|padres|vc|vcp|vdd|vddr|vip|vss|z
+ sg13_lv_nmos L=0.13u W=0.74u AS=0.2516p AD=0.2516p PS=2.16u PD=2.16u rfmode=0
M$1271
+ BOTTOM|TOP|VGND|VSS|anode|cathode|core|h_sw[0]|h_sw[10]|h_sw[1]|h_sw[2]|h_sw[3]|h_sw[4]|h_sw[5]|h_sw[6]|h_sw[7]|h_sw[8]|h_sw[9]|l_sw[0]|l_sw[10]|l_sw[1]|l_sw[2]|l_sw[3]|l_sw[4]|l_sw[5]|l_sw[6]|l_sw[7]|l_sw[8]|l_sw[9]|out|pad|padres|vc|vcp|vdd|vddr|vip|vss|z
+ A|Y$28 \$74922
+ BOTTOM|TOP|VGND|VSS|anode|cathode|core|h_sw[0]|h_sw[10]|h_sw[1]|h_sw[2]|h_sw[3]|h_sw[4]|h_sw[5]|h_sw[6]|h_sw[7]|h_sw[8]|h_sw[9]|l_sw[0]|l_sw[10]|l_sw[1]|l_sw[2]|l_sw[3]|l_sw[4]|l_sw[5]|l_sw[6]|l_sw[7]|l_sw[8]|l_sw[9]|out|pad|padres|vc|vcp|vdd|vddr|vip|vss|z
+ sg13_lv_nmos L=0.13u W=0.5u AS=0.17p AD=0.095p PS=1.68u PD=0.88u rfmode=0
M$1272 \$74922 VDD|VPWR|vdd \$74050
+ BOTTOM|TOP|VGND|VSS|anode|cathode|core|h_sw[0]|h_sw[10]|h_sw[1]|h_sw[2]|h_sw[3]|h_sw[4]|h_sw[5]|h_sw[6]|h_sw[7]|h_sw[8]|h_sw[9]|l_sw[0]|l_sw[10]|l_sw[1]|l_sw[2]|l_sw[3]|l_sw[4]|l_sw[5]|l_sw[6]|l_sw[7]|l_sw[8]|l_sw[9]|out|pad|padres|vc|vcp|vdd|vddr|vip|vss|z
+ sg13_lv_nmos L=0.13u W=0.5u AS=0.095p AD=0.17p PS=0.88u PD=1.68u rfmode=0
M$1273 \$74923 A|X|rdy
+ BOTTOM|TOP|VGND|VSS|anode|cathode|core|h_sw[0]|h_sw[10]|h_sw[1]|h_sw[2]|h_sw[3]|h_sw[4]|h_sw[5]|h_sw[6]|h_sw[7]|h_sw[8]|h_sw[9]|l_sw[0]|l_sw[10]|l_sw[1]|l_sw[2]|l_sw[3]|l_sw[4]|l_sw[5]|l_sw[6]|l_sw[7]|l_sw[8]|l_sw[9]|out|pad|padres|vc|vcp|vdd|vddr|vip|vss|z
+ BOTTOM|TOP|VGND|VSS|anode|cathode|core|h_sw[0]|h_sw[10]|h_sw[1]|h_sw[2]|h_sw[3]|h_sw[4]|h_sw[5]|h_sw[6]|h_sw[7]|h_sw[8]|h_sw[9]|l_sw[0]|l_sw[10]|l_sw[1]|l_sw[2]|l_sw[3]|l_sw[4]|l_sw[5]|l_sw[6]|l_sw[7]|l_sw[8]|l_sw[9]|out|pad|padres|vc|vcp|vdd|vddr|vip|vss|z
+ sg13_lv_nmos L=0.13u W=0.55u AS=0.187p AD=0.14875p PS=1.78u PD=1.16u rfmode=0
M$1274
+ BOTTOM|TOP|VGND|VSS|anode|cathode|core|h_sw[0]|h_sw[10]|h_sw[1]|h_sw[2]|h_sw[3]|h_sw[4]|h_sw[5]|h_sw[6]|h_sw[7]|h_sw[8]|h_sw[9]|l_sw[0]|l_sw[10]|l_sw[1]|l_sw[2]|l_sw[3]|l_sw[4]|l_sw[5]|l_sw[6]|l_sw[7]|l_sw[8]|l_sw[9]|out|pad|padres|vc|vcp|vdd|vddr|vip|vss|z
+ \$74923 A|X$52
+ BOTTOM|TOP|VGND|VSS|anode|cathode|core|h_sw[0]|h_sw[10]|h_sw[1]|h_sw[2]|h_sw[3]|h_sw[4]|h_sw[5]|h_sw[6]|h_sw[7]|h_sw[8]|h_sw[9]|l_sw[0]|l_sw[10]|l_sw[1]|l_sw[2]|l_sw[3]|l_sw[4]|l_sw[5]|l_sw[6]|l_sw[7]|l_sw[8]|l_sw[9]|out|pad|padres|vc|vcp|vdd|vddr|vip|vss|z
+ sg13_lv_nmos L=0.13u W=0.74u AS=0.14875p AD=0.2886p PS=1.16u PD=2.26u rfmode=0
M$1275
+ BOTTOM|TOP|VGND|VSS|anode|cathode|core|h_sw[0]|h_sw[10]|h_sw[1]|h_sw[2]|h_sw[3]|h_sw[4]|h_sw[5]|h_sw[6]|h_sw[7]|h_sw[8]|h_sw[9]|l_sw[0]|l_sw[10]|l_sw[1]|l_sw[2]|l_sw[3]|l_sw[4]|l_sw[5]|l_sw[6]|l_sw[7]|l_sw[8]|l_sw[9]|out|pad|padres|vc|vcp|vdd|vddr|vip|vss|z
+ A|anode|cathode|ck|cks|core|pad|padres RESET_B|Y$2
+ BOTTOM|TOP|VGND|VSS|anode|cathode|core|h_sw[0]|h_sw[10]|h_sw[1]|h_sw[2]|h_sw[3]|h_sw[4]|h_sw[5]|h_sw[6]|h_sw[7]|h_sw[8]|h_sw[9]|l_sw[0]|l_sw[10]|l_sw[1]|l_sw[2]|l_sw[3]|l_sw[4]|l_sw[5]|l_sw[6]|l_sw[7]|l_sw[8]|l_sw[9]|out|pad|padres|vc|vcp|vdd|vddr|vip|vss|z
+ sg13_lv_nmos L=0.13u W=0.74u AS=0.2516p AD=0.2516p PS=2.16u PD=2.16u rfmode=0
M$1276
+ BOTTOM|TOP|VGND|VSS|anode|cathode|core|h_sw[0]|h_sw[10]|h_sw[1]|h_sw[2]|h_sw[3]|h_sw[4]|h_sw[5]|h_sw[6]|h_sw[7]|h_sw[8]|h_sw[9]|l_sw[0]|l_sw[10]|l_sw[1]|l_sw[2]|l_sw[3]|l_sw[4]|l_sw[5]|l_sw[6]|l_sw[7]|l_sw[8]|l_sw[9]|out|pad|padres|vc|vcp|vdd|vddr|vip|vss|z
+ A|Y$25 \$74926
+ BOTTOM|TOP|VGND|VSS|anode|cathode|core|h_sw[0]|h_sw[10]|h_sw[1]|h_sw[2]|h_sw[3]|h_sw[4]|h_sw[5]|h_sw[6]|h_sw[7]|h_sw[8]|h_sw[9]|l_sw[0]|l_sw[10]|l_sw[1]|l_sw[2]|l_sw[3]|l_sw[4]|l_sw[5]|l_sw[6]|l_sw[7]|l_sw[8]|l_sw[9]|out|pad|padres|vc|vcp|vdd|vddr|vip|vss|z
+ sg13_lv_nmos L=0.13u W=0.55u AS=0.14875p AD=0.187p PS=1.16u PD=1.78u rfmode=0
M$1277 A|X$53 \$74926
+ BOTTOM|TOP|VGND|VSS|anode|cathode|core|h_sw[0]|h_sw[10]|h_sw[1]|h_sw[2]|h_sw[3]|h_sw[4]|h_sw[5]|h_sw[6]|h_sw[7]|h_sw[8]|h_sw[9]|l_sw[0]|l_sw[10]|l_sw[1]|l_sw[2]|l_sw[3]|l_sw[4]|l_sw[5]|l_sw[6]|l_sw[7]|l_sw[8]|l_sw[9]|out|pad|padres|vc|vcp|vdd|vddr|vip|vss|z
+ BOTTOM|TOP|VGND|VSS|anode|cathode|core|h_sw[0]|h_sw[10]|h_sw[1]|h_sw[2]|h_sw[3]|h_sw[4]|h_sw[5]|h_sw[6]|h_sw[7]|h_sw[8]|h_sw[9]|l_sw[0]|l_sw[10]|l_sw[1]|l_sw[2]|l_sw[3]|l_sw[4]|l_sw[5]|l_sw[6]|l_sw[7]|l_sw[8]|l_sw[9]|out|pad|padres|vc|vcp|vdd|vddr|vip|vss|z
+ sg13_lv_nmos L=0.13u W=0.74u AS=0.2886p AD=0.14875p PS=2.26u PD=1.16u rfmode=0
M$1278 \$74864 \$75333 \$74929
+ BOTTOM|TOP|VGND|VSS|anode|cathode|core|h_sw[0]|h_sw[10]|h_sw[1]|h_sw[2]|h_sw[3]|h_sw[4]|h_sw[5]|h_sw[6]|h_sw[7]|h_sw[8]|h_sw[9]|l_sw[0]|l_sw[10]|l_sw[1]|l_sw[2]|l_sw[3]|l_sw[4]|l_sw[5]|l_sw[6]|l_sw[7]|l_sw[8]|l_sw[9]|out|pad|padres|vc|vcp|vdd|vddr|vip|vss|z
+ sg13_lv_nmos L=0.13u W=0.42u AS=0.1296p AD=0.0798p PS=1.52u PD=0.8u rfmode=0
M$1279 \$74929 \$74930 \$75358
+ BOTTOM|TOP|VGND|VSS|anode|cathode|core|h_sw[0]|h_sw[10]|h_sw[1]|h_sw[2]|h_sw[3]|h_sw[4]|h_sw[5]|h_sw[6]|h_sw[7]|h_sw[8]|h_sw[9]|l_sw[0]|l_sw[10]|l_sw[1]|l_sw[2]|l_sw[3]|l_sw[4]|l_sw[5]|l_sw[6]|l_sw[7]|l_sw[8]|l_sw[9]|out|pad|padres|vc|vcp|vdd|vddr|vip|vss|z
+ sg13_lv_nmos L=0.13u W=0.42u AS=0.0798p AD=0.2373p PS=0.8u PD=1.97u rfmode=0
M$1280 \$74930 \$75333
+ BOTTOM|TOP|VGND|VSS|anode|cathode|core|h_sw[0]|h_sw[10]|h_sw[1]|h_sw[2]|h_sw[3]|h_sw[4]|h_sw[5]|h_sw[6]|h_sw[7]|h_sw[8]|h_sw[9]|l_sw[0]|l_sw[10]|l_sw[1]|l_sw[2]|l_sw[3]|l_sw[4]|l_sw[5]|l_sw[6]|l_sw[7]|l_sw[8]|l_sw[9]|out|pad|padres|vc|vcp|vdd|vddr|vip|vss|z
+ BOTTOM|TOP|VGND|VSS|anode|cathode|core|h_sw[0]|h_sw[10]|h_sw[1]|h_sw[2]|h_sw[3]|h_sw[4]|h_sw[5]|h_sw[6]|h_sw[7]|h_sw[8]|h_sw[9]|l_sw[0]|l_sw[10]|l_sw[1]|l_sw[2]|l_sw[3]|l_sw[4]|l_sw[5]|l_sw[6]|l_sw[7]|l_sw[8]|l_sw[9]|out|pad|padres|vc|vcp|vdd|vddr|vip|vss|z
+ sg13_lv_nmos L=0.13u W=0.74u AS=0.2516p AD=0.317325p PS=2.16u PD=1.805u
+ rfmode=0
M$1281
+ BOTTOM|TOP|VGND|VSS|anode|cathode|core|h_sw[0]|h_sw[10]|h_sw[1]|h_sw[2]|h_sw[3]|h_sw[4]|h_sw[5]|h_sw[6]|h_sw[7]|h_sw[8]|h_sw[9]|l_sw[0]|l_sw[10]|l_sw[1]|l_sw[2]|l_sw[3]|l_sw[4]|l_sw[5]|l_sw[6]|l_sw[7]|l_sw[8]|l_sw[9]|out|pad|padres|vc|vcp|vdd|vddr|vip|vss|z
+ A|CLK|X \$75333
+ BOTTOM|TOP|VGND|VSS|anode|cathode|core|h_sw[0]|h_sw[10]|h_sw[1]|h_sw[2]|h_sw[3]|h_sw[4]|h_sw[5]|h_sw[6]|h_sw[7]|h_sw[8]|h_sw[9]|l_sw[0]|l_sw[10]|l_sw[1]|l_sw[2]|l_sw[3]|l_sw[4]|l_sw[5]|l_sw[6]|l_sw[7]|l_sw[8]|l_sw[9]|out|pad|padres|vc|vcp|vdd|vddr|vip|vss|z
+ sg13_lv_nmos L=0.13u W=0.74u AS=0.317325p AD=0.2516p PS=1.805u PD=2.16u
+ rfmode=0
M$1282 \$75370 \$75333 \$75334
+ BOTTOM|TOP|VGND|VSS|anode|cathode|core|h_sw[0]|h_sw[10]|h_sw[1]|h_sw[2]|h_sw[3]|h_sw[4]|h_sw[5]|h_sw[6]|h_sw[7]|h_sw[8]|h_sw[9]|l_sw[0]|l_sw[10]|l_sw[1]|l_sw[2]|l_sw[3]|l_sw[4]|l_sw[5]|l_sw[6]|l_sw[7]|l_sw[8]|l_sw[9]|out|pad|padres|vc|vcp|vdd|vddr|vip|vss|z
+ sg13_lv_nmos L=0.13u W=0.42u AS=0.1428p AD=0.12665p PS=1.52u PD=1.145u
+ rfmode=0
M$1283 \$75334 \$74930 \$74928
+ BOTTOM|TOP|VGND|VSS|anode|cathode|core|h_sw[0]|h_sw[10]|h_sw[1]|h_sw[2]|h_sw[3]|h_sw[4]|h_sw[5]|h_sw[6]|h_sw[7]|h_sw[8]|h_sw[9]|l_sw[0]|l_sw[10]|l_sw[1]|l_sw[2]|l_sw[3]|l_sw[4]|l_sw[5]|l_sw[6]|l_sw[7]|l_sw[8]|l_sw[9]|out|pad|padres|vc|vcp|vdd|vddr|vip|vss|z
+ sg13_lv_nmos L=0.13u W=0.74u AS=0.12665p AD=0.3473p PS=1.145u PD=2.71u
+ rfmode=0
M$1284
+ BOTTOM|TOP|VGND|VSS|anode|cathode|core|h_sw[0]|h_sw[10]|h_sw[1]|h_sw[2]|h_sw[3]|h_sw[4]|h_sw[5]|h_sw[6]|h_sw[7]|h_sw[8]|h_sw[9]|l_sw[0]|l_sw[10]|l_sw[1]|l_sw[2]|l_sw[3]|l_sw[4]|l_sw[5]|l_sw[6]|l_sw[7]|l_sw[8]|l_sw[9]|out|pad|padres|vc|vcp|vdd|vddr|vip|vss|z
+ \$75334 Q_N$35
+ BOTTOM|TOP|VGND|VSS|anode|cathode|core|h_sw[0]|h_sw[10]|h_sw[1]|h_sw[2]|h_sw[3]|h_sw[4]|h_sw[5]|h_sw[6]|h_sw[7]|h_sw[8]|h_sw[9]|l_sw[0]|l_sw[10]|l_sw[1]|l_sw[2]|l_sw[3]|l_sw[4]|l_sw[5]|l_sw[6]|l_sw[7]|l_sw[8]|l_sw[9]|out|pad|padres|vc|vcp|vdd|vddr|vip|vss|z
+ sg13_lv_nmos L=0.13u W=0.74u AS=0.2516p AD=0.2849p PS=2.16u PD=2.25u rfmode=0
M$1285 \$74932 \$75334
+ BOTTOM|TOP|VGND|VSS|anode|cathode|core|h_sw[0]|h_sw[10]|h_sw[1]|h_sw[2]|h_sw[3]|h_sw[4]|h_sw[5]|h_sw[6]|h_sw[7]|h_sw[8]|h_sw[9]|l_sw[0]|l_sw[10]|l_sw[1]|l_sw[2]|l_sw[3]|l_sw[4]|l_sw[5]|l_sw[6]|l_sw[7]|l_sw[8]|l_sw[9]|out|pad|padres|vc|vcp|vdd|vddr|vip|vss|z
+ BOTTOM|TOP|VGND|VSS|anode|cathode|core|h_sw[0]|h_sw[10]|h_sw[1]|h_sw[2]|h_sw[3]|h_sw[4]|h_sw[5]|h_sw[6]|h_sw[7]|h_sw[8]|h_sw[9]|l_sw[0]|l_sw[10]|l_sw[1]|l_sw[2]|l_sw[3]|l_sw[4]|l_sw[5]|l_sw[6]|l_sw[7]|l_sw[8]|l_sw[9]|out|pad|padres|vc|vcp|vdd|vddr|vip|vss|z
+ sg13_lv_nmos L=0.13u W=0.74u AS=0.2516p AD=0.1406p PS=2.16u PD=1.12u rfmode=0
M$1286
+ BOTTOM|TOP|VGND|VSS|anode|cathode|core|h_sw[0]|h_sw[10]|h_sw[1]|h_sw[2]|h_sw[3]|h_sw[4]|h_sw[5]|h_sw[6]|h_sw[7]|h_sw[8]|h_sw[9]|l_sw[0]|l_sw[10]|l_sw[1]|l_sw[2]|l_sw[3]|l_sw[4]|l_sw[5]|l_sw[6]|l_sw[7]|l_sw[8]|l_sw[9]|out|pad|padres|vc|vcp|vdd|vddr|vip|vss|z
+ \$74932 CLK|D|GATE|Q$6
+ BOTTOM|TOP|VGND|VSS|anode|cathode|core|h_sw[0]|h_sw[10]|h_sw[1]|h_sw[2]|h_sw[3]|h_sw[4]|h_sw[5]|h_sw[6]|h_sw[7]|h_sw[8]|h_sw[9]|l_sw[0]|l_sw[10]|l_sw[1]|l_sw[2]|l_sw[3]|l_sw[4]|l_sw[5]|l_sw[6]|l_sw[7]|l_sw[8]|l_sw[9]|out|pad|padres|vc|vcp|vdd|vddr|vip|vss|z
+ sg13_lv_nmos L=0.13u W=0.74u AS=0.1406p AD=0.2516p PS=1.12u PD=2.16u rfmode=0
M$1287
+ BOTTOM|TOP|VGND|VSS|anode|cathode|core|h_sw[0]|h_sw[10]|h_sw[1]|h_sw[2]|h_sw[3]|h_sw[4]|h_sw[5]|h_sw[6]|h_sw[7]|h_sw[8]|h_sw[9]|l_sw[0]|l_sw[10]|l_sw[1]|l_sw[2]|l_sw[3]|l_sw[4]|l_sw[5]|l_sw[6]|l_sw[7]|l_sw[8]|l_sw[9]|out|pad|padres|vc|vcp|vdd|vddr|vip|vss|z
+ A|anode|cathode|ck|cks|core|pad|padres RESET_B|Y$1
+ BOTTOM|TOP|VGND|VSS|anode|cathode|core|h_sw[0]|h_sw[10]|h_sw[1]|h_sw[2]|h_sw[3]|h_sw[4]|h_sw[5]|h_sw[6]|h_sw[7]|h_sw[8]|h_sw[9]|l_sw[0]|l_sw[10]|l_sw[1]|l_sw[2]|l_sw[3]|l_sw[4]|l_sw[5]|l_sw[6]|l_sw[7]|l_sw[8]|l_sw[9]|out|pad|padres|vc|vcp|vdd|vddr|vip|vss|z
+ sg13_lv_nmos L=0.13u W=5.92u AS=1.2395p AD=1.2395p PS=10.01u PD=10.01u
+ rfmode=0
M$1295 \$74865 \$75336 \$74934
+ BOTTOM|TOP|VGND|VSS|anode|cathode|core|h_sw[0]|h_sw[10]|h_sw[1]|h_sw[2]|h_sw[3]|h_sw[4]|h_sw[5]|h_sw[6]|h_sw[7]|h_sw[8]|h_sw[9]|l_sw[0]|l_sw[10]|l_sw[1]|l_sw[2]|l_sw[3]|l_sw[4]|l_sw[5]|l_sw[6]|l_sw[7]|l_sw[8]|l_sw[9]|out|pad|padres|vc|vcp|vdd|vddr|vip|vss|z
+ sg13_lv_nmos L=0.13u W=0.42u AS=0.1296p AD=0.0798p PS=1.52u PD=0.8u rfmode=0
M$1296 \$74934 \$74935 \$75359
+ BOTTOM|TOP|VGND|VSS|anode|cathode|core|h_sw[0]|h_sw[10]|h_sw[1]|h_sw[2]|h_sw[3]|h_sw[4]|h_sw[5]|h_sw[6]|h_sw[7]|h_sw[8]|h_sw[9]|l_sw[0]|l_sw[10]|l_sw[1]|l_sw[2]|l_sw[3]|l_sw[4]|l_sw[5]|l_sw[6]|l_sw[7]|l_sw[8]|l_sw[9]|out|pad|padres|vc|vcp|vdd|vddr|vip|vss|z
+ sg13_lv_nmos L=0.13u W=0.42u AS=0.0798p AD=0.2373p PS=0.8u PD=1.97u rfmode=0
M$1297 \$74935 \$75336
+ BOTTOM|TOP|VGND|VSS|anode|cathode|core|h_sw[0]|h_sw[10]|h_sw[1]|h_sw[2]|h_sw[3]|h_sw[4]|h_sw[5]|h_sw[6]|h_sw[7]|h_sw[8]|h_sw[9]|l_sw[0]|l_sw[10]|l_sw[1]|l_sw[2]|l_sw[3]|l_sw[4]|l_sw[5]|l_sw[6]|l_sw[7]|l_sw[8]|l_sw[9]|out|pad|padres|vc|vcp|vdd|vddr|vip|vss|z
+ BOTTOM|TOP|VGND|VSS|anode|cathode|core|h_sw[0]|h_sw[10]|h_sw[1]|h_sw[2]|h_sw[3]|h_sw[4]|h_sw[5]|h_sw[6]|h_sw[7]|h_sw[8]|h_sw[9]|l_sw[0]|l_sw[10]|l_sw[1]|l_sw[2]|l_sw[3]|l_sw[4]|l_sw[5]|l_sw[6]|l_sw[7]|l_sw[8]|l_sw[9]|out|pad|padres|vc|vcp|vdd|vddr|vip|vss|z
+ sg13_lv_nmos L=0.13u W=0.74u AS=0.2516p AD=0.317325p PS=2.16u PD=1.805u
+ rfmode=0
M$1298
+ BOTTOM|TOP|VGND|VSS|anode|cathode|core|h_sw[0]|h_sw[10]|h_sw[1]|h_sw[2]|h_sw[3]|h_sw[4]|h_sw[5]|h_sw[6]|h_sw[7]|h_sw[8]|h_sw[9]|l_sw[0]|l_sw[10]|l_sw[1]|l_sw[2]|l_sw[3]|l_sw[4]|l_sw[5]|l_sw[6]|l_sw[7]|l_sw[8]|l_sw[9]|out|pad|padres|vc|vcp|vdd|vddr|vip|vss|z
+ A|CLK|X \$75336
+ BOTTOM|TOP|VGND|VSS|anode|cathode|core|h_sw[0]|h_sw[10]|h_sw[1]|h_sw[2]|h_sw[3]|h_sw[4]|h_sw[5]|h_sw[6]|h_sw[7]|h_sw[8]|h_sw[9]|l_sw[0]|l_sw[10]|l_sw[1]|l_sw[2]|l_sw[3]|l_sw[4]|l_sw[5]|l_sw[6]|l_sw[7]|l_sw[8]|l_sw[9]|out|pad|padres|vc|vcp|vdd|vddr|vip|vss|z
+ sg13_lv_nmos L=0.13u W=0.74u AS=0.317325p AD=0.2516p PS=1.805u PD=2.16u
+ rfmode=0
M$1299 \$75371 \$75336 \$75337
+ BOTTOM|TOP|VGND|VSS|anode|cathode|core|h_sw[0]|h_sw[10]|h_sw[1]|h_sw[2]|h_sw[3]|h_sw[4]|h_sw[5]|h_sw[6]|h_sw[7]|h_sw[8]|h_sw[9]|l_sw[0]|l_sw[10]|l_sw[1]|l_sw[2]|l_sw[3]|l_sw[4]|l_sw[5]|l_sw[6]|l_sw[7]|l_sw[8]|l_sw[9]|out|pad|padres|vc|vcp|vdd|vddr|vip|vss|z
+ sg13_lv_nmos L=0.13u W=0.42u AS=0.1428p AD=0.12665p PS=1.52u PD=1.145u
+ rfmode=0
M$1300 \$75337 \$74935 \$74933
+ BOTTOM|TOP|VGND|VSS|anode|cathode|core|h_sw[0]|h_sw[10]|h_sw[1]|h_sw[2]|h_sw[3]|h_sw[4]|h_sw[5]|h_sw[6]|h_sw[7]|h_sw[8]|h_sw[9]|l_sw[0]|l_sw[10]|l_sw[1]|l_sw[2]|l_sw[3]|l_sw[4]|l_sw[5]|l_sw[6]|l_sw[7]|l_sw[8]|l_sw[9]|out|pad|padres|vc|vcp|vdd|vddr|vip|vss|z
+ sg13_lv_nmos L=0.13u W=0.74u AS=0.12665p AD=0.3473p PS=1.145u PD=2.71u
+ rfmode=0
M$1301
+ BOTTOM|TOP|VGND|VSS|anode|cathode|core|h_sw[0]|h_sw[10]|h_sw[1]|h_sw[2]|h_sw[3]|h_sw[4]|h_sw[5]|h_sw[6]|h_sw[7]|h_sw[8]|h_sw[9]|l_sw[0]|l_sw[10]|l_sw[1]|l_sw[2]|l_sw[3]|l_sw[4]|l_sw[5]|l_sw[6]|l_sw[7]|l_sw[8]|l_sw[9]|out|pad|padres|vc|vcp|vdd|vddr|vip|vss|z
+ \$75337 Q_N$36
+ BOTTOM|TOP|VGND|VSS|anode|cathode|core|h_sw[0]|h_sw[10]|h_sw[1]|h_sw[2]|h_sw[3]|h_sw[4]|h_sw[5]|h_sw[6]|h_sw[7]|h_sw[8]|h_sw[9]|l_sw[0]|l_sw[10]|l_sw[1]|l_sw[2]|l_sw[3]|l_sw[4]|l_sw[5]|l_sw[6]|l_sw[7]|l_sw[8]|l_sw[9]|out|pad|padres|vc|vcp|vdd|vddr|vip|vss|z
+ sg13_lv_nmos L=0.13u W=0.74u AS=0.2516p AD=0.2849p PS=2.16u PD=2.25u rfmode=0
M$1302 \$74937 \$75337
+ BOTTOM|TOP|VGND|VSS|anode|cathode|core|h_sw[0]|h_sw[10]|h_sw[1]|h_sw[2]|h_sw[3]|h_sw[4]|h_sw[5]|h_sw[6]|h_sw[7]|h_sw[8]|h_sw[9]|l_sw[0]|l_sw[10]|l_sw[1]|l_sw[2]|l_sw[3]|l_sw[4]|l_sw[5]|l_sw[6]|l_sw[7]|l_sw[8]|l_sw[9]|out|pad|padres|vc|vcp|vdd|vddr|vip|vss|z
+ BOTTOM|TOP|VGND|VSS|anode|cathode|core|h_sw[0]|h_sw[10]|h_sw[1]|h_sw[2]|h_sw[3]|h_sw[4]|h_sw[5]|h_sw[6]|h_sw[7]|h_sw[8]|h_sw[9]|l_sw[0]|l_sw[10]|l_sw[1]|l_sw[2]|l_sw[3]|l_sw[4]|l_sw[5]|l_sw[6]|l_sw[7]|l_sw[8]|l_sw[9]|out|pad|padres|vc|vcp|vdd|vddr|vip|vss|z
+ sg13_lv_nmos L=0.13u W=0.74u AS=0.2516p AD=0.1406p PS=2.16u PD=1.12u rfmode=0
M$1303
+ BOTTOM|TOP|VGND|VSS|anode|cathode|core|h_sw[0]|h_sw[10]|h_sw[1]|h_sw[2]|h_sw[3]|h_sw[4]|h_sw[5]|h_sw[6]|h_sw[7]|h_sw[8]|h_sw[9]|l_sw[0]|l_sw[10]|l_sw[1]|l_sw[2]|l_sw[3]|l_sw[4]|l_sw[5]|l_sw[6]|l_sw[7]|l_sw[8]|l_sw[9]|out|pad|padres|vc|vcp|vdd|vddr|vip|vss|z
+ \$74937 CLK|D|GATE|Q$9
+ BOTTOM|TOP|VGND|VSS|anode|cathode|core|h_sw[0]|h_sw[10]|h_sw[1]|h_sw[2]|h_sw[3]|h_sw[4]|h_sw[5]|h_sw[6]|h_sw[7]|h_sw[8]|h_sw[9]|l_sw[0]|l_sw[10]|l_sw[1]|l_sw[2]|l_sw[3]|l_sw[4]|l_sw[5]|l_sw[6]|l_sw[7]|l_sw[8]|l_sw[9]|out|pad|padres|vc|vcp|vdd|vddr|vip|vss|z
+ sg13_lv_nmos L=0.13u W=0.74u AS=0.1406p AD=0.2516p PS=1.12u PD=2.16u rfmode=0
M$1304 \$74866 \$75339 \$74939
+ BOTTOM|TOP|VGND|VSS|anode|cathode|core|h_sw[0]|h_sw[10]|h_sw[1]|h_sw[2]|h_sw[3]|h_sw[4]|h_sw[5]|h_sw[6]|h_sw[7]|h_sw[8]|h_sw[9]|l_sw[0]|l_sw[10]|l_sw[1]|l_sw[2]|l_sw[3]|l_sw[4]|l_sw[5]|l_sw[6]|l_sw[7]|l_sw[8]|l_sw[9]|out|pad|padres|vc|vcp|vdd|vddr|vip|vss|z
+ sg13_lv_nmos L=0.13u W=0.42u AS=0.1296p AD=0.0798p PS=1.52u PD=0.8u rfmode=0
M$1305 \$74939 \$74940 \$75360
+ BOTTOM|TOP|VGND|VSS|anode|cathode|core|h_sw[0]|h_sw[10]|h_sw[1]|h_sw[2]|h_sw[3]|h_sw[4]|h_sw[5]|h_sw[6]|h_sw[7]|h_sw[8]|h_sw[9]|l_sw[0]|l_sw[10]|l_sw[1]|l_sw[2]|l_sw[3]|l_sw[4]|l_sw[5]|l_sw[6]|l_sw[7]|l_sw[8]|l_sw[9]|out|pad|padres|vc|vcp|vdd|vddr|vip|vss|z
+ sg13_lv_nmos L=0.13u W=0.42u AS=0.0798p AD=0.2373p PS=0.8u PD=1.97u rfmode=0
M$1306 \$74940 \$75339
+ BOTTOM|TOP|VGND|VSS|anode|cathode|core|h_sw[0]|h_sw[10]|h_sw[1]|h_sw[2]|h_sw[3]|h_sw[4]|h_sw[5]|h_sw[6]|h_sw[7]|h_sw[8]|h_sw[9]|l_sw[0]|l_sw[10]|l_sw[1]|l_sw[2]|l_sw[3]|l_sw[4]|l_sw[5]|l_sw[6]|l_sw[7]|l_sw[8]|l_sw[9]|out|pad|padres|vc|vcp|vdd|vddr|vip|vss|z
+ BOTTOM|TOP|VGND|VSS|anode|cathode|core|h_sw[0]|h_sw[10]|h_sw[1]|h_sw[2]|h_sw[3]|h_sw[4]|h_sw[5]|h_sw[6]|h_sw[7]|h_sw[8]|h_sw[9]|l_sw[0]|l_sw[10]|l_sw[1]|l_sw[2]|l_sw[3]|l_sw[4]|l_sw[5]|l_sw[6]|l_sw[7]|l_sw[8]|l_sw[9]|out|pad|padres|vc|vcp|vdd|vddr|vip|vss|z
+ sg13_lv_nmos L=0.13u W=0.74u AS=0.2516p AD=0.317325p PS=2.16u PD=1.805u
+ rfmode=0
M$1307
+ BOTTOM|TOP|VGND|VSS|anode|cathode|core|h_sw[0]|h_sw[10]|h_sw[1]|h_sw[2]|h_sw[3]|h_sw[4]|h_sw[5]|h_sw[6]|h_sw[7]|h_sw[8]|h_sw[9]|l_sw[0]|l_sw[10]|l_sw[1]|l_sw[2]|l_sw[3]|l_sw[4]|l_sw[5]|l_sw[6]|l_sw[7]|l_sw[8]|l_sw[9]|out|pad|padres|vc|vcp|vdd|vddr|vip|vss|z
+ A|CLK|X$1 \$75339
+ BOTTOM|TOP|VGND|VSS|anode|cathode|core|h_sw[0]|h_sw[10]|h_sw[1]|h_sw[2]|h_sw[3]|h_sw[4]|h_sw[5]|h_sw[6]|h_sw[7]|h_sw[8]|h_sw[9]|l_sw[0]|l_sw[10]|l_sw[1]|l_sw[2]|l_sw[3]|l_sw[4]|l_sw[5]|l_sw[6]|l_sw[7]|l_sw[8]|l_sw[9]|out|pad|padres|vc|vcp|vdd|vddr|vip|vss|z
+ sg13_lv_nmos L=0.13u W=0.74u AS=0.317325p AD=0.2516p PS=1.805u PD=2.16u
+ rfmode=0
M$1308 \$75372 \$75339 \$75340
+ BOTTOM|TOP|VGND|VSS|anode|cathode|core|h_sw[0]|h_sw[10]|h_sw[1]|h_sw[2]|h_sw[3]|h_sw[4]|h_sw[5]|h_sw[6]|h_sw[7]|h_sw[8]|h_sw[9]|l_sw[0]|l_sw[10]|l_sw[1]|l_sw[2]|l_sw[3]|l_sw[4]|l_sw[5]|l_sw[6]|l_sw[7]|l_sw[8]|l_sw[9]|out|pad|padres|vc|vcp|vdd|vddr|vip|vss|z
+ sg13_lv_nmos L=0.13u W=0.42u AS=0.1428p AD=0.12665p PS=1.52u PD=1.145u
+ rfmode=0
M$1309 \$75340 \$74940 \$74938
+ BOTTOM|TOP|VGND|VSS|anode|cathode|core|h_sw[0]|h_sw[10]|h_sw[1]|h_sw[2]|h_sw[3]|h_sw[4]|h_sw[5]|h_sw[6]|h_sw[7]|h_sw[8]|h_sw[9]|l_sw[0]|l_sw[10]|l_sw[1]|l_sw[2]|l_sw[3]|l_sw[4]|l_sw[5]|l_sw[6]|l_sw[7]|l_sw[8]|l_sw[9]|out|pad|padres|vc|vcp|vdd|vddr|vip|vss|z
+ sg13_lv_nmos L=0.13u W=0.74u AS=0.12665p AD=0.3473p PS=1.145u PD=2.71u
+ rfmode=0
M$1310
+ BOTTOM|TOP|VGND|VSS|anode|cathode|core|h_sw[0]|h_sw[10]|h_sw[1]|h_sw[2]|h_sw[3]|h_sw[4]|h_sw[5]|h_sw[6]|h_sw[7]|h_sw[8]|h_sw[9]|l_sw[0]|l_sw[10]|l_sw[1]|l_sw[2]|l_sw[3]|l_sw[4]|l_sw[5]|l_sw[6]|l_sw[7]|l_sw[8]|l_sw[9]|out|pad|padres|vc|vcp|vdd|vddr|vip|vss|z
+ \$75340 Q_N$37
+ BOTTOM|TOP|VGND|VSS|anode|cathode|core|h_sw[0]|h_sw[10]|h_sw[1]|h_sw[2]|h_sw[3]|h_sw[4]|h_sw[5]|h_sw[6]|h_sw[7]|h_sw[8]|h_sw[9]|l_sw[0]|l_sw[10]|l_sw[1]|l_sw[2]|l_sw[3]|l_sw[4]|l_sw[5]|l_sw[6]|l_sw[7]|l_sw[8]|l_sw[9]|out|pad|padres|vc|vcp|vdd|vddr|vip|vss|z
+ sg13_lv_nmos L=0.13u W=0.74u AS=0.2516p AD=0.2849p PS=2.16u PD=2.25u rfmode=0
M$1311 \$74942 \$75340
+ BOTTOM|TOP|VGND|VSS|anode|cathode|core|h_sw[0]|h_sw[10]|h_sw[1]|h_sw[2]|h_sw[3]|h_sw[4]|h_sw[5]|h_sw[6]|h_sw[7]|h_sw[8]|h_sw[9]|l_sw[0]|l_sw[10]|l_sw[1]|l_sw[2]|l_sw[3]|l_sw[4]|l_sw[5]|l_sw[6]|l_sw[7]|l_sw[8]|l_sw[9]|out|pad|padres|vc|vcp|vdd|vddr|vip|vss|z
+ BOTTOM|TOP|VGND|VSS|anode|cathode|core|h_sw[0]|h_sw[10]|h_sw[1]|h_sw[2]|h_sw[3]|h_sw[4]|h_sw[5]|h_sw[6]|h_sw[7]|h_sw[8]|h_sw[9]|l_sw[0]|l_sw[10]|l_sw[1]|l_sw[2]|l_sw[3]|l_sw[4]|l_sw[5]|l_sw[6]|l_sw[7]|l_sw[8]|l_sw[9]|out|pad|padres|vc|vcp|vdd|vddr|vip|vss|z
+ sg13_lv_nmos L=0.13u W=0.74u AS=0.2516p AD=0.1406p PS=2.16u PD=1.12u rfmode=0
M$1312
+ BOTTOM|TOP|VGND|VSS|anode|cathode|core|h_sw[0]|h_sw[10]|h_sw[1]|h_sw[2]|h_sw[3]|h_sw[4]|h_sw[5]|h_sw[6]|h_sw[7]|h_sw[8]|h_sw[9]|l_sw[0]|l_sw[10]|l_sw[1]|l_sw[2]|l_sw[3]|l_sw[4]|l_sw[5]|l_sw[6]|l_sw[7]|l_sw[8]|l_sw[9]|out|pad|padres|vc|vcp|vdd|vddr|vip|vss|z
+ \$74942 CLK|D|GATE|Q$10
+ BOTTOM|TOP|VGND|VSS|anode|cathode|core|h_sw[0]|h_sw[10]|h_sw[1]|h_sw[2]|h_sw[3]|h_sw[4]|h_sw[5]|h_sw[6]|h_sw[7]|h_sw[8]|h_sw[9]|l_sw[0]|l_sw[10]|l_sw[1]|l_sw[2]|l_sw[3]|l_sw[4]|l_sw[5]|l_sw[6]|l_sw[7]|l_sw[8]|l_sw[9]|out|pad|padres|vc|vcp|vdd|vddr|vip|vss|z
+ sg13_lv_nmos L=0.13u W=0.74u AS=0.1406p AD=0.2516p PS=1.12u PD=2.16u rfmode=0
M$1313 \$74943 A|Q$18
+ BOTTOM|TOP|VGND|VSS|anode|cathode|core|h_sw[0]|h_sw[10]|h_sw[1]|h_sw[2]|h_sw[3]|h_sw[4]|h_sw[5]|h_sw[6]|h_sw[7]|h_sw[8]|h_sw[9]|l_sw[0]|l_sw[10]|l_sw[1]|l_sw[2]|l_sw[3]|l_sw[4]|l_sw[5]|l_sw[6]|l_sw[7]|l_sw[8]|l_sw[9]|out|pad|padres|vc|vcp|vdd|vddr|vip|vss|z
+ BOTTOM|TOP|VGND|VSS|anode|cathode|core|h_sw[0]|h_sw[10]|h_sw[1]|h_sw[2]|h_sw[3]|h_sw[4]|h_sw[5]|h_sw[6]|h_sw[7]|h_sw[8]|h_sw[9]|l_sw[0]|l_sw[10]|l_sw[1]|l_sw[2]|l_sw[3]|l_sw[4]|l_sw[5]|l_sw[6]|l_sw[7]|l_sw[8]|l_sw[9]|out|pad|padres|vc|vcp|vdd|vddr|vip|vss|z
+ sg13_lv_nmos L=0.13u W=0.55u AS=0.187p AD=0.14875p PS=1.78u PD=1.16u rfmode=0
M$1314
+ BOTTOM|TOP|VGND|VSS|anode|cathode|core|h_sw[0]|h_sw[10]|h_sw[1]|h_sw[2]|h_sw[3]|h_sw[4]|h_sw[5]|h_sw[6]|h_sw[7]|h_sw[8]|h_sw[9]|l_sw[0]|l_sw[10]|l_sw[1]|l_sw[2]|l_sw[3]|l_sw[4]|l_sw[5]|l_sw[6]|l_sw[7]|l_sw[8]|l_sw[9]|out|pad|padres|vc|vcp|vdd|vddr|vip|vss|z
+ \$74943 A|X$54
+ BOTTOM|TOP|VGND|VSS|anode|cathode|core|h_sw[0]|h_sw[10]|h_sw[1]|h_sw[2]|h_sw[3]|h_sw[4]|h_sw[5]|h_sw[6]|h_sw[7]|h_sw[8]|h_sw[9]|l_sw[0]|l_sw[10]|l_sw[1]|l_sw[2]|l_sw[3]|l_sw[4]|l_sw[5]|l_sw[6]|l_sw[7]|l_sw[8]|l_sw[9]|out|pad|padres|vc|vcp|vdd|vddr|vip|vss|z
+ sg13_lv_nmos L=0.13u W=0.74u AS=0.14875p AD=0.2886p PS=1.16u PD=2.26u rfmode=0
M$1315 \$74945 A|Q$24
+ BOTTOM|TOP|VGND|VSS|anode|cathode|core|h_sw[0]|h_sw[10]|h_sw[1]|h_sw[2]|h_sw[3]|h_sw[4]|h_sw[5]|h_sw[6]|h_sw[7]|h_sw[8]|h_sw[9]|l_sw[0]|l_sw[10]|l_sw[1]|l_sw[2]|l_sw[3]|l_sw[4]|l_sw[5]|l_sw[6]|l_sw[7]|l_sw[8]|l_sw[9]|out|pad|padres|vc|vcp|vdd|vddr|vip|vss|z
+ BOTTOM|TOP|VGND|VSS|anode|cathode|core|h_sw[0]|h_sw[10]|h_sw[1]|h_sw[2]|h_sw[3]|h_sw[4]|h_sw[5]|h_sw[6]|h_sw[7]|h_sw[8]|h_sw[9]|l_sw[0]|l_sw[10]|l_sw[1]|l_sw[2]|l_sw[3]|l_sw[4]|l_sw[5]|l_sw[6]|l_sw[7]|l_sw[8]|l_sw[9]|out|pad|padres|vc|vcp|vdd|vddr|vip|vss|z
+ sg13_lv_nmos L=0.13u W=0.55u AS=0.187p AD=0.14875p PS=1.78u PD=1.16u rfmode=0
M$1316
+ BOTTOM|TOP|VGND|VSS|anode|cathode|core|h_sw[0]|h_sw[10]|h_sw[1]|h_sw[2]|h_sw[3]|h_sw[4]|h_sw[5]|h_sw[6]|h_sw[7]|h_sw[8]|h_sw[9]|l_sw[0]|l_sw[10]|l_sw[1]|l_sw[2]|l_sw[3]|l_sw[4]|l_sw[5]|l_sw[6]|l_sw[7]|l_sw[8]|l_sw[9]|out|pad|padres|vc|vcp|vdd|vddr|vip|vss|z
+ \$74945 A|X$38
+ BOTTOM|TOP|VGND|VSS|anode|cathode|core|h_sw[0]|h_sw[10]|h_sw[1]|h_sw[2]|h_sw[3]|h_sw[4]|h_sw[5]|h_sw[6]|h_sw[7]|h_sw[8]|h_sw[9]|l_sw[0]|l_sw[10]|l_sw[1]|l_sw[2]|l_sw[3]|l_sw[4]|l_sw[5]|l_sw[6]|l_sw[7]|l_sw[8]|l_sw[9]|out|pad|padres|vc|vcp|vdd|vddr|vip|vss|z
+ sg13_lv_nmos L=0.13u W=0.74u AS=0.14875p AD=0.2886p PS=1.16u PD=2.26u rfmode=0
M$1317 \$74946 A|X$54
+ BOTTOM|TOP|VGND|VSS|anode|cathode|core|h_sw[0]|h_sw[10]|h_sw[1]|h_sw[2]|h_sw[3]|h_sw[4]|h_sw[5]|h_sw[6]|h_sw[7]|h_sw[8]|h_sw[9]|l_sw[0]|l_sw[10]|l_sw[1]|l_sw[2]|l_sw[3]|l_sw[4]|l_sw[5]|l_sw[6]|l_sw[7]|l_sw[8]|l_sw[9]|out|pad|padres|vc|vcp|vdd|vddr|vip|vss|z
+ BOTTOM|TOP|VGND|VSS|anode|cathode|core|h_sw[0]|h_sw[10]|h_sw[1]|h_sw[2]|h_sw[3]|h_sw[4]|h_sw[5]|h_sw[6]|h_sw[7]|h_sw[8]|h_sw[9]|l_sw[0]|l_sw[10]|l_sw[1]|l_sw[2]|l_sw[3]|l_sw[4]|l_sw[5]|l_sw[6]|l_sw[7]|l_sw[8]|l_sw[9]|out|pad|padres|vc|vcp|vdd|vddr|vip|vss|z
+ sg13_lv_nmos L=0.13u W=0.55u AS=0.187p AD=0.14875p PS=1.78u PD=1.16u rfmode=0
M$1318
+ BOTTOM|TOP|VGND|VSS|anode|cathode|core|h_sw[0]|h_sw[10]|h_sw[1]|h_sw[2]|h_sw[3]|h_sw[4]|h_sw[5]|h_sw[6]|h_sw[7]|h_sw[8]|h_sw[9]|l_sw[0]|l_sw[10]|l_sw[1]|l_sw[2]|l_sw[3]|l_sw[4]|l_sw[5]|l_sw[6]|l_sw[7]|l_sw[8]|l_sw[9]|out|pad|padres|vc|vcp|vdd|vddr|vip|vss|z
+ \$74946 A|X$55
+ BOTTOM|TOP|VGND|VSS|anode|cathode|core|h_sw[0]|h_sw[10]|h_sw[1]|h_sw[2]|h_sw[3]|h_sw[4]|h_sw[5]|h_sw[6]|h_sw[7]|h_sw[8]|h_sw[9]|l_sw[0]|l_sw[10]|l_sw[1]|l_sw[2]|l_sw[3]|l_sw[4]|l_sw[5]|l_sw[6]|l_sw[7]|l_sw[8]|l_sw[9]|out|pad|padres|vc|vcp|vdd|vddr|vip|vss|z
+ sg13_lv_nmos L=0.13u W=0.74u AS=0.14875p AD=0.2886p PS=1.16u PD=2.26u rfmode=0
M$1319
+ BOTTOM|TOP|VGND|VSS|anode|cathode|core|h_sw[0]|h_sw[10]|h_sw[1]|h_sw[2]|h_sw[3]|h_sw[4]|h_sw[5]|h_sw[6]|h_sw[7]|h_sw[8]|h_sw[9]|l_sw[0]|l_sw[10]|l_sw[1]|l_sw[2]|l_sw[3]|l_sw[4]|l_sw[5]|l_sw[6]|l_sw[7]|l_sw[8]|l_sw[9]|out|pad|padres|vc|vcp|vdd|vddr|vip|vss|z
+ A|X$57 \$74949
+ BOTTOM|TOP|VGND|VSS|anode|cathode|core|h_sw[0]|h_sw[10]|h_sw[1]|h_sw[2]|h_sw[3]|h_sw[4]|h_sw[5]|h_sw[6]|h_sw[7]|h_sw[8]|h_sw[9]|l_sw[0]|l_sw[10]|l_sw[1]|l_sw[2]|l_sw[3]|l_sw[4]|l_sw[5]|l_sw[6]|l_sw[7]|l_sw[8]|l_sw[9]|out|pad|padres|vc|vcp|vdd|vddr|vip|vss|z
+ sg13_lv_nmos L=0.13u W=0.55u AS=0.14875p AD=0.187p PS=1.16u PD=1.78u rfmode=0
M$1320 X|in_h_sw[5]|ph_sw[5]|x \$74949
+ BOTTOM|TOP|VGND|VSS|anode|cathode|core|h_sw[0]|h_sw[10]|h_sw[1]|h_sw[2]|h_sw[3]|h_sw[4]|h_sw[5]|h_sw[6]|h_sw[7]|h_sw[8]|h_sw[9]|l_sw[0]|l_sw[10]|l_sw[1]|l_sw[2]|l_sw[3]|l_sw[4]|l_sw[5]|l_sw[6]|l_sw[7]|l_sw[8]|l_sw[9]|out|pad|padres|vc|vcp|vdd|vddr|vip|vss|z
+ BOTTOM|TOP|VGND|VSS|anode|cathode|core|h_sw[0]|h_sw[10]|h_sw[1]|h_sw[2]|h_sw[3]|h_sw[4]|h_sw[5]|h_sw[6]|h_sw[7]|h_sw[8]|h_sw[9]|l_sw[0]|l_sw[10]|l_sw[1]|l_sw[2]|l_sw[3]|l_sw[4]|l_sw[5]|l_sw[6]|l_sw[7]|l_sw[8]|l_sw[9]|out|pad|padres|vc|vcp|vdd|vddr|vip|vss|z
+ sg13_lv_nmos L=0.13u W=0.74u AS=0.2886p AD=0.14875p PS=2.26u PD=1.16u rfmode=0
M$1321
+ BOTTOM|TOP|VGND|VSS|anode|cathode|core|h_sw[0]|h_sw[10]|h_sw[1]|h_sw[2]|h_sw[3]|h_sw[4]|h_sw[5]|h_sw[6]|h_sw[7]|h_sw[8]|h_sw[9]|l_sw[0]|l_sw[10]|l_sw[1]|l_sw[2]|l_sw[3]|l_sw[4]|l_sw[5]|l_sw[6]|l_sw[7]|l_sw[8]|l_sw[9]|out|pad|padres|vc|vcp|vdd|vddr|vip|vss|z
+ A|X$61 \$74951
+ BOTTOM|TOP|VGND|VSS|anode|cathode|core|h_sw[0]|h_sw[10]|h_sw[1]|h_sw[2]|h_sw[3]|h_sw[4]|h_sw[5]|h_sw[6]|h_sw[7]|h_sw[8]|h_sw[9]|l_sw[0]|l_sw[10]|l_sw[1]|l_sw[2]|l_sw[3]|l_sw[4]|l_sw[5]|l_sw[6]|l_sw[7]|l_sw[8]|l_sw[9]|out|pad|padres|vc|vcp|vdd|vddr|vip|vss|z
+ sg13_lv_nmos L=0.13u W=0.55u AS=0.14875p AD=0.187p PS=1.16u PD=1.78u rfmode=0
M$1322 X|in_l_sw[6]|pl_sw[6]|x \$74951
+ BOTTOM|TOP|VGND|VSS|anode|cathode|core|h_sw[0]|h_sw[10]|h_sw[1]|h_sw[2]|h_sw[3]|h_sw[4]|h_sw[5]|h_sw[6]|h_sw[7]|h_sw[8]|h_sw[9]|l_sw[0]|l_sw[10]|l_sw[1]|l_sw[2]|l_sw[3]|l_sw[4]|l_sw[5]|l_sw[6]|l_sw[7]|l_sw[8]|l_sw[9]|out|pad|padres|vc|vcp|vdd|vddr|vip|vss|z
+ BOTTOM|TOP|VGND|VSS|anode|cathode|core|h_sw[0]|h_sw[10]|h_sw[1]|h_sw[2]|h_sw[3]|h_sw[4]|h_sw[5]|h_sw[6]|h_sw[7]|h_sw[8]|h_sw[9]|l_sw[0]|l_sw[10]|l_sw[1]|l_sw[2]|l_sw[3]|l_sw[4]|l_sw[5]|l_sw[6]|l_sw[7]|l_sw[8]|l_sw[9]|out|pad|padres|vc|vcp|vdd|vddr|vip|vss|z
+ sg13_lv_nmos L=0.13u W=0.74u AS=0.2886p AD=0.14875p PS=2.26u PD=1.16u rfmode=0
M$1323
+ BOTTOM|TOP|VGND|VSS|anode|cathode|core|h_sw[0]|h_sw[10]|h_sw[1]|h_sw[2]|h_sw[3]|h_sw[4]|h_sw[5]|h_sw[6]|h_sw[7]|h_sw[8]|h_sw[9]|l_sw[0]|l_sw[10]|l_sw[1]|l_sw[2]|l_sw[3]|l_sw[4]|l_sw[5]|l_sw[6]|l_sw[7]|l_sw[8]|l_sw[9]|out|pad|padres|vc|vcp|vdd|vddr|vip|vss|z
+ A|Q$19 \$74952
+ BOTTOM|TOP|VGND|VSS|anode|cathode|core|h_sw[0]|h_sw[10]|h_sw[1]|h_sw[2]|h_sw[3]|h_sw[4]|h_sw[5]|h_sw[6]|h_sw[7]|h_sw[8]|h_sw[9]|l_sw[0]|l_sw[10]|l_sw[1]|l_sw[2]|l_sw[3]|l_sw[4]|l_sw[5]|l_sw[6]|l_sw[7]|l_sw[8]|l_sw[9]|out|pad|padres|vc|vcp|vdd|vddr|vip|vss|z
+ sg13_lv_nmos L=0.13u W=0.55u AS=0.14875p AD=0.187p PS=1.16u PD=1.78u rfmode=0
M$1324 A|X$46 \$74952
+ BOTTOM|TOP|VGND|VSS|anode|cathode|core|h_sw[0]|h_sw[10]|h_sw[1]|h_sw[2]|h_sw[3]|h_sw[4]|h_sw[5]|h_sw[6]|h_sw[7]|h_sw[8]|h_sw[9]|l_sw[0]|l_sw[10]|l_sw[1]|l_sw[2]|l_sw[3]|l_sw[4]|l_sw[5]|l_sw[6]|l_sw[7]|l_sw[8]|l_sw[9]|out|pad|padres|vc|vcp|vdd|vddr|vip|vss|z
+ BOTTOM|TOP|VGND|VSS|anode|cathode|core|h_sw[0]|h_sw[10]|h_sw[1]|h_sw[2]|h_sw[3]|h_sw[4]|h_sw[5]|h_sw[6]|h_sw[7]|h_sw[8]|h_sw[9]|l_sw[0]|l_sw[10]|l_sw[1]|l_sw[2]|l_sw[3]|l_sw[4]|l_sw[5]|l_sw[6]|l_sw[7]|l_sw[8]|l_sw[9]|out|pad|padres|vc|vcp|vdd|vddr|vip|vss|z
+ sg13_lv_nmos L=0.13u W=0.74u AS=0.2886p AD=0.14875p PS=2.26u PD=1.16u rfmode=0
M$1325 \$74953 A|Q$21
+ BOTTOM|TOP|VGND|VSS|anode|cathode|core|h_sw[0]|h_sw[10]|h_sw[1]|h_sw[2]|h_sw[3]|h_sw[4]|h_sw[5]|h_sw[6]|h_sw[7]|h_sw[8]|h_sw[9]|l_sw[0]|l_sw[10]|l_sw[1]|l_sw[2]|l_sw[3]|l_sw[4]|l_sw[5]|l_sw[6]|l_sw[7]|l_sw[8]|l_sw[9]|out|pad|padres|vc|vcp|vdd|vddr|vip|vss|z
+ BOTTOM|TOP|VGND|VSS|anode|cathode|core|h_sw[0]|h_sw[10]|h_sw[1]|h_sw[2]|h_sw[3]|h_sw[4]|h_sw[5]|h_sw[6]|h_sw[7]|h_sw[8]|h_sw[9]|l_sw[0]|l_sw[10]|l_sw[1]|l_sw[2]|l_sw[3]|l_sw[4]|l_sw[5]|l_sw[6]|l_sw[7]|l_sw[8]|l_sw[9]|out|pad|padres|vc|vcp|vdd|vddr|vip|vss|z
+ sg13_lv_nmos L=0.13u W=0.55u AS=0.187p AD=0.14875p PS=1.78u PD=1.16u rfmode=0
M$1326
+ BOTTOM|TOP|VGND|VSS|anode|cathode|core|h_sw[0]|h_sw[10]|h_sw[1]|h_sw[2]|h_sw[3]|h_sw[4]|h_sw[5]|h_sw[6]|h_sw[7]|h_sw[8]|h_sw[9]|l_sw[0]|l_sw[10]|l_sw[1]|l_sw[2]|l_sw[3]|l_sw[4]|l_sw[5]|l_sw[6]|l_sw[7]|l_sw[8]|l_sw[9]|out|pad|padres|vc|vcp|vdd|vddr|vip|vss|z
+ \$74953 A|X$56
+ BOTTOM|TOP|VGND|VSS|anode|cathode|core|h_sw[0]|h_sw[10]|h_sw[1]|h_sw[2]|h_sw[3]|h_sw[4]|h_sw[5]|h_sw[6]|h_sw[7]|h_sw[8]|h_sw[9]|l_sw[0]|l_sw[10]|l_sw[1]|l_sw[2]|l_sw[3]|l_sw[4]|l_sw[5]|l_sw[6]|l_sw[7]|l_sw[8]|l_sw[9]|out|pad|padres|vc|vcp|vdd|vddr|vip|vss|z
+ sg13_lv_nmos L=0.13u W=0.74u AS=0.14875p AD=0.2886p PS=1.16u PD=2.26u rfmode=0
M$1327 \$74867 \$75344 \$74956
+ BOTTOM|TOP|VGND|VSS|anode|cathode|core|h_sw[0]|h_sw[10]|h_sw[1]|h_sw[2]|h_sw[3]|h_sw[4]|h_sw[5]|h_sw[6]|h_sw[7]|h_sw[8]|h_sw[9]|l_sw[0]|l_sw[10]|l_sw[1]|l_sw[2]|l_sw[3]|l_sw[4]|l_sw[5]|l_sw[6]|l_sw[7]|l_sw[8]|l_sw[9]|out|pad|padres|vc|vcp|vdd|vddr|vip|vss|z
+ sg13_lv_nmos L=0.13u W=0.42u AS=0.1296p AD=0.0798p PS=1.52u PD=0.8u rfmode=0
M$1328 \$74956 \$74957 \$75361
+ BOTTOM|TOP|VGND|VSS|anode|cathode|core|h_sw[0]|h_sw[10]|h_sw[1]|h_sw[2]|h_sw[3]|h_sw[4]|h_sw[5]|h_sw[6]|h_sw[7]|h_sw[8]|h_sw[9]|l_sw[0]|l_sw[10]|l_sw[1]|l_sw[2]|l_sw[3]|l_sw[4]|l_sw[5]|l_sw[6]|l_sw[7]|l_sw[8]|l_sw[9]|out|pad|padres|vc|vcp|vdd|vddr|vip|vss|z
+ sg13_lv_nmos L=0.13u W=0.42u AS=0.0798p AD=0.2373p PS=0.8u PD=1.97u rfmode=0
M$1329 \$74957 \$75344
+ BOTTOM|TOP|VGND|VSS|anode|cathode|core|h_sw[0]|h_sw[10]|h_sw[1]|h_sw[2]|h_sw[3]|h_sw[4]|h_sw[5]|h_sw[6]|h_sw[7]|h_sw[8]|h_sw[9]|l_sw[0]|l_sw[10]|l_sw[1]|l_sw[2]|l_sw[3]|l_sw[4]|l_sw[5]|l_sw[6]|l_sw[7]|l_sw[8]|l_sw[9]|out|pad|padres|vc|vcp|vdd|vddr|vip|vss|z
+ BOTTOM|TOP|VGND|VSS|anode|cathode|core|h_sw[0]|h_sw[10]|h_sw[1]|h_sw[2]|h_sw[3]|h_sw[4]|h_sw[5]|h_sw[6]|h_sw[7]|h_sw[8]|h_sw[9]|l_sw[0]|l_sw[10]|l_sw[1]|l_sw[2]|l_sw[3]|l_sw[4]|l_sw[5]|l_sw[6]|l_sw[7]|l_sw[8]|l_sw[9]|out|pad|padres|vc|vcp|vdd|vddr|vip|vss|z
+ sg13_lv_nmos L=0.13u W=0.74u AS=0.2516p AD=0.317325p PS=2.16u PD=1.805u
+ rfmode=0
M$1330
+ BOTTOM|TOP|VGND|VSS|anode|cathode|core|h_sw[0]|h_sw[10]|h_sw[1]|h_sw[2]|h_sw[3]|h_sw[4]|h_sw[5]|h_sw[6]|h_sw[7]|h_sw[8]|h_sw[9]|l_sw[0]|l_sw[10]|l_sw[1]|l_sw[2]|l_sw[3]|l_sw[4]|l_sw[5]|l_sw[6]|l_sw[7]|l_sw[8]|l_sw[9]|out|pad|padres|vc|vcp|vdd|vddr|vip|vss|z
+ A|CLK|X$1 \$75344
+ BOTTOM|TOP|VGND|VSS|anode|cathode|core|h_sw[0]|h_sw[10]|h_sw[1]|h_sw[2]|h_sw[3]|h_sw[4]|h_sw[5]|h_sw[6]|h_sw[7]|h_sw[8]|h_sw[9]|l_sw[0]|l_sw[10]|l_sw[1]|l_sw[2]|l_sw[3]|l_sw[4]|l_sw[5]|l_sw[6]|l_sw[7]|l_sw[8]|l_sw[9]|out|pad|padres|vc|vcp|vdd|vddr|vip|vss|z
+ sg13_lv_nmos L=0.13u W=0.74u AS=0.317325p AD=0.2516p PS=1.805u PD=2.16u
+ rfmode=0
M$1331 \$75373 \$75344 \$75345
+ BOTTOM|TOP|VGND|VSS|anode|cathode|core|h_sw[0]|h_sw[10]|h_sw[1]|h_sw[2]|h_sw[3]|h_sw[4]|h_sw[5]|h_sw[6]|h_sw[7]|h_sw[8]|h_sw[9]|l_sw[0]|l_sw[10]|l_sw[1]|l_sw[2]|l_sw[3]|l_sw[4]|l_sw[5]|l_sw[6]|l_sw[7]|l_sw[8]|l_sw[9]|out|pad|padres|vc|vcp|vdd|vddr|vip|vss|z
+ sg13_lv_nmos L=0.13u W=0.42u AS=0.1428p AD=0.12665p PS=1.52u PD=1.145u
+ rfmode=0
M$1332 \$75345 \$74957 \$74955
+ BOTTOM|TOP|VGND|VSS|anode|cathode|core|h_sw[0]|h_sw[10]|h_sw[1]|h_sw[2]|h_sw[3]|h_sw[4]|h_sw[5]|h_sw[6]|h_sw[7]|h_sw[8]|h_sw[9]|l_sw[0]|l_sw[10]|l_sw[1]|l_sw[2]|l_sw[3]|l_sw[4]|l_sw[5]|l_sw[6]|l_sw[7]|l_sw[8]|l_sw[9]|out|pad|padres|vc|vcp|vdd|vddr|vip|vss|z
+ sg13_lv_nmos L=0.13u W=0.74u AS=0.12665p AD=0.3473p PS=1.145u PD=2.71u
+ rfmode=0
M$1333
+ BOTTOM|TOP|VGND|VSS|anode|cathode|core|h_sw[0]|h_sw[10]|h_sw[1]|h_sw[2]|h_sw[3]|h_sw[4]|h_sw[5]|h_sw[6]|h_sw[7]|h_sw[8]|h_sw[9]|l_sw[0]|l_sw[10]|l_sw[1]|l_sw[2]|l_sw[3]|l_sw[4]|l_sw[5]|l_sw[6]|l_sw[7]|l_sw[8]|l_sw[9]|out|pad|padres|vc|vcp|vdd|vddr|vip|vss|z
+ \$75345 Q_N$38
+ BOTTOM|TOP|VGND|VSS|anode|cathode|core|h_sw[0]|h_sw[10]|h_sw[1]|h_sw[2]|h_sw[3]|h_sw[4]|h_sw[5]|h_sw[6]|h_sw[7]|h_sw[8]|h_sw[9]|l_sw[0]|l_sw[10]|l_sw[1]|l_sw[2]|l_sw[3]|l_sw[4]|l_sw[5]|l_sw[6]|l_sw[7]|l_sw[8]|l_sw[9]|out|pad|padres|vc|vcp|vdd|vddr|vip|vss|z
+ sg13_lv_nmos L=0.13u W=0.74u AS=0.2516p AD=0.2849p PS=2.16u PD=2.25u rfmode=0
M$1334 \$74959 \$75345
+ BOTTOM|TOP|VGND|VSS|anode|cathode|core|h_sw[0]|h_sw[10]|h_sw[1]|h_sw[2]|h_sw[3]|h_sw[4]|h_sw[5]|h_sw[6]|h_sw[7]|h_sw[8]|h_sw[9]|l_sw[0]|l_sw[10]|l_sw[1]|l_sw[2]|l_sw[3]|l_sw[4]|l_sw[5]|l_sw[6]|l_sw[7]|l_sw[8]|l_sw[9]|out|pad|padres|vc|vcp|vdd|vddr|vip|vss|z
+ BOTTOM|TOP|VGND|VSS|anode|cathode|core|h_sw[0]|h_sw[10]|h_sw[1]|h_sw[2]|h_sw[3]|h_sw[4]|h_sw[5]|h_sw[6]|h_sw[7]|h_sw[8]|h_sw[9]|l_sw[0]|l_sw[10]|l_sw[1]|l_sw[2]|l_sw[3]|l_sw[4]|l_sw[5]|l_sw[6]|l_sw[7]|l_sw[8]|l_sw[9]|out|pad|padres|vc|vcp|vdd|vddr|vip|vss|z
+ sg13_lv_nmos L=0.13u W=0.74u AS=0.2516p AD=0.1406p PS=2.16u PD=1.12u rfmode=0
M$1335
+ BOTTOM|TOP|VGND|VSS|anode|cathode|core|h_sw[0]|h_sw[10]|h_sw[1]|h_sw[2]|h_sw[3]|h_sw[4]|h_sw[5]|h_sw[6]|h_sw[7]|h_sw[8]|h_sw[9]|l_sw[0]|l_sw[10]|l_sw[1]|l_sw[2]|l_sw[3]|l_sw[4]|l_sw[5]|l_sw[6]|l_sw[7]|l_sw[8]|l_sw[9]|out|pad|padres|vc|vcp|vdd|vddr|vip|vss|z
+ \$74959 CLK|D|GATE|Q$8
+ BOTTOM|TOP|VGND|VSS|anode|cathode|core|h_sw[0]|h_sw[10]|h_sw[1]|h_sw[2]|h_sw[3]|h_sw[4]|h_sw[5]|h_sw[6]|h_sw[7]|h_sw[8]|h_sw[9]|l_sw[0]|l_sw[10]|l_sw[1]|l_sw[2]|l_sw[3]|l_sw[4]|l_sw[5]|l_sw[6]|l_sw[7]|l_sw[8]|l_sw[9]|out|pad|padres|vc|vcp|vdd|vddr|vip|vss|z
+ sg13_lv_nmos L=0.13u W=0.74u AS=0.1406p AD=0.2516p PS=1.12u PD=2.16u rfmode=0
M$1336 \$74960 D|Q_N$10
+ BOTTOM|TOP|VGND|VSS|anode|cathode|core|h_sw[0]|h_sw[10]|h_sw[1]|h_sw[2]|h_sw[3]|h_sw[4]|h_sw[5]|h_sw[6]|h_sw[7]|h_sw[8]|h_sw[9]|l_sw[0]|l_sw[10]|l_sw[1]|l_sw[2]|l_sw[3]|l_sw[4]|l_sw[5]|l_sw[6]|l_sw[7]|l_sw[8]|l_sw[9]|out|pad|padres|vc|vcp|vdd|vddr|vip|vss|z
+ BOTTOM|TOP|VGND|VSS|anode|cathode|core|h_sw[0]|h_sw[10]|h_sw[1]|h_sw[2]|h_sw[3]|h_sw[4]|h_sw[5]|h_sw[6]|h_sw[7]|h_sw[8]|h_sw[9]|l_sw[0]|l_sw[10]|l_sw[1]|l_sw[2]|l_sw[3]|l_sw[4]|l_sw[5]|l_sw[6]|l_sw[7]|l_sw[8]|l_sw[9]|out|pad|padres|vc|vcp|vdd|vddr|vip|vss|z
+ sg13_lv_nmos L=0.13u W=0.55u AS=0.187p AD=0.15055p PS=1.78u PD=1.17u rfmode=0
M$1337
+ BOTTOM|TOP|VGND|VSS|anode|cathode|core|h_sw[0]|h_sw[10]|h_sw[1]|h_sw[2]|h_sw[3]|h_sw[4]|h_sw[5]|h_sw[6]|h_sw[7]|h_sw[8]|h_sw[9]|l_sw[0]|l_sw[10]|l_sw[1]|l_sw[2]|l_sw[3]|l_sw[4]|l_sw[5]|l_sw[6]|l_sw[7]|l_sw[8]|l_sw[9]|out|pad|padres|vc|vcp|vdd|vddr|vip|vss|z
+ CLK|D|GATE|Q$8 \$75347
+ BOTTOM|TOP|VGND|VSS|anode|cathode|core|h_sw[0]|h_sw[10]|h_sw[1]|h_sw[2]|h_sw[3]|h_sw[4]|h_sw[5]|h_sw[6]|h_sw[7]|h_sw[8]|h_sw[9]|l_sw[0]|l_sw[10]|l_sw[1]|l_sw[2]|l_sw[3]|l_sw[4]|l_sw[5]|l_sw[6]|l_sw[7]|l_sw[8]|l_sw[9]|out|pad|padres|vc|vcp|vdd|vddr|vip|vss|z
+ sg13_lv_nmos L=0.13u W=0.74u AS=0.15055p AD=0.2516p PS=1.17u PD=2.16u rfmode=0
M$1338 \$74961 \$75347 \$75498
+ BOTTOM|TOP|VGND|VSS|anode|cathode|core|h_sw[0]|h_sw[10]|h_sw[1]|h_sw[2]|h_sw[3]|h_sw[4]|h_sw[5]|h_sw[6]|h_sw[7]|h_sw[8]|h_sw[9]|l_sw[0]|l_sw[10]|l_sw[1]|l_sw[2]|l_sw[3]|l_sw[4]|l_sw[5]|l_sw[6]|l_sw[7]|l_sw[8]|l_sw[9]|out|pad|padres|vc|vcp|vdd|vddr|vip|vss|z
+ sg13_lv_nmos L=0.13u W=0.42u AS=0.141p AD=0.04725p PS=1.17u PD=0.645u rfmode=0
M$1339 \$75498 \$74962
+ BOTTOM|TOP|VGND|VSS|anode|cathode|core|h_sw[0]|h_sw[10]|h_sw[1]|h_sw[2]|h_sw[3]|h_sw[4]|h_sw[5]|h_sw[6]|h_sw[7]|h_sw[8]|h_sw[9]|l_sw[0]|l_sw[10]|l_sw[1]|l_sw[2]|l_sw[3]|l_sw[4]|l_sw[5]|l_sw[6]|l_sw[7]|l_sw[8]|l_sw[9]|out|pad|padres|vc|vcp|vdd|vddr|vip|vss|z
+ BOTTOM|TOP|VGND|VSS|anode|cathode|core|h_sw[0]|h_sw[10]|h_sw[1]|h_sw[2]|h_sw[3]|h_sw[4]|h_sw[5]|h_sw[6]|h_sw[7]|h_sw[8]|h_sw[9]|l_sw[0]|l_sw[10]|l_sw[1]|l_sw[2]|l_sw[3]|l_sw[4]|l_sw[5]|l_sw[6]|l_sw[7]|l_sw[8]|l_sw[9]|out|pad|padres|vc|vcp|vdd|vddr|vip|vss|z
+ sg13_lv_nmos L=0.13u W=0.42u AS=0.04725p AD=0.1428p PS=0.645u PD=1.52u
+ rfmode=0
M$1340 \$75348 \$75347
+ BOTTOM|TOP|VGND|VSS|anode|cathode|core|h_sw[0]|h_sw[10]|h_sw[1]|h_sw[2]|h_sw[3]|h_sw[4]|h_sw[5]|h_sw[6]|h_sw[7]|h_sw[8]|h_sw[9]|l_sw[0]|l_sw[10]|l_sw[1]|l_sw[2]|l_sw[3]|l_sw[4]|l_sw[5]|l_sw[6]|l_sw[7]|l_sw[8]|l_sw[9]|out|pad|padres|vc|vcp|vdd|vddr|vip|vss|z
+ BOTTOM|TOP|VGND|VSS|anode|cathode|core|h_sw[0]|h_sw[10]|h_sw[1]|h_sw[2]|h_sw[3]|h_sw[4]|h_sw[5]|h_sw[6]|h_sw[7]|h_sw[8]|h_sw[9]|l_sw[0]|l_sw[10]|l_sw[1]|l_sw[2]|l_sw[3]|l_sw[4]|l_sw[5]|l_sw[6]|l_sw[7]|l_sw[8]|l_sw[9]|out|pad|padres|vc|vcp|vdd|vddr|vip|vss|z
+ sg13_lv_nmos L=0.13u W=0.74u AS=0.2775p AD=0.213425p PS=2.23u PD=1.62u
+ rfmode=0
M$1341
+ BOTTOM|TOP|VGND|VSS|anode|cathode|core|h_sw[0]|h_sw[10]|h_sw[1]|h_sw[2]|h_sw[3]|h_sw[4]|h_sw[5]|h_sw[6]|h_sw[7]|h_sw[8]|h_sw[9]|l_sw[0]|l_sw[10]|l_sw[1]|l_sw[2]|l_sw[3]|l_sw[4]|l_sw[5]|l_sw[6]|l_sw[7]|l_sw[8]|l_sw[9]|out|pad|padres|vc|vcp|vdd|vddr|vip|vss|z
+ \$74960 \$75499
+ BOTTOM|TOP|VGND|VSS|anode|cathode|core|h_sw[0]|h_sw[10]|h_sw[1]|h_sw[2]|h_sw[3]|h_sw[4]|h_sw[5]|h_sw[6]|h_sw[7]|h_sw[8]|h_sw[9]|l_sw[0]|l_sw[10]|l_sw[1]|l_sw[2]|l_sw[3]|l_sw[4]|l_sw[5]|l_sw[6]|l_sw[7]|l_sw[8]|l_sw[9]|out|pad|padres|vc|vcp|vdd|vddr|vip|vss|z
+ sg13_lv_nmos L=0.13u W=0.64u AS=0.213425p AD=0.072p PS=1.62u PD=0.865u
+ rfmode=0
M$1342 \$75499 \$75348 \$74961
+ BOTTOM|TOP|VGND|VSS|anode|cathode|core|h_sw[0]|h_sw[10]|h_sw[1]|h_sw[2]|h_sw[3]|h_sw[4]|h_sw[5]|h_sw[6]|h_sw[7]|h_sw[8]|h_sw[9]|l_sw[0]|l_sw[10]|l_sw[1]|l_sw[2]|l_sw[3]|l_sw[4]|l_sw[5]|l_sw[6]|l_sw[7]|l_sw[8]|l_sw[9]|out|pad|padres|vc|vcp|vdd|vddr|vip|vss|z
+ sg13_lv_nmos L=0.13u W=0.64u AS=0.072p AD=0.141p PS=0.865u PD=1.17u rfmode=0
M$1343 \$74966 A|Q$23
+ BOTTOM|TOP|VGND|VSS|anode|cathode|core|h_sw[0]|h_sw[10]|h_sw[1]|h_sw[2]|h_sw[3]|h_sw[4]|h_sw[5]|h_sw[6]|h_sw[7]|h_sw[8]|h_sw[9]|l_sw[0]|l_sw[10]|l_sw[1]|l_sw[2]|l_sw[3]|l_sw[4]|l_sw[5]|l_sw[6]|l_sw[7]|l_sw[8]|l_sw[9]|out|pad|padres|vc|vcp|vdd|vddr|vip|vss|z
+ BOTTOM|TOP|VGND|VSS|anode|cathode|core|h_sw[0]|h_sw[10]|h_sw[1]|h_sw[2]|h_sw[3]|h_sw[4]|h_sw[5]|h_sw[6]|h_sw[7]|h_sw[8]|h_sw[9]|l_sw[0]|l_sw[10]|l_sw[1]|l_sw[2]|l_sw[3]|l_sw[4]|l_sw[5]|l_sw[6]|l_sw[7]|l_sw[8]|l_sw[9]|out|pad|padres|vc|vcp|vdd|vddr|vip|vss|z
+ sg13_lv_nmos L=0.13u W=0.55u AS=0.187p AD=0.14875p PS=1.78u PD=1.16u rfmode=0
M$1344
+ BOTTOM|TOP|VGND|VSS|anode|cathode|core|h_sw[0]|h_sw[10]|h_sw[1]|h_sw[2]|h_sw[3]|h_sw[4]|h_sw[5]|h_sw[6]|h_sw[7]|h_sw[8]|h_sw[9]|l_sw[0]|l_sw[10]|l_sw[1]|l_sw[2]|l_sw[3]|l_sw[4]|l_sw[5]|l_sw[6]|l_sw[7]|l_sw[8]|l_sw[9]|out|pad|padres|vc|vcp|vdd|vddr|vip|vss|z
+ \$74966 A|X$32
+ BOTTOM|TOP|VGND|VSS|anode|cathode|core|h_sw[0]|h_sw[10]|h_sw[1]|h_sw[2]|h_sw[3]|h_sw[4]|h_sw[5]|h_sw[6]|h_sw[7]|h_sw[8]|h_sw[9]|l_sw[0]|l_sw[10]|l_sw[1]|l_sw[2]|l_sw[3]|l_sw[4]|l_sw[5]|l_sw[6]|l_sw[7]|l_sw[8]|l_sw[9]|out|pad|padres|vc|vcp|vdd|vddr|vip|vss|z
+ sg13_lv_nmos L=0.13u W=0.74u AS=0.14875p AD=0.2886p PS=1.16u PD=2.26u rfmode=0
M$1345
+ BOTTOM|TOP|VGND|VSS|anode|cathode|core|h_sw[0]|h_sw[10]|h_sw[1]|h_sw[2]|h_sw[3]|h_sw[4]|h_sw[5]|h_sw[6]|h_sw[7]|h_sw[8]|h_sw[9]|l_sw[0]|l_sw[10]|l_sw[1]|l_sw[2]|l_sw[3]|l_sw[4]|l_sw[5]|l_sw[6]|l_sw[7]|l_sw[8]|l_sw[9]|out|pad|padres|vc|vcp|vdd|vddr|vip|vss|z
+ A|X$65 \$74968
+ BOTTOM|TOP|VGND|VSS|anode|cathode|core|h_sw[0]|h_sw[10]|h_sw[1]|h_sw[2]|h_sw[3]|h_sw[4]|h_sw[5]|h_sw[6]|h_sw[7]|h_sw[8]|h_sw[9]|l_sw[0]|l_sw[10]|l_sw[1]|l_sw[2]|l_sw[3]|l_sw[4]|l_sw[5]|l_sw[6]|l_sw[7]|l_sw[8]|l_sw[9]|out|pad|padres|vc|vcp|vdd|vddr|vip|vss|z
+ sg13_lv_nmos L=0.13u W=0.55u AS=0.14875p AD=0.187p PS=1.16u PD=1.78u rfmode=0
M$1346 X|in_l_sw[9]|pl_sw[9]|x \$74968
+ BOTTOM|TOP|VGND|VSS|anode|cathode|core|h_sw[0]|h_sw[10]|h_sw[1]|h_sw[2]|h_sw[3]|h_sw[4]|h_sw[5]|h_sw[6]|h_sw[7]|h_sw[8]|h_sw[9]|l_sw[0]|l_sw[10]|l_sw[1]|l_sw[2]|l_sw[3]|l_sw[4]|l_sw[5]|l_sw[6]|l_sw[7]|l_sw[8]|l_sw[9]|out|pad|padres|vc|vcp|vdd|vddr|vip|vss|z
+ BOTTOM|TOP|VGND|VSS|anode|cathode|core|h_sw[0]|h_sw[10]|h_sw[1]|h_sw[2]|h_sw[3]|h_sw[4]|h_sw[5]|h_sw[6]|h_sw[7]|h_sw[8]|h_sw[9]|l_sw[0]|l_sw[10]|l_sw[1]|l_sw[2]|l_sw[3]|l_sw[4]|l_sw[5]|l_sw[6]|l_sw[7]|l_sw[8]|l_sw[9]|out|pad|padres|vc|vcp|vdd|vddr|vip|vss|z
+ sg13_lv_nmos L=0.13u W=0.74u AS=0.2886p AD=0.14875p PS=2.26u PD=1.16u rfmode=0
M$1347 \$74969 A|Y$29
+ BOTTOM|TOP|VGND|VSS|anode|cathode|core|h_sw[0]|h_sw[10]|h_sw[1]|h_sw[2]|h_sw[3]|h_sw[4]|h_sw[5]|h_sw[6]|h_sw[7]|h_sw[8]|h_sw[9]|l_sw[0]|l_sw[10]|l_sw[1]|l_sw[2]|l_sw[3]|l_sw[4]|l_sw[5]|l_sw[6]|l_sw[7]|l_sw[8]|l_sw[9]|out|pad|padres|vc|vcp|vdd|vddr|vip|vss|z
+ BOTTOM|TOP|VGND|VSS|anode|cathode|core|h_sw[0]|h_sw[10]|h_sw[1]|h_sw[2]|h_sw[3]|h_sw[4]|h_sw[5]|h_sw[6]|h_sw[7]|h_sw[8]|h_sw[9]|l_sw[0]|l_sw[10]|l_sw[1]|l_sw[2]|l_sw[3]|l_sw[4]|l_sw[5]|l_sw[6]|l_sw[7]|l_sw[8]|l_sw[9]|out|pad|padres|vc|vcp|vdd|vddr|vip|vss|z
+ sg13_lv_nmos L=0.13u W=0.55u AS=0.187p AD=0.14875p PS=1.78u PD=1.16u rfmode=0
M$1348
+ BOTTOM|TOP|VGND|VSS|anode|cathode|core|h_sw[0]|h_sw[10]|h_sw[1]|h_sw[2]|h_sw[3]|h_sw[4]|h_sw[5]|h_sw[6]|h_sw[7]|h_sw[8]|h_sw[9]|l_sw[0]|l_sw[10]|l_sw[1]|l_sw[2]|l_sw[3]|l_sw[4]|l_sw[5]|l_sw[6]|l_sw[7]|l_sw[8]|l_sw[9]|out|pad|padres|vc|vcp|vdd|vddr|vip|vss|z
+ \$74969 A|X$58
+ BOTTOM|TOP|VGND|VSS|anode|cathode|core|h_sw[0]|h_sw[10]|h_sw[1]|h_sw[2]|h_sw[3]|h_sw[4]|h_sw[5]|h_sw[6]|h_sw[7]|h_sw[8]|h_sw[9]|l_sw[0]|l_sw[10]|l_sw[1]|l_sw[2]|l_sw[3]|l_sw[4]|l_sw[5]|l_sw[6]|l_sw[7]|l_sw[8]|l_sw[9]|out|pad|padres|vc|vcp|vdd|vddr|vip|vss|z
+ sg13_lv_nmos L=0.13u W=0.74u AS=0.14875p AD=0.2886p PS=1.16u PD=2.26u rfmode=0
M$1349 \$74970 A|X$44
+ BOTTOM|TOP|VGND|VSS|anode|cathode|core|h_sw[0]|h_sw[10]|h_sw[1]|h_sw[2]|h_sw[3]|h_sw[4]|h_sw[5]|h_sw[6]|h_sw[7]|h_sw[8]|h_sw[9]|l_sw[0]|l_sw[10]|l_sw[1]|l_sw[2]|l_sw[3]|l_sw[4]|l_sw[5]|l_sw[6]|l_sw[7]|l_sw[8]|l_sw[9]|out|pad|padres|vc|vcp|vdd|vddr|vip|vss|z
+ BOTTOM|TOP|VGND|VSS|anode|cathode|core|h_sw[0]|h_sw[10]|h_sw[1]|h_sw[2]|h_sw[3]|h_sw[4]|h_sw[5]|h_sw[6]|h_sw[7]|h_sw[8]|h_sw[9]|l_sw[0]|l_sw[10]|l_sw[1]|l_sw[2]|l_sw[3]|l_sw[4]|l_sw[5]|l_sw[6]|l_sw[7]|l_sw[8]|l_sw[9]|out|pad|padres|vc|vcp|vdd|vddr|vip|vss|z
+ sg13_lv_nmos L=0.13u W=0.55u AS=0.187p AD=0.14875p PS=1.78u PD=1.16u rfmode=0
M$1350
+ BOTTOM|TOP|VGND|VSS|anode|cathode|core|h_sw[0]|h_sw[10]|h_sw[1]|h_sw[2]|h_sw[3]|h_sw[4]|h_sw[5]|h_sw[6]|h_sw[7]|h_sw[8]|h_sw[9]|l_sw[0]|l_sw[10]|l_sw[1]|l_sw[2]|l_sw[3]|l_sw[4]|l_sw[5]|l_sw[6]|l_sw[7]|l_sw[8]|l_sw[9]|out|pad|padres|vc|vcp|vdd|vddr|vip|vss|z
+ \$74970 A|X$48
+ BOTTOM|TOP|VGND|VSS|anode|cathode|core|h_sw[0]|h_sw[10]|h_sw[1]|h_sw[2]|h_sw[3]|h_sw[4]|h_sw[5]|h_sw[6]|h_sw[7]|h_sw[8]|h_sw[9]|l_sw[0]|l_sw[10]|l_sw[1]|l_sw[2]|l_sw[3]|l_sw[4]|l_sw[5]|l_sw[6]|l_sw[7]|l_sw[8]|l_sw[9]|out|pad|padres|vc|vcp|vdd|vddr|vip|vss|z
+ sg13_lv_nmos L=0.13u W=0.74u AS=0.14875p AD=0.2886p PS=1.16u PD=2.26u rfmode=0
M$1351
+ BOTTOM|TOP|VGND|VSS|anode|cathode|core|h_sw[0]|h_sw[10]|h_sw[1]|h_sw[2]|h_sw[3]|h_sw[4]|h_sw[5]|h_sw[6]|h_sw[7]|h_sw[8]|h_sw[9]|l_sw[0]|l_sw[10]|l_sw[1]|l_sw[2]|l_sw[3]|l_sw[4]|l_sw[5]|l_sw[6]|l_sw[7]|l_sw[8]|l_sw[9]|out|pad|padres|vc|vcp|vdd|vddr|vip|vss|z
+ A|X$58 \$74972
+ BOTTOM|TOP|VGND|VSS|anode|cathode|core|h_sw[0]|h_sw[10]|h_sw[1]|h_sw[2]|h_sw[3]|h_sw[4]|h_sw[5]|h_sw[6]|h_sw[7]|h_sw[8]|h_sw[9]|l_sw[0]|l_sw[10]|l_sw[1]|l_sw[2]|l_sw[3]|l_sw[4]|l_sw[5]|l_sw[6]|l_sw[7]|l_sw[8]|l_sw[9]|out|pad|padres|vc|vcp|vdd|vddr|vip|vss|z
+ sg13_lv_nmos L=0.13u W=0.55u AS=0.14875p AD=0.187p PS=1.16u PD=1.78u rfmode=0
M$1352 X|in_l_sw[10]|pl_sw[10]|x \$74972
+ BOTTOM|TOP|VGND|VSS|anode|cathode|core|h_sw[0]|h_sw[10]|h_sw[1]|h_sw[2]|h_sw[3]|h_sw[4]|h_sw[5]|h_sw[6]|h_sw[7]|h_sw[8]|h_sw[9]|l_sw[0]|l_sw[10]|l_sw[1]|l_sw[2]|l_sw[3]|l_sw[4]|l_sw[5]|l_sw[6]|l_sw[7]|l_sw[8]|l_sw[9]|out|pad|padres|vc|vcp|vdd|vddr|vip|vss|z
+ BOTTOM|TOP|VGND|VSS|anode|cathode|core|h_sw[0]|h_sw[10]|h_sw[1]|h_sw[2]|h_sw[3]|h_sw[4]|h_sw[5]|h_sw[6]|h_sw[7]|h_sw[8]|h_sw[9]|l_sw[0]|l_sw[10]|l_sw[1]|l_sw[2]|l_sw[3]|l_sw[4]|l_sw[5]|l_sw[6]|l_sw[7]|l_sw[8]|l_sw[9]|out|pad|padres|vc|vcp|vdd|vddr|vip|vss|z
+ sg13_lv_nmos L=0.13u W=0.74u AS=0.2886p AD=0.14875p PS=2.26u PD=1.16u rfmode=0
M$1353 \$75356 \$75356
+ BOTTOM|TOP|VGND|VSS|anode|cathode|core|h_sw[0]|h_sw[10]|h_sw[1]|h_sw[2]|h_sw[3]|h_sw[4]|h_sw[5]|h_sw[6]|h_sw[7]|h_sw[8]|h_sw[9]|l_sw[0]|l_sw[10]|l_sw[1]|l_sw[2]|l_sw[3]|l_sw[4]|l_sw[5]|l_sw[6]|l_sw[7]|l_sw[8]|l_sw[9]|out|pad|padres|vc|vcp|vdd|vddr|vip|vss|z
+ BOTTOM|TOP|VGND|VSS|anode|cathode|core|h_sw[0]|h_sw[10]|h_sw[1]|h_sw[2]|h_sw[3]|h_sw[4]|h_sw[5]|h_sw[6]|h_sw[7]|h_sw[8]|h_sw[9]|l_sw[0]|l_sw[10]|l_sw[1]|l_sw[2]|l_sw[3]|l_sw[4]|l_sw[5]|l_sw[6]|l_sw[7]|l_sw[8]|l_sw[9]|out|pad|padres|vc|vcp|vdd|vddr|vip|vss|z
+ sg13_lv_nmos L=0.13u W=0.3u AS=0.111p AD=0.2043375p PS=1.34u PD=1.585u
+ rfmode=0
M$1354
+ BOTTOM|TOP|VGND|VSS|anode|cathode|core|h_sw[0]|h_sw[10]|h_sw[1]|h_sw[2]|h_sw[3]|h_sw[4]|h_sw[5]|h_sw[6]|h_sw[7]|h_sw[8]|h_sw[9]|l_sw[0]|l_sw[10]|l_sw[1]|l_sw[2]|l_sw[3]|l_sw[4]|l_sw[5]|l_sw[6]|l_sw[7]|l_sw[8]|l_sw[9]|out|pad|padres|vc|vcp|vdd|vddr|vip|vss|z
+ \$75332 \$75357
+ BOTTOM|TOP|VGND|VSS|anode|cathode|core|h_sw[0]|h_sw[10]|h_sw[1]|h_sw[2]|h_sw[3]|h_sw[4]|h_sw[5]|h_sw[6]|h_sw[7]|h_sw[8]|h_sw[9]|l_sw[0]|l_sw[10]|l_sw[1]|l_sw[2]|l_sw[3]|l_sw[4]|l_sw[5]|l_sw[6]|l_sw[7]|l_sw[8]|l_sw[9]|out|pad|padres|vc|vcp|vdd|vddr|vip|vss|z
+ sg13_lv_nmos L=0.13u W=0.795u AS=0.2043375p AD=0.274275p PS=1.585u PD=2.28u
+ rfmode=0
M$1355
+ BOTTOM|TOP|VGND|VSS|anode|cathode|core|h_sw[0]|h_sw[10]|h_sw[1]|h_sw[2]|h_sw[3]|h_sw[4]|h_sw[5]|h_sw[6]|h_sw[7]|h_sw[8]|h_sw[9]|l_sw[0]|l_sw[10]|l_sw[1]|l_sw[2]|l_sw[3]|l_sw[4]|l_sw[5]|l_sw[6]|l_sw[7]|l_sw[8]|l_sw[9]|out|pad|padres|vc|vcp|vdd|vddr|vip|vss|z
+ \$74929 \$74928
+ BOTTOM|TOP|VGND|VSS|anode|cathode|core|h_sw[0]|h_sw[10]|h_sw[1]|h_sw[2]|h_sw[3]|h_sw[4]|h_sw[5]|h_sw[6]|h_sw[7]|h_sw[8]|h_sw[9]|l_sw[0]|l_sw[10]|l_sw[1]|l_sw[2]|l_sw[3]|l_sw[4]|l_sw[5]|l_sw[6]|l_sw[7]|l_sw[8]|l_sw[9]|out|pad|padres|vc|vcp|vdd|vddr|vip|vss|z
+ sg13_lv_nmos L=0.13u W=0.74u AS=0.1626p AD=0.2516p PS=1.415u PD=2.16u rfmode=0
M$1356 \$74864 D|L_HI \$75487
+ BOTTOM|TOP|VGND|VSS|anode|cathode|core|h_sw[0]|h_sw[10]|h_sw[1]|h_sw[2]|h_sw[3]|h_sw[4]|h_sw[5]|h_sw[6]|h_sw[7]|h_sw[8]|h_sw[9]|l_sw[0]|l_sw[10]|l_sw[1]|l_sw[2]|l_sw[3]|l_sw[4]|l_sw[5]|l_sw[6]|l_sw[7]|l_sw[8]|l_sw[9]|out|pad|padres|vc|vcp|vdd|vddr|vip|vss|z
+ sg13_lv_nmos L=0.13u W=0.42u AS=0.1428p AD=0.0609p PS=1.52u PD=0.71u rfmode=0
M$1357
+ BOTTOM|TOP|VGND|VSS|anode|cathode|core|h_sw[0]|h_sw[10]|h_sw[1]|h_sw[2]|h_sw[3]|h_sw[4]|h_sw[5]|h_sw[6]|h_sw[7]|h_sw[8]|h_sw[9]|l_sw[0]|l_sw[10]|l_sw[1]|l_sw[2]|l_sw[3]|l_sw[4]|l_sw[5]|l_sw[6]|l_sw[7]|l_sw[8]|l_sw[9]|out|pad|padres|vc|vcp|vdd|vddr|vip|vss|z
+ RESET_B|Y$2 \$75487
+ BOTTOM|TOP|VGND|VSS|anode|cathode|core|h_sw[0]|h_sw[10]|h_sw[1]|h_sw[2]|h_sw[3]|h_sw[4]|h_sw[5]|h_sw[6]|h_sw[7]|h_sw[8]|h_sw[9]|l_sw[0]|l_sw[10]|l_sw[1]|l_sw[2]|l_sw[3]|l_sw[4]|l_sw[5]|l_sw[6]|l_sw[7]|l_sw[8]|l_sw[9]|out|pad|padres|vc|vcp|vdd|vddr|vip|vss|z
+ sg13_lv_nmos L=0.13u W=0.42u AS=0.1626p AD=0.0609p PS=1.415u PD=0.71u rfmode=0
M$1358
+ BOTTOM|TOP|VGND|VSS|anode|cathode|core|h_sw[0]|h_sw[10]|h_sw[1]|h_sw[2]|h_sw[3]|h_sw[4]|h_sw[5]|h_sw[6]|h_sw[7]|h_sw[8]|h_sw[9]|l_sw[0]|l_sw[10]|l_sw[1]|l_sw[2]|l_sw[3]|l_sw[4]|l_sw[5]|l_sw[6]|l_sw[7]|l_sw[8]|l_sw[9]|out|pad|padres|vc|vcp|vdd|vddr|vip|vss|z
+ RESET_B|Y$2 \$75486
+ BOTTOM|TOP|VGND|VSS|anode|cathode|core|h_sw[0]|h_sw[10]|h_sw[1]|h_sw[2]|h_sw[3]|h_sw[4]|h_sw[5]|h_sw[6]|h_sw[7]|h_sw[8]|h_sw[9]|l_sw[0]|l_sw[10]|l_sw[1]|l_sw[2]|l_sw[3]|l_sw[4]|l_sw[5]|l_sw[6]|l_sw[7]|l_sw[8]|l_sw[9]|out|pad|padres|vc|vcp|vdd|vddr|vip|vss|z
+ sg13_lv_nmos L=0.13u W=0.42u AS=0.1701p AD=0.0378p PS=1.65u PD=0.6u rfmode=0
M$1359 \$75486 \$74928 \$75358
+ BOTTOM|TOP|VGND|VSS|anode|cathode|core|h_sw[0]|h_sw[10]|h_sw[1]|h_sw[2]|h_sw[3]|h_sw[4]|h_sw[5]|h_sw[6]|h_sw[7]|h_sw[8]|h_sw[9]|l_sw[0]|l_sw[10]|l_sw[1]|l_sw[2]|l_sw[3]|l_sw[4]|l_sw[5]|l_sw[6]|l_sw[7]|l_sw[8]|l_sw[9]|out|pad|padres|vc|vcp|vdd|vddr|vip|vss|z
+ sg13_lv_nmos L=0.13u W=0.42u AS=0.0378p AD=0.1428p PS=0.6u PD=1.52u rfmode=0
M$1360 \$75370 \$75335
+ BOTTOM|TOP|VGND|VSS|anode|cathode|core|h_sw[0]|h_sw[10]|h_sw[1]|h_sw[2]|h_sw[3]|h_sw[4]|h_sw[5]|h_sw[6]|h_sw[7]|h_sw[8]|h_sw[9]|l_sw[0]|l_sw[10]|l_sw[1]|l_sw[2]|l_sw[3]|l_sw[4]|l_sw[5]|l_sw[6]|l_sw[7]|l_sw[8]|l_sw[9]|out|pad|padres|vc|vcp|vdd|vddr|vip|vss|z
+ BOTTOM|TOP|VGND|VSS|anode|cathode|core|h_sw[0]|h_sw[10]|h_sw[1]|h_sw[2]|h_sw[3]|h_sw[4]|h_sw[5]|h_sw[6]|h_sw[7]|h_sw[8]|h_sw[9]|l_sw[0]|l_sw[10]|l_sw[1]|l_sw[2]|l_sw[3]|l_sw[4]|l_sw[5]|l_sw[6]|l_sw[7]|l_sw[8]|l_sw[9]|out|pad|padres|vc|vcp|vdd|vddr|vip|vss|z
+ sg13_lv_nmos L=0.13u W=0.42u AS=0.1428p AD=0.0798p PS=1.52u PD=0.8u rfmode=0
M$1361
+ BOTTOM|TOP|VGND|VSS|anode|cathode|core|h_sw[0]|h_sw[10]|h_sw[1]|h_sw[2]|h_sw[3]|h_sw[4]|h_sw[5]|h_sw[6]|h_sw[7]|h_sw[8]|h_sw[9]|l_sw[0]|l_sw[10]|l_sw[1]|l_sw[2]|l_sw[3]|l_sw[4]|l_sw[5]|l_sw[6]|l_sw[7]|l_sw[8]|l_sw[9]|out|pad|padres|vc|vcp|vdd|vddr|vip|vss|z
+ RESET_B|Y$2 \$75488
+ BOTTOM|TOP|VGND|VSS|anode|cathode|core|h_sw[0]|h_sw[10]|h_sw[1]|h_sw[2]|h_sw[3]|h_sw[4]|h_sw[5]|h_sw[6]|h_sw[7]|h_sw[8]|h_sw[9]|l_sw[0]|l_sw[10]|l_sw[1]|l_sw[2]|l_sw[3]|l_sw[4]|l_sw[5]|l_sw[6]|l_sw[7]|l_sw[8]|l_sw[9]|out|pad|padres|vc|vcp|vdd|vddr|vip|vss|z
+ sg13_lv_nmos L=0.13u W=0.42u AS=0.0798p AD=0.0378p PS=0.8u PD=0.6u rfmode=0
M$1362 \$75488 \$75334 \$75335
+ BOTTOM|TOP|VGND|VSS|anode|cathode|core|h_sw[0]|h_sw[10]|h_sw[1]|h_sw[2]|h_sw[3]|h_sw[4]|h_sw[5]|h_sw[6]|h_sw[7]|h_sw[8]|h_sw[9]|l_sw[0]|l_sw[10]|l_sw[1]|l_sw[2]|l_sw[3]|l_sw[4]|l_sw[5]|l_sw[6]|l_sw[7]|l_sw[8]|l_sw[9]|out|pad|padres|vc|vcp|vdd|vddr|vip|vss|z
+ sg13_lv_nmos L=0.13u W=0.42u AS=0.0378p AD=0.1428p PS=0.6u PD=1.52u rfmode=0
M$1363
+ BOTTOM|TOP|VGND|VSS|anode|cathode|core|h_sw[0]|h_sw[10]|h_sw[1]|h_sw[2]|h_sw[3]|h_sw[4]|h_sw[5]|h_sw[6]|h_sw[7]|h_sw[8]|h_sw[9]|l_sw[0]|l_sw[10]|l_sw[1]|l_sw[2]|l_sw[3]|l_sw[4]|l_sw[5]|l_sw[6]|l_sw[7]|l_sw[8]|l_sw[9]|out|pad|padres|vc|vcp|vdd|vddr|vip|vss|z
+ \$74934 \$74933
+ BOTTOM|TOP|VGND|VSS|anode|cathode|core|h_sw[0]|h_sw[10]|h_sw[1]|h_sw[2]|h_sw[3]|h_sw[4]|h_sw[5]|h_sw[6]|h_sw[7]|h_sw[8]|h_sw[9]|l_sw[0]|l_sw[10]|l_sw[1]|l_sw[2]|l_sw[3]|l_sw[4]|l_sw[5]|l_sw[6]|l_sw[7]|l_sw[8]|l_sw[9]|out|pad|padres|vc|vcp|vdd|vddr|vip|vss|z
+ sg13_lv_nmos L=0.13u W=0.74u AS=0.1626p AD=0.2516p PS=1.415u PD=2.16u rfmode=0
M$1364 \$74865 CLK|D|GATE|Q$5 \$75490
+ BOTTOM|TOP|VGND|VSS|anode|cathode|core|h_sw[0]|h_sw[10]|h_sw[1]|h_sw[2]|h_sw[3]|h_sw[4]|h_sw[5]|h_sw[6]|h_sw[7]|h_sw[8]|h_sw[9]|l_sw[0]|l_sw[10]|l_sw[1]|l_sw[2]|l_sw[3]|l_sw[4]|l_sw[5]|l_sw[6]|l_sw[7]|l_sw[8]|l_sw[9]|out|pad|padres|vc|vcp|vdd|vddr|vip|vss|z
+ sg13_lv_nmos L=0.13u W=0.42u AS=0.1428p AD=0.0609p PS=1.52u PD=0.71u rfmode=0
M$1365
+ BOTTOM|TOP|VGND|VSS|anode|cathode|core|h_sw[0]|h_sw[10]|h_sw[1]|h_sw[2]|h_sw[3]|h_sw[4]|h_sw[5]|h_sw[6]|h_sw[7]|h_sw[8]|h_sw[9]|l_sw[0]|l_sw[10]|l_sw[1]|l_sw[2]|l_sw[3]|l_sw[4]|l_sw[5]|l_sw[6]|l_sw[7]|l_sw[8]|l_sw[9]|out|pad|padres|vc|vcp|vdd|vddr|vip|vss|z
+ RESET_B|Y$2 \$75490
+ BOTTOM|TOP|VGND|VSS|anode|cathode|core|h_sw[0]|h_sw[10]|h_sw[1]|h_sw[2]|h_sw[3]|h_sw[4]|h_sw[5]|h_sw[6]|h_sw[7]|h_sw[8]|h_sw[9]|l_sw[0]|l_sw[10]|l_sw[1]|l_sw[2]|l_sw[3]|l_sw[4]|l_sw[5]|l_sw[6]|l_sw[7]|l_sw[8]|l_sw[9]|out|pad|padres|vc|vcp|vdd|vddr|vip|vss|z
+ sg13_lv_nmos L=0.13u W=0.42u AS=0.1626p AD=0.0609p PS=1.415u PD=0.71u rfmode=0
M$1366
+ BOTTOM|TOP|VGND|VSS|anode|cathode|core|h_sw[0]|h_sw[10]|h_sw[1]|h_sw[2]|h_sw[3]|h_sw[4]|h_sw[5]|h_sw[6]|h_sw[7]|h_sw[8]|h_sw[9]|l_sw[0]|l_sw[10]|l_sw[1]|l_sw[2]|l_sw[3]|l_sw[4]|l_sw[5]|l_sw[6]|l_sw[7]|l_sw[8]|l_sw[9]|out|pad|padres|vc|vcp|vdd|vddr|vip|vss|z
+ RESET_B|Y$2 \$75489
+ BOTTOM|TOP|VGND|VSS|anode|cathode|core|h_sw[0]|h_sw[10]|h_sw[1]|h_sw[2]|h_sw[3]|h_sw[4]|h_sw[5]|h_sw[6]|h_sw[7]|h_sw[8]|h_sw[9]|l_sw[0]|l_sw[10]|l_sw[1]|l_sw[2]|l_sw[3]|l_sw[4]|l_sw[5]|l_sw[6]|l_sw[7]|l_sw[8]|l_sw[9]|out|pad|padres|vc|vcp|vdd|vddr|vip|vss|z
+ sg13_lv_nmos L=0.13u W=0.42u AS=0.1701p AD=0.0378p PS=1.65u PD=0.6u rfmode=0
M$1367 \$75489 \$74933 \$75359
+ BOTTOM|TOP|VGND|VSS|anode|cathode|core|h_sw[0]|h_sw[10]|h_sw[1]|h_sw[2]|h_sw[3]|h_sw[4]|h_sw[5]|h_sw[6]|h_sw[7]|h_sw[8]|h_sw[9]|l_sw[0]|l_sw[10]|l_sw[1]|l_sw[2]|l_sw[3]|l_sw[4]|l_sw[5]|l_sw[6]|l_sw[7]|l_sw[8]|l_sw[9]|out|pad|padres|vc|vcp|vdd|vddr|vip|vss|z
+ sg13_lv_nmos L=0.13u W=0.42u AS=0.0378p AD=0.1428p PS=0.6u PD=1.52u rfmode=0
M$1368 \$75371 \$75338
+ BOTTOM|TOP|VGND|VSS|anode|cathode|core|h_sw[0]|h_sw[10]|h_sw[1]|h_sw[2]|h_sw[3]|h_sw[4]|h_sw[5]|h_sw[6]|h_sw[7]|h_sw[8]|h_sw[9]|l_sw[0]|l_sw[10]|l_sw[1]|l_sw[2]|l_sw[3]|l_sw[4]|l_sw[5]|l_sw[6]|l_sw[7]|l_sw[8]|l_sw[9]|out|pad|padres|vc|vcp|vdd|vddr|vip|vss|z
+ BOTTOM|TOP|VGND|VSS|anode|cathode|core|h_sw[0]|h_sw[10]|h_sw[1]|h_sw[2]|h_sw[3]|h_sw[4]|h_sw[5]|h_sw[6]|h_sw[7]|h_sw[8]|h_sw[9]|l_sw[0]|l_sw[10]|l_sw[1]|l_sw[2]|l_sw[3]|l_sw[4]|l_sw[5]|l_sw[6]|l_sw[7]|l_sw[8]|l_sw[9]|out|pad|padres|vc|vcp|vdd|vddr|vip|vss|z
+ sg13_lv_nmos L=0.13u W=0.42u AS=0.1428p AD=0.0798p PS=1.52u PD=0.8u rfmode=0
M$1369
+ BOTTOM|TOP|VGND|VSS|anode|cathode|core|h_sw[0]|h_sw[10]|h_sw[1]|h_sw[2]|h_sw[3]|h_sw[4]|h_sw[5]|h_sw[6]|h_sw[7]|h_sw[8]|h_sw[9]|l_sw[0]|l_sw[10]|l_sw[1]|l_sw[2]|l_sw[3]|l_sw[4]|l_sw[5]|l_sw[6]|l_sw[7]|l_sw[8]|l_sw[9]|out|pad|padres|vc|vcp|vdd|vddr|vip|vss|z
+ RESET_B|Y$2 \$75491
+ BOTTOM|TOP|VGND|VSS|anode|cathode|core|h_sw[0]|h_sw[10]|h_sw[1]|h_sw[2]|h_sw[3]|h_sw[4]|h_sw[5]|h_sw[6]|h_sw[7]|h_sw[8]|h_sw[9]|l_sw[0]|l_sw[10]|l_sw[1]|l_sw[2]|l_sw[3]|l_sw[4]|l_sw[5]|l_sw[6]|l_sw[7]|l_sw[8]|l_sw[9]|out|pad|padres|vc|vcp|vdd|vddr|vip|vss|z
+ sg13_lv_nmos L=0.13u W=0.42u AS=0.0798p AD=0.0378p PS=0.8u PD=0.6u rfmode=0
M$1370 \$75491 \$75337 \$75338
+ BOTTOM|TOP|VGND|VSS|anode|cathode|core|h_sw[0]|h_sw[10]|h_sw[1]|h_sw[2]|h_sw[3]|h_sw[4]|h_sw[5]|h_sw[6]|h_sw[7]|h_sw[8]|h_sw[9]|l_sw[0]|l_sw[10]|l_sw[1]|l_sw[2]|l_sw[3]|l_sw[4]|l_sw[5]|l_sw[6]|l_sw[7]|l_sw[8]|l_sw[9]|out|pad|padres|vc|vcp|vdd|vddr|vip|vss|z
+ sg13_lv_nmos L=0.13u W=0.42u AS=0.0378p AD=0.1428p PS=0.6u PD=1.52u rfmode=0
M$1371
+ BOTTOM|TOP|VGND|VSS|anode|cathode|core|h_sw[0]|h_sw[10]|h_sw[1]|h_sw[2]|h_sw[3]|h_sw[4]|h_sw[5]|h_sw[6]|h_sw[7]|h_sw[8]|h_sw[9]|l_sw[0]|l_sw[10]|l_sw[1]|l_sw[2]|l_sw[3]|l_sw[4]|l_sw[5]|l_sw[6]|l_sw[7]|l_sw[8]|l_sw[9]|out|pad|padres|vc|vcp|vdd|vddr|vip|vss|z
+ \$74939 \$74938
+ BOTTOM|TOP|VGND|VSS|anode|cathode|core|h_sw[0]|h_sw[10]|h_sw[1]|h_sw[2]|h_sw[3]|h_sw[4]|h_sw[5]|h_sw[6]|h_sw[7]|h_sw[8]|h_sw[9]|l_sw[0]|l_sw[10]|l_sw[1]|l_sw[2]|l_sw[3]|l_sw[4]|l_sw[5]|l_sw[6]|l_sw[7]|l_sw[8]|l_sw[9]|out|pad|padres|vc|vcp|vdd|vddr|vip|vss|z
+ sg13_lv_nmos L=0.13u W=0.74u AS=0.1626p AD=0.2516p PS=1.415u PD=2.16u rfmode=0
M$1372 \$74866 CLK|D|GATE|Q$9 \$75492
+ BOTTOM|TOP|VGND|VSS|anode|cathode|core|h_sw[0]|h_sw[10]|h_sw[1]|h_sw[2]|h_sw[3]|h_sw[4]|h_sw[5]|h_sw[6]|h_sw[7]|h_sw[8]|h_sw[9]|l_sw[0]|l_sw[10]|l_sw[1]|l_sw[2]|l_sw[3]|l_sw[4]|l_sw[5]|l_sw[6]|l_sw[7]|l_sw[8]|l_sw[9]|out|pad|padres|vc|vcp|vdd|vddr|vip|vss|z
+ sg13_lv_nmos L=0.13u W=0.42u AS=0.1428p AD=0.0609p PS=1.52u PD=0.71u rfmode=0
M$1373
+ BOTTOM|TOP|VGND|VSS|anode|cathode|core|h_sw[0]|h_sw[10]|h_sw[1]|h_sw[2]|h_sw[3]|h_sw[4]|h_sw[5]|h_sw[6]|h_sw[7]|h_sw[8]|h_sw[9]|l_sw[0]|l_sw[10]|l_sw[1]|l_sw[2]|l_sw[3]|l_sw[4]|l_sw[5]|l_sw[6]|l_sw[7]|l_sw[8]|l_sw[9]|out|pad|padres|vc|vcp|vdd|vddr|vip|vss|z
+ RESET_B|Y$2 \$75492
+ BOTTOM|TOP|VGND|VSS|anode|cathode|core|h_sw[0]|h_sw[10]|h_sw[1]|h_sw[2]|h_sw[3]|h_sw[4]|h_sw[5]|h_sw[6]|h_sw[7]|h_sw[8]|h_sw[9]|l_sw[0]|l_sw[10]|l_sw[1]|l_sw[2]|l_sw[3]|l_sw[4]|l_sw[5]|l_sw[6]|l_sw[7]|l_sw[8]|l_sw[9]|out|pad|padres|vc|vcp|vdd|vddr|vip|vss|z
+ sg13_lv_nmos L=0.13u W=0.42u AS=0.1626p AD=0.0609p PS=1.415u PD=0.71u rfmode=0
M$1374
+ BOTTOM|TOP|VGND|VSS|anode|cathode|core|h_sw[0]|h_sw[10]|h_sw[1]|h_sw[2]|h_sw[3]|h_sw[4]|h_sw[5]|h_sw[6]|h_sw[7]|h_sw[8]|h_sw[9]|l_sw[0]|l_sw[10]|l_sw[1]|l_sw[2]|l_sw[3]|l_sw[4]|l_sw[5]|l_sw[6]|l_sw[7]|l_sw[8]|l_sw[9]|out|pad|padres|vc|vcp|vdd|vddr|vip|vss|z
+ RESET_B|Y$2 \$75493
+ BOTTOM|TOP|VGND|VSS|anode|cathode|core|h_sw[0]|h_sw[10]|h_sw[1]|h_sw[2]|h_sw[3]|h_sw[4]|h_sw[5]|h_sw[6]|h_sw[7]|h_sw[8]|h_sw[9]|l_sw[0]|l_sw[10]|l_sw[1]|l_sw[2]|l_sw[3]|l_sw[4]|l_sw[5]|l_sw[6]|l_sw[7]|l_sw[8]|l_sw[9]|out|pad|padres|vc|vcp|vdd|vddr|vip|vss|z
+ sg13_lv_nmos L=0.13u W=0.42u AS=0.1701p AD=0.0378p PS=1.65u PD=0.6u rfmode=0
M$1375 \$75493 \$74938 \$75360
+ BOTTOM|TOP|VGND|VSS|anode|cathode|core|h_sw[0]|h_sw[10]|h_sw[1]|h_sw[2]|h_sw[3]|h_sw[4]|h_sw[5]|h_sw[6]|h_sw[7]|h_sw[8]|h_sw[9]|l_sw[0]|l_sw[10]|l_sw[1]|l_sw[2]|l_sw[3]|l_sw[4]|l_sw[5]|l_sw[6]|l_sw[7]|l_sw[8]|l_sw[9]|out|pad|padres|vc|vcp|vdd|vddr|vip|vss|z
+ sg13_lv_nmos L=0.13u W=0.42u AS=0.0378p AD=0.1428p PS=0.6u PD=1.52u rfmode=0
M$1376 \$75372 \$75341
+ BOTTOM|TOP|VGND|VSS|anode|cathode|core|h_sw[0]|h_sw[10]|h_sw[1]|h_sw[2]|h_sw[3]|h_sw[4]|h_sw[5]|h_sw[6]|h_sw[7]|h_sw[8]|h_sw[9]|l_sw[0]|l_sw[10]|l_sw[1]|l_sw[2]|l_sw[3]|l_sw[4]|l_sw[5]|l_sw[6]|l_sw[7]|l_sw[8]|l_sw[9]|out|pad|padres|vc|vcp|vdd|vddr|vip|vss|z
+ BOTTOM|TOP|VGND|VSS|anode|cathode|core|h_sw[0]|h_sw[10]|h_sw[1]|h_sw[2]|h_sw[3]|h_sw[4]|h_sw[5]|h_sw[6]|h_sw[7]|h_sw[8]|h_sw[9]|l_sw[0]|l_sw[10]|l_sw[1]|l_sw[2]|l_sw[3]|l_sw[4]|l_sw[5]|l_sw[6]|l_sw[7]|l_sw[8]|l_sw[9]|out|pad|padres|vc|vcp|vdd|vddr|vip|vss|z
+ sg13_lv_nmos L=0.13u W=0.42u AS=0.1428p AD=0.0798p PS=1.52u PD=0.8u rfmode=0
M$1377
+ BOTTOM|TOP|VGND|VSS|anode|cathode|core|h_sw[0]|h_sw[10]|h_sw[1]|h_sw[2]|h_sw[3]|h_sw[4]|h_sw[5]|h_sw[6]|h_sw[7]|h_sw[8]|h_sw[9]|l_sw[0]|l_sw[10]|l_sw[1]|l_sw[2]|l_sw[3]|l_sw[4]|l_sw[5]|l_sw[6]|l_sw[7]|l_sw[8]|l_sw[9]|out|pad|padres|vc|vcp|vdd|vddr|vip|vss|z
+ RESET_B|Y$2 \$75494
+ BOTTOM|TOP|VGND|VSS|anode|cathode|core|h_sw[0]|h_sw[10]|h_sw[1]|h_sw[2]|h_sw[3]|h_sw[4]|h_sw[5]|h_sw[6]|h_sw[7]|h_sw[8]|h_sw[9]|l_sw[0]|l_sw[10]|l_sw[1]|l_sw[2]|l_sw[3]|l_sw[4]|l_sw[5]|l_sw[6]|l_sw[7]|l_sw[8]|l_sw[9]|out|pad|padres|vc|vcp|vdd|vddr|vip|vss|z
+ sg13_lv_nmos L=0.13u W=0.42u AS=0.0798p AD=0.0378p PS=0.8u PD=0.6u rfmode=0
M$1378 \$75494 \$75340 \$75341
+ BOTTOM|TOP|VGND|VSS|anode|cathode|core|h_sw[0]|h_sw[10]|h_sw[1]|h_sw[2]|h_sw[3]|h_sw[4]|h_sw[5]|h_sw[6]|h_sw[7]|h_sw[8]|h_sw[9]|l_sw[0]|l_sw[10]|l_sw[1]|l_sw[2]|l_sw[3]|l_sw[4]|l_sw[5]|l_sw[6]|l_sw[7]|l_sw[8]|l_sw[9]|out|pad|padres|vc|vcp|vdd|vddr|vip|vss|z
+ sg13_lv_nmos L=0.13u W=0.42u AS=0.0378p AD=0.1428p PS=0.6u PD=1.52u rfmode=0
M$1379
+ BOTTOM|TOP|VGND|VSS|anode|cathode|core|h_sw[0]|h_sw[10]|h_sw[1]|h_sw[2]|h_sw[3]|h_sw[4]|h_sw[5]|h_sw[6]|h_sw[7]|h_sw[8]|h_sw[9]|l_sw[0]|l_sw[10]|l_sw[1]|l_sw[2]|l_sw[3]|l_sw[4]|l_sw[5]|l_sw[6]|l_sw[7]|l_sw[8]|l_sw[9]|out|pad|padres|vc|vcp|vdd|vddr|vip|vss|z
+ \$74956 \$74955
+ BOTTOM|TOP|VGND|VSS|anode|cathode|core|h_sw[0]|h_sw[10]|h_sw[1]|h_sw[2]|h_sw[3]|h_sw[4]|h_sw[5]|h_sw[6]|h_sw[7]|h_sw[8]|h_sw[9]|l_sw[0]|l_sw[10]|l_sw[1]|l_sw[2]|l_sw[3]|l_sw[4]|l_sw[5]|l_sw[6]|l_sw[7]|l_sw[8]|l_sw[9]|out|pad|padres|vc|vcp|vdd|vddr|vip|vss|z
+ sg13_lv_nmos L=0.13u W=0.74u AS=0.1626p AD=0.2516p PS=1.415u PD=2.16u rfmode=0
M$1380 \$74867 CLK|D|GATE|Q$7 \$75496
+ BOTTOM|TOP|VGND|VSS|anode|cathode|core|h_sw[0]|h_sw[10]|h_sw[1]|h_sw[2]|h_sw[3]|h_sw[4]|h_sw[5]|h_sw[6]|h_sw[7]|h_sw[8]|h_sw[9]|l_sw[0]|l_sw[10]|l_sw[1]|l_sw[2]|l_sw[3]|l_sw[4]|l_sw[5]|l_sw[6]|l_sw[7]|l_sw[8]|l_sw[9]|out|pad|padres|vc|vcp|vdd|vddr|vip|vss|z
+ sg13_lv_nmos L=0.13u W=0.42u AS=0.1428p AD=0.0609p PS=1.52u PD=0.71u rfmode=0
M$1381
+ BOTTOM|TOP|VGND|VSS|anode|cathode|core|h_sw[0]|h_sw[10]|h_sw[1]|h_sw[2]|h_sw[3]|h_sw[4]|h_sw[5]|h_sw[6]|h_sw[7]|h_sw[8]|h_sw[9]|l_sw[0]|l_sw[10]|l_sw[1]|l_sw[2]|l_sw[3]|l_sw[4]|l_sw[5]|l_sw[6]|l_sw[7]|l_sw[8]|l_sw[9]|out|pad|padres|vc|vcp|vdd|vddr|vip|vss|z
+ RESET_B|Y$2 \$75496
+ BOTTOM|TOP|VGND|VSS|anode|cathode|core|h_sw[0]|h_sw[10]|h_sw[1]|h_sw[2]|h_sw[3]|h_sw[4]|h_sw[5]|h_sw[6]|h_sw[7]|h_sw[8]|h_sw[9]|l_sw[0]|l_sw[10]|l_sw[1]|l_sw[2]|l_sw[3]|l_sw[4]|l_sw[5]|l_sw[6]|l_sw[7]|l_sw[8]|l_sw[9]|out|pad|padres|vc|vcp|vdd|vddr|vip|vss|z
+ sg13_lv_nmos L=0.13u W=0.42u AS=0.1626p AD=0.0609p PS=1.415u PD=0.71u rfmode=0
M$1382
+ BOTTOM|TOP|VGND|VSS|anode|cathode|core|h_sw[0]|h_sw[10]|h_sw[1]|h_sw[2]|h_sw[3]|h_sw[4]|h_sw[5]|h_sw[6]|h_sw[7]|h_sw[8]|h_sw[9]|l_sw[0]|l_sw[10]|l_sw[1]|l_sw[2]|l_sw[3]|l_sw[4]|l_sw[5]|l_sw[6]|l_sw[7]|l_sw[8]|l_sw[9]|out|pad|padres|vc|vcp|vdd|vddr|vip|vss|z
+ RESET_B|Y$2 \$75495
+ BOTTOM|TOP|VGND|VSS|anode|cathode|core|h_sw[0]|h_sw[10]|h_sw[1]|h_sw[2]|h_sw[3]|h_sw[4]|h_sw[5]|h_sw[6]|h_sw[7]|h_sw[8]|h_sw[9]|l_sw[0]|l_sw[10]|l_sw[1]|l_sw[2]|l_sw[3]|l_sw[4]|l_sw[5]|l_sw[6]|l_sw[7]|l_sw[8]|l_sw[9]|out|pad|padres|vc|vcp|vdd|vddr|vip|vss|z
+ sg13_lv_nmos L=0.13u W=0.42u AS=0.1701p AD=0.0378p PS=1.65u PD=0.6u rfmode=0
M$1383 \$75495 \$74955 \$75361
+ BOTTOM|TOP|VGND|VSS|anode|cathode|core|h_sw[0]|h_sw[10]|h_sw[1]|h_sw[2]|h_sw[3]|h_sw[4]|h_sw[5]|h_sw[6]|h_sw[7]|h_sw[8]|h_sw[9]|l_sw[0]|l_sw[10]|l_sw[1]|l_sw[2]|l_sw[3]|l_sw[4]|l_sw[5]|l_sw[6]|l_sw[7]|l_sw[8]|l_sw[9]|out|pad|padres|vc|vcp|vdd|vddr|vip|vss|z
+ sg13_lv_nmos L=0.13u W=0.42u AS=0.0378p AD=0.1428p PS=0.6u PD=1.52u rfmode=0
M$1384 \$75373 \$75346
+ BOTTOM|TOP|VGND|VSS|anode|cathode|core|h_sw[0]|h_sw[10]|h_sw[1]|h_sw[2]|h_sw[3]|h_sw[4]|h_sw[5]|h_sw[6]|h_sw[7]|h_sw[8]|h_sw[9]|l_sw[0]|l_sw[10]|l_sw[1]|l_sw[2]|l_sw[3]|l_sw[4]|l_sw[5]|l_sw[6]|l_sw[7]|l_sw[8]|l_sw[9]|out|pad|padres|vc|vcp|vdd|vddr|vip|vss|z
+ BOTTOM|TOP|VGND|VSS|anode|cathode|core|h_sw[0]|h_sw[10]|h_sw[1]|h_sw[2]|h_sw[3]|h_sw[4]|h_sw[5]|h_sw[6]|h_sw[7]|h_sw[8]|h_sw[9]|l_sw[0]|l_sw[10]|l_sw[1]|l_sw[2]|l_sw[3]|l_sw[4]|l_sw[5]|l_sw[6]|l_sw[7]|l_sw[8]|l_sw[9]|out|pad|padres|vc|vcp|vdd|vddr|vip|vss|z
+ sg13_lv_nmos L=0.13u W=0.42u AS=0.1428p AD=0.0798p PS=1.52u PD=0.8u rfmode=0
M$1385
+ BOTTOM|TOP|VGND|VSS|anode|cathode|core|h_sw[0]|h_sw[10]|h_sw[1]|h_sw[2]|h_sw[3]|h_sw[4]|h_sw[5]|h_sw[6]|h_sw[7]|h_sw[8]|h_sw[9]|l_sw[0]|l_sw[10]|l_sw[1]|l_sw[2]|l_sw[3]|l_sw[4]|l_sw[5]|l_sw[6]|l_sw[7]|l_sw[8]|l_sw[9]|out|pad|padres|vc|vcp|vdd|vddr|vip|vss|z
+ RESET_B|Y$2 \$75497
+ BOTTOM|TOP|VGND|VSS|anode|cathode|core|h_sw[0]|h_sw[10]|h_sw[1]|h_sw[2]|h_sw[3]|h_sw[4]|h_sw[5]|h_sw[6]|h_sw[7]|h_sw[8]|h_sw[9]|l_sw[0]|l_sw[10]|l_sw[1]|l_sw[2]|l_sw[3]|l_sw[4]|l_sw[5]|l_sw[6]|l_sw[7]|l_sw[8]|l_sw[9]|out|pad|padres|vc|vcp|vdd|vddr|vip|vss|z
+ sg13_lv_nmos L=0.13u W=0.42u AS=0.0798p AD=0.0378p PS=0.8u PD=0.6u rfmode=0
M$1386 \$75497 \$75345 \$75346
+ BOTTOM|TOP|VGND|VSS|anode|cathode|core|h_sw[0]|h_sw[10]|h_sw[1]|h_sw[2]|h_sw[3]|h_sw[4]|h_sw[5]|h_sw[6]|h_sw[7]|h_sw[8]|h_sw[9]|l_sw[0]|l_sw[10]|l_sw[1]|l_sw[2]|l_sw[3]|l_sw[4]|l_sw[5]|l_sw[6]|l_sw[7]|l_sw[8]|l_sw[9]|out|pad|padres|vc|vcp|vdd|vddr|vip|vss|z
+ sg13_lv_nmos L=0.13u W=0.42u AS=0.0378p AD=0.1428p PS=0.6u PD=1.52u rfmode=0
M$1387 \$74962 \$74961 \$75500
+ BOTTOM|TOP|VGND|VSS|anode|cathode|core|h_sw[0]|h_sw[10]|h_sw[1]|h_sw[2]|h_sw[3]|h_sw[4]|h_sw[5]|h_sw[6]|h_sw[7]|h_sw[8]|h_sw[9]|l_sw[0]|l_sw[10]|l_sw[1]|l_sw[2]|l_sw[3]|l_sw[4]|l_sw[5]|l_sw[6]|l_sw[7]|l_sw[8]|l_sw[9]|out|pad|padres|vc|vcp|vdd|vddr|vip|vss|z
+ sg13_lv_nmos L=0.13u W=0.74u AS=0.2516p AD=0.0777p PS=2.16u PD=0.95u rfmode=0
M$1388 \$75500 RESET_B|Y$1
+ BOTTOM|TOP|VGND|VSS|anode|cathode|core|h_sw[0]|h_sw[10]|h_sw[1]|h_sw[2]|h_sw[3]|h_sw[4]|h_sw[5]|h_sw[6]|h_sw[7]|h_sw[8]|h_sw[9]|l_sw[0]|l_sw[10]|l_sw[1]|l_sw[2]|l_sw[3]|l_sw[4]|l_sw[5]|l_sw[6]|l_sw[7]|l_sw[8]|l_sw[9]|out|pad|padres|vc|vcp|vdd|vddr|vip|vss|z
+ BOTTOM|TOP|VGND|VSS|anode|cathode|core|h_sw[0]|h_sw[10]|h_sw[1]|h_sw[2]|h_sw[3]|h_sw[4]|h_sw[5]|h_sw[6]|h_sw[7]|h_sw[8]|h_sw[9]|l_sw[0]|l_sw[10]|l_sw[1]|l_sw[2]|l_sw[3]|l_sw[4]|l_sw[5]|l_sw[6]|l_sw[7]|l_sw[8]|l_sw[9]|out|pad|padres|vc|vcp|vdd|vddr|vip|vss|z
+ sg13_lv_nmos L=0.13u W=0.74u AS=0.0777p AD=0.1406p PS=0.95u PD=1.12u rfmode=0
M$1389
+ BOTTOM|TOP|VGND|VSS|anode|cathode|core|h_sw[0]|h_sw[10]|h_sw[1]|h_sw[2]|h_sw[3]|h_sw[4]|h_sw[5]|h_sw[6]|h_sw[7]|h_sw[8]|h_sw[9]|l_sw[0]|l_sw[10]|l_sw[1]|l_sw[2]|l_sw[3]|l_sw[4]|l_sw[5]|l_sw[6]|l_sw[7]|l_sw[8]|l_sw[9]|out|pad|padres|vc|vcp|vdd|vddr|vip|vss|z
+ \$74962 A|Q$23
+ BOTTOM|TOP|VGND|VSS|anode|cathode|core|h_sw[0]|h_sw[10]|h_sw[1]|h_sw[2]|h_sw[3]|h_sw[4]|h_sw[5]|h_sw[6]|h_sw[7]|h_sw[8]|h_sw[9]|l_sw[0]|l_sw[10]|l_sw[1]|l_sw[2]|l_sw[3]|l_sw[4]|l_sw[5]|l_sw[6]|l_sw[7]|l_sw[8]|l_sw[9]|out|pad|padres|vc|vcp|vdd|vddr|vip|vss|z
+ sg13_lv_nmos L=0.13u W=0.74u AS=0.1406p AD=0.2516p PS=1.12u PD=2.16u rfmode=0
M$1390
+ BOTTOM|TOP|VGND|VSS|anode|cathode|core|h_sw[0]|h_sw[10]|h_sw[1]|h_sw[2]|h_sw[3]|h_sw[4]|h_sw[5]|h_sw[6]|h_sw[7]|h_sw[8]|h_sw[9]|l_sw[0]|l_sw[10]|l_sw[1]|l_sw[2]|l_sw[3]|l_sw[4]|l_sw[5]|l_sw[6]|l_sw[7]|l_sw[8]|l_sw[9]|out|pad|padres|vc|vcp|vdd|vddr|vip|vss|z
+ \$74962 \$74964
+ BOTTOM|TOP|VGND|VSS|anode|cathode|core|h_sw[0]|h_sw[10]|h_sw[1]|h_sw[2]|h_sw[3]|h_sw[4]|h_sw[5]|h_sw[6]|h_sw[7]|h_sw[8]|h_sw[9]|l_sw[0]|l_sw[10]|l_sw[1]|l_sw[2]|l_sw[3]|l_sw[4]|l_sw[5]|l_sw[6]|l_sw[7]|l_sw[8]|l_sw[9]|out|pad|padres|vc|vcp|vdd|vddr|vip|vss|z
+ sg13_lv_nmos L=0.13u W=0.55u AS=0.1491p AD=0.187p PS=1.18u PD=1.78u rfmode=0
M$1391
+ BOTTOM|TOP|VGND|VSS|anode|cathode|core|h_sw[0]|h_sw[10]|h_sw[1]|h_sw[2]|h_sw[3]|h_sw[4]|h_sw[5]|h_sw[6]|h_sw[7]|h_sw[8]|h_sw[9]|l_sw[0]|l_sw[10]|l_sw[1]|l_sw[2]|l_sw[3]|l_sw[4]|l_sw[5]|l_sw[6]|l_sw[7]|l_sw[8]|l_sw[9]|out|pad|padres|vc|vcp|vdd|vddr|vip|vss|z
+ \$74964 Q_N$39
+ BOTTOM|TOP|VGND|VSS|anode|cathode|core|h_sw[0]|h_sw[10]|h_sw[1]|h_sw[2]|h_sw[3]|h_sw[4]|h_sw[5]|h_sw[6]|h_sw[7]|h_sw[8]|h_sw[9]|l_sw[0]|l_sw[10]|l_sw[1]|l_sw[2]|l_sw[3]|l_sw[4]|l_sw[5]|l_sw[6]|l_sw[7]|l_sw[8]|l_sw[9]|out|pad|padres|vc|vcp|vdd|vddr|vip|vss|z
+ sg13_lv_nmos L=0.13u W=0.74u AS=0.1491p AD=0.2516p PS=1.18u PD=2.16u rfmode=0
M$1392
+ BOTTOM|TOP|VGND|VSS|anode|cathode|core|h_sw[0]|h_sw[10]|h_sw[1]|h_sw[2]|h_sw[3]|h_sw[4]|h_sw[5]|h_sw[6]|h_sw[7]|h_sw[8]|h_sw[9]|l_sw[0]|l_sw[10]|l_sw[1]|l_sw[2]|l_sw[3]|l_sw[4]|l_sw[5]|l_sw[6]|l_sw[7]|l_sw[8]|l_sw[9]|out|pad|padres|vc|vcp|vdd|vddr|vip|vss|z
+ A|X$66 \$75634
+ BOTTOM|TOP|VGND|VSS|anode|cathode|core|h_sw[0]|h_sw[10]|h_sw[1]|h_sw[2]|h_sw[3]|h_sw[4]|h_sw[5]|h_sw[6]|h_sw[7]|h_sw[8]|h_sw[9]|l_sw[0]|l_sw[10]|l_sw[1]|l_sw[2]|l_sw[3]|l_sw[4]|l_sw[5]|l_sw[6]|l_sw[7]|l_sw[8]|l_sw[9]|out|pad|padres|vc|vcp|vdd|vddr|vip|vss|z
+ sg13_lv_nmos L=0.13u W=0.55u AS=0.14875p AD=0.187p PS=1.16u PD=1.78u rfmode=0
M$1393
+ BOTTOM|TOP|VGND|VSS|anode|cathode|core|h_sw[0]|h_sw[10]|h_sw[1]|h_sw[2]|h_sw[3]|h_sw[4]|h_sw[5]|h_sw[6]|h_sw[7]|h_sw[8]|h_sw[9]|l_sw[0]|l_sw[10]|l_sw[1]|l_sw[2]|l_sw[3]|l_sw[4]|l_sw[5]|l_sw[6]|l_sw[7]|l_sw[8]|l_sw[9]|out|pad|padres|vc|vcp|vdd|vddr|vip|vss|z
+ \$75634 X|in_h_sw[0]|ph_sw[0]|x
+ BOTTOM|TOP|VGND|VSS|anode|cathode|core|h_sw[0]|h_sw[10]|h_sw[1]|h_sw[2]|h_sw[3]|h_sw[4]|h_sw[5]|h_sw[6]|h_sw[7]|h_sw[8]|h_sw[9]|l_sw[0]|l_sw[10]|l_sw[1]|l_sw[2]|l_sw[3]|l_sw[4]|l_sw[5]|l_sw[6]|l_sw[7]|l_sw[8]|l_sw[9]|out|pad|padres|vc|vcp|vdd|vddr|vip|vss|z
+ sg13_lv_nmos L=0.13u W=0.74u AS=0.14875p AD=0.2886p PS=1.16u PD=2.26u rfmode=0
M$1394
+ BOTTOM|TOP|VGND|VSS|anode|cathode|core|h_sw[0]|h_sw[10]|h_sw[1]|h_sw[2]|h_sw[3]|h_sw[4]|h_sw[5]|h_sw[6]|h_sw[7]|h_sw[8]|h_sw[9]|l_sw[0]|l_sw[10]|l_sw[1]|l_sw[2]|l_sw[3]|l_sw[4]|l_sw[5]|l_sw[6]|l_sw[7]|l_sw[8]|l_sw[9]|out|pad|padres|vc|vcp|vdd|vddr|vip|vss|z
+ A|X$67 \$75635
+ BOTTOM|TOP|VGND|VSS|anode|cathode|core|h_sw[0]|h_sw[10]|h_sw[1]|h_sw[2]|h_sw[3]|h_sw[4]|h_sw[5]|h_sw[6]|h_sw[7]|h_sw[8]|h_sw[9]|l_sw[0]|l_sw[10]|l_sw[1]|l_sw[2]|l_sw[3]|l_sw[4]|l_sw[5]|l_sw[6]|l_sw[7]|l_sw[8]|l_sw[9]|out|pad|padres|vc|vcp|vdd|vddr|vip|vss|z
+ sg13_lv_nmos L=0.13u W=0.55u AS=0.14875p AD=0.187p PS=1.16u PD=1.78u rfmode=0
M$1395
+ BOTTOM|TOP|VGND|VSS|anode|cathode|core|h_sw[0]|h_sw[10]|h_sw[1]|h_sw[2]|h_sw[3]|h_sw[4]|h_sw[5]|h_sw[6]|h_sw[7]|h_sw[8]|h_sw[9]|l_sw[0]|l_sw[10]|l_sw[1]|l_sw[2]|l_sw[3]|l_sw[4]|l_sw[5]|l_sw[6]|l_sw[7]|l_sw[8]|l_sw[9]|out|pad|padres|vc|vcp|vdd|vddr|vip|vss|z
+ \$75635 X|in_l_sw[1]|pl_sw[1]|x
+ BOTTOM|TOP|VGND|VSS|anode|cathode|core|h_sw[0]|h_sw[10]|h_sw[1]|h_sw[2]|h_sw[3]|h_sw[4]|h_sw[5]|h_sw[6]|h_sw[7]|h_sw[8]|h_sw[9]|l_sw[0]|l_sw[10]|l_sw[1]|l_sw[2]|l_sw[3]|l_sw[4]|l_sw[5]|l_sw[6]|l_sw[7]|l_sw[8]|l_sw[9]|out|pad|padres|vc|vcp|vdd|vddr|vip|vss|z
+ sg13_lv_nmos L=0.13u W=0.74u AS=0.14875p AD=0.2886p PS=1.16u PD=2.26u rfmode=0
M$1396 A|X$66 \$75636
+ BOTTOM|TOP|VGND|VSS|anode|cathode|core|h_sw[0]|h_sw[10]|h_sw[1]|h_sw[2]|h_sw[3]|h_sw[4]|h_sw[5]|h_sw[6]|h_sw[7]|h_sw[8]|h_sw[9]|l_sw[0]|l_sw[10]|l_sw[1]|l_sw[2]|l_sw[3]|l_sw[4]|l_sw[5]|l_sw[6]|l_sw[7]|l_sw[8]|l_sw[9]|out|pad|padres|vc|vcp|vdd|vddr|vip|vss|z
+ BOTTOM|TOP|VGND|VSS|anode|cathode|core|h_sw[0]|h_sw[10]|h_sw[1]|h_sw[2]|h_sw[3]|h_sw[4]|h_sw[5]|h_sw[6]|h_sw[7]|h_sw[8]|h_sw[9]|l_sw[0]|l_sw[10]|l_sw[1]|l_sw[2]|l_sw[3]|l_sw[4]|l_sw[5]|l_sw[6]|l_sw[7]|l_sw[8]|l_sw[9]|out|pad|padres|vc|vcp|vdd|vddr|vip|vss|z
+ sg13_lv_nmos L=0.13u W=0.74u AS=0.2886p AD=0.14875p PS=2.26u PD=1.16u rfmode=0
M$1397
+ BOTTOM|TOP|VGND|VSS|anode|cathode|core|h_sw[0]|h_sw[10]|h_sw[1]|h_sw[2]|h_sw[3]|h_sw[4]|h_sw[5]|h_sw[6]|h_sw[7]|h_sw[8]|h_sw[9]|l_sw[0]|l_sw[10]|l_sw[1]|l_sw[2]|l_sw[3]|l_sw[4]|l_sw[5]|l_sw[6]|l_sw[7]|l_sw[8]|l_sw[9]|out|pad|padres|vc|vcp|vdd|vddr|vip|vss|z
+ A|X$33 \$75636
+ BOTTOM|TOP|VGND|VSS|anode|cathode|core|h_sw[0]|h_sw[10]|h_sw[1]|h_sw[2]|h_sw[3]|h_sw[4]|h_sw[5]|h_sw[6]|h_sw[7]|h_sw[8]|h_sw[9]|l_sw[0]|l_sw[10]|l_sw[1]|l_sw[2]|l_sw[3]|l_sw[4]|l_sw[5]|l_sw[6]|l_sw[7]|l_sw[8]|l_sw[9]|out|pad|padres|vc|vcp|vdd|vddr|vip|vss|z
+ sg13_lv_nmos L=0.13u W=0.55u AS=0.14875p AD=0.187p PS=1.16u PD=1.78u rfmode=0
M$1398
+ BOTTOM|TOP|VGND|VSS|anode|cathode|core|h_sw[0]|h_sw[10]|h_sw[1]|h_sw[2]|h_sw[3]|h_sw[4]|h_sw[5]|h_sw[6]|h_sw[7]|h_sw[8]|h_sw[9]|l_sw[0]|l_sw[10]|l_sw[1]|l_sw[2]|l_sw[3]|l_sw[4]|l_sw[5]|l_sw[6]|l_sw[7]|l_sw[8]|l_sw[9]|out|pad|padres|vc|vcp|vdd|vddr|vip|vss|z
+ A|X$68 \$75637
+ BOTTOM|TOP|VGND|VSS|anode|cathode|core|h_sw[0]|h_sw[10]|h_sw[1]|h_sw[2]|h_sw[3]|h_sw[4]|h_sw[5]|h_sw[6]|h_sw[7]|h_sw[8]|h_sw[9]|l_sw[0]|l_sw[10]|l_sw[1]|l_sw[2]|l_sw[3]|l_sw[4]|l_sw[5]|l_sw[6]|l_sw[7]|l_sw[8]|l_sw[9]|out|pad|padres|vc|vcp|vdd|vddr|vip|vss|z
+ sg13_lv_nmos L=0.13u W=0.55u AS=0.14875p AD=0.187p PS=1.16u PD=1.78u rfmode=0
M$1399
+ BOTTOM|TOP|VGND|VSS|anode|cathode|core|h_sw[0]|h_sw[10]|h_sw[1]|h_sw[2]|h_sw[3]|h_sw[4]|h_sw[5]|h_sw[6]|h_sw[7]|h_sw[8]|h_sw[9]|l_sw[0]|l_sw[10]|l_sw[1]|l_sw[2]|l_sw[3]|l_sw[4]|l_sw[5]|l_sw[6]|l_sw[7]|l_sw[8]|l_sw[9]|out|pad|padres|vc|vcp|vdd|vddr|vip|vss|z
+ \$75637 X|in_h_sw[1]|ph_sw[1]|x
+ BOTTOM|TOP|VGND|VSS|anode|cathode|core|h_sw[0]|h_sw[10]|h_sw[1]|h_sw[2]|h_sw[3]|h_sw[4]|h_sw[5]|h_sw[6]|h_sw[7]|h_sw[8]|h_sw[9]|l_sw[0]|l_sw[10]|l_sw[1]|l_sw[2]|l_sw[3]|l_sw[4]|l_sw[5]|l_sw[6]|l_sw[7]|l_sw[8]|l_sw[9]|out|pad|padres|vc|vcp|vdd|vddr|vip|vss|z
+ sg13_lv_nmos L=0.13u W=0.74u AS=0.14875p AD=0.2886p PS=1.16u PD=2.26u rfmode=0
M$1400
+ BOTTOM|TOP|VGND|VSS|anode|cathode|core|h_sw[0]|h_sw[10]|h_sw[1]|h_sw[2]|h_sw[3]|h_sw[4]|h_sw[5]|h_sw[6]|h_sw[7]|h_sw[8]|h_sw[9]|l_sw[0]|l_sw[10]|l_sw[1]|l_sw[2]|l_sw[3]|l_sw[4]|l_sw[5]|l_sw[6]|l_sw[7]|l_sw[8]|l_sw[9]|out|pad|padres|vc|vcp|vdd|vddr|vip|vss|z
+ A|X$59 \$75638
+ BOTTOM|TOP|VGND|VSS|anode|cathode|core|h_sw[0]|h_sw[10]|h_sw[1]|h_sw[2]|h_sw[3]|h_sw[4]|h_sw[5]|h_sw[6]|h_sw[7]|h_sw[8]|h_sw[9]|l_sw[0]|l_sw[10]|l_sw[1]|l_sw[2]|l_sw[3]|l_sw[4]|l_sw[5]|l_sw[6]|l_sw[7]|l_sw[8]|l_sw[9]|out|pad|padres|vc|vcp|vdd|vddr|vip|vss|z
+ sg13_lv_nmos L=0.13u W=0.55u AS=0.14875p AD=0.187p PS=1.16u PD=1.78u rfmode=0
M$1401
+ BOTTOM|TOP|VGND|VSS|anode|cathode|core|h_sw[0]|h_sw[10]|h_sw[1]|h_sw[2]|h_sw[3]|h_sw[4]|h_sw[5]|h_sw[6]|h_sw[7]|h_sw[8]|h_sw[9]|l_sw[0]|l_sw[10]|l_sw[1]|l_sw[2]|l_sw[3]|l_sw[4]|l_sw[5]|l_sw[6]|l_sw[7]|l_sw[8]|l_sw[9]|out|pad|padres|vc|vcp|vdd|vddr|vip|vss|z
+ \$75638 X|in_l_sw[2]|pl_sw[2]|x
+ BOTTOM|TOP|VGND|VSS|anode|cathode|core|h_sw[0]|h_sw[10]|h_sw[1]|h_sw[2]|h_sw[3]|h_sw[4]|h_sw[5]|h_sw[6]|h_sw[7]|h_sw[8]|h_sw[9]|l_sw[0]|l_sw[10]|l_sw[1]|l_sw[2]|l_sw[3]|l_sw[4]|l_sw[5]|l_sw[6]|l_sw[7]|l_sw[8]|l_sw[9]|out|pad|padres|vc|vcp|vdd|vddr|vip|vss|z
+ sg13_lv_nmos L=0.13u W=0.74u AS=0.14875p AD=0.2886p PS=1.16u PD=2.26u rfmode=0
M$1402 A|X$67 \$75639
+ BOTTOM|TOP|VGND|VSS|anode|cathode|core|h_sw[0]|h_sw[10]|h_sw[1]|h_sw[2]|h_sw[3]|h_sw[4]|h_sw[5]|h_sw[6]|h_sw[7]|h_sw[8]|h_sw[9]|l_sw[0]|l_sw[10]|l_sw[1]|l_sw[2]|l_sw[3]|l_sw[4]|l_sw[5]|l_sw[6]|l_sw[7]|l_sw[8]|l_sw[9]|out|pad|padres|vc|vcp|vdd|vddr|vip|vss|z
+ BOTTOM|TOP|VGND|VSS|anode|cathode|core|h_sw[0]|h_sw[10]|h_sw[1]|h_sw[2]|h_sw[3]|h_sw[4]|h_sw[5]|h_sw[6]|h_sw[7]|h_sw[8]|h_sw[9]|l_sw[0]|l_sw[10]|l_sw[1]|l_sw[2]|l_sw[3]|l_sw[4]|l_sw[5]|l_sw[6]|l_sw[7]|l_sw[8]|l_sw[9]|out|pad|padres|vc|vcp|vdd|vddr|vip|vss|z
+ sg13_lv_nmos L=0.13u W=0.74u AS=0.2886p AD=0.14875p PS=2.26u PD=1.16u rfmode=0
M$1403
+ BOTTOM|TOP|VGND|VSS|anode|cathode|core|h_sw[0]|h_sw[10]|h_sw[1]|h_sw[2]|h_sw[3]|h_sw[4]|h_sw[5]|h_sw[6]|h_sw[7]|h_sw[8]|h_sw[9]|l_sw[0]|l_sw[10]|l_sw[1]|l_sw[2]|l_sw[3]|l_sw[4]|l_sw[5]|l_sw[6]|l_sw[7]|l_sw[8]|l_sw[9]|out|pad|padres|vc|vcp|vdd|vddr|vip|vss|z
+ A|Y$21 \$75639
+ BOTTOM|TOP|VGND|VSS|anode|cathode|core|h_sw[0]|h_sw[10]|h_sw[1]|h_sw[2]|h_sw[3]|h_sw[4]|h_sw[5]|h_sw[6]|h_sw[7]|h_sw[8]|h_sw[9]|l_sw[0]|l_sw[10]|l_sw[1]|l_sw[2]|l_sw[3]|l_sw[4]|l_sw[5]|l_sw[6]|l_sw[7]|l_sw[8]|l_sw[9]|out|pad|padres|vc|vcp|vdd|vddr|vip|vss|z
+ sg13_lv_nmos L=0.13u W=0.55u AS=0.14875p AD=0.187p PS=1.16u PD=1.78u rfmode=0
M$1404 A|CLK|X \$75640
+ BOTTOM|TOP|VGND|VSS|anode|cathode|core|h_sw[0]|h_sw[10]|h_sw[1]|h_sw[2]|h_sw[3]|h_sw[4]|h_sw[5]|h_sw[6]|h_sw[7]|h_sw[8]|h_sw[9]|l_sw[0]|l_sw[10]|l_sw[1]|l_sw[2]|l_sw[3]|l_sw[4]|l_sw[5]|l_sw[6]|l_sw[7]|l_sw[8]|l_sw[9]|out|pad|padres|vc|vcp|vdd|vddr|vip|vss|z
+ BOTTOM|TOP|VGND|VSS|anode|cathode|core|h_sw[0]|h_sw[10]|h_sw[1]|h_sw[2]|h_sw[3]|h_sw[4]|h_sw[5]|h_sw[6]|h_sw[7]|h_sw[8]|h_sw[9]|l_sw[0]|l_sw[10]|l_sw[1]|l_sw[2]|l_sw[3]|l_sw[4]|l_sw[5]|l_sw[6]|l_sw[7]|l_sw[8]|l_sw[9]|out|pad|padres|vc|vcp|vdd|vddr|vip|vss|z
+ sg13_lv_nmos L=0.13u W=0.74u AS=0.2886p AD=0.14875p PS=2.26u PD=1.16u rfmode=0
M$1405
+ BOTTOM|TOP|VGND|VSS|anode|cathode|core|h_sw[0]|h_sw[10]|h_sw[1]|h_sw[2]|h_sw[3]|h_sw[4]|h_sw[5]|h_sw[6]|h_sw[7]|h_sw[8]|h_sw[9]|l_sw[0]|l_sw[10]|l_sw[1]|l_sw[2]|l_sw[3]|l_sw[4]|l_sw[5]|l_sw[6]|l_sw[7]|l_sw[8]|l_sw[9]|out|pad|padres|vc|vcp|vdd|vddr|vip|vss|z
+ A|X$52 \$75640
+ BOTTOM|TOP|VGND|VSS|anode|cathode|core|h_sw[0]|h_sw[10]|h_sw[1]|h_sw[2]|h_sw[3]|h_sw[4]|h_sw[5]|h_sw[6]|h_sw[7]|h_sw[8]|h_sw[9]|l_sw[0]|l_sw[10]|l_sw[1]|l_sw[2]|l_sw[3]|l_sw[4]|l_sw[5]|l_sw[6]|l_sw[7]|l_sw[8]|l_sw[9]|out|pad|padres|vc|vcp|vdd|vddr|vip|vss|z
+ sg13_lv_nmos L=0.13u W=0.55u AS=0.14875p AD=0.187p PS=1.16u PD=1.78u rfmode=0
M$1406 A|X$68 \$75641
+ BOTTOM|TOP|VGND|VSS|anode|cathode|core|h_sw[0]|h_sw[10]|h_sw[1]|h_sw[2]|h_sw[3]|h_sw[4]|h_sw[5]|h_sw[6]|h_sw[7]|h_sw[8]|h_sw[9]|l_sw[0]|l_sw[10]|l_sw[1]|l_sw[2]|l_sw[3]|l_sw[4]|l_sw[5]|l_sw[6]|l_sw[7]|l_sw[8]|l_sw[9]|out|pad|padres|vc|vcp|vdd|vddr|vip|vss|z
+ BOTTOM|TOP|VGND|VSS|anode|cathode|core|h_sw[0]|h_sw[10]|h_sw[1]|h_sw[2]|h_sw[3]|h_sw[4]|h_sw[5]|h_sw[6]|h_sw[7]|h_sw[8]|h_sw[9]|l_sw[0]|l_sw[10]|l_sw[1]|l_sw[2]|l_sw[3]|l_sw[4]|l_sw[5]|l_sw[6]|l_sw[7]|l_sw[8]|l_sw[9]|out|pad|padres|vc|vcp|vdd|vddr|vip|vss|z
+ sg13_lv_nmos L=0.13u W=0.74u AS=0.2886p AD=0.14875p PS=2.26u PD=1.16u rfmode=0
M$1407
+ BOTTOM|TOP|VGND|VSS|anode|cathode|core|h_sw[0]|h_sw[10]|h_sw[1]|h_sw[2]|h_sw[3]|h_sw[4]|h_sw[5]|h_sw[6]|h_sw[7]|h_sw[8]|h_sw[9]|l_sw[0]|l_sw[10]|l_sw[1]|l_sw[2]|l_sw[3]|l_sw[4]|l_sw[5]|l_sw[6]|l_sw[7]|l_sw[8]|l_sw[9]|out|pad|padres|vc|vcp|vdd|vddr|vip|vss|z
+ A|X$34 \$75641
+ BOTTOM|TOP|VGND|VSS|anode|cathode|core|h_sw[0]|h_sw[10]|h_sw[1]|h_sw[2]|h_sw[3]|h_sw[4]|h_sw[5]|h_sw[6]|h_sw[7]|h_sw[8]|h_sw[9]|l_sw[0]|l_sw[10]|l_sw[1]|l_sw[2]|l_sw[3]|l_sw[4]|l_sw[5]|l_sw[6]|l_sw[7]|l_sw[8]|l_sw[9]|out|pad|padres|vc|vcp|vdd|vddr|vip|vss|z
+ sg13_lv_nmos L=0.13u W=0.55u AS=0.14875p AD=0.187p PS=1.16u PD=1.78u rfmode=0
M$1408
+ BOTTOM|TOP|VGND|VSS|anode|cathode|core|h_sw[0]|h_sw[10]|h_sw[1]|h_sw[2]|h_sw[3]|h_sw[4]|h_sw[5]|h_sw[6]|h_sw[7]|h_sw[8]|h_sw[9]|l_sw[0]|l_sw[10]|l_sw[1]|l_sw[2]|l_sw[3]|l_sw[4]|l_sw[5]|l_sw[6]|l_sw[7]|l_sw[8]|l_sw[9]|out|pad|padres|vc|vcp|vdd|vddr|vip|vss|z
+ A|X$69 \$75642
+ BOTTOM|TOP|VGND|VSS|anode|cathode|core|h_sw[0]|h_sw[10]|h_sw[1]|h_sw[2]|h_sw[3]|h_sw[4]|h_sw[5]|h_sw[6]|h_sw[7]|h_sw[8]|h_sw[9]|l_sw[0]|l_sw[10]|l_sw[1]|l_sw[2]|l_sw[3]|l_sw[4]|l_sw[5]|l_sw[6]|l_sw[7]|l_sw[8]|l_sw[9]|out|pad|padres|vc|vcp|vdd|vddr|vip|vss|z
+ sg13_lv_nmos L=0.13u W=0.55u AS=0.14875p AD=0.187p PS=1.16u PD=1.78u rfmode=0
M$1409
+ BOTTOM|TOP|VGND|VSS|anode|cathode|core|h_sw[0]|h_sw[10]|h_sw[1]|h_sw[2]|h_sw[3]|h_sw[4]|h_sw[5]|h_sw[6]|h_sw[7]|h_sw[8]|h_sw[9]|l_sw[0]|l_sw[10]|l_sw[1]|l_sw[2]|l_sw[3]|l_sw[4]|l_sw[5]|l_sw[6]|l_sw[7]|l_sw[8]|l_sw[9]|out|pad|padres|vc|vcp|vdd|vddr|vip|vss|z
+ \$75642 X|in_h_sw[2]|ph_sw[2]|x
+ BOTTOM|TOP|VGND|VSS|anode|cathode|core|h_sw[0]|h_sw[10]|h_sw[1]|h_sw[2]|h_sw[3]|h_sw[4]|h_sw[5]|h_sw[6]|h_sw[7]|h_sw[8]|h_sw[9]|l_sw[0]|l_sw[10]|l_sw[1]|l_sw[2]|l_sw[3]|l_sw[4]|l_sw[5]|l_sw[6]|l_sw[7]|l_sw[8]|l_sw[9]|out|pad|padres|vc|vcp|vdd|vddr|vip|vss|z
+ sg13_lv_nmos L=0.13u W=0.74u AS=0.14875p AD=0.2886p PS=1.16u PD=2.26u rfmode=0
M$1410 A|X$59 \$75643
+ BOTTOM|TOP|VGND|VSS|anode|cathode|core|h_sw[0]|h_sw[10]|h_sw[1]|h_sw[2]|h_sw[3]|h_sw[4]|h_sw[5]|h_sw[6]|h_sw[7]|h_sw[8]|h_sw[9]|l_sw[0]|l_sw[10]|l_sw[1]|l_sw[2]|l_sw[3]|l_sw[4]|l_sw[5]|l_sw[6]|l_sw[7]|l_sw[8]|l_sw[9]|out|pad|padres|vc|vcp|vdd|vddr|vip|vss|z
+ BOTTOM|TOP|VGND|VSS|anode|cathode|core|h_sw[0]|h_sw[10]|h_sw[1]|h_sw[2]|h_sw[3]|h_sw[4]|h_sw[5]|h_sw[6]|h_sw[7]|h_sw[8]|h_sw[9]|l_sw[0]|l_sw[10]|l_sw[1]|l_sw[2]|l_sw[3]|l_sw[4]|l_sw[5]|l_sw[6]|l_sw[7]|l_sw[8]|l_sw[9]|out|pad|padres|vc|vcp|vdd|vddr|vip|vss|z
+ sg13_lv_nmos L=0.13u W=0.74u AS=0.2886p AD=0.14875p PS=2.26u PD=1.16u rfmode=0
M$1411
+ BOTTOM|TOP|VGND|VSS|anode|cathode|core|h_sw[0]|h_sw[10]|h_sw[1]|h_sw[2]|h_sw[3]|h_sw[4]|h_sw[5]|h_sw[6]|h_sw[7]|h_sw[8]|h_sw[9]|l_sw[0]|l_sw[10]|l_sw[1]|l_sw[2]|l_sw[3]|l_sw[4]|l_sw[5]|l_sw[6]|l_sw[7]|l_sw[8]|l_sw[9]|out|pad|padres|vc|vcp|vdd|vddr|vip|vss|z
+ A|Y$30 \$75643
+ BOTTOM|TOP|VGND|VSS|anode|cathode|core|h_sw[0]|h_sw[10]|h_sw[1]|h_sw[2]|h_sw[3]|h_sw[4]|h_sw[5]|h_sw[6]|h_sw[7]|h_sw[8]|h_sw[9]|l_sw[0]|l_sw[10]|l_sw[1]|l_sw[2]|l_sw[3]|l_sw[4]|l_sw[5]|l_sw[6]|l_sw[7]|l_sw[8]|l_sw[9]|out|pad|padres|vc|vcp|vdd|vddr|vip|vss|z
+ sg13_lv_nmos L=0.13u W=0.55u AS=0.14875p AD=0.187p PS=1.16u PD=1.78u rfmode=0
M$1412 A|Y$30 A|X$5
+ BOTTOM|TOP|VGND|VSS|anode|cathode|core|h_sw[0]|h_sw[10]|h_sw[1]|h_sw[2]|h_sw[3]|h_sw[4]|h_sw[5]|h_sw[6]|h_sw[7]|h_sw[8]|h_sw[9]|l_sw[0]|l_sw[10]|l_sw[1]|l_sw[2]|l_sw[3]|l_sw[4]|l_sw[5]|l_sw[6]|l_sw[7]|l_sw[8]|l_sw[9]|out|pad|padres|vc|vcp|vdd|vddr|vip|vss|z
+ BOTTOM|TOP|VGND|VSS|anode|cathode|core|h_sw[0]|h_sw[10]|h_sw[1]|h_sw[2]|h_sw[3]|h_sw[4]|h_sw[5]|h_sw[6]|h_sw[7]|h_sw[8]|h_sw[9]|l_sw[0]|l_sw[10]|l_sw[1]|l_sw[2]|l_sw[3]|l_sw[4]|l_sw[5]|l_sw[6]|l_sw[7]|l_sw[8]|l_sw[9]|out|pad|padres|vc|vcp|vdd|vddr|vip|vss|z
+ sg13_lv_nmos L=0.13u W=0.74u AS=0.2516p AD=0.2516p PS=2.16u PD=2.16u rfmode=0
M$1413 A|X$69 \$75644
+ BOTTOM|TOP|VGND|VSS|anode|cathode|core|h_sw[0]|h_sw[10]|h_sw[1]|h_sw[2]|h_sw[3]|h_sw[4]|h_sw[5]|h_sw[6]|h_sw[7]|h_sw[8]|h_sw[9]|l_sw[0]|l_sw[10]|l_sw[1]|l_sw[2]|l_sw[3]|l_sw[4]|l_sw[5]|l_sw[6]|l_sw[7]|l_sw[8]|l_sw[9]|out|pad|padres|vc|vcp|vdd|vddr|vip|vss|z
+ BOTTOM|TOP|VGND|VSS|anode|cathode|core|h_sw[0]|h_sw[10]|h_sw[1]|h_sw[2]|h_sw[3]|h_sw[4]|h_sw[5]|h_sw[6]|h_sw[7]|h_sw[8]|h_sw[9]|l_sw[0]|l_sw[10]|l_sw[1]|l_sw[2]|l_sw[3]|l_sw[4]|l_sw[5]|l_sw[6]|l_sw[7]|l_sw[8]|l_sw[9]|out|pad|padres|vc|vcp|vdd|vddr|vip|vss|z
+ sg13_lv_nmos L=0.13u W=0.74u AS=0.2886p AD=0.14875p PS=2.26u PD=1.16u rfmode=0
M$1414
+ BOTTOM|TOP|VGND|VSS|anode|cathode|core|h_sw[0]|h_sw[10]|h_sw[1]|h_sw[2]|h_sw[3]|h_sw[4]|h_sw[5]|h_sw[6]|h_sw[7]|h_sw[8]|h_sw[9]|l_sw[0]|l_sw[10]|l_sw[1]|l_sw[2]|l_sw[3]|l_sw[4]|l_sw[5]|l_sw[6]|l_sw[7]|l_sw[8]|l_sw[9]|out|pad|padres|vc|vcp|vdd|vddr|vip|vss|z
+ A|X$40 \$75644
+ BOTTOM|TOP|VGND|VSS|anode|cathode|core|h_sw[0]|h_sw[10]|h_sw[1]|h_sw[2]|h_sw[3]|h_sw[4]|h_sw[5]|h_sw[6]|h_sw[7]|h_sw[8]|h_sw[9]|l_sw[0]|l_sw[10]|l_sw[1]|l_sw[2]|l_sw[3]|l_sw[4]|l_sw[5]|l_sw[6]|l_sw[7]|l_sw[8]|l_sw[9]|out|pad|padres|vc|vcp|vdd|vddr|vip|vss|z
+ sg13_lv_nmos L=0.13u W=0.55u AS=0.14875p AD=0.187p PS=1.16u PD=1.78u rfmode=0
M$1415
+ BOTTOM|TOP|VGND|VSS|anode|cathode|core|h_sw[0]|h_sw[10]|h_sw[1]|h_sw[2]|h_sw[3]|h_sw[4]|h_sw[5]|h_sw[6]|h_sw[7]|h_sw[8]|h_sw[9]|l_sw[0]|l_sw[10]|l_sw[1]|l_sw[2]|l_sw[3]|l_sw[4]|l_sw[5]|l_sw[6]|l_sw[7]|l_sw[8]|l_sw[9]|out|pad|padres|vc|vcp|vdd|vddr|vip|vss|z
+ A|X$70 \$75645
+ BOTTOM|TOP|VGND|VSS|anode|cathode|core|h_sw[0]|h_sw[10]|h_sw[1]|h_sw[2]|h_sw[3]|h_sw[4]|h_sw[5]|h_sw[6]|h_sw[7]|h_sw[8]|h_sw[9]|l_sw[0]|l_sw[10]|l_sw[1]|l_sw[2]|l_sw[3]|l_sw[4]|l_sw[5]|l_sw[6]|l_sw[7]|l_sw[8]|l_sw[9]|out|pad|padres|vc|vcp|vdd|vddr|vip|vss|z
+ sg13_lv_nmos L=0.13u W=0.55u AS=0.14875p AD=0.187p PS=1.16u PD=1.78u rfmode=0
M$1416
+ BOTTOM|TOP|VGND|VSS|anode|cathode|core|h_sw[0]|h_sw[10]|h_sw[1]|h_sw[2]|h_sw[3]|h_sw[4]|h_sw[5]|h_sw[6]|h_sw[7]|h_sw[8]|h_sw[9]|l_sw[0]|l_sw[10]|l_sw[1]|l_sw[2]|l_sw[3]|l_sw[4]|l_sw[5]|l_sw[6]|l_sw[7]|l_sw[8]|l_sw[9]|out|pad|padres|vc|vcp|vdd|vddr|vip|vss|z
+ \$75645 X|in_h_sw[3]|ph_sw[3]|x
+ BOTTOM|TOP|VGND|VSS|anode|cathode|core|h_sw[0]|h_sw[10]|h_sw[1]|h_sw[2]|h_sw[3]|h_sw[4]|h_sw[5]|h_sw[6]|h_sw[7]|h_sw[8]|h_sw[9]|l_sw[0]|l_sw[10]|l_sw[1]|l_sw[2]|l_sw[3]|l_sw[4]|l_sw[5]|l_sw[6]|l_sw[7]|l_sw[8]|l_sw[9]|out|pad|padres|vc|vcp|vdd|vddr|vip|vss|z
+ sg13_lv_nmos L=0.13u W=0.74u AS=0.14875p AD=0.2886p PS=1.16u PD=2.26u rfmode=0
M$1417
+ BOTTOM|TOP|VGND|VSS|anode|cathode|core|h_sw[0]|h_sw[10]|h_sw[1]|h_sw[2]|h_sw[3]|h_sw[4]|h_sw[5]|h_sw[6]|h_sw[7]|h_sw[8]|h_sw[9]|l_sw[0]|l_sw[10]|l_sw[1]|l_sw[2]|l_sw[3]|l_sw[4]|l_sw[5]|l_sw[6]|l_sw[7]|l_sw[8]|l_sw[9]|out|pad|padres|vc|vcp|vdd|vddr|vip|vss|z
+ A|X$60 \$75646
+ BOTTOM|TOP|VGND|VSS|anode|cathode|core|h_sw[0]|h_sw[10]|h_sw[1]|h_sw[2]|h_sw[3]|h_sw[4]|h_sw[5]|h_sw[6]|h_sw[7]|h_sw[8]|h_sw[9]|l_sw[0]|l_sw[10]|l_sw[1]|l_sw[2]|l_sw[3]|l_sw[4]|l_sw[5]|l_sw[6]|l_sw[7]|l_sw[8]|l_sw[9]|out|pad|padres|vc|vcp|vdd|vddr|vip|vss|z
+ sg13_lv_nmos L=0.13u W=0.55u AS=0.14875p AD=0.187p PS=1.16u PD=1.78u rfmode=0
M$1418
+ BOTTOM|TOP|VGND|VSS|anode|cathode|core|h_sw[0]|h_sw[10]|h_sw[1]|h_sw[2]|h_sw[3]|h_sw[4]|h_sw[5]|h_sw[6]|h_sw[7]|h_sw[8]|h_sw[9]|l_sw[0]|l_sw[10]|l_sw[1]|l_sw[2]|l_sw[3]|l_sw[4]|l_sw[5]|l_sw[6]|l_sw[7]|l_sw[8]|l_sw[9]|out|pad|padres|vc|vcp|vdd|vddr|vip|vss|z
+ \$75646 X|in_l_sw[4]|pl_sw[4]|x
+ BOTTOM|TOP|VGND|VSS|anode|cathode|core|h_sw[0]|h_sw[10]|h_sw[1]|h_sw[2]|h_sw[3]|h_sw[4]|h_sw[5]|h_sw[6]|h_sw[7]|h_sw[8]|h_sw[9]|l_sw[0]|l_sw[10]|l_sw[1]|l_sw[2]|l_sw[3]|l_sw[4]|l_sw[5]|l_sw[6]|l_sw[7]|l_sw[8]|l_sw[9]|out|pad|padres|vc|vcp|vdd|vddr|vip|vss|z
+ sg13_lv_nmos L=0.13u W=0.74u AS=0.14875p AD=0.2886p PS=1.16u PD=2.26u rfmode=0
M$1419
+ BOTTOM|TOP|VGND|VSS|anode|cathode|core|h_sw[0]|h_sw[10]|h_sw[1]|h_sw[2]|h_sw[3]|h_sw[4]|h_sw[5]|h_sw[6]|h_sw[7]|h_sw[8]|h_sw[9]|l_sw[0]|l_sw[10]|l_sw[1]|l_sw[2]|l_sw[3]|l_sw[4]|l_sw[5]|l_sw[6]|l_sw[7]|l_sw[8]|l_sw[9]|out|pad|padres|vc|vcp|vdd|vddr|vip|vss|z
+ A|Y$27 \$75647
+ BOTTOM|TOP|VGND|VSS|anode|cathode|core|h_sw[0]|h_sw[10]|h_sw[1]|h_sw[2]|h_sw[3]|h_sw[4]|h_sw[5]|h_sw[6]|h_sw[7]|h_sw[8]|h_sw[9]|l_sw[0]|l_sw[10]|l_sw[1]|l_sw[2]|l_sw[3]|l_sw[4]|l_sw[5]|l_sw[6]|l_sw[7]|l_sw[8]|l_sw[9]|out|pad|padres|vc|vcp|vdd|vddr|vip|vss|z
+ sg13_lv_nmos L=0.13u W=0.55u AS=0.14875p AD=0.187p PS=1.16u PD=1.78u rfmode=0
M$1420
+ BOTTOM|TOP|VGND|VSS|anode|cathode|core|h_sw[0]|h_sw[10]|h_sw[1]|h_sw[2]|h_sw[3]|h_sw[4]|h_sw[5]|h_sw[6]|h_sw[7]|h_sw[8]|h_sw[9]|l_sw[0]|l_sw[10]|l_sw[1]|l_sw[2]|l_sw[3]|l_sw[4]|l_sw[5]|l_sw[6]|l_sw[7]|l_sw[8]|l_sw[9]|out|pad|padres|vc|vcp|vdd|vddr|vip|vss|z
+ \$75647 A|X$50
+ BOTTOM|TOP|VGND|VSS|anode|cathode|core|h_sw[0]|h_sw[10]|h_sw[1]|h_sw[2]|h_sw[3]|h_sw[4]|h_sw[5]|h_sw[6]|h_sw[7]|h_sw[8]|h_sw[9]|l_sw[0]|l_sw[10]|l_sw[1]|l_sw[2]|l_sw[3]|l_sw[4]|l_sw[5]|l_sw[6]|l_sw[7]|l_sw[8]|l_sw[9]|out|pad|padres|vc|vcp|vdd|vddr|vip|vss|z
+ sg13_lv_nmos L=0.13u W=0.74u AS=0.14875p AD=0.2886p PS=1.16u PD=2.26u rfmode=0
M$1421
+ BOTTOM|TOP|VGND|VSS|anode|cathode|core|h_sw[0]|h_sw[10]|h_sw[1]|h_sw[2]|h_sw[3]|h_sw[4]|h_sw[5]|h_sw[6]|h_sw[7]|h_sw[8]|h_sw[9]|l_sw[0]|l_sw[10]|l_sw[1]|l_sw[2]|l_sw[3]|l_sw[4]|l_sw[5]|l_sw[6]|l_sw[7]|l_sw[8]|l_sw[9]|out|pad|padres|vc|vcp|vdd|vddr|vip|vss|z
+ A|X$71 \$75648
+ BOTTOM|TOP|VGND|VSS|anode|cathode|core|h_sw[0]|h_sw[10]|h_sw[1]|h_sw[2]|h_sw[3]|h_sw[4]|h_sw[5]|h_sw[6]|h_sw[7]|h_sw[8]|h_sw[9]|l_sw[0]|l_sw[10]|l_sw[1]|l_sw[2]|l_sw[3]|l_sw[4]|l_sw[5]|l_sw[6]|l_sw[7]|l_sw[8]|l_sw[9]|out|pad|padres|vc|vcp|vdd|vddr|vip|vss|z
+ sg13_lv_nmos L=0.13u W=0.55u AS=0.14875p AD=0.187p PS=1.16u PD=1.78u rfmode=0
M$1422
+ BOTTOM|TOP|VGND|VSS|anode|cathode|core|h_sw[0]|h_sw[10]|h_sw[1]|h_sw[2]|h_sw[3]|h_sw[4]|h_sw[5]|h_sw[6]|h_sw[7]|h_sw[8]|h_sw[9]|l_sw[0]|l_sw[10]|l_sw[1]|l_sw[2]|l_sw[3]|l_sw[4]|l_sw[5]|l_sw[6]|l_sw[7]|l_sw[8]|l_sw[9]|out|pad|padres|vc|vcp|vdd|vddr|vip|vss|z
+ \$75648 X|in_h_sw[4]|ph_sw[4]|x
+ BOTTOM|TOP|VGND|VSS|anode|cathode|core|h_sw[0]|h_sw[10]|h_sw[1]|h_sw[2]|h_sw[3]|h_sw[4]|h_sw[5]|h_sw[6]|h_sw[7]|h_sw[8]|h_sw[9]|l_sw[0]|l_sw[10]|l_sw[1]|l_sw[2]|l_sw[3]|l_sw[4]|l_sw[5]|l_sw[6]|l_sw[7]|l_sw[8]|l_sw[9]|out|pad|padres|vc|vcp|vdd|vddr|vip|vss|z
+ sg13_lv_nmos L=0.13u W=0.74u AS=0.14875p AD=0.2886p PS=1.16u PD=2.26u rfmode=0
M$1423 A|X$70 \$75649
+ BOTTOM|TOP|VGND|VSS|anode|cathode|core|h_sw[0]|h_sw[10]|h_sw[1]|h_sw[2]|h_sw[3]|h_sw[4]|h_sw[5]|h_sw[6]|h_sw[7]|h_sw[8]|h_sw[9]|l_sw[0]|l_sw[10]|l_sw[1]|l_sw[2]|l_sw[3]|l_sw[4]|l_sw[5]|l_sw[6]|l_sw[7]|l_sw[8]|l_sw[9]|out|pad|padres|vc|vcp|vdd|vddr|vip|vss|z
+ BOTTOM|TOP|VGND|VSS|anode|cathode|core|h_sw[0]|h_sw[10]|h_sw[1]|h_sw[2]|h_sw[3]|h_sw[4]|h_sw[5]|h_sw[6]|h_sw[7]|h_sw[8]|h_sw[9]|l_sw[0]|l_sw[10]|l_sw[1]|l_sw[2]|l_sw[3]|l_sw[4]|l_sw[5]|l_sw[6]|l_sw[7]|l_sw[8]|l_sw[9]|out|pad|padres|vc|vcp|vdd|vddr|vip|vss|z
+ sg13_lv_nmos L=0.13u W=0.74u AS=0.2886p AD=0.14875p PS=2.26u PD=1.16u rfmode=0
M$1424
+ BOTTOM|TOP|VGND|VSS|anode|cathode|core|h_sw[0]|h_sw[10]|h_sw[1]|h_sw[2]|h_sw[3]|h_sw[4]|h_sw[5]|h_sw[6]|h_sw[7]|h_sw[8]|h_sw[9]|l_sw[0]|l_sw[10]|l_sw[1]|l_sw[2]|l_sw[3]|l_sw[4]|l_sw[5]|l_sw[6]|l_sw[7]|l_sw[8]|l_sw[9]|out|pad|padres|vc|vcp|vdd|vddr|vip|vss|z
+ A|X$29 \$75649
+ BOTTOM|TOP|VGND|VSS|anode|cathode|core|h_sw[0]|h_sw[10]|h_sw[1]|h_sw[2]|h_sw[3]|h_sw[4]|h_sw[5]|h_sw[6]|h_sw[7]|h_sw[8]|h_sw[9]|l_sw[0]|l_sw[10]|l_sw[1]|l_sw[2]|l_sw[3]|l_sw[4]|l_sw[5]|l_sw[6]|l_sw[7]|l_sw[8]|l_sw[9]|out|pad|padres|vc|vcp|vdd|vddr|vip|vss|z
+ sg13_lv_nmos L=0.13u W=0.55u AS=0.14875p AD=0.187p PS=1.16u PD=1.78u rfmode=0
M$1425
+ BOTTOM|TOP|VGND|VSS|anode|cathode|core|h_sw[0]|h_sw[10]|h_sw[1]|h_sw[2]|h_sw[3]|h_sw[4]|h_sw[5]|h_sw[6]|h_sw[7]|h_sw[8]|h_sw[9]|l_sw[0]|l_sw[10]|l_sw[1]|l_sw[2]|l_sw[3]|l_sw[4]|l_sw[5]|l_sw[6]|l_sw[7]|l_sw[8]|l_sw[9]|out|pad|padres|vc|vcp|vdd|vddr|vip|vss|z
+ A|X$72 \$75650
+ BOTTOM|TOP|VGND|VSS|anode|cathode|core|h_sw[0]|h_sw[10]|h_sw[1]|h_sw[2]|h_sw[3]|h_sw[4]|h_sw[5]|h_sw[6]|h_sw[7]|h_sw[8]|h_sw[9]|l_sw[0]|l_sw[10]|l_sw[1]|l_sw[2]|l_sw[3]|l_sw[4]|l_sw[5]|l_sw[6]|l_sw[7]|l_sw[8]|l_sw[9]|out|pad|padres|vc|vcp|vdd|vddr|vip|vss|z
+ sg13_lv_nmos L=0.13u W=0.55u AS=0.14875p AD=0.187p PS=1.16u PD=1.78u rfmode=0
M$1426
+ BOTTOM|TOP|VGND|VSS|anode|cathode|core|h_sw[0]|h_sw[10]|h_sw[1]|h_sw[2]|h_sw[3]|h_sw[4]|h_sw[5]|h_sw[6]|h_sw[7]|h_sw[8]|h_sw[9]|l_sw[0]|l_sw[10]|l_sw[1]|l_sw[2]|l_sw[3]|l_sw[4]|l_sw[5]|l_sw[6]|l_sw[7]|l_sw[8]|l_sw[9]|out|pad|padres|vc|vcp|vdd|vddr|vip|vss|z
+ \$75650 X|in_l_sw[5]|pl_sw[5]|x
+ BOTTOM|TOP|VGND|VSS|anode|cathode|core|h_sw[0]|h_sw[10]|h_sw[1]|h_sw[2]|h_sw[3]|h_sw[4]|h_sw[5]|h_sw[6]|h_sw[7]|h_sw[8]|h_sw[9]|l_sw[0]|l_sw[10]|l_sw[1]|l_sw[2]|l_sw[3]|l_sw[4]|l_sw[5]|l_sw[6]|l_sw[7]|l_sw[8]|l_sw[9]|out|pad|padres|vc|vcp|vdd|vddr|vip|vss|z
+ sg13_lv_nmos L=0.13u W=0.74u AS=0.14875p AD=0.2886p PS=1.16u PD=2.26u rfmode=0
M$1427 A|X$60 \$75651
+ BOTTOM|TOP|VGND|VSS|anode|cathode|core|h_sw[0]|h_sw[10]|h_sw[1]|h_sw[2]|h_sw[3]|h_sw[4]|h_sw[5]|h_sw[6]|h_sw[7]|h_sw[8]|h_sw[9]|l_sw[0]|l_sw[10]|l_sw[1]|l_sw[2]|l_sw[3]|l_sw[4]|l_sw[5]|l_sw[6]|l_sw[7]|l_sw[8]|l_sw[9]|out|pad|padres|vc|vcp|vdd|vddr|vip|vss|z
+ BOTTOM|TOP|VGND|VSS|anode|cathode|core|h_sw[0]|h_sw[10]|h_sw[1]|h_sw[2]|h_sw[3]|h_sw[4]|h_sw[5]|h_sw[6]|h_sw[7]|h_sw[8]|h_sw[9]|l_sw[0]|l_sw[10]|l_sw[1]|l_sw[2]|l_sw[3]|l_sw[4]|l_sw[5]|l_sw[6]|l_sw[7]|l_sw[8]|l_sw[9]|out|pad|padres|vc|vcp|vdd|vddr|vip|vss|z
+ sg13_lv_nmos L=0.13u W=0.74u AS=0.2886p AD=0.14875p PS=2.26u PD=1.16u rfmode=0
M$1428
+ BOTTOM|TOP|VGND|VSS|anode|cathode|core|h_sw[0]|h_sw[10]|h_sw[1]|h_sw[2]|h_sw[3]|h_sw[4]|h_sw[5]|h_sw[6]|h_sw[7]|h_sw[8]|h_sw[9]|l_sw[0]|l_sw[10]|l_sw[1]|l_sw[2]|l_sw[3]|l_sw[4]|l_sw[5]|l_sw[6]|l_sw[7]|l_sw[8]|l_sw[9]|out|pad|padres|vc|vcp|vdd|vddr|vip|vss|z
+ A|Y$26 \$75651
+ BOTTOM|TOP|VGND|VSS|anode|cathode|core|h_sw[0]|h_sw[10]|h_sw[1]|h_sw[2]|h_sw[3]|h_sw[4]|h_sw[5]|h_sw[6]|h_sw[7]|h_sw[8]|h_sw[9]|l_sw[0]|l_sw[10]|l_sw[1]|l_sw[2]|l_sw[3]|l_sw[4]|l_sw[5]|l_sw[6]|l_sw[7]|l_sw[8]|l_sw[9]|out|pad|padres|vc|vcp|vdd|vddr|vip|vss|z
+ sg13_lv_nmos L=0.13u W=0.55u AS=0.14875p AD=0.187p PS=1.16u PD=1.78u rfmode=0
M$1429 A|X$71 \$75652
+ BOTTOM|TOP|VGND|VSS|anode|cathode|core|h_sw[0]|h_sw[10]|h_sw[1]|h_sw[2]|h_sw[3]|h_sw[4]|h_sw[5]|h_sw[6]|h_sw[7]|h_sw[8]|h_sw[9]|l_sw[0]|l_sw[10]|l_sw[1]|l_sw[2]|l_sw[3]|l_sw[4]|l_sw[5]|l_sw[6]|l_sw[7]|l_sw[8]|l_sw[9]|out|pad|padres|vc|vcp|vdd|vddr|vip|vss|z
+ BOTTOM|TOP|VGND|VSS|anode|cathode|core|h_sw[0]|h_sw[10]|h_sw[1]|h_sw[2]|h_sw[3]|h_sw[4]|h_sw[5]|h_sw[6]|h_sw[7]|h_sw[8]|h_sw[9]|l_sw[0]|l_sw[10]|l_sw[1]|l_sw[2]|l_sw[3]|l_sw[4]|l_sw[5]|l_sw[6]|l_sw[7]|l_sw[8]|l_sw[9]|out|pad|padres|vc|vcp|vdd|vddr|vip|vss|z
+ sg13_lv_nmos L=0.13u W=0.74u AS=0.2886p AD=0.14875p PS=2.26u PD=1.16u rfmode=0
M$1430
+ BOTTOM|TOP|VGND|VSS|anode|cathode|core|h_sw[0]|h_sw[10]|h_sw[1]|h_sw[2]|h_sw[3]|h_sw[4]|h_sw[5]|h_sw[6]|h_sw[7]|h_sw[8]|h_sw[9]|l_sw[0]|l_sw[10]|l_sw[1]|l_sw[2]|l_sw[3]|l_sw[4]|l_sw[5]|l_sw[6]|l_sw[7]|l_sw[8]|l_sw[9]|out|pad|padres|vc|vcp|vdd|vddr|vip|vss|z
+ A|X$37 \$75652
+ BOTTOM|TOP|VGND|VSS|anode|cathode|core|h_sw[0]|h_sw[10]|h_sw[1]|h_sw[2]|h_sw[3]|h_sw[4]|h_sw[5]|h_sw[6]|h_sw[7]|h_sw[8]|h_sw[9]|l_sw[0]|l_sw[10]|l_sw[1]|l_sw[2]|l_sw[3]|l_sw[4]|l_sw[5]|l_sw[6]|l_sw[7]|l_sw[8]|l_sw[9]|out|pad|padres|vc|vcp|vdd|vddr|vip|vss|z
+ sg13_lv_nmos L=0.13u W=0.55u AS=0.14875p AD=0.187p PS=1.16u PD=1.78u rfmode=0
M$1431
+ BOTTOM|TOP|VGND|VSS|anode|cathode|core|h_sw[0]|h_sw[10]|h_sw[1]|h_sw[2]|h_sw[3]|h_sw[4]|h_sw[5]|h_sw[6]|h_sw[7]|h_sw[8]|h_sw[9]|l_sw[0]|l_sw[10]|l_sw[1]|l_sw[2]|l_sw[3]|l_sw[4]|l_sw[5]|l_sw[6]|l_sw[7]|l_sw[8]|l_sw[9]|out|pad|padres|vc|vcp|vdd|vddr|vip|vss|z
+ A|X$52 \$75653
+ BOTTOM|TOP|VGND|VSS|anode|cathode|core|h_sw[0]|h_sw[10]|h_sw[1]|h_sw[2]|h_sw[3]|h_sw[4]|h_sw[5]|h_sw[6]|h_sw[7]|h_sw[8]|h_sw[9]|l_sw[0]|l_sw[10]|l_sw[1]|l_sw[2]|l_sw[3]|l_sw[4]|l_sw[5]|l_sw[6]|l_sw[7]|l_sw[8]|l_sw[9]|out|pad|padres|vc|vcp|vdd|vddr|vip|vss|z
+ sg13_lv_nmos L=0.13u W=0.55u AS=0.14875p AD=0.187p PS=1.16u PD=1.78u rfmode=0
M$1432
+ BOTTOM|TOP|VGND|VSS|anode|cathode|core|h_sw[0]|h_sw[10]|h_sw[1]|h_sw[2]|h_sw[3]|h_sw[4]|h_sw[5]|h_sw[6]|h_sw[7]|h_sw[8]|h_sw[9]|l_sw[0]|l_sw[10]|l_sw[1]|l_sw[2]|l_sw[3]|l_sw[4]|l_sw[5]|l_sw[6]|l_sw[7]|l_sw[8]|l_sw[9]|out|pad|padres|vc|vcp|vdd|vddr|vip|vss|z
+ \$75653 A|CLK|X$1
+ BOTTOM|TOP|VGND|VSS|anode|cathode|core|h_sw[0]|h_sw[10]|h_sw[1]|h_sw[2]|h_sw[3]|h_sw[4]|h_sw[5]|h_sw[6]|h_sw[7]|h_sw[8]|h_sw[9]|l_sw[0]|l_sw[10]|l_sw[1]|l_sw[2]|l_sw[3]|l_sw[4]|l_sw[5]|l_sw[6]|l_sw[7]|l_sw[8]|l_sw[9]|out|pad|padres|vc|vcp|vdd|vddr|vip|vss|z
+ sg13_lv_nmos L=0.13u W=0.74u AS=0.14875p AD=0.2886p PS=1.16u PD=2.26u rfmode=0
M$1433 A|X$72 \$75654
+ BOTTOM|TOP|VGND|VSS|anode|cathode|core|h_sw[0]|h_sw[10]|h_sw[1]|h_sw[2]|h_sw[3]|h_sw[4]|h_sw[5]|h_sw[6]|h_sw[7]|h_sw[8]|h_sw[9]|l_sw[0]|l_sw[10]|l_sw[1]|l_sw[2]|l_sw[3]|l_sw[4]|l_sw[5]|l_sw[6]|l_sw[7]|l_sw[8]|l_sw[9]|out|pad|padres|vc|vcp|vdd|vddr|vip|vss|z
+ BOTTOM|TOP|VGND|VSS|anode|cathode|core|h_sw[0]|h_sw[10]|h_sw[1]|h_sw[2]|h_sw[3]|h_sw[4]|h_sw[5]|h_sw[6]|h_sw[7]|h_sw[8]|h_sw[9]|l_sw[0]|l_sw[10]|l_sw[1]|l_sw[2]|l_sw[3]|l_sw[4]|l_sw[5]|l_sw[6]|l_sw[7]|l_sw[8]|l_sw[9]|out|pad|padres|vc|vcp|vdd|vddr|vip|vss|z
+ sg13_lv_nmos L=0.13u W=0.74u AS=0.2886p AD=0.14875p PS=2.26u PD=1.16u rfmode=0
M$1434
+ BOTTOM|TOP|VGND|VSS|anode|cathode|core|h_sw[0]|h_sw[10]|h_sw[1]|h_sw[2]|h_sw[3]|h_sw[4]|h_sw[5]|h_sw[6]|h_sw[7]|h_sw[8]|h_sw[9]|l_sw[0]|l_sw[10]|l_sw[1]|l_sw[2]|l_sw[3]|l_sw[4]|l_sw[5]|l_sw[6]|l_sw[7]|l_sw[8]|l_sw[9]|out|pad|padres|vc|vcp|vdd|vddr|vip|vss|z
+ A|Y$19 \$75654
+ BOTTOM|TOP|VGND|VSS|anode|cathode|core|h_sw[0]|h_sw[10]|h_sw[1]|h_sw[2]|h_sw[3]|h_sw[4]|h_sw[5]|h_sw[6]|h_sw[7]|h_sw[8]|h_sw[9]|l_sw[0]|l_sw[10]|l_sw[1]|l_sw[2]|l_sw[3]|l_sw[4]|l_sw[5]|l_sw[6]|l_sw[7]|l_sw[8]|l_sw[9]|out|pad|padres|vc|vcp|vdd|vddr|vip|vss|z
+ sg13_lv_nmos L=0.13u W=0.55u AS=0.14875p AD=0.187p PS=1.16u PD=1.78u rfmode=0
M$1435
+ BOTTOM|TOP|VGND|VSS|anode|cathode|core|h_sw[0]|h_sw[10]|h_sw[1]|h_sw[2]|h_sw[3]|h_sw[4]|h_sw[5]|h_sw[6]|h_sw[7]|h_sw[8]|h_sw[9]|l_sw[0]|l_sw[10]|l_sw[1]|l_sw[2]|l_sw[3]|l_sw[4]|l_sw[5]|l_sw[6]|l_sw[7]|l_sw[8]|l_sw[9]|out|pad|padres|vc|vcp|vdd|vddr|vip|vss|z
+ A|X$35 \$75655
+ BOTTOM|TOP|VGND|VSS|anode|cathode|core|h_sw[0]|h_sw[10]|h_sw[1]|h_sw[2]|h_sw[3]|h_sw[4]|h_sw[5]|h_sw[6]|h_sw[7]|h_sw[8]|h_sw[9]|l_sw[0]|l_sw[10]|l_sw[1]|l_sw[2]|l_sw[3]|l_sw[4]|l_sw[5]|l_sw[6]|l_sw[7]|l_sw[8]|l_sw[9]|out|pad|padres|vc|vcp|vdd|vddr|vip|vss|z
+ sg13_lv_nmos L=0.13u W=0.55u AS=0.14875p AD=0.187p PS=1.16u PD=1.78u rfmode=0
M$1436
+ BOTTOM|TOP|VGND|VSS|anode|cathode|core|h_sw[0]|h_sw[10]|h_sw[1]|h_sw[2]|h_sw[3]|h_sw[4]|h_sw[5]|h_sw[6]|h_sw[7]|h_sw[8]|h_sw[9]|l_sw[0]|l_sw[10]|l_sw[1]|l_sw[2]|l_sw[3]|l_sw[4]|l_sw[5]|l_sw[6]|l_sw[7]|l_sw[8]|l_sw[9]|out|pad|padres|vc|vcp|vdd|vddr|vip|vss|z
+ \$75655 A|X$57
+ BOTTOM|TOP|VGND|VSS|anode|cathode|core|h_sw[0]|h_sw[10]|h_sw[1]|h_sw[2]|h_sw[3]|h_sw[4]|h_sw[5]|h_sw[6]|h_sw[7]|h_sw[8]|h_sw[9]|l_sw[0]|l_sw[10]|l_sw[1]|l_sw[2]|l_sw[3]|l_sw[4]|l_sw[5]|l_sw[6]|l_sw[7]|l_sw[8]|l_sw[9]|out|pad|padres|vc|vcp|vdd|vddr|vip|vss|z
+ sg13_lv_nmos L=0.13u W=0.74u AS=0.14875p AD=0.2886p PS=1.16u PD=2.26u rfmode=0
M$1437
+ BOTTOM|TOP|VGND|VSS|anode|cathode|core|h_sw[0]|h_sw[10]|h_sw[1]|h_sw[2]|h_sw[3]|h_sw[4]|h_sw[5]|h_sw[6]|h_sw[7]|h_sw[8]|h_sw[9]|l_sw[0]|l_sw[10]|l_sw[1]|l_sw[2]|l_sw[3]|l_sw[4]|l_sw[5]|l_sw[6]|l_sw[7]|l_sw[8]|l_sw[9]|out|pad|padres|vc|vcp|vdd|vddr|vip|vss|z
+ D|Q_N$9 \$75656
+ BOTTOM|TOP|VGND|VSS|anode|cathode|core|h_sw[0]|h_sw[10]|h_sw[1]|h_sw[2]|h_sw[3]|h_sw[4]|h_sw[5]|h_sw[6]|h_sw[7]|h_sw[8]|h_sw[9]|l_sw[0]|l_sw[10]|l_sw[1]|l_sw[2]|l_sw[3]|l_sw[4]|l_sw[5]|l_sw[6]|l_sw[7]|l_sw[8]|l_sw[9]|out|pad|padres|vc|vcp|vdd|vddr|vip|vss|z
+ sg13_lv_nmos L=0.13u W=0.55u AS=0.15055p AD=0.187p PS=1.17u PD=1.78u rfmode=0
M$1438
+ BOTTOM|TOP|VGND|VSS|anode|cathode|core|h_sw[0]|h_sw[10]|h_sw[1]|h_sw[2]|h_sw[3]|h_sw[4]|h_sw[5]|h_sw[6]|h_sw[7]|h_sw[8]|h_sw[9]|l_sw[0]|l_sw[10]|l_sw[1]|l_sw[2]|l_sw[3]|l_sw[4]|l_sw[5]|l_sw[6]|l_sw[7]|l_sw[8]|l_sw[9]|out|pad|padres|vc|vcp|vdd|vddr|vip|vss|z
+ CLK|D|GATE|Q$9 \$75611
+ BOTTOM|TOP|VGND|VSS|anode|cathode|core|h_sw[0]|h_sw[10]|h_sw[1]|h_sw[2]|h_sw[3]|h_sw[4]|h_sw[5]|h_sw[6]|h_sw[7]|h_sw[8]|h_sw[9]|l_sw[0]|l_sw[10]|l_sw[1]|l_sw[2]|l_sw[3]|l_sw[4]|l_sw[5]|l_sw[6]|l_sw[7]|l_sw[8]|l_sw[9]|out|pad|padres|vc|vcp|vdd|vddr|vip|vss|z
+ sg13_lv_nmos L=0.13u W=0.74u AS=0.15055p AD=0.2516p PS=1.17u PD=2.16u rfmode=0
M$1439
+ BOTTOM|TOP|VGND|VSS|anode|cathode|core|h_sw[0]|h_sw[10]|h_sw[1]|h_sw[2]|h_sw[3]|h_sw[4]|h_sw[5]|h_sw[6]|h_sw[7]|h_sw[8]|h_sw[9]|l_sw[0]|l_sw[10]|l_sw[1]|l_sw[2]|l_sw[3]|l_sw[4]|l_sw[5]|l_sw[6]|l_sw[7]|l_sw[8]|l_sw[9]|out|pad|padres|vc|vcp|vdd|vddr|vip|vss|z
+ \$75656 \$75731
+ BOTTOM|TOP|VGND|VSS|anode|cathode|core|h_sw[0]|h_sw[10]|h_sw[1]|h_sw[2]|h_sw[3]|h_sw[4]|h_sw[5]|h_sw[6]|h_sw[7]|h_sw[8]|h_sw[9]|l_sw[0]|l_sw[10]|l_sw[1]|l_sw[2]|l_sw[3]|l_sw[4]|l_sw[5]|l_sw[6]|l_sw[7]|l_sw[8]|l_sw[9]|out|pad|padres|vc|vcp|vdd|vddr|vip|vss|z
+ sg13_lv_nmos L=0.13u W=0.64u AS=0.213425p AD=0.072p PS=1.62u PD=0.865u
+ rfmode=0
M$1440 \$75731 \$75657 \$75612
+ BOTTOM|TOP|VGND|VSS|anode|cathode|core|h_sw[0]|h_sw[10]|h_sw[1]|h_sw[2]|h_sw[3]|h_sw[4]|h_sw[5]|h_sw[6]|h_sw[7]|h_sw[8]|h_sw[9]|l_sw[0]|l_sw[10]|l_sw[1]|l_sw[2]|l_sw[3]|l_sw[4]|l_sw[5]|l_sw[6]|l_sw[7]|l_sw[8]|l_sw[9]|out|pad|padres|vc|vcp|vdd|vddr|vip|vss|z
+ sg13_lv_nmos L=0.13u W=0.64u AS=0.072p AD=0.141p PS=0.865u PD=1.17u rfmode=0
M$1441 \$75612 \$75611 \$75730
+ BOTTOM|TOP|VGND|VSS|anode|cathode|core|h_sw[0]|h_sw[10]|h_sw[1]|h_sw[2]|h_sw[3]|h_sw[4]|h_sw[5]|h_sw[6]|h_sw[7]|h_sw[8]|h_sw[9]|l_sw[0]|l_sw[10]|l_sw[1]|l_sw[2]|l_sw[3]|l_sw[4]|l_sw[5]|l_sw[6]|l_sw[7]|l_sw[8]|l_sw[9]|out|pad|padres|vc|vcp|vdd|vddr|vip|vss|z
+ sg13_lv_nmos L=0.13u W=0.42u AS=0.141p AD=0.04725p PS=1.17u PD=0.645u rfmode=0
M$1442 \$75730 \$75613
+ BOTTOM|TOP|VGND|VSS|anode|cathode|core|h_sw[0]|h_sw[10]|h_sw[1]|h_sw[2]|h_sw[3]|h_sw[4]|h_sw[5]|h_sw[6]|h_sw[7]|h_sw[8]|h_sw[9]|l_sw[0]|l_sw[10]|l_sw[1]|l_sw[2]|l_sw[3]|l_sw[4]|l_sw[5]|l_sw[6]|l_sw[7]|l_sw[8]|l_sw[9]|out|pad|padres|vc|vcp|vdd|vddr|vip|vss|z
+ BOTTOM|TOP|VGND|VSS|anode|cathode|core|h_sw[0]|h_sw[10]|h_sw[1]|h_sw[2]|h_sw[3]|h_sw[4]|h_sw[5]|h_sw[6]|h_sw[7]|h_sw[8]|h_sw[9]|l_sw[0]|l_sw[10]|l_sw[1]|l_sw[2]|l_sw[3]|l_sw[4]|l_sw[5]|l_sw[6]|l_sw[7]|l_sw[8]|l_sw[9]|out|pad|padres|vc|vcp|vdd|vddr|vip|vss|z
+ sg13_lv_nmos L=0.13u W=0.42u AS=0.04725p AD=0.1428p PS=0.645u PD=1.52u
+ rfmode=0
M$1443
+ BOTTOM|TOP|VGND|VSS|anode|cathode|core|h_sw[0]|h_sw[10]|h_sw[1]|h_sw[2]|h_sw[3]|h_sw[4]|h_sw[5]|h_sw[6]|h_sw[7]|h_sw[8]|h_sw[9]|l_sw[0]|l_sw[10]|l_sw[1]|l_sw[2]|l_sw[3]|l_sw[4]|l_sw[5]|l_sw[6]|l_sw[7]|l_sw[8]|l_sw[9]|out|pad|padres|vc|vcp|vdd|vddr|vip|vss|z
+ \$75611 \$75657
+ BOTTOM|TOP|VGND|VSS|anode|cathode|core|h_sw[0]|h_sw[10]|h_sw[1]|h_sw[2]|h_sw[3]|h_sw[4]|h_sw[5]|h_sw[6]|h_sw[7]|h_sw[8]|h_sw[9]|l_sw[0]|l_sw[10]|l_sw[1]|l_sw[2]|l_sw[3]|l_sw[4]|l_sw[5]|l_sw[6]|l_sw[7]|l_sw[8]|l_sw[9]|out|pad|padres|vc|vcp|vdd|vddr|vip|vss|z
+ sg13_lv_nmos L=0.13u W=0.74u AS=0.213425p AD=0.2775p PS=1.62u PD=2.23u
+ rfmode=0
M$1444 \$75613 \$75612 \$75729
+ BOTTOM|TOP|VGND|VSS|anode|cathode|core|h_sw[0]|h_sw[10]|h_sw[1]|h_sw[2]|h_sw[3]|h_sw[4]|h_sw[5]|h_sw[6]|h_sw[7]|h_sw[8]|h_sw[9]|l_sw[0]|l_sw[10]|l_sw[1]|l_sw[2]|l_sw[3]|l_sw[4]|l_sw[5]|l_sw[6]|l_sw[7]|l_sw[8]|l_sw[9]|out|pad|padres|vc|vcp|vdd|vddr|vip|vss|z
+ sg13_lv_nmos L=0.13u W=0.74u AS=0.2516p AD=0.0777p PS=2.16u PD=0.95u rfmode=0
M$1445 \$75729 RESET_B|Y$1
+ BOTTOM|TOP|VGND|VSS|anode|cathode|core|h_sw[0]|h_sw[10]|h_sw[1]|h_sw[2]|h_sw[3]|h_sw[4]|h_sw[5]|h_sw[6]|h_sw[7]|h_sw[8]|h_sw[9]|l_sw[0]|l_sw[10]|l_sw[1]|l_sw[2]|l_sw[3]|l_sw[4]|l_sw[5]|l_sw[6]|l_sw[7]|l_sw[8]|l_sw[9]|out|pad|padres|vc|vcp|vdd|vddr|vip|vss|z
+ BOTTOM|TOP|VGND|VSS|anode|cathode|core|h_sw[0]|h_sw[10]|h_sw[1]|h_sw[2]|h_sw[3]|h_sw[4]|h_sw[5]|h_sw[6]|h_sw[7]|h_sw[8]|h_sw[9]|l_sw[0]|l_sw[10]|l_sw[1]|l_sw[2]|l_sw[3]|l_sw[4]|l_sw[5]|l_sw[6]|l_sw[7]|l_sw[8]|l_sw[9]|out|pad|padres|vc|vcp|vdd|vddr|vip|vss|z
+ sg13_lv_nmos L=0.13u W=0.74u AS=0.0777p AD=0.1406p PS=0.95u PD=1.12u rfmode=0
M$1446
+ BOTTOM|TOP|VGND|VSS|anode|cathode|core|h_sw[0]|h_sw[10]|h_sw[1]|h_sw[2]|h_sw[3]|h_sw[4]|h_sw[5]|h_sw[6]|h_sw[7]|h_sw[8]|h_sw[9]|l_sw[0]|l_sw[10]|l_sw[1]|l_sw[2]|l_sw[3]|l_sw[4]|l_sw[5]|l_sw[6]|l_sw[7]|l_sw[8]|l_sw[9]|out|pad|padres|vc|vcp|vdd|vddr|vip|vss|z
+ \$75613 A|Q$24
+ BOTTOM|TOP|VGND|VSS|anode|cathode|core|h_sw[0]|h_sw[10]|h_sw[1]|h_sw[2]|h_sw[3]|h_sw[4]|h_sw[5]|h_sw[6]|h_sw[7]|h_sw[8]|h_sw[9]|l_sw[0]|l_sw[10]|l_sw[1]|l_sw[2]|l_sw[3]|l_sw[4]|l_sw[5]|l_sw[6]|l_sw[7]|l_sw[8]|l_sw[9]|out|pad|padres|vc|vcp|vdd|vddr|vip|vss|z
+ sg13_lv_nmos L=0.13u W=0.74u AS=0.1406p AD=0.2516p PS=1.12u PD=2.16u rfmode=0
M$1447
+ BOTTOM|TOP|VGND|VSS|anode|cathode|core|h_sw[0]|h_sw[10]|h_sw[1]|h_sw[2]|h_sw[3]|h_sw[4]|h_sw[5]|h_sw[6]|h_sw[7]|h_sw[8]|h_sw[9]|l_sw[0]|l_sw[10]|l_sw[1]|l_sw[2]|l_sw[3]|l_sw[4]|l_sw[5]|l_sw[6]|l_sw[7]|l_sw[8]|l_sw[9]|out|pad|padres|vc|vcp|vdd|vddr|vip|vss|z
+ \$75613 \$75614
+ BOTTOM|TOP|VGND|VSS|anode|cathode|core|h_sw[0]|h_sw[10]|h_sw[1]|h_sw[2]|h_sw[3]|h_sw[4]|h_sw[5]|h_sw[6]|h_sw[7]|h_sw[8]|h_sw[9]|l_sw[0]|l_sw[10]|l_sw[1]|l_sw[2]|l_sw[3]|l_sw[4]|l_sw[5]|l_sw[6]|l_sw[7]|l_sw[8]|l_sw[9]|out|pad|padres|vc|vcp|vdd|vddr|vip|vss|z
+ sg13_lv_nmos L=0.13u W=0.55u AS=0.1491p AD=0.187p PS=1.18u PD=1.78u rfmode=0
M$1448
+ BOTTOM|TOP|VGND|VSS|anode|cathode|core|h_sw[0]|h_sw[10]|h_sw[1]|h_sw[2]|h_sw[3]|h_sw[4]|h_sw[5]|h_sw[6]|h_sw[7]|h_sw[8]|h_sw[9]|l_sw[0]|l_sw[10]|l_sw[1]|l_sw[2]|l_sw[3]|l_sw[4]|l_sw[5]|l_sw[6]|l_sw[7]|l_sw[8]|l_sw[9]|out|pad|padres|vc|vcp|vdd|vddr|vip|vss|z
+ \$75614 Q_N$40
+ BOTTOM|TOP|VGND|VSS|anode|cathode|core|h_sw[0]|h_sw[10]|h_sw[1]|h_sw[2]|h_sw[3]|h_sw[4]|h_sw[5]|h_sw[6]|h_sw[7]|h_sw[8]|h_sw[9]|l_sw[0]|l_sw[10]|l_sw[1]|l_sw[2]|l_sw[3]|l_sw[4]|l_sw[5]|l_sw[6]|l_sw[7]|l_sw[8]|l_sw[9]|out|pad|padres|vc|vcp|vdd|vddr|vip|vss|z
+ sg13_lv_nmos L=0.13u W=0.74u AS=0.1491p AD=0.2516p PS=1.18u PD=2.16u rfmode=0
M$1449
+ BOTTOM|TOP|VGND|VSS|anode|cathode|core|h_sw[0]|h_sw[10]|h_sw[1]|h_sw[2]|h_sw[3]|h_sw[4]|h_sw[5]|h_sw[6]|h_sw[7]|h_sw[8]|h_sw[9]|l_sw[0]|l_sw[10]|l_sw[1]|l_sw[2]|l_sw[3]|l_sw[4]|l_sw[5]|l_sw[6]|l_sw[7]|l_sw[8]|l_sw[9]|out|pad|padres|vc|vcp|vdd|vddr|vip|vss|z
+ A|Y$22 \$75658
+ BOTTOM|TOP|VGND|VSS|anode|cathode|core|h_sw[0]|h_sw[10]|h_sw[1]|h_sw[2]|h_sw[3]|h_sw[4]|h_sw[5]|h_sw[6]|h_sw[7]|h_sw[8]|h_sw[9]|l_sw[0]|l_sw[10]|l_sw[1]|l_sw[2]|l_sw[3]|l_sw[4]|l_sw[5]|l_sw[6]|l_sw[7]|l_sw[8]|l_sw[9]|out|pad|padres|vc|vcp|vdd|vddr|vip|vss|z
+ sg13_lv_nmos L=0.13u W=0.55u AS=0.14875p AD=0.187p PS=1.16u PD=1.78u rfmode=0
M$1450
+ BOTTOM|TOP|VGND|VSS|anode|cathode|core|h_sw[0]|h_sw[10]|h_sw[1]|h_sw[2]|h_sw[3]|h_sw[4]|h_sw[5]|h_sw[6]|h_sw[7]|h_sw[8]|h_sw[9]|l_sw[0]|l_sw[10]|l_sw[1]|l_sw[2]|l_sw[3]|l_sw[4]|l_sw[5]|l_sw[6]|l_sw[7]|l_sw[8]|l_sw[9]|out|pad|padres|vc|vcp|vdd|vddr|vip|vss|z
+ \$75658 A|X$61
+ BOTTOM|TOP|VGND|VSS|anode|cathode|core|h_sw[0]|h_sw[10]|h_sw[1]|h_sw[2]|h_sw[3]|h_sw[4]|h_sw[5]|h_sw[6]|h_sw[7]|h_sw[8]|h_sw[9]|l_sw[0]|l_sw[10]|l_sw[1]|l_sw[2]|l_sw[3]|l_sw[4]|l_sw[5]|l_sw[6]|l_sw[7]|l_sw[8]|l_sw[9]|out|pad|padres|vc|vcp|vdd|vddr|vip|vss|z
+ sg13_lv_nmos L=0.13u W=0.74u AS=0.14875p AD=0.2886p PS=1.16u PD=2.26u rfmode=0
M$1451 \$75659 CLK|D|GATE|Q$10 \$75733
+ BOTTOM|TOP|VGND|VSS|anode|cathode|core|h_sw[0]|h_sw[10]|h_sw[1]|h_sw[2]|h_sw[3]|h_sw[4]|h_sw[5]|h_sw[6]|h_sw[7]|h_sw[8]|h_sw[9]|l_sw[0]|l_sw[10]|l_sw[1]|l_sw[2]|l_sw[3]|l_sw[4]|l_sw[5]|l_sw[6]|l_sw[7]|l_sw[8]|l_sw[9]|out|pad|padres|vc|vcp|vdd|vddr|vip|vss|z
+ sg13_lv_nmos L=0.13u W=0.42u AS=0.1428p AD=0.0609p PS=1.52u PD=0.71u rfmode=0
M$1452 \$75733 RESET_B|Y$2
+ BOTTOM|TOP|VGND|VSS|anode|cathode|core|h_sw[0]|h_sw[10]|h_sw[1]|h_sw[2]|h_sw[3]|h_sw[4]|h_sw[5]|h_sw[6]|h_sw[7]|h_sw[8]|h_sw[9]|l_sw[0]|l_sw[10]|l_sw[1]|l_sw[2]|l_sw[3]|l_sw[4]|l_sw[5]|l_sw[6]|l_sw[7]|l_sw[8]|l_sw[9]|out|pad|padres|vc|vcp|vdd|vddr|vip|vss|z
+ BOTTOM|TOP|VGND|VSS|anode|cathode|core|h_sw[0]|h_sw[10]|h_sw[1]|h_sw[2]|h_sw[3]|h_sw[4]|h_sw[5]|h_sw[6]|h_sw[7]|h_sw[8]|h_sw[9]|l_sw[0]|l_sw[10]|l_sw[1]|l_sw[2]|l_sw[3]|l_sw[4]|l_sw[5]|l_sw[6]|l_sw[7]|l_sw[8]|l_sw[9]|out|pad|padres|vc|vcp|vdd|vddr|vip|vss|z
+ sg13_lv_nmos L=0.13u W=0.42u AS=0.0609p AD=0.1626p PS=0.71u PD=1.415u rfmode=0
M$1453
+ BOTTOM|TOP|VGND|VSS|anode|cathode|core|h_sw[0]|h_sw[10]|h_sw[1]|h_sw[2]|h_sw[3]|h_sw[4]|h_sw[5]|h_sw[6]|h_sw[7]|h_sw[8]|h_sw[9]|l_sw[0]|l_sw[10]|l_sw[1]|l_sw[2]|l_sw[3]|l_sw[4]|l_sw[5]|l_sw[6]|l_sw[7]|l_sw[8]|l_sw[9]|out|pad|padres|vc|vcp|vdd|vddr|vip|vss|z
+ \$75743 \$75618
+ BOTTOM|TOP|VGND|VSS|anode|cathode|core|h_sw[0]|h_sw[10]|h_sw[1]|h_sw[2]|h_sw[3]|h_sw[4]|h_sw[5]|h_sw[6]|h_sw[7]|h_sw[8]|h_sw[9]|l_sw[0]|l_sw[10]|l_sw[1]|l_sw[2]|l_sw[3]|l_sw[4]|l_sw[5]|l_sw[6]|l_sw[7]|l_sw[8]|l_sw[9]|out|pad|padres|vc|vcp|vdd|vddr|vip|vss|z
+ sg13_lv_nmos L=0.13u W=0.74u AS=0.1626p AD=0.2516p PS=1.415u PD=2.16u rfmode=0
M$1454
+ BOTTOM|TOP|VGND|VSS|anode|cathode|core|h_sw[0]|h_sw[10]|h_sw[1]|h_sw[2]|h_sw[3]|h_sw[4]|h_sw[5]|h_sw[6]|h_sw[7]|h_sw[8]|h_sw[9]|l_sw[0]|l_sw[10]|l_sw[1]|l_sw[2]|l_sw[3]|l_sw[4]|l_sw[5]|l_sw[6]|l_sw[7]|l_sw[8]|l_sw[9]|out|pad|padres|vc|vcp|vdd|vddr|vip|vss|z
+ RESET_B|Y$2 \$75732
+ BOTTOM|TOP|VGND|VSS|anode|cathode|core|h_sw[0]|h_sw[10]|h_sw[1]|h_sw[2]|h_sw[3]|h_sw[4]|h_sw[5]|h_sw[6]|h_sw[7]|h_sw[8]|h_sw[9]|l_sw[0]|l_sw[10]|l_sw[1]|l_sw[2]|l_sw[3]|l_sw[4]|l_sw[5]|l_sw[6]|l_sw[7]|l_sw[8]|l_sw[9]|out|pad|padres|vc|vcp|vdd|vddr|vip|vss|z
+ sg13_lv_nmos L=0.13u W=0.42u AS=0.1701p AD=0.0378p PS=1.65u PD=0.6u rfmode=0
M$1455 \$75732 \$75618 \$75617
+ BOTTOM|TOP|VGND|VSS|anode|cathode|core|h_sw[0]|h_sw[10]|h_sw[1]|h_sw[2]|h_sw[3]|h_sw[4]|h_sw[5]|h_sw[6]|h_sw[7]|h_sw[8]|h_sw[9]|l_sw[0]|l_sw[10]|l_sw[1]|l_sw[2]|l_sw[3]|l_sw[4]|l_sw[5]|l_sw[6]|l_sw[7]|l_sw[8]|l_sw[9]|out|pad|padres|vc|vcp|vdd|vddr|vip|vss|z
+ sg13_lv_nmos L=0.13u W=0.42u AS=0.0378p AD=0.1428p PS=0.6u PD=1.52u rfmode=0
M$1456 \$75659 \$75619 \$75743
+ BOTTOM|TOP|VGND|VSS|anode|cathode|core|h_sw[0]|h_sw[10]|h_sw[1]|h_sw[2]|h_sw[3]|h_sw[4]|h_sw[5]|h_sw[6]|h_sw[7]|h_sw[8]|h_sw[9]|l_sw[0]|l_sw[10]|l_sw[1]|l_sw[2]|l_sw[3]|l_sw[4]|l_sw[5]|l_sw[6]|l_sw[7]|l_sw[8]|l_sw[9]|out|pad|padres|vc|vcp|vdd|vddr|vip|vss|z
+ sg13_lv_nmos L=0.13u W=0.42u AS=0.1296p AD=0.0798p PS=1.52u PD=0.8u rfmode=0
M$1457 \$75743 \$75660 \$75617
+ BOTTOM|TOP|VGND|VSS|anode|cathode|core|h_sw[0]|h_sw[10]|h_sw[1]|h_sw[2]|h_sw[3]|h_sw[4]|h_sw[5]|h_sw[6]|h_sw[7]|h_sw[8]|h_sw[9]|l_sw[0]|l_sw[10]|l_sw[1]|l_sw[2]|l_sw[3]|l_sw[4]|l_sw[5]|l_sw[6]|l_sw[7]|l_sw[8]|l_sw[9]|out|pad|padres|vc|vcp|vdd|vddr|vip|vss|z
+ sg13_lv_nmos L=0.13u W=0.42u AS=0.0798p AD=0.2373p PS=0.8u PD=1.97u rfmode=0
M$1458
+ BOTTOM|TOP|VGND|VSS|anode|cathode|core|h_sw[0]|h_sw[10]|h_sw[1]|h_sw[2]|h_sw[3]|h_sw[4]|h_sw[5]|h_sw[6]|h_sw[7]|h_sw[8]|h_sw[9]|l_sw[0]|l_sw[10]|l_sw[1]|l_sw[2]|l_sw[3]|l_sw[4]|l_sw[5]|l_sw[6]|l_sw[7]|l_sw[8]|l_sw[9]|out|pad|padres|vc|vcp|vdd|vddr|vip|vss|z
+ \$75619 \$75660
+ BOTTOM|TOP|VGND|VSS|anode|cathode|core|h_sw[0]|h_sw[10]|h_sw[1]|h_sw[2]|h_sw[3]|h_sw[4]|h_sw[5]|h_sw[6]|h_sw[7]|h_sw[8]|h_sw[9]|l_sw[0]|l_sw[10]|l_sw[1]|l_sw[2]|l_sw[3]|l_sw[4]|l_sw[5]|l_sw[6]|l_sw[7]|l_sw[8]|l_sw[9]|out|pad|padres|vc|vcp|vdd|vddr|vip|vss|z
+ sg13_lv_nmos L=0.13u W=0.74u AS=0.317325p AD=0.2516p PS=1.805u PD=2.16u
+ rfmode=0
M$1459
+ BOTTOM|TOP|VGND|VSS|anode|cathode|core|h_sw[0]|h_sw[10]|h_sw[1]|h_sw[2]|h_sw[3]|h_sw[4]|h_sw[5]|h_sw[6]|h_sw[7]|h_sw[8]|h_sw[9]|l_sw[0]|l_sw[10]|l_sw[1]|l_sw[2]|l_sw[3]|l_sw[4]|l_sw[5]|l_sw[6]|l_sw[7]|l_sw[8]|l_sw[9]|out|pad|padres|vc|vcp|vdd|vddr|vip|vss|z
+ A|CLK|X$1 \$75619
+ BOTTOM|TOP|VGND|VSS|anode|cathode|core|h_sw[0]|h_sw[10]|h_sw[1]|h_sw[2]|h_sw[3]|h_sw[4]|h_sw[5]|h_sw[6]|h_sw[7]|h_sw[8]|h_sw[9]|l_sw[0]|l_sw[10]|l_sw[1]|l_sw[2]|l_sw[3]|l_sw[4]|l_sw[5]|l_sw[6]|l_sw[7]|l_sw[8]|l_sw[9]|out|pad|padres|vc|vcp|vdd|vddr|vip|vss|z
+ sg13_lv_nmos L=0.13u W=0.74u AS=0.317325p AD=0.2516p PS=1.805u PD=2.16u
+ rfmode=0
M$1460 \$75661 \$75619 \$75620
+ BOTTOM|TOP|VGND|VSS|anode|cathode|core|h_sw[0]|h_sw[10]|h_sw[1]|h_sw[2]|h_sw[3]|h_sw[4]|h_sw[5]|h_sw[6]|h_sw[7]|h_sw[8]|h_sw[9]|l_sw[0]|l_sw[10]|l_sw[1]|l_sw[2]|l_sw[3]|l_sw[4]|l_sw[5]|l_sw[6]|l_sw[7]|l_sw[8]|l_sw[9]|out|pad|padres|vc|vcp|vdd|vddr|vip|vss|z
+ sg13_lv_nmos L=0.13u W=0.42u AS=0.12665p AD=0.1428p PS=1.145u PD=1.52u
+ rfmode=0
M$1461 \$75618 \$75660 \$75661
+ BOTTOM|TOP|VGND|VSS|anode|cathode|core|h_sw[0]|h_sw[10]|h_sw[1]|h_sw[2]|h_sw[3]|h_sw[4]|h_sw[5]|h_sw[6]|h_sw[7]|h_sw[8]|h_sw[9]|l_sw[0]|l_sw[10]|l_sw[1]|l_sw[2]|l_sw[3]|l_sw[4]|l_sw[5]|l_sw[6]|l_sw[7]|l_sw[8]|l_sw[9]|out|pad|padres|vc|vcp|vdd|vddr|vip|vss|z
+ sg13_lv_nmos L=0.13u W=0.74u AS=0.3473p AD=0.12665p PS=2.71u PD=1.145u
+ rfmode=0
M$1462 \$75620 \$75621
+ BOTTOM|TOP|VGND|VSS|anode|cathode|core|h_sw[0]|h_sw[10]|h_sw[1]|h_sw[2]|h_sw[3]|h_sw[4]|h_sw[5]|h_sw[6]|h_sw[7]|h_sw[8]|h_sw[9]|l_sw[0]|l_sw[10]|l_sw[1]|l_sw[2]|l_sw[3]|l_sw[4]|l_sw[5]|l_sw[6]|l_sw[7]|l_sw[8]|l_sw[9]|out|pad|padres|vc|vcp|vdd|vddr|vip|vss|z
+ BOTTOM|TOP|VGND|VSS|anode|cathode|core|h_sw[0]|h_sw[10]|h_sw[1]|h_sw[2]|h_sw[3]|h_sw[4]|h_sw[5]|h_sw[6]|h_sw[7]|h_sw[8]|h_sw[9]|l_sw[0]|l_sw[10]|l_sw[1]|l_sw[2]|l_sw[3]|l_sw[4]|l_sw[5]|l_sw[6]|l_sw[7]|l_sw[8]|l_sw[9]|out|pad|padres|vc|vcp|vdd|vddr|vip|vss|z
+ sg13_lv_nmos L=0.13u W=0.42u AS=0.1428p AD=0.0798p PS=1.52u PD=0.8u rfmode=0
M$1463
+ BOTTOM|TOP|VGND|VSS|anode|cathode|core|h_sw[0]|h_sw[10]|h_sw[1]|h_sw[2]|h_sw[3]|h_sw[4]|h_sw[5]|h_sw[6]|h_sw[7]|h_sw[8]|h_sw[9]|l_sw[0]|l_sw[10]|l_sw[1]|l_sw[2]|l_sw[3]|l_sw[4]|l_sw[5]|l_sw[6]|l_sw[7]|l_sw[8]|l_sw[9]|out|pad|padres|vc|vcp|vdd|vddr|vip|vss|z
+ RESET_B|Y$2 \$75734
+ BOTTOM|TOP|VGND|VSS|anode|cathode|core|h_sw[0]|h_sw[10]|h_sw[1]|h_sw[2]|h_sw[3]|h_sw[4]|h_sw[5]|h_sw[6]|h_sw[7]|h_sw[8]|h_sw[9]|l_sw[0]|l_sw[10]|l_sw[1]|l_sw[2]|l_sw[3]|l_sw[4]|l_sw[5]|l_sw[6]|l_sw[7]|l_sw[8]|l_sw[9]|out|pad|padres|vc|vcp|vdd|vddr|vip|vss|z
+ sg13_lv_nmos L=0.13u W=0.42u AS=0.0798p AD=0.0378p PS=0.8u PD=0.6u rfmode=0
M$1464 \$75734 \$75661 \$75621
+ BOTTOM|TOP|VGND|VSS|anode|cathode|core|h_sw[0]|h_sw[10]|h_sw[1]|h_sw[2]|h_sw[3]|h_sw[4]|h_sw[5]|h_sw[6]|h_sw[7]|h_sw[8]|h_sw[9]|l_sw[0]|l_sw[10]|l_sw[1]|l_sw[2]|l_sw[3]|l_sw[4]|l_sw[5]|l_sw[6]|l_sw[7]|l_sw[8]|l_sw[9]|out|pad|padres|vc|vcp|vdd|vddr|vip|vss|z
+ sg13_lv_nmos L=0.13u W=0.42u AS=0.0378p AD=0.1428p PS=0.6u PD=1.52u rfmode=0
M$1465
+ BOTTOM|TOP|VGND|VSS|anode|cathode|core|h_sw[0]|h_sw[10]|h_sw[1]|h_sw[2]|h_sw[3]|h_sw[4]|h_sw[5]|h_sw[6]|h_sw[7]|h_sw[8]|h_sw[9]|l_sw[0]|l_sw[10]|l_sw[1]|l_sw[2]|l_sw[3]|l_sw[4]|l_sw[5]|l_sw[6]|l_sw[7]|l_sw[8]|l_sw[9]|out|pad|padres|vc|vcp|vdd|vddr|vip|vss|z
+ \$75661 Q_N$41
+ BOTTOM|TOP|VGND|VSS|anode|cathode|core|h_sw[0]|h_sw[10]|h_sw[1]|h_sw[2]|h_sw[3]|h_sw[4]|h_sw[5]|h_sw[6]|h_sw[7]|h_sw[8]|h_sw[9]|l_sw[0]|l_sw[10]|l_sw[1]|l_sw[2]|l_sw[3]|l_sw[4]|l_sw[5]|l_sw[6]|l_sw[7]|l_sw[8]|l_sw[9]|out|pad|padres|vc|vcp|vdd|vddr|vip|vss|z
+ sg13_lv_nmos L=0.13u W=0.74u AS=0.2516p AD=0.2849p PS=2.16u PD=2.25u rfmode=0
M$1466 \$75623 \$75661
+ BOTTOM|TOP|VGND|VSS|anode|cathode|core|h_sw[0]|h_sw[10]|h_sw[1]|h_sw[2]|h_sw[3]|h_sw[4]|h_sw[5]|h_sw[6]|h_sw[7]|h_sw[8]|h_sw[9]|l_sw[0]|l_sw[10]|l_sw[1]|l_sw[2]|l_sw[3]|l_sw[4]|l_sw[5]|l_sw[6]|l_sw[7]|l_sw[8]|l_sw[9]|out|pad|padres|vc|vcp|vdd|vddr|vip|vss|z
+ BOTTOM|TOP|VGND|VSS|anode|cathode|core|h_sw[0]|h_sw[10]|h_sw[1]|h_sw[2]|h_sw[3]|h_sw[4]|h_sw[5]|h_sw[6]|h_sw[7]|h_sw[8]|h_sw[9]|l_sw[0]|l_sw[10]|l_sw[1]|l_sw[2]|l_sw[3]|l_sw[4]|l_sw[5]|l_sw[6]|l_sw[7]|l_sw[8]|l_sw[9]|out|pad|padres|vc|vcp|vdd|vddr|vip|vss|z
+ sg13_lv_nmos L=0.13u W=0.74u AS=0.2516p AD=0.1406p PS=2.16u PD=1.12u rfmode=0
M$1467
+ BOTTOM|TOP|VGND|VSS|anode|cathode|core|h_sw[0]|h_sw[10]|h_sw[1]|h_sw[2]|h_sw[3]|h_sw[4]|h_sw[5]|h_sw[6]|h_sw[7]|h_sw[8]|h_sw[9]|l_sw[0]|l_sw[10]|l_sw[1]|l_sw[2]|l_sw[3]|l_sw[4]|l_sw[5]|l_sw[6]|l_sw[7]|l_sw[8]|l_sw[9]|out|pad|padres|vc|vcp|vdd|vddr|vip|vss|z
+ \$75623 CLK|D|GATE|Q$7
+ BOTTOM|TOP|VGND|VSS|anode|cathode|core|h_sw[0]|h_sw[10]|h_sw[1]|h_sw[2]|h_sw[3]|h_sw[4]|h_sw[5]|h_sw[6]|h_sw[7]|h_sw[8]|h_sw[9]|l_sw[0]|l_sw[10]|l_sw[1]|l_sw[2]|l_sw[3]|l_sw[4]|l_sw[5]|l_sw[6]|l_sw[7]|l_sw[8]|l_sw[9]|out|pad|padres|vc|vcp|vdd|vddr|vip|vss|z
+ sg13_lv_nmos L=0.13u W=0.74u AS=0.1406p AD=0.2516p PS=1.12u PD=2.16u rfmode=0
M$1468
+ BOTTOM|TOP|VGND|VSS|anode|cathode|core|h_sw[0]|h_sw[10]|h_sw[1]|h_sw[2]|h_sw[3]|h_sw[4]|h_sw[5]|h_sw[6]|h_sw[7]|h_sw[8]|h_sw[9]|l_sw[0]|l_sw[10]|l_sw[1]|l_sw[2]|l_sw[3]|l_sw[4]|l_sw[5]|l_sw[6]|l_sw[7]|l_sw[8]|l_sw[9]|out|pad|padres|vc|vcp|vdd|vddr|vip|vss|z
+ A|Y$23 \$75662
+ BOTTOM|TOP|VGND|VSS|anode|cathode|core|h_sw[0]|h_sw[10]|h_sw[1]|h_sw[2]|h_sw[3]|h_sw[4]|h_sw[5]|h_sw[6]|h_sw[7]|h_sw[8]|h_sw[9]|l_sw[0]|l_sw[10]|l_sw[1]|l_sw[2]|l_sw[3]|l_sw[4]|l_sw[5]|l_sw[6]|l_sw[7]|l_sw[8]|l_sw[9]|out|pad|padres|vc|vcp|vdd|vddr|vip|vss|z
+ sg13_lv_nmos L=0.13u W=0.55u AS=0.14875p AD=0.187p PS=1.16u PD=1.78u rfmode=0
M$1469
+ BOTTOM|TOP|VGND|VSS|anode|cathode|core|h_sw[0]|h_sw[10]|h_sw[1]|h_sw[2]|h_sw[3]|h_sw[4]|h_sw[5]|h_sw[6]|h_sw[7]|h_sw[8]|h_sw[9]|l_sw[0]|l_sw[10]|l_sw[1]|l_sw[2]|l_sw[3]|l_sw[4]|l_sw[5]|l_sw[6]|l_sw[7]|l_sw[8]|l_sw[9]|out|pad|padres|vc|vcp|vdd|vddr|vip|vss|z
+ \$75662 A|X$62
+ BOTTOM|TOP|VGND|VSS|anode|cathode|core|h_sw[0]|h_sw[10]|h_sw[1]|h_sw[2]|h_sw[3]|h_sw[4]|h_sw[5]|h_sw[6]|h_sw[7]|h_sw[8]|h_sw[9]|l_sw[0]|l_sw[10]|l_sw[1]|l_sw[2]|l_sw[3]|l_sw[4]|l_sw[5]|l_sw[6]|l_sw[7]|l_sw[8]|l_sw[9]|out|pad|padres|vc|vcp|vdd|vddr|vip|vss|z
+ sg13_lv_nmos L=0.13u W=0.74u AS=0.14875p AD=0.2886p PS=1.16u PD=2.26u rfmode=0
M$1470
+ BOTTOM|TOP|VGND|VSS|anode|cathode|core|h_sw[0]|h_sw[10]|h_sw[1]|h_sw[2]|h_sw[3]|h_sw[4]|h_sw[5]|h_sw[6]|h_sw[7]|h_sw[8]|h_sw[9]|l_sw[0]|l_sw[10]|l_sw[1]|l_sw[2]|l_sw[3]|l_sw[4]|l_sw[5]|l_sw[6]|l_sw[7]|l_sw[8]|l_sw[9]|out|pad|padres|vc|vcp|vdd|vddr|vip|vss|z
+ A|X$56 \$75663
+ BOTTOM|TOP|VGND|VSS|anode|cathode|core|h_sw[0]|h_sw[10]|h_sw[1]|h_sw[2]|h_sw[3]|h_sw[4]|h_sw[5]|h_sw[6]|h_sw[7]|h_sw[8]|h_sw[9]|l_sw[0]|l_sw[10]|l_sw[1]|l_sw[2]|l_sw[3]|l_sw[4]|l_sw[5]|l_sw[6]|l_sw[7]|l_sw[8]|l_sw[9]|out|pad|padres|vc|vcp|vdd|vddr|vip|vss|z
+ sg13_lv_nmos L=0.13u W=0.55u AS=0.14875p AD=0.187p PS=1.16u PD=1.78u rfmode=0
M$1471
+ BOTTOM|TOP|VGND|VSS|anode|cathode|core|h_sw[0]|h_sw[10]|h_sw[1]|h_sw[2]|h_sw[3]|h_sw[4]|h_sw[5]|h_sw[6]|h_sw[7]|h_sw[8]|h_sw[9]|l_sw[0]|l_sw[10]|l_sw[1]|l_sw[2]|l_sw[3]|l_sw[4]|l_sw[5]|l_sw[6]|l_sw[7]|l_sw[8]|l_sw[9]|out|pad|padres|vc|vcp|vdd|vddr|vip|vss|z
+ \$75663 A|X$63
+ BOTTOM|TOP|VGND|VSS|anode|cathode|core|h_sw[0]|h_sw[10]|h_sw[1]|h_sw[2]|h_sw[3]|h_sw[4]|h_sw[5]|h_sw[6]|h_sw[7]|h_sw[8]|h_sw[9]|l_sw[0]|l_sw[10]|l_sw[1]|l_sw[2]|l_sw[3]|l_sw[4]|l_sw[5]|l_sw[6]|l_sw[7]|l_sw[8]|l_sw[9]|out|pad|padres|vc|vcp|vdd|vddr|vip|vss|z
+ sg13_lv_nmos L=0.13u W=0.74u AS=0.14875p AD=0.2886p PS=1.16u PD=2.26u rfmode=0
M$1472 X|in_h_sw[6]|ph_sw[6]|x \$75664
+ BOTTOM|TOP|VGND|VSS|anode|cathode|core|h_sw[0]|h_sw[10]|h_sw[1]|h_sw[2]|h_sw[3]|h_sw[4]|h_sw[5]|h_sw[6]|h_sw[7]|h_sw[8]|h_sw[9]|l_sw[0]|l_sw[10]|l_sw[1]|l_sw[2]|l_sw[3]|l_sw[4]|l_sw[5]|l_sw[6]|l_sw[7]|l_sw[8]|l_sw[9]|out|pad|padres|vc|vcp|vdd|vddr|vip|vss|z
+ BOTTOM|TOP|VGND|VSS|anode|cathode|core|h_sw[0]|h_sw[10]|h_sw[1]|h_sw[2]|h_sw[3]|h_sw[4]|h_sw[5]|h_sw[6]|h_sw[7]|h_sw[8]|h_sw[9]|l_sw[0]|l_sw[10]|l_sw[1]|l_sw[2]|l_sw[3]|l_sw[4]|l_sw[5]|l_sw[6]|l_sw[7]|l_sw[8]|l_sw[9]|out|pad|padres|vc|vcp|vdd|vddr|vip|vss|z
+ sg13_lv_nmos L=0.13u W=0.74u AS=0.2886p AD=0.14875p PS=2.26u PD=1.16u rfmode=0
M$1473
+ BOTTOM|TOP|VGND|VSS|anode|cathode|core|h_sw[0]|h_sw[10]|h_sw[1]|h_sw[2]|h_sw[3]|h_sw[4]|h_sw[5]|h_sw[6]|h_sw[7]|h_sw[8]|h_sw[9]|l_sw[0]|l_sw[10]|l_sw[1]|l_sw[2]|l_sw[3]|l_sw[4]|l_sw[5]|l_sw[6]|l_sw[7]|l_sw[8]|l_sw[9]|out|pad|padres|vc|vcp|vdd|vddr|vip|vss|z
+ A|X$55 \$75664
+ BOTTOM|TOP|VGND|VSS|anode|cathode|core|h_sw[0]|h_sw[10]|h_sw[1]|h_sw[2]|h_sw[3]|h_sw[4]|h_sw[5]|h_sw[6]|h_sw[7]|h_sw[8]|h_sw[9]|l_sw[0]|l_sw[10]|l_sw[1]|l_sw[2]|l_sw[3]|l_sw[4]|l_sw[5]|l_sw[6]|l_sw[7]|l_sw[8]|l_sw[9]|out|pad|padres|vc|vcp|vdd|vddr|vip|vss|z
+ sg13_lv_nmos L=0.13u W=0.55u AS=0.14875p AD=0.187p PS=1.16u PD=1.78u rfmode=0
M$1474
+ BOTTOM|TOP|VGND|VSS|anode|cathode|core|h_sw[0]|h_sw[10]|h_sw[1]|h_sw[2]|h_sw[3]|h_sw[4]|h_sw[5]|h_sw[6]|h_sw[7]|h_sw[8]|h_sw[9]|l_sw[0]|l_sw[10]|l_sw[1]|l_sw[2]|l_sw[3]|l_sw[4]|l_sw[5]|l_sw[6]|l_sw[7]|l_sw[8]|l_sw[9]|out|pad|padres|vc|vcp|vdd|vddr|vip|vss|z
+ A|Y$20 \$75665
+ BOTTOM|TOP|VGND|VSS|anode|cathode|core|h_sw[0]|h_sw[10]|h_sw[1]|h_sw[2]|h_sw[3]|h_sw[4]|h_sw[5]|h_sw[6]|h_sw[7]|h_sw[8]|h_sw[9]|l_sw[0]|l_sw[10]|l_sw[1]|l_sw[2]|l_sw[3]|l_sw[4]|l_sw[5]|l_sw[6]|l_sw[7]|l_sw[8]|l_sw[9]|out|pad|padres|vc|vcp|vdd|vddr|vip|vss|z
+ sg13_lv_nmos L=0.13u W=0.55u AS=0.14875p AD=0.187p PS=1.16u PD=1.78u rfmode=0
M$1475
+ BOTTOM|TOP|VGND|VSS|anode|cathode|core|h_sw[0]|h_sw[10]|h_sw[1]|h_sw[2]|h_sw[3]|h_sw[4]|h_sw[5]|h_sw[6]|h_sw[7]|h_sw[8]|h_sw[9]|l_sw[0]|l_sw[10]|l_sw[1]|l_sw[2]|l_sw[3]|l_sw[4]|l_sw[5]|l_sw[6]|l_sw[7]|l_sw[8]|l_sw[9]|out|pad|padres|vc|vcp|vdd|vddr|vip|vss|z
+ \$75665 A|X$73
+ BOTTOM|TOP|VGND|VSS|anode|cathode|core|h_sw[0]|h_sw[10]|h_sw[1]|h_sw[2]|h_sw[3]|h_sw[4]|h_sw[5]|h_sw[6]|h_sw[7]|h_sw[8]|h_sw[9]|l_sw[0]|l_sw[10]|l_sw[1]|l_sw[2]|l_sw[3]|l_sw[4]|l_sw[5]|l_sw[6]|l_sw[7]|l_sw[8]|l_sw[9]|out|pad|padres|vc|vcp|vdd|vddr|vip|vss|z
+ sg13_lv_nmos L=0.13u W=0.74u AS=0.14875p AD=0.2886p PS=1.16u PD=2.26u rfmode=0
M$1476
+ BOTTOM|TOP|VGND|VSS|anode|cathode|core|h_sw[0]|h_sw[10]|h_sw[1]|h_sw[2]|h_sw[3]|h_sw[4]|h_sw[5]|h_sw[6]|h_sw[7]|h_sw[8]|h_sw[9]|l_sw[0]|l_sw[10]|l_sw[1]|l_sw[2]|l_sw[3]|l_sw[4]|l_sw[5]|l_sw[6]|l_sw[7]|l_sw[8]|l_sw[9]|out|pad|padres|vc|vcp|vdd|vddr|vip|vss|z
+ A|X$43 \$75666
+ BOTTOM|TOP|VGND|VSS|anode|cathode|core|h_sw[0]|h_sw[10]|h_sw[1]|h_sw[2]|h_sw[3]|h_sw[4]|h_sw[5]|h_sw[6]|h_sw[7]|h_sw[8]|h_sw[9]|l_sw[0]|l_sw[10]|l_sw[1]|l_sw[2]|l_sw[3]|l_sw[4]|l_sw[5]|l_sw[6]|l_sw[7]|l_sw[8]|l_sw[9]|out|pad|padres|vc|vcp|vdd|vddr|vip|vss|z
+ sg13_lv_nmos L=0.13u W=0.55u AS=0.14875p AD=0.187p PS=1.16u PD=1.78u rfmode=0
M$1477
+ BOTTOM|TOP|VGND|VSS|anode|cathode|core|h_sw[0]|h_sw[10]|h_sw[1]|h_sw[2]|h_sw[3]|h_sw[4]|h_sw[5]|h_sw[6]|h_sw[7]|h_sw[8]|h_sw[9]|l_sw[0]|l_sw[10]|l_sw[1]|l_sw[2]|l_sw[3]|l_sw[4]|l_sw[5]|l_sw[6]|l_sw[7]|l_sw[8]|l_sw[9]|out|pad|padres|vc|vcp|vdd|vddr|vip|vss|z
+ \$75666 A|X$64
+ BOTTOM|TOP|VGND|VSS|anode|cathode|core|h_sw[0]|h_sw[10]|h_sw[1]|h_sw[2]|h_sw[3]|h_sw[4]|h_sw[5]|h_sw[6]|h_sw[7]|h_sw[8]|h_sw[9]|l_sw[0]|l_sw[10]|l_sw[1]|l_sw[2]|l_sw[3]|l_sw[4]|l_sw[5]|l_sw[6]|l_sw[7]|l_sw[8]|l_sw[9]|out|pad|padres|vc|vcp|vdd|vddr|vip|vss|z
+ sg13_lv_nmos L=0.13u W=0.74u AS=0.14875p AD=0.2886p PS=1.16u PD=2.26u rfmode=0
M$1478 X|in_l_sw[7]|pl_sw[7]|x \$75667
+ BOTTOM|TOP|VGND|VSS|anode|cathode|core|h_sw[0]|h_sw[10]|h_sw[1]|h_sw[2]|h_sw[3]|h_sw[4]|h_sw[5]|h_sw[6]|h_sw[7]|h_sw[8]|h_sw[9]|l_sw[0]|l_sw[10]|l_sw[1]|l_sw[2]|l_sw[3]|l_sw[4]|l_sw[5]|l_sw[6]|l_sw[7]|l_sw[8]|l_sw[9]|out|pad|padres|vc|vcp|vdd|vddr|vip|vss|z
+ BOTTOM|TOP|VGND|VSS|anode|cathode|core|h_sw[0]|h_sw[10]|h_sw[1]|h_sw[2]|h_sw[3]|h_sw[4]|h_sw[5]|h_sw[6]|h_sw[7]|h_sw[8]|h_sw[9]|l_sw[0]|l_sw[10]|l_sw[1]|l_sw[2]|l_sw[3]|l_sw[4]|l_sw[5]|l_sw[6]|l_sw[7]|l_sw[8]|l_sw[9]|out|pad|padres|vc|vcp|vdd|vddr|vip|vss|z
+ sg13_lv_nmos L=0.13u W=0.74u AS=0.2886p AD=0.14875p PS=2.26u PD=1.16u rfmode=0
M$1479
+ BOTTOM|TOP|VGND|VSS|anode|cathode|core|h_sw[0]|h_sw[10]|h_sw[1]|h_sw[2]|h_sw[3]|h_sw[4]|h_sw[5]|h_sw[6]|h_sw[7]|h_sw[8]|h_sw[9]|l_sw[0]|l_sw[10]|l_sw[1]|l_sw[2]|l_sw[3]|l_sw[4]|l_sw[5]|l_sw[6]|l_sw[7]|l_sw[8]|l_sw[9]|out|pad|padres|vc|vcp|vdd|vddr|vip|vss|z
+ A|X$62 \$75667
+ BOTTOM|TOP|VGND|VSS|anode|cathode|core|h_sw[0]|h_sw[10]|h_sw[1]|h_sw[2]|h_sw[3]|h_sw[4]|h_sw[5]|h_sw[6]|h_sw[7]|h_sw[8]|h_sw[9]|l_sw[0]|l_sw[10]|l_sw[1]|l_sw[2]|l_sw[3]|l_sw[4]|l_sw[5]|l_sw[6]|l_sw[7]|l_sw[8]|l_sw[9]|out|pad|padres|vc|vcp|vdd|vddr|vip|vss|z
+ sg13_lv_nmos L=0.13u W=0.55u AS=0.14875p AD=0.187p PS=1.16u PD=1.78u rfmode=0
M$1480 X|in_h_sw[7]|ph_sw[7]|x \$75668
+ BOTTOM|TOP|VGND|VSS|anode|cathode|core|h_sw[0]|h_sw[10]|h_sw[1]|h_sw[2]|h_sw[3]|h_sw[4]|h_sw[5]|h_sw[6]|h_sw[7]|h_sw[8]|h_sw[9]|l_sw[0]|l_sw[10]|l_sw[1]|l_sw[2]|l_sw[3]|l_sw[4]|l_sw[5]|l_sw[6]|l_sw[7]|l_sw[8]|l_sw[9]|out|pad|padres|vc|vcp|vdd|vddr|vip|vss|z
+ BOTTOM|TOP|VGND|VSS|anode|cathode|core|h_sw[0]|h_sw[10]|h_sw[1]|h_sw[2]|h_sw[3]|h_sw[4]|h_sw[5]|h_sw[6]|h_sw[7]|h_sw[8]|h_sw[9]|l_sw[0]|l_sw[10]|l_sw[1]|l_sw[2]|l_sw[3]|l_sw[4]|l_sw[5]|l_sw[6]|l_sw[7]|l_sw[8]|l_sw[9]|out|pad|padres|vc|vcp|vdd|vddr|vip|vss|z
+ sg13_lv_nmos L=0.13u W=0.74u AS=0.2886p AD=0.14875p PS=2.26u PD=1.16u rfmode=0
M$1481
+ BOTTOM|TOP|VGND|VSS|anode|cathode|core|h_sw[0]|h_sw[10]|h_sw[1]|h_sw[2]|h_sw[3]|h_sw[4]|h_sw[5]|h_sw[6]|h_sw[7]|h_sw[8]|h_sw[9]|l_sw[0]|l_sw[10]|l_sw[1]|l_sw[2]|l_sw[3]|l_sw[4]|l_sw[5]|l_sw[6]|l_sw[7]|l_sw[8]|l_sw[9]|out|pad|padres|vc|vcp|vdd|vddr|vip|vss|z
+ A|X$63 \$75668
+ BOTTOM|TOP|VGND|VSS|anode|cathode|core|h_sw[0]|h_sw[10]|h_sw[1]|h_sw[2]|h_sw[3]|h_sw[4]|h_sw[5]|h_sw[6]|h_sw[7]|h_sw[8]|h_sw[9]|l_sw[0]|l_sw[10]|l_sw[1]|l_sw[2]|l_sw[3]|l_sw[4]|l_sw[5]|l_sw[6]|l_sw[7]|l_sw[8]|l_sw[9]|out|pad|padres|vc|vcp|vdd|vddr|vip|vss|z
+ sg13_lv_nmos L=0.13u W=0.55u AS=0.14875p AD=0.187p PS=1.16u PD=1.78u rfmode=0
M$1482 X|in_l_sw[8]|pl_sw[8]|x \$75669
+ BOTTOM|TOP|VGND|VSS|anode|cathode|core|h_sw[0]|h_sw[10]|h_sw[1]|h_sw[2]|h_sw[3]|h_sw[4]|h_sw[5]|h_sw[6]|h_sw[7]|h_sw[8]|h_sw[9]|l_sw[0]|l_sw[10]|l_sw[1]|l_sw[2]|l_sw[3]|l_sw[4]|l_sw[5]|l_sw[6]|l_sw[7]|l_sw[8]|l_sw[9]|out|pad|padres|vc|vcp|vdd|vddr|vip|vss|z
+ BOTTOM|TOP|VGND|VSS|anode|cathode|core|h_sw[0]|h_sw[10]|h_sw[1]|h_sw[2]|h_sw[3]|h_sw[4]|h_sw[5]|h_sw[6]|h_sw[7]|h_sw[8]|h_sw[9]|l_sw[0]|l_sw[10]|l_sw[1]|l_sw[2]|l_sw[3]|l_sw[4]|l_sw[5]|l_sw[6]|l_sw[7]|l_sw[8]|l_sw[9]|out|pad|padres|vc|vcp|vdd|vddr|vip|vss|z
+ sg13_lv_nmos L=0.13u W=0.74u AS=0.2886p AD=0.14875p PS=2.26u PD=1.16u rfmode=0
M$1483
+ BOTTOM|TOP|VGND|VSS|anode|cathode|core|h_sw[0]|h_sw[10]|h_sw[1]|h_sw[2]|h_sw[3]|h_sw[4]|h_sw[5]|h_sw[6]|h_sw[7]|h_sw[8]|h_sw[9]|l_sw[0]|l_sw[10]|l_sw[1]|l_sw[2]|l_sw[3]|l_sw[4]|l_sw[5]|l_sw[6]|l_sw[7]|l_sw[8]|l_sw[9]|out|pad|padres|vc|vcp|vdd|vddr|vip|vss|z
+ A|X$73 \$75669
+ BOTTOM|TOP|VGND|VSS|anode|cathode|core|h_sw[0]|h_sw[10]|h_sw[1]|h_sw[2]|h_sw[3]|h_sw[4]|h_sw[5]|h_sw[6]|h_sw[7]|h_sw[8]|h_sw[9]|l_sw[0]|l_sw[10]|l_sw[1]|l_sw[2]|l_sw[3]|l_sw[4]|l_sw[5]|l_sw[6]|l_sw[7]|l_sw[8]|l_sw[9]|out|pad|padres|vc|vcp|vdd|vddr|vip|vss|z
+ sg13_lv_nmos L=0.13u W=0.55u AS=0.14875p AD=0.187p PS=1.16u PD=1.78u rfmode=0
M$1484
+ BOTTOM|TOP|VGND|VSS|anode|cathode|core|h_sw[0]|h_sw[10]|h_sw[1]|h_sw[2]|h_sw[3]|h_sw[4]|h_sw[5]|h_sw[6]|h_sw[7]|h_sw[8]|h_sw[9]|l_sw[0]|l_sw[10]|l_sw[1]|l_sw[2]|l_sw[3]|l_sw[4]|l_sw[5]|l_sw[6]|l_sw[7]|l_sw[8]|l_sw[9]|out|pad|padres|vc|vcp|vdd|vddr|vip|vss|z
+ A|Y$24 \$75670
+ BOTTOM|TOP|VGND|VSS|anode|cathode|core|h_sw[0]|h_sw[10]|h_sw[1]|h_sw[2]|h_sw[3]|h_sw[4]|h_sw[5]|h_sw[6]|h_sw[7]|h_sw[8]|h_sw[9]|l_sw[0]|l_sw[10]|l_sw[1]|l_sw[2]|l_sw[3]|l_sw[4]|l_sw[5]|l_sw[6]|l_sw[7]|l_sw[8]|l_sw[9]|out|pad|padres|vc|vcp|vdd|vddr|vip|vss|z
+ sg13_lv_nmos L=0.13u W=0.55u AS=0.14875p AD=0.187p PS=1.16u PD=1.78u rfmode=0
M$1485
+ BOTTOM|TOP|VGND|VSS|anode|cathode|core|h_sw[0]|h_sw[10]|h_sw[1]|h_sw[2]|h_sw[3]|h_sw[4]|h_sw[5]|h_sw[6]|h_sw[7]|h_sw[8]|h_sw[9]|l_sw[0]|l_sw[10]|l_sw[1]|l_sw[2]|l_sw[3]|l_sw[4]|l_sw[5]|l_sw[6]|l_sw[7]|l_sw[8]|l_sw[9]|out|pad|padres|vc|vcp|vdd|vddr|vip|vss|z
+ \$75670 A|X$65
+ BOTTOM|TOP|VGND|VSS|anode|cathode|core|h_sw[0]|h_sw[10]|h_sw[1]|h_sw[2]|h_sw[3]|h_sw[4]|h_sw[5]|h_sw[6]|h_sw[7]|h_sw[8]|h_sw[9]|l_sw[0]|l_sw[10]|l_sw[1]|l_sw[2]|l_sw[3]|l_sw[4]|l_sw[5]|l_sw[6]|l_sw[7]|l_sw[8]|l_sw[9]|out|pad|padres|vc|vcp|vdd|vddr|vip|vss|z
+ sg13_lv_nmos L=0.13u W=0.74u AS=0.14875p AD=0.2886p PS=1.16u PD=2.26u rfmode=0
M$1486
+ BOTTOM|TOP|VGND|VSS|anode|cathode|core|h_sw[0]|h_sw[10]|h_sw[1]|h_sw[2]|h_sw[3]|h_sw[4]|h_sw[5]|h_sw[6]|h_sw[7]|h_sw[8]|h_sw[9]|l_sw[0]|l_sw[10]|l_sw[1]|l_sw[2]|l_sw[3]|l_sw[4]|l_sw[5]|l_sw[6]|l_sw[7]|l_sw[8]|l_sw[9]|out|pad|padres|vc|vcp|vdd|vddr|vip|vss|z
+ A|X$49 \$75671
+ BOTTOM|TOP|VGND|VSS|anode|cathode|core|h_sw[0]|h_sw[10]|h_sw[1]|h_sw[2]|h_sw[3]|h_sw[4]|h_sw[5]|h_sw[6]|h_sw[7]|h_sw[8]|h_sw[9]|l_sw[0]|l_sw[10]|l_sw[1]|l_sw[2]|l_sw[3]|l_sw[4]|l_sw[5]|l_sw[6]|l_sw[7]|l_sw[8]|l_sw[9]|out|pad|padres|vc|vcp|vdd|vddr|vip|vss|z
+ sg13_lv_nmos L=0.13u W=0.55u AS=0.14875p AD=0.187p PS=1.16u PD=1.78u rfmode=0
M$1487
+ BOTTOM|TOP|VGND|VSS|anode|cathode|core|h_sw[0]|h_sw[10]|h_sw[1]|h_sw[2]|h_sw[3]|h_sw[4]|h_sw[5]|h_sw[6]|h_sw[7]|h_sw[8]|h_sw[9]|l_sw[0]|l_sw[10]|l_sw[1]|l_sw[2]|l_sw[3]|l_sw[4]|l_sw[5]|l_sw[6]|l_sw[7]|l_sw[8]|l_sw[9]|out|pad|padres|vc|vcp|vdd|vddr|vip|vss|z
+ \$75671 A|X$47
+ BOTTOM|TOP|VGND|VSS|anode|cathode|core|h_sw[0]|h_sw[10]|h_sw[1]|h_sw[2]|h_sw[3]|h_sw[4]|h_sw[5]|h_sw[6]|h_sw[7]|h_sw[8]|h_sw[9]|l_sw[0]|l_sw[10]|l_sw[1]|l_sw[2]|l_sw[3]|l_sw[4]|l_sw[5]|l_sw[6]|l_sw[7]|l_sw[8]|l_sw[9]|out|pad|padres|vc|vcp|vdd|vddr|vip|vss|z
+ sg13_lv_nmos L=0.13u W=0.74u AS=0.14875p AD=0.2886p PS=1.16u PD=2.26u rfmode=0
M$1488 X|in_h_sw[8]|ph_sw[8]|x \$75672
+ BOTTOM|TOP|VGND|VSS|anode|cathode|core|h_sw[0]|h_sw[10]|h_sw[1]|h_sw[2]|h_sw[3]|h_sw[4]|h_sw[5]|h_sw[6]|h_sw[7]|h_sw[8]|h_sw[9]|l_sw[0]|l_sw[10]|l_sw[1]|l_sw[2]|l_sw[3]|l_sw[4]|l_sw[5]|l_sw[6]|l_sw[7]|l_sw[8]|l_sw[9]|out|pad|padres|vc|vcp|vdd|vddr|vip|vss|z
+ BOTTOM|TOP|VGND|VSS|anode|cathode|core|h_sw[0]|h_sw[10]|h_sw[1]|h_sw[2]|h_sw[3]|h_sw[4]|h_sw[5]|h_sw[6]|h_sw[7]|h_sw[8]|h_sw[9]|l_sw[0]|l_sw[10]|l_sw[1]|l_sw[2]|l_sw[3]|l_sw[4]|l_sw[5]|l_sw[6]|l_sw[7]|l_sw[8]|l_sw[9]|out|pad|padres|vc|vcp|vdd|vddr|vip|vss|z
+ sg13_lv_nmos L=0.13u W=0.74u AS=0.2886p AD=0.14875p PS=2.26u PD=1.16u rfmode=0
M$1489
+ BOTTOM|TOP|VGND|VSS|anode|cathode|core|h_sw[0]|h_sw[10]|h_sw[1]|h_sw[2]|h_sw[3]|h_sw[4]|h_sw[5]|h_sw[6]|h_sw[7]|h_sw[8]|h_sw[9]|l_sw[0]|l_sw[10]|l_sw[1]|l_sw[2]|l_sw[3]|l_sw[4]|l_sw[5]|l_sw[6]|l_sw[7]|l_sw[8]|l_sw[9]|out|pad|padres|vc|vcp|vdd|vddr|vip|vss|z
+ A|X$64 \$75672
+ BOTTOM|TOP|VGND|VSS|anode|cathode|core|h_sw[0]|h_sw[10]|h_sw[1]|h_sw[2]|h_sw[3]|h_sw[4]|h_sw[5]|h_sw[6]|h_sw[7]|h_sw[8]|h_sw[9]|l_sw[0]|l_sw[10]|l_sw[1]|l_sw[2]|l_sw[3]|l_sw[4]|l_sw[5]|l_sw[6]|l_sw[7]|l_sw[8]|l_sw[9]|out|pad|padres|vc|vcp|vdd|vddr|vip|vss|z
+ sg13_lv_nmos L=0.13u W=0.55u AS=0.14875p AD=0.187p PS=1.16u PD=1.78u rfmode=0
M$1490 \$75633 A|anode|cathode|ck|cks|core|pad|padres
+ BOTTOM|TOP|VGND|VSS|anode|cathode|core|h_sw[0]|h_sw[10]|h_sw[1]|h_sw[2]|h_sw[3]|h_sw[4]|h_sw[5]|h_sw[6]|h_sw[7]|h_sw[8]|h_sw[9]|l_sw[0]|l_sw[10]|l_sw[1]|l_sw[2]|l_sw[3]|l_sw[4]|l_sw[5]|l_sw[6]|l_sw[7]|l_sw[8]|l_sw[9]|out|pad|padres|vc|vcp|vdd|vddr|vip|vss|z
+ BOTTOM|TOP|VGND|VSS|anode|cathode|core|h_sw[0]|h_sw[10]|h_sw[1]|h_sw[2]|h_sw[3]|h_sw[4]|h_sw[5]|h_sw[6]|h_sw[7]|h_sw[8]|h_sw[9]|l_sw[0]|l_sw[10]|l_sw[1]|l_sw[2]|l_sw[3]|l_sw[4]|l_sw[5]|l_sw[6]|l_sw[7]|l_sw[8]|l_sw[9]|out|pad|padres|vc|vcp|vdd|vddr|vip|vss|z
+ sg13_lv_nmos L=0.13u W=2.22u AS=0.5365p AD=0.4218p PS=4.41u PD=3.36u rfmode=0
M$1493
+ BOTTOM|TOP|VGND|VSS|anode|cathode|core|h_sw[0]|h_sw[10]|h_sw[1]|h_sw[2]|h_sw[3]|h_sw[4]|h_sw[5]|h_sw[6]|h_sw[7]|h_sw[8]|h_sw[9]|l_sw[0]|l_sw[10]|l_sw[1]|l_sw[2]|l_sw[3]|l_sw[4]|l_sw[5]|l_sw[6]|l_sw[7]|l_sw[8]|l_sw[9]|out|pad|padres|vc|vcp|vdd|vddr|vip|vss|z
+ \$75633 A|X$51
+ BOTTOM|TOP|VGND|VSS|anode|cathode|core|h_sw[0]|h_sw[10]|h_sw[1]|h_sw[2]|h_sw[3]|h_sw[4]|h_sw[5]|h_sw[6]|h_sw[7]|h_sw[8]|h_sw[9]|l_sw[0]|l_sw[10]|l_sw[1]|l_sw[2]|l_sw[3]|l_sw[4]|l_sw[5]|l_sw[6]|l_sw[7]|l_sw[8]|l_sw[9]|out|pad|padres|vc|vcp|vdd|vddr|vip|vss|z
+ sg13_lv_nmos L=0.13u W=5.92u AS=1.1248p AD=1.2358p PS=8.96u PD=10u rfmode=0
M$1501
+ BOTTOM|TOP|VGND|VSS|anode|cathode|core|h_sw[0]|h_sw[10]|h_sw[1]|h_sw[2]|h_sw[3]|h_sw[4]|h_sw[5]|h_sw[6]|h_sw[7]|h_sw[8]|h_sw[9]|l_sw[0]|l_sw[10]|l_sw[1]|l_sw[2]|l_sw[3]|l_sw[4]|l_sw[5]|l_sw[6]|l_sw[7]|l_sw[8]|l_sw[9]|out|pad|padres|vc|vcp|vdd|vddr|vip|vss|z
+ A|X$28 A|Y$29
+ BOTTOM|TOP|VGND|VSS|anode|cathode|core|h_sw[0]|h_sw[10]|h_sw[1]|h_sw[2]|h_sw[3]|h_sw[4]|h_sw[5]|h_sw[6]|h_sw[7]|h_sw[8]|h_sw[9]|l_sw[0]|l_sw[10]|l_sw[1]|l_sw[2]|l_sw[3]|l_sw[4]|l_sw[5]|l_sw[6]|l_sw[7]|l_sw[8]|l_sw[9]|out|pad|padres|vc|vcp|vdd|vddr|vip|vss|z
+ sg13_lv_nmos L=0.13u W=0.74u AS=0.2516p AD=0.2516p PS=2.16u PD=2.16u rfmode=0
M$1502
+ BOTTOM|TOP|VGND|VSS|anode|cathode|core|h_sw[0]|h_sw[10]|h_sw[1]|h_sw[2]|h_sw[3]|h_sw[4]|h_sw[5]|h_sw[6]|h_sw[7]|h_sw[8]|h_sw[9]|l_sw[0]|l_sw[10]|l_sw[1]|l_sw[2]|l_sw[3]|l_sw[4]|l_sw[5]|l_sw[6]|l_sw[7]|l_sw[8]|l_sw[9]|out|pad|padres|vc|vcp|vdd|vddr|vip|vss|z
+ X|in_l_sw[0]|pl_sw[0]|x
+ BOTTOM|TOP|VGND|VSS|anode|cathode|core|h_sw[0]|h_sw[10]|h_sw[1]|h_sw[2]|h_sw[3]|h_sw[4]|h_sw[5]|h_sw[6]|h_sw[7]|h_sw[8]|h_sw[9]|l_sw[0]|l_sw[10]|l_sw[1]|l_sw[2]|l_sw[3]|l_sw[4]|l_sw[5]|l_sw[6]|l_sw[7]|l_sw[8]|l_sw[9]|out|pad|padres|vc|vcp|vdd|vddr|vip|vss|z
+ BOTTOM|TOP|VGND|VSS|anode|cathode|core|h_sw[0]|h_sw[10]|h_sw[1]|h_sw[2]|h_sw[3]|h_sw[4]|h_sw[5]|h_sw[6]|h_sw[7]|h_sw[8]|h_sw[9]|l_sw[0]|l_sw[10]|l_sw[1]|l_sw[2]|l_sw[3]|l_sw[4]|l_sw[5]|l_sw[6]|l_sw[7]|l_sw[8]|l_sw[9]|out|pad|padres|vc|vcp|vdd|vddr|vip|vss|z
+ sg13_lv_nmos L=0.13u W=16u AS=3.115p AD=3.115p PS=28.96u PD=28.96u rfmode=0
M$1534
+ BOTTOM|TOP|VGND|VSS|anode|cathode|core|h_sw[0]|h_sw[10]|h_sw[1]|h_sw[2]|h_sw[3]|h_sw[4]|h_sw[5]|h_sw[6]|h_sw[7]|h_sw[8]|h_sw[9]|l_sw[0]|l_sw[10]|l_sw[1]|l_sw[2]|l_sw[3]|l_sw[4]|l_sw[5]|l_sw[6]|l_sw[7]|l_sw[8]|l_sw[9]|out|pad|padres|vc|vcp|vdd|vddr|vip|vss|z
+ X|in_h_sw[0]|ph_sw[0]|x
+ BOTTOM|TOP|VGND|VSS|anode|cathode|core|h_sw[0]|h_sw[10]|h_sw[1]|h_sw[2]|h_sw[3]|h_sw[4]|h_sw[5]|h_sw[6]|h_sw[7]|h_sw[8]|h_sw[9]|l_sw[0]|l_sw[10]|l_sw[1]|l_sw[2]|l_sw[3]|l_sw[4]|l_sw[5]|l_sw[6]|l_sw[7]|l_sw[8]|l_sw[9]|out|pad|padres|vc|vcp|vdd|vddr|vip|vss|z
+ BOTTOM|TOP|VGND|VSS|anode|cathode|core|h_sw[0]|h_sw[10]|h_sw[1]|h_sw[2]|h_sw[3]|h_sw[4]|h_sw[5]|h_sw[6]|h_sw[7]|h_sw[8]|h_sw[9]|l_sw[0]|l_sw[10]|l_sw[1]|l_sw[2]|l_sw[3]|l_sw[4]|l_sw[5]|l_sw[6]|l_sw[7]|l_sw[8]|l_sw[9]|out|pad|padres|vc|vcp|vdd|vddr|vip|vss|z
+ sg13_lv_nmos L=0.13u W=16u AS=3.115p AD=3.115p PS=28.96u PD=28.96u rfmode=0
M$1566
+ BOTTOM|TOP|VGND|VSS|anode|cathode|core|h_sw[0]|h_sw[10]|h_sw[1]|h_sw[2]|h_sw[3]|h_sw[4]|h_sw[5]|h_sw[6]|h_sw[7]|h_sw[8]|h_sw[9]|l_sw[0]|l_sw[10]|l_sw[1]|l_sw[2]|l_sw[3]|l_sw[4]|l_sw[5]|l_sw[6]|l_sw[7]|l_sw[8]|l_sw[9]|out|pad|padres|vc|vcp|vdd|vddr|vip|vss|z
+ X|in_h_sw[3]|ph_sw[3]|x
+ BOTTOM|TOP|VGND|VSS|anode|cathode|core|h_sw[0]|h_sw[10]|h_sw[1]|h_sw[2]|h_sw[3]|h_sw[4]|h_sw[5]|h_sw[6]|h_sw[7]|h_sw[8]|h_sw[9]|l_sw[0]|l_sw[10]|l_sw[1]|l_sw[2]|l_sw[3]|l_sw[4]|l_sw[5]|l_sw[6]|l_sw[7]|l_sw[8]|l_sw[9]|out|pad|padres|vc|vcp|vdd|vddr|vip|vss|z
+ BOTTOM|TOP|VGND|VSS|anode|cathode|core|h_sw[0]|h_sw[10]|h_sw[1]|h_sw[2]|h_sw[3]|h_sw[4]|h_sw[5]|h_sw[6]|h_sw[7]|h_sw[8]|h_sw[9]|l_sw[0]|l_sw[10]|l_sw[1]|l_sw[2]|l_sw[3]|l_sw[4]|l_sw[5]|l_sw[6]|l_sw[7]|l_sw[8]|l_sw[9]|out|pad|padres|vc|vcp|vdd|vddr|vip|vss|z
+ sg13_lv_nmos L=0.13u W=4u AS=0.835p AD=0.835p PS=7.84u PD=7.84u rfmode=0
M$1574
+ BOTTOM|TOP|VGND|VSS|anode|cathode|core|h_sw[0]|h_sw[10]|h_sw[1]|h_sw[2]|h_sw[3]|h_sw[4]|h_sw[5]|h_sw[6]|h_sw[7]|h_sw[8]|h_sw[9]|l_sw[0]|l_sw[10]|l_sw[1]|l_sw[2]|l_sw[3]|l_sw[4]|l_sw[5]|l_sw[6]|l_sw[7]|l_sw[8]|l_sw[9]|out|pad|padres|vc|vcp|vdd|vddr|vip|vss|z
+ X|in_h_sw[4]|ph_sw[4]|x
+ BOTTOM|TOP|VGND|VSS|anode|cathode|core|h_sw[0]|h_sw[10]|h_sw[1]|h_sw[2]|h_sw[3]|h_sw[4]|h_sw[5]|h_sw[6]|h_sw[7]|h_sw[8]|h_sw[9]|l_sw[0]|l_sw[10]|l_sw[1]|l_sw[2]|l_sw[3]|l_sw[4]|l_sw[5]|l_sw[6]|l_sw[7]|l_sw[8]|l_sw[9]|out|pad|padres|vc|vcp|vdd|vddr|vip|vss|z
+ BOTTOM|TOP|VGND|VSS|anode|cathode|core|h_sw[0]|h_sw[10]|h_sw[1]|h_sw[2]|h_sw[3]|h_sw[4]|h_sw[5]|h_sw[6]|h_sw[7]|h_sw[8]|h_sw[9]|l_sw[0]|l_sw[10]|l_sw[1]|l_sw[2]|l_sw[3]|l_sw[4]|l_sw[5]|l_sw[6]|l_sw[7]|l_sw[8]|l_sw[9]|out|pad|padres|vc|vcp|vdd|vddr|vip|vss|z
+ sg13_lv_nmos L=0.13u W=4u AS=0.835p AD=0.835p PS=7.84u PD=7.84u rfmode=0
M$1582
+ BOTTOM|TOP|VGND|VSS|anode|cathode|core|h_sw[0]|h_sw[10]|h_sw[1]|h_sw[2]|h_sw[3]|h_sw[4]|h_sw[5]|h_sw[6]|h_sw[7]|h_sw[8]|h_sw[9]|l_sw[0]|l_sw[10]|l_sw[1]|l_sw[2]|l_sw[3]|l_sw[4]|l_sw[5]|l_sw[6]|l_sw[7]|l_sw[8]|l_sw[9]|out|pad|padres|vc|vcp|vdd|vddr|vip|vss|z
+ X|in_h_sw[5]|ph_sw[5]|x
+ BOTTOM|TOP|VGND|VSS|anode|cathode|core|h_sw[0]|h_sw[10]|h_sw[1]|h_sw[2]|h_sw[3]|h_sw[4]|h_sw[5]|h_sw[6]|h_sw[7]|h_sw[8]|h_sw[9]|l_sw[0]|l_sw[10]|l_sw[1]|l_sw[2]|l_sw[3]|l_sw[4]|l_sw[5]|l_sw[6]|l_sw[7]|l_sw[8]|l_sw[9]|out|pad|padres|vc|vcp|vdd|vddr|vip|vss|z
+ BOTTOM|TOP|VGND|VSS|anode|cathode|core|h_sw[0]|h_sw[10]|h_sw[1]|h_sw[2]|h_sw[3]|h_sw[4]|h_sw[5]|h_sw[6]|h_sw[7]|h_sw[8]|h_sw[9]|l_sw[0]|l_sw[10]|l_sw[1]|l_sw[2]|l_sw[3]|l_sw[4]|l_sw[5]|l_sw[6]|l_sw[7]|l_sw[8]|l_sw[9]|out|pad|padres|vc|vcp|vdd|vddr|vip|vss|z
+ sg13_lv_nmos L=0.13u W=4u AS=0.835p AD=0.835p PS=7.84u PD=7.84u rfmode=0
M$1590
+ BOTTOM|TOP|VGND|VSS|anode|cathode|core|h_sw[0]|h_sw[10]|h_sw[1]|h_sw[2]|h_sw[3]|h_sw[4]|h_sw[5]|h_sw[6]|h_sw[7]|h_sw[8]|h_sw[9]|l_sw[0]|l_sw[10]|l_sw[1]|l_sw[2]|l_sw[3]|l_sw[4]|l_sw[5]|l_sw[6]|l_sw[7]|l_sw[8]|l_sw[9]|out|pad|padres|vc|vcp|vdd|vddr|vip|vss|z
+ X|in_l_sw[1]|pl_sw[1]|x
+ BOTTOM|TOP|VGND|VSS|anode|cathode|core|h_sw[0]|h_sw[10]|h_sw[1]|h_sw[2]|h_sw[3]|h_sw[4]|h_sw[5]|h_sw[6]|h_sw[7]|h_sw[8]|h_sw[9]|l_sw[0]|l_sw[10]|l_sw[1]|l_sw[2]|l_sw[3]|l_sw[4]|l_sw[5]|l_sw[6]|l_sw[7]|l_sw[8]|l_sw[9]|out|pad|padres|vc|vcp|vdd|vddr|vip|vss|z
+ BOTTOM|TOP|VGND|VSS|anode|cathode|core|h_sw[0]|h_sw[10]|h_sw[1]|h_sw[2]|h_sw[3]|h_sw[4]|h_sw[5]|h_sw[6]|h_sw[7]|h_sw[8]|h_sw[9]|l_sw[0]|l_sw[10]|l_sw[1]|l_sw[2]|l_sw[3]|l_sw[4]|l_sw[5]|l_sw[6]|l_sw[7]|l_sw[8]|l_sw[9]|out|pad|padres|vc|vcp|vdd|vddr|vip|vss|z
+ sg13_lv_nmos L=0.13u W=8u AS=1.595p AD=1.595p PS=14.88u PD=14.88u rfmode=0
M$1606
+ BOTTOM|TOP|VGND|VSS|anode|cathode|core|h_sw[0]|h_sw[10]|h_sw[1]|h_sw[2]|h_sw[3]|h_sw[4]|h_sw[5]|h_sw[6]|h_sw[7]|h_sw[8]|h_sw[9]|l_sw[0]|l_sw[10]|l_sw[1]|l_sw[2]|l_sw[3]|l_sw[4]|l_sw[5]|l_sw[6]|l_sw[7]|l_sw[8]|l_sw[9]|out|pad|padres|vc|vcp|vdd|vddr|vip|vss|z
+ X|in_h_sw[1]|ph_sw[1]|x
+ BOTTOM|TOP|VGND|VSS|anode|cathode|core|h_sw[0]|h_sw[10]|h_sw[1]|h_sw[2]|h_sw[3]|h_sw[4]|h_sw[5]|h_sw[6]|h_sw[7]|h_sw[8]|h_sw[9]|l_sw[0]|l_sw[10]|l_sw[1]|l_sw[2]|l_sw[3]|l_sw[4]|l_sw[5]|l_sw[6]|l_sw[7]|l_sw[8]|l_sw[9]|out|pad|padres|vc|vcp|vdd|vddr|vip|vss|z
+ BOTTOM|TOP|VGND|VSS|anode|cathode|core|h_sw[0]|h_sw[10]|h_sw[1]|h_sw[2]|h_sw[3]|h_sw[4]|h_sw[5]|h_sw[6]|h_sw[7]|h_sw[8]|h_sw[9]|l_sw[0]|l_sw[10]|l_sw[1]|l_sw[2]|l_sw[3]|l_sw[4]|l_sw[5]|l_sw[6]|l_sw[7]|l_sw[8]|l_sw[9]|out|pad|padres|vc|vcp|vdd|vddr|vip|vss|z
+ sg13_lv_nmos L=0.13u W=8u AS=1.595p AD=1.595p PS=14.88u PD=14.88u rfmode=0
M$1622
+ BOTTOM|TOP|VGND|VSS|anode|cathode|core|h_sw[0]|h_sw[10]|h_sw[1]|h_sw[2]|h_sw[3]|h_sw[4]|h_sw[5]|h_sw[6]|h_sw[7]|h_sw[8]|h_sw[9]|l_sw[0]|l_sw[10]|l_sw[1]|l_sw[2]|l_sw[3]|l_sw[4]|l_sw[5]|l_sw[6]|l_sw[7]|l_sw[8]|l_sw[9]|out|pad|padres|vc|vcp|vdd|vddr|vip|vss|z
+ X|in_l_sw[2]|pl_sw[2]|x
+ BOTTOM|TOP|VGND|VSS|anode|cathode|core|h_sw[0]|h_sw[10]|h_sw[1]|h_sw[2]|h_sw[3]|h_sw[4]|h_sw[5]|h_sw[6]|h_sw[7]|h_sw[8]|h_sw[9]|l_sw[0]|l_sw[10]|l_sw[1]|l_sw[2]|l_sw[3]|l_sw[4]|l_sw[5]|l_sw[6]|l_sw[7]|l_sw[8]|l_sw[9]|out|pad|padres|vc|vcp|vdd|vddr|vip|vss|z
+ BOTTOM|TOP|VGND|VSS|anode|cathode|core|h_sw[0]|h_sw[10]|h_sw[1]|h_sw[2]|h_sw[3]|h_sw[4]|h_sw[5]|h_sw[6]|h_sw[7]|h_sw[8]|h_sw[9]|l_sw[0]|l_sw[10]|l_sw[1]|l_sw[2]|l_sw[3]|l_sw[4]|l_sw[5]|l_sw[6]|l_sw[7]|l_sw[8]|l_sw[9]|out|pad|padres|vc|vcp|vdd|vddr|vip|vss|z
+ sg13_lv_nmos L=0.13u W=8u AS=1.595p AD=1.595p PS=14.88u PD=14.88u rfmode=0
M$1638
+ BOTTOM|TOP|VGND|VSS|anode|cathode|core|h_sw[0]|h_sw[10]|h_sw[1]|h_sw[2]|h_sw[3]|h_sw[4]|h_sw[5]|h_sw[6]|h_sw[7]|h_sw[8]|h_sw[9]|l_sw[0]|l_sw[10]|l_sw[1]|l_sw[2]|l_sw[3]|l_sw[4]|l_sw[5]|l_sw[6]|l_sw[7]|l_sw[8]|l_sw[9]|out|pad|padres|vc|vcp|vdd|vddr|vip|vss|z
+ X|in_h_sw[2]|ph_sw[2]|x
+ BOTTOM|TOP|VGND|VSS|anode|cathode|core|h_sw[0]|h_sw[10]|h_sw[1]|h_sw[2]|h_sw[3]|h_sw[4]|h_sw[5]|h_sw[6]|h_sw[7]|h_sw[8]|h_sw[9]|l_sw[0]|l_sw[10]|l_sw[1]|l_sw[2]|l_sw[3]|l_sw[4]|l_sw[5]|l_sw[6]|l_sw[7]|l_sw[8]|l_sw[9]|out|pad|padres|vc|vcp|vdd|vddr|vip|vss|z
+ BOTTOM|TOP|VGND|VSS|anode|cathode|core|h_sw[0]|h_sw[10]|h_sw[1]|h_sw[2]|h_sw[3]|h_sw[4]|h_sw[5]|h_sw[6]|h_sw[7]|h_sw[8]|h_sw[9]|l_sw[0]|l_sw[10]|l_sw[1]|l_sw[2]|l_sw[3]|l_sw[4]|l_sw[5]|l_sw[6]|l_sw[7]|l_sw[8]|l_sw[9]|out|pad|padres|vc|vcp|vdd|vddr|vip|vss|z
+ sg13_lv_nmos L=0.13u W=8u AS=1.595p AD=1.595p PS=14.88u PD=14.88u rfmode=0
M$1654
+ BOTTOM|TOP|VGND|VSS|anode|cathode|core|h_sw[0]|h_sw[10]|h_sw[1]|h_sw[2]|h_sw[3]|h_sw[4]|h_sw[5]|h_sw[6]|h_sw[7]|h_sw[8]|h_sw[9]|l_sw[0]|l_sw[10]|l_sw[1]|l_sw[2]|l_sw[3]|l_sw[4]|l_sw[5]|l_sw[6]|l_sw[7]|l_sw[8]|l_sw[9]|out|pad|padres|vc|vcp|vdd|vddr|vip|vss|z
+ X|in_h_sw[6]|ph_sw[6]|x
+ BOTTOM|TOP|VGND|VSS|anode|cathode|core|h_sw[0]|h_sw[10]|h_sw[1]|h_sw[2]|h_sw[3]|h_sw[4]|h_sw[5]|h_sw[6]|h_sw[7]|h_sw[8]|h_sw[9]|l_sw[0]|l_sw[10]|l_sw[1]|l_sw[2]|l_sw[3]|l_sw[4]|l_sw[5]|l_sw[6]|l_sw[7]|l_sw[8]|l_sw[9]|out|pad|padres|vc|vcp|vdd|vddr|vip|vss|z
+ BOTTOM|TOP|VGND|VSS|anode|cathode|core|h_sw[0]|h_sw[10]|h_sw[1]|h_sw[2]|h_sw[3]|h_sw[4]|h_sw[5]|h_sw[6]|h_sw[7]|h_sw[8]|h_sw[9]|l_sw[0]|l_sw[10]|l_sw[1]|l_sw[2]|l_sw[3]|l_sw[4]|l_sw[5]|l_sw[6]|l_sw[7]|l_sw[8]|l_sw[9]|out|pad|padres|vc|vcp|vdd|vddr|vip|vss|z
+ sg13_lv_nmos L=0.13u W=2u AS=0.455p AD=0.455p PS=4.32u PD=4.32u rfmode=0
M$1658
+ BOTTOM|TOP|VGND|VSS|anode|cathode|core|h_sw[0]|h_sw[10]|h_sw[1]|h_sw[2]|h_sw[3]|h_sw[4]|h_sw[5]|h_sw[6]|h_sw[7]|h_sw[8]|h_sw[9]|l_sw[0]|l_sw[10]|l_sw[1]|l_sw[2]|l_sw[3]|l_sw[4]|l_sw[5]|l_sw[6]|l_sw[7]|l_sw[8]|l_sw[9]|out|pad|padres|vc|vcp|vdd|vddr|vip|vss|z
+ X|in_h_sw[7]|ph_sw[7]|x
+ BOTTOM|TOP|VGND|VSS|anode|cathode|core|h_sw[0]|h_sw[10]|h_sw[1]|h_sw[2]|h_sw[3]|h_sw[4]|h_sw[5]|h_sw[6]|h_sw[7]|h_sw[8]|h_sw[9]|l_sw[0]|l_sw[10]|l_sw[1]|l_sw[2]|l_sw[3]|l_sw[4]|l_sw[5]|l_sw[6]|l_sw[7]|l_sw[8]|l_sw[9]|out|pad|padres|vc|vcp|vdd|vddr|vip|vss|z
+ BOTTOM|TOP|VGND|VSS|anode|cathode|core|h_sw[0]|h_sw[10]|h_sw[1]|h_sw[2]|h_sw[3]|h_sw[4]|h_sw[5]|h_sw[6]|h_sw[7]|h_sw[8]|h_sw[9]|l_sw[0]|l_sw[10]|l_sw[1]|l_sw[2]|l_sw[3]|l_sw[4]|l_sw[5]|l_sw[6]|l_sw[7]|l_sw[8]|l_sw[9]|out|pad|padres|vc|vcp|vdd|vddr|vip|vss|z
+ sg13_lv_nmos L=0.13u W=2u AS=0.455p AD=0.455p PS=4.32u PD=4.32u rfmode=0
M$1662
+ BOTTOM|TOP|VGND|VSS|anode|cathode|core|h_sw[0]|h_sw[10]|h_sw[1]|h_sw[2]|h_sw[3]|h_sw[4]|h_sw[5]|h_sw[6]|h_sw[7]|h_sw[8]|h_sw[9]|l_sw[0]|l_sw[10]|l_sw[1]|l_sw[2]|l_sw[3]|l_sw[4]|l_sw[5]|l_sw[6]|l_sw[7]|l_sw[8]|l_sw[9]|out|pad|padres|vc|vcp|vdd|vddr|vip|vss|z
+ X|in_h_sw[8]|ph_sw[8]|x
+ BOTTOM|TOP|VGND|VSS|anode|cathode|core|h_sw[0]|h_sw[10]|h_sw[1]|h_sw[2]|h_sw[3]|h_sw[4]|h_sw[5]|h_sw[6]|h_sw[7]|h_sw[8]|h_sw[9]|l_sw[0]|l_sw[10]|l_sw[1]|l_sw[2]|l_sw[3]|l_sw[4]|l_sw[5]|l_sw[6]|l_sw[7]|l_sw[8]|l_sw[9]|out|pad|padres|vc|vcp|vdd|vddr|vip|vss|z
+ BOTTOM|TOP|VGND|VSS|anode|cathode|core|h_sw[0]|h_sw[10]|h_sw[1]|h_sw[2]|h_sw[3]|h_sw[4]|h_sw[5]|h_sw[6]|h_sw[7]|h_sw[8]|h_sw[9]|l_sw[0]|l_sw[10]|l_sw[1]|l_sw[2]|l_sw[3]|l_sw[4]|l_sw[5]|l_sw[6]|l_sw[7]|l_sw[8]|l_sw[9]|out|pad|padres|vc|vcp|vdd|vddr|vip|vss|z
+ sg13_lv_nmos L=0.13u W=1u AS=0.265p AD=0.265p PS=2.56u PD=2.56u rfmode=0
M$1664
+ BOTTOM|TOP|VGND|VSS|anode|cathode|core|h_sw[0]|h_sw[10]|h_sw[1]|h_sw[2]|h_sw[3]|h_sw[4]|h_sw[5]|h_sw[6]|h_sw[7]|h_sw[8]|h_sw[9]|l_sw[0]|l_sw[10]|l_sw[1]|l_sw[2]|l_sw[3]|l_sw[4]|l_sw[5]|l_sw[6]|l_sw[7]|l_sw[8]|l_sw[9]|out|pad|padres|vc|vcp|vdd|vddr|vip|vss|z
+ X|in_h_sw[9]|ph_sw[9]|x
+ BOTTOM|TOP|VGND|VSS|anode|cathode|core|h_sw[0]|h_sw[10]|h_sw[1]|h_sw[2]|h_sw[3]|h_sw[4]|h_sw[5]|h_sw[6]|h_sw[7]|h_sw[8]|h_sw[9]|l_sw[0]|l_sw[10]|l_sw[1]|l_sw[2]|l_sw[3]|l_sw[4]|l_sw[5]|l_sw[6]|l_sw[7]|l_sw[8]|l_sw[9]|out|pad|padres|vc|vcp|vdd|vddr|vip|vss|z
+ BOTTOM|TOP|VGND|VSS|anode|cathode|core|h_sw[0]|h_sw[10]|h_sw[1]|h_sw[2]|h_sw[3]|h_sw[4]|h_sw[5]|h_sw[6]|h_sw[7]|h_sw[8]|h_sw[9]|l_sw[0]|l_sw[10]|l_sw[1]|l_sw[2]|l_sw[3]|l_sw[4]|l_sw[5]|l_sw[6]|l_sw[7]|l_sw[8]|l_sw[9]|out|pad|padres|vc|vcp|vdd|vddr|vip|vss|z
+ sg13_lv_nmos L=0.13u W=1u AS=0.265p AD=0.265p PS=2.56u PD=2.56u rfmode=0
M$1666
+ BOTTOM|TOP|VGND|VSS|anode|cathode|core|h_sw[0]|h_sw[10]|h_sw[1]|h_sw[2]|h_sw[3]|h_sw[4]|h_sw[5]|h_sw[6]|h_sw[7]|h_sw[8]|h_sw[9]|l_sw[0]|l_sw[10]|l_sw[1]|l_sw[2]|l_sw[3]|l_sw[4]|l_sw[5]|l_sw[6]|l_sw[7]|l_sw[8]|l_sw[9]|out|pad|padres|vc|vcp|vdd|vddr|vip|vss|z
+ X|in_l_sw[3]|pl_sw[3]|x
+ BOTTOM|TOP|VGND|VSS|anode|cathode|core|h_sw[0]|h_sw[10]|h_sw[1]|h_sw[2]|h_sw[3]|h_sw[4]|h_sw[5]|h_sw[6]|h_sw[7]|h_sw[8]|h_sw[9]|l_sw[0]|l_sw[10]|l_sw[1]|l_sw[2]|l_sw[3]|l_sw[4]|l_sw[5]|l_sw[6]|l_sw[7]|l_sw[8]|l_sw[9]|out|pad|padres|vc|vcp|vdd|vddr|vip|vss|z
+ BOTTOM|TOP|VGND|VSS|anode|cathode|core|h_sw[0]|h_sw[10]|h_sw[1]|h_sw[2]|h_sw[3]|h_sw[4]|h_sw[5]|h_sw[6]|h_sw[7]|h_sw[8]|h_sw[9]|l_sw[0]|l_sw[10]|l_sw[1]|l_sw[2]|l_sw[3]|l_sw[4]|l_sw[5]|l_sw[6]|l_sw[7]|l_sw[8]|l_sw[9]|out|pad|padres|vc|vcp|vdd|vddr|vip|vss|z
+ sg13_lv_nmos L=0.13u W=4u AS=0.835p AD=0.835p PS=7.84u PD=7.84u rfmode=0
M$1674
+ BOTTOM|TOP|VGND|VSS|anode|cathode|core|h_sw[0]|h_sw[10]|h_sw[1]|h_sw[2]|h_sw[3]|h_sw[4]|h_sw[5]|h_sw[6]|h_sw[7]|h_sw[8]|h_sw[9]|l_sw[0]|l_sw[10]|l_sw[1]|l_sw[2]|l_sw[3]|l_sw[4]|l_sw[5]|l_sw[6]|l_sw[7]|l_sw[8]|l_sw[9]|out|pad|padres|vc|vcp|vdd|vddr|vip|vss|z
+ X|in_l_sw[4]|pl_sw[4]|x
+ BOTTOM|TOP|VGND|VSS|anode|cathode|core|h_sw[0]|h_sw[10]|h_sw[1]|h_sw[2]|h_sw[3]|h_sw[4]|h_sw[5]|h_sw[6]|h_sw[7]|h_sw[8]|h_sw[9]|l_sw[0]|l_sw[10]|l_sw[1]|l_sw[2]|l_sw[3]|l_sw[4]|l_sw[5]|l_sw[6]|l_sw[7]|l_sw[8]|l_sw[9]|out|pad|padres|vc|vcp|vdd|vddr|vip|vss|z
+ BOTTOM|TOP|VGND|VSS|anode|cathode|core|h_sw[0]|h_sw[10]|h_sw[1]|h_sw[2]|h_sw[3]|h_sw[4]|h_sw[5]|h_sw[6]|h_sw[7]|h_sw[8]|h_sw[9]|l_sw[0]|l_sw[10]|l_sw[1]|l_sw[2]|l_sw[3]|l_sw[4]|l_sw[5]|l_sw[6]|l_sw[7]|l_sw[8]|l_sw[9]|out|pad|padres|vc|vcp|vdd|vddr|vip|vss|z
+ sg13_lv_nmos L=0.13u W=4u AS=0.835p AD=0.835p PS=7.84u PD=7.84u rfmode=0
M$1682
+ BOTTOM|TOP|VGND|VSS|anode|cathode|core|h_sw[0]|h_sw[10]|h_sw[1]|h_sw[2]|h_sw[3]|h_sw[4]|h_sw[5]|h_sw[6]|h_sw[7]|h_sw[8]|h_sw[9]|l_sw[0]|l_sw[10]|l_sw[1]|l_sw[2]|l_sw[3]|l_sw[4]|l_sw[5]|l_sw[6]|l_sw[7]|l_sw[8]|l_sw[9]|out|pad|padres|vc|vcp|vdd|vddr|vip|vss|z
+ X|in_l_sw[5]|pl_sw[5]|x
+ BOTTOM|TOP|VGND|VSS|anode|cathode|core|h_sw[0]|h_sw[10]|h_sw[1]|h_sw[2]|h_sw[3]|h_sw[4]|h_sw[5]|h_sw[6]|h_sw[7]|h_sw[8]|h_sw[9]|l_sw[0]|l_sw[10]|l_sw[1]|l_sw[2]|l_sw[3]|l_sw[4]|l_sw[5]|l_sw[6]|l_sw[7]|l_sw[8]|l_sw[9]|out|pad|padres|vc|vcp|vdd|vddr|vip|vss|z
+ BOTTOM|TOP|VGND|VSS|anode|cathode|core|h_sw[0]|h_sw[10]|h_sw[1]|h_sw[2]|h_sw[3]|h_sw[4]|h_sw[5]|h_sw[6]|h_sw[7]|h_sw[8]|h_sw[9]|l_sw[0]|l_sw[10]|l_sw[1]|l_sw[2]|l_sw[3]|l_sw[4]|l_sw[5]|l_sw[6]|l_sw[7]|l_sw[8]|l_sw[9]|out|pad|padres|vc|vcp|vdd|vddr|vip|vss|z
+ sg13_lv_nmos L=0.13u W=4u AS=0.835p AD=0.835p PS=7.84u PD=7.84u rfmode=0
M$1690
+ BOTTOM|TOP|VGND|VSS|anode|cathode|core|h_sw[0]|h_sw[10]|h_sw[1]|h_sw[2]|h_sw[3]|h_sw[4]|h_sw[5]|h_sw[6]|h_sw[7]|h_sw[8]|h_sw[9]|l_sw[0]|l_sw[10]|l_sw[1]|l_sw[2]|l_sw[3]|l_sw[4]|l_sw[5]|l_sw[6]|l_sw[7]|l_sw[8]|l_sw[9]|out|pad|padres|vc|vcp|vdd|vddr|vip|vss|z
+ X|in_h_sw[10]|ph_sw[10]|x
+ BOTTOM|TOP|VGND|VSS|anode|cathode|core|h_sw[0]|h_sw[10]|h_sw[1]|h_sw[2]|h_sw[3]|h_sw[4]|h_sw[5]|h_sw[6]|h_sw[7]|h_sw[8]|h_sw[9]|l_sw[0]|l_sw[10]|l_sw[1]|l_sw[2]|l_sw[3]|l_sw[4]|l_sw[5]|l_sw[6]|l_sw[7]|l_sw[8]|l_sw[9]|out|pad|padres|vc|vcp|vdd|vddr|vip|vss|z
+ BOTTOM|TOP|VGND|VSS|anode|cathode|core|h_sw[0]|h_sw[10]|h_sw[1]|h_sw[2]|h_sw[3]|h_sw[4]|h_sw[5]|h_sw[6]|h_sw[7]|h_sw[8]|h_sw[9]|l_sw[0]|l_sw[10]|l_sw[1]|l_sw[2]|l_sw[3]|l_sw[4]|l_sw[5]|l_sw[6]|l_sw[7]|l_sw[8]|l_sw[9]|out|pad|padres|vc|vcp|vdd|vddr|vip|vss|z
+ sg13_lv_nmos L=0.13u W=0.5u AS=0.17p AD=0.17p PS=1.68u PD=1.68u rfmode=0
M$1691
+ BOTTOM|TOP|VGND|VSS|anode|cathode|core|h_sw[0]|h_sw[10]|h_sw[1]|h_sw[2]|h_sw[3]|h_sw[4]|h_sw[5]|h_sw[6]|h_sw[7]|h_sw[8]|h_sw[9]|l_sw[0]|l_sw[10]|l_sw[1]|l_sw[2]|l_sw[3]|l_sw[4]|l_sw[5]|l_sw[6]|l_sw[7]|l_sw[8]|l_sw[9]|out|pad|padres|vc|vcp|vdd|vddr|vip|vss|z
+ X|in_l_sw[7]|pl_sw[7]|x
+ BOTTOM|TOP|VGND|VSS|anode|cathode|core|h_sw[0]|h_sw[10]|h_sw[1]|h_sw[2]|h_sw[3]|h_sw[4]|h_sw[5]|h_sw[6]|h_sw[7]|h_sw[8]|h_sw[9]|l_sw[0]|l_sw[10]|l_sw[1]|l_sw[2]|l_sw[3]|l_sw[4]|l_sw[5]|l_sw[6]|l_sw[7]|l_sw[8]|l_sw[9]|out|pad|padres|vc|vcp|vdd|vddr|vip|vss|z
+ BOTTOM|TOP|VGND|VSS|anode|cathode|core|h_sw[0]|h_sw[10]|h_sw[1]|h_sw[2]|h_sw[3]|h_sw[4]|h_sw[5]|h_sw[6]|h_sw[7]|h_sw[8]|h_sw[9]|l_sw[0]|l_sw[10]|l_sw[1]|l_sw[2]|l_sw[3]|l_sw[4]|l_sw[5]|l_sw[6]|l_sw[7]|l_sw[8]|l_sw[9]|out|pad|padres|vc|vcp|vdd|vddr|vip|vss|z
+ sg13_lv_nmos L=0.13u W=2u AS=0.455p AD=0.455p PS=4.32u PD=4.32u rfmode=0
M$1695
+ BOTTOM|TOP|VGND|VSS|anode|cathode|core|h_sw[0]|h_sw[10]|h_sw[1]|h_sw[2]|h_sw[3]|h_sw[4]|h_sw[5]|h_sw[6]|h_sw[7]|h_sw[8]|h_sw[9]|l_sw[0]|l_sw[10]|l_sw[1]|l_sw[2]|l_sw[3]|l_sw[4]|l_sw[5]|l_sw[6]|l_sw[7]|l_sw[8]|l_sw[9]|out|pad|padres|vc|vcp|vdd|vddr|vip|vss|z
+ X|in_l_sw[6]|pl_sw[6]|x
+ BOTTOM|TOP|VGND|VSS|anode|cathode|core|h_sw[0]|h_sw[10]|h_sw[1]|h_sw[2]|h_sw[3]|h_sw[4]|h_sw[5]|h_sw[6]|h_sw[7]|h_sw[8]|h_sw[9]|l_sw[0]|l_sw[10]|l_sw[1]|l_sw[2]|l_sw[3]|l_sw[4]|l_sw[5]|l_sw[6]|l_sw[7]|l_sw[8]|l_sw[9]|out|pad|padres|vc|vcp|vdd|vddr|vip|vss|z
+ BOTTOM|TOP|VGND|VSS|anode|cathode|core|h_sw[0]|h_sw[10]|h_sw[1]|h_sw[2]|h_sw[3]|h_sw[4]|h_sw[5]|h_sw[6]|h_sw[7]|h_sw[8]|h_sw[9]|l_sw[0]|l_sw[10]|l_sw[1]|l_sw[2]|l_sw[3]|l_sw[4]|l_sw[5]|l_sw[6]|l_sw[7]|l_sw[8]|l_sw[9]|out|pad|padres|vc|vcp|vdd|vddr|vip|vss|z
+ sg13_lv_nmos L=0.13u W=2u AS=0.455p AD=0.455p PS=4.32u PD=4.32u rfmode=0
M$1699
+ BOTTOM|TOP|VGND|VSS|anode|cathode|core|h_sw[0]|h_sw[10]|h_sw[1]|h_sw[2]|h_sw[3]|h_sw[4]|h_sw[5]|h_sw[6]|h_sw[7]|h_sw[8]|h_sw[9]|l_sw[0]|l_sw[10]|l_sw[1]|l_sw[2]|l_sw[3]|l_sw[4]|l_sw[5]|l_sw[6]|l_sw[7]|l_sw[8]|l_sw[9]|out|pad|padres|vc|vcp|vdd|vddr|vip|vss|z
+ X|in_l_sw[8]|pl_sw[8]|x
+ BOTTOM|TOP|VGND|VSS|anode|cathode|core|h_sw[0]|h_sw[10]|h_sw[1]|h_sw[2]|h_sw[3]|h_sw[4]|h_sw[5]|h_sw[6]|h_sw[7]|h_sw[8]|h_sw[9]|l_sw[0]|l_sw[10]|l_sw[1]|l_sw[2]|l_sw[3]|l_sw[4]|l_sw[5]|l_sw[6]|l_sw[7]|l_sw[8]|l_sw[9]|out|pad|padres|vc|vcp|vdd|vddr|vip|vss|z
+ BOTTOM|TOP|VGND|VSS|anode|cathode|core|h_sw[0]|h_sw[10]|h_sw[1]|h_sw[2]|h_sw[3]|h_sw[4]|h_sw[5]|h_sw[6]|h_sw[7]|h_sw[8]|h_sw[9]|l_sw[0]|l_sw[10]|l_sw[1]|l_sw[2]|l_sw[3]|l_sw[4]|l_sw[5]|l_sw[6]|l_sw[7]|l_sw[8]|l_sw[9]|out|pad|padres|vc|vcp|vdd|vddr|vip|vss|z
+ sg13_lv_nmos L=0.13u W=1u AS=0.265p AD=0.265p PS=2.56u PD=2.56u rfmode=0
M$1701
+ BOTTOM|TOP|VGND|VSS|anode|cathode|core|h_sw[0]|h_sw[10]|h_sw[1]|h_sw[2]|h_sw[3]|h_sw[4]|h_sw[5]|h_sw[6]|h_sw[7]|h_sw[8]|h_sw[9]|l_sw[0]|l_sw[10]|l_sw[1]|l_sw[2]|l_sw[3]|l_sw[4]|l_sw[5]|l_sw[6]|l_sw[7]|l_sw[8]|l_sw[9]|out|pad|padres|vc|vcp|vdd|vddr|vip|vss|z
+ X|in_l_sw[9]|pl_sw[9]|x
+ BOTTOM|TOP|VGND|VSS|anode|cathode|core|h_sw[0]|h_sw[10]|h_sw[1]|h_sw[2]|h_sw[3]|h_sw[4]|h_sw[5]|h_sw[6]|h_sw[7]|h_sw[8]|h_sw[9]|l_sw[0]|l_sw[10]|l_sw[1]|l_sw[2]|l_sw[3]|l_sw[4]|l_sw[5]|l_sw[6]|l_sw[7]|l_sw[8]|l_sw[9]|out|pad|padres|vc|vcp|vdd|vddr|vip|vss|z
+ BOTTOM|TOP|VGND|VSS|anode|cathode|core|h_sw[0]|h_sw[10]|h_sw[1]|h_sw[2]|h_sw[3]|h_sw[4]|h_sw[5]|h_sw[6]|h_sw[7]|h_sw[8]|h_sw[9]|l_sw[0]|l_sw[10]|l_sw[1]|l_sw[2]|l_sw[3]|l_sw[4]|l_sw[5]|l_sw[6]|l_sw[7]|l_sw[8]|l_sw[9]|out|pad|padres|vc|vcp|vdd|vddr|vip|vss|z
+ sg13_lv_nmos L=0.13u W=1u AS=0.265p AD=0.265p PS=2.56u PD=2.56u rfmode=0
M$1703
+ BOTTOM|TOP|VGND|VSS|anode|cathode|core|h_sw[0]|h_sw[10]|h_sw[1]|h_sw[2]|h_sw[3]|h_sw[4]|h_sw[5]|h_sw[6]|h_sw[7]|h_sw[8]|h_sw[9]|l_sw[0]|l_sw[10]|l_sw[1]|l_sw[2]|l_sw[3]|l_sw[4]|l_sw[5]|l_sw[6]|l_sw[7]|l_sw[8]|l_sw[9]|out|pad|padres|vc|vcp|vdd|vddr|vip|vss|z
+ X|in_l_sw[10]|pl_sw[10]|x
+ BOTTOM|TOP|VGND|VSS|anode|cathode|core|h_sw[0]|h_sw[10]|h_sw[1]|h_sw[2]|h_sw[3]|h_sw[4]|h_sw[5]|h_sw[6]|h_sw[7]|h_sw[8]|h_sw[9]|l_sw[0]|l_sw[10]|l_sw[1]|l_sw[2]|l_sw[3]|l_sw[4]|l_sw[5]|l_sw[6]|l_sw[7]|l_sw[8]|l_sw[9]|out|pad|padres|vc|vcp|vdd|vddr|vip|vss|z
+ BOTTOM|TOP|VGND|VSS|anode|cathode|core|h_sw[0]|h_sw[10]|h_sw[1]|h_sw[2]|h_sw[3]|h_sw[4]|h_sw[5]|h_sw[6]|h_sw[7]|h_sw[8]|h_sw[9]|l_sw[0]|l_sw[10]|l_sw[1]|l_sw[2]|l_sw[3]|l_sw[4]|l_sw[5]|l_sw[6]|l_sw[7]|l_sw[8]|l_sw[9]|out|pad|padres|vc|vcp|vdd|vddr|vip|vss|z
+ sg13_lv_nmos L=0.13u W=0.5u AS=0.17p AD=0.17p PS=1.68u PD=1.68u rfmode=0
M$1704 anode|guard|iovss \$26896
+ X|anode|cathode|core|d_out[0]|dout[0]|pad|padres
+ BOTTOM|TOP|VGND|VSS|anode|cathode|core|h_sw[0]|h_sw[10]|h_sw[1]|h_sw[2]|h_sw[3]|h_sw[4]|h_sw[5]|h_sw[6]|h_sw[7]|h_sw[8]|h_sw[9]|l_sw[0]|l_sw[10]|l_sw[1]|l_sw[2]|l_sw[3]|l_sw[4]|l_sw[5]|l_sw[6]|l_sw[7]|l_sw[8]|l_sw[9]|out|pad|padres|vc|vcp|vdd|vddr|vip|vss|z
+ sg13_hv_nmos L=0.6u W=88u AS=40.7p AD=40.7p PS=110.9u PD=110.9u rfmode=0
M$1724 anode|guard|iovss \$26897
+ X|anode|cathode|core|d_out[1]|dout[1]|pad|padres
+ BOTTOM|TOP|VGND|VSS|anode|cathode|core|h_sw[0]|h_sw[10]|h_sw[1]|h_sw[2]|h_sw[3]|h_sw[4]|h_sw[5]|h_sw[6]|h_sw[7]|h_sw[8]|h_sw[9]|l_sw[0]|l_sw[10]|l_sw[1]|l_sw[2]|l_sw[3]|l_sw[4]|l_sw[5]|l_sw[6]|l_sw[7]|l_sw[8]|l_sw[9]|out|pad|padres|vc|vcp|vdd|vddr|vip|vss|z
+ sg13_hv_nmos L=0.6u W=88u AS=40.7p AD=40.7p PS=110.9u PD=110.9u rfmode=0
M$1744 anode|guard|iovss \$26898
+ X|anode|cathode|core|d_out[2]|dout[2]|pad|padres
+ BOTTOM|TOP|VGND|VSS|anode|cathode|core|h_sw[0]|h_sw[10]|h_sw[1]|h_sw[2]|h_sw[3]|h_sw[4]|h_sw[5]|h_sw[6]|h_sw[7]|h_sw[8]|h_sw[9]|l_sw[0]|l_sw[10]|l_sw[1]|l_sw[2]|l_sw[3]|l_sw[4]|l_sw[5]|l_sw[6]|l_sw[7]|l_sw[8]|l_sw[9]|out|pad|padres|vc|vcp|vdd|vddr|vip|vss|z
+ sg13_hv_nmos L=0.6u W=88u AS=40.7p AD=40.7p PS=110.9u PD=110.9u rfmode=0
M$1764 anode|guard|iovss \$26899 X|anode|cathode|cko|core|pad|padres
+ BOTTOM|TOP|VGND|VSS|anode|cathode|core|h_sw[0]|h_sw[10]|h_sw[1]|h_sw[2]|h_sw[3]|h_sw[4]|h_sw[5]|h_sw[6]|h_sw[7]|h_sw[8]|h_sw[9]|l_sw[0]|l_sw[10]|l_sw[1]|l_sw[2]|l_sw[3]|l_sw[4]|l_sw[5]|l_sw[6]|l_sw[7]|l_sw[8]|l_sw[9]|out|pad|padres|vc|vcp|vdd|vddr|vip|vss|z
+ sg13_hv_nmos L=0.6u W=88u AS=40.7p AD=40.7p PS=110.9u PD=110.9u rfmode=0
M$1784 anode|guard|iovss \$26900 X|anode|cathode|core|frame|pad|padres
+ BOTTOM|TOP|VGND|VSS|anode|cathode|core|h_sw[0]|h_sw[10]|h_sw[1]|h_sw[2]|h_sw[3]|h_sw[4]|h_sw[5]|h_sw[6]|h_sw[7]|h_sw[8]|h_sw[9]|l_sw[0]|l_sw[10]|l_sw[1]|l_sw[2]|l_sw[3]|l_sw[4]|l_sw[5]|l_sw[6]|l_sw[7]|l_sw[8]|l_sw[9]|out|pad|padres|vc|vcp|vdd|vddr|vip|vss|z
+ sg13_hv_nmos L=0.6u W=88u AS=40.7p AD=40.7p PS=110.9u PD=110.9u rfmode=0
M$1804 anode|guard|iovss \$51948
+ BOTTOM|TOP|VGND|VSS|anode|cathode|core|h_sw[0]|h_sw[10]|h_sw[1]|h_sw[2]|h_sw[3]|h_sw[4]|h_sw[5]|h_sw[6]|h_sw[7]|h_sw[8]|h_sw[9]|l_sw[0]|l_sw[10]|l_sw[1]|l_sw[2]|l_sw[3]|l_sw[4]|l_sw[5]|l_sw[6]|l_sw[7]|l_sw[8]|l_sw[9]|out|pad|padres|vc|vcp|vdd|vddr|vip|vss|z
+ BOTTOM|TOP|VGND|VSS|anode|cathode|core|h_sw[0]|h_sw[10]|h_sw[1]|h_sw[2]|h_sw[3]|h_sw[4]|h_sw[5]|h_sw[6]|h_sw[7]|h_sw[8]|h_sw[9]|l_sw[0]|l_sw[10]|l_sw[1]|l_sw[2]|l_sw[3]|l_sw[4]|l_sw[5]|l_sw[6]|l_sw[7]|l_sw[8]|l_sw[9]|out|pad|padres|vc|vcp|vdd|vddr|vip|vss|z
+ sg13_hv_nmos L=0.6u W=88u AS=40.7p AD=40.7p PS=110.9u PD=110.9u rfmode=0
M$1824 anode|guard|iovss \$51951 anode|cathode|core|pad|padres
+ BOTTOM|TOP|VGND|VSS|anode|cathode|core|h_sw[0]|h_sw[10]|h_sw[1]|h_sw[2]|h_sw[3]|h_sw[4]|h_sw[5]|h_sw[6]|h_sw[7]|h_sw[8]|h_sw[9]|l_sw[0]|l_sw[10]|l_sw[1]|l_sw[2]|l_sw[3]|l_sw[4]|l_sw[5]|l_sw[6]|l_sw[7]|l_sw[8]|l_sw[9]|out|pad|padres|vc|vcp|vdd|vddr|vip|vss|z
+ sg13_hv_nmos L=0.6u W=88u AS=40.7p AD=40.7p PS=110.9u PD=110.9u rfmode=0
M$1844 anode|guard|iovss \$62225 anode|cathode|core|in|pad|padres|vin
+ BOTTOM|TOP|VGND|VSS|anode|cathode|core|h_sw[0]|h_sw[10]|h_sw[1]|h_sw[2]|h_sw[3]|h_sw[4]|h_sw[5]|h_sw[6]|h_sw[7]|h_sw[8]|h_sw[9]|l_sw[0]|l_sw[10]|l_sw[1]|l_sw[2]|l_sw[3]|l_sw[4]|l_sw[5]|l_sw[6]|l_sw[7]|l_sw[8]|l_sw[9]|out|pad|padres|vc|vcp|vdd|vddr|vip|vss|z
+ sg13_hv_nmos L=0.6u W=88u AS=40.7p AD=40.7p PS=110.9u PD=110.9u rfmode=0
M$1864 anode|guard|iovss \$64279 anode|cathode|core|pad|padres$1
+ BOTTOM|TOP|VGND|VSS|anode|cathode|core|h_sw[0]|h_sw[10]|h_sw[1]|h_sw[2]|h_sw[3]|h_sw[4]|h_sw[5]|h_sw[6]|h_sw[7]|h_sw[8]|h_sw[9]|l_sw[0]|l_sw[10]|l_sw[1]|l_sw[2]|l_sw[3]|l_sw[4]|l_sw[5]|l_sw[6]|l_sw[7]|l_sw[8]|l_sw[9]|out|pad|padres|vc|vcp|vdd|vddr|vip|vss|z
+ sg13_hv_nmos L=0.6u W=88u AS=40.7p AD=40.7p PS=110.9u PD=110.9u rfmode=0
M$1884 anode|guard|iovss \$77017 anode|cathode|core|in|pad|padres|vip
+ BOTTOM|TOP|VGND|VSS|anode|cathode|core|h_sw[0]|h_sw[10]|h_sw[1]|h_sw[2]|h_sw[3]|h_sw[4]|h_sw[5]|h_sw[6]|h_sw[7]|h_sw[8]|h_sw[9]|l_sw[0]|l_sw[10]|l_sw[1]|l_sw[2]|l_sw[3]|l_sw[4]|l_sw[5]|l_sw[6]|l_sw[7]|l_sw[8]|l_sw[9]|out|pad|padres|vc|vcp|vdd|vddr|vip|vss|z
+ sg13_hv_nmos L=0.6u W=88u AS=40.7p AD=40.7p PS=110.9u PD=110.9u rfmode=0
M$1904 anode|guard|iovss \$77020 anode|cathode|core|pad|padres$2
+ BOTTOM|TOP|VGND|VSS|anode|cathode|core|h_sw[0]|h_sw[10]|h_sw[1]|h_sw[2]|h_sw[3]|h_sw[4]|h_sw[5]|h_sw[6]|h_sw[7]|h_sw[8]|h_sw[9]|l_sw[0]|l_sw[10]|l_sw[1]|l_sw[2]|l_sw[3]|l_sw[4]|l_sw[5]|l_sw[6]|l_sw[7]|l_sw[8]|l_sw[9]|out|pad|padres|vc|vcp|vdd|vddr|vip|vss|z
+ sg13_hv_nmos L=0.6u W=88u AS=40.7p AD=40.7p PS=110.9u PD=110.9u rfmode=0
M$1924 anode|guard|iovss \$87182 A|anode|cathode|ck|cks|core|pad|padres
+ BOTTOM|TOP|VGND|VSS|anode|cathode|core|h_sw[0]|h_sw[10]|h_sw[1]|h_sw[2]|h_sw[3]|h_sw[4]|h_sw[5]|h_sw[6]|h_sw[7]|h_sw[8]|h_sw[9]|l_sw[0]|l_sw[10]|l_sw[1]|l_sw[2]|l_sw[3]|l_sw[4]|l_sw[5]|l_sw[6]|l_sw[7]|l_sw[8]|l_sw[9]|out|pad|padres|vc|vcp|vdd|vddr|vip|vss|z
+ sg13_hv_nmos L=0.6u W=88u AS=40.7p AD=40.7p PS=110.9u PD=110.9u rfmode=0
M$1944 anode|guard|iovss \$89388 anode|cathode|core|pad|padres$3
+ BOTTOM|TOP|VGND|VSS|anode|cathode|core|h_sw[0]|h_sw[10]|h_sw[1]|h_sw[2]|h_sw[3]|h_sw[4]|h_sw[5]|h_sw[6]|h_sw[7]|h_sw[8]|h_sw[9]|l_sw[0]|l_sw[10]|l_sw[1]|l_sw[2]|l_sw[3]|l_sw[4]|l_sw[5]|l_sw[6]|l_sw[7]|l_sw[8]|l_sw[9]|out|pad|padres|vc|vcp|vdd|vddr|vip|vss|z
+ sg13_hv_nmos L=0.6u W=88u AS=40.7p AD=40.7p PS=110.9u PD=110.9u rfmode=0
M$1964 anode|guard|iovss in|pad|pin1|pin2|vdd anode|guard|iovss
+ BOTTOM|TOP|VGND|VSS|anode|cathode|core|h_sw[0]|h_sw[10]|h_sw[1]|h_sw[2]|h_sw[3]|h_sw[4]|h_sw[5]|h_sw[6]|h_sw[7]|h_sw[8]|h_sw[9]|l_sw[0]|l_sw[10]|l_sw[1]|l_sw[2]|l_sw[3]|l_sw[4]|l_sw[5]|l_sw[6]|l_sw[7]|l_sw[8]|l_sw[9]|out|pad|padres|vc|vcp|vdd|vddr|vip|vss|z
+ sg13_hv_nmos L=9.5u W=126u AS=26.64p AD=23.94p PS=149.92u PD=131.32u rfmode=0
M$1971 anode|guard|iovss in|pad|pin1|pin2|vdd gate|out
+ BOTTOM|TOP|VGND|VSS|anode|cathode|core|h_sw[0]|h_sw[10]|h_sw[1]|h_sw[2]|h_sw[3]|h_sw[4]|h_sw[5]|h_sw[6]|h_sw[7]|h_sw[8]|h_sw[9]|l_sw[0]|l_sw[10]|l_sw[1]|l_sw[2]|l_sw[3]|l_sw[4]|l_sw[5]|l_sw[6]|l_sw[7]|l_sw[8]|l_sw[9]|out|pad|padres|vc|vcp|vdd|vddr|vip|vss|z
+ sg13_hv_nmos L=0.5u W=108u AS=20.52p AD=23.22p PS=112.56u PD=131.16u rfmode=0
M$1990 in|pad|pin1|pin2|vdd gate|out anode|guard|iovss
+ BOTTOM|TOP|VGND|VSS|anode|cathode|core|h_sw[0]|h_sw[10]|h_sw[1]|h_sw[2]|h_sw[3]|h_sw[4]|h_sw[5]|h_sw[6]|h_sw[7]|h_sw[8]|h_sw[9]|l_sw[0]|l_sw[10]|l_sw[1]|l_sw[2]|l_sw[3]|l_sw[4]|l_sw[5]|l_sw[6]|l_sw[7]|l_sw[8]|l_sw[9]|out|pad|padres|vc|vcp|vdd|vddr|vip|vss|z
+ sg13_hv_nmos L=0.6u W=756.8u AS=349.36p AD=344.608p PS=933.2u PD=931.04u
+ rfmode=0
M$2162 anode|guard|iovss \$132615 anode|cathode|core|pad|padres$4
+ BOTTOM|TOP|VGND|VSS|anode|cathode|core|h_sw[0]|h_sw[10]|h_sw[1]|h_sw[2]|h_sw[3]|h_sw[4]|h_sw[5]|h_sw[6]|h_sw[7]|h_sw[8]|h_sw[9]|l_sw[0]|l_sw[10]|l_sw[1]|l_sw[2]|l_sw[3]|l_sw[4]|l_sw[5]|l_sw[6]|l_sw[7]|l_sw[8]|l_sw[9]|out|pad|padres|vc|vcp|vdd|vddr|vip|vss|z
+ sg13_hv_nmos L=0.6u W=88u AS=40.7p AD=40.7p PS=110.9u PD=110.9u rfmode=0
M$2182 anode|guard|iovss \$132616 anode|cathode|core|pad|padres$5
+ BOTTOM|TOP|VGND|VSS|anode|cathode|core|h_sw[0]|h_sw[10]|h_sw[1]|h_sw[2]|h_sw[3]|h_sw[4]|h_sw[5]|h_sw[6]|h_sw[7]|h_sw[8]|h_sw[9]|l_sw[0]|l_sw[10]|l_sw[1]|l_sw[2]|l_sw[3]|l_sw[4]|l_sw[5]|l_sw[6]|l_sw[7]|l_sw[8]|l_sw[9]|out|pad|padres|vc|vcp|vdd|vddr|vip|vss|z
+ sg13_hv_nmos L=0.6u W=88u AS=40.7p AD=40.7p PS=110.9u PD=110.9u rfmode=0
M$2202 anode|guard|iovss \$132617 anode|cathode|core|pad|padres$6
+ BOTTOM|TOP|VGND|VSS|anode|cathode|core|h_sw[0]|h_sw[10]|h_sw[1]|h_sw[2]|h_sw[3]|h_sw[4]|h_sw[5]|h_sw[6]|h_sw[7]|h_sw[8]|h_sw[9]|l_sw[0]|l_sw[10]|l_sw[1]|l_sw[2]|l_sw[3]|l_sw[4]|l_sw[5]|l_sw[6]|l_sw[7]|l_sw[8]|l_sw[9]|out|pad|padres|vc|vcp|vdd|vddr|vip|vss|z
+ sg13_hv_nmos L=0.6u W=88u AS=40.7p AD=40.7p PS=110.9u PD=110.9u rfmode=0
M$2222 anode|guard|iovss \$132618 anode|cathode|core|pad|padres$7
+ BOTTOM|TOP|VGND|VSS|anode|cathode|core|h_sw[0]|h_sw[10]|h_sw[1]|h_sw[2]|h_sw[3]|h_sw[4]|h_sw[5]|h_sw[6]|h_sw[7]|h_sw[8]|h_sw[9]|l_sw[0]|l_sw[10]|l_sw[1]|l_sw[2]|l_sw[3]|l_sw[4]|l_sw[5]|l_sw[6]|l_sw[7]|l_sw[8]|l_sw[9]|out|pad|padres|vc|vcp|vdd|vddr|vip|vss|z
+ sg13_hv_nmos L=0.6u W=88u AS=40.7p AD=40.7p PS=110.9u PD=110.9u rfmode=0
M$2242 anode|guard|iovss \$132619 anode|cathode|core|pad|padres$8
+ BOTTOM|TOP|VGND|VSS|anode|cathode|core|h_sw[0]|h_sw[10]|h_sw[1]|h_sw[2]|h_sw[3]|h_sw[4]|h_sw[5]|h_sw[6]|h_sw[7]|h_sw[8]|h_sw[9]|l_sw[0]|l_sw[10]|l_sw[1]|l_sw[2]|l_sw[3]|l_sw[4]|l_sw[5]|l_sw[6]|l_sw[7]|l_sw[8]|l_sw[9]|out|pad|padres|vc|vcp|vdd|vddr|vip|vss|z
+ sg13_hv_nmos L=0.6u W=88u AS=40.7p AD=40.7p PS=110.9u PD=110.9u rfmode=0
M$2262
+ BOTTOM|TOP|VGND|VSS|anode|cathode|core|h_sw[0]|h_sw[10]|h_sw[1]|h_sw[2]|h_sw[3]|h_sw[4]|h_sw[5]|h_sw[6]|h_sw[7]|h_sw[8]|h_sw[9]|l_sw[0]|l_sw[10]|l_sw[1]|l_sw[2]|l_sw[3]|l_sw[4]|l_sw[5]|l_sw[6]|l_sw[7]|l_sw[8]|l_sw[9]|out|pad|padres|vc|vcp|vdd|vddr|vip|vss|z
+ X|in_l_sw[0]|nl_sw[0]|x
+ BOTTOM|TOP|VGND|VSS|anode|cathode|core|h_sw[0]|h_sw[10]|h_sw[1]|h_sw[2]|h_sw[3]|h_sw[4]|h_sw[5]|h_sw[6]|h_sw[7]|h_sw[8]|h_sw[9]|l_sw[0]|l_sw[10]|l_sw[1]|l_sw[2]|l_sw[3]|l_sw[4]|l_sw[5]|l_sw[6]|l_sw[7]|l_sw[8]|l_sw[9]|out|pad|padres|vc|vcp|vdd|vddr|vip|vss|z
+ \$64988 sg13_lv_pmos L=0.13u W=32u AS=6.23p AD=6.23p PS=45.46u PD=45.46u
+ rfmode=0
M$2294
+ BOTTOM|TOP|VGND|VSS|anode|cathode|core|h_sw[0]|h_sw[10]|h_sw[1]|h_sw[2]|h_sw[3]|h_sw[4]|h_sw[5]|h_sw[6]|h_sw[7]|h_sw[8]|h_sw[9]|l_sw[0]|l_sw[10]|l_sw[1]|l_sw[2]|l_sw[3]|l_sw[4]|l_sw[5]|l_sw[6]|l_sw[7]|l_sw[8]|l_sw[9]|out|pad|padres|vc|vcp|vdd|vddr|vip|vss|z
+ X|in_h_sw[0]|nh_sw[0]|x
+ BOTTOM|TOP|VGND|VSS|anode|cathode|core|h_sw[0]|h_sw[10]|h_sw[1]|h_sw[2]|h_sw[3]|h_sw[4]|h_sw[5]|h_sw[6]|h_sw[7]|h_sw[8]|h_sw[9]|l_sw[0]|l_sw[10]|l_sw[1]|l_sw[2]|l_sw[3]|l_sw[4]|l_sw[5]|l_sw[6]|l_sw[7]|l_sw[8]|l_sw[9]|out|pad|padres|vc|vcp|vdd|vddr|vip|vss|z
+ \$64988 sg13_lv_pmos L=0.13u W=32u AS=6.23p AD=6.23p PS=45.46u PD=45.46u
+ rfmode=0
M$2326
+ BOTTOM|TOP|VGND|VSS|anode|cathode|core|h_sw[0]|h_sw[10]|h_sw[1]|h_sw[2]|h_sw[3]|h_sw[4]|h_sw[5]|h_sw[6]|h_sw[7]|h_sw[8]|h_sw[9]|l_sw[0]|l_sw[10]|l_sw[1]|l_sw[2]|l_sw[3]|l_sw[4]|l_sw[5]|l_sw[6]|l_sw[7]|l_sw[8]|l_sw[9]|out|pad|padres|vc|vcp|vdd|vddr|vip|vss|z
+ X|in_l_sw[1]|nl_sw[1]|x
+ BOTTOM|TOP|VGND|VSS|anode|cathode|core|h_sw[0]|h_sw[10]|h_sw[1]|h_sw[2]|h_sw[3]|h_sw[4]|h_sw[5]|h_sw[6]|h_sw[7]|h_sw[8]|h_sw[9]|l_sw[0]|l_sw[10]|l_sw[1]|l_sw[2]|l_sw[3]|l_sw[4]|l_sw[5]|l_sw[6]|l_sw[7]|l_sw[8]|l_sw[9]|out|pad|padres|vc|vcp|vdd|vddr|vip|vss|z
+ \$64989 sg13_lv_pmos L=0.13u W=16u AS=3.19p AD=3.19p PS=23.38u PD=23.38u
+ rfmode=0
M$2342
+ BOTTOM|TOP|VGND|VSS|anode|cathode|core|h_sw[0]|h_sw[10]|h_sw[1]|h_sw[2]|h_sw[3]|h_sw[4]|h_sw[5]|h_sw[6]|h_sw[7]|h_sw[8]|h_sw[9]|l_sw[0]|l_sw[10]|l_sw[1]|l_sw[2]|l_sw[3]|l_sw[4]|l_sw[5]|l_sw[6]|l_sw[7]|l_sw[8]|l_sw[9]|out|pad|padres|vc|vcp|vdd|vddr|vip|vss|z
+ X|in_h_sw[1]|nh_sw[1]|x
+ BOTTOM|TOP|VGND|VSS|anode|cathode|core|h_sw[0]|h_sw[10]|h_sw[1]|h_sw[2]|h_sw[3]|h_sw[4]|h_sw[5]|h_sw[6]|h_sw[7]|h_sw[8]|h_sw[9]|l_sw[0]|l_sw[10]|l_sw[1]|l_sw[2]|l_sw[3]|l_sw[4]|l_sw[5]|l_sw[6]|l_sw[7]|l_sw[8]|l_sw[9]|out|pad|padres|vc|vcp|vdd|vddr|vip|vss|z
+ \$64989 sg13_lv_pmos L=0.13u W=16u AS=3.19p AD=3.19p PS=23.38u PD=23.38u
+ rfmode=0
M$2358
+ BOTTOM|TOP|VGND|VSS|anode|cathode|core|h_sw[0]|h_sw[10]|h_sw[1]|h_sw[2]|h_sw[3]|h_sw[4]|h_sw[5]|h_sw[6]|h_sw[7]|h_sw[8]|h_sw[9]|l_sw[0]|l_sw[10]|l_sw[1]|l_sw[2]|l_sw[3]|l_sw[4]|l_sw[5]|l_sw[6]|l_sw[7]|l_sw[8]|l_sw[9]|out|pad|padres|vc|vcp|vdd|vddr|vip|vss|z
+ X|in_l_sw[2]|nl_sw[2]|x
+ BOTTOM|TOP|VGND|VSS|anode|cathode|core|h_sw[0]|h_sw[10]|h_sw[1]|h_sw[2]|h_sw[3]|h_sw[4]|h_sw[5]|h_sw[6]|h_sw[7]|h_sw[8]|h_sw[9]|l_sw[0]|l_sw[10]|l_sw[1]|l_sw[2]|l_sw[3]|l_sw[4]|l_sw[5]|l_sw[6]|l_sw[7]|l_sw[8]|l_sw[9]|out|pad|padres|vc|vcp|vdd|vddr|vip|vss|z
+ \$64990 sg13_lv_pmos L=0.13u W=16u AS=3.19p AD=3.19p PS=23.38u PD=23.38u
+ rfmode=0
M$2374
+ BOTTOM|TOP|VGND|VSS|anode|cathode|core|h_sw[0]|h_sw[10]|h_sw[1]|h_sw[2]|h_sw[3]|h_sw[4]|h_sw[5]|h_sw[6]|h_sw[7]|h_sw[8]|h_sw[9]|l_sw[0]|l_sw[10]|l_sw[1]|l_sw[2]|l_sw[3]|l_sw[4]|l_sw[5]|l_sw[6]|l_sw[7]|l_sw[8]|l_sw[9]|out|pad|padres|vc|vcp|vdd|vddr|vip|vss|z
+ X|in_h_sw[2]|nh_sw[2]|x
+ BOTTOM|TOP|VGND|VSS|anode|cathode|core|h_sw[0]|h_sw[10]|h_sw[1]|h_sw[2]|h_sw[3]|h_sw[4]|h_sw[5]|h_sw[6]|h_sw[7]|h_sw[8]|h_sw[9]|l_sw[0]|l_sw[10]|l_sw[1]|l_sw[2]|l_sw[3]|l_sw[4]|l_sw[5]|l_sw[6]|l_sw[7]|l_sw[8]|l_sw[9]|out|pad|padres|vc|vcp|vdd|vddr|vip|vss|z
+ \$64990 sg13_lv_pmos L=0.13u W=16u AS=3.19p AD=3.19p PS=23.38u PD=23.38u
+ rfmode=0
M$2390
+ BOTTOM|TOP|VGND|VSS|anode|cathode|core|h_sw[0]|h_sw[10]|h_sw[1]|h_sw[2]|h_sw[3]|h_sw[4]|h_sw[5]|h_sw[6]|h_sw[7]|h_sw[8]|h_sw[9]|l_sw[0]|l_sw[10]|l_sw[1]|l_sw[2]|l_sw[3]|l_sw[4]|l_sw[5]|l_sw[6]|l_sw[7]|l_sw[8]|l_sw[9]|out|pad|padres|vc|vcp|vdd|vddr|vip|vss|z
+ X|in_l_sw[3]|nl_sw[3]|x
+ BOTTOM|TOP|VGND|VSS|anode|cathode|core|h_sw[0]|h_sw[10]|h_sw[1]|h_sw[2]|h_sw[3]|h_sw[4]|h_sw[5]|h_sw[6]|h_sw[7]|h_sw[8]|h_sw[9]|l_sw[0]|l_sw[10]|l_sw[1]|l_sw[2]|l_sw[3]|l_sw[4]|l_sw[5]|l_sw[6]|l_sw[7]|l_sw[8]|l_sw[9]|out|pad|padres|vc|vcp|vdd|vddr|vip|vss|z
+ \$64991 sg13_lv_pmos L=0.13u W=8u AS=1.67p AD=1.67p PS=12.34u PD=12.34u
+ rfmode=0
M$2398
+ BOTTOM|TOP|VGND|VSS|anode|cathode|core|h_sw[0]|h_sw[10]|h_sw[1]|h_sw[2]|h_sw[3]|h_sw[4]|h_sw[5]|h_sw[6]|h_sw[7]|h_sw[8]|h_sw[9]|l_sw[0]|l_sw[10]|l_sw[1]|l_sw[2]|l_sw[3]|l_sw[4]|l_sw[5]|l_sw[6]|l_sw[7]|l_sw[8]|l_sw[9]|out|pad|padres|vc|vcp|vdd|vddr|vip|vss|z
+ X|in_l_sw[4]|nl_sw[4]|x
+ BOTTOM|TOP|VGND|VSS|anode|cathode|core|h_sw[0]|h_sw[10]|h_sw[1]|h_sw[2]|h_sw[3]|h_sw[4]|h_sw[5]|h_sw[6]|h_sw[7]|h_sw[8]|h_sw[9]|l_sw[0]|l_sw[10]|l_sw[1]|l_sw[2]|l_sw[3]|l_sw[4]|l_sw[5]|l_sw[6]|l_sw[7]|l_sw[8]|l_sw[9]|out|pad|padres|vc|vcp|vdd|vddr|vip|vss|z
+ \$64991 sg13_lv_pmos L=0.13u W=8u AS=1.67p AD=1.67p PS=12.34u PD=12.34u
+ rfmode=0
M$2406
+ BOTTOM|TOP|VGND|VSS|anode|cathode|core|h_sw[0]|h_sw[10]|h_sw[1]|h_sw[2]|h_sw[3]|h_sw[4]|h_sw[5]|h_sw[6]|h_sw[7]|h_sw[8]|h_sw[9]|l_sw[0]|l_sw[10]|l_sw[1]|l_sw[2]|l_sw[3]|l_sw[4]|l_sw[5]|l_sw[6]|l_sw[7]|l_sw[8]|l_sw[9]|out|pad|padres|vc|vcp|vdd|vddr|vip|vss|z
+ X|in_l_sw[5]|nl_sw[5]|x
+ BOTTOM|TOP|VGND|VSS|anode|cathode|core|h_sw[0]|h_sw[10]|h_sw[1]|h_sw[2]|h_sw[3]|h_sw[4]|h_sw[5]|h_sw[6]|h_sw[7]|h_sw[8]|h_sw[9]|l_sw[0]|l_sw[10]|l_sw[1]|l_sw[2]|l_sw[3]|l_sw[4]|l_sw[5]|l_sw[6]|l_sw[7]|l_sw[8]|l_sw[9]|out|pad|padres|vc|vcp|vdd|vddr|vip|vss|z
+ \$64992 sg13_lv_pmos L=0.13u W=8u AS=1.67p AD=1.67p PS=12.34u PD=12.34u
+ rfmode=0
M$2414
+ BOTTOM|TOP|VGND|VSS|anode|cathode|core|h_sw[0]|h_sw[10]|h_sw[1]|h_sw[2]|h_sw[3]|h_sw[4]|h_sw[5]|h_sw[6]|h_sw[7]|h_sw[8]|h_sw[9]|l_sw[0]|l_sw[10]|l_sw[1]|l_sw[2]|l_sw[3]|l_sw[4]|l_sw[5]|l_sw[6]|l_sw[7]|l_sw[8]|l_sw[9]|out|pad|padres|vc|vcp|vdd|vddr|vip|vss|z
+ X|in_l_sw[6]|nl_sw[6]|x
+ BOTTOM|TOP|VGND|VSS|anode|cathode|core|h_sw[0]|h_sw[10]|h_sw[1]|h_sw[2]|h_sw[3]|h_sw[4]|h_sw[5]|h_sw[6]|h_sw[7]|h_sw[8]|h_sw[9]|l_sw[0]|l_sw[10]|l_sw[1]|l_sw[2]|l_sw[3]|l_sw[4]|l_sw[5]|l_sw[6]|l_sw[7]|l_sw[8]|l_sw[9]|out|pad|padres|vc|vcp|vdd|vddr|vip|vss|z
+ \$64992 sg13_lv_pmos L=0.13u W=4u AS=0.91p AD=0.91p PS=6.82u PD=6.82u rfmode=0
M$2418
+ BOTTOM|TOP|VGND|VSS|anode|cathode|core|h_sw[0]|h_sw[10]|h_sw[1]|h_sw[2]|h_sw[3]|h_sw[4]|h_sw[5]|h_sw[6]|h_sw[7]|h_sw[8]|h_sw[9]|l_sw[0]|l_sw[10]|l_sw[1]|l_sw[2]|l_sw[3]|l_sw[4]|l_sw[5]|l_sw[6]|l_sw[7]|l_sw[8]|l_sw[9]|out|pad|padres|vc|vcp|vdd|vddr|vip|vss|z
+ X|in_l_sw[7]|nl_sw[7]|x
+ BOTTOM|TOP|VGND|VSS|anode|cathode|core|h_sw[0]|h_sw[10]|h_sw[1]|h_sw[2]|h_sw[3]|h_sw[4]|h_sw[5]|h_sw[6]|h_sw[7]|h_sw[8]|h_sw[9]|l_sw[0]|l_sw[10]|l_sw[1]|l_sw[2]|l_sw[3]|l_sw[4]|l_sw[5]|l_sw[6]|l_sw[7]|l_sw[8]|l_sw[9]|out|pad|padres|vc|vcp|vdd|vddr|vip|vss|z
+ \$64993 sg13_lv_pmos L=0.13u W=4u AS=0.91p AD=0.91p PS=6.82u PD=6.82u rfmode=0
M$2422
+ BOTTOM|TOP|VGND|VSS|anode|cathode|core|h_sw[0]|h_sw[10]|h_sw[1]|h_sw[2]|h_sw[3]|h_sw[4]|h_sw[5]|h_sw[6]|h_sw[7]|h_sw[8]|h_sw[9]|l_sw[0]|l_sw[10]|l_sw[1]|l_sw[2]|l_sw[3]|l_sw[4]|l_sw[5]|l_sw[6]|l_sw[7]|l_sw[8]|l_sw[9]|out|pad|padres|vc|vcp|vdd|vddr|vip|vss|z
+ X|in_l_sw[8]|nl_sw[8]|x
+ BOTTOM|TOP|VGND|VSS|anode|cathode|core|h_sw[0]|h_sw[10]|h_sw[1]|h_sw[2]|h_sw[3]|h_sw[4]|h_sw[5]|h_sw[6]|h_sw[7]|h_sw[8]|h_sw[9]|l_sw[0]|l_sw[10]|l_sw[1]|l_sw[2]|l_sw[3]|l_sw[4]|l_sw[5]|l_sw[6]|l_sw[7]|l_sw[8]|l_sw[9]|out|pad|padres|vc|vcp|vdd|vddr|vip|vss|z
+ \$64993 sg13_lv_pmos L=0.13u W=2u AS=0.53p AD=0.53p PS=4.06u PD=4.06u rfmode=0
M$2424
+ BOTTOM|TOP|VGND|VSS|anode|cathode|core|h_sw[0]|h_sw[10]|h_sw[1]|h_sw[2]|h_sw[3]|h_sw[4]|h_sw[5]|h_sw[6]|h_sw[7]|h_sw[8]|h_sw[9]|l_sw[0]|l_sw[10]|l_sw[1]|l_sw[2]|l_sw[3]|l_sw[4]|l_sw[5]|l_sw[6]|l_sw[7]|l_sw[8]|l_sw[9]|out|pad|padres|vc|vcp|vdd|vddr|vip|vss|z
+ X|in_l_sw[9]|nl_sw[9]|x
+ BOTTOM|TOP|VGND|VSS|anode|cathode|core|h_sw[0]|h_sw[10]|h_sw[1]|h_sw[2]|h_sw[3]|h_sw[4]|h_sw[5]|h_sw[6]|h_sw[7]|h_sw[8]|h_sw[9]|l_sw[0]|l_sw[10]|l_sw[1]|l_sw[2]|l_sw[3]|l_sw[4]|l_sw[5]|l_sw[6]|l_sw[7]|l_sw[8]|l_sw[9]|out|pad|padres|vc|vcp|vdd|vddr|vip|vss|z
+ \$64994 sg13_lv_pmos L=0.13u W=2u AS=0.53p AD=0.53p PS=4.06u PD=4.06u rfmode=0
M$2426
+ BOTTOM|TOP|VGND|VSS|anode|cathode|core|h_sw[0]|h_sw[10]|h_sw[1]|h_sw[2]|h_sw[3]|h_sw[4]|h_sw[5]|h_sw[6]|h_sw[7]|h_sw[8]|h_sw[9]|l_sw[0]|l_sw[10]|l_sw[1]|l_sw[2]|l_sw[3]|l_sw[4]|l_sw[5]|l_sw[6]|l_sw[7]|l_sw[8]|l_sw[9]|out|pad|padres|vc|vcp|vdd|vddr|vip|vss|z
+ X|in_l_sw[10]|nl_sw[10]|x
+ BOTTOM|TOP|VGND|VSS|anode|cathode|core|h_sw[0]|h_sw[10]|h_sw[1]|h_sw[2]|h_sw[3]|h_sw[4]|h_sw[5]|h_sw[6]|h_sw[7]|h_sw[8]|h_sw[9]|l_sw[0]|l_sw[10]|l_sw[1]|l_sw[2]|l_sw[3]|l_sw[4]|l_sw[5]|l_sw[6]|l_sw[7]|l_sw[8]|l_sw[9]|out|pad|padres|vc|vcp|vdd|vddr|vip|vss|z
+ \$64994 sg13_lv_pmos L=0.13u W=1u AS=0.34p AD=0.34p PS=2.68u PD=2.68u rfmode=0
M$2427
+ BOTTOM|TOP|VGND|VSS|anode|cathode|core|h_sw[0]|h_sw[10]|h_sw[1]|h_sw[2]|h_sw[3]|h_sw[4]|h_sw[5]|h_sw[6]|h_sw[7]|h_sw[8]|h_sw[9]|l_sw[0]|l_sw[10]|l_sw[1]|l_sw[2]|l_sw[3]|l_sw[4]|l_sw[5]|l_sw[6]|l_sw[7]|l_sw[8]|l_sw[9]|out|pad|padres|vc|vcp|vdd|vddr|vip|vss|z
+ X|in_h_sw[10]|nh_sw[10]|x
+ BOTTOM|TOP|VGND|VSS|anode|cathode|core|h_sw[0]|h_sw[10]|h_sw[1]|h_sw[2]|h_sw[3]|h_sw[4]|h_sw[5]|h_sw[6]|h_sw[7]|h_sw[8]|h_sw[9]|l_sw[0]|l_sw[10]|l_sw[1]|l_sw[2]|l_sw[3]|l_sw[4]|l_sw[5]|l_sw[6]|l_sw[7]|l_sw[8]|l_sw[9]|out|pad|padres|vc|vcp|vdd|vddr|vip|vss|z
+ \$64994 sg13_lv_pmos L=0.13u W=1u AS=0.34p AD=0.34p PS=2.68u PD=2.68u rfmode=0
M$2428
+ BOTTOM|TOP|VGND|VSS|anode|cathode|core|h_sw[0]|h_sw[10]|h_sw[1]|h_sw[2]|h_sw[3]|h_sw[4]|h_sw[5]|h_sw[6]|h_sw[7]|h_sw[8]|h_sw[9]|l_sw[0]|l_sw[10]|l_sw[1]|l_sw[2]|l_sw[3]|l_sw[4]|l_sw[5]|l_sw[6]|l_sw[7]|l_sw[8]|l_sw[9]|out|pad|padres|vc|vcp|vdd|vddr|vip|vss|z
+ X|in_h_sw[8]|nh_sw[8]|x
+ BOTTOM|TOP|VGND|VSS|anode|cathode|core|h_sw[0]|h_sw[10]|h_sw[1]|h_sw[2]|h_sw[3]|h_sw[4]|h_sw[5]|h_sw[6]|h_sw[7]|h_sw[8]|h_sw[9]|l_sw[0]|l_sw[10]|l_sw[1]|l_sw[2]|l_sw[3]|l_sw[4]|l_sw[5]|l_sw[6]|l_sw[7]|l_sw[8]|l_sw[9]|out|pad|padres|vc|vcp|vdd|vddr|vip|vss|z
+ \$64993 sg13_lv_pmos L=0.13u W=2u AS=0.53p AD=0.53p PS=4.06u PD=4.06u rfmode=0
M$2430
+ BOTTOM|TOP|VGND|VSS|anode|cathode|core|h_sw[0]|h_sw[10]|h_sw[1]|h_sw[2]|h_sw[3]|h_sw[4]|h_sw[5]|h_sw[6]|h_sw[7]|h_sw[8]|h_sw[9]|l_sw[0]|l_sw[10]|l_sw[1]|l_sw[2]|l_sw[3]|l_sw[4]|l_sw[5]|l_sw[6]|l_sw[7]|l_sw[8]|l_sw[9]|out|pad|padres|vc|vcp|vdd|vddr|vip|vss|z
+ X|in_h_sw[9]|nh_sw[9]|x
+ BOTTOM|TOP|VGND|VSS|anode|cathode|core|h_sw[0]|h_sw[10]|h_sw[1]|h_sw[2]|h_sw[3]|h_sw[4]|h_sw[5]|h_sw[6]|h_sw[7]|h_sw[8]|h_sw[9]|l_sw[0]|l_sw[10]|l_sw[1]|l_sw[2]|l_sw[3]|l_sw[4]|l_sw[5]|l_sw[6]|l_sw[7]|l_sw[8]|l_sw[9]|out|pad|padres|vc|vcp|vdd|vddr|vip|vss|z
+ \$64994 sg13_lv_pmos L=0.13u W=2u AS=0.53p AD=0.53p PS=4.06u PD=4.06u rfmode=0
M$2432
+ BOTTOM|TOP|VGND|VSS|anode|cathode|core|h_sw[0]|h_sw[10]|h_sw[1]|h_sw[2]|h_sw[3]|h_sw[4]|h_sw[5]|h_sw[6]|h_sw[7]|h_sw[8]|h_sw[9]|l_sw[0]|l_sw[10]|l_sw[1]|l_sw[2]|l_sw[3]|l_sw[4]|l_sw[5]|l_sw[6]|l_sw[7]|l_sw[8]|l_sw[9]|out|pad|padres|vc|vcp|vdd|vddr|vip|vss|z
+ X|in_h_sw[6]|nh_sw[6]|x
+ BOTTOM|TOP|VGND|VSS|anode|cathode|core|h_sw[0]|h_sw[10]|h_sw[1]|h_sw[2]|h_sw[3]|h_sw[4]|h_sw[5]|h_sw[6]|h_sw[7]|h_sw[8]|h_sw[9]|l_sw[0]|l_sw[10]|l_sw[1]|l_sw[2]|l_sw[3]|l_sw[4]|l_sw[5]|l_sw[6]|l_sw[7]|l_sw[8]|l_sw[9]|out|pad|padres|vc|vcp|vdd|vddr|vip|vss|z
+ \$64992 sg13_lv_pmos L=0.13u W=4u AS=0.91p AD=0.91p PS=6.82u PD=6.82u rfmode=0
M$2436
+ BOTTOM|TOP|VGND|VSS|anode|cathode|core|h_sw[0]|h_sw[10]|h_sw[1]|h_sw[2]|h_sw[3]|h_sw[4]|h_sw[5]|h_sw[6]|h_sw[7]|h_sw[8]|h_sw[9]|l_sw[0]|l_sw[10]|l_sw[1]|l_sw[2]|l_sw[3]|l_sw[4]|l_sw[5]|l_sw[6]|l_sw[7]|l_sw[8]|l_sw[9]|out|pad|padres|vc|vcp|vdd|vddr|vip|vss|z
+ X|in_h_sw[7]|nh_sw[7]|x
+ BOTTOM|TOP|VGND|VSS|anode|cathode|core|h_sw[0]|h_sw[10]|h_sw[1]|h_sw[2]|h_sw[3]|h_sw[4]|h_sw[5]|h_sw[6]|h_sw[7]|h_sw[8]|h_sw[9]|l_sw[0]|l_sw[10]|l_sw[1]|l_sw[2]|l_sw[3]|l_sw[4]|l_sw[5]|l_sw[6]|l_sw[7]|l_sw[8]|l_sw[9]|out|pad|padres|vc|vcp|vdd|vddr|vip|vss|z
+ \$64993 sg13_lv_pmos L=0.13u W=4u AS=0.91p AD=0.91p PS=6.82u PD=6.82u rfmode=0
M$2440
+ BOTTOM|TOP|VGND|VSS|anode|cathode|core|h_sw[0]|h_sw[10]|h_sw[1]|h_sw[2]|h_sw[3]|h_sw[4]|h_sw[5]|h_sw[6]|h_sw[7]|h_sw[8]|h_sw[9]|l_sw[0]|l_sw[10]|l_sw[1]|l_sw[2]|l_sw[3]|l_sw[4]|l_sw[5]|l_sw[6]|l_sw[7]|l_sw[8]|l_sw[9]|out|pad|padres|vc|vcp|vdd|vddr|vip|vss|z
+ X|in_h_sw[3]|nh_sw[3]|x
+ BOTTOM|TOP|VGND|VSS|anode|cathode|core|h_sw[0]|h_sw[10]|h_sw[1]|h_sw[2]|h_sw[3]|h_sw[4]|h_sw[5]|h_sw[6]|h_sw[7]|h_sw[8]|h_sw[9]|l_sw[0]|l_sw[10]|l_sw[1]|l_sw[2]|l_sw[3]|l_sw[4]|l_sw[5]|l_sw[6]|l_sw[7]|l_sw[8]|l_sw[9]|out|pad|padres|vc|vcp|vdd|vddr|vip|vss|z
+ \$64991 sg13_lv_pmos L=0.13u W=8u AS=1.67p AD=1.67p PS=12.34u PD=12.34u
+ rfmode=0
M$2448
+ BOTTOM|TOP|VGND|VSS|anode|cathode|core|h_sw[0]|h_sw[10]|h_sw[1]|h_sw[2]|h_sw[3]|h_sw[4]|h_sw[5]|h_sw[6]|h_sw[7]|h_sw[8]|h_sw[9]|l_sw[0]|l_sw[10]|l_sw[1]|l_sw[2]|l_sw[3]|l_sw[4]|l_sw[5]|l_sw[6]|l_sw[7]|l_sw[8]|l_sw[9]|out|pad|padres|vc|vcp|vdd|vddr|vip|vss|z
+ X|in_h_sw[4]|nh_sw[4]|x
+ BOTTOM|TOP|VGND|VSS|anode|cathode|core|h_sw[0]|h_sw[10]|h_sw[1]|h_sw[2]|h_sw[3]|h_sw[4]|h_sw[5]|h_sw[6]|h_sw[7]|h_sw[8]|h_sw[9]|l_sw[0]|l_sw[10]|l_sw[1]|l_sw[2]|l_sw[3]|l_sw[4]|l_sw[5]|l_sw[6]|l_sw[7]|l_sw[8]|l_sw[9]|out|pad|padres|vc|vcp|vdd|vddr|vip|vss|z
+ \$64991 sg13_lv_pmos L=0.13u W=8u AS=1.67p AD=1.67p PS=12.34u PD=12.34u
+ rfmode=0
M$2456
+ BOTTOM|TOP|VGND|VSS|anode|cathode|core|h_sw[0]|h_sw[10]|h_sw[1]|h_sw[2]|h_sw[3]|h_sw[4]|h_sw[5]|h_sw[6]|h_sw[7]|h_sw[8]|h_sw[9]|l_sw[0]|l_sw[10]|l_sw[1]|l_sw[2]|l_sw[3]|l_sw[4]|l_sw[5]|l_sw[6]|l_sw[7]|l_sw[8]|l_sw[9]|out|pad|padres|vc|vcp|vdd|vddr|vip|vss|z
+ X|in_h_sw[5]|nh_sw[5]|x
+ BOTTOM|TOP|VGND|VSS|anode|cathode|core|h_sw[0]|h_sw[10]|h_sw[1]|h_sw[2]|h_sw[3]|h_sw[4]|h_sw[5]|h_sw[6]|h_sw[7]|h_sw[8]|h_sw[9]|l_sw[0]|l_sw[10]|l_sw[1]|l_sw[2]|l_sw[3]|l_sw[4]|l_sw[5]|l_sw[6]|l_sw[7]|l_sw[8]|l_sw[9]|out|pad|padres|vc|vcp|vdd|vddr|vip|vss|z
+ \$64992 sg13_lv_pmos L=0.13u W=8u AS=1.67p AD=1.67p PS=12.34u PD=12.34u
+ rfmode=0
M$2464 \$69205 \$69042 VDD|VPWR|vdd VDD|VPWR|vdd sg13_lv_pmos L=0.13u W=1.12u
+ AS=0.3864p AD=0.41165p PS=2.93u PD=2.12u rfmode=0
M$2465 VDD|VPWR|vdd CLK|Y \$69042 VDD|VPWR|vdd sg13_lv_pmos L=0.13u W=1.12u
+ AS=0.41165p AD=0.4088p PS=2.12u PD=2.97u rfmode=0
M$2466 \$69212 \$69054 VDD|VPWR|vdd VDD|VPWR|vdd sg13_lv_pmos L=0.13u W=1.12u
+ AS=0.3864p AD=0.41165p PS=2.93u PD=2.12u rfmode=0
M$2467 VDD|VPWR|vdd CLK|Y \$69054 VDD|VPWR|vdd sg13_lv_pmos L=0.13u W=1.12u
+ AS=0.41165p AD=0.4088p PS=2.12u PD=2.97u rfmode=0
M$2468 VDD|VPWR|vdd A|comp_p|outp \$69079 VDD|VPWR|vdd sg13_lv_pmos L=0.13u
+ W=0.84u AS=0.2114p AD=0.2856p PS=1.54u PD=2.36u rfmode=0
M$2469 VDD|VPWR|vdd \$69079 A|X VDD|VPWR|vdd sg13_lv_pmos L=0.13u W=1.12u
+ AS=0.2114p AD=0.42p PS=1.54u PD=2.99u rfmode=0
M$2470 A|X$1 \$69080 VDD|VPWR|vdd VDD|VPWR|vdd sg13_lv_pmos L=0.13u W=1.12u
+ AS=0.42p AD=0.2114p PS=2.99u PD=1.54u rfmode=0
M$2471 VDD|VPWR|vdd A|Y$1 \$69080 VDD|VPWR|vdd sg13_lv_pmos L=0.13u W=0.84u
+ AS=0.2114p AD=0.2856p PS=1.54u PD=2.36u rfmode=0
M$2472 VDD|VPWR|vdd A|X$17 \$69081 VDD|VPWR|vdd sg13_lv_pmos L=0.13u W=0.84u
+ AS=0.2114p AD=0.2856p PS=1.54u PD=2.36u rfmode=0
M$2473 VDD|VPWR|vdd \$69081 A|X$2 VDD|VPWR|vdd sg13_lv_pmos L=0.13u W=1.12u
+ AS=0.2114p AD=0.42p PS=1.54u PD=2.99u rfmode=0
M$2474 VDD|VPWR|vdd A|X$18 \$69082 VDD|VPWR|vdd sg13_lv_pmos L=0.13u W=0.84u
+ AS=0.2114p AD=0.2856p PS=1.54u PD=2.36u rfmode=0
M$2475 VDD|VPWR|vdd \$69082 X|in_l_sw[1]|nl_sw[1]|x VDD|VPWR|vdd sg13_lv_pmos
+ L=0.13u W=1.12u AS=0.2114p AD=0.42p PS=1.54u PD=2.99u rfmode=0
M$2476 VDD|VPWR|vdd A|X$4 \$69083 VDD|VPWR|vdd sg13_lv_pmos L=0.13u W=0.84u
+ AS=0.2114p AD=0.2856p PS=1.54u PD=2.36u rfmode=0
M$2477 VDD|VPWR|vdd \$69083 X|in_l_sw[2]|nl_sw[2]|x VDD|VPWR|vdd sg13_lv_pmos
+ L=0.13u W=1.12u AS=0.2114p AD=0.42p PS=1.54u PD=2.99u rfmode=0
M$2478 A|X$18 \$69084 VDD|VPWR|vdd VDD|VPWR|vdd sg13_lv_pmos L=0.13u W=1.12u
+ AS=0.42p AD=0.2114p PS=2.99u PD=1.54u rfmode=0
M$2479 VDD|VPWR|vdd A|Y$2 \$69084 VDD|VPWR|vdd sg13_lv_pmos L=0.13u W=0.84u
+ AS=0.2114p AD=0.2856p PS=1.54u PD=2.36u rfmode=0
M$2480 A|X$3 \$69085 VDD|VPWR|vdd VDD|VPWR|vdd sg13_lv_pmos L=0.13u W=1.12u
+ AS=0.42p AD=0.2114p PS=2.99u PD=1.54u rfmode=0
M$2481 VDD|VPWR|vdd A|X$19 \$69085 VDD|VPWR|vdd sg13_lv_pmos L=0.13u W=0.84u
+ AS=0.2114p AD=0.2856p PS=1.54u PD=2.36u rfmode=0
M$2482 VDD|VPWR|vdd A|X$20 \$69086 VDD|VPWR|vdd sg13_lv_pmos L=0.13u W=0.84u
+ AS=0.2114p AD=0.2856p PS=1.54u PD=2.36u rfmode=0
M$2483 VDD|VPWR|vdd \$69086 X|in_h_sw[2]|nh_sw[2]|x VDD|VPWR|vdd sg13_lv_pmos
+ L=0.13u W=1.12u AS=0.2114p AD=0.42p PS=1.54u PD=2.99u rfmode=0
M$2484 A|X$4 \$69087 VDD|VPWR|vdd VDD|VPWR|vdd sg13_lv_pmos L=0.13u W=1.12u
+ AS=0.42p AD=0.2114p PS=2.99u PD=1.54u rfmode=0
M$2485 VDD|VPWR|vdd A|Y$3 \$69087 VDD|VPWR|vdd sg13_lv_pmos L=0.13u W=0.84u
+ AS=0.2114p AD=0.2856p PS=1.54u PD=2.36u rfmode=0
M$2486 VDD|VPWR|vdd A|X$21 \$69088 VDD|VPWR|vdd sg13_lv_pmos L=0.13u W=0.84u
+ AS=0.2114p AD=0.2856p PS=1.54u PD=2.36u rfmode=0
M$2487 VDD|VPWR|vdd \$69088 X|in_l_sw[3]|nl_sw[3]|x VDD|VPWR|vdd sg13_lv_pmos
+ L=0.13u W=1.12u AS=0.2114p AD=0.42p PS=1.54u PD=2.99u rfmode=0
M$2488 VDD|VPWR|vdd A|Q$2 \$69089 VDD|VPWR|vdd sg13_lv_pmos L=0.13u W=0.84u
+ AS=0.2114p AD=0.2856p PS=1.54u PD=2.36u rfmode=0
M$2489 VDD|VPWR|vdd \$69089 A|X$5 VDD|VPWR|vdd sg13_lv_pmos L=0.13u W=1.12u
+ AS=0.2114p AD=0.42p PS=1.54u PD=2.99u rfmode=0
M$2490 A|X$20 \$69090 VDD|VPWR|vdd VDD|VPWR|vdd sg13_lv_pmos L=0.13u W=1.12u
+ AS=0.42p AD=0.2114p PS=2.99u PD=1.54u rfmode=0
M$2491 VDD|VPWR|vdd A|X$5 \$69090 VDD|VPWR|vdd sg13_lv_pmos L=0.13u W=0.84u
+ AS=0.2114p AD=0.2856p PS=1.54u PD=2.36u rfmode=0
M$2492 VDD|VPWR|vdd A|X$22 \$69091 VDD|VPWR|vdd sg13_lv_pmos L=0.13u W=0.84u
+ AS=0.2114p AD=0.2856p PS=1.54u PD=2.36u rfmode=0
M$2493 VDD|VPWR|vdd \$69091 X|in_h_sw[3]|nh_sw[3]|x VDD|VPWR|vdd sg13_lv_pmos
+ L=0.13u W=1.12u AS=0.2114p AD=0.42p PS=1.54u PD=2.99u rfmode=0
M$2494 A|X$21 \$69092 VDD|VPWR|vdd VDD|VPWR|vdd sg13_lv_pmos L=0.13u W=1.12u
+ AS=0.42p AD=0.2114p PS=2.99u PD=1.54u rfmode=0
M$2495 VDD|VPWR|vdd A|Y$4 \$69092 VDD|VPWR|vdd sg13_lv_pmos L=0.13u W=0.84u
+ AS=0.2114p AD=0.2856p PS=1.54u PD=2.36u rfmode=0
M$2496 A|X$22 \$69093 VDD|VPWR|vdd VDD|VPWR|vdd sg13_lv_pmos L=0.13u W=1.12u
+ AS=0.42p AD=0.2114p PS=2.99u PD=1.54u rfmode=0
M$2497 VDD|VPWR|vdd A|X$23 \$69093 VDD|VPWR|vdd sg13_lv_pmos L=0.13u W=0.84u
+ AS=0.2114p AD=0.2856p PS=1.54u PD=2.36u rfmode=0
M$2498 VDD|VPWR|vdd \$69029 \$69031 VDD|VPWR|vdd sg13_lv_pmos L=0.13u W=0.84u
+ AS=0.1974p AD=0.2856p PS=1.5u PD=2.36u rfmode=0
M$2499 VDD|VPWR|vdd \$69031 Q_N VDD|VPWR|vdd sg13_lv_pmos L=0.13u W=1.12u
+ AS=0.1974p AD=0.3808p PS=1.5u PD=2.92u rfmode=0
M$2500 VDD|VPWR|vdd A|X$24 \$69096 VDD|VPWR|vdd sg13_lv_pmos L=0.13u W=0.84u
+ AS=0.2114p AD=0.2856p PS=1.54u PD=2.36u rfmode=0
M$2501 VDD|VPWR|vdd \$69096 A|X$6 VDD|VPWR|vdd sg13_lv_pmos L=0.13u W=1.12u
+ AS=0.2114p AD=0.42p PS=1.54u PD=2.99u rfmode=0
M$2502 A|X$7 \$69097 VDD|VPWR|vdd VDD|VPWR|vdd sg13_lv_pmos L=0.13u W=1.12u
+ AS=0.42p AD=0.2114p PS=2.99u PD=1.54u rfmode=0
M$2503 VDD|VPWR|vdd A|Y$5 \$69097 VDD|VPWR|vdd sg13_lv_pmos L=0.13u W=0.84u
+ AS=0.2114p AD=0.2856p PS=1.54u PD=2.36u rfmode=0
M$2504 VDD|VPWR|vdd A|Y$6 \$69098 VDD|VPWR|vdd sg13_lv_pmos L=0.13u W=0.84u
+ AS=0.2114p AD=0.2856p PS=1.54u PD=2.36u rfmode=0
M$2505 VDD|VPWR|vdd \$69098 A|X$8 VDD|VPWR|vdd sg13_lv_pmos L=0.13u W=1.12u
+ AS=0.2114p AD=0.42p PS=1.54u PD=2.99u rfmode=0
M$2506 VDD|VPWR|vdd A|X$25 \$69099 VDD|VPWR|vdd sg13_lv_pmos L=0.13u W=0.84u
+ AS=0.2114p AD=0.2856p PS=1.54u PD=2.36u rfmode=0
M$2507 VDD|VPWR|vdd \$69099 A|X$9 VDD|VPWR|vdd sg13_lv_pmos L=0.13u W=1.12u
+ AS=0.2114p AD=0.42p PS=1.54u PD=2.99u rfmode=0
M$2508 B1|Y A2|B|B1|Y \$69202 VDD|VPWR|vdd sg13_lv_pmos L=0.13u W=1.12u
+ AS=0.3808p AD=0.2128p PS=2.92u PD=1.5u rfmode=0
M$2509 \$69202 A1|D|Q VDD|VPWR|vdd VDD|VPWR|vdd sg13_lv_pmos L=0.13u W=1.12u
+ AS=0.2128p AD=0.2128p PS=1.5u PD=1.5u rfmode=0
M$2510 VDD|VPWR|vdd A2|B1|Y \$69202 VDD|VPWR|vdd sg13_lv_pmos L=0.13u W=1.12u
+ AS=0.2128p AD=0.3808p PS=1.5u PD=2.92u rfmode=0
M$2511 VDD|VPWR|vdd A|Y$7 \$69101 VDD|VPWR|vdd sg13_lv_pmos L=0.13u W=0.84u
+ AS=0.2114p AD=0.2856p PS=1.54u PD=2.36u rfmode=0
M$2512 VDD|VPWR|vdd \$69101 A|X$10 VDD|VPWR|vdd sg13_lv_pmos L=0.13u W=1.12u
+ AS=0.2114p AD=0.42p PS=1.54u PD=2.99u rfmode=0
M$2513 \$69045 \$69102 VDD|VPWR|vdd VDD|VPWR|vdd sg13_lv_pmos L=0.13u W=1.12u
+ AS=0.3864p AD=0.2128p PS=2.93u PD=1.5u rfmode=0
M$2514 VDD|VPWR|vdd \$69045 A|Q$1 VDD|VPWR|vdd sg13_lv_pmos L=0.13u W=1.12u
+ AS=0.2128p AD=0.3808p PS=1.5u PD=2.92u rfmode=0
M$2515 VDD|VPWR|vdd A|Y$8 \$69103 VDD|VPWR|vdd sg13_lv_pmos L=0.13u W=0.84u
+ AS=0.2114p AD=0.2856p PS=1.54u PD=2.36u rfmode=0
M$2516 VDD|VPWR|vdd \$69103 A|X$11 VDD|VPWR|vdd sg13_lv_pmos L=0.13u W=1.12u
+ AS=0.2114p AD=0.42p PS=1.54u PD=2.99u rfmode=0
M$2517 VDD|VPWR|vdd A|X$46 \$69104 VDD|VPWR|vdd sg13_lv_pmos L=0.13u W=0.84u
+ AS=0.2114p AD=0.2856p PS=1.54u PD=2.36u rfmode=0
M$2518 VDD|VPWR|vdd \$69104 A|X$12 VDD|VPWR|vdd sg13_lv_pmos L=0.13u W=1.12u
+ AS=0.2114p AD=0.42p PS=1.54u PD=2.99u rfmode=0
M$2519 X|in_h_sw[6]|nh_sw[6]|x \$69105 VDD|VPWR|vdd VDD|VPWR|vdd sg13_lv_pmos
+ L=0.13u W=1.12u AS=0.42p AD=0.2114p PS=2.99u PD=1.54u rfmode=0
M$2520 VDD|VPWR|vdd A|X$26 \$69105 VDD|VPWR|vdd sg13_lv_pmos L=0.13u W=0.84u
+ AS=0.2114p AD=0.2856p PS=1.54u PD=2.36u rfmode=0
M$2521 VDD|VPWR|vdd A|A_N|B|B_N|Q \$69106 VDD|VPWR|vdd sg13_lv_pmos L=0.13u
+ W=0.84u AS=0.2198p AD=0.2856p PS=1.53u PD=2.36u rfmode=0
M$2522 VDD|VPWR|vdd \$69106 A2|B|B1|Y VDD|VPWR|vdd sg13_lv_pmos L=0.13u W=1.12u
+ AS=0.3808p AD=0.2128p PS=2.92u PD=1.5u rfmode=0
M$2523 A2|B|B1|Y A|B|B_N|Q VDD|VPWR|vdd VDD|VPWR|vdd sg13_lv_pmos L=0.13u
+ W=1.12u AS=0.2128p AD=0.2198p PS=1.5u PD=1.53u rfmode=0
M$2524 VDD|VPWR|vdd A|Y$9 \$69107 VDD|VPWR|vdd sg13_lv_pmos L=0.13u W=0.84u
+ AS=0.2114p AD=0.2856p PS=1.54u PD=2.36u rfmode=0
M$2525 VDD|VPWR|vdd \$69107 A|X$13 VDD|VPWR|vdd sg13_lv_pmos L=0.13u W=1.12u
+ AS=0.2114p AD=0.42p PS=1.54u PD=2.99u rfmode=0
M$2526 X|in_l_sw[7]|nl_sw[7]|x \$69108 VDD|VPWR|vdd VDD|VPWR|vdd sg13_lv_pmos
+ L=0.13u W=1.12u AS=0.42p AD=0.2114p PS=2.99u PD=1.54u rfmode=0
M$2527 VDD|VPWR|vdd A|X$11 \$69108 VDD|VPWR|vdd sg13_lv_pmos L=0.13u W=0.84u
+ AS=0.2114p AD=0.2856p PS=1.54u PD=2.36u rfmode=0
M$2528 VDD|VPWR|vdd A|X$27 \$69109 VDD|VPWR|vdd sg13_lv_pmos L=0.13u W=0.84u
+ AS=0.2114p AD=0.2856p PS=1.54u PD=2.36u rfmode=0
M$2529 VDD|VPWR|vdd \$69109 A|X$14 VDD|VPWR|vdd sg13_lv_pmos L=0.13u W=1.12u
+ AS=0.2114p AD=0.42p PS=1.54u PD=2.99u rfmode=0
M$2530 \$69057 \$69110 VDD|VPWR|vdd VDD|VPWR|vdd sg13_lv_pmos L=0.13u W=1.12u
+ AS=0.3864p AD=0.2128p PS=2.93u PD=1.5u rfmode=0
M$2531 VDD|VPWR|vdd \$69057 A|A_N|B|B_N|Q VDD|VPWR|vdd sg13_lv_pmos L=0.13u
+ W=1.12u AS=0.2128p AD=0.3808p PS=1.5u PD=2.92u rfmode=0
M$2532 A|X$15 \$69111 VDD|VPWR|vdd VDD|VPWR|vdd sg13_lv_pmos L=0.13u W=1.12u
+ AS=0.42p AD=0.2114p PS=2.99u PD=1.54u rfmode=0
M$2533 VDD|VPWR|vdd A|Y$10 \$69111 VDD|VPWR|vdd sg13_lv_pmos L=0.13u W=0.84u
+ AS=0.2114p AD=0.2856p PS=1.54u PD=2.36u rfmode=0
M$2534 VDD|VPWR|vdd A|X$28 \$69112 VDD|VPWR|vdd sg13_lv_pmos L=0.13u W=0.84u
+ AS=0.2114p AD=0.2856p PS=1.54u PD=2.36u rfmode=0
M$2535 VDD|VPWR|vdd \$69112 A|X$16 VDD|VPWR|vdd sg13_lv_pmos L=0.13u W=1.12u
+ AS=0.2114p AD=0.42p PS=1.54u PD=2.99u rfmode=0
M$2536 \$69094 A1|D|Q VDD|VPWR|vdd VDD|VPWR|vdd sg13_lv_pmos L=0.13u W=0.84u
+ AS=0.2856p AD=0.3018p PS=2.36u PD=1.97u rfmode=0
M$2537 VDD|VPWR|vdd CLK|D|GATE|Q$1 \$69027 VDD|VPWR|vdd sg13_lv_pmos L=0.13u
+ W=0.84u AS=0.3018p AD=0.3234p PS=1.97u PD=2.45u rfmode=0
M$2538 \$69095 \$69027 VDD|VPWR|vdd VDD|VPWR|vdd sg13_lv_pmos L=0.13u W=0.84u
+ AS=0.2856p AD=0.26675p PS=2.36u PD=1.845u rfmode=0
M$2539 VDD|VPWR|vdd \$69094 \$69341 VDD|VPWR|vdd sg13_lv_pmos L=0.13u W=1u
+ AS=0.26675p AD=0.105p PS=1.845u PD=1.21u rfmode=0
M$2540 \$69341 \$69027 \$69028 VDD|VPWR|vdd sg13_lv_pmos L=0.13u W=1u AS=0.105p
+ AD=0.191p PS=1.21u PD=1.44u rfmode=0
M$2541 \$69028 \$69095 \$69342 VDD|VPWR|vdd sg13_lv_pmos L=0.13u W=0.42u
+ AS=0.191p AD=0.1008p PS=1.44u PD=0.9u rfmode=0
M$2542 VDD|VPWR|vdd \$69029 \$69342 VDD|VPWR|vdd sg13_lv_pmos L=0.13u W=0.42u
+ AS=0.2387p AD=0.1008p PS=1.84u PD=0.9u rfmode=0
M$2543 VDD|VPWR|vdd \$69028 \$69029 VDD|VPWR|vdd sg13_lv_pmos L=0.13u W=1.12u
+ AS=0.2387p AD=0.2128p PS=1.84u PD=1.5u rfmode=0
M$2544 \$69029 RESET_B|Y$1 VDD|VPWR|vdd VDD|VPWR|vdd sg13_lv_pmos L=0.13u
+ W=1.12u AS=0.2128p AD=0.2128p PS=1.5u PD=1.5u rfmode=0
M$2545 VDD|VPWR|vdd \$69029 A|Q VDD|VPWR|vdd sg13_lv_pmos L=0.13u W=1.12u
+ AS=0.2128p AD=0.3808p PS=1.5u PD=2.92u rfmode=0
M$2546 VDD|VPWR|vdd D|Y \$69039 VDD|VPWR|vdd sg13_lv_pmos L=0.13u W=0.42u
+ AS=0.1428p AD=0.0798p PS=1.52u PD=0.8u rfmode=0
M$2547 VDD|VPWR|vdd RESET_B|Y \$69039 VDD|VPWR|vdd sg13_lv_pmos L=0.13u W=0.42u
+ AS=0.3623875p AD=0.0798p PS=2.605u PD=0.8u rfmode=0
M$2548 VDD|VPWR|vdd \$69204 \$69041 VDD|VPWR|vdd sg13_lv_pmos L=0.13u W=1u
+ AS=0.3623875p AD=0.34p PS=2.605u PD=2.68u rfmode=0
M$2549 \$69204 RESET_B|Y VDD|VPWR|vdd VDD|VPWR|vdd sg13_lv_pmos L=0.13u W=0.42u
+ AS=0.147p AD=0.1563p PS=1.54u PD=1.22u rfmode=0
M$2550 VDD|VPWR|vdd \$69041 \$69345 VDD|VPWR|vdd sg13_lv_pmos L=0.13u W=0.42u
+ AS=0.1563p AD=0.063p PS=1.22u PD=0.72u rfmode=0
M$2551 \$69345 \$69042 \$69204 VDD|VPWR|vdd sg13_lv_pmos L=0.13u W=0.42u
+ AS=0.063p AD=0.0798p PS=0.72u PD=0.8u rfmode=0
M$2552 \$69204 \$69205 \$69039 VDD|VPWR|vdd sg13_lv_pmos L=0.13u W=0.42u
+ AS=0.0798p AD=0.1428p PS=0.8u PD=1.52u rfmode=0
M$2553 \$69102 \$69205 \$69346 VDD|VPWR|vdd sg13_lv_pmos L=0.13u W=0.42u
+ AS=0.2048p AD=0.09345p PS=1.63u PD=0.865u rfmode=0
M$2554 \$69346 \$69206 VDD|VPWR|vdd VDD|VPWR|vdd sg13_lv_pmos L=0.13u W=0.42u
+ AS=0.09345p AD=0.204p PS=0.865u PD=1.835u rfmode=0
M$2555 VDD|VPWR|vdd RESET_B|Y \$69206 VDD|VPWR|vdd sg13_lv_pmos L=0.13u W=0.42u
+ AS=0.204p AD=0.0798p PS=1.835u PD=0.8u rfmode=0
M$2556 VDD|VPWR|vdd \$69102 \$69206 VDD|VPWR|vdd sg13_lv_pmos L=0.13u W=0.42u
+ AS=0.2639p AD=0.0798p PS=1.81u PD=0.8u rfmode=0
M$2557 \$69041 \$69042 \$69102 VDD|VPWR|vdd sg13_lv_pmos L=0.13u W=1u AS=0.34p
+ AD=0.2048p PS=2.68u PD=1.63u rfmode=0
M$2558 VDD|VPWR|vdd \$69102 Q_N$1 VDD|VPWR|vdd sg13_lv_pmos L=0.13u W=1.12u
+ AS=0.2639p AD=0.4312p PS=1.81u PD=3.01u rfmode=0
M$2559 VDD|VPWR|vdd B|D|Y \$69051 VDD|VPWR|vdd sg13_lv_pmos L=0.13u W=0.42u
+ AS=0.1428p AD=0.0798p PS=1.52u PD=0.8u rfmode=0
M$2560 VDD|VPWR|vdd RESET_B|Y \$69051 VDD|VPWR|vdd sg13_lv_pmos L=0.13u W=0.42u
+ AS=0.3623875p AD=0.0798p PS=2.605u PD=0.8u rfmode=0
M$2561 VDD|VPWR|vdd \$69211 \$69053 VDD|VPWR|vdd sg13_lv_pmos L=0.13u W=1u
+ AS=0.3623875p AD=0.34p PS=2.605u PD=2.68u rfmode=0
M$2562 \$69211 RESET_B|Y VDD|VPWR|vdd VDD|VPWR|vdd sg13_lv_pmos L=0.13u W=0.42u
+ AS=0.147p AD=0.1563p PS=1.54u PD=1.22u rfmode=0
M$2563 VDD|VPWR|vdd \$69053 \$69349 VDD|VPWR|vdd sg13_lv_pmos L=0.13u W=0.42u
+ AS=0.1563p AD=0.063p PS=1.22u PD=0.72u rfmode=0
M$2564 \$69349 \$69054 \$69211 VDD|VPWR|vdd sg13_lv_pmos L=0.13u W=0.42u
+ AS=0.063p AD=0.0798p PS=0.72u PD=0.8u rfmode=0
M$2565 \$69211 \$69212 \$69051 VDD|VPWR|vdd sg13_lv_pmos L=0.13u W=0.42u
+ AS=0.0798p AD=0.1428p PS=0.8u PD=1.52u rfmode=0
M$2566 \$69110 \$69212 \$69353 VDD|VPWR|vdd sg13_lv_pmos L=0.13u W=0.42u
+ AS=0.2048p AD=0.09345p PS=1.63u PD=0.865u rfmode=0
M$2567 \$69353 \$69214 VDD|VPWR|vdd VDD|VPWR|vdd sg13_lv_pmos L=0.13u W=0.42u
+ AS=0.09345p AD=0.204p PS=0.865u PD=1.835u rfmode=0
M$2568 VDD|VPWR|vdd RESET_B|Y \$69214 VDD|VPWR|vdd sg13_lv_pmos L=0.13u W=0.42u
+ AS=0.204p AD=0.0798p PS=1.835u PD=0.8u rfmode=0
M$2569 VDD|VPWR|vdd \$69110 \$69214 VDD|VPWR|vdd sg13_lv_pmos L=0.13u W=0.42u
+ AS=0.2639p AD=0.0798p PS=1.81u PD=0.8u rfmode=0
M$2570 \$69053 \$69054 \$69110 VDD|VPWR|vdd sg13_lv_pmos L=0.13u W=1u AS=0.34p
+ AD=0.2048p PS=2.68u PD=1.63u rfmode=0
M$2571 VDD|VPWR|vdd \$69110 Q_N$2 VDD|VPWR|vdd sg13_lv_pmos L=0.13u W=1.12u
+ AS=0.2639p AD=0.4312p PS=1.81u PD=3.01u rfmode=0
M$2572 A|Y$11 A|X$39 VDD|VPWR|vdd VDD|VPWR|vdd sg13_lv_pmos L=0.13u W=1.12u
+ AS=0.3808p AD=0.3808p PS=2.92u PD=2.92u rfmode=0
M$2573 VDD|VPWR|vdd A|Y$14 A|Y$12 VDD|VPWR|vdd sg13_lv_pmos L=0.13u W=1.12u
+ AS=0.3808p AD=0.3808p PS=2.92u PD=2.92u rfmode=0
M$2574 A|Y$1 A|X$33 VDD|VPWR|vdd VDD|VPWR|vdd sg13_lv_pmos L=0.13u W=1.12u
+ AS=0.3808p AD=0.3808p PS=2.92u PD=2.92u rfmode=0
M$2575 A|Y$2 A|X$34 VDD|VPWR|vdd VDD|VPWR|vdd sg13_lv_pmos L=0.13u W=1.12u
+ AS=0.3808p AD=0.3808p PS=2.92u PD=2.92u rfmode=0
M$2576 A|Y$6 A|X$35 VDD|VPWR|vdd VDD|VPWR|vdd sg13_lv_pmos L=0.13u W=1.12u
+ AS=0.3808p AD=0.3808p PS=2.92u PD=2.92u rfmode=0
M$2577 VDD|VPWR|vdd A1|Y \$69509 VDD|VPWR|vdd sg13_lv_pmos L=0.13u W=1.12u
+ AS=0.3808p AD=0.2716p PS=2.92u PD=1.605u rfmode=0
M$2578 \$69509 B1|Y D|Y VDD|VPWR|vdd sg13_lv_pmos L=0.13u W=1.12u AS=0.2716p
+ AD=0.2128p PS=1.605u PD=1.5u rfmode=0
M$2579 D|Y B2|Y \$69509 VDD|VPWR|vdd sg13_lv_pmos L=0.13u W=1.12u AS=0.2128p
+ AD=0.2744p PS=1.5u PD=1.61u rfmode=0
M$2580 \$69509 A2|B|B1|Y VDD|VPWR|vdd VDD|VPWR|vdd sg13_lv_pmos L=0.13u W=1.12u
+ AS=0.2744p AD=0.3808p PS=1.61u PD=2.92u rfmode=0
M$2581 VDD|VPWR|vdd A|X$54 A|Y$7 VDD|VPWR|vdd sg13_lv_pmos L=0.13u W=1.12u
+ AS=0.3808p AD=0.3808p PS=2.92u PD=2.92u rfmode=0
M$2582 VDD|VPWR|vdd A|X$1 \$69569 VDD|VPWR|vdd sg13_lv_pmos L=0.13u W=0.84u
+ AS=0.2114p AD=0.2856p PS=1.54u PD=2.36u rfmode=0
M$2583 X|in_l_sw[0]|nl_sw[0]|x \$69569 VDD|VPWR|vdd VDD|VPWR|vdd sg13_lv_pmos
+ L=0.13u W=1.12u AS=0.42p AD=0.2114p PS=2.99u PD=1.54u rfmode=0
M$2584 VDD|VPWR|vdd A|X$2 \$69572 VDD|VPWR|vdd sg13_lv_pmos L=0.13u W=0.84u
+ AS=0.2114p AD=0.2856p PS=1.54u PD=2.36u rfmode=0
M$2585 X|in_h_sw[0]|nh_sw[0]|x \$69572 VDD|VPWR|vdd VDD|VPWR|vdd sg13_lv_pmos
+ L=0.13u W=1.12u AS=0.42p AD=0.2114p PS=2.99u PD=1.54u rfmode=0
M$2586 VDD|VPWR|vdd
+ BOTTOM|TOP|VGND|VSS|anode|cathode|core|h_sw[0]|h_sw[10]|h_sw[1]|h_sw[2]|h_sw[3]|h_sw[4]|h_sw[5]|h_sw[6]|h_sw[7]|h_sw[8]|h_sw[9]|l_sw[0]|l_sw[10]|l_sw[1]|l_sw[2]|l_sw[3]|l_sw[4]|l_sw[5]|l_sw[6]|l_sw[7]|l_sw[8]|l_sw[9]|out|pad|padres|vc|vcp|vdd|vddr|vip|vss|z
+ VDD|VPWR|vdd VDD|VPWR|vdd sg13_lv_pmos L=1u W=40u AS=11.65p AD=11.65p
+ PS=90.3u PD=90.3u rfmode=0
M$2587 \$69573 A|X$3 VDD|VPWR|vdd VDD|VPWR|vdd sg13_lv_pmos L=0.13u W=0.84u
+ AS=0.2856p AD=0.2114p PS=2.36u PD=1.54u rfmode=0
M$2588 VDD|VPWR|vdd \$69573 X|in_h_sw[1]|nh_sw[1]|x VDD|VPWR|vdd sg13_lv_pmos
+ L=0.13u W=1.12u AS=0.2114p AD=0.42p PS=1.54u PD=2.99u rfmode=0
M$2589 \$69575 \$69616 \$69614 VDD|VPWR|vdd sg13_lv_pmos L=0.13u W=0.42u
+ AS=0.191p AD=0.1008p PS=1.44u PD=0.9u rfmode=0
M$2590 \$69614 \$69576 VDD|VPWR|vdd VDD|VPWR|vdd sg13_lv_pmos L=0.13u W=0.42u
+ AS=0.1008p AD=0.2387p PS=0.9u PD=1.84u rfmode=0
M$2591 VDD|VPWR|vdd \$69615 \$69616 VDD|VPWR|vdd sg13_lv_pmos L=0.13u W=0.84u
+ AS=0.26675p AD=0.2856p PS=1.845u PD=2.36u rfmode=0
M$2592 VDD|VPWR|vdd \$69574 \$69835 VDD|VPWR|vdd sg13_lv_pmos L=0.13u W=1u
+ AS=0.26675p AD=0.105p PS=1.845u PD=1.21u rfmode=0
M$2593 \$69835 \$69615 \$69575 VDD|VPWR|vdd sg13_lv_pmos L=0.13u W=1u AS=0.105p
+ AD=0.191p PS=1.21u PD=1.44u rfmode=0
M$2594 VDD|VPWR|vdd \$69575 \$69576 VDD|VPWR|vdd sg13_lv_pmos L=0.13u W=1.12u
+ AS=0.2387p AD=0.2128p PS=1.84u PD=1.5u rfmode=0
M$2595 \$69576 RESET_B|Y$1 VDD|VPWR|vdd VDD|VPWR|vdd sg13_lv_pmos L=0.13u
+ W=1.12u AS=0.2128p AD=0.2128p PS=1.5u PD=1.5u rfmode=0
M$2596 VDD|VPWR|vdd \$69576 A|Q$2 VDD|VPWR|vdd sg13_lv_pmos L=0.13u W=1.12u
+ AS=0.2128p AD=0.3808p PS=1.5u PD=2.92u rfmode=0
M$2597 \$69578 \$69576 VDD|VPWR|vdd VDD|VPWR|vdd sg13_lv_pmos L=0.13u W=0.84u
+ AS=0.2856p AD=0.1974p PS=2.36u PD=1.5u rfmode=0
M$2598 VDD|VPWR|vdd \$69578 Q_N$3 VDD|VPWR|vdd sg13_lv_pmos L=0.13u W=1.12u
+ AS=0.1974p AD=0.3808p PS=1.5u PD=2.92u rfmode=0
M$2599 \$69584 \$70005 VDD|VPWR|vdd VDD|VPWR|vdd sg13_lv_pmos L=0.13u W=1.12u
+ AS=0.3864p AD=0.2128p PS=2.93u PD=1.5u rfmode=0
M$2600 VDD|VPWR|vdd \$69584 A1|D|Q VDD|VPWR|vdd sg13_lv_pmos L=0.13u W=1.12u
+ AS=0.2128p AD=0.3808p PS=1.5u PD=2.92u rfmode=0
M$2601 VDD|VPWR|vdd A|Q \$69586 VDD|VPWR|vdd sg13_lv_pmos L=0.13u W=0.84u
+ AS=0.2114p AD=0.2856p PS=1.54u PD=2.36u rfmode=0
M$2602 A|X$29 \$69586 VDD|VPWR|vdd VDD|VPWR|vdd sg13_lv_pmos L=0.13u W=1.12u
+ AS=0.42p AD=0.2114p PS=2.99u PD=1.54u rfmode=0
M$2603 VDD|VPWR|vdd A|Q$3 \$69587 VDD|VPWR|vdd sg13_lv_pmos L=0.13u W=0.84u
+ AS=0.2114p AD=0.2856p PS=1.54u PD=2.36u rfmode=0
M$2604 A|X$23 \$69587 VDD|VPWR|vdd VDD|VPWR|vdd sg13_lv_pmos L=0.13u W=1.12u
+ AS=0.42p AD=0.2114p PS=2.99u PD=1.54u rfmode=0
M$2605 VDD|VPWR|vdd A|X$7 \$69588 VDD|VPWR|vdd sg13_lv_pmos L=0.13u W=0.84u
+ AS=0.2114p AD=0.2856p PS=1.54u PD=2.36u rfmode=0
M$2606 X|in_l_sw[4]|nl_sw[4]|x \$69588 VDD|VPWR|vdd VDD|VPWR|vdd sg13_lv_pmos
+ L=0.13u W=1.12u AS=0.42p AD=0.2114p PS=2.99u PD=1.54u rfmode=0
M$2607 VDD|VPWR|vdd A|X$6 \$69589 VDD|VPWR|vdd sg13_lv_pmos L=0.13u W=0.84u
+ AS=0.2114p AD=0.2856p PS=1.54u PD=2.36u rfmode=0
M$2608 X|in_h_sw[4]|nh_sw[4]|x \$69589 VDD|VPWR|vdd VDD|VPWR|vdd sg13_lv_pmos
+ L=0.13u W=1.12u AS=0.42p AD=0.2114p PS=2.99u PD=1.54u rfmode=0
M$2609 VDD|VPWR|vdd A|B_N|Q \$69590 VDD|VPWR|vdd sg13_lv_pmos L=0.13u W=0.84u
+ AS=0.4536p AD=0.1596p PS=2.76u PD=1.22u rfmode=0
M$2610 VDD|VPWR|vdd A2|B|B1|Y \$69590 VDD|VPWR|vdd sg13_lv_pmos L=0.13u W=0.84u
+ AS=0.2891p AD=0.1596p PS=1.695u PD=1.22u rfmode=0
M$2611 VDD|VPWR|vdd A|B_N|Q \$69841 VDD|VPWR|vdd sg13_lv_pmos L=0.13u W=1.12u
+ AS=0.2891p AD=0.1428p PS=1.695u PD=1.375u rfmode=0
M$2612 \$69841 A2|B|B1|Y D|Y$1 VDD|VPWR|vdd sg13_lv_pmos L=0.13u W=1.12u
+ AS=0.1428p AD=0.2408p PS=1.375u PD=1.55u rfmode=0
M$2613 D|Y$1 \$69590 VDD|VPWR|vdd VDD|VPWR|vdd sg13_lv_pmos L=0.13u W=1.12u
+ AS=0.2408p AD=0.3808p PS=1.55u PD=2.92u rfmode=0
M$2614 \$69597 \$70009 VDD|VPWR|vdd VDD|VPWR|vdd sg13_lv_pmos L=0.13u W=1.12u
+ AS=0.3864p AD=0.2128p PS=2.93u PD=1.5u rfmode=0
M$2615 VDD|VPWR|vdd \$69597 A|B_N|Q VDD|VPWR|vdd sg13_lv_pmos L=0.13u W=1.12u
+ AS=0.2128p AD=0.3808p PS=1.5u PD=2.92u rfmode=0
M$2616 VDD|VPWR|vdd A|A_N|B|B_N|Q \$69598 VDD|VPWR|vdd sg13_lv_pmos L=0.13u
+ W=0.84u AS=0.2618p AD=0.2856p PS=1.63u PD=2.36u rfmode=0
M$2617 VDD|VPWR|vdd \$69598 \$69848 VDD|VPWR|vdd sg13_lv_pmos L=0.13u W=1.12u
+ AS=0.2618p AD=0.1176p PS=1.63u PD=1.33u rfmode=0
M$2618 \$69848 A|B|B_N|Q D|Y$2 VDD|VPWR|vdd sg13_lv_pmos L=0.13u W=1.12u
+ AS=0.1176p AD=0.3808p PS=1.33u PD=2.92u rfmode=0
M$2619 A|A1|B|Y A|A_N|B|B_N|Q \$69847 VDD|VPWR|vdd sg13_lv_pmos L=0.13u W=1.12u
+ AS=0.3808p AD=0.1176p PS=2.92u PD=1.33u rfmode=0
M$2620 \$69847 \$69600 VDD|VPWR|vdd VDD|VPWR|vdd sg13_lv_pmos L=0.13u W=1.12u
+ AS=0.1176p AD=0.2618p PS=1.33u PD=1.63u rfmode=0
M$2621 VDD|VPWR|vdd A|B|B_N|Q \$69600 VDD|VPWR|vdd sg13_lv_pmos L=0.13u W=0.84u
+ AS=0.2618p AD=0.2856p PS=1.63u PD=2.36u rfmode=0
M$2622 \$69605 \$70011 VDD|VPWR|vdd VDD|VPWR|vdd sg13_lv_pmos L=0.13u W=1.12u
+ AS=0.3864p AD=0.2128p PS=2.93u PD=1.5u rfmode=0
M$2623 VDD|VPWR|vdd \$69605 A|B|B_N|Q VDD|VPWR|vdd sg13_lv_pmos L=0.13u W=1.12u
+ AS=0.2128p AD=0.3808p PS=1.5u PD=2.92u rfmode=0
M$2624 VDD|VPWR|vdd A|B|B_N|Q \$69852 VDD|VPWR|vdd sg13_lv_pmos L=0.13u W=1.12u
+ AS=0.4032p AD=0.1176p PS=2.96u PD=1.33u rfmode=0
M$2625 \$69852 A|A_N|B|B_N|Q B|D|Y VDD|VPWR|vdd sg13_lv_pmos L=0.13u W=1.12u
+ AS=0.1176p AD=0.3808p PS=1.33u PD=2.92u rfmode=0
M$2626 \$69606 A|Y$13 VDD|VPWR|vdd VDD|VPWR|vdd sg13_lv_pmos L=0.13u W=0.84u
+ AS=0.2856p AD=0.2114p PS=2.36u PD=1.54u rfmode=0
M$2627 VDD|VPWR|vdd \$69606 A|X$30 VDD|VPWR|vdd sg13_lv_pmos L=0.13u W=1.12u
+ AS=0.2114p AD=0.42p PS=1.54u PD=2.99u rfmode=0
M$2628 \$69608 A|X$32 VDD|VPWR|vdd VDD|VPWR|vdd sg13_lv_pmos L=0.13u W=0.84u
+ AS=0.2856p AD=0.2114p PS=2.36u PD=1.54u rfmode=0
M$2629 VDD|VPWR|vdd \$69608 A|X$31 VDD|VPWR|vdd sg13_lv_pmos L=0.13u W=1.12u
+ AS=0.2114p AD=0.42p PS=1.54u PD=2.99u rfmode=0
M$2630 VDD|VPWR|vdd A|X$30 \$69610 VDD|VPWR|vdd sg13_lv_pmos L=0.13u W=0.84u
+ AS=0.2114p AD=0.2856p PS=1.54u PD=2.36u rfmode=0
M$2631 X|in_l_sw[9]|nl_sw[9]|x \$69610 VDD|VPWR|vdd VDD|VPWR|vdd sg13_lv_pmos
+ L=0.13u W=1.12u AS=0.42p AD=0.2114p PS=2.99u PD=1.54u rfmode=0
M$2632 VDD|VPWR|vdd A|X$31 \$69611 VDD|VPWR|vdd sg13_lv_pmos L=0.13u W=0.84u
+ AS=0.2114p AD=0.2856p PS=1.54u PD=2.36u rfmode=0
M$2633 X|in_h_sw[9]|nh_sw[9]|x \$69611 VDD|VPWR|vdd VDD|VPWR|vdd sg13_lv_pmos
+ L=0.13u W=1.12u AS=0.42p AD=0.2114p PS=2.99u PD=1.54u rfmode=0
M$2634 VDD|VPWR|vdd A|X$15 \$69612 VDD|VPWR|vdd sg13_lv_pmos L=0.13u W=0.84u
+ AS=0.2114p AD=0.2856p PS=1.54u PD=2.36u rfmode=0
M$2635 X|in_l_sw[10]|nl_sw[10]|x \$69612 VDD|VPWR|vdd VDD|VPWR|vdd sg13_lv_pmos
+ L=0.13u W=1.12u AS=0.42p AD=0.2114p PS=2.99u PD=1.54u rfmode=0
M$2636 \$69613 A|Q$1 VDD|VPWR|vdd VDD|VPWR|vdd sg13_lv_pmos L=0.13u W=0.84u
+ AS=0.2856p AD=0.2114p PS=2.36u PD=1.54u rfmode=0
M$2637 VDD|VPWR|vdd \$69613 X|anode|cathode|core|d_out[0]|dout[0]|pad|padres
+ VDD|VPWR|vdd sg13_lv_pmos L=0.13u W=1.12u AS=0.2114p AD=0.42p PS=1.54u
+ PD=2.99u rfmode=0
M$2639 VDD|VPWR|vdd A|anode|cathode|ck|cks|core|pad|padres A|Y VDD|VPWR|vdd
+ sg13_lv_pmos L=0.13u W=1.12u AS=0.3808p AD=0.3808p PS=2.92u PD=2.92u rfmode=0
M$2640 VDD|VPWR|vdd A|Y Y VDD|VPWR|vdd sg13_lv_pmos L=0.13u W=1.12u AS=0.3808p
+ AD=0.3808p PS=2.92u PD=2.92u rfmode=0
M$2642 \$70281 \$70280 VDD|VPWR|vdd VDD|VPWR|vdd sg13_lv_pmos L=0.25u W=1u
+ AS=0.445p AD=0.2245p PS=2.89u PD=1.53u rfmode=0
M$2643 VDD|VPWR|vdd \$70281 A|X$36 VDD|VPWR|vdd sg13_lv_pmos L=0.13u W=1.12u
+ AS=0.2245p AD=0.3808p PS=1.53u PD=2.92u rfmode=0
M$2644 VDD|VPWR|vdd A|X \$70283 VDD|VPWR|vdd sg13_lv_pmos L=0.13u W=0.84u
+ AS=0.2114p AD=0.2856p PS=1.54u PD=2.36u rfmode=0
M$2645 VDD|VPWR|vdd \$70283 D|X VDD|VPWR|vdd sg13_lv_pmos L=0.13u W=1.12u
+ AS=0.2114p AD=0.42p PS=1.54u PD=2.99u rfmode=0
M$2646 \$70398 \$70172 VDD|VPWR|vdd VDD|VPWR|vdd sg13_lv_pmos L=0.13u W=1.12u
+ AS=0.3864p AD=0.41165p PS=2.93u PD=2.12u rfmode=0
M$2647 VDD|VPWR|vdd CLK|D|GATE|Q \$70172 VDD|VPWR|vdd sg13_lv_pmos L=0.13u
+ W=1.12u AS=0.41165p AD=0.4088p PS=2.12u PD=2.97u rfmode=0
M$2648 VDD|VPWR|vdd D|Q_N$1 \$69574 VDD|VPWR|vdd sg13_lv_pmos L=0.13u W=0.84u
+ AS=0.3018p AD=0.2856p PS=1.97u PD=2.36u rfmode=0
M$2649 VDD|VPWR|vdd CLK|D|GATE|Q \$69615 VDD|VPWR|vdd sg13_lv_pmos L=0.13u
+ W=0.84u AS=0.3018p AD=0.3234p PS=1.97u PD=2.45u rfmode=0
M$2650 \$70175 \$70286 VDD|VPWR|vdd VDD|VPWR|vdd sg13_lv_pmos L=0.13u W=1.12u
+ AS=0.3864p AD=0.2128p PS=2.93u PD=1.5u rfmode=0
M$2651 VDD|VPWR|vdd \$70175 A1|D|Q$1 VDD|VPWR|vdd sg13_lv_pmos L=0.13u W=1.12u
+ AS=0.2128p AD=0.3808p PS=1.5u PD=2.92u rfmode=0
M$2652 VDD|VPWR|vdd D|X \$69507 VDD|VPWR|vdd sg13_lv_pmos L=0.13u W=0.42u
+ AS=0.1428p AD=0.0798p PS=1.52u PD=0.8u rfmode=0
M$2653 VDD|VPWR|vdd RESET_B|Y$1 \$69507 VDD|VPWR|vdd sg13_lv_pmos L=0.13u
+ W=0.42u AS=0.3623875p AD=0.0798p PS=2.605u PD=0.8u rfmode=0
M$2654 VDD|VPWR|vdd \$69581 \$69580 VDD|VPWR|vdd sg13_lv_pmos L=0.13u W=1u
+ AS=0.3623875p AD=0.34p PS=2.605u PD=2.68u rfmode=0
M$2655 VDD|VPWR|vdd RESET_B|Y$1 \$69581 VDD|VPWR|vdd sg13_lv_pmos L=0.13u
+ W=0.42u AS=0.1563p AD=0.147p PS=1.22u PD=1.54u rfmode=0
M$2656 VDD|VPWR|vdd \$69580 \$69836 VDD|VPWR|vdd sg13_lv_pmos L=0.13u W=0.42u
+ AS=0.1563p AD=0.063p PS=1.22u PD=0.72u rfmode=0
M$2657 \$69836 \$69617 \$69581 VDD|VPWR|vdd sg13_lv_pmos L=0.13u W=0.42u
+ AS=0.063p AD=0.0798p PS=0.72u PD=0.8u rfmode=0
M$2658 \$69581 \$69582 \$69507 VDD|VPWR|vdd sg13_lv_pmos L=0.13u W=0.42u
+ AS=0.0798p AD=0.1428p PS=0.8u PD=1.52u rfmode=0
M$2659 VDD|VPWR|vdd \$69617 \$69582 VDD|VPWR|vdd sg13_lv_pmos L=0.13u W=1.12u
+ AS=0.41165p AD=0.3864p PS=2.12u PD=2.93u rfmode=0
M$2660 VDD|VPWR|vdd CLK|D|GATE|Q$1 \$69617 VDD|VPWR|vdd sg13_lv_pmos L=0.13u
+ W=1.12u AS=0.41165p AD=0.4088p PS=2.12u PD=2.97u rfmode=0
M$2661 VDD|VPWR|vdd \$70177 \$70179 VDD|VPWR|vdd sg13_lv_pmos L=0.13u W=0.84u
+ AS=0.1974p AD=0.2856p PS=1.5u PD=2.36u rfmode=0
M$2662 VDD|VPWR|vdd \$70179 Q_N$6 VDD|VPWR|vdd sg13_lv_pmos L=0.13u W=1.12u
+ AS=0.1974p AD=0.3808p PS=1.5u PD=2.92u rfmode=0
M$2663 \$69580 \$69617 \$70005 VDD|VPWR|vdd sg13_lv_pmos L=0.13u W=1u AS=0.34p
+ AD=0.2048p PS=2.68u PD=1.63u rfmode=0
M$2664 \$70005 \$69582 \$69839 VDD|VPWR|vdd sg13_lv_pmos L=0.13u W=0.42u
+ AS=0.2048p AD=0.09345p PS=1.63u PD=0.865u rfmode=0
M$2665 VDD|VPWR|vdd \$69618 \$69839 VDD|VPWR|vdd sg13_lv_pmos L=0.13u W=0.42u
+ AS=0.204p AD=0.09345p PS=1.835u PD=0.865u rfmode=0
M$2666 VDD|VPWR|vdd RESET_B|Y$1 \$69618 VDD|VPWR|vdd sg13_lv_pmos L=0.13u
+ W=0.42u AS=0.204p AD=0.0798p PS=1.835u PD=0.8u rfmode=0
M$2667 VDD|VPWR|vdd \$70005 \$69618 VDD|VPWR|vdd sg13_lv_pmos L=0.13u W=0.42u
+ AS=0.2639p AD=0.0798p PS=1.81u PD=0.8u rfmode=0
M$2668 VDD|VPWR|vdd \$70005 D|Q_N VDD|VPWR|vdd sg13_lv_pmos L=0.13u W=1.12u
+ AS=0.2639p AD=0.4312p PS=1.81u PD=3.01u rfmode=0
M$2669 VDD|VPWR|vdd \$70181 \$70182 VDD|VPWR|vdd sg13_lv_pmos L=0.13u W=0.84u
+ AS=0.1974p AD=0.2856p PS=1.5u PD=2.36u rfmode=0
M$2670 VDD|VPWR|vdd \$70182 Q_N$7 VDD|VPWR|vdd sg13_lv_pmos L=0.13u W=1.12u
+ AS=0.1974p AD=0.3808p PS=1.5u PD=2.92u rfmode=0
M$2671 X|in_l_sw[5]|nl_sw[5]|x \$70295 VDD|VPWR|vdd VDD|VPWR|vdd sg13_lv_pmos
+ L=0.13u W=1.12u AS=0.42p AD=0.2114p PS=2.99u PD=1.54u rfmode=0
M$2672 VDD|VPWR|vdd A|X$8 \$70295 VDD|VPWR|vdd sg13_lv_pmos L=0.13u W=0.84u
+ AS=0.2114p AD=0.2856p PS=1.54u PD=2.36u rfmode=0
M$2673 VDD|VPWR|vdd A|A1|B|Y B1|Y$1 VDD|VPWR|vdd sg13_lv_pmos L=0.13u W=1.12u
+ AS=0.3808p AD=0.2128p PS=2.92u PD=1.5u rfmode=0
M$2674 B1|Y$1 A|B_N|Q VDD|VPWR|vdd VDD|VPWR|vdd sg13_lv_pmos L=0.13u W=1.12u
+ AS=0.2128p AD=0.3808p PS=1.5u PD=2.92u rfmode=0
M$2675 VDD|VPWR|vdd B|Y A2|Y VDD|VPWR|vdd sg13_lv_pmos L=0.13u W=1.12u
+ AS=0.3808p AD=0.2128p PS=2.92u PD=1.5u rfmode=0
M$2676 A2|Y A|A1|B|Y VDD|VPWR|vdd VDD|VPWR|vdd sg13_lv_pmos L=0.13u W=1.12u
+ AS=0.2128p AD=0.3808p PS=1.5u PD=2.92u rfmode=0
M$2677 VDD|VPWR|vdd D|Y$1 \$69510 VDD|VPWR|vdd sg13_lv_pmos L=0.13u W=0.42u
+ AS=0.1428p AD=0.0798p PS=1.52u PD=0.8u rfmode=0
M$2678 VDD|VPWR|vdd RESET_B|Y \$69510 VDD|VPWR|vdd sg13_lv_pmos L=0.13u W=0.42u
+ AS=0.3623875p AD=0.0798p PS=2.605u PD=0.8u rfmode=0
M$2679 VDD|VPWR|vdd \$69594 \$69593 VDD|VPWR|vdd sg13_lv_pmos L=0.13u W=1u
+ AS=0.3623875p AD=0.34p PS=2.605u PD=2.68u rfmode=0
M$2680 X|in_h_sw[5]|nh_sw[5]|x \$70298 VDD|VPWR|vdd VDD|VPWR|vdd sg13_lv_pmos
+ L=0.13u W=1.12u AS=0.42p AD=0.2114p PS=2.99u PD=1.54u rfmode=0
M$2681 VDD|VPWR|vdd A|X$9 \$70298 VDD|VPWR|vdd sg13_lv_pmos L=0.13u W=0.84u
+ AS=0.2114p AD=0.2856p PS=1.54u PD=2.36u rfmode=0
M$2682 VDD|VPWR|vdd RESET_B|Y \$69594 VDD|VPWR|vdd sg13_lv_pmos L=0.13u W=0.42u
+ AS=0.1563p AD=0.147p PS=1.22u PD=1.54u rfmode=0
M$2683 VDD|VPWR|vdd \$69593 \$69843 VDD|VPWR|vdd sg13_lv_pmos L=0.13u W=0.42u
+ AS=0.1563p AD=0.063p PS=1.22u PD=0.72u rfmode=0
M$2684 \$69843 \$69622 \$69594 VDD|VPWR|vdd sg13_lv_pmos L=0.13u W=0.42u
+ AS=0.063p AD=0.0798p PS=0.72u PD=0.8u rfmode=0
M$2685 \$69594 \$69595 \$69510 VDD|VPWR|vdd sg13_lv_pmos L=0.13u W=0.42u
+ AS=0.0798p AD=0.1428p PS=0.8u PD=1.52u rfmode=0
M$2686 VDD|VPWR|vdd A|X$10 \$70299 VDD|VPWR|vdd sg13_lv_pmos L=0.13u W=0.84u
+ AS=0.2114p AD=0.2856p PS=1.54u PD=2.36u rfmode=0
M$2687 VDD|VPWR|vdd \$70299 X|in_l_sw[6]|nl_sw[6]|x VDD|VPWR|vdd sg13_lv_pmos
+ L=0.13u W=1.12u AS=0.2114p AD=0.42p PS=1.54u PD=2.99u rfmode=0
M$2688 VDD|VPWR|vdd \$69622 \$69595 VDD|VPWR|vdd sg13_lv_pmos L=0.13u W=1.12u
+ AS=0.41165p AD=0.3864p PS=2.12u PD=2.93u rfmode=0
M$2689 VDD|VPWR|vdd CLK|Y \$69622 VDD|VPWR|vdd sg13_lv_pmos L=0.13u W=1.12u
+ AS=0.41165p AD=0.4088p PS=2.12u PD=2.97u rfmode=0
M$2690 VDD|VPWR|vdd A|X$38 \$70300 VDD|VPWR|vdd sg13_lv_pmos L=0.13u W=0.84u
+ AS=0.2114p AD=0.2856p PS=1.54u PD=2.36u rfmode=0
M$2691 VDD|VPWR|vdd \$70300 A|X$26 VDD|VPWR|vdd sg13_lv_pmos L=0.13u W=1.12u
+ AS=0.2114p AD=0.42p PS=1.54u PD=2.99u rfmode=0
M$2692 \$69593 \$69622 \$70009 VDD|VPWR|vdd sg13_lv_pmos L=0.13u W=1u AS=0.34p
+ AD=0.2048p PS=2.68u PD=1.63u rfmode=0
M$2693 \$70009 \$69595 \$69844 VDD|VPWR|vdd sg13_lv_pmos L=0.13u W=0.42u
+ AS=0.2048p AD=0.09345p PS=1.63u PD=0.865u rfmode=0
M$2694 VDD|VPWR|vdd \$69623 \$69844 VDD|VPWR|vdd sg13_lv_pmos L=0.13u W=0.42u
+ AS=0.204p AD=0.09345p PS=1.835u PD=0.865u rfmode=0
M$2695 VDD|VPWR|vdd RESET_B|Y \$69623 VDD|VPWR|vdd sg13_lv_pmos L=0.13u W=0.42u
+ AS=0.204p AD=0.0798p PS=1.835u PD=0.8u rfmode=0
M$2696 VDD|VPWR|vdd \$70009 \$69623 VDD|VPWR|vdd sg13_lv_pmos L=0.13u W=0.42u
+ AS=0.2639p AD=0.0798p PS=1.81u PD=0.8u rfmode=0
M$2697 VDD|VPWR|vdd \$70009 Q_N$4 VDD|VPWR|vdd sg13_lv_pmos L=0.13u W=1.12u
+ AS=0.2639p AD=0.4312p PS=1.81u PD=3.01u rfmode=0
M$2698 \$70399 \$70187 VDD|VPWR|vdd VDD|VPWR|vdd sg13_lv_pmos L=0.13u W=1.12u
+ AS=0.3864p AD=0.41165p PS=2.93u PD=2.12u rfmode=0
M$2699 VDD|VPWR|vdd CLK|Y \$70187 VDD|VPWR|vdd sg13_lv_pmos L=0.13u W=1.12u
+ AS=0.41165p AD=0.4088p PS=2.12u PD=2.97u rfmode=0
M$2700 VDD|VPWR|vdd D|Y$2 \$69511 VDD|VPWR|vdd sg13_lv_pmos L=0.13u W=0.42u
+ AS=0.1428p AD=0.0798p PS=1.52u PD=0.8u rfmode=0
M$2701 VDD|VPWR|vdd RESET_B|Y \$69511 VDD|VPWR|vdd sg13_lv_pmos L=0.13u W=0.42u
+ AS=0.3623875p AD=0.0798p PS=2.605u PD=0.8u rfmode=0
M$2702 VDD|VPWR|vdd \$69602 \$69601 VDD|VPWR|vdd sg13_lv_pmos L=0.13u W=1u
+ AS=0.3623875p AD=0.34p PS=2.605u PD=2.68u rfmode=0
M$2703 \$70191 \$70303 VDD|VPWR|vdd VDD|VPWR|vdd sg13_lv_pmos L=0.13u W=1.12u
+ AS=0.3864p AD=0.2128p PS=2.93u PD=1.5u rfmode=0
M$2704 VDD|VPWR|vdd \$70191 A|Q$5 VDD|VPWR|vdd sg13_lv_pmos L=0.13u W=1.12u
+ AS=0.2128p AD=0.3808p PS=1.5u PD=2.92u rfmode=0
M$2705 VDD|VPWR|vdd RESET_B|Y \$69602 VDD|VPWR|vdd sg13_lv_pmos L=0.13u W=0.42u
+ AS=0.1563p AD=0.147p PS=1.22u PD=1.54u rfmode=0
M$2706 VDD|VPWR|vdd \$69601 \$69849 VDD|VPWR|vdd sg13_lv_pmos L=0.13u W=0.42u
+ AS=0.1563p AD=0.063p PS=1.22u PD=0.72u rfmode=0
M$2707 \$69849 \$69624 \$69602 VDD|VPWR|vdd sg13_lv_pmos L=0.13u W=0.42u
+ AS=0.063p AD=0.0798p PS=0.72u PD=0.8u rfmode=0
M$2708 \$69602 \$69603 \$69511 VDD|VPWR|vdd sg13_lv_pmos L=0.13u W=0.42u
+ AS=0.0798p AD=0.1428p PS=0.8u PD=1.52u rfmode=0
M$2709 X|in_h_sw[7]|nh_sw[7]|x \$70304 VDD|VPWR|vdd VDD|VPWR|vdd sg13_lv_pmos
+ L=0.13u W=1.12u AS=0.42p AD=0.2114p PS=2.99u PD=1.54u rfmode=0
M$2710 VDD|VPWR|vdd A|X$12 \$70304 VDD|VPWR|vdd sg13_lv_pmos L=0.13u W=0.84u
+ AS=0.2114p AD=0.2856p PS=1.54u PD=2.36u rfmode=0
M$2711 X|in_l_sw[8]|nl_sw[8]|x \$70305 VDD|VPWR|vdd VDD|VPWR|vdd sg13_lv_pmos
+ L=0.13u W=1.12u AS=0.42p AD=0.2114p PS=2.99u PD=1.54u rfmode=0
M$2712 VDD|VPWR|vdd A|X$13 \$70305 VDD|VPWR|vdd sg13_lv_pmos L=0.13u W=0.84u
+ AS=0.2114p AD=0.2856p PS=1.54u PD=2.36u rfmode=0
M$2713 VDD|VPWR|vdd \$69624 \$69603 VDD|VPWR|vdd sg13_lv_pmos L=0.13u W=1.12u
+ AS=0.41165p AD=0.3864p PS=2.12u PD=2.93u rfmode=0
M$2714 VDD|VPWR|vdd CLK|Y \$69624 VDD|VPWR|vdd sg13_lv_pmos L=0.13u W=1.12u
+ AS=0.41165p AD=0.4088p PS=2.12u PD=2.97u rfmode=0
M$2715 \$69601 \$69624 \$70011 VDD|VPWR|vdd sg13_lv_pmos L=0.13u W=1u AS=0.34p
+ AD=0.2048p PS=2.68u PD=1.63u rfmode=0
M$2716 \$70011 \$69603 \$69851 VDD|VPWR|vdd sg13_lv_pmos L=0.13u W=0.42u
+ AS=0.2048p AD=0.09345p PS=1.63u PD=0.865u rfmode=0
M$2717 VDD|VPWR|vdd \$69625 \$69851 VDD|VPWR|vdd sg13_lv_pmos L=0.13u W=0.42u
+ AS=0.204p AD=0.09345p PS=1.835u PD=0.865u rfmode=0
M$2718 VDD|VPWR|vdd RESET_B|Y \$69625 VDD|VPWR|vdd sg13_lv_pmos L=0.13u W=0.42u
+ AS=0.204p AD=0.0798p PS=1.835u PD=0.8u rfmode=0
M$2719 VDD|VPWR|vdd \$70011 \$69625 VDD|VPWR|vdd sg13_lv_pmos L=0.13u W=0.42u
+ AS=0.2639p AD=0.0798p PS=1.81u PD=0.8u rfmode=0
M$2720 VDD|VPWR|vdd \$70011 Q_N$5 VDD|VPWR|vdd sg13_lv_pmos L=0.13u W=1.12u
+ AS=0.2639p AD=0.4312p PS=1.81u PD=3.01u rfmode=0
M$2721 X|in_h_sw[8]|nh_sw[8]|x \$70306 VDD|VPWR|vdd VDD|VPWR|vdd sg13_lv_pmos
+ L=0.13u W=1.12u AS=0.42p AD=0.2114p PS=2.99u PD=1.54u rfmode=0
M$2722 VDD|VPWR|vdd A|X$14 \$70306 VDD|VPWR|vdd sg13_lv_pmos L=0.13u W=0.84u
+ AS=0.2114p AD=0.2856p PS=1.54u PD=2.36u rfmode=0
M$2723 \$70400 \$70194 VDD|VPWR|vdd VDD|VPWR|vdd sg13_lv_pmos L=0.13u W=1.12u
+ AS=0.3864p AD=0.41165p PS=2.93u PD=2.12u rfmode=0
M$2724 VDD|VPWR|vdd CLK|Y \$70194 VDD|VPWR|vdd sg13_lv_pmos L=0.13u W=1.12u
+ AS=0.41165p AD=0.4088p PS=2.12u PD=2.97u rfmode=0
M$2725 \$70198 \$70309 VDD|VPWR|vdd VDD|VPWR|vdd sg13_lv_pmos L=0.13u W=1.12u
+ AS=0.3864p AD=0.2128p PS=2.93u PD=1.5u rfmode=0
M$2726 VDD|VPWR|vdd \$70198 A|Q$6 VDD|VPWR|vdd sg13_lv_pmos L=0.13u W=1.12u
+ AS=0.2128p AD=0.3808p PS=1.5u PD=2.92u rfmode=0
M$2727 VDD|VPWR|vdd A|X$16 \$70310 VDD|VPWR|vdd sg13_lv_pmos L=0.13u W=0.84u
+ AS=0.2114p AD=0.2856p PS=1.54u PD=2.36u rfmode=0
M$2728 VDD|VPWR|vdd \$70310 X|in_h_sw[10]|nh_sw[10]|x VDD|VPWR|vdd sg13_lv_pmos
+ L=0.13u W=1.12u AS=0.2114p AD=0.42p PS=1.54u PD=2.99u rfmode=0
M$2729 A|Y$15 A|CLK|X VDD|VPWR|vdd VDD|VPWR|vdd sg13_lv_pmos L=0.13u W=1.12u
+ AS=0.3808p AD=0.3808p PS=2.92u PD=2.92u rfmode=0
M$2730 VDD|VPWR|vdd A|Y$16 \$70279 VDD|VPWR|vdd sg13_lv_pmos L=0.13u W=0.42u
+ AS=0.2481p AD=0.1428p PS=1.56u PD=1.52u rfmode=0
M$2731 VDD|VPWR|vdd \$70279 \$70280 VDD|VPWR|vdd sg13_lv_pmos L=0.25u W=1u
+ AS=0.2481p AD=0.34p PS=1.56u PD=2.68u rfmode=0
M$2732 VDD|VPWR|vdd D|X \$70285 VDD|VPWR|vdd sg13_lv_pmos L=0.13u W=0.42u
+ AS=0.1428p AD=0.0798p PS=1.52u PD=0.8u rfmode=0
M$2733 VDD|VPWR|vdd RESET_B|Y$1 \$70285 VDD|VPWR|vdd sg13_lv_pmos L=0.13u
+ W=0.42u AS=0.3623875p AD=0.0798p PS=2.605u PD=0.8u rfmode=0
M$2734 VDD|VPWR|vdd \$70332 \$70171 VDD|VPWR|vdd sg13_lv_pmos L=0.13u W=1u
+ AS=0.3623875p AD=0.34p PS=2.605u PD=2.68u rfmode=0
M$2735 \$70286 \$70398 \$70643 VDD|VPWR|vdd sg13_lv_pmos L=0.13u W=0.42u
+ AS=0.2048p AD=0.09345p PS=1.63u PD=0.865u rfmode=0
M$2736 \$70643 \$70174 VDD|VPWR|vdd VDD|VPWR|vdd sg13_lv_pmos L=0.13u W=0.42u
+ AS=0.09345p AD=0.204p PS=0.865u PD=1.835u rfmode=0
M$2737 VDD|VPWR|vdd RESET_B|Y$1 \$70174 VDD|VPWR|vdd sg13_lv_pmos L=0.13u
+ W=0.42u AS=0.204p AD=0.0798p PS=1.835u PD=0.8u rfmode=0
M$2738 VDD|VPWR|vdd \$70286 \$70174 VDD|VPWR|vdd sg13_lv_pmos L=0.13u W=0.42u
+ AS=0.2639p AD=0.0798p PS=1.81u PD=0.8u rfmode=0
M$2739 \$70171 \$70172 \$70286 VDD|VPWR|vdd sg13_lv_pmos L=0.13u W=1u AS=0.34p
+ AD=0.2048p PS=2.68u PD=1.63u rfmode=0
M$2740 VDD|VPWR|vdd \$70286 D|Q_N$1 VDD|VPWR|vdd sg13_lv_pmos L=0.13u W=1.12u
+ AS=0.2639p AD=0.4312p PS=1.81u PD=3.01u rfmode=0
M$2741 \$70287 A1|D|Q$1 VDD|VPWR|vdd VDD|VPWR|vdd sg13_lv_pmos L=0.13u W=0.84u
+ AS=0.2856p AD=0.3018p PS=2.36u PD=1.97u rfmode=0
M$2742 VDD|VPWR|vdd CLK|D|GATE|Q \$70288 VDD|VPWR|vdd sg13_lv_pmos L=0.13u
+ W=0.84u AS=0.3018p AD=0.3234p PS=1.97u PD=2.45u rfmode=0
M$2743 \$70289 \$70288 VDD|VPWR|vdd VDD|VPWR|vdd sg13_lv_pmos L=0.13u W=0.84u
+ AS=0.2856p AD=0.26675p PS=2.36u PD=1.845u rfmode=0
M$2744 VDD|VPWR|vdd \$70287 \$70872 VDD|VPWR|vdd sg13_lv_pmos L=0.13u W=1u
+ AS=0.26675p AD=0.105p PS=1.845u PD=1.21u rfmode=0
M$2745 \$70872 \$70288 \$70290 VDD|VPWR|vdd sg13_lv_pmos L=0.13u W=1u AS=0.105p
+ AD=0.191p PS=1.21u PD=1.44u rfmode=0
M$2746 \$70290 \$70289 \$70871 VDD|VPWR|vdd sg13_lv_pmos L=0.13u W=0.42u
+ AS=0.191p AD=0.1008p PS=1.44u PD=0.9u rfmode=0
M$2747 VDD|VPWR|vdd \$70177 \$70871 VDD|VPWR|vdd sg13_lv_pmos L=0.13u W=0.42u
+ AS=0.2387p AD=0.1008p PS=1.84u PD=0.9u rfmode=0
M$2748 VDD|VPWR|vdd \$70290 \$70177 VDD|VPWR|vdd sg13_lv_pmos L=0.13u W=1.12u
+ AS=0.2387p AD=0.2128p PS=1.84u PD=1.5u rfmode=0
M$2749 \$70177 RESET_B|Y$1 VDD|VPWR|vdd VDD|VPWR|vdd sg13_lv_pmos L=0.13u
+ W=1.12u AS=0.2128p AD=0.2128p PS=1.5u PD=1.5u rfmode=0
M$2750 VDD|VPWR|vdd \$70177 A|Q$4 VDD|VPWR|vdd sg13_lv_pmos L=0.13u W=1.12u
+ AS=0.2128p AD=0.3808p PS=1.5u PD=2.92u rfmode=0
M$2751 \$70291 D|Q_N VDD|VPWR|vdd VDD|VPWR|vdd sg13_lv_pmos L=0.13u W=0.84u
+ AS=0.2856p AD=0.3018p PS=2.36u PD=1.97u rfmode=0
M$2752 VDD|VPWR|vdd CLK|D|GATE|Q$1 \$70292 VDD|VPWR|vdd sg13_lv_pmos L=0.13u
+ W=0.84u AS=0.3018p AD=0.3234p PS=1.97u PD=2.45u rfmode=0
M$2753 \$70293 \$70292 VDD|VPWR|vdd VDD|VPWR|vdd sg13_lv_pmos L=0.13u W=0.84u
+ AS=0.2856p AD=0.26675p PS=2.36u PD=1.845u rfmode=0
M$2754 VDD|VPWR|vdd \$70291 \$70874 VDD|VPWR|vdd sg13_lv_pmos L=0.13u W=1u
+ AS=0.26675p AD=0.105p PS=1.845u PD=1.21u rfmode=0
M$2755 \$70874 \$70292 \$70294 VDD|VPWR|vdd sg13_lv_pmos L=0.13u W=1u AS=0.105p
+ AD=0.191p PS=1.21u PD=1.44u rfmode=0
M$2756 \$70294 \$70293 \$70873 VDD|VPWR|vdd sg13_lv_pmos L=0.13u W=0.42u
+ AS=0.191p AD=0.1008p PS=1.44u PD=0.9u rfmode=0
M$2757 VDD|VPWR|vdd \$70181 \$70873 VDD|VPWR|vdd sg13_lv_pmos L=0.13u W=0.42u
+ AS=0.2387p AD=0.1008p PS=1.84u PD=0.9u rfmode=0
M$2758 VDD|VPWR|vdd \$70294 \$70181 VDD|VPWR|vdd sg13_lv_pmos L=0.13u W=1.12u
+ AS=0.2387p AD=0.2128p PS=1.84u PD=1.5u rfmode=0
M$2759 \$70181 RESET_B|Y$1 VDD|VPWR|vdd VDD|VPWR|vdd sg13_lv_pmos L=0.13u
+ W=1.12u AS=0.2128p AD=0.2128p PS=1.5u PD=1.5u rfmode=0
M$2760 VDD|VPWR|vdd \$70181 A|Q$3 VDD|VPWR|vdd sg13_lv_pmos L=0.13u W=1.12u
+ AS=0.2128p AD=0.3808p PS=1.5u PD=2.92u rfmode=0
M$2761 VDD|VPWR|vdd A|X$37 A|Y$5 VDD|VPWR|vdd sg13_lv_pmos L=0.13u W=1.12u
+ AS=0.3808p AD=0.3808p PS=2.92u PD=2.92u rfmode=0
M$2762 VDD|VPWR|vdd A|X$29 A|Y$4 VDD|VPWR|vdd sg13_lv_pmos L=0.13u W=1.12u
+ AS=0.3808p AD=0.3808p PS=2.92u PD=2.92u rfmode=0
M$2765 A1|Y A|Q$1 VDD|VPWR|vdd VDD|VPWR|vdd sg13_lv_pmos L=0.13u W=1.12u
+ AS=0.3808p AD=0.3808p PS=2.92u PD=2.92u rfmode=0
M$2766 VDD|VPWR|vdd A1|Y$1 \$70875 VDD|VPWR|vdd sg13_lv_pmos L=0.15u W=1.12u
+ AS=0.3808p AD=0.2128p PS=2.92u PD=1.5u rfmode=0
M$2767 \$70875 A2|Y D|Y$3 VDD|VPWR|vdd sg13_lv_pmos L=0.15u W=1.12u AS=0.2128p
+ AD=0.2128p PS=1.5u PD=1.5u rfmode=0
M$2768 D|Y$3 B1|Y$2 VDD|VPWR|vdd VDD|VPWR|vdd sg13_lv_pmos L=0.15u W=1.12u
+ AS=0.2128p AD=0.3808p PS=1.5u PD=2.92u rfmode=0
M$2769 VDD|VPWR|vdd D|Y$3 \$70302 VDD|VPWR|vdd sg13_lv_pmos L=0.13u W=0.42u
+ AS=0.1428p AD=0.0798p PS=1.52u PD=0.8u rfmode=0
M$2770 VDD|VPWR|vdd RESET_B|Y \$70302 VDD|VPWR|vdd sg13_lv_pmos L=0.13u W=0.42u
+ AS=0.3623875p AD=0.0798p PS=2.605u PD=0.8u rfmode=0
M$2771 VDD|VPWR|vdd \$70338 \$70186 VDD|VPWR|vdd sg13_lv_pmos L=0.13u W=1u
+ AS=0.3623875p AD=0.34p PS=2.605u PD=2.68u rfmode=0
M$2772 \$70303 \$70399 \$70656 VDD|VPWR|vdd sg13_lv_pmos L=0.13u W=0.42u
+ AS=0.2048p AD=0.09345p PS=1.63u PD=0.865u rfmode=0
M$2773 \$70656 \$70189 VDD|VPWR|vdd VDD|VPWR|vdd sg13_lv_pmos L=0.13u W=0.42u
+ AS=0.09345p AD=0.204p PS=0.865u PD=1.835u rfmode=0
M$2774 VDD|VPWR|vdd RESET_B|Y \$70189 VDD|VPWR|vdd sg13_lv_pmos L=0.13u W=0.42u
+ AS=0.204p AD=0.0798p PS=1.835u PD=0.8u rfmode=0
M$2775 VDD|VPWR|vdd \$70303 \$70189 VDD|VPWR|vdd sg13_lv_pmos L=0.13u W=0.42u
+ AS=0.2639p AD=0.0798p PS=1.81u PD=0.8u rfmode=0
M$2776 \$70186 \$70187 \$70303 VDD|VPWR|vdd sg13_lv_pmos L=0.13u W=1u AS=0.34p
+ AD=0.2048p PS=2.68u PD=1.63u rfmode=0
M$2777 VDD|VPWR|vdd \$70303 Q_N$8 VDD|VPWR|vdd sg13_lv_pmos L=0.13u W=1.12u
+ AS=0.2639p AD=0.4312p PS=1.81u PD=3.01u rfmode=0
M$2778 RESET_B|Y A|anode|cathode|ck|cks|core|pad|padres VDD|VPWR|vdd
+ VDD|VPWR|vdd sg13_lv_pmos L=0.13u W=1.12u AS=0.3808p AD=0.3808p PS=2.92u
+ PD=2.92u rfmode=0
M$2779 VDD|VPWR|vdd D|Y$5 \$70308 VDD|VPWR|vdd sg13_lv_pmos L=0.13u W=0.42u
+ AS=0.1428p AD=0.0798p PS=1.52u PD=0.8u rfmode=0
M$2780 VDD|VPWR|vdd RESET_B|Y \$70308 VDD|VPWR|vdd sg13_lv_pmos L=0.13u W=0.42u
+ AS=0.3623875p AD=0.0798p PS=2.605u PD=0.8u rfmode=0
M$2781 VDD|VPWR|vdd \$70339 \$70193 VDD|VPWR|vdd sg13_lv_pmos L=0.13u W=1u
+ AS=0.3623875p AD=0.34p PS=2.605u PD=2.68u rfmode=0
M$2782 \$70309 \$70400 \$70712 VDD|VPWR|vdd sg13_lv_pmos L=0.13u W=0.42u
+ AS=0.2048p AD=0.09345p PS=1.63u PD=0.865u rfmode=0
M$2783 \$70712 \$70196 VDD|VPWR|vdd VDD|VPWR|vdd sg13_lv_pmos L=0.13u W=0.42u
+ AS=0.09345p AD=0.204p PS=0.865u PD=1.835u rfmode=0
M$2784 VDD|VPWR|vdd RESET_B|Y \$70196 VDD|VPWR|vdd sg13_lv_pmos L=0.13u W=0.42u
+ AS=0.204p AD=0.0798p PS=1.835u PD=0.8u rfmode=0
M$2785 VDD|VPWR|vdd \$70309 \$70196 VDD|VPWR|vdd sg13_lv_pmos L=0.13u W=0.42u
+ AS=0.2639p AD=0.0798p PS=1.81u PD=0.8u rfmode=0
M$2786 \$70193 \$70194 \$70309 VDD|VPWR|vdd sg13_lv_pmos L=0.13u W=1u AS=0.34p
+ AD=0.2048p PS=2.68u PD=1.63u rfmode=0
M$2787 VDD|VPWR|vdd \$70309 Q_N$9 VDD|VPWR|vdd sg13_lv_pmos L=0.13u W=1.12u
+ AS=0.2639p AD=0.4312p PS=1.81u PD=3.01u rfmode=0
M$2788 VDD|VPWR|vdd A|Y$12 \$71083 VDD|VPWR|vdd sg13_lv_pmos L=0.13u W=1.12u
+ AS=0.4032p AD=0.1176p PS=2.96u PD=1.33u rfmode=0
M$2789 \$71083 A|B|X B|Y$1 VDD|VPWR|vdd sg13_lv_pmos L=0.13u W=1.12u AS=0.1176p
+ AD=0.3808p PS=1.33u PD=2.92u rfmode=0
M$2790 A|X$39 \$70936 VDD|VPWR|vdd VDD|VPWR|vdd sg13_lv_pmos L=0.13u W=1.12u
+ AS=0.4256p AD=0.2254p PS=3u PD=1.53u rfmode=0
M$2791 VDD|VPWR|vdd \$70937 \$70936 VDD|VPWR|vdd sg13_lv_pmos L=0.5u W=1u
+ AS=0.2254p AD=0.34p PS=1.53u PD=2.68u rfmode=0
M$2792 VDD|VPWR|vdd A|X$36 \$70938 VDD|VPWR|vdd sg13_lv_pmos L=0.13u W=0.42u
+ AS=0.1523p AD=0.1428p PS=1.38u PD=1.52u rfmode=0
M$2793 \$70937 \$70938 VDD|VPWR|vdd VDD|VPWR|vdd sg13_lv_pmos L=0.5u W=1u
+ AS=0.34p AD=0.1523p PS=2.68u PD=1.38u rfmode=0
M$2794 VDD|VPWR|vdd CLK|D|GATE|Q$2 \$70939 VDD|VPWR|vdd sg13_lv_pmos L=0.13u
+ W=0.42u AS=0.1428p AD=0.0798p PS=1.52u PD=0.8u rfmode=0
M$2795 VDD|VPWR|vdd RESET_B|Y$2 \$70939 VDD|VPWR|vdd sg13_lv_pmos L=0.13u
+ W=0.42u AS=0.3623875p AD=0.0798p PS=2.605u PD=0.8u rfmode=0
M$2796 VDD|VPWR|vdd \$70940 \$70976 VDD|VPWR|vdd sg13_lv_pmos L=0.13u W=1u
+ AS=0.3623875p AD=0.34p PS=2.605u PD=2.68u rfmode=0
M$2797 VDD|VPWR|vdd RESET_B|Y$2 \$70940 VDD|VPWR|vdd sg13_lv_pmos L=0.13u
+ W=0.42u AS=0.1563p AD=0.147p PS=1.22u PD=1.54u rfmode=0
M$2798 VDD|VPWR|vdd \$70976 \$71086 VDD|VPWR|vdd sg13_lv_pmos L=0.13u W=0.42u
+ AS=0.1563p AD=0.063p PS=1.22u PD=0.72u rfmode=0
M$2799 \$71086 \$70977 \$70940 VDD|VPWR|vdd sg13_lv_pmos L=0.13u W=0.42u
+ AS=0.063p AD=0.0798p PS=0.72u PD=0.8u rfmode=0
M$2800 \$70940 \$70941 \$70939 VDD|VPWR|vdd sg13_lv_pmos L=0.13u W=0.42u
+ AS=0.0798p AD=0.1428p PS=0.8u PD=1.52u rfmode=0
M$2801 \$70332 RESET_B|Y$1 VDD|VPWR|vdd VDD|VPWR|vdd sg13_lv_pmos L=0.13u
+ W=0.42u AS=0.147p AD=0.1563p PS=1.54u PD=1.22u rfmode=0
M$2802 VDD|VPWR|vdd \$70171 \$70870 VDD|VPWR|vdd sg13_lv_pmos L=0.13u W=0.42u
+ AS=0.1563p AD=0.063p PS=1.22u PD=0.72u rfmode=0
M$2803 \$70870 \$70172 \$70332 VDD|VPWR|vdd sg13_lv_pmos L=0.13u W=0.42u
+ AS=0.063p AD=0.0798p PS=0.72u PD=0.8u rfmode=0
M$2804 \$70332 \$70398 \$70285 VDD|VPWR|vdd sg13_lv_pmos L=0.13u W=0.42u
+ AS=0.0798p AD=0.1428p PS=0.8u PD=1.52u rfmode=0
M$2805 VDD|VPWR|vdd \$70977 \$70941 VDD|VPWR|vdd sg13_lv_pmos L=0.13u W=1.12u
+ AS=0.41165p AD=0.3864p PS=2.12u PD=2.93u rfmode=0
M$2806 VDD|VPWR|vdd A|CLK|X \$70977 VDD|VPWR|vdd sg13_lv_pmos L=0.13u W=1.12u
+ AS=0.41165p AD=0.4088p PS=2.12u PD=2.97u rfmode=0
M$2807 \$70976 \$70977 \$71155 VDD|VPWR|vdd sg13_lv_pmos L=0.13u W=1u AS=0.34p
+ AD=0.2048p PS=2.68u PD=1.63u rfmode=0
M$2808 \$71155 \$70941 \$71087 VDD|VPWR|vdd sg13_lv_pmos L=0.13u W=0.42u
+ AS=0.2048p AD=0.09345p PS=1.63u PD=0.865u rfmode=0
M$2809 VDD|VPWR|vdd \$70978 \$71087 VDD|VPWR|vdd sg13_lv_pmos L=0.13u W=0.42u
+ AS=0.204p AD=0.09345p PS=1.835u PD=0.865u rfmode=0
M$2810 VDD|VPWR|vdd RESET_B|Y$2 \$70978 VDD|VPWR|vdd sg13_lv_pmos L=0.13u
+ W=0.42u AS=0.204p AD=0.0798p PS=1.835u PD=0.8u rfmode=0
M$2811 VDD|VPWR|vdd \$71155 \$70978 VDD|VPWR|vdd sg13_lv_pmos L=0.13u W=0.42u
+ AS=0.2639p AD=0.0798p PS=1.81u PD=0.8u rfmode=0
M$2812 VDD|VPWR|vdd \$71155 Q_N$10 VDD|VPWR|vdd sg13_lv_pmos L=0.13u W=1.12u
+ AS=0.2639p AD=0.4312p PS=1.81u PD=3.01u rfmode=0
M$2813 \$70943 \$71155 VDD|VPWR|vdd VDD|VPWR|vdd sg13_lv_pmos L=0.13u W=1.12u
+ AS=0.3864p AD=0.2128p PS=2.93u PD=1.5u rfmode=0
M$2814 VDD|VPWR|vdd \$70943 CLK|D|GATE|Q VDD|VPWR|vdd sg13_lv_pmos L=0.13u
+ W=1.12u AS=0.2128p AD=0.3808p PS=1.5u PD=2.92u rfmode=0
M$2815 A|Y$3 A|X$40 VDD|VPWR|vdd VDD|VPWR|vdd sg13_lv_pmos L=0.13u W=1.12u
+ AS=0.3808p AD=0.3808p PS=2.92u PD=2.92u rfmode=0
M$2816 VDD|VPWR|vdd A|Q$4 \$70945 VDD|VPWR|vdd sg13_lv_pmos L=0.13u W=0.84u
+ AS=0.2114p AD=0.2856p PS=1.54u PD=2.36u rfmode=0
M$2817 A|X$40 \$70945 VDD|VPWR|vdd VDD|VPWR|vdd sg13_lv_pmos L=0.13u W=1.12u
+ AS=0.42p AD=0.2114p PS=2.99u PD=1.54u rfmode=0
M$2818 VDD|VPWR|vdd D|X \$70946 VDD|VPWR|vdd sg13_lv_pmos L=0.13u W=0.42u
+ AS=0.1428p AD=0.0798p PS=1.52u PD=0.8u rfmode=0
M$2819 VDD|VPWR|vdd RESET_B|Y$1 \$70946 VDD|VPWR|vdd sg13_lv_pmos L=0.13u
+ W=0.42u AS=0.3623875p AD=0.0798p PS=2.605u PD=0.8u rfmode=0
M$2820 VDD|VPWR|vdd \$70947 \$70979 VDD|VPWR|vdd sg13_lv_pmos L=0.13u W=1u
+ AS=0.3623875p AD=0.34p PS=2.605u PD=2.68u rfmode=0
M$2821 VDD|VPWR|vdd RESET_B|Y$1 \$70947 VDD|VPWR|vdd sg13_lv_pmos L=0.13u
+ W=0.42u AS=0.1563p AD=0.147p PS=1.22u PD=1.54u rfmode=0
M$2822 VDD|VPWR|vdd \$70979 \$71088 VDD|VPWR|vdd sg13_lv_pmos L=0.13u W=0.42u
+ AS=0.1563p AD=0.063p PS=1.22u PD=0.72u rfmode=0
M$2823 \$71088 \$70980 \$70947 VDD|VPWR|vdd sg13_lv_pmos L=0.13u W=0.42u
+ AS=0.063p AD=0.0798p PS=0.72u PD=0.8u rfmode=0
M$2824 \$70947 \$70948 \$70946 VDD|VPWR|vdd sg13_lv_pmos L=0.13u W=0.42u
+ AS=0.0798p AD=0.1428p PS=0.8u PD=1.52u rfmode=0
M$2825 VDD|VPWR|vdd \$70980 \$70948 VDD|VPWR|vdd sg13_lv_pmos L=0.13u W=1.12u
+ AS=0.41165p AD=0.3864p PS=2.12u PD=2.93u rfmode=0
M$2826 VDD|VPWR|vdd CLK|D|GATE|Q$3 \$70980 VDD|VPWR|vdd sg13_lv_pmos L=0.13u
+ W=1.12u AS=0.41165p AD=0.4088p PS=2.12u PD=2.97u rfmode=0
M$2827 \$70979 \$70980 \$71158 VDD|VPWR|vdd sg13_lv_pmos L=0.13u W=1u AS=0.34p
+ AD=0.2048p PS=2.68u PD=1.63u rfmode=0
M$2828 \$71158 \$70948 \$71089 VDD|VPWR|vdd sg13_lv_pmos L=0.13u W=0.42u
+ AS=0.2048p AD=0.09345p PS=1.63u PD=0.865u rfmode=0
M$2829 VDD|VPWR|vdd \$70981 \$71089 VDD|VPWR|vdd sg13_lv_pmos L=0.13u W=0.42u
+ AS=0.204p AD=0.09345p PS=1.835u PD=0.865u rfmode=0
M$2830 VDD|VPWR|vdd RESET_B|Y$1 \$70981 VDD|VPWR|vdd sg13_lv_pmos L=0.13u
+ W=0.42u AS=0.204p AD=0.0798p PS=1.835u PD=0.8u rfmode=0
M$2831 VDD|VPWR|vdd \$71158 \$70981 VDD|VPWR|vdd sg13_lv_pmos L=0.13u W=0.42u
+ AS=0.2639p AD=0.0798p PS=1.81u PD=0.8u rfmode=0
M$2832 VDD|VPWR|vdd \$71158 D|Q_N$2 VDD|VPWR|vdd sg13_lv_pmos L=0.13u W=1.12u
+ AS=0.2639p AD=0.4312p PS=1.81u PD=3.01u rfmode=0
M$2833 \$70950 \$71158 VDD|VPWR|vdd VDD|VPWR|vdd sg13_lv_pmos L=0.13u W=1.12u
+ AS=0.3864p AD=0.2128p PS=2.93u PD=1.5u rfmode=0
M$2834 VDD|VPWR|vdd \$70950 A2|D|Q VDD|VPWR|vdd sg13_lv_pmos L=0.13u W=1.12u
+ AS=0.2128p AD=0.3808p PS=1.5u PD=2.92u rfmode=0
M$2835 VDD|VPWR|vdd A|Q$7 \$70952 VDD|VPWR|vdd sg13_lv_pmos L=0.13u W=0.84u
+ AS=0.2114p AD=0.2856p PS=1.54u PD=2.36u rfmode=0
M$2836 A|X$24 \$70952 VDD|VPWR|vdd VDD|VPWR|vdd sg13_lv_pmos L=0.13u W=1.12u
+ AS=0.42p AD=0.2114p PS=2.99u PD=1.54u rfmode=0
M$2837 VDD|VPWR|vdd A|Q$8 \$70953 VDD|VPWR|vdd sg13_lv_pmos L=0.13u W=0.84u
+ AS=0.2114p AD=0.2856p PS=1.54u PD=2.36u rfmode=0
M$2838 A|X$37 \$70953 VDD|VPWR|vdd VDD|VPWR|vdd sg13_lv_pmos L=0.13u W=1.12u
+ AS=0.42p AD=0.2114p PS=2.99u PD=1.54u rfmode=0
M$2841 D|Y$4 A|Y$17 VDD|VPWR|vdd VDD|VPWR|vdd sg13_lv_pmos L=0.13u W=1.12u
+ AS=0.3808p AD=0.3808p PS=2.92u PD=2.92u rfmode=0
M$2842 B1|Y$3 A2|B|B1|Y \$70955 VDD|VPWR|vdd sg13_lv_pmos L=0.13u W=1.12u
+ AS=0.3808p AD=0.2128p PS=2.92u PD=1.5u rfmode=0
M$2843 \$70955 A1|D|Q$1 VDD|VPWR|vdd VDD|VPWR|vdd sg13_lv_pmos L=0.13u W=1.12u
+ AS=0.2128p AD=0.2128p PS=1.5u PD=1.5u rfmode=0
M$2844 VDD|VPWR|vdd A2|B|B1|C1|Y \$70955 VDD|VPWR|vdd sg13_lv_pmos L=0.13u
+ W=1.12u AS=0.2128p AD=0.3808p PS=1.5u PD=2.92u rfmode=0
M$2845 VDD|VPWR|vdd A|A1|B|Y \$70956 VDD|VPWR|vdd sg13_lv_pmos L=0.13u W=1.12u
+ AS=0.3808p AD=0.2716p PS=2.92u PD=1.605u rfmode=0
M$2846 \$70956 B1|Y$1 A|Y$17 VDD|VPWR|vdd sg13_lv_pmos L=0.13u W=1.12u
+ AS=0.2716p AD=0.2128p PS=1.605u PD=1.5u rfmode=0
M$2847 A|Y$17 A|B|B2|B_N|Q \$70956 VDD|VPWR|vdd sg13_lv_pmos L=0.13u W=1.12u
+ AS=0.2128p AD=0.2744p PS=1.5u PD=1.61u rfmode=0
M$2848 \$70956 A2|B1|Y VDD|VPWR|vdd VDD|VPWR|vdd sg13_lv_pmos L=0.13u W=1.12u
+ AS=0.2744p AD=0.3808p PS=1.61u PD=2.92u rfmode=0
M$2849 VDD|VPWR|vdd D|Y$4 \$70957 VDD|VPWR|vdd sg13_lv_pmos L=0.13u W=0.42u
+ AS=0.1428p AD=0.0798p PS=1.52u PD=0.8u rfmode=0
M$2850 VDD|VPWR|vdd RESET_B|Y \$70957 VDD|VPWR|vdd sg13_lv_pmos L=0.13u W=0.42u
+ AS=0.3623875p AD=0.0798p PS=2.605u PD=0.8u rfmode=0
M$2851 VDD|VPWR|vdd \$70958 \$70985 VDD|VPWR|vdd sg13_lv_pmos L=0.13u W=1u
+ AS=0.3623875p AD=0.34p PS=2.605u PD=2.68u rfmode=0
M$2852 VDD|VPWR|vdd RESET_B|Y \$70958 VDD|VPWR|vdd sg13_lv_pmos L=0.13u W=0.42u
+ AS=0.1563p AD=0.147p PS=1.22u PD=1.54u rfmode=0
M$2853 VDD|VPWR|vdd \$70985 \$71090 VDD|VPWR|vdd sg13_lv_pmos L=0.13u W=0.42u
+ AS=0.1563p AD=0.063p PS=1.22u PD=0.72u rfmode=0
M$2854 \$71090 \$70986 \$70958 VDD|VPWR|vdd sg13_lv_pmos L=0.13u W=0.42u
+ AS=0.063p AD=0.0798p PS=0.72u PD=0.8u rfmode=0
M$2855 \$70958 \$70959 \$70957 VDD|VPWR|vdd sg13_lv_pmos L=0.13u W=0.42u
+ AS=0.0798p AD=0.1428p PS=0.8u PD=1.52u rfmode=0
M$2856 VDD|VPWR|vdd \$70986 \$70959 VDD|VPWR|vdd sg13_lv_pmos L=0.13u W=1.12u
+ AS=0.41165p AD=0.3864p PS=2.12u PD=2.93u rfmode=0
M$2857 VDD|VPWR|vdd CLK|Y \$70986 VDD|VPWR|vdd sg13_lv_pmos L=0.13u W=1.12u
+ AS=0.41165p AD=0.4088p PS=2.12u PD=2.97u rfmode=0
M$2858 \$70985 \$70986 \$71161 VDD|VPWR|vdd sg13_lv_pmos L=0.13u W=1u AS=0.34p
+ AD=0.2048p PS=2.68u PD=1.63u rfmode=0
M$2859 \$71161 \$70959 \$71093 VDD|VPWR|vdd sg13_lv_pmos L=0.13u W=0.42u
+ AS=0.2048p AD=0.09345p PS=1.63u PD=0.865u rfmode=0
M$2860 VDD|VPWR|vdd \$70987 \$71093 VDD|VPWR|vdd sg13_lv_pmos L=0.13u W=0.42u
+ AS=0.204p AD=0.09345p PS=1.835u PD=0.865u rfmode=0
M$2861 VDD|VPWR|vdd RESET_B|Y \$70987 VDD|VPWR|vdd sg13_lv_pmos L=0.13u W=0.42u
+ AS=0.204p AD=0.0798p PS=1.835u PD=0.8u rfmode=0
M$2862 VDD|VPWR|vdd \$71161 \$70987 VDD|VPWR|vdd sg13_lv_pmos L=0.13u W=0.42u
+ AS=0.2639p AD=0.0798p PS=1.81u PD=0.8u rfmode=0
M$2863 VDD|VPWR|vdd \$71161 Q_N$11 VDD|VPWR|vdd sg13_lv_pmos L=0.13u W=1.12u
+ AS=0.2639p AD=0.4312p PS=1.81u PD=3.01u rfmode=0
M$2864 \$70338 RESET_B|Y VDD|VPWR|vdd VDD|VPWR|vdd sg13_lv_pmos L=0.13u W=0.42u
+ AS=0.147p AD=0.1563p PS=1.54u PD=1.22u rfmode=0
M$2865 VDD|VPWR|vdd \$70186 \$70876 VDD|VPWR|vdd sg13_lv_pmos L=0.13u W=0.42u
+ AS=0.1563p AD=0.063p PS=1.22u PD=0.72u rfmode=0
M$2866 \$70876 \$70187 \$70338 VDD|VPWR|vdd sg13_lv_pmos L=0.13u W=0.42u
+ AS=0.063p AD=0.0798p PS=0.72u PD=0.8u rfmode=0
M$2867 \$70338 \$70399 \$70302 VDD|VPWR|vdd sg13_lv_pmos L=0.13u W=0.42u
+ AS=0.0798p AD=0.1428p PS=0.8u PD=1.52u rfmode=0
M$2868 \$70962 \$71161 VDD|VPWR|vdd VDD|VPWR|vdd sg13_lv_pmos L=0.13u W=1.12u
+ AS=0.3864p AD=0.2128p PS=2.93u PD=1.5u rfmode=0
M$2869 VDD|VPWR|vdd \$70962 A|B|B2|B_N|Q VDD|VPWR|vdd sg13_lv_pmos L=0.13u
+ W=1.12u AS=0.2128p AD=0.3808p PS=1.5u PD=2.92u rfmode=0
M$2870 A|Y$8 A|X$56 VDD|VPWR|vdd VDD|VPWR|vdd sg13_lv_pmos L=0.13u W=1.12u
+ AS=0.3808p AD=0.3808p PS=2.92u PD=2.92u rfmode=0
M$2871 VDD|VPWR|vdd A2|B|B1|Y B1|Y$2 VDD|VPWR|vdd sg13_lv_pmos L=0.13u W=1.12u
+ AS=0.3808p AD=0.2128p PS=2.92u PD=1.5u rfmode=0
M$2872 B1|Y$2 A|Q$5 VDD|VPWR|vdd VDD|VPWR|vdd sg13_lv_pmos L=0.13u W=1.12u
+ AS=0.2128p AD=0.3808p PS=1.5u PD=2.92u rfmode=0
M$2873 VDD|VPWR|vdd A2|B|B1|Y \$70963 VDD|VPWR|vdd sg13_lv_pmos L=0.13u W=1.12u
+ AS=0.3808p AD=0.2744p PS=2.92u PD=1.61u rfmode=0
M$2874 \$70963 B2|Y$2 D|Y$5 VDD|VPWR|vdd sg13_lv_pmos L=0.13u W=1.12u
+ AS=0.2744p AD=0.2128p PS=1.61u PD=1.5u rfmode=0
M$2875 D|Y$5 B1|Y$3 \$70963 VDD|VPWR|vdd sg13_lv_pmos L=0.13u W=1.12u
+ AS=0.2128p AD=0.2716p PS=1.5u PD=1.605u rfmode=0
M$2876 \$70963 A1|Y$2 VDD|VPWR|vdd VDD|VPWR|vdd sg13_lv_pmos L=0.13u W=1.12u
+ AS=0.2716p AD=0.3808p PS=1.605u PD=2.92u rfmode=0
M$2877 CLK|Y A|CLK|X$1 VDD|VPWR|vdd VDD|VPWR|vdd sg13_lv_pmos L=0.13u W=1.12u
+ AS=0.3808p AD=0.3808p PS=2.92u PD=2.92u rfmode=0
M$2878 C|Q \$70965 VDD|VPWR|vdd VDD|VPWR|vdd sg13_lv_pmos L=0.13u W=1.12u
+ AS=0.3808p AD=0.2128p PS=2.92u PD=1.5u rfmode=0
M$2879 VDD|VPWR|vdd \$71163 \$70965 VDD|VPWR|vdd sg13_lv_pmos L=0.13u W=1.12u
+ AS=0.2128p AD=0.3864p PS=1.5u PD=2.93u rfmode=0
M$2880 VDD|VPWR|vdd \$71163 \$70990 VDD|VPWR|vdd sg13_lv_pmos L=0.13u W=0.42u
+ AS=0.2639p AD=0.0798p PS=1.81u PD=0.8u rfmode=0
M$2881 VDD|VPWR|vdd RESET_B|Y$1 \$70990 VDD|VPWR|vdd sg13_lv_pmos L=0.13u
+ W=0.42u AS=0.204p AD=0.0798p PS=1.835u PD=0.8u rfmode=0
M$2882 VDD|VPWR|vdd \$70990 \$71094 VDD|VPWR|vdd sg13_lv_pmos L=0.13u W=0.42u
+ AS=0.204p AD=0.09345p PS=1.835u PD=0.865u rfmode=0
M$2883 \$71163 \$70967 \$71094 VDD|VPWR|vdd sg13_lv_pmos L=0.13u W=0.42u
+ AS=0.2048p AD=0.09345p PS=1.63u PD=0.865u rfmode=0
M$2884 \$71163 \$70991 \$70992 VDD|VPWR|vdd sg13_lv_pmos L=0.13u W=1u
+ AS=0.2048p AD=0.34p PS=1.63u PD=2.68u rfmode=0
M$2885 Q_N$12 \$71163 VDD|VPWR|vdd VDD|VPWR|vdd sg13_lv_pmos L=0.13u W=1.12u
+ AS=0.4312p AD=0.2639p PS=3.01u PD=1.81u rfmode=0
M$2886 VDD|VPWR|vdd A|CLK|Q \$70991 VDD|VPWR|vdd sg13_lv_pmos L=0.13u W=1.12u
+ AS=0.41165p AD=0.4088p PS=2.12u PD=2.97u rfmode=0
M$2887 VDD|VPWR|vdd \$70991 \$70967 VDD|VPWR|vdd sg13_lv_pmos L=0.13u W=1.12u
+ AS=0.41165p AD=0.3864p PS=2.12u PD=2.93u rfmode=0
M$2888 \$70968 \$70967 \$70969 VDD|VPWR|vdd sg13_lv_pmos L=0.13u W=0.42u
+ AS=0.1428p AD=0.0798p PS=1.52u PD=0.8u rfmode=0
M$2889 \$70969 \$70991 \$71097 VDD|VPWR|vdd sg13_lv_pmos L=0.13u W=0.42u
+ AS=0.0798p AD=0.063p PS=0.8u PD=0.72u rfmode=0
M$2890 VDD|VPWR|vdd \$70992 \$71097 VDD|VPWR|vdd sg13_lv_pmos L=0.13u W=0.42u
+ AS=0.1563p AD=0.063p PS=1.22u PD=0.72u rfmode=0
M$2891 VDD|VPWR|vdd RESET_B|Y$1 \$70969 VDD|VPWR|vdd sg13_lv_pmos L=0.13u
+ W=0.42u AS=0.1563p AD=0.147p PS=1.22u PD=1.54u rfmode=0
M$2892 \$70339 RESET_B|Y VDD|VPWR|vdd VDD|VPWR|vdd sg13_lv_pmos L=0.13u W=0.42u
+ AS=0.147p AD=0.1563p PS=1.54u PD=1.22u rfmode=0
M$2893 VDD|VPWR|vdd \$70193 \$70877 VDD|VPWR|vdd sg13_lv_pmos L=0.13u W=0.42u
+ AS=0.1563p AD=0.063p PS=1.22u PD=0.72u rfmode=0
M$2894 \$70877 \$70194 \$70339 VDD|VPWR|vdd sg13_lv_pmos L=0.13u W=0.42u
+ AS=0.063p AD=0.0798p PS=0.72u PD=0.8u rfmode=0
M$2895 \$70339 \$70400 \$70308 VDD|VPWR|vdd sg13_lv_pmos L=0.13u W=0.42u
+ AS=0.0798p AD=0.1428p PS=0.8u PD=1.52u rfmode=0
M$2896 VDD|VPWR|vdd \$70969 \$70992 VDD|VPWR|vdd sg13_lv_pmos L=0.13u W=1u
+ AS=0.3623875p AD=0.34p PS=2.605u PD=2.68u rfmode=0
M$2897 VDD|VPWR|vdd RESET_B|Y$1 \$70968 VDD|VPWR|vdd sg13_lv_pmos L=0.13u
+ W=0.42u AS=0.3623875p AD=0.0798p PS=2.605u PD=0.8u rfmode=0
M$2898 \$70968 D|X VDD|VPWR|vdd VDD|VPWR|vdd sg13_lv_pmos L=0.13u W=0.42u
+ AS=0.0798p AD=0.1428p PS=0.8u PD=1.52u rfmode=0
M$2899 \$70970 A|CLK|Q VDD|VPWR|vdd VDD|VPWR|vdd sg13_lv_pmos L=0.13u W=3.36u
+ AS=0.8064p AD=0.6384p PS=5.92u PD=4.5u rfmode=0
M$2902 VDD|VPWR|vdd \$70970 A|B|X VDD|VPWR|vdd sg13_lv_pmos L=0.13u W=8.96u
+ AS=1.7024p AD=1.876p PS=12u PD=13.43u rfmode=0
M$2910 A1|Y$2 A|Q$6 VDD|VPWR|vdd VDD|VPWR|vdd sg13_lv_pmos L=0.13u W=1.12u
+ AS=0.3808p AD=0.3808p PS=2.92u PD=2.92u rfmode=0
M$2911 \$70971 A|Q$5 VDD|VPWR|vdd VDD|VPWR|vdd sg13_lv_pmos L=0.13u W=0.84u
+ AS=0.2856p AD=0.2114p PS=2.36u PD=1.54u rfmode=0
M$2912 VDD|VPWR|vdd \$70971 X|anode|cathode|core|d_out[1]|dout[1]|pad|padres
+ VDD|VPWR|vdd sg13_lv_pmos L=0.13u W=1.12u AS=0.2114p AD=0.42p PS=1.54u
+ PD=2.99u rfmode=0
M$2913 \$70972 A|Q$6 VDD|VPWR|vdd VDD|VPWR|vdd sg13_lv_pmos L=0.13u W=0.84u
+ AS=0.2856p AD=0.2114p PS=2.36u PD=1.54u rfmode=0
M$2914 VDD|VPWR|vdd \$70972 X|anode|cathode|core|d_out[2]|dout[2]|pad|padres
+ VDD|VPWR|vdd sg13_lv_pmos L=0.13u W=1.12u AS=0.2114p AD=0.42p PS=1.54u
+ PD=2.99u rfmode=0
M$2915 \$66428 Y$1 \$70277 \$70878 sg13_lv_pmos L=0.13u W=0.5u AS=0.17p
+ AD=0.17p PS=1.68u PD=1.68u rfmode=0
M$2916 X|ckc|clk \$71807 VDD|VPWR|vdd VDD|VPWR|vdd sg13_lv_pmos L=0.13u W=1.12u
+ AS=0.42p AD=0.2114p PS=2.99u PD=1.54u rfmode=0
M$2917 VDD|VPWR|vdd A|Y$11 \$71807 VDD|VPWR|vdd sg13_lv_pmos L=0.13u W=0.84u
+ AS=0.2114p AD=0.2856p PS=1.54u PD=2.36u rfmode=0
M$2918 VDD|VPWR|vdd A|anode|cathode|ck|cks|core|pad|padres A|Y$14 VDD|VPWR|vdd
+ sg13_lv_pmos L=0.13u W=1.12u AS=0.3808p AD=0.3808p PS=2.92u PD=2.92u rfmode=0
M$2919 VDD|VPWR|vdd A|Y$15 A|Y$16 VDD|VPWR|vdd sg13_lv_pmos L=0.13u W=1.12u
+ AS=0.3808p AD=0.2128p PS=2.92u PD=1.5u rfmode=0
M$2920 A|Y$16 B|Y$1 VDD|VPWR|vdd VDD|VPWR|vdd sg13_lv_pmos L=0.13u W=1.12u
+ AS=0.2128p AD=0.3808p PS=1.5u PD=2.92u rfmode=0
M$2921 \$71808 D|Q_N$3 VDD|VPWR|vdd VDD|VPWR|vdd sg13_lv_pmos L=0.13u W=0.84u
+ AS=0.2856p AD=0.3018p PS=2.36u PD=1.97u rfmode=0
M$2922 VDD|VPWR|vdd CLK|D|GATE|Q$2 \$71313 VDD|VPWR|vdd sg13_lv_pmos L=0.13u
+ W=0.84u AS=0.3018p AD=0.3234p PS=1.97u PD=2.45u rfmode=0
M$2923 VDD|VPWR|vdd \$71314 \$71316 VDD|VPWR|vdd sg13_lv_pmos L=0.13u W=0.84u
+ AS=0.1974p AD=0.2856p PS=1.5u PD=2.36u rfmode=0
M$2924 VDD|VPWR|vdd \$71316 Q_N$13 VDD|VPWR|vdd sg13_lv_pmos L=0.13u W=1.12u
+ AS=0.1974p AD=0.3808p PS=1.5u PD=2.92u rfmode=0
M$2925 VDD|VPWR|vdd CLK|D|GATE|Q \$71810 VDD|VPWR|vdd sg13_lv_pmos L=0.13u
+ W=0.42u AS=0.1428p AD=0.0798p PS=1.52u PD=0.8u rfmode=0
M$2926 VDD|VPWR|vdd RESET_B|Y$2 \$71810 VDD|VPWR|vdd sg13_lv_pmos L=0.13u
+ W=0.42u AS=0.3623875p AD=0.0798p PS=2.605u PD=0.8u rfmode=0
M$2927 VDD|VPWR|vdd \$71891 \$71318 VDD|VPWR|vdd sg13_lv_pmos L=0.13u W=1u
+ AS=0.3623875p AD=0.34p PS=2.605u PD=2.68u rfmode=0
M$2928 \$71790 \$71319 VDD|VPWR|vdd VDD|VPWR|vdd sg13_lv_pmos L=0.13u W=1.12u
+ AS=0.3864p AD=0.41165p PS=2.93u PD=2.12u rfmode=0
M$2929 VDD|VPWR|vdd A|CLK|X \$71319 VDD|VPWR|vdd sg13_lv_pmos L=0.13u W=1.12u
+ AS=0.41165p AD=0.4088p PS=2.12u PD=2.97u rfmode=0
M$2930 \$71811 \$71790 \$72054 VDD|VPWR|vdd sg13_lv_pmos L=0.13u W=0.42u
+ AS=0.2048p AD=0.09345p PS=1.63u PD=0.865u rfmode=0
M$2931 \$72054 \$71321 VDD|VPWR|vdd VDD|VPWR|vdd sg13_lv_pmos L=0.13u W=0.42u
+ AS=0.09345p AD=0.204p PS=0.865u PD=1.835u rfmode=0
M$2932 VDD|VPWR|vdd RESET_B|Y$2 \$71321 VDD|VPWR|vdd sg13_lv_pmos L=0.13u
+ W=0.42u AS=0.204p AD=0.0798p PS=1.835u PD=0.8u rfmode=0
M$2933 VDD|VPWR|vdd \$71811 \$71321 VDD|VPWR|vdd sg13_lv_pmos L=0.13u W=0.42u
+ AS=0.2639p AD=0.0798p PS=1.81u PD=0.8u rfmode=0
M$2934 \$71318 \$71319 \$71811 VDD|VPWR|vdd sg13_lv_pmos L=0.13u W=1u AS=0.34p
+ AD=0.2048p PS=2.68u PD=1.63u rfmode=0
M$2935 VDD|VPWR|vdd \$71811 Q_N$14 VDD|VPWR|vdd sg13_lv_pmos L=0.13u W=1.12u
+ AS=0.2639p AD=0.4312p PS=1.81u PD=3.01u rfmode=0
M$2936 \$71323 \$71811 VDD|VPWR|vdd VDD|VPWR|vdd sg13_lv_pmos L=0.13u W=1.12u
+ AS=0.3864p AD=0.2128p PS=2.93u PD=1.5u rfmode=0
M$2937 VDD|VPWR|vdd \$71323 CLK|D|GATE|Q$1 VDD|VPWR|vdd sg13_lv_pmos L=0.13u
+ W=1.12u AS=0.2128p AD=0.3808p PS=1.5u PD=2.92u rfmode=0
M$2938 VDD|VPWR|vdd CLK|D|GATE|Q$1 \$71812 VDD|VPWR|vdd sg13_lv_pmos L=0.13u
+ W=0.42u AS=0.1428p AD=0.0798p PS=1.52u PD=0.8u rfmode=0
M$2939 VDD|VPWR|vdd RESET_B|Y$2 \$71812 VDD|VPWR|vdd sg13_lv_pmos L=0.13u
+ W=0.42u AS=0.3623875p AD=0.0798p PS=2.605u PD=0.8u rfmode=0
M$2940 VDD|VPWR|vdd \$71892 \$71324 VDD|VPWR|vdd sg13_lv_pmos L=0.13u W=1u
+ AS=0.3623875p AD=0.34p PS=2.605u PD=2.68u rfmode=0
M$2941 \$71792 \$71325 VDD|VPWR|vdd VDD|VPWR|vdd sg13_lv_pmos L=0.13u W=1.12u
+ AS=0.3864p AD=0.41165p PS=2.93u PD=2.12u rfmode=0
M$2942 VDD|VPWR|vdd A|CLK|X \$71325 VDD|VPWR|vdd sg13_lv_pmos L=0.13u W=1.12u
+ AS=0.41165p AD=0.4088p PS=2.12u PD=2.97u rfmode=0
M$2943 \$71813 \$71792 \$72065 VDD|VPWR|vdd sg13_lv_pmos L=0.13u W=0.42u
+ AS=0.2048p AD=0.09345p PS=1.63u PD=0.865u rfmode=0
M$2944 \$72065 \$71327 VDD|VPWR|vdd VDD|VPWR|vdd sg13_lv_pmos L=0.13u W=0.42u
+ AS=0.09345p AD=0.204p PS=0.865u PD=1.835u rfmode=0
M$2945 VDD|VPWR|vdd RESET_B|Y$2 \$71327 VDD|VPWR|vdd sg13_lv_pmos L=0.13u
+ W=0.42u AS=0.204p AD=0.0798p PS=1.835u PD=0.8u rfmode=0
M$2946 VDD|VPWR|vdd \$71813 \$71327 VDD|VPWR|vdd sg13_lv_pmos L=0.13u W=0.42u
+ AS=0.2639p AD=0.0798p PS=1.81u PD=0.8u rfmode=0
M$2947 \$71324 \$71325 \$71813 VDD|VPWR|vdd sg13_lv_pmos L=0.13u W=1u AS=0.34p
+ AD=0.2048p PS=2.68u PD=1.63u rfmode=0
M$2948 VDD|VPWR|vdd \$71813 Q_N$15 VDD|VPWR|vdd sg13_lv_pmos L=0.13u W=1.12u
+ AS=0.2639p AD=0.4312p PS=1.81u PD=3.01u rfmode=0
M$2949 \$71329 \$71813 VDD|VPWR|vdd VDD|VPWR|vdd sg13_lv_pmos L=0.13u W=1.12u
+ AS=0.3864p AD=0.2128p PS=2.93u PD=1.5u rfmode=0
M$2950 VDD|VPWR|vdd \$71329 CLK|D|GATE|Q$3 VDD|VPWR|vdd sg13_lv_pmos L=0.13u
+ W=1.12u AS=0.2128p AD=0.3808p PS=1.5u PD=2.92u rfmode=0
M$2951 \$71814 D|Q_N$2 VDD|VPWR|vdd VDD|VPWR|vdd sg13_lv_pmos L=0.13u W=0.84u
+ AS=0.2856p AD=0.3018p PS=2.36u PD=1.97u rfmode=0
M$2952 VDD|VPWR|vdd CLK|D|GATE|Q$3 \$71330 VDD|VPWR|vdd sg13_lv_pmos L=0.13u
+ W=0.84u AS=0.3018p AD=0.3234p PS=1.97u PD=2.45u rfmode=0
M$2953 VDD|VPWR|vdd \$71331 \$71332 VDD|VPWR|vdd sg13_lv_pmos L=0.13u W=0.84u
+ AS=0.1974p AD=0.2856p PS=1.5u PD=2.36u rfmode=0
M$2954 VDD|VPWR|vdd \$71332 Q_N$16 VDD|VPWR|vdd sg13_lv_pmos L=0.13u W=1.12u
+ AS=0.1974p AD=0.3808p PS=1.5u PD=2.92u rfmode=0
M$2955 \$71794 A_N|D|Q VDD|VPWR|vdd VDD|VPWR|vdd sg13_lv_pmos L=0.13u W=0.84u
+ AS=0.2856p AD=0.2198p PS=2.36u PD=1.53u rfmode=0
M$2956 VDD|VPWR|vdd A2|B|B1|C1|Y B|Y VDD|VPWR|vdd sg13_lv_pmos L=0.13u W=1.12u
+ AS=0.2198p AD=0.2128p PS=1.53u PD=1.5u rfmode=0
M$2957 B|Y \$71794 VDD|VPWR|vdd VDD|VPWR|vdd sg13_lv_pmos L=0.13u W=1.12u
+ AS=0.2128p AD=0.3808p PS=1.5u PD=2.92u rfmode=0
M$2958 VDD|VPWR|vdd A2|D|Q \$71901 VDD|VPWR|vdd sg13_lv_pmos L=0.13u W=1.12u
+ AS=0.3808p AD=0.2128p PS=2.92u PD=1.5u rfmode=0
M$2959 \$71901 A1|Y$3 VDD|VPWR|vdd VDD|VPWR|vdd sg13_lv_pmos L=0.13u W=1.12u
+ AS=0.2128p AD=0.3808p PS=1.5u PD=2.92u rfmode=0
M$2960 \$71902 B1|X \$71901 VDD|VPWR|vdd sg13_lv_pmos L=0.13u W=1.12u
+ AS=0.3808p AD=0.2128p PS=2.92u PD=1.5u rfmode=0
M$2961 \$71901 B2|Y$1 \$71902 VDD|VPWR|vdd sg13_lv_pmos L=0.13u W=1.12u
+ AS=0.2128p AD=0.2128p PS=1.5u PD=1.5u rfmode=0
M$2962 \$71902 A2|B|B1|C1|Y A1|Y$1 VDD|VPWR|vdd sg13_lv_pmos L=0.13u W=1.12u
+ AS=0.2128p AD=0.3808p PS=1.5u PD=2.92u rfmode=0
M$2963 A2|B|B1|C1|Y A|B|B2|B_N|Q \$72093 VDD|VPWR|vdd sg13_lv_pmos L=0.13u
+ W=1.12u AS=0.3808p AD=0.1176p PS=2.92u PD=1.33u rfmode=0
M$2964 \$72093 A|B_N|Q VDD|VPWR|vdd VDD|VPWR|vdd sg13_lv_pmos L=0.13u W=1.12u
+ AS=0.1176p AD=0.4032p PS=1.33u PD=2.96u rfmode=0
M$2965 A1|Y$3 A|B|B2|B_N|Q VDD|VPWR|vdd VDD|VPWR|vdd sg13_lv_pmos L=0.13u
+ W=1.12u AS=0.3808p AD=0.3808p PS=2.92u PD=2.92u rfmode=0
M$2966 \$71816 A|B_N|Q VDD|VPWR|vdd VDD|VPWR|vdd sg13_lv_pmos L=0.13u W=0.84u
+ AS=0.2856p AD=0.2618p PS=2.36u PD=1.63u rfmode=0
M$2967 VDD|VPWR|vdd \$71816 \$72095 VDD|VPWR|vdd sg13_lv_pmos L=0.13u W=1.12u
+ AS=0.2618p AD=0.1176p PS=1.63u PD=1.33u rfmode=0
M$2968 \$72095 A|B|B2|B_N|Q A2|B1|Y VDD|VPWR|vdd sg13_lv_pmos L=0.13u W=1.12u
+ AS=0.1176p AD=0.3808p PS=1.33u PD=2.92u rfmode=0
M$2969 A|Y$9 A|X$43 VDD|VPWR|vdd VDD|VPWR|vdd sg13_lv_pmos L=0.13u W=1.12u
+ AS=0.3808p AD=0.3808p PS=2.92u PD=2.92u rfmode=0
M$2970 VDD|VPWR|vdd CLK|D|GATE|Q$4 \$71818 VDD|VPWR|vdd sg13_lv_pmos L=0.13u
+ W=0.42u AS=0.1428p AD=0.0798p PS=1.52u PD=0.8u rfmode=0
M$2971 VDD|VPWR|vdd RESET_B|Y$2 \$71818 VDD|VPWR|vdd sg13_lv_pmos L=0.13u
+ W=0.42u AS=0.3623875p AD=0.0798p PS=2.605u PD=0.8u rfmode=0
M$2972 VDD|VPWR|vdd \$71899 \$71334 VDD|VPWR|vdd sg13_lv_pmos L=0.13u W=1u
+ AS=0.3623875p AD=0.34p PS=2.605u PD=2.68u rfmode=0
M$2973 \$71798 \$71335 VDD|VPWR|vdd VDD|VPWR|vdd sg13_lv_pmos L=0.13u W=1.12u
+ AS=0.3864p AD=0.41165p PS=2.93u PD=2.12u rfmode=0
M$2974 VDD|VPWR|vdd A|CLK|X$1 \$71335 VDD|VPWR|vdd sg13_lv_pmos L=0.13u W=1.12u
+ AS=0.41165p AD=0.4088p PS=2.12u PD=2.97u rfmode=0
M$2975 \$71819 \$71798 \$72066 VDD|VPWR|vdd sg13_lv_pmos L=0.13u W=0.42u
+ AS=0.2048p AD=0.09345p PS=1.63u PD=0.865u rfmode=0
M$2976 \$72066 \$71337 VDD|VPWR|vdd VDD|VPWR|vdd sg13_lv_pmos L=0.13u W=0.42u
+ AS=0.09345p AD=0.204p PS=0.865u PD=1.835u rfmode=0
M$2977 VDD|VPWR|vdd RESET_B|Y$2 \$71337 VDD|VPWR|vdd sg13_lv_pmos L=0.13u
+ W=0.42u AS=0.204p AD=0.0798p PS=1.835u PD=0.8u rfmode=0
M$2978 VDD|VPWR|vdd \$71819 \$71337 VDD|VPWR|vdd sg13_lv_pmos L=0.13u W=0.42u
+ AS=0.2639p AD=0.0798p PS=1.81u PD=0.8u rfmode=0
M$2979 \$71334 \$71335 \$71819 VDD|VPWR|vdd sg13_lv_pmos L=0.13u W=1u AS=0.34p
+ AD=0.2048p PS=2.68u PD=1.63u rfmode=0
M$2980 VDD|VPWR|vdd \$71819 Q_N$17 VDD|VPWR|vdd sg13_lv_pmos L=0.13u W=1.12u
+ AS=0.2639p AD=0.4312p PS=1.81u PD=3.01u rfmode=0
M$2981 \$71339 \$71819 VDD|VPWR|vdd VDD|VPWR|vdd sg13_lv_pmos L=0.13u W=1.12u
+ AS=0.3864p AD=0.2128p PS=2.93u PD=1.5u rfmode=0
M$2982 VDD|VPWR|vdd \$71339 A|CLK|Q VDD|VPWR|vdd sg13_lv_pmos L=0.13u W=1.12u
+ AS=0.2128p AD=0.3808p PS=1.5u PD=2.92u rfmode=0
M$2983 A|Y$10 A|X$44 VDD|VPWR|vdd VDD|VPWR|vdd sg13_lv_pmos L=0.13u W=1.12u
+ AS=0.3808p AD=0.3808p PS=2.92u PD=2.92u rfmode=0
M$2984 \$71799 A|X$41 VDD|VPWR|vdd VDD|VPWR|vdd sg13_lv_pmos L=0.13u W=3.36u
+ AS=0.8064p AD=0.6384p PS=5.92u PD=4.5u rfmode=0
M$2987 VDD|VPWR|vdd \$71799 A|X$42 VDD|VPWR|vdd sg13_lv_pmos L=0.13u W=8.96u
+ AS=1.7024p AD=1.876p PS=12u PD=13.43u rfmode=0
M$2995 \$70169 A VDD|VPWR|vdd \$71889 sg13_lv_pmos L=0.13u W=0.5u AS=0.17p
+ AD=0.17p PS=1.68u PD=1.68u rfmode=0
M$2996 VDD|VPWR|vdd A Y$1 \$71889 sg13_lv_pmos L=0.13u W=1.12u AS=0.3808p
+ AD=0.3808p PS=2.92u PD=2.92u rfmode=0
M$2997 VDD|VPWR|vdd
+ BOTTOM|TOP|VGND|VSS|anode|cathode|core|h_sw[0]|h_sw[10]|h_sw[1]|h_sw[2]|h_sw[3]|h_sw[4]|h_sw[5]|h_sw[6]|h_sw[7]|h_sw[8]|h_sw[9]|l_sw[0]|l_sw[10]|l_sw[1]|l_sw[2]|l_sw[3]|l_sw[4]|l_sw[5]|l_sw[6]|l_sw[7]|l_sw[8]|l_sw[9]|out|pad|padres|vc|vcp|vdd|vddr|vip|vss|z
+ VDD|VPWR|vdd \$71889 sg13_lv_pmos L=1u W=1u AS=0.34p AD=0.34p PS=2.68u
+ PD=2.68u rfmode=0
M$2998 \$71809 \$71313 VDD|VPWR|vdd VDD|VPWR|vdd sg13_lv_pmos L=0.13u W=0.84u
+ AS=0.2856p AD=0.26675p PS=2.36u PD=1.845u rfmode=0
M$2999 VDD|VPWR|vdd \$71808 \$72091 VDD|VPWR|vdd sg13_lv_pmos L=0.13u W=1u
+ AS=0.26675p AD=0.105p PS=1.845u PD=1.21u rfmode=0
M$3000 \$72091 \$71313 \$71787 VDD|VPWR|vdd sg13_lv_pmos L=0.13u W=1u AS=0.105p
+ AD=0.191p PS=1.21u PD=1.44u rfmode=0
M$3001 \$71787 \$71809 \$72090 VDD|VPWR|vdd sg13_lv_pmos L=0.13u W=0.42u
+ AS=0.191p AD=0.1008p PS=1.44u PD=0.9u rfmode=0
M$3002 VDD|VPWR|vdd \$71314 \$72090 VDD|VPWR|vdd sg13_lv_pmos L=0.13u W=0.42u
+ AS=0.2387p AD=0.1008p PS=1.84u PD=0.9u rfmode=0
M$3003 VDD|VPWR|vdd \$71787 \$71314 VDD|VPWR|vdd sg13_lv_pmos L=0.13u W=1.12u
+ AS=0.2387p AD=0.2128p PS=1.84u PD=1.5u rfmode=0
M$3004 \$71314 RESET_B|Y$1 VDD|VPWR|vdd VDD|VPWR|vdd sg13_lv_pmos L=0.13u
+ W=1.12u AS=0.2128p AD=0.2128p PS=1.5u PD=1.5u rfmode=0
M$3005 VDD|VPWR|vdd \$71314 A|Q$9 VDD|VPWR|vdd sg13_lv_pmos L=0.13u W=1.12u
+ AS=0.2128p AD=0.3808p PS=1.5u PD=2.92u rfmode=0
M$3006 \$72159 \$72253 VDD|VPWR|vdd VDD|VPWR|vdd sg13_lv_pmos L=0.13u W=1.12u
+ AS=0.3864p AD=0.2128p PS=2.93u PD=1.5u rfmode=0
M$3007 VDD|VPWR|vdd \$72159 A_N|D|Q VDD|VPWR|vdd sg13_lv_pmos L=0.13u W=1.12u
+ AS=0.2128p AD=0.3808p PS=1.5u PD=2.92u rfmode=0
M$3008 VDD|VPWR|vdd A|Q$9 \$72160 VDD|VPWR|vdd sg13_lv_pmos L=0.13u W=0.84u
+ AS=0.2114p AD=0.2856p PS=1.54u PD=2.36u rfmode=0
M$3009 A|X$19 \$72160 VDD|VPWR|vdd VDD|VPWR|vdd sg13_lv_pmos L=0.13u W=1.12u
+ AS=0.42p AD=0.2114p PS=2.99u PD=1.54u rfmode=0
M$3011 \$71891 RESET_B|Y$2 VDD|VPWR|vdd VDD|VPWR|vdd sg13_lv_pmos L=0.13u
+ W=0.42u AS=0.147p AD=0.1563p PS=1.54u PD=1.22u rfmode=0
M$3012 VDD|VPWR|vdd \$71318 \$72092 VDD|VPWR|vdd sg13_lv_pmos L=0.13u W=0.42u
+ AS=0.1563p AD=0.063p PS=1.22u PD=0.72u rfmode=0
M$3013 \$72092 \$71319 \$71891 VDD|VPWR|vdd sg13_lv_pmos L=0.13u W=0.42u
+ AS=0.063p AD=0.0798p PS=0.72u PD=0.8u rfmode=0
M$3014 \$71891 \$71790 \$71810 VDD|VPWR|vdd sg13_lv_pmos L=0.13u W=0.42u
+ AS=0.0798p AD=0.1428p PS=0.8u PD=1.52u rfmode=0
M$3015 VDD|VPWR|vdd A|Q$20 \$72161 VDD|VPWR|vdd sg13_lv_pmos L=0.13u W=0.84u
+ AS=0.2114p AD=0.2856p PS=1.54u PD=2.36u rfmode=0
M$3016 A|X$34 \$72161 VDD|VPWR|vdd VDD|VPWR|vdd sg13_lv_pmos L=0.13u W=1.12u
+ AS=0.42p AD=0.2114p PS=2.99u PD=1.54u rfmode=0
M$3018 CLK|D|GATE|Q$5 \$72163 VDD|VPWR|vdd VDD|VPWR|vdd sg13_lv_pmos L=0.13u
+ W=1.12u AS=0.3808p AD=0.2128p PS=2.92u PD=1.5u rfmode=0
M$3019 VDD|VPWR|vdd \$72603 \$72163 VDD|VPWR|vdd sg13_lv_pmos L=0.13u W=1.12u
+ AS=0.2128p AD=0.3864p PS=1.5u PD=2.93u rfmode=0
M$3020 VDD|VPWR|vdd \$72603 \$72255 VDD|VPWR|vdd sg13_lv_pmos L=0.13u W=0.42u
+ AS=0.2639p AD=0.0798p PS=1.81u PD=0.8u rfmode=0
M$3021 VDD|VPWR|vdd RESET_B|Y$2 \$72255 VDD|VPWR|vdd sg13_lv_pmos L=0.13u
+ W=0.42u AS=0.204p AD=0.0798p PS=1.835u PD=0.8u rfmode=0
M$3022 VDD|VPWR|vdd \$72255 \$72485 VDD|VPWR|vdd sg13_lv_pmos L=0.13u W=0.42u
+ AS=0.204p AD=0.09345p PS=1.835u PD=0.865u rfmode=0
M$3023 \$72603 \$72165 \$72485 VDD|VPWR|vdd sg13_lv_pmos L=0.13u W=0.42u
+ AS=0.2048p AD=0.09345p PS=1.63u PD=0.865u rfmode=0
M$3024 \$72603 \$72256 \$72257 VDD|VPWR|vdd sg13_lv_pmos L=0.13u W=1u
+ AS=0.2048p AD=0.34p PS=1.63u PD=2.68u rfmode=0
M$3025 Q_N$18 \$72603 VDD|VPWR|vdd VDD|VPWR|vdd sg13_lv_pmos L=0.13u W=1.12u
+ AS=0.4312p AD=0.2639p PS=3.01u PD=1.81u rfmode=0
M$3026 \$71892 RESET_B|Y$2 VDD|VPWR|vdd VDD|VPWR|vdd sg13_lv_pmos L=0.13u
+ W=0.42u AS=0.147p AD=0.1563p PS=1.54u PD=1.22u rfmode=0
M$3027 VDD|VPWR|vdd \$71324 \$72094 VDD|VPWR|vdd sg13_lv_pmos L=0.13u W=0.42u
+ AS=0.1563p AD=0.063p PS=1.22u PD=0.72u rfmode=0
M$3028 \$72094 \$71325 \$71892 VDD|VPWR|vdd sg13_lv_pmos L=0.13u W=0.42u
+ AS=0.063p AD=0.0798p PS=0.72u PD=0.8u rfmode=0
M$3029 \$71892 \$71792 \$71812 VDD|VPWR|vdd sg13_lv_pmos L=0.13u W=0.42u
+ AS=0.0798p AD=0.1428p PS=0.8u PD=1.52u rfmode=0
M$3031 \$72169 \$72259 \$72249 VDD|VPWR|vdd sg13_lv_pmos L=0.13u W=0.42u
+ AS=0.191p AD=0.1008p PS=1.44u PD=0.9u rfmode=0
M$3032 \$72249 \$72170 VDD|VPWR|vdd VDD|VPWR|vdd sg13_lv_pmos L=0.13u W=0.42u
+ AS=0.1008p AD=0.2387p PS=0.9u PD=1.84u rfmode=0
M$3033 VDD|VPWR|vdd \$72258 \$72259 VDD|VPWR|vdd sg13_lv_pmos L=0.13u W=0.84u
+ AS=0.26675p AD=0.2856p PS=1.845u PD=2.36u rfmode=0
M$3034 VDD|VPWR|vdd \$72168 \$72526 VDD|VPWR|vdd sg13_lv_pmos L=0.13u W=1u
+ AS=0.26675p AD=0.105p PS=1.845u PD=1.21u rfmode=0
M$3035 \$72526 \$72258 \$72169 VDD|VPWR|vdd sg13_lv_pmos L=0.13u W=1u AS=0.105p
+ AD=0.191p PS=1.21u PD=1.44u rfmode=0
M$3036 VDD|VPWR|vdd \$72169 \$72170 VDD|VPWR|vdd sg13_lv_pmos L=0.13u W=1.12u
+ AS=0.2387p AD=0.2128p PS=1.84u PD=1.5u rfmode=0
M$3037 \$72170 RESET_B|Y$1 VDD|VPWR|vdd VDD|VPWR|vdd sg13_lv_pmos L=0.13u
+ W=1.12u AS=0.2128p AD=0.2128p PS=1.5u PD=1.5u rfmode=0
M$3038 VDD|VPWR|vdd \$72170 A|Q$8 VDD|VPWR|vdd sg13_lv_pmos L=0.13u W=1.12u
+ AS=0.2128p AD=0.3808p PS=1.5u PD=2.92u rfmode=0
M$3039 \$71815 \$71330 VDD|VPWR|vdd VDD|VPWR|vdd sg13_lv_pmos L=0.13u W=0.84u
+ AS=0.2856p AD=0.26675p PS=2.36u PD=1.845u rfmode=0
M$3040 VDD|VPWR|vdd \$71814 \$72097 VDD|VPWR|vdd sg13_lv_pmos L=0.13u W=1u
+ AS=0.26675p AD=0.105p PS=1.845u PD=1.21u rfmode=0
M$3041 \$72097 \$71330 \$71793 VDD|VPWR|vdd sg13_lv_pmos L=0.13u W=1u AS=0.105p
+ AD=0.191p PS=1.21u PD=1.44u rfmode=0
M$3042 \$71793 \$71815 \$72096 VDD|VPWR|vdd sg13_lv_pmos L=0.13u W=0.42u
+ AS=0.191p AD=0.1008p PS=1.44u PD=0.9u rfmode=0
M$3043 VDD|VPWR|vdd \$71331 \$72096 VDD|VPWR|vdd sg13_lv_pmos L=0.13u W=0.42u
+ AS=0.2387p AD=0.1008p PS=1.84u PD=0.9u rfmode=0
M$3044 VDD|VPWR|vdd \$71793 \$71331 VDD|VPWR|vdd sg13_lv_pmos L=0.13u W=1.12u
+ AS=0.2387p AD=0.2128p PS=1.84u PD=1.5u rfmode=0
M$3045 \$71331 RESET_B|Y$1 VDD|VPWR|vdd VDD|VPWR|vdd sg13_lv_pmos L=0.13u
+ W=1.12u AS=0.2128p AD=0.2128p PS=1.5u PD=1.5u rfmode=0
M$3046 VDD|VPWR|vdd \$71331 A|Q$7 VDD|VPWR|vdd sg13_lv_pmos L=0.13u W=1.12u
+ AS=0.2128p AD=0.3808p PS=1.5u PD=2.92u rfmode=0
M$3047 \$72171 \$72170 VDD|VPWR|vdd VDD|VPWR|vdd sg13_lv_pmos L=0.13u W=0.84u
+ AS=0.2856p AD=0.1974p PS=2.36u PD=1.5u rfmode=0
M$3048 VDD|VPWR|vdd \$72171 Q_N$19 VDD|VPWR|vdd sg13_lv_pmos L=0.13u W=1.12u
+ AS=0.1974p AD=0.3808p PS=1.5u PD=2.92u rfmode=0
M$3049 A|Y$19 A|X$25 VDD|VPWR|vdd VDD|VPWR|vdd sg13_lv_pmos L=0.13u W=1.12u
+ AS=0.3808p AD=0.3808p PS=2.92u PD=2.92u rfmode=0
M$3050 B2|Y C1|X$1 \$72174 VDD|VPWR|vdd sg13_lv_pmos L=0.13u W=1.12u AS=0.3808p
+ AD=0.2128p PS=2.92u PD=1.5u rfmode=0
M$3051 \$72174 B2|D|Q \$72175 VDD|VPWR|vdd sg13_lv_pmos L=0.13u W=1.12u
+ AS=0.2128p AD=0.2128p PS=1.5u PD=1.5u rfmode=0
M$3052 \$72175 A2|B|B1|C1|Y \$72174 VDD|VPWR|vdd sg13_lv_pmos L=0.13u W=1.12u
+ AS=0.2128p AD=0.3808p PS=1.5u PD=2.92u rfmode=0
M$3053 VDD|VPWR|vdd A1|D|Q$3 \$72175 VDD|VPWR|vdd sg13_lv_pmos L=0.13u W=1.12u
+ AS=0.3808p AD=0.2128p PS=2.92u PD=1.5u rfmode=0
M$3054 \$72175 A2|B|B1|Y$1 VDD|VPWR|vdd VDD|VPWR|vdd sg13_lv_pmos L=0.13u
+ W=1.12u AS=0.2128p AD=0.3808p PS=1.5u PD=2.92u rfmode=0
M$3055 VDD|VPWR|vdd C|D|Q \$72177 VDD|VPWR|vdd sg13_lv_pmos L=0.13u W=0.84u
+ AS=0.36195p AD=0.1596p PS=1.84u PD=1.22u rfmode=0
M$3056 \$72177 A|B|B2|B_N|Q VDD|VPWR|vdd VDD|VPWR|vdd sg13_lv_pmos L=0.13u
+ W=0.84u AS=0.1596p AD=0.1596p PS=1.22u PD=1.22u rfmode=0
M$3057 VDD|VPWR|vdd A|B_N|Q \$72177 VDD|VPWR|vdd sg13_lv_pmos L=0.13u W=0.84u
+ AS=0.1596p AD=0.2856p PS=1.22u PD=2.36u rfmode=0
M$3058 C1|X$1 \$72177 VDD|VPWR|vdd VDD|VPWR|vdd sg13_lv_pmos L=0.13u W=1.12u
+ AS=0.3808p AD=0.36195p PS=2.92u PD=1.84u rfmode=0
M$3059 B2|Y$1 A2|B1|Y \$72178 VDD|VPWR|vdd sg13_lv_pmos L=0.13u W=1.12u
+ AS=0.3808p AD=0.2128p PS=2.92u PD=1.5u rfmode=0
M$3060 \$72178 A1|Y$4 VDD|VPWR|vdd VDD|VPWR|vdd sg13_lv_pmos L=0.13u W=1.12u
+ AS=0.2128p AD=0.2128p PS=1.5u PD=1.5u rfmode=0
M$3061 VDD|VPWR|vdd A2|B|B1|Y$1 \$72178 VDD|VPWR|vdd sg13_lv_pmos L=0.13u
+ W=1.12u AS=0.2128p AD=0.3808p PS=1.5u PD=2.92u rfmode=0
M$3062 VDD|VPWR|vdd A|D|Q \$72599 VDD|VPWR|vdd sg13_lv_pmos L=0.13u W=0.84u
+ AS=0.2226p AD=0.1596p PS=1.535u PD=1.22u rfmode=0
M$3063 \$72599 A2|B|B1|Y$1 \$72180 VDD|VPWR|vdd sg13_lv_pmos L=0.13u W=0.84u
+ AS=0.1596p AD=0.2856p PS=1.22u PD=2.36u rfmode=0
M$3064 B1|X \$72180 VDD|VPWR|vdd VDD|VPWR|vdd sg13_lv_pmos L=0.13u W=1.12u
+ AS=0.3976p AD=0.2226p PS=2.95u PD=1.535u rfmode=0
M$3065 A2|B|B1|Y$1 A|B_N|Q \$72597 VDD|VPWR|vdd sg13_lv_pmos L=0.13u W=1.12u
+ AS=0.3808p AD=0.1176p PS=2.92u PD=1.33u rfmode=0
M$3066 \$72597 \$72181 VDD|VPWR|vdd VDD|VPWR|vdd sg13_lv_pmos L=0.13u W=1.12u
+ AS=0.1176p AD=0.2618p PS=1.33u PD=1.63u rfmode=0
M$3067 VDD|VPWR|vdd A|B|B2|B_N|Q \$72181 VDD|VPWR|vdd sg13_lv_pmos L=0.13u
+ W=0.84u AS=0.2618p AD=0.2856p PS=1.63u PD=2.36u rfmode=0
M$3068 \$71817 A|B_N|Q VDD|VPWR|vdd VDD|VPWR|vdd sg13_lv_pmos L=0.13u W=0.84u
+ AS=0.2856p AD=0.1596p PS=2.36u PD=1.22u rfmode=0
M$3069 VDD|VPWR|vdd A|B|B2|B_N|Q \$71817 VDD|VPWR|vdd sg13_lv_pmos L=0.13u
+ W=0.84u AS=0.1596p AD=0.1596p PS=1.22u PD=1.22u rfmode=0
M$3070 VDD|VPWR|vdd C|Q \$71817 VDD|VPWR|vdd sg13_lv_pmos L=0.13u W=0.84u
+ AS=0.36195p AD=0.1596p PS=1.84u PD=1.22u rfmode=0
M$3071 VDD|VPWR|vdd \$71817 C1|X VDD|VPWR|vdd sg13_lv_pmos L=0.13u W=1.12u
+ AS=0.36195p AD=0.3808p PS=1.84u PD=2.92u rfmode=0
M$3072 VDD|VPWR|vdd A2|B1|Y \$72182 VDD|VPWR|vdd sg13_lv_pmos L=0.13u W=1.12u
+ AS=0.3808p AD=0.2128p PS=2.92u PD=1.5u rfmode=0
M$3073 \$72182 A1|D|Q$2 VDD|VPWR|vdd VDD|VPWR|vdd sg13_lv_pmos L=0.13u W=1.12u
+ AS=0.2128p AD=0.3808p PS=1.5u PD=2.92u rfmode=0
M$3074 \$72183 A2|B|B1|Y$1 \$72182 VDD|VPWR|vdd sg13_lv_pmos L=0.13u W=1.12u
+ AS=0.3808p AD=0.2128p PS=2.92u PD=1.5u rfmode=0
M$3075 \$72182 B2|D|Q$1 \$72183 VDD|VPWR|vdd sg13_lv_pmos L=0.13u W=1.12u
+ AS=0.2128p AD=0.2128p PS=1.5u PD=1.5u rfmode=0
M$3076 \$72183 C1|X B2|Y$2 VDD|VPWR|vdd sg13_lv_pmos L=0.13u W=1.12u AS=0.2128p
+ AD=0.3808p PS=1.5u PD=2.92u rfmode=0
M$3081 \$72186 \$72267 \$72248 VDD|VPWR|vdd sg13_lv_pmos L=0.13u W=0.42u
+ AS=0.191p AD=0.1008p PS=1.44u PD=0.9u rfmode=0
M$3082 \$72248 \$72187 VDD|VPWR|vdd VDD|VPWR|vdd sg13_lv_pmos L=0.13u W=0.42u
+ AS=0.1008p AD=0.2387p PS=0.9u PD=1.84u rfmode=0
M$3083 VDD|VPWR|vdd \$72266 \$72267 VDD|VPWR|vdd sg13_lv_pmos L=0.13u W=0.84u
+ AS=0.26675p AD=0.2856p PS=1.845u PD=2.36u rfmode=0
M$3084 VDD|VPWR|vdd \$72185 \$72600 VDD|VPWR|vdd sg13_lv_pmos L=0.13u W=1u
+ AS=0.26675p AD=0.105p PS=1.845u PD=1.21u rfmode=0
M$3085 \$72600 \$72266 \$72186 VDD|VPWR|vdd sg13_lv_pmos L=0.13u W=1u AS=0.105p
+ AD=0.191p PS=1.21u PD=1.44u rfmode=0
M$3086 VDD|VPWR|vdd \$72186 \$72187 VDD|VPWR|vdd sg13_lv_pmos L=0.13u W=1.12u
+ AS=0.2387p AD=0.2128p PS=1.84u PD=1.5u rfmode=0
M$3087 \$72187 RESET_B|Y$1 VDD|VPWR|vdd VDD|VPWR|vdd sg13_lv_pmos L=0.13u
+ W=1.12u AS=0.2128p AD=0.2128p PS=1.5u PD=1.5u rfmode=0
M$3088 VDD|VPWR|vdd \$72187 A|Q$10 VDD|VPWR|vdd sg13_lv_pmos L=0.13u W=1.12u
+ AS=0.2128p AD=0.3808p PS=1.5u PD=2.92u rfmode=0
M$3089 \$72189 \$72187 VDD|VPWR|vdd VDD|VPWR|vdd sg13_lv_pmos L=0.13u W=0.84u
+ AS=0.2856p AD=0.1974p PS=2.36u PD=1.5u rfmode=0
M$3090 VDD|VPWR|vdd \$72189 Q_N$20 VDD|VPWR|vdd sg13_lv_pmos L=0.13u W=1.12u
+ AS=0.1974p AD=0.3808p PS=1.5u PD=2.92u rfmode=0
M$3091 \$71899 RESET_B|Y$2 VDD|VPWR|vdd VDD|VPWR|vdd sg13_lv_pmos L=0.13u
+ W=0.42u AS=0.147p AD=0.1563p PS=1.54u PD=1.22u rfmode=0
M$3092 VDD|VPWR|vdd \$71334 \$72089 VDD|VPWR|vdd sg13_lv_pmos L=0.13u W=0.42u
+ AS=0.1563p AD=0.063p PS=1.22u PD=0.72u rfmode=0
M$3093 \$72089 \$71335 \$71899 VDD|VPWR|vdd sg13_lv_pmos L=0.13u W=0.42u
+ AS=0.063p AD=0.0798p PS=0.72u PD=0.8u rfmode=0
M$3094 \$71899 \$71798 \$71818 VDD|VPWR|vdd sg13_lv_pmos L=0.13u W=0.42u
+ AS=0.0798p AD=0.1428p PS=0.8u PD=1.52u rfmode=0
M$3095 A|Y$20 A|X$27 VDD|VPWR|vdd VDD|VPWR|vdd sg13_lv_pmos L=0.13u W=1.12u
+ AS=0.3808p AD=0.3808p PS=2.92u PD=2.92u rfmode=0
M$3102 \$71340 B|D|Y \$72088 VDD|VPWR|vdd sg13_lv_pmos L=0.13u W=0.84u
+ AS=0.2856p AD=0.1596p PS=2.36u PD=1.22u rfmode=0
M$3103 VDD|VPWR|vdd A|B|X \$72088 VDD|VPWR|vdd sg13_lv_pmos L=0.13u W=0.84u
+ AS=0.2226p AD=0.1596p PS=1.535u PD=1.22u rfmode=0
M$3104 VDD|VPWR|vdd \$71340 A|X$41 VDD|VPWR|vdd sg13_lv_pmos L=0.13u W=1.12u
+ AS=0.2226p AD=0.3976p PS=1.535u PD=2.95u rfmode=0
M$3105 \$72193 \$72269 \$72247 VDD|VPWR|vdd sg13_lv_pmos L=0.13u W=0.42u
+ AS=0.191p AD=0.1008p PS=1.44u PD=0.9u rfmode=0
M$3106 \$72247 \$72194 VDD|VPWR|vdd VDD|VPWR|vdd sg13_lv_pmos L=0.13u W=0.42u
+ AS=0.1008p AD=0.2387p PS=0.9u PD=1.84u rfmode=0
M$3107 VDD|VPWR|vdd \$72268 \$72269 VDD|VPWR|vdd sg13_lv_pmos L=0.13u W=0.84u
+ AS=0.26675p AD=0.2856p PS=1.845u PD=2.36u rfmode=0
M$3108 VDD|VPWR|vdd \$72192 \$72598 VDD|VPWR|vdd sg13_lv_pmos L=0.13u W=1u
+ AS=0.26675p AD=0.105p PS=1.845u PD=1.21u rfmode=0
M$3109 \$72598 \$72268 \$72193 VDD|VPWR|vdd sg13_lv_pmos L=0.13u W=1u AS=0.105p
+ AD=0.191p PS=1.21u PD=1.44u rfmode=0
M$3110 VDD|VPWR|vdd \$72193 \$72194 VDD|VPWR|vdd sg13_lv_pmos L=0.13u W=1.12u
+ AS=0.2387p AD=0.2128p PS=1.84u PD=1.5u rfmode=0
M$3111 \$72194 RESET_B|Y$1 VDD|VPWR|vdd VDD|VPWR|vdd sg13_lv_pmos L=0.13u
+ W=1.12u AS=0.2128p AD=0.2128p PS=1.5u PD=1.5u rfmode=0
M$3112 VDD|VPWR|vdd \$72194 A|Q$11 VDD|VPWR|vdd sg13_lv_pmos L=0.13u W=1.12u
+ AS=0.2128p AD=0.3808p PS=1.5u PD=2.92u rfmode=0
M$3113 \$72196 \$72194 VDD|VPWR|vdd VDD|VPWR|vdd sg13_lv_pmos L=0.13u W=0.84u
+ AS=0.2856p AD=0.1974p PS=2.36u PD=1.5u rfmode=0
M$3114 VDD|VPWR|vdd \$72196 Q_N$21 VDD|VPWR|vdd sg13_lv_pmos L=0.13u W=1.12u
+ AS=0.1974p AD=0.3808p PS=1.5u PD=2.92u rfmode=0
M$3115 VDD|VPWR|vdd A|Q$11 \$72198 VDD|VPWR|vdd sg13_lv_pmos L=0.13u W=0.84u
+ AS=0.2114p AD=0.2856p PS=1.54u PD=2.36u rfmode=0
M$3116 A|X$44 \$72198 VDD|VPWR|vdd VDD|VPWR|vdd sg13_lv_pmos L=0.13u W=1.12u
+ AS=0.42p AD=0.2114p PS=2.99u PD=1.54u rfmode=0
M$3117 \$73145 A$1 VDD|VPWR|vdd \$72817 sg13_lv_pmos L=0.13u W=0.5u AS=0.17p
+ AD=0.17p PS=1.68u PD=1.68u rfmode=0
M$3118 VDD|VPWR|vdd A$1 Y$2 \$72817 sg13_lv_pmos L=0.13u W=1.12u AS=0.3808p
+ AD=0.3808p PS=2.92u PD=2.92u rfmode=0
M$3119 VDD|VPWR|vdd
+ BOTTOM|TOP|VGND|VSS|anode|cathode|core|h_sw[0]|h_sw[10]|h_sw[1]|h_sw[2]|h_sw[3]|h_sw[4]|h_sw[5]|h_sw[6]|h_sw[7]|h_sw[8]|h_sw[9]|l_sw[0]|l_sw[10]|l_sw[1]|l_sw[2]|l_sw[3]|l_sw[4]|l_sw[5]|l_sw[6]|l_sw[7]|l_sw[8]|l_sw[9]|out|pad|padres|vc|vcp|vdd|vddr|vip|vss|z
+ VDD|VPWR|vdd \$72817 sg13_lv_pmos L=1u W=1u AS=0.34p AD=0.34p PS=2.68u
+ PD=2.68u rfmode=0
M$3121 VDD|VPWR|vdd A|comp_p|outp A|Y$18 VDD|VPWR|vdd sg13_lv_pmos L=0.13u
+ W=1.12u AS=0.3808p AD=0.3808p PS=2.92u PD=2.92u rfmode=0
M$3122 VDD|VPWR|vdd A|outn B|Y$2 VDD|VPWR|vdd sg13_lv_pmos L=0.13u W=1.12u
+ AS=0.3808p AD=0.3808p PS=2.92u PD=2.92u rfmode=0
M$3123 \$72151 B|Y$2 \$72939 VDD|VPWR|vdd sg13_lv_pmos L=0.13u W=0.84u
+ AS=0.2856p AD=0.1596p PS=2.36u PD=1.22u rfmode=0
M$3124 VDD|VPWR|vdd A|Y$18 \$72939 VDD|VPWR|vdd sg13_lv_pmos L=0.13u W=0.84u
+ AS=0.2226p AD=0.1596p PS=1.535u PD=1.22u rfmode=0
M$3125 VDD|VPWR|vdd \$72151 A|X$45 VDD|VPWR|vdd sg13_lv_pmos L=0.13u W=1.12u
+ AS=0.2226p AD=0.3976p PS=1.535u PD=2.95u rfmode=0
M$3127 VDD|VPWR|vdd A|X$45 \$72153 VDD|VPWR|vdd sg13_lv_pmos L=0.13u W=0.42u
+ AS=0.1523p AD=0.1428p PS=1.38u PD=1.52u rfmode=0
M$3128 VDD|VPWR|vdd \$72153 \$72154 VDD|VPWR|vdd sg13_lv_pmos L=0.5u W=1u
+ AS=0.1523p AD=0.34p PS=1.38u PD=2.68u rfmode=0
M$3129 \$72250 \$72154 VDD|VPWR|vdd VDD|VPWR|vdd sg13_lv_pmos L=0.5u W=1u
+ AS=0.34p AD=0.2254p PS=2.68u PD=1.53u rfmode=0
M$3130 VDD|VPWR|vdd \$72250 A|X|rdy VDD|VPWR|vdd sg13_lv_pmos L=0.13u W=1.12u
+ AS=0.2254p AD=0.4256p PS=1.53u PD=3u rfmode=0
M$3131 VDD|VPWR|vdd D|X \$72156 VDD|VPWR|vdd sg13_lv_pmos L=0.13u W=0.42u
+ AS=0.1428p AD=0.0798p PS=1.52u PD=0.8u rfmode=0
M$3132 VDD|VPWR|vdd RESET_B|Y$1 \$72156 VDD|VPWR|vdd sg13_lv_pmos L=0.13u
+ W=0.42u AS=0.3623875p AD=0.0798p PS=2.605u PD=0.8u rfmode=0
M$3133 VDD|VPWR|vdd \$72157 \$72251 VDD|VPWR|vdd sg13_lv_pmos L=0.13u W=1u
+ AS=0.3623875p AD=0.34p PS=2.605u PD=2.68u rfmode=0
M$3134 VDD|VPWR|vdd RESET_B|Y$1 \$72157 VDD|VPWR|vdd sg13_lv_pmos L=0.13u
+ W=0.42u AS=0.1563p AD=0.147p PS=1.22u PD=1.54u rfmode=0
M$3135 VDD|VPWR|vdd \$72251 \$72480 VDD|VPWR|vdd sg13_lv_pmos L=0.13u W=0.42u
+ AS=0.1563p AD=0.063p PS=1.22u PD=0.72u rfmode=0
M$3136 \$72480 \$72252 \$72157 VDD|VPWR|vdd sg13_lv_pmos L=0.13u W=0.42u
+ AS=0.063p AD=0.0798p PS=0.72u PD=0.8u rfmode=0
M$3137 \$72157 \$72158 \$72156 VDD|VPWR|vdd sg13_lv_pmos L=0.13u W=0.42u
+ AS=0.0798p AD=0.1428p PS=0.8u PD=1.52u rfmode=0
M$3138 A|X$17 \$73057 VDD|VPWR|vdd VDD|VPWR|vdd sg13_lv_pmos L=0.13u W=1.12u
+ AS=0.42p AD=0.2114p PS=2.99u PD=1.54u rfmode=0
M$3139 VDD|VPWR|vdd A|Q$14 \$73057 VDD|VPWR|vdd sg13_lv_pmos L=0.13u W=0.84u
+ AS=0.2114p AD=0.2856p PS=1.54u PD=2.36u rfmode=0
M$3140 VDD|VPWR|vdd \$72252 \$72158 VDD|VPWR|vdd sg13_lv_pmos L=0.13u W=1.12u
+ AS=0.41165p AD=0.3864p PS=2.12u PD=2.93u rfmode=0
M$3141 VDD|VPWR|vdd CLK|D|GATE|Q$2 \$72252 VDD|VPWR|vdd sg13_lv_pmos L=0.13u
+ W=1.12u AS=0.41165p AD=0.4088p PS=2.12u PD=2.97u rfmode=0
M$3142 CLK|D|GATE|Q$2 \$73013 VDD|VPWR|vdd VDD|VPWR|vdd sg13_lv_pmos L=0.13u
+ W=1.12u AS=0.3808p AD=0.2128p PS=2.92u PD=1.5u rfmode=0
M$3143 VDD|VPWR|vdd \$73058 \$73013 VDD|VPWR|vdd sg13_lv_pmos L=0.13u W=1.12u
+ AS=0.2128p AD=0.3864p PS=1.5u PD=2.93u rfmode=0
M$3144 \$72251 \$72252 \$72253 VDD|VPWR|vdd sg13_lv_pmos L=0.13u W=1u AS=0.34p
+ AD=0.2048p PS=2.68u PD=1.63u rfmode=0
M$3145 \$72253 \$72158 \$72481 VDD|VPWR|vdd sg13_lv_pmos L=0.13u W=0.42u
+ AS=0.2048p AD=0.09345p PS=1.63u PD=0.865u rfmode=0
M$3146 VDD|VPWR|vdd \$72254 \$72481 VDD|VPWR|vdd sg13_lv_pmos L=0.13u W=0.42u
+ AS=0.204p AD=0.09345p PS=1.835u PD=0.865u rfmode=0
M$3147 VDD|VPWR|vdd RESET_B|Y$1 \$72254 VDD|VPWR|vdd sg13_lv_pmos L=0.13u
+ W=0.42u AS=0.204p AD=0.0798p PS=1.835u PD=0.8u rfmode=0
M$3148 VDD|VPWR|vdd \$72253 \$72254 VDD|VPWR|vdd sg13_lv_pmos L=0.13u W=0.42u
+ AS=0.2639p AD=0.0798p PS=1.81u PD=0.8u rfmode=0
M$3149 VDD|VPWR|vdd \$72253 D|Q_N$3 VDD|VPWR|vdd sg13_lv_pmos L=0.13u W=1.12u
+ AS=0.2639p AD=0.4312p PS=1.81u PD=3.01u rfmode=0
M$3150 VDD|VPWR|vdd \$73058 \$73015 VDD|VPWR|vdd sg13_lv_pmos L=0.13u W=0.42u
+ AS=0.2639p AD=0.0798p PS=1.81u PD=0.8u rfmode=0
M$3151 \$73015 RESET_B|Y$2 VDD|VPWR|vdd VDD|VPWR|vdd sg13_lv_pmos L=0.13u
+ W=0.42u AS=0.0798p AD=0.204p PS=0.8u PD=1.835u rfmode=0
M$3152 VDD|VPWR|vdd \$73015 \$73372 VDD|VPWR|vdd sg13_lv_pmos L=0.13u W=0.42u
+ AS=0.204p AD=0.09345p PS=1.835u PD=0.865u rfmode=0
M$3153 \$73372 \$73148 \$73058 VDD|VPWR|vdd sg13_lv_pmos L=0.13u W=0.42u
+ AS=0.09345p AD=0.2048p PS=0.865u PD=1.63u rfmode=0
M$3154 \$73058 \$73149 \$73017 VDD|VPWR|vdd sg13_lv_pmos L=0.13u W=1u
+ AS=0.2048p AD=0.34p PS=1.63u PD=2.68u rfmode=0
M$3155 Q_N$22 \$73058 VDD|VPWR|vdd VDD|VPWR|vdd sg13_lv_pmos L=0.13u W=1.12u
+ AS=0.4312p AD=0.2639p PS=3.01u PD=1.81u rfmode=0
M$3156 \$73149 A|CLK|X VDD|VPWR|vdd VDD|VPWR|vdd sg13_lv_pmos L=0.13u W=1.12u
+ AS=0.4088p AD=0.41165p PS=2.97u PD=2.12u rfmode=0
M$3157 VDD|VPWR|vdd \$73149 \$73148 VDD|VPWR|vdd sg13_lv_pmos L=0.13u W=1.12u
+ AS=0.41165p AD=0.3864p PS=2.12u PD=2.93u rfmode=0
M$3158 A|X$33 \$73060 VDD|VPWR|vdd VDD|VPWR|vdd sg13_lv_pmos L=0.13u W=1.12u
+ AS=0.42p AD=0.2114p PS=2.99u PD=1.54u rfmode=0
M$3159 VDD|VPWR|vdd A|Q$15 \$73060 VDD|VPWR|vdd sg13_lv_pmos L=0.13u W=0.84u
+ AS=0.2114p AD=0.2856p PS=1.54u PD=2.36u rfmode=0
M$3160 VDD|VPWR|vdd A|CLK|X \$72256 VDD|VPWR|vdd sg13_lv_pmos L=0.13u W=1.12u
+ AS=0.41165p AD=0.4088p PS=2.12u PD=2.97u rfmode=0
M$3161 VDD|VPWR|vdd \$72256 \$72165 VDD|VPWR|vdd sg13_lv_pmos L=0.13u W=1.12u
+ AS=0.41165p AD=0.3864p PS=2.12u PD=2.93u rfmode=0
M$3162 \$73061 \$73022 VDD|VPWR|vdd VDD|VPWR|vdd sg13_lv_pmos L=0.13u W=1.12u
+ AS=0.3864p AD=0.41165p PS=2.93u PD=2.12u rfmode=0
M$3163 VDD|VPWR|vdd CLK|D|GATE|Q$5 \$73022 VDD|VPWR|vdd sg13_lv_pmos L=0.13u
+ W=1.12u AS=0.41165p AD=0.4088p PS=2.12u PD=2.97u rfmode=0
M$3164 \$72166 \$72165 \$72167 VDD|VPWR|vdd sg13_lv_pmos L=0.13u W=0.42u
+ AS=0.1428p AD=0.0798p PS=1.52u PD=0.8u rfmode=0
M$3165 \$72167 \$72256 \$72490 VDD|VPWR|vdd sg13_lv_pmos L=0.13u W=0.42u
+ AS=0.0798p AD=0.063p PS=0.8u PD=0.72u rfmode=0
M$3166 VDD|VPWR|vdd \$72257 \$72490 VDD|VPWR|vdd sg13_lv_pmos L=0.13u W=0.42u
+ AS=0.1563p AD=0.063p PS=1.22u PD=0.72u rfmode=0
M$3167 VDD|VPWR|vdd RESET_B|Y$2 \$72167 VDD|VPWR|vdd sg13_lv_pmos L=0.13u
+ W=0.42u AS=0.1563p AD=0.147p PS=1.22u PD=1.54u rfmode=0
M$3168 VDD|VPWR|vdd \$72167 \$72257 VDD|VPWR|vdd sg13_lv_pmos L=0.13u W=1u
+ AS=0.3623875p AD=0.34p PS=2.605u PD=2.68u rfmode=0
M$3169 VDD|VPWR|vdd RESET_B|Y$2 \$72166 VDD|VPWR|vdd sg13_lv_pmos L=0.13u
+ W=0.42u AS=0.3623875p AD=0.0798p PS=2.605u PD=0.8u rfmode=0
M$3170 \$72166 CLK|D|GATE|Q$3 VDD|VPWR|vdd VDD|VPWR|vdd sg13_lv_pmos L=0.13u
+ W=0.42u AS=0.0798p AD=0.1428p PS=0.8u PD=1.52u rfmode=0
M$3171 \$73026 \$73062 VDD|VPWR|vdd VDD|VPWR|vdd sg13_lv_pmos L=0.13u W=1.12u
+ AS=0.3864p AD=0.2128p PS=2.93u PD=1.5u rfmode=0
M$3172 VDD|VPWR|vdd \$73026 A1|D|Q$2 VDD|VPWR|vdd sg13_lv_pmos L=0.13u W=1.12u
+ AS=0.2128p AD=0.3808p PS=1.5u PD=2.92u rfmode=0
M$3173 VDD|VPWR|vdd A2|D|Q \$72168 VDD|VPWR|vdd sg13_lv_pmos L=0.13u W=0.84u
+ AS=0.3018p AD=0.2856p PS=1.97u PD=2.36u rfmode=0
M$3174 VDD|VPWR|vdd CLK|D|GATE|Q$3 \$72258 VDD|VPWR|vdd sg13_lv_pmos L=0.13u
+ W=0.84u AS=0.3018p AD=0.3234p PS=1.97u PD=2.45u rfmode=0
M$3175 VDD|VPWR|vdd \$73029 \$73031 VDD|VPWR|vdd sg13_lv_pmos L=0.13u W=0.84u
+ AS=0.1974p AD=0.2856p PS=1.5u PD=2.36u rfmode=0
M$3176 VDD|VPWR|vdd \$73031 Q_N$23 VDD|VPWR|vdd sg13_lv_pmos L=0.13u W=1.12u
+ AS=0.1974p AD=0.3808p PS=1.5u PD=2.92u rfmode=0
M$3177 A|X$35 \$73066 VDD|VPWR|vdd VDD|VPWR|vdd sg13_lv_pmos L=0.13u W=1.12u
+ AS=0.42p AD=0.2114p PS=2.99u PD=1.54u rfmode=0
M$3178 VDD|VPWR|vdd A|Q$12 \$73066 VDD|VPWR|vdd sg13_lv_pmos L=0.13u W=0.84u
+ AS=0.2114p AD=0.2856p PS=1.54u PD=2.36u rfmode=0
M$3179 A|X$25 \$73067 VDD|VPWR|vdd VDD|VPWR|vdd sg13_lv_pmos L=0.13u W=1.12u
+ AS=0.42p AD=0.2114p PS=2.99u PD=1.54u rfmode=0
M$3180 VDD|VPWR|vdd A|Q$16 \$73067 VDD|VPWR|vdd sg13_lv_pmos L=0.13u W=0.84u
+ AS=0.2114p AD=0.2856p PS=1.54u PD=2.36u rfmode=0
M$3181 \$73068 \$73036 VDD|VPWR|vdd VDD|VPWR|vdd sg13_lv_pmos L=0.13u W=1.12u
+ AS=0.3864p AD=0.41165p PS=2.93u PD=2.12u rfmode=0
M$3182 VDD|VPWR|vdd CLK|D|GATE|Q$7 \$73036 VDD|VPWR|vdd sg13_lv_pmos L=0.13u
+ W=1.12u AS=0.41165p AD=0.4088p PS=2.12u PD=2.97u rfmode=0
M$3183 VDD|VPWR|vdd D|Q_N$4 \$72185 VDD|VPWR|vdd sg13_lv_pmos L=0.13u W=0.84u
+ AS=0.3018p AD=0.2856p PS=1.97u PD=2.36u rfmode=0
M$3184 VDD|VPWR|vdd CLK|D|GATE|Q$7 \$72266 VDD|VPWR|vdd sg13_lv_pmos L=0.13u
+ W=0.84u AS=0.3018p AD=0.3234p PS=1.97u PD=2.45u rfmode=0
M$3185 \$73039 \$73069 VDD|VPWR|vdd VDD|VPWR|vdd sg13_lv_pmos L=0.13u W=1.12u
+ AS=0.3864p AD=0.2128p PS=2.93u PD=1.5u rfmode=0
M$3186 VDD|VPWR|vdd \$73039 B2|D|Q$1 VDD|VPWR|vdd sg13_lv_pmos L=0.13u W=1.12u
+ AS=0.2128p AD=0.3808p PS=1.5u PD=2.92u rfmode=0
M$3187 VDD|VPWR|vdd A|Q$17 \$73070 VDD|VPWR|vdd sg13_lv_pmos L=0.13u W=0.84u
+ AS=0.2114p AD=0.2856p PS=1.54u PD=2.36u rfmode=0
M$3188 VDD|VPWR|vdd \$73070 A|X$43 VDD|VPWR|vdd sg13_lv_pmos L=0.13u W=1.12u
+ AS=0.2114p AD=0.42p PS=1.54u PD=2.99u rfmode=0
M$3189 VDD|VPWR|vdd A|Q$10 \$73071 VDD|VPWR|vdd sg13_lv_pmos L=0.13u W=0.84u
+ AS=0.2114p AD=0.2856p PS=1.54u PD=2.36u rfmode=0
M$3190 VDD|VPWR|vdd \$73071 A|X$27 VDD|VPWR|vdd sg13_lv_pmos L=0.13u W=1.12u
+ AS=0.2114p AD=0.42p PS=1.54u PD=2.99u rfmode=0
M$3191 \$73072 \$73043 VDD|VPWR|vdd VDD|VPWR|vdd sg13_lv_pmos L=0.13u W=1.12u
+ AS=0.3864p AD=0.41165p PS=2.93u PD=2.12u rfmode=0
M$3192 VDD|VPWR|vdd CLK|D|GATE|Q$4 \$73043 VDD|VPWR|vdd sg13_lv_pmos L=0.13u
+ W=1.12u AS=0.41165p AD=0.4088p PS=2.12u PD=2.97u rfmode=0
M$3193 \$73047 \$73073 VDD|VPWR|vdd VDD|VPWR|vdd sg13_lv_pmos L=0.13u W=1.12u
+ AS=0.3864p AD=0.2128p PS=2.93u PD=1.5u rfmode=0
M$3194 VDD|VPWR|vdd \$73047 A|D|Q VDD|VPWR|vdd sg13_lv_pmos L=0.13u W=1.12u
+ AS=0.2128p AD=0.3808p PS=1.5u PD=2.92u rfmode=0
M$3195 VDD|VPWR|vdd A|D|Q \$72192 VDD|VPWR|vdd sg13_lv_pmos L=0.13u W=0.84u
+ AS=0.3018p AD=0.2856p PS=1.97u PD=2.36u rfmode=0
M$3196 VDD|VPWR|vdd CLK|D|GATE|Q$4 \$72268 VDD|VPWR|vdd sg13_lv_pmos L=0.13u
+ W=0.84u AS=0.3018p AD=0.3234p PS=1.97u PD=2.45u rfmode=0
M$3197 VDD|VPWR|vdd \$73049 \$73051 VDD|VPWR|vdd sg13_lv_pmos L=0.13u W=0.84u
+ AS=0.1974p AD=0.2856p PS=1.5u PD=2.36u rfmode=0
M$3198 VDD|VPWR|vdd \$73051 Q_N$24 VDD|VPWR|vdd sg13_lv_pmos L=0.13u W=1.12u
+ AS=0.1974p AD=0.3808p PS=1.5u PD=2.92u rfmode=0
M$3199 VDD|VPWR|vdd RESET_B|Y$2 \$73059 VDD|VPWR|vdd sg13_lv_pmos L=0.13u
+ W=0.42u AS=0.3623875p AD=0.0798p PS=2.605u PD=0.8u rfmode=0
M$3200 \$73059 CLK|D|GATE|Q$6 VDD|VPWR|vdd VDD|VPWR|vdd sg13_lv_pmos L=0.13u
+ W=0.42u AS=0.0798p AD=0.1428p PS=0.8u PD=1.52u rfmode=0
M$3201 \$73017 \$73150 VDD|VPWR|vdd VDD|VPWR|vdd sg13_lv_pmos L=0.13u W=1u
+ AS=0.34p AD=0.3623875p PS=2.68u PD=2.605u rfmode=0
M$3203 VDD|VPWR|vdd D|X \$73019 VDD|VPWR|vdd sg13_lv_pmos L=0.13u W=0.42u
+ AS=0.1428p AD=0.0798p PS=1.52u PD=0.8u rfmode=0
M$3204 VDD|VPWR|vdd RESET_B|Y$1 \$73019 VDD|VPWR|vdd sg13_lv_pmos L=0.13u
+ W=0.42u AS=0.3623875p AD=0.0798p PS=2.605u PD=0.8u rfmode=0
M$3205 VDD|VPWR|vdd \$73152 \$73021 VDD|VPWR|vdd sg13_lv_pmos L=0.13u W=1u
+ AS=0.3623875p AD=0.34p PS=2.605u PD=2.68u rfmode=0
M$3206 \$73062 \$73061 \$73385 VDD|VPWR|vdd sg13_lv_pmos L=0.13u W=0.42u
+ AS=0.2048p AD=0.09345p PS=1.63u PD=0.865u rfmode=0
M$3207 \$73385 \$73024 VDD|VPWR|vdd VDD|VPWR|vdd sg13_lv_pmos L=0.13u W=0.42u
+ AS=0.09345p AD=0.204p PS=0.865u PD=1.835u rfmode=0
M$3208 VDD|VPWR|vdd RESET_B|Y$1 \$73024 VDD|VPWR|vdd sg13_lv_pmos L=0.13u
+ W=0.42u AS=0.204p AD=0.0798p PS=1.835u PD=0.8u rfmode=0
M$3209 VDD|VPWR|vdd \$73062 \$73024 VDD|VPWR|vdd sg13_lv_pmos L=0.13u W=0.42u
+ AS=0.2639p AD=0.0798p PS=1.81u PD=0.8u rfmode=0
M$3210 \$73021 \$73022 \$73062 VDD|VPWR|vdd sg13_lv_pmos L=0.13u W=1u AS=0.34p
+ AD=0.2048p PS=2.68u PD=1.63u rfmode=0
M$3211 VDD|VPWR|vdd \$73062 D|Q_N$5 VDD|VPWR|vdd sg13_lv_pmos L=0.13u W=1.12u
+ AS=0.2639p AD=0.4312p PS=1.81u PD=3.01u rfmode=0
M$3212 \$73063 A1|D|Q$2 VDD|VPWR|vdd VDD|VPWR|vdd sg13_lv_pmos L=0.13u W=0.84u
+ AS=0.2856p AD=0.3018p PS=2.36u PD=1.97u rfmode=0
M$3213 VDD|VPWR|vdd CLK|D|GATE|Q$5 \$73028 VDD|VPWR|vdd sg13_lv_pmos L=0.13u
+ W=0.84u AS=0.3018p AD=0.3234p PS=1.97u PD=2.45u rfmode=0
M$3214 \$73064 \$73028 VDD|VPWR|vdd VDD|VPWR|vdd sg13_lv_pmos L=0.13u W=0.84u
+ AS=0.2856p AD=0.26675p PS=2.36u PD=1.845u rfmode=0
M$3215 VDD|VPWR|vdd \$73063 \$73551 VDD|VPWR|vdd sg13_lv_pmos L=0.13u W=1u
+ AS=0.26675p AD=0.105p PS=1.845u PD=1.21u rfmode=0
M$3216 \$73551 \$73028 \$73065 VDD|VPWR|vdd sg13_lv_pmos L=0.13u W=1u AS=0.105p
+ AD=0.191p PS=1.21u PD=1.44u rfmode=0
M$3217 \$73065 \$73064 \$73550 VDD|VPWR|vdd sg13_lv_pmos L=0.13u W=0.42u
+ AS=0.191p AD=0.1008p PS=1.44u PD=0.9u rfmode=0
M$3218 VDD|VPWR|vdd \$73029 \$73550 VDD|VPWR|vdd sg13_lv_pmos L=0.13u W=0.42u
+ AS=0.2387p AD=0.1008p PS=1.84u PD=0.9u rfmode=0
M$3219 VDD|VPWR|vdd \$73065 \$73029 VDD|VPWR|vdd sg13_lv_pmos L=0.13u W=1.12u
+ AS=0.2387p AD=0.2128p PS=1.84u PD=1.5u rfmode=0
M$3220 \$73029 RESET_B|Y$1 VDD|VPWR|vdd VDD|VPWR|vdd sg13_lv_pmos L=0.13u
+ W=1.12u AS=0.2128p AD=0.2128p PS=1.5u PD=1.5u rfmode=0
M$3221 VDD|VPWR|vdd \$73029 A|Q$12 VDD|VPWR|vdd sg13_lv_pmos L=0.13u W=1.12u
+ AS=0.2128p AD=0.3808p PS=1.5u PD=2.92u rfmode=0
M$3223 A1|Y$4 A|D|Q$1 VDD|VPWR|vdd VDD|VPWR|vdd sg13_lv_pmos L=0.13u W=1.12u
+ AS=0.3808p AD=0.3808p PS=2.92u PD=2.92u rfmode=0
M$3224 VDD|VPWR|vdd D|X$1 \$73033 VDD|VPWR|vdd sg13_lv_pmos L=0.13u W=0.42u
+ AS=0.1428p AD=0.0798p PS=1.52u PD=0.8u rfmode=0
M$3225 VDD|VPWR|vdd RESET_B|Y$1 \$73033 VDD|VPWR|vdd sg13_lv_pmos L=0.13u
+ W=0.42u AS=0.3623875p AD=0.0798p PS=2.605u PD=0.8u rfmode=0
M$3226 VDD|VPWR|vdd \$73156 \$73035 VDD|VPWR|vdd sg13_lv_pmos L=0.13u W=1u
+ AS=0.3623875p AD=0.34p PS=2.605u PD=2.68u rfmode=0
M$3227 \$73069 \$73068 \$73390 VDD|VPWR|vdd sg13_lv_pmos L=0.13u W=0.42u
+ AS=0.2048p AD=0.09345p PS=1.63u PD=0.865u rfmode=0
M$3228 \$73390 \$73038 VDD|VPWR|vdd VDD|VPWR|vdd sg13_lv_pmos L=0.13u W=0.42u
+ AS=0.09345p AD=0.204p PS=0.865u PD=1.835u rfmode=0
M$3229 VDD|VPWR|vdd RESET_B|Y$1 \$73038 VDD|VPWR|vdd sg13_lv_pmos L=0.13u
+ W=0.42u AS=0.204p AD=0.0798p PS=1.835u PD=0.8u rfmode=0
M$3230 VDD|VPWR|vdd \$73069 \$73038 VDD|VPWR|vdd sg13_lv_pmos L=0.13u W=0.42u
+ AS=0.2639p AD=0.0798p PS=1.81u PD=0.8u rfmode=0
M$3231 \$73035 \$73036 \$73069 VDD|VPWR|vdd sg13_lv_pmos L=0.13u W=1u AS=0.34p
+ AD=0.2048p PS=2.68u PD=1.63u rfmode=0
M$3232 VDD|VPWR|vdd \$73069 D|Q_N$4 VDD|VPWR|vdd sg13_lv_pmos L=0.13u W=1.12u
+ AS=0.2639p AD=0.4312p PS=1.81u PD=3.01u rfmode=0
M$3233 VDD|VPWR|vdd D|X$1 \$73040 VDD|VPWR|vdd sg13_lv_pmos L=0.13u W=0.42u
+ AS=0.1428p AD=0.0798p PS=1.52u PD=0.8u rfmode=0
M$3234 VDD|VPWR|vdd RESET_B|Y$1 \$73040 VDD|VPWR|vdd sg13_lv_pmos L=0.13u
+ W=0.42u AS=0.3623875p AD=0.0798p PS=2.605u PD=0.8u rfmode=0
M$3235 VDD|VPWR|vdd \$73158 \$73042 VDD|VPWR|vdd sg13_lv_pmos L=0.13u W=1u
+ AS=0.3623875p AD=0.34p PS=2.605u PD=2.68u rfmode=0
M$3236 \$73073 \$73072 \$73394 VDD|VPWR|vdd sg13_lv_pmos L=0.13u W=0.42u
+ AS=0.2048p AD=0.09345p PS=1.63u PD=0.865u rfmode=0
M$3237 \$73394 \$73045 VDD|VPWR|vdd VDD|VPWR|vdd sg13_lv_pmos L=0.13u W=0.42u
+ AS=0.09345p AD=0.204p PS=0.865u PD=1.835u rfmode=0
M$3238 VDD|VPWR|vdd RESET_B|Y$1 \$73045 VDD|VPWR|vdd sg13_lv_pmos L=0.13u
+ W=0.42u AS=0.204p AD=0.0798p PS=1.835u PD=0.8u rfmode=0
M$3239 VDD|VPWR|vdd \$73073 \$73045 VDD|VPWR|vdd sg13_lv_pmos L=0.13u W=0.42u
+ AS=0.2639p AD=0.0798p PS=1.81u PD=0.8u rfmode=0
M$3240 \$73042 \$73043 \$73073 VDD|VPWR|vdd sg13_lv_pmos L=0.13u W=1u AS=0.34p
+ AD=0.2048p PS=2.68u PD=1.63u rfmode=0
M$3241 VDD|VPWR|vdd \$73073 D|Q_N$6 VDD|VPWR|vdd sg13_lv_pmos L=0.13u W=1.12u
+ AS=0.2639p AD=0.4312p PS=1.81u PD=3.01u rfmode=0
M$3242 \$73074 D|Q_N$6 VDD|VPWR|vdd VDD|VPWR|vdd sg13_lv_pmos L=0.13u W=0.84u
+ AS=0.2856p AD=0.3018p PS=2.36u PD=1.97u rfmode=0
M$3243 VDD|VPWR|vdd CLK|D|GATE|Q$4 \$73048 VDD|VPWR|vdd sg13_lv_pmos L=0.13u
+ W=0.84u AS=0.3018p AD=0.3234p PS=1.97u PD=2.45u rfmode=0
M$3244 \$73075 \$73048 VDD|VPWR|vdd VDD|VPWR|vdd sg13_lv_pmos L=0.13u W=0.84u
+ AS=0.2856p AD=0.26675p PS=2.36u PD=1.845u rfmode=0
M$3245 VDD|VPWR|vdd \$73074 \$73545 VDD|VPWR|vdd sg13_lv_pmos L=0.13u W=1u
+ AS=0.26675p AD=0.105p PS=1.845u PD=1.21u rfmode=0
M$3246 \$73545 \$73048 \$73076 VDD|VPWR|vdd sg13_lv_pmos L=0.13u W=1u AS=0.105p
+ AD=0.191p PS=1.21u PD=1.44u rfmode=0
M$3247 \$73076 \$73075 \$73546 VDD|VPWR|vdd sg13_lv_pmos L=0.13u W=0.42u
+ AS=0.191p AD=0.1008p PS=1.44u PD=0.9u rfmode=0
M$3248 VDD|VPWR|vdd \$73049 \$73546 VDD|VPWR|vdd sg13_lv_pmos L=0.13u W=0.42u
+ AS=0.2387p AD=0.1008p PS=1.84u PD=0.9u rfmode=0
M$3249 VDD|VPWR|vdd \$73076 \$73049 VDD|VPWR|vdd sg13_lv_pmos L=0.13u W=1.12u
+ AS=0.2387p AD=0.2128p PS=1.84u PD=1.5u rfmode=0
M$3250 \$73049 RESET_B|Y$1 VDD|VPWR|vdd VDD|VPWR|vdd sg13_lv_pmos L=0.13u
+ W=1.12u AS=0.2128p AD=0.2128p PS=1.5u PD=1.5u rfmode=0
M$3251 VDD|VPWR|vdd \$73049 A|Q$13 VDD|VPWR|vdd sg13_lv_pmos L=0.13u W=1.12u
+ AS=0.2128p AD=0.3808p PS=1.5u PD=2.92u rfmode=0
M$3254 \$73609 \$73907 VDD|VPWR|vdd VDD|VPWR|vdd sg13_lv_pmos L=0.13u W=1.12u
+ AS=0.3864p AD=0.2128p PS=2.93u PD=1.5u rfmode=0
M$3255 VDD|VPWR|vdd \$73609 B2|D|Q VDD|VPWR|vdd sg13_lv_pmos L=0.13u W=1.12u
+ AS=0.2128p AD=0.3808p PS=1.5u PD=2.92u rfmode=0
M$3256 VDD|VPWR|vdd A|X$19 A|Y$21 VDD|VPWR|vdd sg13_lv_pmos L=0.13u W=1.12u
+ AS=0.3808p AD=0.3808p PS=2.92u PD=2.92u rfmode=0
M$3257 \$73059 \$73148 \$73150 VDD|VPWR|vdd sg13_lv_pmos L=0.13u W=0.42u
+ AS=0.1428p AD=0.0798p PS=1.52u PD=0.8u rfmode=0
M$3258 \$73150 \$73149 \$73376 VDD|VPWR|vdd sg13_lv_pmos L=0.13u W=0.42u
+ AS=0.0798p AD=0.063p PS=0.8u PD=0.72u rfmode=0
M$3259 \$73376 \$73017 VDD|VPWR|vdd VDD|VPWR|vdd sg13_lv_pmos L=0.13u W=0.42u
+ AS=0.063p AD=0.1563p PS=0.72u PD=1.22u rfmode=0
M$3260 VDD|VPWR|vdd RESET_B|Y$2 \$73150 VDD|VPWR|vdd sg13_lv_pmos L=0.13u
+ W=0.42u AS=0.1563p AD=0.147p PS=1.22u PD=1.54u rfmode=0
M$3261 \$73650 \$73910 \$73772 VDD|VPWR|vdd sg13_lv_pmos L=0.13u W=0.42u
+ AS=0.191p AD=0.1008p PS=1.44u PD=0.9u rfmode=0
M$3262 \$73772 \$73611 VDD|VPWR|vdd VDD|VPWR|vdd sg13_lv_pmos L=0.13u W=0.42u
+ AS=0.1008p AD=0.2387p PS=0.9u PD=1.84u rfmode=0
M$3263 VDD|VPWR|vdd \$73909 \$73910 VDD|VPWR|vdd sg13_lv_pmos L=0.13u W=0.84u
+ AS=0.26675p AD=0.2856p PS=1.845u PD=2.36u rfmode=0
M$3264 VDD|VPWR|vdd \$73649 \$73973 VDD|VPWR|vdd sg13_lv_pmos L=0.13u W=1u
+ AS=0.26675p AD=0.105p PS=1.845u PD=1.21u rfmode=0
M$3265 \$73973 \$73909 \$73650 VDD|VPWR|vdd sg13_lv_pmos L=0.13u W=1u AS=0.105p
+ AD=0.191p PS=1.21u PD=1.44u rfmode=0
M$3266 VDD|VPWR|vdd \$73650 \$73611 VDD|VPWR|vdd sg13_lv_pmos L=0.13u W=1.12u
+ AS=0.2387p AD=0.2128p PS=1.84u PD=1.5u rfmode=0
M$3267 \$73611 RESET_B|Y$1 VDD|VPWR|vdd VDD|VPWR|vdd sg13_lv_pmos L=0.13u
+ W=1.12u AS=0.2128p AD=0.2128p PS=1.5u PD=1.5u rfmode=0
M$3268 VDD|VPWR|vdd \$73611 A|Q$15 VDD|VPWR|vdd sg13_lv_pmos L=0.13u W=1.12u
+ AS=0.2128p AD=0.3808p PS=1.5u PD=2.92u rfmode=0
M$3269 \$73612 \$73611 VDD|VPWR|vdd VDD|VPWR|vdd sg13_lv_pmos L=0.13u W=0.84u
+ AS=0.2856p AD=0.1974p PS=2.36u PD=1.5u rfmode=0
M$3270 VDD|VPWR|vdd \$73612 Q_N$25 VDD|VPWR|vdd sg13_lv_pmos L=0.13u W=1.12u
+ AS=0.1974p AD=0.3808p PS=1.5u PD=2.92u rfmode=0
M$3273 \$73152 RESET_B|Y$1 VDD|VPWR|vdd VDD|VPWR|vdd sg13_lv_pmos L=0.13u
+ W=0.42u AS=0.147p AD=0.1563p PS=1.54u PD=1.22u rfmode=0
M$3274 VDD|VPWR|vdd \$73021 \$73383 VDD|VPWR|vdd sg13_lv_pmos L=0.13u W=0.42u
+ AS=0.1563p AD=0.063p PS=1.22u PD=0.72u rfmode=0
M$3275 \$73383 \$73022 \$73152 VDD|VPWR|vdd sg13_lv_pmos L=0.13u W=0.42u
+ AS=0.063p AD=0.0798p PS=0.72u PD=0.8u rfmode=0
M$3276 \$73152 \$73061 \$73019 VDD|VPWR|vdd sg13_lv_pmos L=0.13u W=0.42u
+ AS=0.0798p AD=0.1428p PS=0.8u PD=1.52u rfmode=0
M$3281 \$73652 \$73912 \$73775 VDD|VPWR|vdd sg13_lv_pmos L=0.13u W=0.42u
+ AS=0.191p AD=0.1008p PS=1.44u PD=0.9u rfmode=0
M$3282 \$73775 \$73614 VDD|VPWR|vdd VDD|VPWR|vdd sg13_lv_pmos L=0.13u W=0.42u
+ AS=0.1008p AD=0.2387p PS=0.9u PD=1.84u rfmode=0
M$3283 VDD|VPWR|vdd \$73911 \$73912 VDD|VPWR|vdd sg13_lv_pmos L=0.13u W=0.84u
+ AS=0.26675p AD=0.2856p PS=1.845u PD=2.36u rfmode=0
M$3284 VDD|VPWR|vdd \$73651 \$73975 VDD|VPWR|vdd sg13_lv_pmos L=0.13u W=1u
+ AS=0.26675p AD=0.105p PS=1.845u PD=1.21u rfmode=0
M$3285 \$73975 \$73911 \$73652 VDD|VPWR|vdd sg13_lv_pmos L=0.13u W=1u AS=0.105p
+ AD=0.191p PS=1.21u PD=1.44u rfmode=0
M$3286 VDD|VPWR|vdd \$73652 \$73614 VDD|VPWR|vdd sg13_lv_pmos L=0.13u W=1.12u
+ AS=0.2387p AD=0.2128p PS=1.84u PD=1.5u rfmode=0
M$3287 \$73614 RESET_B|Y$1 VDD|VPWR|vdd VDD|VPWR|vdd sg13_lv_pmos L=0.13u
+ W=1.12u AS=0.2128p AD=0.2128p PS=1.5u PD=1.5u rfmode=0
M$3288 VDD|VPWR|vdd \$73614 A|Q$16 VDD|VPWR|vdd sg13_lv_pmos L=0.13u W=1.12u
+ AS=0.2128p AD=0.3808p PS=1.5u PD=2.92u rfmode=0
M$3289 \$73615 \$73614 VDD|VPWR|vdd VDD|VPWR|vdd sg13_lv_pmos L=0.13u W=0.84u
+ AS=0.2856p AD=0.1974p PS=2.36u PD=1.5u rfmode=0
M$3290 VDD|VPWR|vdd \$73615 Q_N$26 VDD|VPWR|vdd sg13_lv_pmos L=0.13u W=1.12u
+ AS=0.1974p AD=0.3808p PS=1.5u PD=2.92u rfmode=0
M$3291 \$73617 A|X VDD|VPWR|vdd VDD|VPWR|vdd sg13_lv_pmos L=0.13u W=0.84u
+ AS=0.2856p AD=0.2114p PS=2.36u PD=1.54u rfmode=0
M$3292 VDD|VPWR|vdd \$73617 D|X$1 VDD|VPWR|vdd sg13_lv_pmos L=0.13u W=1.12u
+ AS=0.2114p AD=0.42p PS=1.54u PD=2.99u rfmode=0
M$3293 \$73654 \$73915 \$73776 VDD|VPWR|vdd sg13_lv_pmos L=0.13u W=0.42u
+ AS=0.191p AD=0.1008p PS=1.44u PD=0.9u rfmode=0
M$3294 \$73776 \$73618 VDD|VPWR|vdd VDD|VPWR|vdd sg13_lv_pmos L=0.13u W=0.42u
+ AS=0.1008p AD=0.2387p PS=0.9u PD=1.84u rfmode=0
M$3295 VDD|VPWR|vdd \$73914 \$73915 VDD|VPWR|vdd sg13_lv_pmos L=0.13u W=0.84u
+ AS=0.26675p AD=0.2856p PS=1.845u PD=2.36u rfmode=0
M$3296 VDD|VPWR|vdd \$73653 \$73976 VDD|VPWR|vdd sg13_lv_pmos L=0.13u W=1u
+ AS=0.26675p AD=0.105p PS=1.845u PD=1.21u rfmode=0
M$3297 \$73976 \$73914 \$73654 VDD|VPWR|vdd sg13_lv_pmos L=0.13u W=1u AS=0.105p
+ AD=0.191p PS=1.21u PD=1.44u rfmode=0
M$3298 VDD|VPWR|vdd \$73654 \$73618 VDD|VPWR|vdd sg13_lv_pmos L=0.13u W=1.12u
+ AS=0.2387p AD=0.2128p PS=1.84u PD=1.5u rfmode=0
M$3299 \$73618 RESET_B|Y$1 VDD|VPWR|vdd VDD|VPWR|vdd sg13_lv_pmos L=0.13u
+ W=1.12u AS=0.2128p AD=0.2128p PS=1.5u PD=1.5u rfmode=0
M$3300 VDD|VPWR|vdd \$73618 A|Q$18 VDD|VPWR|vdd sg13_lv_pmos L=0.13u W=1.12u
+ AS=0.2128p AD=0.3808p PS=1.5u PD=2.92u rfmode=0
M$3303 \$73620 \$73618 VDD|VPWR|vdd VDD|VPWR|vdd sg13_lv_pmos L=0.13u W=0.84u
+ AS=0.2856p AD=0.1974p PS=2.36u PD=1.5u rfmode=0
M$3304 VDD|VPWR|vdd \$73620 Q_N$27 VDD|VPWR|vdd sg13_lv_pmos L=0.13u W=1.12u
+ AS=0.1974p AD=0.3808p PS=1.5u PD=2.92u rfmode=0
M$3305 A|Y$22 A|X$38 VDD|VPWR|vdd VDD|VPWR|vdd sg13_lv_pmos L=0.13u W=1.12u
+ AS=0.3808p AD=0.3808p PS=2.92u PD=2.92u rfmode=0
M$3306 A|Y$23 A|X$46 VDD|VPWR|vdd VDD|VPWR|vdd sg13_lv_pmos L=0.13u W=1.12u
+ AS=0.3808p AD=0.3808p PS=2.92u PD=2.92u rfmode=0
M$3307 \$73156 RESET_B|Y$1 VDD|VPWR|vdd VDD|VPWR|vdd sg13_lv_pmos L=0.13u
+ W=0.42u AS=0.147p AD=0.1563p PS=1.54u PD=1.22u rfmode=0
M$3308 VDD|VPWR|vdd \$73035 \$73389 VDD|VPWR|vdd sg13_lv_pmos L=0.13u W=0.42u
+ AS=0.1563p AD=0.063p PS=1.22u PD=0.72u rfmode=0
M$3309 \$73389 \$73036 \$73156 VDD|VPWR|vdd sg13_lv_pmos L=0.13u W=0.42u
+ AS=0.063p AD=0.0798p PS=0.72u PD=0.8u rfmode=0
M$3310 \$73156 \$73068 \$73033 VDD|VPWR|vdd sg13_lv_pmos L=0.13u W=0.42u
+ AS=0.0798p AD=0.1428p PS=0.8u PD=1.52u rfmode=0
M$3311 \$73656 \$73919 \$73818 VDD|VPWR|vdd sg13_lv_pmos L=0.13u W=0.42u
+ AS=0.191p AD=0.1008p PS=1.44u PD=0.9u rfmode=0
M$3312 \$73818 \$73624 VDD|VPWR|vdd VDD|VPWR|vdd sg13_lv_pmos L=0.13u W=0.42u
+ AS=0.1008p AD=0.2387p PS=0.9u PD=1.84u rfmode=0
M$3313 VDD|VPWR|vdd \$73918 \$73919 VDD|VPWR|vdd sg13_lv_pmos L=0.13u W=0.84u
+ AS=0.26675p AD=0.2856p PS=1.845u PD=2.36u rfmode=0
M$3314 VDD|VPWR|vdd \$73655 \$73974 VDD|VPWR|vdd sg13_lv_pmos L=0.13u W=1u
+ AS=0.26675p AD=0.105p PS=1.845u PD=1.21u rfmode=0
M$3315 \$73974 \$73918 \$73656 VDD|VPWR|vdd sg13_lv_pmos L=0.13u W=1u AS=0.105p
+ AD=0.191p PS=1.21u PD=1.44u rfmode=0
M$3316 VDD|VPWR|vdd \$73656 \$73624 VDD|VPWR|vdd sg13_lv_pmos L=0.13u W=1.12u
+ AS=0.2387p AD=0.2128p PS=1.84u PD=1.5u rfmode=0
M$3317 \$73624 RESET_B|Y$1 VDD|VPWR|vdd VDD|VPWR|vdd sg13_lv_pmos L=0.13u
+ W=1.12u AS=0.2128p AD=0.2128p PS=1.5u PD=1.5u rfmode=0
M$3318 VDD|VPWR|vdd \$73624 A|Q$19 VDD|VPWR|vdd sg13_lv_pmos L=0.13u W=1.12u
+ AS=0.2128p AD=0.3808p PS=1.5u PD=2.92u rfmode=0
M$3319 \$73626 \$73624 VDD|VPWR|vdd VDD|VPWR|vdd sg13_lv_pmos L=0.13u W=0.84u
+ AS=0.2856p AD=0.1974p PS=2.36u PD=1.5u rfmode=0
M$3320 VDD|VPWR|vdd \$73626 Q_N$28 VDD|VPWR|vdd sg13_lv_pmos L=0.13u W=1.12u
+ AS=0.1974p AD=0.3808p PS=1.5u PD=2.92u rfmode=0
M$3321 \$73658 \$73922 \$73877 VDD|VPWR|vdd sg13_lv_pmos L=0.13u W=0.42u
+ AS=0.191p AD=0.1008p PS=1.44u PD=0.9u rfmode=0
M$3322 \$73877 \$73628 VDD|VPWR|vdd VDD|VPWR|vdd sg13_lv_pmos L=0.13u W=0.42u
+ AS=0.1008p AD=0.2387p PS=0.9u PD=1.84u rfmode=0
M$3323 VDD|VPWR|vdd \$73921 \$73922 VDD|VPWR|vdd sg13_lv_pmos L=0.13u W=0.84u
+ AS=0.26675p AD=0.2856p PS=1.845u PD=2.36u rfmode=0
M$3324 VDD|VPWR|vdd \$73657 \$73972 VDD|VPWR|vdd sg13_lv_pmos L=0.13u W=1u
+ AS=0.26675p AD=0.105p PS=1.845u PD=1.21u rfmode=0
M$3325 \$73972 \$73921 \$73658 VDD|VPWR|vdd sg13_lv_pmos L=0.13u W=1u AS=0.105p
+ AD=0.191p PS=1.21u PD=1.44u rfmode=0
M$3326 VDD|VPWR|vdd \$73658 \$73628 VDD|VPWR|vdd sg13_lv_pmos L=0.13u W=1.12u
+ AS=0.2387p AD=0.2128p PS=1.84u PD=1.5u rfmode=0
M$3327 \$73628 RESET_B|Y$1 VDD|VPWR|vdd VDD|VPWR|vdd sg13_lv_pmos L=0.13u
+ W=1.12u AS=0.2128p AD=0.2128p PS=1.5u PD=1.5u rfmode=0
M$3328 VDD|VPWR|vdd \$73628 A|Q$17 VDD|VPWR|vdd sg13_lv_pmos L=0.13u W=1.12u
+ AS=0.2128p AD=0.3808p PS=1.5u PD=2.92u rfmode=0
M$3329 \$73629 \$73628 VDD|VPWR|vdd VDD|VPWR|vdd sg13_lv_pmos L=0.13u W=0.84u
+ AS=0.2856p AD=0.1974p PS=2.36u PD=1.5u rfmode=0
M$3330 VDD|VPWR|vdd \$73629 Q_N$29 VDD|VPWR|vdd sg13_lv_pmos L=0.13u W=1.12u
+ AS=0.1974p AD=0.3808p PS=1.5u PD=2.92u rfmode=0
M$3331 \$73158 RESET_B|Y$1 VDD|VPWR|vdd VDD|VPWR|vdd sg13_lv_pmos L=0.13u
+ W=0.42u AS=0.147p AD=0.1563p PS=1.54u PD=1.22u rfmode=0
M$3332 VDD|VPWR|vdd \$73042 \$73393 VDD|VPWR|vdd sg13_lv_pmos L=0.13u W=0.42u
+ AS=0.1563p AD=0.063p PS=1.22u PD=0.72u rfmode=0
M$3333 \$73393 \$73043 \$73158 VDD|VPWR|vdd sg13_lv_pmos L=0.13u W=0.42u
+ AS=0.063p AD=0.0798p PS=0.72u PD=0.8u rfmode=0
M$3334 \$73158 \$73072 \$73040 VDD|VPWR|vdd sg13_lv_pmos L=0.13u W=0.42u
+ AS=0.0798p AD=0.1428p PS=0.8u PD=1.52u rfmode=0
M$3335 \$73633 \$73924 VDD|VPWR|vdd VDD|VPWR|vdd sg13_lv_pmos L=0.13u W=1.12u
+ AS=0.3864p AD=0.2128p PS=2.93u PD=1.5u rfmode=0
M$3336 VDD|VPWR|vdd \$73633 CLK|D|GATE|Q$4 VDD|VPWR|vdd sg13_lv_pmos L=0.13u
+ W=1.12u AS=0.2128p AD=0.3808p PS=1.5u PD=2.92u rfmode=0
M$3337 VDD|VPWR|vdd A|X$47 \$73635 VDD|VPWR|vdd sg13_lv_pmos L=0.13u W=0.84u
+ AS=0.2114p AD=0.2856p PS=1.54u PD=2.36u rfmode=0
M$3338 X|in_h_sw[9]|ph_sw[9]|x \$73635 VDD|VPWR|vdd VDD|VPWR|vdd sg13_lv_pmos
+ L=0.13u W=1.12u AS=0.42p AD=0.2114p PS=2.99u PD=1.54u rfmode=0
M$3339 VDD|VPWR|vdd A|X$32 A|Y$24 VDD|VPWR|vdd sg13_lv_pmos L=0.13u W=1.12u
+ AS=0.3808p AD=0.3808p PS=2.92u PD=2.92u rfmode=0
M$3340 \$73637 A|Q$13 VDD|VPWR|vdd VDD|VPWR|vdd sg13_lv_pmos L=0.13u W=0.84u
+ AS=0.2856p AD=0.2114p PS=2.36u PD=1.54u rfmode=0
M$3341 VDD|VPWR|vdd \$73637 A|X$28 VDD|VPWR|vdd sg13_lv_pmos L=0.13u W=1.12u
+ AS=0.2114p AD=0.42p PS=1.54u PD=2.99u rfmode=0
M$3343 \$73638 A|X$48 VDD|VPWR|vdd VDD|VPWR|vdd sg13_lv_pmos L=0.13u W=0.84u
+ AS=0.2856p AD=0.2114p PS=2.36u PD=1.54u rfmode=0
M$3344 VDD|VPWR|vdd \$73638 X|in_h_sw[10]|ph_sw[10]|x VDD|VPWR|vdd sg13_lv_pmos
+ L=0.13u W=1.12u AS=0.2114p AD=0.42p PS=1.54u PD=2.99u rfmode=0
M$3345 \$73904 Y$2 \$74050 \$73903 sg13_lv_pmos L=0.13u W=0.5u AS=0.17p
+ AD=0.17p PS=1.68u PD=1.68u rfmode=0
M$3346 \$71238 X|ckc|clk VDD|VPWR|vdd \$73544 sg13_lv_pmos L=0.13u W=1u
+ AS=0.265p AD=0.265p PS=2.56u PD=2.56u rfmode=0
M$3348 A|comp_p|outp X|ckc|clk VDD|VPWR|vdd \$73544 sg13_lv_pmos L=0.13u W=1u
+ AS=0.265p AD=0.265p PS=2.56u PD=2.56u rfmode=0
M$3350 A|comp_p|outp A|outn VDD|VPWR|vdd \$73544 sg13_lv_pmos L=0.13u W=2.5u
+ AS=0.6625p AD=0.6625p PS=4.81u PD=4.81u rfmode=0
M$3352 A|outn A|comp_p|outp VDD|VPWR|vdd \$73544 sg13_lv_pmos L=0.13u W=2.5u
+ AS=0.6625p AD=0.6625p PS=4.81u PD=4.81u rfmode=0
M$3354 A|outn X|ckc|clk VDD|VPWR|vdd \$73544 sg13_lv_pmos L=0.13u W=1u
+ AS=0.265p AD=0.265p PS=2.56u PD=2.56u rfmode=0
M$3356 \$71240 X|ckc|clk VDD|VPWR|vdd \$73544 sg13_lv_pmos L=0.13u W=1u
+ AS=0.265p AD=0.265p PS=2.56u PD=2.56u rfmode=0
M$3358 VDD|VPWR|vdd D|X \$73607 VDD|VPWR|vdd sg13_lv_pmos L=0.13u W=0.42u
+ AS=0.1428p AD=0.0798p PS=1.52u PD=0.8u rfmode=0
M$3359 VDD|VPWR|vdd RESET_B|Y$1 \$73607 VDD|VPWR|vdd sg13_lv_pmos L=0.13u
+ W=0.42u AS=0.3623875p AD=0.0798p PS=2.605u PD=0.8u rfmode=0
M$3360 VDD|VPWR|vdd \$73647 \$73646 VDD|VPWR|vdd sg13_lv_pmos L=0.13u W=1u
+ AS=0.3623875p AD=0.34p PS=2.605u PD=2.68u rfmode=0
M$3361 X|in_l_sw[0]|pl_sw[0]|x \$74495 VDD|VPWR|vdd VDD|VPWR|vdd sg13_lv_pmos
+ L=0.13u W=1.12u AS=0.42p AD=0.2114p PS=2.99u PD=1.54u rfmode=0
M$3362 VDD|VPWR|vdd A|X$53 \$74495 VDD|VPWR|vdd sg13_lv_pmos L=0.13u W=0.84u
+ AS=0.2114p AD=0.2856p PS=1.54u PD=2.36u rfmode=0
M$3363 VDD|VPWR|vdd RESET_B|Y$1 \$73647 VDD|VPWR|vdd sg13_lv_pmos L=0.13u
+ W=0.42u AS=0.1563p AD=0.147p PS=1.22u PD=1.54u rfmode=0
M$3364 VDD|VPWR|vdd \$73646 \$73763 VDD|VPWR|vdd sg13_lv_pmos L=0.13u W=0.42u
+ AS=0.1563p AD=0.063p PS=1.22u PD=0.72u rfmode=0
M$3365 \$73763 \$73905 \$73647 VDD|VPWR|vdd sg13_lv_pmos L=0.13u W=0.42u
+ AS=0.063p AD=0.0798p PS=0.72u PD=0.8u rfmode=0
M$3366 \$73647 \$73648 \$73607 VDD|VPWR|vdd sg13_lv_pmos L=0.13u W=0.42u
+ AS=0.0798p AD=0.1428p PS=0.8u PD=1.52u rfmode=0
M$3367 VDD|VPWR|vdd \$73905 \$73648 VDD|VPWR|vdd sg13_lv_pmos L=0.13u W=1.12u
+ AS=0.41165p AD=0.3864p PS=2.12u PD=2.93u rfmode=0
M$3368 VDD|VPWR|vdd CLK|D|GATE|Q$6 \$73905 VDD|VPWR|vdd sg13_lv_pmos L=0.13u
+ W=1.12u AS=0.41165p AD=0.4088p PS=2.12u PD=2.97u rfmode=0
M$3369 Q_N$31 \$74457 VDD|VPWR|vdd VDD|VPWR|vdd sg13_lv_pmos L=0.13u W=1.12u
+ AS=0.3808p AD=0.1974p PS=2.92u PD=1.5u rfmode=0
M$3370 VDD|VPWR|vdd \$74593 \$74457 VDD|VPWR|vdd sg13_lv_pmos L=0.13u W=0.84u
+ AS=0.1974p AD=0.2856p PS=1.5u PD=2.36u rfmode=0
M$3371 \$73646 \$73905 \$73907 VDD|VPWR|vdd sg13_lv_pmos L=0.13u W=1u AS=0.34p
+ AD=0.2048p PS=2.68u PD=1.63u rfmode=0
M$3372 \$73907 \$73648 \$73970 VDD|VPWR|vdd sg13_lv_pmos L=0.13u W=0.42u
+ AS=0.2048p AD=0.09345p PS=1.63u PD=0.865u rfmode=0
M$3373 VDD|VPWR|vdd \$73908 \$73970 VDD|VPWR|vdd sg13_lv_pmos L=0.13u W=0.42u
+ AS=0.204p AD=0.09345p PS=1.835u PD=0.865u rfmode=0
M$3374 VDD|VPWR|vdd RESET_B|Y$1 \$73908 VDD|VPWR|vdd sg13_lv_pmos L=0.13u
+ W=0.42u AS=0.204p AD=0.0798p PS=1.835u PD=0.8u rfmode=0
M$3375 VDD|VPWR|vdd \$73907 \$73908 VDD|VPWR|vdd sg13_lv_pmos L=0.13u W=0.42u
+ AS=0.2639p AD=0.0798p PS=1.81u PD=0.8u rfmode=0
M$3376 VDD|VPWR|vdd \$73907 D|Q_N$7 VDD|VPWR|vdd sg13_lv_pmos L=0.13u W=1.12u
+ AS=0.2639p AD=0.4312p PS=1.81u PD=3.01u rfmode=0
M$3377 VDD|VPWR|vdd \$74458 \$74496 VDD|VPWR|vdd sg13_lv_pmos L=0.13u W=0.84u
+ AS=0.26675p AD=0.2856p PS=1.845u PD=2.36u rfmode=0
M$3378 A|Q$14 \$74593 VDD|VPWR|vdd VDD|VPWR|vdd sg13_lv_pmos L=0.13u W=1.12u
+ AS=0.3808p AD=0.2128p PS=2.92u PD=1.5u rfmode=0
M$3379 VDD|VPWR|vdd RESET_B|Y$1 \$74593 VDD|VPWR|vdd sg13_lv_pmos L=0.13u
+ W=1.12u AS=0.2128p AD=0.2128p PS=1.5u PD=1.5u rfmode=0
M$3380 \$74593 \$74594 VDD|VPWR|vdd VDD|VPWR|vdd sg13_lv_pmos L=0.13u W=1.12u
+ AS=0.2128p AD=0.2387p PS=1.5u PD=1.84u rfmode=0
M$3381 VDD|VPWR|vdd \$74593 \$74782 VDD|VPWR|vdd sg13_lv_pmos L=0.13u W=0.42u
+ AS=0.2387p AD=0.1008p PS=1.84u PD=0.9u rfmode=0
M$3382 \$74594 \$74496 \$74782 VDD|VPWR|vdd sg13_lv_pmos L=0.13u W=0.42u
+ AS=0.191p AD=0.1008p PS=1.44u PD=0.9u rfmode=0
M$3383 \$74594 \$74458 \$74781 VDD|VPWR|vdd sg13_lv_pmos L=0.13u W=1u AS=0.191p
+ AD=0.105p PS=1.44u PD=1.21u rfmode=0
M$3384 \$74781 \$74600 VDD|VPWR|vdd VDD|VPWR|vdd sg13_lv_pmos L=0.13u W=1u
+ AS=0.105p AD=0.26675p PS=1.21u PD=1.845u rfmode=0
M$3385 Q_N$32 \$74460 VDD|VPWR|vdd VDD|VPWR|vdd sg13_lv_pmos L=0.13u W=1.12u
+ AS=0.3808p AD=0.1974p PS=2.92u PD=1.5u rfmode=0
M$3386 VDD|VPWR|vdd \$74595 \$74460 VDD|VPWR|vdd sg13_lv_pmos L=0.13u W=0.84u
+ AS=0.1974p AD=0.2856p PS=1.5u PD=2.36u rfmode=0
M$3387 VDD|VPWR|vdd B2|D|Q \$73649 VDD|VPWR|vdd sg13_lv_pmos L=0.13u W=0.84u
+ AS=0.3018p AD=0.2856p PS=1.97u PD=2.36u rfmode=0
M$3388 VDD|VPWR|vdd CLK|D|GATE|Q$6 \$73909 VDD|VPWR|vdd sg13_lv_pmos L=0.13u
+ W=0.84u AS=0.3018p AD=0.3234p PS=1.97u PD=2.45u rfmode=0
M$3389 VDD|VPWR|vdd \$74462 \$74497 VDD|VPWR|vdd sg13_lv_pmos L=0.13u W=0.84u
+ AS=0.26675p AD=0.2856p PS=1.845u PD=2.36u rfmode=0
M$3390 A|Q$20 \$74595 VDD|VPWR|vdd VDD|VPWR|vdd sg13_lv_pmos L=0.13u W=1.12u
+ AS=0.3808p AD=0.2128p PS=2.92u PD=1.5u rfmode=0
M$3391 VDD|VPWR|vdd RESET_B|Y$1 \$74595 VDD|VPWR|vdd sg13_lv_pmos L=0.13u
+ W=1.12u AS=0.2128p AD=0.2128p PS=1.5u PD=1.5u rfmode=0
M$3392 \$74595 \$74596 VDD|VPWR|vdd VDD|VPWR|vdd sg13_lv_pmos L=0.13u W=1.12u
+ AS=0.2128p AD=0.2387p PS=1.5u PD=1.84u rfmode=0
M$3393 VDD|VPWR|vdd \$74595 \$74784 VDD|VPWR|vdd sg13_lv_pmos L=0.13u W=0.42u
+ AS=0.2387p AD=0.1008p PS=1.84u PD=0.9u rfmode=0
M$3394 \$74596 \$74497 \$74784 VDD|VPWR|vdd sg13_lv_pmos L=0.13u W=0.42u
+ AS=0.191p AD=0.1008p PS=1.44u PD=0.9u rfmode=0
M$3395 \$74596 \$74462 \$74783 VDD|VPWR|vdd sg13_lv_pmos L=0.13u W=1u AS=0.191p
+ AD=0.105p PS=1.44u PD=1.21u rfmode=0
M$3396 \$74783 \$74601 VDD|VPWR|vdd VDD|VPWR|vdd sg13_lv_pmos L=0.13u W=1u
+ AS=0.105p AD=0.26675p PS=1.21u PD=1.845u rfmode=0
M$3397 X|in_l_sw[3]|pl_sw[3]|x \$74499 VDD|VPWR|vdd VDD|VPWR|vdd sg13_lv_pmos
+ L=0.13u W=1.12u AS=0.42p AD=0.2114p PS=2.99u PD=1.54u rfmode=0
M$3398 VDD|VPWR|vdd A|X$50 \$74499 VDD|VPWR|vdd sg13_lv_pmos L=0.13u W=0.84u
+ AS=0.2114p AD=0.2856p PS=1.54u PD=2.36u rfmode=0
M$3399 VDD|VPWR|vdd D|Q_N$5 \$73651 VDD|VPWR|vdd sg13_lv_pmos L=0.13u W=0.84u
+ AS=0.3018p AD=0.2856p PS=1.97u PD=2.36u rfmode=0
M$3400 VDD|VPWR|vdd CLK|D|GATE|Q$5 \$73911 VDD|VPWR|vdd sg13_lv_pmos L=0.13u
+ W=0.84u AS=0.3018p AD=0.3234p PS=1.97u PD=2.45u rfmode=0
M$3401 \$74501 \$74466 VDD|VPWR|vdd VDD|VPWR|vdd sg13_lv_pmos L=0.13u W=1.12u
+ AS=0.3864p AD=0.41165p PS=2.93u PD=2.12u rfmode=0
M$3402 VDD|VPWR|vdd CLK|D|GATE|Q$9 \$74466 VDD|VPWR|vdd sg13_lv_pmos L=0.13u
+ W=1.12u AS=0.41165p AD=0.4088p PS=2.12u PD=2.97u rfmode=0
M$3403 \$74470 \$74502 VDD|VPWR|vdd VDD|VPWR|vdd sg13_lv_pmos L=0.13u W=1.12u
+ AS=0.3864p AD=0.2128p PS=2.93u PD=1.5u rfmode=0
M$3404 VDD|VPWR|vdd \$74470 A1|D|Q$3 VDD|VPWR|vdd sg13_lv_pmos L=0.13u W=1.12u
+ AS=0.2128p AD=0.3808p PS=1.5u PD=2.92u rfmode=0
M$3405 VDD|VPWR|vdd A1|D|Q$3 \$73653 VDD|VPWR|vdd sg13_lv_pmos L=0.13u W=0.84u
+ AS=0.3018p AD=0.2856p PS=1.97u PD=2.36u rfmode=0
M$3406 VDD|VPWR|vdd CLK|D|GATE|Q$9 \$73914 VDD|VPWR|vdd sg13_lv_pmos L=0.13u
+ W=0.84u AS=0.3018p AD=0.3234p PS=1.97u PD=2.45u rfmode=0
M$3407 \$74504 \$74472 VDD|VPWR|vdd VDD|VPWR|vdd sg13_lv_pmos L=0.13u W=1.12u
+ AS=0.3864p AD=0.41165p PS=2.93u PD=2.12u rfmode=0
M$3408 VDD|VPWR|vdd CLK|D|GATE|Q$10 \$74472 VDD|VPWR|vdd sg13_lv_pmos L=0.13u
+ W=1.12u AS=0.41165p AD=0.4088p PS=2.12u PD=2.97u rfmode=0
M$3409 VDD|VPWR|vdd D|Q_N$8 \$73655 VDD|VPWR|vdd sg13_lv_pmos L=0.13u W=0.84u
+ AS=0.3018p AD=0.2856p PS=1.97u PD=2.36u rfmode=0
M$3410 VDD|VPWR|vdd CLK|D|GATE|Q$10 \$73918 VDD|VPWR|vdd sg13_lv_pmos L=0.13u
+ W=0.84u AS=0.3018p AD=0.3234p PS=1.97u PD=2.45u rfmode=0
M$3411 \$74475 \$74505 VDD|VPWR|vdd VDD|VPWR|vdd sg13_lv_pmos L=0.13u W=1.12u
+ AS=0.3864p AD=0.2128p PS=2.93u PD=1.5u rfmode=0
M$3412 VDD|VPWR|vdd \$74475 A|D|Q$1 VDD|VPWR|vdd sg13_lv_pmos L=0.13u W=1.12u
+ AS=0.2128p AD=0.3808p PS=1.5u PD=2.92u rfmode=0
M$3413 VDD|VPWR|vdd B2|D|Q$1 \$73657 VDD|VPWR|vdd sg13_lv_pmos L=0.13u W=0.84u
+ AS=0.3018p AD=0.2856p PS=1.97u PD=2.36u rfmode=0
M$3414 VDD|VPWR|vdd CLK|D|GATE|Q$7 \$73921 VDD|VPWR|vdd sg13_lv_pmos L=0.13u
+ W=0.84u AS=0.3018p AD=0.3234p PS=1.97u PD=2.45u rfmode=0
M$3415 VDD|VPWR|vdd \$74478 \$74480 VDD|VPWR|vdd sg13_lv_pmos L=0.13u W=0.84u
+ AS=0.1974p AD=0.2856p PS=1.5u PD=2.36u rfmode=0
M$3416 VDD|VPWR|vdd \$74480 Q_N$33 VDD|VPWR|vdd sg13_lv_pmos L=0.13u W=1.12u
+ AS=0.1974p AD=0.3808p PS=1.5u PD=2.92u rfmode=0
M$3417 VDD|VPWR|vdd CLK|D|GATE|Q$8 \$73631 VDD|VPWR|vdd sg13_lv_pmos L=0.13u
+ W=0.42u AS=0.1428p AD=0.0798p PS=1.52u PD=0.8u rfmode=0
M$3418 VDD|VPWR|vdd RESET_B|Y$2 \$73631 VDD|VPWR|vdd sg13_lv_pmos L=0.13u
+ W=0.42u AS=0.3623875p AD=0.0798p PS=2.605u PD=0.8u rfmode=0
M$3419 VDD|VPWR|vdd \$73660 \$73659 VDD|VPWR|vdd sg13_lv_pmos L=0.13u W=1u
+ AS=0.3623875p AD=0.34p PS=2.605u PD=2.68u rfmode=0
M$3420 \$74509 \$74483 VDD|VPWR|vdd VDD|VPWR|vdd sg13_lv_pmos L=0.13u W=1.12u
+ AS=0.3864p AD=0.41165p PS=2.93u PD=2.12u rfmode=0
M$3421 VDD|VPWR|vdd CLK|D|GATE|Q$8 \$74483 VDD|VPWR|vdd sg13_lv_pmos L=0.13u
+ W=1.12u AS=0.41165p AD=0.4088p PS=2.12u PD=2.97u rfmode=0
M$3422 VDD|VPWR|vdd RESET_B|Y$2 \$73660 VDD|VPWR|vdd sg13_lv_pmos L=0.13u
+ W=0.42u AS=0.1563p AD=0.147p PS=1.22u PD=1.54u rfmode=0
M$3423 VDD|VPWR|vdd \$73659 \$73902 VDD|VPWR|vdd sg13_lv_pmos L=0.13u W=0.42u
+ AS=0.1563p AD=0.063p PS=1.22u PD=0.72u rfmode=0
M$3424 \$73902 \$73923 \$73660 VDD|VPWR|vdd sg13_lv_pmos L=0.13u W=0.42u
+ AS=0.063p AD=0.0798p PS=0.72u PD=0.8u rfmode=0
M$3425 \$73660 \$73661 \$73631 VDD|VPWR|vdd sg13_lv_pmos L=0.13u W=0.42u
+ AS=0.0798p AD=0.1428p PS=0.8u PD=1.52u rfmode=0
M$3426 VDD|VPWR|vdd \$73923 \$73661 VDD|VPWR|vdd sg13_lv_pmos L=0.13u W=1.12u
+ AS=0.41165p AD=0.3864p PS=2.12u PD=2.93u rfmode=0
M$3427 VDD|VPWR|vdd A|CLK|X$1 \$73923 VDD|VPWR|vdd sg13_lv_pmos L=0.13u W=1.12u
+ AS=0.41165p AD=0.4088p PS=2.12u PD=2.97u rfmode=0
M$3428 \$74487 \$74510 VDD|VPWR|vdd VDD|VPWR|vdd sg13_lv_pmos L=0.13u W=1.12u
+ AS=0.3864p AD=0.2128p PS=2.93u PD=1.5u rfmode=0
M$3429 VDD|VPWR|vdd \$74487 C|D|Q VDD|VPWR|vdd sg13_lv_pmos L=0.13u W=1.12u
+ AS=0.2128p AD=0.3808p PS=1.5u PD=2.92u rfmode=0
M$3430 \$73659 \$73923 \$73924 VDD|VPWR|vdd sg13_lv_pmos L=0.13u W=1u AS=0.34p
+ AD=0.2048p PS=2.68u PD=1.63u rfmode=0
M$3431 \$73924 \$73661 \$73971 VDD|VPWR|vdd sg13_lv_pmos L=0.13u W=0.42u
+ AS=0.2048p AD=0.09345p PS=1.63u PD=0.865u rfmode=0
M$3432 VDD|VPWR|vdd \$73925 \$73971 VDD|VPWR|vdd sg13_lv_pmos L=0.13u W=0.42u
+ AS=0.204p AD=0.09345p PS=1.835u PD=0.865u rfmode=0
M$3433 VDD|VPWR|vdd RESET_B|Y$2 \$73925 VDD|VPWR|vdd sg13_lv_pmos L=0.13u
+ W=0.42u AS=0.204p AD=0.0798p PS=1.835u PD=0.8u rfmode=0
M$3434 VDD|VPWR|vdd \$73924 \$73925 VDD|VPWR|vdd sg13_lv_pmos L=0.13u W=0.42u
+ AS=0.2639p AD=0.0798p PS=1.81u PD=0.8u rfmode=0
M$3435 VDD|VPWR|vdd \$73924 Q_N$30 VDD|VPWR|vdd sg13_lv_pmos L=0.13u W=1.12u
+ AS=0.2639p AD=0.4312p PS=1.81u PD=3.01u rfmode=0
M$3436 VDD|VPWR|vdd \$74490 \$74491 VDD|VPWR|vdd sg13_lv_pmos L=0.13u W=0.84u
+ AS=0.1974p AD=0.2856p PS=1.5u PD=2.36u rfmode=0
M$3437 VDD|VPWR|vdd \$74491 Q_N$34 VDD|VPWR|vdd sg13_lv_pmos L=0.13u W=1.12u
+ AS=0.1974p AD=0.3808p PS=1.5u PD=2.92u rfmode=0
M$3438 VDD|VPWR|vdd A|Q$22 \$74513 VDD|VPWR|vdd sg13_lv_pmos L=0.13u W=0.84u
+ AS=0.2114p AD=0.2856p PS=1.54u PD=2.36u rfmode=0
M$3439 VDD|VPWR|vdd \$74513 A|X$49 VDD|VPWR|vdd sg13_lv_pmos L=0.13u W=1.12u
+ AS=0.2114p AD=0.42p PS=1.54u PD=2.99u rfmode=0
M$3440 VDD|VPWR|vdd A|X$51 \$74514 VDD|VPWR|vdd sg13_lv_pmos L=0.13u W=0.84u
+ AS=0.2114p AD=0.2856p PS=1.54u PD=2.36u rfmode=0
M$3441 VDD|VPWR|vdd \$74514 X|anode|cathode|core|frame|pad|padres VDD|VPWR|vdd
+ sg13_lv_pmos L=0.13u W=1.12u AS=0.2114p AD=0.42p PS=1.54u PD=2.99u rfmode=0
M$3442 VDD|VPWR|vdd A|X$42 \$74515 VDD|VPWR|vdd sg13_lv_pmos L=0.13u W=0.84u
+ AS=0.2114p AD=0.2856p PS=1.54u PD=2.36u rfmode=0
M$3443 VDD|VPWR|vdd \$74515 X|anode|cathode|cko|core|pad|padres VDD|VPWR|vdd
+ sg13_lv_pmos L=0.13u W=1.12u AS=0.2114p AD=0.42p PS=1.54u PD=2.99u rfmode=0
M$3444 A|Y$25 A|X$17 VDD|VPWR|vdd VDD|VPWR|vdd sg13_lv_pmos L=0.13u W=1.12u
+ AS=0.3808p AD=0.3808p PS=2.92u PD=2.92u rfmode=0
M$3445 \$74458 CLK|D|GATE|Q$6 VDD|VPWR|vdd VDD|VPWR|vdd sg13_lv_pmos L=0.13u
+ W=0.84u AS=0.3234p AD=0.3018p PS=2.45u PD=1.97u rfmode=0
M$3446 VDD|VPWR|vdd D|Q_N$7 \$74600 VDD|VPWR|vdd sg13_lv_pmos L=0.13u W=0.84u
+ AS=0.3018p AD=0.2856p PS=1.97u PD=2.36u rfmode=0
M$3447 \$74462 CLK|D|GATE|Q$2 VDD|VPWR|vdd VDD|VPWR|vdd sg13_lv_pmos L=0.13u
+ W=0.84u AS=0.3234p AD=0.3018p PS=2.45u PD=1.97u rfmode=0
M$3448 VDD|VPWR|vdd A_N|D|Q \$74601 VDD|VPWR|vdd sg13_lv_pmos L=0.13u W=0.84u
+ AS=0.3018p AD=0.2856p PS=1.97u PD=2.36u rfmode=0
M$3450 A|Y$27 A|X$23 VDD|VPWR|vdd VDD|VPWR|vdd sg13_lv_pmos L=0.13u W=1.12u
+ AS=0.3808p AD=0.3808p PS=2.92u PD=2.92u rfmode=0
M$3451 A|Y$26 A|X$24 VDD|VPWR|vdd VDD|VPWR|vdd sg13_lv_pmos L=0.13u W=1.12u
+ AS=0.3808p AD=0.3808p PS=2.92u PD=2.92u rfmode=0
M$3452 VDD|VPWR|vdd D|X \$74500 VDD|VPWR|vdd sg13_lv_pmos L=0.13u W=0.42u
+ AS=0.1428p AD=0.0798p PS=1.52u PD=0.8u rfmode=0
M$3453 VDD|VPWR|vdd RESET_B|Y$1 \$74500 VDD|VPWR|vdd sg13_lv_pmos L=0.13u
+ W=0.42u AS=0.3623875p AD=0.0798p PS=2.605u PD=0.8u rfmode=0
M$3454 VDD|VPWR|vdd \$74603 \$74429 VDD|VPWR|vdd sg13_lv_pmos L=0.13u W=1u
+ AS=0.3623875p AD=0.34p PS=2.605u PD=2.68u rfmode=0
M$3455 \$74502 \$74501 \$74740 VDD|VPWR|vdd sg13_lv_pmos L=0.13u W=0.42u
+ AS=0.2048p AD=0.09345p PS=1.63u PD=0.865u rfmode=0
M$3456 \$74740 \$74468 VDD|VPWR|vdd VDD|VPWR|vdd sg13_lv_pmos L=0.13u W=0.42u
+ AS=0.09345p AD=0.204p PS=0.865u PD=1.835u rfmode=0
M$3457 VDD|VPWR|vdd RESET_B|Y$1 \$74468 VDD|VPWR|vdd sg13_lv_pmos L=0.13u
+ W=0.42u AS=0.204p AD=0.0798p PS=1.835u PD=0.8u rfmode=0
M$3458 VDD|VPWR|vdd \$74502 \$74468 VDD|VPWR|vdd sg13_lv_pmos L=0.13u W=0.42u
+ AS=0.2639p AD=0.0798p PS=1.81u PD=0.8u rfmode=0
M$3459 \$74429 \$74466 \$74502 VDD|VPWR|vdd sg13_lv_pmos L=0.13u W=1u AS=0.34p
+ AD=0.2048p PS=2.68u PD=1.63u rfmode=0
M$3460 VDD|VPWR|vdd \$74502 D|Q_N$9 VDD|VPWR|vdd sg13_lv_pmos L=0.13u W=1.12u
+ AS=0.2639p AD=0.4312p PS=1.81u PD=3.01u rfmode=0
M$3461 VDD|VPWR|vdd D|X$1 \$74503 VDD|VPWR|vdd sg13_lv_pmos L=0.13u W=0.42u
+ AS=0.1428p AD=0.0798p PS=1.52u PD=0.8u rfmode=0
M$3462 VDD|VPWR|vdd RESET_B|Y$1 \$74503 VDD|VPWR|vdd sg13_lv_pmos L=0.13u
+ W=0.42u AS=0.3623875p AD=0.0798p PS=2.605u PD=0.8u rfmode=0
M$3463 VDD|VPWR|vdd \$74604 \$74431 VDD|VPWR|vdd sg13_lv_pmos L=0.13u W=1u
+ AS=0.3623875p AD=0.34p PS=2.605u PD=2.68u rfmode=0
M$3464 \$74505 \$74504 \$74742 VDD|VPWR|vdd sg13_lv_pmos L=0.13u W=0.42u
+ AS=0.2048p AD=0.09345p PS=1.63u PD=0.865u rfmode=0
M$3465 \$74742 \$74474 VDD|VPWR|vdd VDD|VPWR|vdd sg13_lv_pmos L=0.13u W=0.42u
+ AS=0.09345p AD=0.204p PS=0.865u PD=1.835u rfmode=0
M$3466 VDD|VPWR|vdd RESET_B|Y$1 \$74474 VDD|VPWR|vdd sg13_lv_pmos L=0.13u
+ W=0.42u AS=0.204p AD=0.0798p PS=1.835u PD=0.8u rfmode=0
M$3467 VDD|VPWR|vdd \$74505 \$74474 VDD|VPWR|vdd sg13_lv_pmos L=0.13u W=0.42u
+ AS=0.2639p AD=0.0798p PS=1.81u PD=0.8u rfmode=0
M$3468 \$74431 \$74472 \$74505 VDD|VPWR|vdd sg13_lv_pmos L=0.13u W=1u AS=0.34p
+ AD=0.2048p PS=2.68u PD=1.63u rfmode=0
M$3469 VDD|VPWR|vdd \$74505 D|Q_N$8 VDD|VPWR|vdd sg13_lv_pmos L=0.13u W=1.12u
+ AS=0.2639p AD=0.4312p PS=1.81u PD=3.01u rfmode=0
M$3470 \$74506 A|D|Q$1 VDD|VPWR|vdd VDD|VPWR|vdd sg13_lv_pmos L=0.13u W=0.84u
+ AS=0.2856p AD=0.3018p PS=2.36u PD=1.97u rfmode=0
M$3471 VDD|VPWR|vdd CLK|D|GATE|Q$10 \$74476 VDD|VPWR|vdd sg13_lv_pmos L=0.13u
+ W=0.84u AS=0.3018p AD=0.3234p PS=1.97u PD=2.45u rfmode=0
M$3472 \$74507 \$74476 VDD|VPWR|vdd VDD|VPWR|vdd sg13_lv_pmos L=0.13u W=0.84u
+ AS=0.2856p AD=0.26675p PS=2.36u PD=1.845u rfmode=0
M$3473 VDD|VPWR|vdd \$74506 \$74790 VDD|VPWR|vdd sg13_lv_pmos L=0.13u W=1u
+ AS=0.26675p AD=0.105p PS=1.845u PD=1.21u rfmode=0
M$3474 \$74790 \$74476 \$74477 VDD|VPWR|vdd sg13_lv_pmos L=0.13u W=1u AS=0.105p
+ AD=0.191p PS=1.21u PD=1.44u rfmode=0
M$3475 \$74477 \$74507 \$74789 VDD|VPWR|vdd sg13_lv_pmos L=0.13u W=0.42u
+ AS=0.191p AD=0.1008p PS=1.44u PD=0.9u rfmode=0
M$3476 VDD|VPWR|vdd \$74478 \$74789 VDD|VPWR|vdd sg13_lv_pmos L=0.13u W=0.42u
+ AS=0.2387p AD=0.1008p PS=1.84u PD=0.9u rfmode=0
M$3477 VDD|VPWR|vdd \$74477 \$74478 VDD|VPWR|vdd sg13_lv_pmos L=0.13u W=1.12u
+ AS=0.2387p AD=0.2128p PS=1.84u PD=1.5u rfmode=0
M$3478 \$74478 RESET_B|Y$1 VDD|VPWR|vdd VDD|VPWR|vdd sg13_lv_pmos L=0.13u
+ W=1.12u AS=0.2128p AD=0.2128p PS=1.5u PD=1.5u rfmode=0
M$3479 VDD|VPWR|vdd \$74478 A|Q$21 VDD|VPWR|vdd sg13_lv_pmos L=0.13u W=1.12u
+ AS=0.2128p AD=0.3808p PS=1.5u PD=2.92u rfmode=0
M$3480 VDD|VPWR|vdd D|X$1 \$74508 VDD|VPWR|vdd sg13_lv_pmos L=0.13u W=0.42u
+ AS=0.1428p AD=0.0798p PS=1.52u PD=0.8u rfmode=0
M$3481 VDD|VPWR|vdd RESET_B|Y$1 \$74508 VDD|VPWR|vdd sg13_lv_pmos L=0.13u
+ W=0.42u AS=0.3623875p AD=0.0798p PS=2.605u PD=0.8u rfmode=0
M$3482 VDD|VPWR|vdd \$74605 \$74432 VDD|VPWR|vdd sg13_lv_pmos L=0.13u W=1u
+ AS=0.3623875p AD=0.34p PS=2.605u PD=2.68u rfmode=0
M$3483 \$74510 \$74509 \$74741 VDD|VPWR|vdd sg13_lv_pmos L=0.13u W=0.42u
+ AS=0.2048p AD=0.09345p PS=1.63u PD=0.865u rfmode=0
M$3484 \$74741 \$74485 VDD|VPWR|vdd VDD|VPWR|vdd sg13_lv_pmos L=0.13u W=0.42u
+ AS=0.09345p AD=0.204p PS=0.865u PD=1.835u rfmode=0
M$3485 VDD|VPWR|vdd RESET_B|Y$1 \$74485 VDD|VPWR|vdd sg13_lv_pmos L=0.13u
+ W=0.42u AS=0.204p AD=0.0798p PS=1.835u PD=0.8u rfmode=0
M$3486 VDD|VPWR|vdd \$74510 \$74485 VDD|VPWR|vdd sg13_lv_pmos L=0.13u W=0.42u
+ AS=0.2639p AD=0.0798p PS=1.81u PD=0.8u rfmode=0
M$3487 \$74432 \$74483 \$74510 VDD|VPWR|vdd sg13_lv_pmos L=0.13u W=1u AS=0.34p
+ AD=0.2048p PS=2.68u PD=1.63u rfmode=0
M$3488 VDD|VPWR|vdd \$74510 D|Q_N$10 VDD|VPWR|vdd sg13_lv_pmos L=0.13u W=1.12u
+ AS=0.2639p AD=0.4312p PS=1.81u PD=3.01u rfmode=0
M$3489 \$74511 C|D|Q VDD|VPWR|vdd VDD|VPWR|vdd sg13_lv_pmos L=0.13u W=0.84u
+ AS=0.2856p AD=0.3018p PS=2.36u PD=1.97u rfmode=0
M$3490 VDD|VPWR|vdd CLK|D|GATE|Q$8 \$74488 VDD|VPWR|vdd sg13_lv_pmos L=0.13u
+ W=0.84u AS=0.3018p AD=0.3234p PS=1.97u PD=2.45u rfmode=0
M$3491 \$74512 \$74488 VDD|VPWR|vdd VDD|VPWR|vdd sg13_lv_pmos L=0.13u W=0.84u
+ AS=0.2856p AD=0.26675p PS=2.36u PD=1.845u rfmode=0
M$3492 VDD|VPWR|vdd \$74511 \$74813 VDD|VPWR|vdd sg13_lv_pmos L=0.13u W=1u
+ AS=0.26675p AD=0.105p PS=1.845u PD=1.21u rfmode=0
M$3493 \$74813 \$74488 \$74489 VDD|VPWR|vdd sg13_lv_pmos L=0.13u W=1u AS=0.105p
+ AD=0.191p PS=1.21u PD=1.44u rfmode=0
M$3494 \$74489 \$74512 \$74808 VDD|VPWR|vdd sg13_lv_pmos L=0.13u W=0.42u
+ AS=0.191p AD=0.1008p PS=1.44u PD=0.9u rfmode=0
M$3495 VDD|VPWR|vdd \$74490 \$74808 VDD|VPWR|vdd sg13_lv_pmos L=0.13u W=0.42u
+ AS=0.2387p AD=0.1008p PS=1.84u PD=0.9u rfmode=0
M$3496 VDD|VPWR|vdd \$74489 \$74490 VDD|VPWR|vdd sg13_lv_pmos L=0.13u W=1.12u
+ AS=0.2387p AD=0.2128p PS=1.84u PD=1.5u rfmode=0
M$3497 \$74490 RESET_B|Y$1 VDD|VPWR|vdd VDD|VPWR|vdd sg13_lv_pmos L=0.13u
+ W=1.12u AS=0.2128p AD=0.2128p PS=1.5u PD=1.5u rfmode=0
M$3498 VDD|VPWR|vdd \$74490 A|Q$22 VDD|VPWR|vdd sg13_lv_pmos L=0.13u W=1.12u
+ AS=0.2128p AD=0.3808p PS=1.5u PD=2.92u rfmode=0
M$3499 VDD|VPWR|vdd A|X$49 A|Y$13 VDD|VPWR|vdd sg13_lv_pmos L=0.13u W=1.12u
+ AS=0.3808p AD=0.3808p PS=2.92u PD=2.92u rfmode=0
M$3501 VDD|VPWR|vdd A|anode|cathode|ck|cks|core|pad|padres A|Y$28 VDD|VPWR|vdd
+ sg13_lv_pmos L=0.13u W=1.12u AS=0.3808p AD=0.3808p PS=2.92u PD=2.92u rfmode=0
M$3502 VDD|VPWR|vdd A|Y$28 Y$3 VDD|VPWR|vdd sg13_lv_pmos L=0.13u W=1.12u
+ AS=0.3808p AD=0.3808p PS=2.92u PD=2.92u rfmode=0
M$3504 \$74923 A|X|rdy VDD|VPWR|vdd VDD|VPWR|vdd sg13_lv_pmos L=0.13u W=0.84u
+ AS=0.2856p AD=0.2114p PS=2.36u PD=1.54u rfmode=0
M$3505 VDD|VPWR|vdd \$74923 A|X$52 VDD|VPWR|vdd sg13_lv_pmos L=0.13u W=1.12u
+ AS=0.2114p AD=0.42p PS=1.54u PD=2.99u rfmode=0
M$3506 VDD|VPWR|vdd A|anode|cathode|ck|cks|core|pad|padres RESET_B|Y$2
+ VDD|VPWR|vdd sg13_lv_pmos L=0.13u W=1.12u AS=0.3808p AD=0.3808p PS=2.92u
+ PD=2.92u rfmode=0
M$3507 VDD|VPWR|vdd A|Y$25 \$74926 VDD|VPWR|vdd sg13_lv_pmos L=0.13u W=0.84u
+ AS=0.2114p AD=0.2856p PS=1.54u PD=2.36u rfmode=0
M$3508 A|X$53 \$74926 VDD|VPWR|vdd VDD|VPWR|vdd sg13_lv_pmos L=0.13u W=1.12u
+ AS=0.42p AD=0.2114p PS=2.99u PD=1.54u rfmode=0
M$3509 VDD|VPWR|vdd \$75356 \$75332 VDD|VPWR|vdd sg13_lv_pmos L=0.13u W=0.66u
+ AS=0.4657125p AD=0.2442p PS=2.54u PD=2.06u rfmode=0
M$3510 VDD|VPWR|vdd \$75357 D|L_HI VDD|VPWR|vdd sg13_lv_pmos L=0.13u W=1.155u
+ AS=0.4657125p AD=0.3927p PS=2.54u PD=2.99u rfmode=0
M$3511 \$74932 \$75334 VDD|VPWR|vdd VDD|VPWR|vdd sg13_lv_pmos L=0.13u W=1.12u
+ AS=0.3864p AD=0.2128p PS=2.93u PD=1.5u rfmode=0
M$3512 VDD|VPWR|vdd \$74932 CLK|D|GATE|Q$6 VDD|VPWR|vdd sg13_lv_pmos L=0.13u
+ W=1.12u AS=0.2128p AD=0.3808p PS=1.5u PD=2.92u rfmode=0
M$3513 VDD|VPWR|vdd A|anode|cathode|ck|cks|core|pad|padres RESET_B|Y$1
+ VDD|VPWR|vdd sg13_lv_pmos L=0.13u W=8.96u AS=1.876p AD=1.876p PS=13.43u
+ PD=13.43u rfmode=0
M$3523 \$74603 RESET_B|Y$1 VDD|VPWR|vdd VDD|VPWR|vdd sg13_lv_pmos L=0.13u
+ W=0.42u AS=0.147p AD=0.1563p PS=1.54u PD=1.22u rfmode=0
M$3524 VDD|VPWR|vdd \$74429 \$74785 VDD|VPWR|vdd sg13_lv_pmos L=0.13u W=0.42u
+ AS=0.1563p AD=0.063p PS=1.22u PD=0.72u rfmode=0
M$3525 \$74785 \$74466 \$74603 VDD|VPWR|vdd sg13_lv_pmos L=0.13u W=0.42u
+ AS=0.063p AD=0.0798p PS=0.72u PD=0.8u rfmode=0
M$3526 \$74603 \$74501 \$74500 VDD|VPWR|vdd sg13_lv_pmos L=0.13u W=0.42u
+ AS=0.0798p AD=0.1428p PS=0.8u PD=1.52u rfmode=0
M$3527 \$74937 \$75337 VDD|VPWR|vdd VDD|VPWR|vdd sg13_lv_pmos L=0.13u W=1.12u
+ AS=0.3864p AD=0.2128p PS=2.93u PD=1.5u rfmode=0
M$3528 VDD|VPWR|vdd \$74937 CLK|D|GATE|Q$9 VDD|VPWR|vdd sg13_lv_pmos L=0.13u
+ W=1.12u AS=0.2128p AD=0.3808p PS=1.5u PD=2.92u rfmode=0
M$3529 \$74604 RESET_B|Y$1 VDD|VPWR|vdd VDD|VPWR|vdd sg13_lv_pmos L=0.13u
+ W=0.42u AS=0.147p AD=0.1563p PS=1.54u PD=1.22u rfmode=0
M$3530 VDD|VPWR|vdd \$74431 \$74788 VDD|VPWR|vdd sg13_lv_pmos L=0.13u W=0.42u
+ AS=0.1563p AD=0.063p PS=1.22u PD=0.72u rfmode=0
M$3531 \$74788 \$74472 \$74604 VDD|VPWR|vdd sg13_lv_pmos L=0.13u W=0.42u
+ AS=0.063p AD=0.0798p PS=0.72u PD=0.8u rfmode=0
M$3532 \$74604 \$74504 \$74503 VDD|VPWR|vdd sg13_lv_pmos L=0.13u W=0.42u
+ AS=0.0798p AD=0.1428p PS=0.8u PD=1.52u rfmode=0
M$3533 \$74942 \$75340 VDD|VPWR|vdd VDD|VPWR|vdd sg13_lv_pmos L=0.13u W=1.12u
+ AS=0.3864p AD=0.2128p PS=2.93u PD=1.5u rfmode=0
M$3534 VDD|VPWR|vdd \$74942 CLK|D|GATE|Q$10 VDD|VPWR|vdd sg13_lv_pmos L=0.13u
+ W=1.12u AS=0.2128p AD=0.3808p PS=1.5u PD=2.92u rfmode=0
M$3535 \$74943 A|Q$18 VDD|VPWR|vdd VDD|VPWR|vdd sg13_lv_pmos L=0.13u W=0.84u
+ AS=0.2856p AD=0.2114p PS=2.36u PD=1.54u rfmode=0
M$3536 VDD|VPWR|vdd \$74943 A|X$54 VDD|VPWR|vdd sg13_lv_pmos L=0.13u W=1.12u
+ AS=0.2114p AD=0.42p PS=1.54u PD=2.99u rfmode=0
M$3537 \$74945 A|Q$24 VDD|VPWR|vdd VDD|VPWR|vdd sg13_lv_pmos L=0.13u W=0.84u
+ AS=0.2856p AD=0.2114p PS=2.36u PD=1.54u rfmode=0
M$3538 VDD|VPWR|vdd \$74945 A|X$38 VDD|VPWR|vdd sg13_lv_pmos L=0.13u W=1.12u
+ AS=0.2114p AD=0.42p PS=1.54u PD=2.99u rfmode=0
M$3539 \$74946 A|X$54 VDD|VPWR|vdd VDD|VPWR|vdd sg13_lv_pmos L=0.13u W=0.84u
+ AS=0.2856p AD=0.2114p PS=2.36u PD=1.54u rfmode=0
M$3540 VDD|VPWR|vdd \$74946 A|X$55 VDD|VPWR|vdd sg13_lv_pmos L=0.13u W=1.12u
+ AS=0.2114p AD=0.42p PS=1.54u PD=2.99u rfmode=0
M$3541 VDD|VPWR|vdd A|X$57 \$74949 VDD|VPWR|vdd sg13_lv_pmos L=0.13u W=0.84u
+ AS=0.2114p AD=0.2856p PS=1.54u PD=2.36u rfmode=0
M$3542 X|in_h_sw[5]|ph_sw[5]|x \$74949 VDD|VPWR|vdd VDD|VPWR|vdd sg13_lv_pmos
+ L=0.13u W=1.12u AS=0.42p AD=0.2114p PS=2.99u PD=1.54u rfmode=0
M$3543 VDD|VPWR|vdd A|X$61 \$74951 VDD|VPWR|vdd sg13_lv_pmos L=0.13u W=0.84u
+ AS=0.2114p AD=0.2856p PS=1.54u PD=2.36u rfmode=0
M$3544 X|in_l_sw[6]|pl_sw[6]|x \$74951 VDD|VPWR|vdd VDD|VPWR|vdd sg13_lv_pmos
+ L=0.13u W=1.12u AS=0.42p AD=0.2114p PS=2.99u PD=1.54u rfmode=0
M$3545 VDD|VPWR|vdd A|Q$19 \$74952 VDD|VPWR|vdd sg13_lv_pmos L=0.13u W=0.84u
+ AS=0.2114p AD=0.2856p PS=1.54u PD=2.36u rfmode=0
M$3546 A|X$46 \$74952 VDD|VPWR|vdd VDD|VPWR|vdd sg13_lv_pmos L=0.13u W=1.12u
+ AS=0.42p AD=0.2114p PS=2.99u PD=1.54u rfmode=0
M$3547 \$74953 A|Q$21 VDD|VPWR|vdd VDD|VPWR|vdd sg13_lv_pmos L=0.13u W=0.84u
+ AS=0.2856p AD=0.2114p PS=2.36u PD=1.54u rfmode=0
M$3548 VDD|VPWR|vdd \$74953 A|X$56 VDD|VPWR|vdd sg13_lv_pmos L=0.13u W=1.12u
+ AS=0.2114p AD=0.42p PS=1.54u PD=2.99u rfmode=0
M$3549 \$74605 RESET_B|Y$1 VDD|VPWR|vdd VDD|VPWR|vdd sg13_lv_pmos L=0.13u
+ W=0.42u AS=0.147p AD=0.1563p PS=1.54u PD=1.22u rfmode=0
M$3550 VDD|VPWR|vdd \$74432 \$74791 VDD|VPWR|vdd sg13_lv_pmos L=0.13u W=0.42u
+ AS=0.1563p AD=0.063p PS=1.22u PD=0.72u rfmode=0
M$3551 \$74791 \$74483 \$74605 VDD|VPWR|vdd sg13_lv_pmos L=0.13u W=0.42u
+ AS=0.063p AD=0.0798p PS=0.72u PD=0.8u rfmode=0
M$3552 \$74605 \$74509 \$74508 VDD|VPWR|vdd sg13_lv_pmos L=0.13u W=0.42u
+ AS=0.0798p AD=0.1428p PS=0.8u PD=1.52u rfmode=0
M$3553 \$74959 \$75345 VDD|VPWR|vdd VDD|VPWR|vdd sg13_lv_pmos L=0.13u W=1.12u
+ AS=0.3864p AD=0.2128p PS=2.93u PD=1.5u rfmode=0
M$3554 VDD|VPWR|vdd \$74959 CLK|D|GATE|Q$8 VDD|VPWR|vdd sg13_lv_pmos L=0.13u
+ W=1.12u AS=0.2128p AD=0.3808p PS=1.5u PD=2.92u rfmode=0
M$3555 \$74961 \$75348 \$75195 VDD|VPWR|vdd sg13_lv_pmos L=0.13u W=0.42u
+ AS=0.191p AD=0.1008p PS=1.44u PD=0.9u rfmode=0
M$3556 \$75195 \$74962 VDD|VPWR|vdd VDD|VPWR|vdd sg13_lv_pmos L=0.13u W=0.42u
+ AS=0.1008p AD=0.2387p PS=0.9u PD=1.84u rfmode=0
M$3557 VDD|VPWR|vdd \$75347 \$75348 VDD|VPWR|vdd sg13_lv_pmos L=0.13u W=0.84u
+ AS=0.26675p AD=0.2856p PS=1.845u PD=2.36u rfmode=0
M$3558 VDD|VPWR|vdd \$74960 \$75351 VDD|VPWR|vdd sg13_lv_pmos L=0.13u W=1u
+ AS=0.26675p AD=0.105p PS=1.845u PD=1.21u rfmode=0
M$3559 \$75351 \$75347 \$74961 VDD|VPWR|vdd sg13_lv_pmos L=0.13u W=1u AS=0.105p
+ AD=0.191p PS=1.21u PD=1.44u rfmode=0
M$3560 VDD|VPWR|vdd \$74961 \$74962 VDD|VPWR|vdd sg13_lv_pmos L=0.13u W=1.12u
+ AS=0.2387p AD=0.2128p PS=1.84u PD=1.5u rfmode=0
M$3561 \$74962 RESET_B|Y$1 VDD|VPWR|vdd VDD|VPWR|vdd sg13_lv_pmos L=0.13u
+ W=1.12u AS=0.2128p AD=0.2128p PS=1.5u PD=1.5u rfmode=0
M$3562 VDD|VPWR|vdd \$74962 A|Q$23 VDD|VPWR|vdd sg13_lv_pmos L=0.13u W=1.12u
+ AS=0.2128p AD=0.3808p PS=1.5u PD=2.92u rfmode=0
M$3563 \$74964 \$74962 VDD|VPWR|vdd VDD|VPWR|vdd sg13_lv_pmos L=0.13u W=0.84u
+ AS=0.2856p AD=0.1974p PS=2.36u PD=1.5u rfmode=0
M$3564 VDD|VPWR|vdd \$74964 Q_N$39 VDD|VPWR|vdd sg13_lv_pmos L=0.13u W=1.12u
+ AS=0.1974p AD=0.3808p PS=1.5u PD=2.92u rfmode=0
M$3565 \$74966 A|Q$23 VDD|VPWR|vdd VDD|VPWR|vdd sg13_lv_pmos L=0.13u W=0.84u
+ AS=0.2856p AD=0.2114p PS=2.36u PD=1.54u rfmode=0
M$3566 VDD|VPWR|vdd \$74966 A|X$32 VDD|VPWR|vdd sg13_lv_pmos L=0.13u W=1.12u
+ AS=0.2114p AD=0.42p PS=1.54u PD=2.99u rfmode=0
M$3567 VDD|VPWR|vdd A|X$65 \$74968 VDD|VPWR|vdd sg13_lv_pmos L=0.13u W=0.84u
+ AS=0.2114p AD=0.2856p PS=1.54u PD=2.36u rfmode=0
M$3568 X|in_l_sw[9]|pl_sw[9]|x \$74968 VDD|VPWR|vdd VDD|VPWR|vdd sg13_lv_pmos
+ L=0.13u W=1.12u AS=0.42p AD=0.2114p PS=2.99u PD=1.54u rfmode=0
M$3569 \$74969 A|Y$29 VDD|VPWR|vdd VDD|VPWR|vdd sg13_lv_pmos L=0.13u W=0.84u
+ AS=0.2856p AD=0.2114p PS=2.36u PD=1.54u rfmode=0
M$3570 VDD|VPWR|vdd \$74969 A|X$58 VDD|VPWR|vdd sg13_lv_pmos L=0.13u W=1.12u
+ AS=0.2114p AD=0.42p PS=1.54u PD=2.99u rfmode=0
M$3571 \$74970 A|X$44 VDD|VPWR|vdd VDD|VPWR|vdd sg13_lv_pmos L=0.13u W=0.84u
+ AS=0.2856p AD=0.2114p PS=2.36u PD=1.54u rfmode=0
M$3572 VDD|VPWR|vdd \$74970 A|X$48 VDD|VPWR|vdd sg13_lv_pmos L=0.13u W=1.12u
+ AS=0.2114p AD=0.42p PS=1.54u PD=2.99u rfmode=0
M$3573 VDD|VPWR|vdd A|X$58 \$74972 VDD|VPWR|vdd sg13_lv_pmos L=0.13u W=0.84u
+ AS=0.2114p AD=0.2856p PS=1.54u PD=2.36u rfmode=0
M$3574 X|in_l_sw[10]|pl_sw[10]|x \$74972 VDD|VPWR|vdd VDD|VPWR|vdd sg13_lv_pmos
+ L=0.13u W=1.12u AS=0.42p AD=0.2114p PS=2.99u PD=1.54u rfmode=0
M$3575 VDD|VPWR|vdd A|X$66 \$75634 VDD|VPWR|vdd sg13_lv_pmos L=0.13u W=0.84u
+ AS=0.2114p AD=0.2856p PS=1.54u PD=2.36u rfmode=0
M$3576 VDD|VPWR|vdd \$75634 X|in_h_sw[0]|ph_sw[0]|x VDD|VPWR|vdd sg13_lv_pmos
+ L=0.13u W=1.12u AS=0.2114p AD=0.42p PS=1.54u PD=2.99u rfmode=0
M$3577 VDD|VPWR|vdd A|X$67 \$75635 VDD|VPWR|vdd sg13_lv_pmos L=0.13u W=0.84u
+ AS=0.2114p AD=0.2856p PS=1.54u PD=2.36u rfmode=0
M$3578 VDD|VPWR|vdd \$75635 X|in_l_sw[1]|pl_sw[1]|x VDD|VPWR|vdd sg13_lv_pmos
+ L=0.13u W=1.12u AS=0.2114p AD=0.42p PS=1.54u PD=2.99u rfmode=0
M$3579 A|X$66 \$75636 VDD|VPWR|vdd VDD|VPWR|vdd sg13_lv_pmos L=0.13u W=1.12u
+ AS=0.42p AD=0.2114p PS=2.99u PD=1.54u rfmode=0
M$3580 VDD|VPWR|vdd A|X$33 \$75636 VDD|VPWR|vdd sg13_lv_pmos L=0.13u W=0.84u
+ AS=0.2114p AD=0.2856p PS=1.54u PD=2.36u rfmode=0
M$3581 VDD|VPWR|vdd D|L_HI \$74864 VDD|VPWR|vdd sg13_lv_pmos L=0.13u W=0.42u
+ AS=0.1428p AD=0.0798p PS=1.52u PD=0.8u rfmode=0
M$3582 VDD|VPWR|vdd RESET_B|Y$2 \$74864 VDD|VPWR|vdd sg13_lv_pmos L=0.13u
+ W=0.42u AS=0.3623875p AD=0.0798p PS=2.605u PD=0.8u rfmode=0
M$3583 VDD|VPWR|vdd \$74929 \$74928 VDD|VPWR|vdd sg13_lv_pmos L=0.13u W=1u
+ AS=0.3623875p AD=0.34p PS=2.605u PD=2.68u rfmode=0
M$3584 VDD|VPWR|vdd A|X$68 \$75637 VDD|VPWR|vdd sg13_lv_pmos L=0.13u W=0.84u
+ AS=0.2114p AD=0.2856p PS=1.54u PD=2.36u rfmode=0
M$3585 VDD|VPWR|vdd \$75637 X|in_h_sw[1]|ph_sw[1]|x VDD|VPWR|vdd sg13_lv_pmos
+ L=0.13u W=1.12u AS=0.2114p AD=0.42p PS=1.54u PD=2.99u rfmode=0
M$3586 VDD|VPWR|vdd RESET_B|Y$2 \$74929 VDD|VPWR|vdd sg13_lv_pmos L=0.13u
+ W=0.42u AS=0.1563p AD=0.147p PS=1.22u PD=1.54u rfmode=0
M$3587 VDD|VPWR|vdd \$74928 \$75355 VDD|VPWR|vdd sg13_lv_pmos L=0.13u W=0.42u
+ AS=0.1563p AD=0.063p PS=1.22u PD=0.72u rfmode=0
M$3588 \$75355 \$75333 \$74929 VDD|VPWR|vdd sg13_lv_pmos L=0.13u W=0.42u
+ AS=0.063p AD=0.0798p PS=0.72u PD=0.8u rfmode=0
M$3589 \$74929 \$74930 \$74864 VDD|VPWR|vdd sg13_lv_pmos L=0.13u W=0.42u
+ AS=0.0798p AD=0.1428p PS=0.8u PD=1.52u rfmode=0
M$3590 VDD|VPWR|vdd A|X$59 \$75638 VDD|VPWR|vdd sg13_lv_pmos L=0.13u W=0.84u
+ AS=0.2114p AD=0.2856p PS=1.54u PD=2.36u rfmode=0
M$3591 VDD|VPWR|vdd \$75638 X|in_l_sw[2]|pl_sw[2]|x VDD|VPWR|vdd sg13_lv_pmos
+ L=0.13u W=1.12u AS=0.2114p AD=0.42p PS=1.54u PD=2.99u rfmode=0
M$3592 A|X$67 \$75639 VDD|VPWR|vdd VDD|VPWR|vdd sg13_lv_pmos L=0.13u W=1.12u
+ AS=0.42p AD=0.2114p PS=2.99u PD=1.54u rfmode=0
M$3593 VDD|VPWR|vdd A|Y$21 \$75639 VDD|VPWR|vdd sg13_lv_pmos L=0.13u W=0.84u
+ AS=0.2114p AD=0.2856p PS=1.54u PD=2.36u rfmode=0
M$3594 VDD|VPWR|vdd \$75333 \$74930 VDD|VPWR|vdd sg13_lv_pmos L=0.13u W=1.12u
+ AS=0.41165p AD=0.3864p PS=2.12u PD=2.93u rfmode=0
M$3595 VDD|VPWR|vdd A|CLK|X \$75333 VDD|VPWR|vdd sg13_lv_pmos L=0.13u W=1.12u
+ AS=0.41165p AD=0.4088p PS=2.12u PD=2.97u rfmode=0
M$3596 A|CLK|X \$75640 VDD|VPWR|vdd VDD|VPWR|vdd sg13_lv_pmos L=0.13u W=1.12u
+ AS=0.42p AD=0.2114p PS=2.99u PD=1.54u rfmode=0
M$3597 VDD|VPWR|vdd A|X$52 \$75640 VDD|VPWR|vdd sg13_lv_pmos L=0.13u W=0.84u
+ AS=0.2114p AD=0.2856p PS=1.54u PD=2.36u rfmode=0
M$3598 \$74928 \$75333 \$75334 VDD|VPWR|vdd sg13_lv_pmos L=0.13u W=1u AS=0.34p
+ AD=0.2048p PS=2.68u PD=1.63u rfmode=0
M$3599 \$75334 \$74930 \$75366 VDD|VPWR|vdd sg13_lv_pmos L=0.13u W=0.42u
+ AS=0.2048p AD=0.09345p PS=1.63u PD=0.865u rfmode=0
M$3600 VDD|VPWR|vdd \$75335 \$75366 VDD|VPWR|vdd sg13_lv_pmos L=0.13u W=0.42u
+ AS=0.204p AD=0.09345p PS=1.835u PD=0.865u rfmode=0
M$3601 VDD|VPWR|vdd RESET_B|Y$2 \$75335 VDD|VPWR|vdd sg13_lv_pmos L=0.13u
+ W=0.42u AS=0.204p AD=0.0798p PS=1.835u PD=0.8u rfmode=0
M$3602 VDD|VPWR|vdd \$75334 \$75335 VDD|VPWR|vdd sg13_lv_pmos L=0.13u W=0.42u
+ AS=0.2639p AD=0.0798p PS=1.81u PD=0.8u rfmode=0
M$3603 VDD|VPWR|vdd \$75334 Q_N$35 VDD|VPWR|vdd sg13_lv_pmos L=0.13u W=1.12u
+ AS=0.2639p AD=0.4312p PS=1.81u PD=3.01u rfmode=0
M$3604 A|X$68 \$75641 VDD|VPWR|vdd VDD|VPWR|vdd sg13_lv_pmos L=0.13u W=1.12u
+ AS=0.42p AD=0.2114p PS=2.99u PD=1.54u rfmode=0
M$3605 VDD|VPWR|vdd A|X$34 \$75641 VDD|VPWR|vdd sg13_lv_pmos L=0.13u W=0.84u
+ AS=0.2114p AD=0.2856p PS=1.54u PD=2.36u rfmode=0
M$3606 VDD|VPWR|vdd A|X$69 \$75642 VDD|VPWR|vdd sg13_lv_pmos L=0.13u W=0.84u
+ AS=0.2114p AD=0.2856p PS=1.54u PD=2.36u rfmode=0
M$3607 VDD|VPWR|vdd \$75642 X|in_h_sw[2]|ph_sw[2]|x VDD|VPWR|vdd sg13_lv_pmos
+ L=0.13u W=1.12u AS=0.2114p AD=0.42p PS=1.54u PD=2.99u rfmode=0
M$3608 A|X$59 \$75643 VDD|VPWR|vdd VDD|VPWR|vdd sg13_lv_pmos L=0.13u W=1.12u
+ AS=0.42p AD=0.2114p PS=2.99u PD=1.54u rfmode=0
M$3609 VDD|VPWR|vdd A|Y$30 \$75643 VDD|VPWR|vdd sg13_lv_pmos L=0.13u W=0.84u
+ AS=0.2114p AD=0.2856p PS=1.54u PD=2.36u rfmode=0
M$3610 A|X$69 \$75644 VDD|VPWR|vdd VDD|VPWR|vdd sg13_lv_pmos L=0.13u W=1.12u
+ AS=0.42p AD=0.2114p PS=2.99u PD=1.54u rfmode=0
M$3611 VDD|VPWR|vdd A|X$40 \$75644 VDD|VPWR|vdd sg13_lv_pmos L=0.13u W=0.84u
+ AS=0.2114p AD=0.2856p PS=1.54u PD=2.36u rfmode=0
M$3612 VDD|VPWR|vdd A|X$70 \$75645 VDD|VPWR|vdd sg13_lv_pmos L=0.13u W=0.84u
+ AS=0.2114p AD=0.2856p PS=1.54u PD=2.36u rfmode=0
M$3613 VDD|VPWR|vdd \$75645 X|in_h_sw[3]|ph_sw[3]|x VDD|VPWR|vdd sg13_lv_pmos
+ L=0.13u W=1.12u AS=0.2114p AD=0.42p PS=1.54u PD=2.99u rfmode=0
M$3614 VDD|VPWR|vdd CLK|D|GATE|Q$5 \$74865 VDD|VPWR|vdd sg13_lv_pmos L=0.13u
+ W=0.42u AS=0.1428p AD=0.0798p PS=1.52u PD=0.8u rfmode=0
M$3615 VDD|VPWR|vdd RESET_B|Y$2 \$74865 VDD|VPWR|vdd sg13_lv_pmos L=0.13u
+ W=0.42u AS=0.3623875p AD=0.0798p PS=2.605u PD=0.8u rfmode=0
M$3616 VDD|VPWR|vdd \$74934 \$74933 VDD|VPWR|vdd sg13_lv_pmos L=0.13u W=1u
+ AS=0.3623875p AD=0.34p PS=2.605u PD=2.68u rfmode=0
M$3617 VDD|VPWR|vdd A|X$60 \$75646 VDD|VPWR|vdd sg13_lv_pmos L=0.13u W=0.84u
+ AS=0.2114p AD=0.2856p PS=1.54u PD=2.36u rfmode=0
M$3618 VDD|VPWR|vdd \$75646 X|in_l_sw[4]|pl_sw[4]|x VDD|VPWR|vdd sg13_lv_pmos
+ L=0.13u W=1.12u AS=0.2114p AD=0.42p PS=1.54u PD=2.99u rfmode=0
M$3619 VDD|VPWR|vdd RESET_B|Y$2 \$74934 VDD|VPWR|vdd sg13_lv_pmos L=0.13u
+ W=0.42u AS=0.1563p AD=0.147p PS=1.22u PD=1.54u rfmode=0
M$3620 VDD|VPWR|vdd \$74933 \$75354 VDD|VPWR|vdd sg13_lv_pmos L=0.13u W=0.42u
+ AS=0.1563p AD=0.063p PS=1.22u PD=0.72u rfmode=0
M$3621 \$75354 \$75336 \$74934 VDD|VPWR|vdd sg13_lv_pmos L=0.13u W=0.42u
+ AS=0.063p AD=0.0798p PS=0.72u PD=0.8u rfmode=0
M$3622 \$74934 \$74935 \$74865 VDD|VPWR|vdd sg13_lv_pmos L=0.13u W=0.42u
+ AS=0.0798p AD=0.1428p PS=0.8u PD=1.52u rfmode=0
M$3623 VDD|VPWR|vdd A|Y$27 \$75647 VDD|VPWR|vdd sg13_lv_pmos L=0.13u W=0.84u
+ AS=0.2114p AD=0.2856p PS=1.54u PD=2.36u rfmode=0
M$3624 VDD|VPWR|vdd \$75647 A|X$50 VDD|VPWR|vdd sg13_lv_pmos L=0.13u W=1.12u
+ AS=0.2114p AD=0.42p PS=1.54u PD=2.99u rfmode=0
M$3625 VDD|VPWR|vdd A|X$71 \$75648 VDD|VPWR|vdd sg13_lv_pmos L=0.13u W=0.84u
+ AS=0.2114p AD=0.2856p PS=1.54u PD=2.36u rfmode=0
M$3626 VDD|VPWR|vdd \$75648 X|in_h_sw[4]|ph_sw[4]|x VDD|VPWR|vdd sg13_lv_pmos
+ L=0.13u W=1.12u AS=0.2114p AD=0.42p PS=1.54u PD=2.99u rfmode=0
M$3627 VDD|VPWR|vdd \$75336 \$74935 VDD|VPWR|vdd sg13_lv_pmos L=0.13u W=1.12u
+ AS=0.41165p AD=0.3864p PS=2.12u PD=2.93u rfmode=0
M$3628 VDD|VPWR|vdd A|CLK|X \$75336 VDD|VPWR|vdd sg13_lv_pmos L=0.13u W=1.12u
+ AS=0.41165p AD=0.4088p PS=2.12u PD=2.97u rfmode=0
M$3629 A|X$70 \$75649 VDD|VPWR|vdd VDD|VPWR|vdd sg13_lv_pmos L=0.13u W=1.12u
+ AS=0.42p AD=0.2114p PS=2.99u PD=1.54u rfmode=0
M$3630 VDD|VPWR|vdd A|X$29 \$75649 VDD|VPWR|vdd sg13_lv_pmos L=0.13u W=0.84u
+ AS=0.2114p AD=0.2856p PS=1.54u PD=2.36u rfmode=0
M$3631 \$74933 \$75336 \$75337 VDD|VPWR|vdd sg13_lv_pmos L=0.13u W=1u AS=0.34p
+ AD=0.2048p PS=2.68u PD=1.63u rfmode=0
M$3632 \$75337 \$74935 \$75367 VDD|VPWR|vdd sg13_lv_pmos L=0.13u W=0.42u
+ AS=0.2048p AD=0.09345p PS=1.63u PD=0.865u rfmode=0
M$3633 VDD|VPWR|vdd \$75338 \$75367 VDD|VPWR|vdd sg13_lv_pmos L=0.13u W=0.42u
+ AS=0.204p AD=0.09345p PS=1.835u PD=0.865u rfmode=0
M$3634 VDD|VPWR|vdd RESET_B|Y$2 \$75338 VDD|VPWR|vdd sg13_lv_pmos L=0.13u
+ W=0.42u AS=0.204p AD=0.0798p PS=1.835u PD=0.8u rfmode=0
M$3635 VDD|VPWR|vdd \$75337 \$75338 VDD|VPWR|vdd sg13_lv_pmos L=0.13u W=0.42u
+ AS=0.2639p AD=0.0798p PS=1.81u PD=0.8u rfmode=0
M$3636 VDD|VPWR|vdd \$75337 Q_N$36 VDD|VPWR|vdd sg13_lv_pmos L=0.13u W=1.12u
+ AS=0.2639p AD=0.4312p PS=1.81u PD=3.01u rfmode=0
M$3637 VDD|VPWR|vdd A|X$72 \$75650 VDD|VPWR|vdd sg13_lv_pmos L=0.13u W=0.84u
+ AS=0.2114p AD=0.2856p PS=1.54u PD=2.36u rfmode=0
M$3638 VDD|VPWR|vdd \$75650 X|in_l_sw[5]|pl_sw[5]|x VDD|VPWR|vdd sg13_lv_pmos
+ L=0.13u W=1.12u AS=0.2114p AD=0.42p PS=1.54u PD=2.99u rfmode=0
M$3639 A|X$60 \$75651 VDD|VPWR|vdd VDD|VPWR|vdd sg13_lv_pmos L=0.13u W=1.12u
+ AS=0.42p AD=0.2114p PS=2.99u PD=1.54u rfmode=0
M$3640 VDD|VPWR|vdd A|Y$26 \$75651 VDD|VPWR|vdd sg13_lv_pmos L=0.13u W=0.84u
+ AS=0.2114p AD=0.2856p PS=1.54u PD=2.36u rfmode=0
M$3641 A|X$71 \$75652 VDD|VPWR|vdd VDD|VPWR|vdd sg13_lv_pmos L=0.13u W=1.12u
+ AS=0.42p AD=0.2114p PS=2.99u PD=1.54u rfmode=0
M$3642 VDD|VPWR|vdd A|X$37 \$75652 VDD|VPWR|vdd sg13_lv_pmos L=0.13u W=0.84u
+ AS=0.2114p AD=0.2856p PS=1.54u PD=2.36u rfmode=0
M$3643 VDD|VPWR|vdd CLK|D|GATE|Q$9 \$74866 VDD|VPWR|vdd sg13_lv_pmos L=0.13u
+ W=0.42u AS=0.1428p AD=0.0798p PS=1.52u PD=0.8u rfmode=0
M$3644 VDD|VPWR|vdd RESET_B|Y$2 \$74866 VDD|VPWR|vdd sg13_lv_pmos L=0.13u
+ W=0.42u AS=0.3623875p AD=0.0798p PS=2.605u PD=0.8u rfmode=0
M$3645 VDD|VPWR|vdd \$74939 \$74938 VDD|VPWR|vdd sg13_lv_pmos L=0.13u W=1u
+ AS=0.3623875p AD=0.34p PS=2.605u PD=2.68u rfmode=0
M$3646 VDD|VPWR|vdd A|X$52 \$75653 VDD|VPWR|vdd sg13_lv_pmos L=0.13u W=0.84u
+ AS=0.2114p AD=0.2856p PS=1.54u PD=2.36u rfmode=0
M$3647 VDD|VPWR|vdd \$75653 A|CLK|X$1 VDD|VPWR|vdd sg13_lv_pmos L=0.13u W=1.12u
+ AS=0.2114p AD=0.42p PS=1.54u PD=2.99u rfmode=0
M$3648 VDD|VPWR|vdd RESET_B|Y$2 \$74939 VDD|VPWR|vdd sg13_lv_pmos L=0.13u
+ W=0.42u AS=0.1563p AD=0.147p PS=1.22u PD=1.54u rfmode=0
M$3649 VDD|VPWR|vdd \$74938 \$75353 VDD|VPWR|vdd sg13_lv_pmos L=0.13u W=0.42u
+ AS=0.1563p AD=0.063p PS=1.22u PD=0.72u rfmode=0
M$3650 \$75353 \$75339 \$74939 VDD|VPWR|vdd sg13_lv_pmos L=0.13u W=0.42u
+ AS=0.063p AD=0.0798p PS=0.72u PD=0.8u rfmode=0
M$3651 \$74939 \$74940 \$74866 VDD|VPWR|vdd sg13_lv_pmos L=0.13u W=0.42u
+ AS=0.0798p AD=0.1428p PS=0.8u PD=1.52u rfmode=0
M$3652 A|X$72 \$75654 VDD|VPWR|vdd VDD|VPWR|vdd sg13_lv_pmos L=0.13u W=1.12u
+ AS=0.42p AD=0.2114p PS=2.99u PD=1.54u rfmode=0
M$3653 VDD|VPWR|vdd A|Y$19 \$75654 VDD|VPWR|vdd sg13_lv_pmos L=0.13u W=0.84u
+ AS=0.2114p AD=0.2856p PS=1.54u PD=2.36u rfmode=0
M$3654 VDD|VPWR|vdd A|X$35 \$75655 VDD|VPWR|vdd sg13_lv_pmos L=0.13u W=0.84u
+ AS=0.2114p AD=0.2856p PS=1.54u PD=2.36u rfmode=0
M$3655 VDD|VPWR|vdd \$75655 A|X$57 VDD|VPWR|vdd sg13_lv_pmos L=0.13u W=1.12u
+ AS=0.2114p AD=0.42p PS=1.54u PD=2.99u rfmode=0
M$3656 VDD|VPWR|vdd \$75339 \$74940 VDD|VPWR|vdd sg13_lv_pmos L=0.13u W=1.12u
+ AS=0.41165p AD=0.3864p PS=2.12u PD=2.93u rfmode=0
M$3657 VDD|VPWR|vdd A|CLK|X$1 \$75339 VDD|VPWR|vdd sg13_lv_pmos L=0.13u W=1.12u
+ AS=0.41165p AD=0.4088p PS=2.12u PD=2.97u rfmode=0
M$3658 \$74938 \$75339 \$75340 VDD|VPWR|vdd sg13_lv_pmos L=0.13u W=1u AS=0.34p
+ AD=0.2048p PS=2.68u PD=1.63u rfmode=0
M$3659 \$75340 \$74940 \$75368 VDD|VPWR|vdd sg13_lv_pmos L=0.13u W=0.42u
+ AS=0.2048p AD=0.09345p PS=1.63u PD=0.865u rfmode=0
M$3660 VDD|VPWR|vdd \$75341 \$75368 VDD|VPWR|vdd sg13_lv_pmos L=0.13u W=0.42u
+ AS=0.204p AD=0.09345p PS=1.835u PD=0.865u rfmode=0
M$3661 VDD|VPWR|vdd RESET_B|Y$2 \$75341 VDD|VPWR|vdd sg13_lv_pmos L=0.13u
+ W=0.42u AS=0.204p AD=0.0798p PS=1.835u PD=0.8u rfmode=0
M$3662 VDD|VPWR|vdd \$75340 \$75341 VDD|VPWR|vdd sg13_lv_pmos L=0.13u W=0.42u
+ AS=0.2639p AD=0.0798p PS=1.81u PD=0.8u rfmode=0
M$3663 VDD|VPWR|vdd \$75340 Q_N$37 VDD|VPWR|vdd sg13_lv_pmos L=0.13u W=1.12u
+ AS=0.2639p AD=0.4312p PS=1.81u PD=3.01u rfmode=0
M$3664 VDD|VPWR|vdd \$75613 \$75614 VDD|VPWR|vdd sg13_lv_pmos L=0.13u W=0.84u
+ AS=0.1974p AD=0.2856p PS=1.5u PD=2.36u rfmode=0
M$3665 VDD|VPWR|vdd \$75614 Q_N$40 VDD|VPWR|vdd sg13_lv_pmos L=0.13u W=1.12u
+ AS=0.1974p AD=0.3808p PS=1.5u PD=2.92u rfmode=0
M$3666 VDD|VPWR|vdd A|Y$22 \$75658 VDD|VPWR|vdd sg13_lv_pmos L=0.13u W=0.84u
+ AS=0.2114p AD=0.2856p PS=1.54u PD=2.36u rfmode=0
M$3667 VDD|VPWR|vdd \$75658 A|X$61 VDD|VPWR|vdd sg13_lv_pmos L=0.13u W=1.12u
+ AS=0.2114p AD=0.42p PS=1.54u PD=2.99u rfmode=0
M$3668 \$75660 \$75619 VDD|VPWR|vdd VDD|VPWR|vdd sg13_lv_pmos L=0.13u W=1.12u
+ AS=0.3864p AD=0.41165p PS=2.93u PD=2.12u rfmode=0
M$3669 VDD|VPWR|vdd A|CLK|X$1 \$75619 VDD|VPWR|vdd sg13_lv_pmos L=0.13u W=1.12u
+ AS=0.41165p AD=0.4088p PS=2.12u PD=2.97u rfmode=0
M$3670 \$75623 \$75661 VDD|VPWR|vdd VDD|VPWR|vdd sg13_lv_pmos L=0.13u W=1.12u
+ AS=0.3864p AD=0.2128p PS=2.93u PD=1.5u rfmode=0
M$3671 VDD|VPWR|vdd \$75623 CLK|D|GATE|Q$7 VDD|VPWR|vdd sg13_lv_pmos L=0.13u
+ W=1.12u AS=0.2128p AD=0.3808p PS=1.5u PD=2.92u rfmode=0
M$3672 VDD|VPWR|vdd CLK|D|GATE|Q$7 \$74867 VDD|VPWR|vdd sg13_lv_pmos L=0.13u
+ W=0.42u AS=0.1428p AD=0.0798p PS=1.52u PD=0.8u rfmode=0
M$3673 VDD|VPWR|vdd RESET_B|Y$2 \$74867 VDD|VPWR|vdd sg13_lv_pmos L=0.13u
+ W=0.42u AS=0.3623875p AD=0.0798p PS=2.605u PD=0.8u rfmode=0
M$3674 VDD|VPWR|vdd \$74956 \$74955 VDD|VPWR|vdd sg13_lv_pmos L=0.13u W=1u
+ AS=0.3623875p AD=0.34p PS=2.605u PD=2.68u rfmode=0
M$3675 VDD|VPWR|vdd A|Y$23 \$75662 VDD|VPWR|vdd sg13_lv_pmos L=0.13u W=0.84u
+ AS=0.2114p AD=0.2856p PS=1.54u PD=2.36u rfmode=0
M$3676 VDD|VPWR|vdd \$75662 A|X$62 VDD|VPWR|vdd sg13_lv_pmos L=0.13u W=1.12u
+ AS=0.2114p AD=0.42p PS=1.54u PD=2.99u rfmode=0
M$3677 VDD|VPWR|vdd RESET_B|Y$2 \$74956 VDD|VPWR|vdd sg13_lv_pmos L=0.13u
+ W=0.42u AS=0.1563p AD=0.147p PS=1.22u PD=1.54u rfmode=0
M$3678 VDD|VPWR|vdd \$74955 \$75352 VDD|VPWR|vdd sg13_lv_pmos L=0.13u W=0.42u
+ AS=0.1563p AD=0.063p PS=1.22u PD=0.72u rfmode=0
M$3679 \$75352 \$75344 \$74956 VDD|VPWR|vdd sg13_lv_pmos L=0.13u W=0.42u
+ AS=0.063p AD=0.0798p PS=0.72u PD=0.8u rfmode=0
M$3680 \$74956 \$74957 \$74867 VDD|VPWR|vdd sg13_lv_pmos L=0.13u W=0.42u
+ AS=0.0798p AD=0.1428p PS=0.8u PD=1.52u rfmode=0
M$3681 VDD|VPWR|vdd A|X$56 \$75663 VDD|VPWR|vdd sg13_lv_pmos L=0.13u W=0.84u
+ AS=0.2114p AD=0.2856p PS=1.54u PD=2.36u rfmode=0
M$3682 VDD|VPWR|vdd \$75663 A|X$63 VDD|VPWR|vdd sg13_lv_pmos L=0.13u W=1.12u
+ AS=0.2114p AD=0.42p PS=1.54u PD=2.99u rfmode=0
M$3683 VDD|VPWR|vdd \$75344 \$74957 VDD|VPWR|vdd sg13_lv_pmos L=0.13u W=1.12u
+ AS=0.41165p AD=0.3864p PS=2.12u PD=2.93u rfmode=0
M$3684 VDD|VPWR|vdd A|CLK|X$1 \$75344 VDD|VPWR|vdd sg13_lv_pmos L=0.13u W=1.12u
+ AS=0.41165p AD=0.4088p PS=2.12u PD=2.97u rfmode=0
M$3685 X|in_h_sw[6]|ph_sw[6]|x \$75664 VDD|VPWR|vdd VDD|VPWR|vdd sg13_lv_pmos
+ L=0.13u W=1.12u AS=0.42p AD=0.2114p PS=2.99u PD=1.54u rfmode=0
M$3686 VDD|VPWR|vdd A|X$55 \$75664 VDD|VPWR|vdd sg13_lv_pmos L=0.13u W=0.84u
+ AS=0.2114p AD=0.2856p PS=1.54u PD=2.36u rfmode=0
M$3687 \$74955 \$75344 \$75345 VDD|VPWR|vdd sg13_lv_pmos L=0.13u W=1u AS=0.34p
+ AD=0.2048p PS=2.68u PD=1.63u rfmode=0
M$3688 \$75345 \$74957 \$75369 VDD|VPWR|vdd sg13_lv_pmos L=0.13u W=0.42u
+ AS=0.2048p AD=0.09345p PS=1.63u PD=0.865u rfmode=0
M$3689 VDD|VPWR|vdd \$75346 \$75369 VDD|VPWR|vdd sg13_lv_pmos L=0.13u W=0.42u
+ AS=0.204p AD=0.09345p PS=1.835u PD=0.865u rfmode=0
M$3690 VDD|VPWR|vdd RESET_B|Y$2 \$75346 VDD|VPWR|vdd sg13_lv_pmos L=0.13u
+ W=0.42u AS=0.204p AD=0.0798p PS=1.835u PD=0.8u rfmode=0
M$3691 VDD|VPWR|vdd \$75345 \$75346 VDD|VPWR|vdd sg13_lv_pmos L=0.13u W=0.42u
+ AS=0.2639p AD=0.0798p PS=1.81u PD=0.8u rfmode=0
M$3692 VDD|VPWR|vdd \$75345 Q_N$38 VDD|VPWR|vdd sg13_lv_pmos L=0.13u W=1.12u
+ AS=0.2639p AD=0.4312p PS=1.81u PD=3.01u rfmode=0
M$3693 VDD|VPWR|vdd A|Y$20 \$75665 VDD|VPWR|vdd sg13_lv_pmos L=0.13u W=0.84u
+ AS=0.2114p AD=0.2856p PS=1.54u PD=2.36u rfmode=0
M$3694 VDD|VPWR|vdd \$75665 A|X$73 VDD|VPWR|vdd sg13_lv_pmos L=0.13u W=1.12u
+ AS=0.2114p AD=0.42p PS=1.54u PD=2.99u rfmode=0
M$3695 VDD|VPWR|vdd A|X$43 \$75666 VDD|VPWR|vdd sg13_lv_pmos L=0.13u W=0.84u
+ AS=0.2114p AD=0.2856p PS=1.54u PD=2.36u rfmode=0
M$3696 VDD|VPWR|vdd \$75666 A|X$64 VDD|VPWR|vdd sg13_lv_pmos L=0.13u W=1.12u
+ AS=0.2114p AD=0.42p PS=1.54u PD=2.99u rfmode=0
M$3697 X|in_l_sw[7]|pl_sw[7]|x \$75667 VDD|VPWR|vdd VDD|VPWR|vdd sg13_lv_pmos
+ L=0.13u W=1.12u AS=0.42p AD=0.2114p PS=2.99u PD=1.54u rfmode=0
M$3698 VDD|VPWR|vdd A|X$62 \$75667 VDD|VPWR|vdd sg13_lv_pmos L=0.13u W=0.84u
+ AS=0.2114p AD=0.2856p PS=1.54u PD=2.36u rfmode=0
M$3699 X|in_h_sw[7]|ph_sw[7]|x \$75668 VDD|VPWR|vdd VDD|VPWR|vdd sg13_lv_pmos
+ L=0.13u W=1.12u AS=0.42p AD=0.2114p PS=2.99u PD=1.54u rfmode=0
M$3700 VDD|VPWR|vdd A|X$63 \$75668 VDD|VPWR|vdd sg13_lv_pmos L=0.13u W=0.84u
+ AS=0.2114p AD=0.2856p PS=1.54u PD=2.36u rfmode=0
M$3701 VDD|VPWR|vdd D|Q_N$10 \$74960 VDD|VPWR|vdd sg13_lv_pmos L=0.13u W=0.84u
+ AS=0.3018p AD=0.2856p PS=1.97u PD=2.36u rfmode=0
M$3702 VDD|VPWR|vdd CLK|D|GATE|Q$8 \$75347 VDD|VPWR|vdd sg13_lv_pmos L=0.13u
+ W=0.84u AS=0.3018p AD=0.3234p PS=1.97u PD=2.45u rfmode=0
M$3703 X|in_l_sw[8]|pl_sw[8]|x \$75669 VDD|VPWR|vdd VDD|VPWR|vdd sg13_lv_pmos
+ L=0.13u W=1.12u AS=0.42p AD=0.2114p PS=2.99u PD=1.54u rfmode=0
M$3704 VDD|VPWR|vdd A|X$73 \$75669 VDD|VPWR|vdd sg13_lv_pmos L=0.13u W=0.84u
+ AS=0.2114p AD=0.2856p PS=1.54u PD=2.36u rfmode=0
M$3705 VDD|VPWR|vdd A|Y$24 \$75670 VDD|VPWR|vdd sg13_lv_pmos L=0.13u W=0.84u
+ AS=0.2114p AD=0.2856p PS=1.54u PD=2.36u rfmode=0
M$3706 VDD|VPWR|vdd \$75670 A|X$65 VDD|VPWR|vdd sg13_lv_pmos L=0.13u W=1.12u
+ AS=0.2114p AD=0.42p PS=1.54u PD=2.99u rfmode=0
M$3707 VDD|VPWR|vdd A|X$49 \$75671 VDD|VPWR|vdd sg13_lv_pmos L=0.13u W=0.84u
+ AS=0.2114p AD=0.2856p PS=1.54u PD=2.36u rfmode=0
M$3708 VDD|VPWR|vdd \$75671 A|X$47 VDD|VPWR|vdd sg13_lv_pmos L=0.13u W=1.12u
+ AS=0.2114p AD=0.42p PS=1.54u PD=2.99u rfmode=0
M$3709 X|in_h_sw[8]|ph_sw[8]|x \$75672 VDD|VPWR|vdd VDD|VPWR|vdd sg13_lv_pmos
+ L=0.13u W=1.12u AS=0.42p AD=0.2114p PS=2.99u PD=1.54u rfmode=0
M$3710 VDD|VPWR|vdd A|X$64 \$75672 VDD|VPWR|vdd sg13_lv_pmos L=0.13u W=0.84u
+ AS=0.2114p AD=0.2856p PS=1.54u PD=2.36u rfmode=0
M$3711 \$75633 A|anode|cathode|ck|cks|core|pad|padres VDD|VPWR|vdd VDD|VPWR|vdd
+ sg13_lv_pmos L=0.13u W=3.36u AS=0.8064p AD=0.6384p PS=5.92u PD=4.5u rfmode=0
M$3714 VDD|VPWR|vdd \$75633 A|X$51 VDD|VPWR|vdd sg13_lv_pmos L=0.13u W=8.96u
+ AS=1.7024p AD=1.876p PS=12u PD=13.43u rfmode=0
M$3722
+ BOTTOM|TOP|VGND|VSS|anode|cathode|core|h_sw[0]|h_sw[10]|h_sw[1]|h_sw[2]|h_sw[3]|h_sw[4]|h_sw[5]|h_sw[6]|h_sw[7]|h_sw[8]|h_sw[9]|l_sw[0]|l_sw[10]|l_sw[1]|l_sw[2]|l_sw[3]|l_sw[4]|l_sw[5]|l_sw[6]|l_sw[7]|l_sw[8]|l_sw[9]|out|pad|padres|vc|vcp|vdd|vddr|vip|vss|z
+ X|in_l_sw[0]|pl_sw[0]|x
+ BOTTOM|TOP|VGND|VSS|anode|cathode|core|h_sw[0]|h_sw[10]|h_sw[1]|h_sw[2]|h_sw[3]|h_sw[4]|h_sw[5]|h_sw[6]|h_sw[7]|h_sw[8]|h_sw[9]|l_sw[0]|l_sw[10]|l_sw[1]|l_sw[2]|l_sw[3]|l_sw[4]|l_sw[5]|l_sw[6]|l_sw[7]|l_sw[8]|l_sw[9]|out|pad|padres|vc|vcp|vdd|vddr|vip|vss|z
+ \$77307 sg13_lv_pmos L=0.13u W=32u AS=6.23p AD=6.23p PS=45.46u PD=45.46u
+ rfmode=0
M$3754
+ BOTTOM|TOP|VGND|VSS|anode|cathode|core|h_sw[0]|h_sw[10]|h_sw[1]|h_sw[2]|h_sw[3]|h_sw[4]|h_sw[5]|h_sw[6]|h_sw[7]|h_sw[8]|h_sw[9]|l_sw[0]|l_sw[10]|l_sw[1]|l_sw[2]|l_sw[3]|l_sw[4]|l_sw[5]|l_sw[6]|l_sw[7]|l_sw[8]|l_sw[9]|out|pad|padres|vc|vcp|vdd|vddr|vip|vss|z
+ X|in_h_sw[0]|ph_sw[0]|x
+ BOTTOM|TOP|VGND|VSS|anode|cathode|core|h_sw[0]|h_sw[10]|h_sw[1]|h_sw[2]|h_sw[3]|h_sw[4]|h_sw[5]|h_sw[6]|h_sw[7]|h_sw[8]|h_sw[9]|l_sw[0]|l_sw[10]|l_sw[1]|l_sw[2]|l_sw[3]|l_sw[4]|l_sw[5]|l_sw[6]|l_sw[7]|l_sw[8]|l_sw[9]|out|pad|padres|vc|vcp|vdd|vddr|vip|vss|z
+ \$77307 sg13_lv_pmos L=0.13u W=32u AS=6.23p AD=6.23p PS=45.46u PD=45.46u
+ rfmode=0
M$3786 A|Y$30 A|X$5 VDD|VPWR|vdd VDD|VPWR|vdd sg13_lv_pmos L=0.13u W=1.12u
+ AS=0.3808p AD=0.3808p PS=2.92u PD=2.92u rfmode=0
M$3787 \$75656 D|Q_N$9 VDD|VPWR|vdd VDD|VPWR|vdd sg13_lv_pmos L=0.13u W=0.84u
+ AS=0.2856p AD=0.3018p PS=2.36u PD=1.97u rfmode=0
M$3788 VDD|VPWR|vdd CLK|D|GATE|Q$9 \$75611 VDD|VPWR|vdd sg13_lv_pmos L=0.13u
+ W=0.84u AS=0.3018p AD=0.3234p PS=1.97u PD=2.45u rfmode=0
M$3789 \$75657 \$75611 VDD|VPWR|vdd VDD|VPWR|vdd sg13_lv_pmos L=0.13u W=0.84u
+ AS=0.2856p AD=0.26675p PS=2.36u PD=1.845u rfmode=0
M$3790 VDD|VPWR|vdd \$75656 \$76227 VDD|VPWR|vdd sg13_lv_pmos L=0.13u W=1u
+ AS=0.26675p AD=0.105p PS=1.845u PD=1.21u rfmode=0
M$3791 \$76227 \$75611 \$75612 VDD|VPWR|vdd sg13_lv_pmos L=0.13u W=1u AS=0.105p
+ AD=0.191p PS=1.21u PD=1.44u rfmode=0
M$3792 \$75612 \$75657 \$76226 VDD|VPWR|vdd sg13_lv_pmos L=0.13u W=0.42u
+ AS=0.191p AD=0.1008p PS=1.44u PD=0.9u rfmode=0
M$3793 VDD|VPWR|vdd \$75613 \$76226 VDD|VPWR|vdd sg13_lv_pmos L=0.13u W=0.42u
+ AS=0.2387p AD=0.1008p PS=1.84u PD=0.9u rfmode=0
M$3794 VDD|VPWR|vdd \$75612 \$75613 VDD|VPWR|vdd sg13_lv_pmos L=0.13u W=1.12u
+ AS=0.2387p AD=0.2128p PS=1.84u PD=1.5u rfmode=0
M$3795 \$75613 RESET_B|Y$1 VDD|VPWR|vdd VDD|VPWR|vdd sg13_lv_pmos L=0.13u
+ W=1.12u AS=0.2128p AD=0.2128p PS=1.5u PD=1.5u rfmode=0
M$3796 VDD|VPWR|vdd \$75613 A|Q$24 VDD|VPWR|vdd sg13_lv_pmos L=0.13u W=1.12u
+ AS=0.2128p AD=0.3808p PS=1.5u PD=2.92u rfmode=0
M$3797 VDD|VPWR|vdd CLK|D|GATE|Q$10 \$75659 VDD|VPWR|vdd sg13_lv_pmos L=0.13u
+ W=0.42u AS=0.1428p AD=0.0798p PS=1.52u PD=0.8u rfmode=0
M$3798 VDD|VPWR|vdd RESET_B|Y$2 \$75659 VDD|VPWR|vdd sg13_lv_pmos L=0.13u
+ W=0.42u AS=0.3623875p AD=0.0798p PS=2.605u PD=0.8u rfmode=0
M$3799 VDD|VPWR|vdd \$75743 \$75618 VDD|VPWR|vdd sg13_lv_pmos L=0.13u W=1u
+ AS=0.3623875p AD=0.34p PS=2.605u PD=2.68u rfmode=0
M$3800 \$75743 RESET_B|Y$2 VDD|VPWR|vdd VDD|VPWR|vdd sg13_lv_pmos L=0.13u
+ W=0.42u AS=0.147p AD=0.1563p PS=1.54u PD=1.22u rfmode=0
M$3801 VDD|VPWR|vdd \$75618 \$76066 VDD|VPWR|vdd sg13_lv_pmos L=0.13u W=0.42u
+ AS=0.1563p AD=0.063p PS=1.22u PD=0.72u rfmode=0
M$3802 \$76066 \$75619 \$75743 VDD|VPWR|vdd sg13_lv_pmos L=0.13u W=0.42u
+ AS=0.063p AD=0.0798p PS=0.72u PD=0.8u rfmode=0
M$3803 \$75743 \$75660 \$75659 VDD|VPWR|vdd sg13_lv_pmos L=0.13u W=0.42u
+ AS=0.0798p AD=0.1428p PS=0.8u PD=1.52u rfmode=0
M$3804 \$75661 \$75660 \$76068 VDD|VPWR|vdd sg13_lv_pmos L=0.13u W=0.42u
+ AS=0.2048p AD=0.09345p PS=1.63u PD=0.865u rfmode=0
M$3805 \$76068 \$75621 VDD|VPWR|vdd VDD|VPWR|vdd sg13_lv_pmos L=0.13u W=0.42u
+ AS=0.09345p AD=0.204p PS=0.865u PD=1.835u rfmode=0
M$3806 VDD|VPWR|vdd RESET_B|Y$2 \$75621 VDD|VPWR|vdd sg13_lv_pmos L=0.13u
+ W=0.42u AS=0.204p AD=0.0798p PS=1.835u PD=0.8u rfmode=0
M$3807 VDD|VPWR|vdd \$75661 \$75621 VDD|VPWR|vdd sg13_lv_pmos L=0.13u W=0.42u
+ AS=0.2639p AD=0.0798p PS=1.81u PD=0.8u rfmode=0
M$3808 \$75618 \$75619 \$75661 VDD|VPWR|vdd sg13_lv_pmos L=0.13u W=1u AS=0.34p
+ AD=0.2048p PS=2.68u PD=1.63u rfmode=0
M$3809 VDD|VPWR|vdd \$75661 Q_N$41 VDD|VPWR|vdd sg13_lv_pmos L=0.13u W=1.12u
+ AS=0.2639p AD=0.4312p PS=1.81u PD=3.01u rfmode=0
M$3810 VDD|VPWR|vdd A|X$28 A|Y$29 VDD|VPWR|vdd sg13_lv_pmos L=0.13u W=1.12u
+ AS=0.3808p AD=0.3808p PS=2.92u PD=2.92u rfmode=0
M$3811
+ BOTTOM|TOP|VGND|VSS|anode|cathode|core|h_sw[0]|h_sw[10]|h_sw[1]|h_sw[2]|h_sw[3]|h_sw[4]|h_sw[5]|h_sw[6]|h_sw[7]|h_sw[8]|h_sw[9]|l_sw[0]|l_sw[10]|l_sw[1]|l_sw[2]|l_sw[3]|l_sw[4]|l_sw[5]|l_sw[6]|l_sw[7]|l_sw[8]|l_sw[9]|out|pad|padres|vc|vcp|vdd|vddr|vip|vss|z
+ X|in_h_sw[3]|ph_sw[3]|x
+ BOTTOM|TOP|VGND|VSS|anode|cathode|core|h_sw[0]|h_sw[10]|h_sw[1]|h_sw[2]|h_sw[3]|h_sw[4]|h_sw[5]|h_sw[6]|h_sw[7]|h_sw[8]|h_sw[9]|l_sw[0]|l_sw[10]|l_sw[1]|l_sw[2]|l_sw[3]|l_sw[4]|l_sw[5]|l_sw[6]|l_sw[7]|l_sw[8]|l_sw[9]|out|pad|padres|vc|vcp|vdd|vddr|vip|vss|z
+ \$78069 sg13_lv_pmos L=0.13u W=8u AS=1.67p AD=1.67p PS=12.34u PD=12.34u
+ rfmode=0
M$3819
+ BOTTOM|TOP|VGND|VSS|anode|cathode|core|h_sw[0]|h_sw[10]|h_sw[1]|h_sw[2]|h_sw[3]|h_sw[4]|h_sw[5]|h_sw[6]|h_sw[7]|h_sw[8]|h_sw[9]|l_sw[0]|l_sw[10]|l_sw[1]|l_sw[2]|l_sw[3]|l_sw[4]|l_sw[5]|l_sw[6]|l_sw[7]|l_sw[8]|l_sw[9]|out|pad|padres|vc|vcp|vdd|vddr|vip|vss|z
+ X|in_h_sw[4]|ph_sw[4]|x
+ BOTTOM|TOP|VGND|VSS|anode|cathode|core|h_sw[0]|h_sw[10]|h_sw[1]|h_sw[2]|h_sw[3]|h_sw[4]|h_sw[5]|h_sw[6]|h_sw[7]|h_sw[8]|h_sw[9]|l_sw[0]|l_sw[10]|l_sw[1]|l_sw[2]|l_sw[3]|l_sw[4]|l_sw[5]|l_sw[6]|l_sw[7]|l_sw[8]|l_sw[9]|out|pad|padres|vc|vcp|vdd|vddr|vip|vss|z
+ \$78069 sg13_lv_pmos L=0.13u W=8u AS=1.67p AD=1.67p PS=12.34u PD=12.34u
+ rfmode=0
M$3827
+ BOTTOM|TOP|VGND|VSS|anode|cathode|core|h_sw[0]|h_sw[10]|h_sw[1]|h_sw[2]|h_sw[3]|h_sw[4]|h_sw[5]|h_sw[6]|h_sw[7]|h_sw[8]|h_sw[9]|l_sw[0]|l_sw[10]|l_sw[1]|l_sw[2]|l_sw[3]|l_sw[4]|l_sw[5]|l_sw[6]|l_sw[7]|l_sw[8]|l_sw[9]|out|pad|padres|vc|vcp|vdd|vddr|vip|vss|z
+ X|in_h_sw[5]|ph_sw[5]|x
+ BOTTOM|TOP|VGND|VSS|anode|cathode|core|h_sw[0]|h_sw[10]|h_sw[1]|h_sw[2]|h_sw[3]|h_sw[4]|h_sw[5]|h_sw[6]|h_sw[7]|h_sw[8]|h_sw[9]|l_sw[0]|l_sw[10]|l_sw[1]|l_sw[2]|l_sw[3]|l_sw[4]|l_sw[5]|l_sw[6]|l_sw[7]|l_sw[8]|l_sw[9]|out|pad|padres|vc|vcp|vdd|vddr|vip|vss|z
+ \$78070 sg13_lv_pmos L=0.13u W=8u AS=1.67p AD=1.67p PS=12.34u PD=12.34u
+ rfmode=0
M$3835
+ BOTTOM|TOP|VGND|VSS|anode|cathode|core|h_sw[0]|h_sw[10]|h_sw[1]|h_sw[2]|h_sw[3]|h_sw[4]|h_sw[5]|h_sw[6]|h_sw[7]|h_sw[8]|h_sw[9]|l_sw[0]|l_sw[10]|l_sw[1]|l_sw[2]|l_sw[3]|l_sw[4]|l_sw[5]|l_sw[6]|l_sw[7]|l_sw[8]|l_sw[9]|out|pad|padres|vc|vcp|vdd|vddr|vip|vss|z
+ X|in_l_sw[1]|pl_sw[1]|x
+ BOTTOM|TOP|VGND|VSS|anode|cathode|core|h_sw[0]|h_sw[10]|h_sw[1]|h_sw[2]|h_sw[3]|h_sw[4]|h_sw[5]|h_sw[6]|h_sw[7]|h_sw[8]|h_sw[9]|l_sw[0]|l_sw[10]|l_sw[1]|l_sw[2]|l_sw[3]|l_sw[4]|l_sw[5]|l_sw[6]|l_sw[7]|l_sw[8]|l_sw[9]|out|pad|padres|vc|vcp|vdd|vddr|vip|vss|z
+ \$78597 sg13_lv_pmos L=0.13u W=16u AS=3.19p AD=3.19p PS=23.38u PD=23.38u
+ rfmode=0
M$3851
+ BOTTOM|TOP|VGND|VSS|anode|cathode|core|h_sw[0]|h_sw[10]|h_sw[1]|h_sw[2]|h_sw[3]|h_sw[4]|h_sw[5]|h_sw[6]|h_sw[7]|h_sw[8]|h_sw[9]|l_sw[0]|l_sw[10]|l_sw[1]|l_sw[2]|l_sw[3]|l_sw[4]|l_sw[5]|l_sw[6]|l_sw[7]|l_sw[8]|l_sw[9]|out|pad|padres|vc|vcp|vdd|vddr|vip|vss|z
+ X|in_h_sw[1]|ph_sw[1]|x
+ BOTTOM|TOP|VGND|VSS|anode|cathode|core|h_sw[0]|h_sw[10]|h_sw[1]|h_sw[2]|h_sw[3]|h_sw[4]|h_sw[5]|h_sw[6]|h_sw[7]|h_sw[8]|h_sw[9]|l_sw[0]|l_sw[10]|l_sw[1]|l_sw[2]|l_sw[3]|l_sw[4]|l_sw[5]|l_sw[6]|l_sw[7]|l_sw[8]|l_sw[9]|out|pad|padres|vc|vcp|vdd|vddr|vip|vss|z
+ \$78597 sg13_lv_pmos L=0.13u W=16u AS=3.19p AD=3.19p PS=23.38u PD=23.38u
+ rfmode=0
M$3867
+ BOTTOM|TOP|VGND|VSS|anode|cathode|core|h_sw[0]|h_sw[10]|h_sw[1]|h_sw[2]|h_sw[3]|h_sw[4]|h_sw[5]|h_sw[6]|h_sw[7]|h_sw[8]|h_sw[9]|l_sw[0]|l_sw[10]|l_sw[1]|l_sw[2]|l_sw[3]|l_sw[4]|l_sw[5]|l_sw[6]|l_sw[7]|l_sw[8]|l_sw[9]|out|pad|padres|vc|vcp|vdd|vddr|vip|vss|z
+ X|in_l_sw[2]|pl_sw[2]|x
+ BOTTOM|TOP|VGND|VSS|anode|cathode|core|h_sw[0]|h_sw[10]|h_sw[1]|h_sw[2]|h_sw[3]|h_sw[4]|h_sw[5]|h_sw[6]|h_sw[7]|h_sw[8]|h_sw[9]|l_sw[0]|l_sw[10]|l_sw[1]|l_sw[2]|l_sw[3]|l_sw[4]|l_sw[5]|l_sw[6]|l_sw[7]|l_sw[8]|l_sw[9]|out|pad|padres|vc|vcp|vdd|vddr|vip|vss|z
+ \$78598 sg13_lv_pmos L=0.13u W=16u AS=3.19p AD=3.19p PS=23.38u PD=23.38u
+ rfmode=0
M$3883
+ BOTTOM|TOP|VGND|VSS|anode|cathode|core|h_sw[0]|h_sw[10]|h_sw[1]|h_sw[2]|h_sw[3]|h_sw[4]|h_sw[5]|h_sw[6]|h_sw[7]|h_sw[8]|h_sw[9]|l_sw[0]|l_sw[10]|l_sw[1]|l_sw[2]|l_sw[3]|l_sw[4]|l_sw[5]|l_sw[6]|l_sw[7]|l_sw[8]|l_sw[9]|out|pad|padres|vc|vcp|vdd|vddr|vip|vss|z
+ X|in_h_sw[2]|ph_sw[2]|x
+ BOTTOM|TOP|VGND|VSS|anode|cathode|core|h_sw[0]|h_sw[10]|h_sw[1]|h_sw[2]|h_sw[3]|h_sw[4]|h_sw[5]|h_sw[6]|h_sw[7]|h_sw[8]|h_sw[9]|l_sw[0]|l_sw[10]|l_sw[1]|l_sw[2]|l_sw[3]|l_sw[4]|l_sw[5]|l_sw[6]|l_sw[7]|l_sw[8]|l_sw[9]|out|pad|padres|vc|vcp|vdd|vddr|vip|vss|z
+ \$78598 sg13_lv_pmos L=0.13u W=16u AS=3.19p AD=3.19p PS=23.38u PD=23.38u
+ rfmode=0
M$3899
+ BOTTOM|TOP|VGND|VSS|anode|cathode|core|h_sw[0]|h_sw[10]|h_sw[1]|h_sw[2]|h_sw[3]|h_sw[4]|h_sw[5]|h_sw[6]|h_sw[7]|h_sw[8]|h_sw[9]|l_sw[0]|l_sw[10]|l_sw[1]|l_sw[2]|l_sw[3]|l_sw[4]|l_sw[5]|l_sw[6]|l_sw[7]|l_sw[8]|l_sw[9]|out|pad|padres|vc|vcp|vdd|vddr|vip|vss|z
+ X|in_h_sw[6]|ph_sw[6]|x
+ BOTTOM|TOP|VGND|VSS|anode|cathode|core|h_sw[0]|h_sw[10]|h_sw[1]|h_sw[2]|h_sw[3]|h_sw[4]|h_sw[5]|h_sw[6]|h_sw[7]|h_sw[8]|h_sw[9]|l_sw[0]|l_sw[10]|l_sw[1]|l_sw[2]|l_sw[3]|l_sw[4]|l_sw[5]|l_sw[6]|l_sw[7]|l_sw[8]|l_sw[9]|out|pad|padres|vc|vcp|vdd|vddr|vip|vss|z
+ \$78070 sg13_lv_pmos L=0.13u W=4u AS=0.91p AD=0.91p PS=6.82u PD=6.82u rfmode=0
M$3903
+ BOTTOM|TOP|VGND|VSS|anode|cathode|core|h_sw[0]|h_sw[10]|h_sw[1]|h_sw[2]|h_sw[3]|h_sw[4]|h_sw[5]|h_sw[6]|h_sw[7]|h_sw[8]|h_sw[9]|l_sw[0]|l_sw[10]|l_sw[1]|l_sw[2]|l_sw[3]|l_sw[4]|l_sw[5]|l_sw[6]|l_sw[7]|l_sw[8]|l_sw[9]|out|pad|padres|vc|vcp|vdd|vddr|vip|vss|z
+ X|in_h_sw[7]|ph_sw[7]|x
+ BOTTOM|TOP|VGND|VSS|anode|cathode|core|h_sw[0]|h_sw[10]|h_sw[1]|h_sw[2]|h_sw[3]|h_sw[4]|h_sw[5]|h_sw[6]|h_sw[7]|h_sw[8]|h_sw[9]|l_sw[0]|l_sw[10]|l_sw[1]|l_sw[2]|l_sw[3]|l_sw[4]|l_sw[5]|l_sw[6]|l_sw[7]|l_sw[8]|l_sw[9]|out|pad|padres|vc|vcp|vdd|vddr|vip|vss|z
+ \$78657 sg13_lv_pmos L=0.13u W=4u AS=0.91p AD=0.91p PS=6.82u PD=6.82u rfmode=0
M$3907
+ BOTTOM|TOP|VGND|VSS|anode|cathode|core|h_sw[0]|h_sw[10]|h_sw[1]|h_sw[2]|h_sw[3]|h_sw[4]|h_sw[5]|h_sw[6]|h_sw[7]|h_sw[8]|h_sw[9]|l_sw[0]|l_sw[10]|l_sw[1]|l_sw[2]|l_sw[3]|l_sw[4]|l_sw[5]|l_sw[6]|l_sw[7]|l_sw[8]|l_sw[9]|out|pad|padres|vc|vcp|vdd|vddr|vip|vss|z
+ X|in_h_sw[8]|ph_sw[8]|x
+ BOTTOM|TOP|VGND|VSS|anode|cathode|core|h_sw[0]|h_sw[10]|h_sw[1]|h_sw[2]|h_sw[3]|h_sw[4]|h_sw[5]|h_sw[6]|h_sw[7]|h_sw[8]|h_sw[9]|l_sw[0]|l_sw[10]|l_sw[1]|l_sw[2]|l_sw[3]|l_sw[4]|l_sw[5]|l_sw[6]|l_sw[7]|l_sw[8]|l_sw[9]|out|pad|padres|vc|vcp|vdd|vddr|vip|vss|z
+ \$78657 sg13_lv_pmos L=0.13u W=2u AS=0.53p AD=0.53p PS=4.06u PD=4.06u rfmode=0
M$3909
+ BOTTOM|TOP|VGND|VSS|anode|cathode|core|h_sw[0]|h_sw[10]|h_sw[1]|h_sw[2]|h_sw[3]|h_sw[4]|h_sw[5]|h_sw[6]|h_sw[7]|h_sw[8]|h_sw[9]|l_sw[0]|l_sw[10]|l_sw[1]|l_sw[2]|l_sw[3]|l_sw[4]|l_sw[5]|l_sw[6]|l_sw[7]|l_sw[8]|l_sw[9]|out|pad|padres|vc|vcp|vdd|vddr|vip|vss|z
+ X|in_h_sw[9]|ph_sw[9]|x
+ BOTTOM|TOP|VGND|VSS|anode|cathode|core|h_sw[0]|h_sw[10]|h_sw[1]|h_sw[2]|h_sw[3]|h_sw[4]|h_sw[5]|h_sw[6]|h_sw[7]|h_sw[8]|h_sw[9]|l_sw[0]|l_sw[10]|l_sw[1]|l_sw[2]|l_sw[3]|l_sw[4]|l_sw[5]|l_sw[6]|l_sw[7]|l_sw[8]|l_sw[9]|out|pad|padres|vc|vcp|vdd|vddr|vip|vss|z
+ \$78956 sg13_lv_pmos L=0.13u W=2u AS=0.53p AD=0.53p PS=4.06u PD=4.06u rfmode=0
M$3911
+ BOTTOM|TOP|VGND|VSS|anode|cathode|core|h_sw[0]|h_sw[10]|h_sw[1]|h_sw[2]|h_sw[3]|h_sw[4]|h_sw[5]|h_sw[6]|h_sw[7]|h_sw[8]|h_sw[9]|l_sw[0]|l_sw[10]|l_sw[1]|l_sw[2]|l_sw[3]|l_sw[4]|l_sw[5]|l_sw[6]|l_sw[7]|l_sw[8]|l_sw[9]|out|pad|padres|vc|vcp|vdd|vddr|vip|vss|z
+ X|in_l_sw[4]|pl_sw[4]|x
+ BOTTOM|TOP|VGND|VSS|anode|cathode|core|h_sw[0]|h_sw[10]|h_sw[1]|h_sw[2]|h_sw[3]|h_sw[4]|h_sw[5]|h_sw[6]|h_sw[7]|h_sw[8]|h_sw[9]|l_sw[0]|l_sw[10]|l_sw[1]|l_sw[2]|l_sw[3]|l_sw[4]|l_sw[5]|l_sw[6]|l_sw[7]|l_sw[8]|l_sw[9]|out|pad|padres|vc|vcp|vdd|vddr|vip|vss|z
+ \$78069 sg13_lv_pmos L=0.13u W=8u AS=1.67p AD=1.67p PS=12.34u PD=12.34u
+ rfmode=0
M$3919
+ BOTTOM|TOP|VGND|VSS|anode|cathode|core|h_sw[0]|h_sw[10]|h_sw[1]|h_sw[2]|h_sw[3]|h_sw[4]|h_sw[5]|h_sw[6]|h_sw[7]|h_sw[8]|h_sw[9]|l_sw[0]|l_sw[10]|l_sw[1]|l_sw[2]|l_sw[3]|l_sw[4]|l_sw[5]|l_sw[6]|l_sw[7]|l_sw[8]|l_sw[9]|out|pad|padres|vc|vcp|vdd|vddr|vip|vss|z
+ X|in_h_sw[10]|ph_sw[10]|x
+ BOTTOM|TOP|VGND|VSS|anode|cathode|core|h_sw[0]|h_sw[10]|h_sw[1]|h_sw[2]|h_sw[3]|h_sw[4]|h_sw[5]|h_sw[6]|h_sw[7]|h_sw[8]|h_sw[9]|l_sw[0]|l_sw[10]|l_sw[1]|l_sw[2]|l_sw[3]|l_sw[4]|l_sw[5]|l_sw[6]|l_sw[7]|l_sw[8]|l_sw[9]|out|pad|padres|vc|vcp|vdd|vddr|vip|vss|z
+ \$78956 sg13_lv_pmos L=0.13u W=1u AS=0.34p AD=0.34p PS=2.68u PD=2.68u rfmode=0
M$3920
+ BOTTOM|TOP|VGND|VSS|anode|cathode|core|h_sw[0]|h_sw[10]|h_sw[1]|h_sw[2]|h_sw[3]|h_sw[4]|h_sw[5]|h_sw[6]|h_sw[7]|h_sw[8]|h_sw[9]|l_sw[0]|l_sw[10]|l_sw[1]|l_sw[2]|l_sw[3]|l_sw[4]|l_sw[5]|l_sw[6]|l_sw[7]|l_sw[8]|l_sw[9]|out|pad|padres|vc|vcp|vdd|vddr|vip|vss|z
+ X|in_l_sw[3]|pl_sw[3]|x
+ BOTTOM|TOP|VGND|VSS|anode|cathode|core|h_sw[0]|h_sw[10]|h_sw[1]|h_sw[2]|h_sw[3]|h_sw[4]|h_sw[5]|h_sw[6]|h_sw[7]|h_sw[8]|h_sw[9]|l_sw[0]|l_sw[10]|l_sw[1]|l_sw[2]|l_sw[3]|l_sw[4]|l_sw[5]|l_sw[6]|l_sw[7]|l_sw[8]|l_sw[9]|out|pad|padres|vc|vcp|vdd|vddr|vip|vss|z
+ \$78069 sg13_lv_pmos L=0.13u W=8u AS=1.67p AD=1.67p PS=12.34u PD=12.34u
+ rfmode=0
M$3928
+ BOTTOM|TOP|VGND|VSS|anode|cathode|core|h_sw[0]|h_sw[10]|h_sw[1]|h_sw[2]|h_sw[3]|h_sw[4]|h_sw[5]|h_sw[6]|h_sw[7]|h_sw[8]|h_sw[9]|l_sw[0]|l_sw[10]|l_sw[1]|l_sw[2]|l_sw[3]|l_sw[4]|l_sw[5]|l_sw[6]|l_sw[7]|l_sw[8]|l_sw[9]|out|pad|padres|vc|vcp|vdd|vddr|vip|vss|z
+ X|in_l_sw[5]|pl_sw[5]|x
+ BOTTOM|TOP|VGND|VSS|anode|cathode|core|h_sw[0]|h_sw[10]|h_sw[1]|h_sw[2]|h_sw[3]|h_sw[4]|h_sw[5]|h_sw[6]|h_sw[7]|h_sw[8]|h_sw[9]|l_sw[0]|l_sw[10]|l_sw[1]|l_sw[2]|l_sw[3]|l_sw[4]|l_sw[5]|l_sw[6]|l_sw[7]|l_sw[8]|l_sw[9]|out|pad|padres|vc|vcp|vdd|vddr|vip|vss|z
+ \$78070 sg13_lv_pmos L=0.13u W=8u AS=1.67p AD=1.67p PS=12.34u PD=12.34u
+ rfmode=0
M$3936
+ BOTTOM|TOP|VGND|VSS|anode|cathode|core|h_sw[0]|h_sw[10]|h_sw[1]|h_sw[2]|h_sw[3]|h_sw[4]|h_sw[5]|h_sw[6]|h_sw[7]|h_sw[8]|h_sw[9]|l_sw[0]|l_sw[10]|l_sw[1]|l_sw[2]|l_sw[3]|l_sw[4]|l_sw[5]|l_sw[6]|l_sw[7]|l_sw[8]|l_sw[9]|out|pad|padres|vc|vcp|vdd|vddr|vip|vss|z
+ X|in_l_sw[6]|pl_sw[6]|x
+ BOTTOM|TOP|VGND|VSS|anode|cathode|core|h_sw[0]|h_sw[10]|h_sw[1]|h_sw[2]|h_sw[3]|h_sw[4]|h_sw[5]|h_sw[6]|h_sw[7]|h_sw[8]|h_sw[9]|l_sw[0]|l_sw[10]|l_sw[1]|l_sw[2]|l_sw[3]|l_sw[4]|l_sw[5]|l_sw[6]|l_sw[7]|l_sw[8]|l_sw[9]|out|pad|padres|vc|vcp|vdd|vddr|vip|vss|z
+ \$78070 sg13_lv_pmos L=0.13u W=4u AS=0.91p AD=0.91p PS=6.82u PD=6.82u rfmode=0
M$3940
+ BOTTOM|TOP|VGND|VSS|anode|cathode|core|h_sw[0]|h_sw[10]|h_sw[1]|h_sw[2]|h_sw[3]|h_sw[4]|h_sw[5]|h_sw[6]|h_sw[7]|h_sw[8]|h_sw[9]|l_sw[0]|l_sw[10]|l_sw[1]|l_sw[2]|l_sw[3]|l_sw[4]|l_sw[5]|l_sw[6]|l_sw[7]|l_sw[8]|l_sw[9]|out|pad|padres|vc|vcp|vdd|vddr|vip|vss|z
+ X|in_l_sw[7]|pl_sw[7]|x
+ BOTTOM|TOP|VGND|VSS|anode|cathode|core|h_sw[0]|h_sw[10]|h_sw[1]|h_sw[2]|h_sw[3]|h_sw[4]|h_sw[5]|h_sw[6]|h_sw[7]|h_sw[8]|h_sw[9]|l_sw[0]|l_sw[10]|l_sw[1]|l_sw[2]|l_sw[3]|l_sw[4]|l_sw[5]|l_sw[6]|l_sw[7]|l_sw[8]|l_sw[9]|out|pad|padres|vc|vcp|vdd|vddr|vip|vss|z
+ \$78657 sg13_lv_pmos L=0.13u W=4u AS=0.91p AD=0.91p PS=6.82u PD=6.82u rfmode=0
M$3944
+ BOTTOM|TOP|VGND|VSS|anode|cathode|core|h_sw[0]|h_sw[10]|h_sw[1]|h_sw[2]|h_sw[3]|h_sw[4]|h_sw[5]|h_sw[6]|h_sw[7]|h_sw[8]|h_sw[9]|l_sw[0]|l_sw[10]|l_sw[1]|l_sw[2]|l_sw[3]|l_sw[4]|l_sw[5]|l_sw[6]|l_sw[7]|l_sw[8]|l_sw[9]|out|pad|padres|vc|vcp|vdd|vddr|vip|vss|z
+ X|in_l_sw[9]|pl_sw[9]|x
+ BOTTOM|TOP|VGND|VSS|anode|cathode|core|h_sw[0]|h_sw[10]|h_sw[1]|h_sw[2]|h_sw[3]|h_sw[4]|h_sw[5]|h_sw[6]|h_sw[7]|h_sw[8]|h_sw[9]|l_sw[0]|l_sw[10]|l_sw[1]|l_sw[2]|l_sw[3]|l_sw[4]|l_sw[5]|l_sw[6]|l_sw[7]|l_sw[8]|l_sw[9]|out|pad|padres|vc|vcp|vdd|vddr|vip|vss|z
+ \$78956 sg13_lv_pmos L=0.13u W=2u AS=0.53p AD=0.53p PS=4.06u PD=4.06u rfmode=0
M$3946
+ BOTTOM|TOP|VGND|VSS|anode|cathode|core|h_sw[0]|h_sw[10]|h_sw[1]|h_sw[2]|h_sw[3]|h_sw[4]|h_sw[5]|h_sw[6]|h_sw[7]|h_sw[8]|h_sw[9]|l_sw[0]|l_sw[10]|l_sw[1]|l_sw[2]|l_sw[3]|l_sw[4]|l_sw[5]|l_sw[6]|l_sw[7]|l_sw[8]|l_sw[9]|out|pad|padres|vc|vcp|vdd|vddr|vip|vss|z
+ X|in_l_sw[8]|pl_sw[8]|x
+ BOTTOM|TOP|VGND|VSS|anode|cathode|core|h_sw[0]|h_sw[10]|h_sw[1]|h_sw[2]|h_sw[3]|h_sw[4]|h_sw[5]|h_sw[6]|h_sw[7]|h_sw[8]|h_sw[9]|l_sw[0]|l_sw[10]|l_sw[1]|l_sw[2]|l_sw[3]|l_sw[4]|l_sw[5]|l_sw[6]|l_sw[7]|l_sw[8]|l_sw[9]|out|pad|padres|vc|vcp|vdd|vddr|vip|vss|z
+ \$78657 sg13_lv_pmos L=0.13u W=2u AS=0.53p AD=0.53p PS=4.06u PD=4.06u rfmode=0
M$3948
+ BOTTOM|TOP|VGND|VSS|anode|cathode|core|h_sw[0]|h_sw[10]|h_sw[1]|h_sw[2]|h_sw[3]|h_sw[4]|h_sw[5]|h_sw[6]|h_sw[7]|h_sw[8]|h_sw[9]|l_sw[0]|l_sw[10]|l_sw[1]|l_sw[2]|l_sw[3]|l_sw[4]|l_sw[5]|l_sw[6]|l_sw[7]|l_sw[8]|l_sw[9]|out|pad|padres|vc|vcp|vdd|vddr|vip|vss|z
+ X|in_l_sw[10]|pl_sw[10]|x
+ BOTTOM|TOP|VGND|VSS|anode|cathode|core|h_sw[0]|h_sw[10]|h_sw[1]|h_sw[2]|h_sw[3]|h_sw[4]|h_sw[5]|h_sw[6]|h_sw[7]|h_sw[8]|h_sw[9]|l_sw[0]|l_sw[10]|l_sw[1]|l_sw[2]|l_sw[3]|l_sw[4]|l_sw[5]|l_sw[6]|l_sw[7]|l_sw[8]|l_sw[9]|out|pad|padres|vc|vcp|vdd|vddr|vip|vss|z
+ \$78956 sg13_lv_pmos L=0.13u W=1u AS=0.34p AD=0.34p PS=2.68u PD=2.68u rfmode=0
M$3949 cathode|iovdd \$34198 X|anode|cathode|core|d_out[0]|dout[0]|pad|padres
+ cathode|iovdd sg13_hv_pmos L=0.6u W=266.4u AS=123.21p AD=123.21p PS=316.72u
+ PD=316.72u rfmode=0
M$3969 cathode|iovdd \$34199 X|anode|cathode|core|d_out[1]|dout[1]|pad|padres
+ cathode|iovdd sg13_hv_pmos L=0.6u W=266.4u AS=123.21p AD=123.21p PS=316.72u
+ PD=316.72u rfmode=0
M$3989 cathode|iovdd \$34200 X|anode|cathode|core|d_out[2]|dout[2]|pad|padres
+ cathode|iovdd sg13_hv_pmos L=0.6u W=266.4u AS=123.21p AD=123.21p PS=316.72u
+ PD=316.72u rfmode=0
M$4009 cathode|iovdd \$34201 X|anode|cathode|cko|core|pad|padres cathode|iovdd
+ sg13_hv_pmos L=0.6u W=266.4u AS=123.21p AD=123.21p PS=316.72u PD=316.72u
+ rfmode=0
M$4029 cathode|iovdd \$34202 X|anode|cathode|core|frame|pad|padres
+ cathode|iovdd sg13_hv_pmos L=0.6u W=266.4u AS=123.21p AD=123.21p PS=316.72u
+ PD=316.72u rfmode=0
M$4149 cathode|iovdd \$62226 anode|cathode|core|in|pad|padres|vin cathode|iovdd
+ sg13_hv_pmos L=0.6u W=266.4u AS=123.21p AD=123.21p PS=316.72u PD=316.72u
+ rfmode=0
M$4169 cathode|iovdd \$51949
+ BOTTOM|TOP|VGND|VSS|anode|cathode|core|h_sw[0]|h_sw[10]|h_sw[1]|h_sw[2]|h_sw[3]|h_sw[4]|h_sw[5]|h_sw[6]|h_sw[7]|h_sw[8]|h_sw[9]|l_sw[0]|l_sw[10]|l_sw[1]|l_sw[2]|l_sw[3]|l_sw[4]|l_sw[5]|l_sw[6]|l_sw[7]|l_sw[8]|l_sw[9]|out|pad|padres|vc|vcp|vdd|vddr|vip|vss|z
+ cathode|iovdd sg13_hv_pmos L=0.6u W=266.4u AS=123.21p AD=123.21p PS=316.72u
+ PD=316.72u rfmode=0
M$4229 cathode|iovdd \$64278 anode|cathode|core|pad|padres$1 cathode|iovdd
+ sg13_hv_pmos L=0.6u W=266.4u AS=123.21p AD=123.21p PS=316.72u PD=316.72u
+ rfmode=0
M$4249 cathode|iovdd \$51950 anode|cathode|core|pad|padres cathode|iovdd
+ sg13_hv_pmos L=0.6u W=266.4u AS=123.21p AD=123.21p PS=316.72u PD=316.72u
+ rfmode=0
M$4309 cathode|iovdd \$77018 anode|cathode|core|in|pad|padres|vip cathode|iovdd
+ sg13_hv_pmos L=0.6u W=266.4u AS=123.21p AD=123.21p PS=316.72u PD=316.72u
+ rfmode=0
M$4349 cathode|iovdd \$77019 anode|cathode|core|pad|padres$2 cathode|iovdd
+ sg13_hv_pmos L=0.6u W=266.4u AS=123.21p AD=123.21p PS=316.72u PD=316.72u
+ rfmode=0
M$4389 cathode|iovdd \$89386 A|anode|cathode|ck|cks|core|pad|padres
+ cathode|iovdd sg13_hv_pmos L=0.6u W=266.4u AS=123.21p AD=123.21p PS=316.72u
+ PD=316.72u rfmode=0
M$4429 cathode|iovdd \$89387 anode|cathode|core|pad|padres$3 cathode|iovdd
+ sg13_hv_pmos L=0.6u W=266.4u AS=123.21p AD=123.21p PS=316.72u PD=316.72u
+ rfmode=0
M$4469 supply|vdd in|pad|pin1|pin2|vdd gate|out supply|vdd sg13_hv_pmos L=0.5u
+ W=350u AS=67.55p AD=67.55p PS=376.3u PD=376.3u rfmode=0
M$4519 cathode|iovdd \$124169 anode|cathode|core|pad|padres$4 cathode|iovdd
+ sg13_hv_pmos L=0.6u W=266.4u AS=123.21p AD=123.21p PS=316.72u PD=316.72u
+ rfmode=0
M$4539 cathode|iovdd \$124170 anode|cathode|core|pad|padres$5 cathode|iovdd
+ sg13_hv_pmos L=0.6u W=266.4u AS=123.21p AD=123.21p PS=316.72u PD=316.72u
+ rfmode=0
M$4559 cathode|iovdd \$124171 anode|cathode|core|pad|padres$6 cathode|iovdd
+ sg13_hv_pmos L=0.6u W=266.4u AS=123.21p AD=123.21p PS=316.72u PD=316.72u
+ rfmode=0
M$4579 cathode|iovdd \$124172 anode|cathode|core|pad|padres$7 cathode|iovdd
+ sg13_hv_pmos L=0.6u W=266.4u AS=123.21p AD=123.21p PS=316.72u PD=316.72u
+ rfmode=0
M$4599 cathode|iovdd \$124173 anode|cathode|core|pad|padres$8 cathode|iovdd
+ sg13_hv_pmos L=0.6u W=266.4u AS=123.21p AD=123.21p PS=316.72u PD=316.72u
+ rfmode=0
D$4719
+ BOTTOM|TOP|VGND|VSS|anode|cathode|core|h_sw[0]|h_sw[10]|h_sw[1]|h_sw[2]|h_sw[3]|h_sw[4]|h_sw[5]|h_sw[6]|h_sw[7]|h_sw[8]|h_sw[9]|l_sw[0]|l_sw[10]|l_sw[1]|l_sw[2]|l_sw[3]|l_sw[4]|l_sw[5]|l_sw[6]|l_sw[7]|l_sw[8]|l_sw[9]|out|pad|padres|vc|vcp|vdd|vddr|vip|vss|z
+ X|anode|cathode|core|d_out[0]|dout[0]|pad|padres dantenna A=35.0028p P=58.08u
+ m=2
D$4720
+ BOTTOM|TOP|VGND|VSS|anode|cathode|core|h_sw[0]|h_sw[10]|h_sw[1]|h_sw[2]|h_sw[3]|h_sw[4]|h_sw[5]|h_sw[6]|h_sw[7]|h_sw[8]|h_sw[9]|l_sw[0]|l_sw[10]|l_sw[1]|l_sw[2]|l_sw[3]|l_sw[4]|l_sw[5]|l_sw[6]|l_sw[7]|l_sw[8]|l_sw[9]|out|pad|padres|vc|vcp|vdd|vddr|vip|vss|z
+ X|anode|cathode|core|d_out[1]|dout[1]|pad|padres dantenna A=35.0028p P=58.08u
+ m=2
D$4721
+ BOTTOM|TOP|VGND|VSS|anode|cathode|core|h_sw[0]|h_sw[10]|h_sw[1]|h_sw[2]|h_sw[3]|h_sw[4]|h_sw[5]|h_sw[6]|h_sw[7]|h_sw[8]|h_sw[9]|l_sw[0]|l_sw[10]|l_sw[1]|l_sw[2]|l_sw[3]|l_sw[4]|l_sw[5]|l_sw[6]|l_sw[7]|l_sw[8]|l_sw[9]|out|pad|padres|vc|vcp|vdd|vddr|vip|vss|z
+ X|anode|cathode|core|d_out[2]|dout[2]|pad|padres dantenna A=35.0028p P=58.08u
+ m=2
D$4722
+ BOTTOM|TOP|VGND|VSS|anode|cathode|core|h_sw[0]|h_sw[10]|h_sw[1]|h_sw[2]|h_sw[3]|h_sw[4]|h_sw[5]|h_sw[6]|h_sw[7]|h_sw[8]|h_sw[9]|l_sw[0]|l_sw[10]|l_sw[1]|l_sw[2]|l_sw[3]|l_sw[4]|l_sw[5]|l_sw[6]|l_sw[7]|l_sw[8]|l_sw[9]|out|pad|padres|vc|vcp|vdd|vddr|vip|vss|z
+ X|anode|cathode|cko|core|pad|padres dantenna A=35.0028p P=58.08u m=2
D$4723
+ BOTTOM|TOP|VGND|VSS|anode|cathode|core|h_sw[0]|h_sw[10]|h_sw[1]|h_sw[2]|h_sw[3]|h_sw[4]|h_sw[5]|h_sw[6]|h_sw[7]|h_sw[8]|h_sw[9]|l_sw[0]|l_sw[10]|l_sw[1]|l_sw[2]|l_sw[3]|l_sw[4]|l_sw[5]|l_sw[6]|l_sw[7]|l_sw[8]|l_sw[9]|out|pad|padres|vc|vcp|vdd|vddr|vip|vss|z
+ X|anode|cathode|core|frame|pad|padres dantenna A=35.0028p P=58.08u m=2
D$4729
+ BOTTOM|TOP|VGND|VSS|anode|cathode|core|h_sw[0]|h_sw[10]|h_sw[1]|h_sw[2]|h_sw[3]|h_sw[4]|h_sw[5]|h_sw[6]|h_sw[7]|h_sw[8]|h_sw[9]|l_sw[0]|l_sw[10]|l_sw[1]|l_sw[2]|l_sw[3]|l_sw[4]|l_sw[5]|l_sw[6]|l_sw[7]|l_sw[8]|l_sw[9]|out|pad|padres|vc|vcp|vdd|vddr|vip|vss|z
+ X|anode|cathode|core|d_out[0]|dout[0]|pad|padres dantenna A=1.984p P=7.48u m=1
D$4730
+ BOTTOM|TOP|VGND|VSS|anode|cathode|core|h_sw[0]|h_sw[10]|h_sw[1]|h_sw[2]|h_sw[3]|h_sw[4]|h_sw[5]|h_sw[6]|h_sw[7]|h_sw[8]|h_sw[9]|l_sw[0]|l_sw[10]|l_sw[1]|l_sw[2]|l_sw[3]|l_sw[4]|l_sw[5]|l_sw[6]|l_sw[7]|l_sw[8]|l_sw[9]|out|pad|padres|vc|vcp|vdd|vddr|vip|vss|z
+ X|anode|cathode|core|d_out[1]|dout[1]|pad|padres dantenna A=1.984p P=7.48u m=1
D$4731
+ BOTTOM|TOP|VGND|VSS|anode|cathode|core|h_sw[0]|h_sw[10]|h_sw[1]|h_sw[2]|h_sw[3]|h_sw[4]|h_sw[5]|h_sw[6]|h_sw[7]|h_sw[8]|h_sw[9]|l_sw[0]|l_sw[10]|l_sw[1]|l_sw[2]|l_sw[3]|l_sw[4]|l_sw[5]|l_sw[6]|l_sw[7]|l_sw[8]|l_sw[9]|out|pad|padres|vc|vcp|vdd|vddr|vip|vss|z
+ X|anode|cathode|core|d_out[2]|dout[2]|pad|padres dantenna A=1.984p P=7.48u m=1
D$4732
+ BOTTOM|TOP|VGND|VSS|anode|cathode|core|h_sw[0]|h_sw[10]|h_sw[1]|h_sw[2]|h_sw[3]|h_sw[4]|h_sw[5]|h_sw[6]|h_sw[7]|h_sw[8]|h_sw[9]|l_sw[0]|l_sw[10]|l_sw[1]|l_sw[2]|l_sw[3]|l_sw[4]|l_sw[5]|l_sw[6]|l_sw[7]|l_sw[8]|l_sw[9]|out|pad|padres|vc|vcp|vdd|vddr|vip|vss|z
+ X|anode|cathode|cko|core|pad|padres dantenna A=1.984p P=7.48u m=1
D$4733
+ BOTTOM|TOP|VGND|VSS|anode|cathode|core|h_sw[0]|h_sw[10]|h_sw[1]|h_sw[2]|h_sw[3]|h_sw[4]|h_sw[5]|h_sw[6]|h_sw[7]|h_sw[8]|h_sw[9]|l_sw[0]|l_sw[10]|l_sw[1]|l_sw[2]|l_sw[3]|l_sw[4]|l_sw[5]|l_sw[6]|l_sw[7]|l_sw[8]|l_sw[9]|out|pad|padres|vc|vcp|vdd|vddr|vip|vss|z
+ X|anode|cathode|core|frame|pad|padres dantenna A=1.984p P=7.48u m=1
D$4736
+ BOTTOM|TOP|VGND|VSS|anode|cathode|core|h_sw[0]|h_sw[10]|h_sw[1]|h_sw[2]|h_sw[3]|h_sw[4]|h_sw[5]|h_sw[6]|h_sw[7]|h_sw[8]|h_sw[9]|l_sw[0]|l_sw[10]|l_sw[1]|l_sw[2]|l_sw[3]|l_sw[4]|l_sw[5]|l_sw[6]|l_sw[7]|l_sw[8]|l_sw[9]|out|pad|padres|vc|vcp|vdd|vddr|vip|vss|z
+ anode|cathode|core|pad|padres dantenna A=35.0028p P=58.08u m=2
D$4739
+ BOTTOM|TOP|VGND|VSS|anode|cathode|core|h_sw[0]|h_sw[10]|h_sw[1]|h_sw[2]|h_sw[3]|h_sw[4]|h_sw[5]|h_sw[6]|h_sw[7]|h_sw[8]|h_sw[9]|l_sw[0]|l_sw[10]|l_sw[1]|l_sw[2]|l_sw[3]|l_sw[4]|l_sw[5]|l_sw[6]|l_sw[7]|l_sw[8]|l_sw[9]|out|pad|padres|vc|vcp|vdd|vddr|vip|vss|z
+ anode|cathode|core|pad|padres dantenna A=1.984p P=7.48u m=1
D$4740
+ BOTTOM|TOP|VGND|VSS|anode|cathode|core|h_sw[0]|h_sw[10]|h_sw[1]|h_sw[2]|h_sw[3]|h_sw[4]|h_sw[5]|h_sw[6]|h_sw[7]|h_sw[8]|h_sw[9]|l_sw[0]|l_sw[10]|l_sw[1]|l_sw[2]|l_sw[3]|l_sw[4]|l_sw[5]|l_sw[6]|l_sw[7]|l_sw[8]|l_sw[9]|out|pad|padres|vc|vcp|vdd|vddr|vip|vss|z
+ anode|cathode|core|in|pad|padres|vin dantenna A=1.984p P=7.48u m=1
D$4741
+ BOTTOM|TOP|VGND|VSS|anode|cathode|core|h_sw[0]|h_sw[10]|h_sw[1]|h_sw[2]|h_sw[3]|h_sw[4]|h_sw[5]|h_sw[6]|h_sw[7]|h_sw[8]|h_sw[9]|l_sw[0]|l_sw[10]|l_sw[1]|l_sw[2]|l_sw[3]|l_sw[4]|l_sw[5]|l_sw[6]|l_sw[7]|l_sw[8]|l_sw[9]|out|pad|padres|vc|vcp|vdd|vddr|vip|vss|z
+ anode|cathode|core|in|pad|padres|vin dantenna A=35.0028p P=58.08u m=2
D$4743
+ BOTTOM|TOP|VGND|VSS|anode|cathode|core|h_sw[0]|h_sw[10]|h_sw[1]|h_sw[2]|h_sw[3]|h_sw[4]|h_sw[5]|h_sw[6]|h_sw[7]|h_sw[8]|h_sw[9]|l_sw[0]|l_sw[10]|l_sw[1]|l_sw[2]|l_sw[3]|l_sw[4]|l_sw[5]|l_sw[6]|l_sw[7]|l_sw[8]|l_sw[9]|out|pad|padres|vc|vcp|vdd|vddr|vip|vss|z
+ anode|cathode|core|pad|padres$1 dantenna A=35.0028p P=58.08u m=2
D$4745
+ BOTTOM|TOP|VGND|VSS|anode|cathode|core|h_sw[0]|h_sw[10]|h_sw[1]|h_sw[2]|h_sw[3]|h_sw[4]|h_sw[5]|h_sw[6]|h_sw[7]|h_sw[8]|h_sw[9]|l_sw[0]|l_sw[10]|l_sw[1]|l_sw[2]|l_sw[3]|l_sw[4]|l_sw[5]|l_sw[6]|l_sw[7]|l_sw[8]|l_sw[9]|out|pad|padres|vc|vcp|vdd|vddr|vip|vss|z
+ anode|cathode|core|in|pad|padres|vip dantenna A=35.0028p P=58.08u m=2
D$4747
+ BOTTOM|TOP|VGND|VSS|anode|cathode|core|h_sw[0]|h_sw[10]|h_sw[1]|h_sw[2]|h_sw[3]|h_sw[4]|h_sw[5]|h_sw[6]|h_sw[7]|h_sw[8]|h_sw[9]|l_sw[0]|l_sw[10]|l_sw[1]|l_sw[2]|l_sw[3]|l_sw[4]|l_sw[5]|l_sw[6]|l_sw[7]|l_sw[8]|l_sw[9]|out|pad|padres|vc|vcp|vdd|vddr|vip|vss|z
+ anode|cathode|core|pad|padres$1 dantenna A=1.984p P=7.48u m=1
D$4748
+ BOTTOM|TOP|VGND|VSS|anode|cathode|core|h_sw[0]|h_sw[10]|h_sw[1]|h_sw[2]|h_sw[3]|h_sw[4]|h_sw[5]|h_sw[6]|h_sw[7]|h_sw[8]|h_sw[9]|l_sw[0]|l_sw[10]|l_sw[1]|l_sw[2]|l_sw[3]|l_sw[4]|l_sw[5]|l_sw[6]|l_sw[7]|l_sw[8]|l_sw[9]|out|pad|padres|vc|vcp|vdd|vddr|vip|vss|z
+ anode|cathode|core|pad|padres$2 dantenna A=35.0028p P=58.08u m=2
D$4750
+ BOTTOM|TOP|VGND|VSS|anode|cathode|core|h_sw[0]|h_sw[10]|h_sw[1]|h_sw[2]|h_sw[3]|h_sw[4]|h_sw[5]|h_sw[6]|h_sw[7]|h_sw[8]|h_sw[9]|l_sw[0]|l_sw[10]|l_sw[1]|l_sw[2]|l_sw[3]|l_sw[4]|l_sw[5]|l_sw[6]|l_sw[7]|l_sw[8]|l_sw[9]|out|pad|padres|vc|vcp|vdd|vddr|vip|vss|z
+ A|anode|cathode|ck|cks|core|pad|padres dantenna A=1.984p P=7.48u m=1
D$4751
+ BOTTOM|TOP|VGND|VSS|anode|cathode|core|h_sw[0]|h_sw[10]|h_sw[1]|h_sw[2]|h_sw[3]|h_sw[4]|h_sw[5]|h_sw[6]|h_sw[7]|h_sw[8]|h_sw[9]|l_sw[0]|l_sw[10]|l_sw[1]|l_sw[2]|l_sw[3]|l_sw[4]|l_sw[5]|l_sw[6]|l_sw[7]|l_sw[8]|l_sw[9]|out|pad|padres|vc|vcp|vdd|vddr|vip|vss|z
+ anode|cathode|core|in|pad|padres|vip dantenna A=1.984p P=7.48u m=1
D$4752
+ BOTTOM|TOP|VGND|VSS|anode|cathode|core|h_sw[0]|h_sw[10]|h_sw[1]|h_sw[2]|h_sw[3]|h_sw[4]|h_sw[5]|h_sw[6]|h_sw[7]|h_sw[8]|h_sw[9]|l_sw[0]|l_sw[10]|l_sw[1]|l_sw[2]|l_sw[3]|l_sw[4]|l_sw[5]|l_sw[6]|l_sw[7]|l_sw[8]|l_sw[9]|out|pad|padres|vc|vcp|vdd|vddr|vip|vss|z
+ anode|cathode|core|pad|padres$2 dantenna A=1.984p P=7.48u m=1
D$4753
+ BOTTOM|TOP|VGND|VSS|anode|cathode|core|h_sw[0]|h_sw[10]|h_sw[1]|h_sw[2]|h_sw[3]|h_sw[4]|h_sw[5]|h_sw[6]|h_sw[7]|h_sw[8]|h_sw[9]|l_sw[0]|l_sw[10]|l_sw[1]|l_sw[2]|l_sw[3]|l_sw[4]|l_sw[5]|l_sw[6]|l_sw[7]|l_sw[8]|l_sw[9]|out|pad|padres|vc|vcp|vdd|vddr|vip|vss|z
+ A|anode|cathode|ck|cks|core|pad|padres dantenna A=35.0028p P=58.08u m=2
D$4755
+ BOTTOM|TOP|VGND|VSS|anode|cathode|core|h_sw[0]|h_sw[10]|h_sw[1]|h_sw[2]|h_sw[3]|h_sw[4]|h_sw[5]|h_sw[6]|h_sw[7]|h_sw[8]|h_sw[9]|l_sw[0]|l_sw[10]|l_sw[1]|l_sw[2]|l_sw[3]|l_sw[4]|l_sw[5]|l_sw[6]|l_sw[7]|l_sw[8]|l_sw[9]|out|pad|padres|vc|vcp|vdd|vddr|vip|vss|z
+ anode|cathode|core|pad|padres$3 dantenna A=35.0028p P=58.08u m=2
D$4757
+ BOTTOM|TOP|VGND|VSS|anode|cathode|core|h_sw[0]|h_sw[10]|h_sw[1]|h_sw[2]|h_sw[3]|h_sw[4]|h_sw[5]|h_sw[6]|h_sw[7]|h_sw[8]|h_sw[9]|l_sw[0]|l_sw[10]|l_sw[1]|l_sw[2]|l_sw[3]|l_sw[4]|l_sw[5]|l_sw[6]|l_sw[7]|l_sw[8]|l_sw[9]|out|pad|padres|vc|vcp|vdd|vddr|vip|vss|z
+ gate|out dantenna A=0.2304p P=1.92u m=1
D$4758
+ BOTTOM|TOP|VGND|VSS|anode|cathode|core|h_sw[0]|h_sw[10]|h_sw[1]|h_sw[2]|h_sw[3]|h_sw[4]|h_sw[5]|h_sw[6]|h_sw[7]|h_sw[8]|h_sw[9]|l_sw[0]|l_sw[10]|l_sw[1]|l_sw[2]|l_sw[3]|l_sw[4]|l_sw[5]|l_sw[6]|l_sw[7]|l_sw[8]|l_sw[9]|out|pad|padres|vc|vcp|vdd|vddr|vip|vss|z
+ anode|cathode|core|pad|padres$3 dantenna A=1.984p P=7.48u m=1
D$4759
+ BOTTOM|TOP|VGND|VSS|anode|cathode|core|h_sw[0]|h_sw[10]|h_sw[1]|h_sw[2]|h_sw[3]|h_sw[4]|h_sw[5]|h_sw[6]|h_sw[7]|h_sw[8]|h_sw[9]|l_sw[0]|l_sw[10]|l_sw[1]|l_sw[2]|l_sw[3]|l_sw[4]|l_sw[5]|l_sw[6]|l_sw[7]|l_sw[8]|l_sw[9]|out|pad|padres|vc|vcp|vdd|vddr|vip|vss|z
+ anode|cathode|vss dantenna A=35.0028p P=58.08u m=2
D$4761
+ BOTTOM|TOP|VGND|VSS|anode|cathode|core|h_sw[0]|h_sw[10]|h_sw[1]|h_sw[2]|h_sw[3]|h_sw[4]|h_sw[5]|h_sw[6]|h_sw[7]|h_sw[8]|h_sw[9]|l_sw[0]|l_sw[10]|l_sw[1]|l_sw[2]|l_sw[3]|l_sw[4]|l_sw[5]|l_sw[6]|l_sw[7]|l_sw[8]|l_sw[9]|out|pad|padres|vc|vcp|vdd|vddr|vip|vss|z
+ anode|cathode|core|pad|padres$4 dantenna A=1.984p P=7.48u m=1
D$4762
+ BOTTOM|TOP|VGND|VSS|anode|cathode|core|h_sw[0]|h_sw[10]|h_sw[1]|h_sw[2]|h_sw[3]|h_sw[4]|h_sw[5]|h_sw[6]|h_sw[7]|h_sw[8]|h_sw[9]|l_sw[0]|l_sw[10]|l_sw[1]|l_sw[2]|l_sw[3]|l_sw[4]|l_sw[5]|l_sw[6]|l_sw[7]|l_sw[8]|l_sw[9]|out|pad|padres|vc|vcp|vdd|vddr|vip|vss|z
+ anode|cathode|core|pad|padres$5 dantenna A=1.984p P=7.48u m=1
D$4763
+ BOTTOM|TOP|VGND|VSS|anode|cathode|core|h_sw[0]|h_sw[10]|h_sw[1]|h_sw[2]|h_sw[3]|h_sw[4]|h_sw[5]|h_sw[6]|h_sw[7]|h_sw[8]|h_sw[9]|l_sw[0]|l_sw[10]|l_sw[1]|l_sw[2]|l_sw[3]|l_sw[4]|l_sw[5]|l_sw[6]|l_sw[7]|l_sw[8]|l_sw[9]|out|pad|padres|vc|vcp|vdd|vddr|vip|vss|z
+ anode|cathode|core|pad|padres$6 dantenna A=1.984p P=7.48u m=1
D$4764
+ BOTTOM|TOP|VGND|VSS|anode|cathode|core|h_sw[0]|h_sw[10]|h_sw[1]|h_sw[2]|h_sw[3]|h_sw[4]|h_sw[5]|h_sw[6]|h_sw[7]|h_sw[8]|h_sw[9]|l_sw[0]|l_sw[10]|l_sw[1]|l_sw[2]|l_sw[3]|l_sw[4]|l_sw[5]|l_sw[6]|l_sw[7]|l_sw[8]|l_sw[9]|out|pad|padres|vc|vcp|vdd|vddr|vip|vss|z
+ anode|cathode|core|pad|padres$7 dantenna A=1.984p P=7.48u m=1
D$4765
+ BOTTOM|TOP|VGND|VSS|anode|cathode|core|h_sw[0]|h_sw[10]|h_sw[1]|h_sw[2]|h_sw[3]|h_sw[4]|h_sw[5]|h_sw[6]|h_sw[7]|h_sw[8]|h_sw[9]|l_sw[0]|l_sw[10]|l_sw[1]|l_sw[2]|l_sw[3]|l_sw[4]|l_sw[5]|l_sw[6]|l_sw[7]|l_sw[8]|l_sw[9]|out|pad|padres|vc|vcp|vdd|vddr|vip|vss|z
+ anode|cathode|core|pad|padres$8 dantenna A=1.984p P=7.48u m=1
D$4766
+ BOTTOM|TOP|VGND|VSS|anode|cathode|core|h_sw[0]|h_sw[10]|h_sw[1]|h_sw[2]|h_sw[3]|h_sw[4]|h_sw[5]|h_sw[6]|h_sw[7]|h_sw[8]|h_sw[9]|l_sw[0]|l_sw[10]|l_sw[1]|l_sw[2]|l_sw[3]|l_sw[4]|l_sw[5]|l_sw[6]|l_sw[7]|l_sw[8]|l_sw[9]|out|pad|padres|vc|vcp|vdd|vddr|vip|vss|z
+ anode|cathode|core|pad|padres$4 dantenna A=35.0028p P=58.08u m=2
D$4767
+ BOTTOM|TOP|VGND|VSS|anode|cathode|core|h_sw[0]|h_sw[10]|h_sw[1]|h_sw[2]|h_sw[3]|h_sw[4]|h_sw[5]|h_sw[6]|h_sw[7]|h_sw[8]|h_sw[9]|l_sw[0]|l_sw[10]|l_sw[1]|l_sw[2]|l_sw[3]|l_sw[4]|l_sw[5]|l_sw[6]|l_sw[7]|l_sw[8]|l_sw[9]|out|pad|padres|vc|vcp|vdd|vddr|vip|vss|z
+ anode|cathode|core|pad|padres$5 dantenna A=35.0028p P=58.08u m=2
D$4768
+ BOTTOM|TOP|VGND|VSS|anode|cathode|core|h_sw[0]|h_sw[10]|h_sw[1]|h_sw[2]|h_sw[3]|h_sw[4]|h_sw[5]|h_sw[6]|h_sw[7]|h_sw[8]|h_sw[9]|l_sw[0]|l_sw[10]|l_sw[1]|l_sw[2]|l_sw[3]|l_sw[4]|l_sw[5]|l_sw[6]|l_sw[7]|l_sw[8]|l_sw[9]|out|pad|padres|vc|vcp|vdd|vddr|vip|vss|z
+ anode|cathode|core|pad|padres$6 dantenna A=35.0028p P=58.08u m=2
D$4769
+ BOTTOM|TOP|VGND|VSS|anode|cathode|core|h_sw[0]|h_sw[10]|h_sw[1]|h_sw[2]|h_sw[3]|h_sw[4]|h_sw[5]|h_sw[6]|h_sw[7]|h_sw[8]|h_sw[9]|l_sw[0]|l_sw[10]|l_sw[1]|l_sw[2]|l_sw[3]|l_sw[4]|l_sw[5]|l_sw[6]|l_sw[7]|l_sw[8]|l_sw[9]|out|pad|padres|vc|vcp|vdd|vddr|vip|vss|z
+ anode|cathode|core|pad|padres$7 dantenna A=35.0028p P=58.08u m=2
D$4770
+ BOTTOM|TOP|VGND|VSS|anode|cathode|core|h_sw[0]|h_sw[10]|h_sw[1]|h_sw[2]|h_sw[3]|h_sw[4]|h_sw[5]|h_sw[6]|h_sw[7]|h_sw[8]|h_sw[9]|l_sw[0]|l_sw[10]|l_sw[1]|l_sw[2]|l_sw[3]|l_sw[4]|l_sw[5]|l_sw[6]|l_sw[7]|l_sw[8]|l_sw[9]|out|pad|padres|vc|vcp|vdd|vddr|vip|vss|z
+ anode|cathode|core|pad|padres$8 dantenna A=35.0028p P=58.08u m=2
D$4776 X|anode|cathode|core|d_out[0]|dout[0]|pad|padres cathode|iovdd dpantenna
+ A=35.0028p P=58.08u m=2
D$4777 X|anode|cathode|core|d_out[1]|dout[1]|pad|padres cathode|iovdd dpantenna
+ A=35.0028p P=58.08u m=2
D$4778 X|anode|cathode|core|d_out[2]|dout[2]|pad|padres cathode|iovdd dpantenna
+ A=35.0028p P=58.08u m=2
D$4779 X|anode|cathode|cko|core|pad|padres cathode|iovdd dpantenna A=35.0028p
+ P=58.08u m=2
D$4780 X|anode|cathode|core|frame|pad|padres cathode|iovdd dpantenna A=35.0028p
+ P=58.08u m=2
D$4786 X|anode|cathode|core|d_out[0]|dout[0]|pad|padres cathode|iovdd dpantenna
+ A=3.1872p P=11.24u m=1
D$4787 X|anode|cathode|core|d_out[1]|dout[1]|pad|padres cathode|iovdd dpantenna
+ A=3.1872p P=11.24u m=1
D$4788 X|anode|cathode|core|d_out[2]|dout[2]|pad|padres cathode|iovdd dpantenna
+ A=3.1872p P=11.24u m=1
D$4789 X|anode|cathode|cko|core|pad|padres cathode|iovdd dpantenna A=3.1872p
+ P=11.24u m=1
D$4790 X|anode|cathode|core|frame|pad|padres cathode|iovdd dpantenna A=3.1872p
+ P=11.24u m=1
D$4791
+ BOTTOM|TOP|VGND|VSS|anode|cathode|core|h_sw[0]|h_sw[10]|h_sw[1]|h_sw[2]|h_sw[3]|h_sw[4]|h_sw[5]|h_sw[6]|h_sw[7]|h_sw[8]|h_sw[9]|l_sw[0]|l_sw[10]|l_sw[1]|l_sw[2]|l_sw[3]|l_sw[4]|l_sw[5]|l_sw[6]|l_sw[7]|l_sw[8]|l_sw[9]|out|pad|padres|vc|vcp|vdd|vddr|vip|vss|z
+ cathode|iovdd dpantenna A=35.0028p P=58.08u m=2
D$4793
+ BOTTOM|TOP|VGND|VSS|anode|cathode|core|h_sw[0]|h_sw[10]|h_sw[1]|h_sw[2]|h_sw[3]|h_sw[4]|h_sw[5]|h_sw[6]|h_sw[7]|h_sw[8]|h_sw[9]|l_sw[0]|l_sw[10]|l_sw[1]|l_sw[2]|l_sw[3]|l_sw[4]|l_sw[5]|l_sw[6]|l_sw[7]|l_sw[8]|l_sw[9]|out|pad|padres|vc|vcp|vdd|vddr|vip|vss|z
+ cathode|iovdd dpantenna A=3.1872p P=11.24u m=1
D$4794 anode|cathode|core|pad|padres cathode|iovdd dpantenna A=3.1872p P=11.24u
+ m=1
D$4795 anode|cathode|core|pad|padres cathode|iovdd dpantenna A=35.0028p
+ P=58.08u m=2
D$4797 anode|cathode|core|in|pad|padres|vin cathode|iovdd dpantenna A=35.0028p
+ P=58.08u m=2
D$4799 anode|cathode|core|in|pad|padres|vin cathode|iovdd dpantenna A=3.1872p
+ P=11.24u m=1
D$4800 anode|cathode|core|pad|padres$1 cathode|iovdd dpantenna A=3.1872p
+ P=11.24u m=1
D$4801 anode|cathode|core|pad|padres$1 cathode|iovdd dpantenna A=35.0028p
+ P=58.08u m=2
D$4803 anode|cathode|core|in|pad|padres|vip cathode|iovdd dpantenna A=35.0028p
+ P=58.08u m=2
D$4805 anode|cathode|core|in|pad|padres|vip cathode|iovdd dpantenna A=3.1872p
+ P=11.24u m=1
D$4806 anode|cathode|core|pad|padres$2 cathode|iovdd dpantenna A=3.1872p
+ P=11.24u m=1
D$4807 anode|cathode|core|pad|padres$2 cathode|iovdd dpantenna A=35.0028p
+ P=58.08u m=2
D$4809 A|anode|cathode|ck|cks|core|pad|padres cathode|iovdd dpantenna
+ A=35.0028p P=58.08u m=2
D$4811 A|anode|cathode|ck|cks|core|pad|padres cathode|iovdd dpantenna A=3.1872p
+ P=11.24u m=1
D$4812 anode|cathode|core|pad|padres$3 cathode|iovdd dpantenna A=3.1872p
+ P=11.24u m=1
D$4813 anode|cathode|core|pad|padres$3 cathode|iovdd dpantenna A=35.0028p
+ P=58.08u m=2
D$4815 anode|cathode|core|pad|padres$4 cathode|iovdd dpantenna A=3.1872p
+ P=11.24u m=1
D$4816 anode|cathode|core|pad|padres$5 cathode|iovdd dpantenna A=3.1872p
+ P=11.24u m=1
D$4817 anode|cathode|core|pad|padres$6 cathode|iovdd dpantenna A=3.1872p
+ P=11.24u m=1
D$4818 anode|cathode|core|pad|padres$7 cathode|iovdd dpantenna A=3.1872p
+ P=11.24u m=1
D$4819 anode|cathode|core|pad|padres$8 cathode|iovdd dpantenna A=3.1872p
+ P=11.24u m=1
D$4820 anode|cathode|vss cathode|iovdd dpantenna A=35.0028p P=58.08u m=2
D$4822 anode|cathode|core|pad|padres$4 cathode|iovdd dpantenna A=35.0028p
+ P=58.08u m=2
D$4823 anode|cathode|core|pad|padres$5 cathode|iovdd dpantenna A=35.0028p
+ P=58.08u m=2
D$4824 anode|cathode|core|pad|padres$6 cathode|iovdd dpantenna A=35.0028p
+ P=58.08u m=2
D$4825 anode|cathode|core|pad|padres$7 cathode|iovdd dpantenna A=35.0028p
+ P=58.08u m=2
D$4826 anode|cathode|core|pad|padres$8 cathode|iovdd dpantenna A=35.0028p
+ P=58.08u m=2
R$4832 anode|guard|iovss \$26896
+ BOTTOM|TOP|VGND|VSS|anode|cathode|core|h_sw[0]|h_sw[10]|h_sw[1]|h_sw[2]|h_sw[3]|h_sw[4]|h_sw[5]|h_sw[6]|h_sw[7]|h_sw[8]|h_sw[9]|l_sw[0]|l_sw[10]|l_sw[1]|l_sw[2]|l_sw[3]|l_sw[4]|l_sw[5]|l_sw[6]|l_sw[7]|l_sw[8]|l_sw[9]|out|pad|padres|vc|vcp|vdd|vddr|vip|vss|z
+ rppd w=0.5u l=3.54u ps=0u b=0 m=1
R$4833 anode|guard|iovss \$26897
+ BOTTOM|TOP|VGND|VSS|anode|cathode|core|h_sw[0]|h_sw[10]|h_sw[1]|h_sw[2]|h_sw[3]|h_sw[4]|h_sw[5]|h_sw[6]|h_sw[7]|h_sw[8]|h_sw[9]|l_sw[0]|l_sw[10]|l_sw[1]|l_sw[2]|l_sw[3]|l_sw[4]|l_sw[5]|l_sw[6]|l_sw[7]|l_sw[8]|l_sw[9]|out|pad|padres|vc|vcp|vdd|vddr|vip|vss|z
+ rppd w=0.5u l=3.54u ps=0u b=0 m=1
R$4834 anode|guard|iovss \$26898
+ BOTTOM|TOP|VGND|VSS|anode|cathode|core|h_sw[0]|h_sw[10]|h_sw[1]|h_sw[2]|h_sw[3]|h_sw[4]|h_sw[5]|h_sw[6]|h_sw[7]|h_sw[8]|h_sw[9]|l_sw[0]|l_sw[10]|l_sw[1]|l_sw[2]|l_sw[3]|l_sw[4]|l_sw[5]|l_sw[6]|l_sw[7]|l_sw[8]|l_sw[9]|out|pad|padres|vc|vcp|vdd|vddr|vip|vss|z
+ rppd w=0.5u l=3.54u ps=0u b=0 m=1
R$4835 anode|guard|iovss \$26899
+ BOTTOM|TOP|VGND|VSS|anode|cathode|core|h_sw[0]|h_sw[10]|h_sw[1]|h_sw[2]|h_sw[3]|h_sw[4]|h_sw[5]|h_sw[6]|h_sw[7]|h_sw[8]|h_sw[9]|l_sw[0]|l_sw[10]|l_sw[1]|l_sw[2]|l_sw[3]|l_sw[4]|l_sw[5]|l_sw[6]|l_sw[7]|l_sw[8]|l_sw[9]|out|pad|padres|vc|vcp|vdd|vddr|vip|vss|z
+ rppd w=0.5u l=3.54u ps=0u b=0 m=1
R$4836 anode|guard|iovss \$26900
+ BOTTOM|TOP|VGND|VSS|anode|cathode|core|h_sw[0]|h_sw[10]|h_sw[1]|h_sw[2]|h_sw[3]|h_sw[4]|h_sw[5]|h_sw[6]|h_sw[7]|h_sw[8]|h_sw[9]|l_sw[0]|l_sw[10]|l_sw[1]|l_sw[2]|l_sw[3]|l_sw[4]|l_sw[5]|l_sw[6]|l_sw[7]|l_sw[8]|l_sw[9]|out|pad|padres|vc|vcp|vdd|vddr|vip|vss|z
+ rppd w=0.5u l=3.54u ps=0u b=0 m=1
R$4837 cathode|iovdd \$34198 cathode|iovdd rppd w=0.5u l=12.9u ps=0u b=0 m=1
R$4838 cathode|iovdd \$34199 cathode|iovdd rppd w=0.5u l=12.9u ps=0u b=0 m=1
R$4839 cathode|iovdd \$34200 cathode|iovdd rppd w=0.5u l=12.9u ps=0u b=0 m=1
R$4840 cathode|iovdd \$34201 cathode|iovdd rppd w=0.5u l=12.9u ps=0u b=0 m=1
R$4841 cathode|iovdd \$34202 cathode|iovdd rppd w=0.5u l=12.9u ps=0u b=0 m=1
R$4842 anode|guard|iovss \$51948
+ BOTTOM|TOP|VGND|VSS|anode|cathode|core|h_sw[0]|h_sw[10]|h_sw[1]|h_sw[2]|h_sw[3]|h_sw[4]|h_sw[5]|h_sw[6]|h_sw[7]|h_sw[8]|h_sw[9]|l_sw[0]|l_sw[10]|l_sw[1]|l_sw[2]|l_sw[3]|l_sw[4]|l_sw[5]|l_sw[6]|l_sw[7]|l_sw[8]|l_sw[9]|out|pad|padres|vc|vcp|vdd|vddr|vip|vss|z
+ rppd w=0.5u l=3.54u ps=0u b=0 m=1
R$4843 cathode|iovdd \$51949 cathode|iovdd rppd w=0.5u l=12.9u ps=0u b=0 m=1
R$4844 \$51950 cathode|iovdd cathode|iovdd rppd w=0.5u l=12.9u ps=0u b=0 m=1
R$4845 \$51951 anode|guard|iovss
+ BOTTOM|TOP|VGND|VSS|anode|cathode|core|h_sw[0]|h_sw[10]|h_sw[1]|h_sw[2]|h_sw[3]|h_sw[4]|h_sw[5]|h_sw[6]|h_sw[7]|h_sw[8]|h_sw[9]|l_sw[0]|l_sw[10]|l_sw[1]|l_sw[2]|l_sw[3]|l_sw[4]|l_sw[5]|l_sw[6]|l_sw[7]|l_sw[8]|l_sw[9]|out|pad|padres|vc|vcp|vdd|vddr|vip|vss|z
+ rppd w=0.5u l=3.54u ps=0u b=0 m=1
R$4846 anode|guard|iovss \$62225
+ BOTTOM|TOP|VGND|VSS|anode|cathode|core|h_sw[0]|h_sw[10]|h_sw[1]|h_sw[2]|h_sw[3]|h_sw[4]|h_sw[5]|h_sw[6]|h_sw[7]|h_sw[8]|h_sw[9]|l_sw[0]|l_sw[10]|l_sw[1]|l_sw[2]|l_sw[3]|l_sw[4]|l_sw[5]|l_sw[6]|l_sw[7]|l_sw[8]|l_sw[9]|out|pad|padres|vc|vcp|vdd|vddr|vip|vss|z
+ rppd w=0.5u l=3.54u ps=0u b=0 m=1
R$4847 cathode|iovdd \$62226 cathode|iovdd rppd w=0.5u l=12.9u ps=0u b=0 m=1
R$4848 \$64278 cathode|iovdd cathode|iovdd rppd w=0.5u l=12.9u ps=0u b=0 m=1
R$4849 \$64279 anode|guard|iovss
+ BOTTOM|TOP|VGND|VSS|anode|cathode|core|h_sw[0]|h_sw[10]|h_sw[1]|h_sw[2]|h_sw[3]|h_sw[4]|h_sw[5]|h_sw[6]|h_sw[7]|h_sw[8]|h_sw[9]|l_sw[0]|l_sw[10]|l_sw[1]|l_sw[2]|l_sw[3]|l_sw[4]|l_sw[5]|l_sw[6]|l_sw[7]|l_sw[8]|l_sw[9]|out|pad|padres|vc|vcp|vdd|vddr|vip|vss|z
+ rppd w=0.5u l=3.54u ps=0u b=0 m=1
R$4850 anode|guard|iovss \$77017
+ BOTTOM|TOP|VGND|VSS|anode|cathode|core|h_sw[0]|h_sw[10]|h_sw[1]|h_sw[2]|h_sw[3]|h_sw[4]|h_sw[5]|h_sw[6]|h_sw[7]|h_sw[8]|h_sw[9]|l_sw[0]|l_sw[10]|l_sw[1]|l_sw[2]|l_sw[3]|l_sw[4]|l_sw[5]|l_sw[6]|l_sw[7]|l_sw[8]|l_sw[9]|out|pad|padres|vc|vcp|vdd|vddr|vip|vss|z
+ rppd w=0.5u l=3.54u ps=0u b=0 m=1
R$4851 cathode|iovdd \$77018 cathode|iovdd rppd w=0.5u l=12.9u ps=0u b=0 m=1
R$4852 \$77019 cathode|iovdd cathode|iovdd rppd w=0.5u l=12.9u ps=0u b=0 m=1
R$4853 \$77020 anode|guard|iovss
+ BOTTOM|TOP|VGND|VSS|anode|cathode|core|h_sw[0]|h_sw[10]|h_sw[1]|h_sw[2]|h_sw[3]|h_sw[4]|h_sw[5]|h_sw[6]|h_sw[7]|h_sw[8]|h_sw[9]|l_sw[0]|l_sw[10]|l_sw[1]|l_sw[2]|l_sw[3]|l_sw[4]|l_sw[5]|l_sw[6]|l_sw[7]|l_sw[8]|l_sw[9]|out|pad|padres|vc|vcp|vdd|vddr|vip|vss|z
+ rppd w=0.5u l=3.54u ps=0u b=0 m=1
R$4854 anode|guard|iovss \$87182
+ BOTTOM|TOP|VGND|VSS|anode|cathode|core|h_sw[0]|h_sw[10]|h_sw[1]|h_sw[2]|h_sw[3]|h_sw[4]|h_sw[5]|h_sw[6]|h_sw[7]|h_sw[8]|h_sw[9]|l_sw[0]|l_sw[10]|l_sw[1]|l_sw[2]|l_sw[3]|l_sw[4]|l_sw[5]|l_sw[6]|l_sw[7]|l_sw[8]|l_sw[9]|out|pad|padres|vc|vcp|vdd|vddr|vip|vss|z
+ rppd w=0.5u l=3.54u ps=0u b=0 m=1
R$4855 cathode|iovdd \$89386 cathode|iovdd rppd w=0.5u l=12.9u ps=0u b=0 m=1
R$4856 \$89387 cathode|iovdd cathode|iovdd rppd w=0.5u l=12.9u ps=0u b=0 m=1
R$4857 \$89388 anode|guard|iovss
+ BOTTOM|TOP|VGND|VSS|anode|cathode|core|h_sw[0]|h_sw[10]|h_sw[1]|h_sw[2]|h_sw[3]|h_sw[4]|h_sw[5]|h_sw[6]|h_sw[7]|h_sw[8]|h_sw[9]|l_sw[0]|l_sw[10]|l_sw[1]|l_sw[2]|l_sw[3]|l_sw[4]|l_sw[5]|l_sw[6]|l_sw[7]|l_sw[8]|l_sw[9]|out|pad|padres|vc|vcp|vdd|vddr|vip|vss|z
+ rppd w=0.5u l=3.54u ps=0u b=0 m=1
R$4858 \$124169 cathode|iovdd cathode|iovdd rppd w=0.5u l=12.9u ps=0u b=0 m=1
R$4859 \$124170 cathode|iovdd cathode|iovdd rppd w=0.5u l=12.9u ps=0u b=0 m=1
R$4860 \$124171 cathode|iovdd cathode|iovdd rppd w=0.5u l=12.9u ps=0u b=0 m=1
R$4861 \$124172 cathode|iovdd cathode|iovdd rppd w=0.5u l=12.9u ps=0u b=0 m=1
R$4862 \$124173 cathode|iovdd cathode|iovdd rppd w=0.5u l=12.9u ps=0u b=0 m=1
R$4863 \$132615 anode|guard|iovss
+ BOTTOM|TOP|VGND|VSS|anode|cathode|core|h_sw[0]|h_sw[10]|h_sw[1]|h_sw[2]|h_sw[3]|h_sw[4]|h_sw[5]|h_sw[6]|h_sw[7]|h_sw[8]|h_sw[9]|l_sw[0]|l_sw[10]|l_sw[1]|l_sw[2]|l_sw[3]|l_sw[4]|l_sw[5]|l_sw[6]|l_sw[7]|l_sw[8]|l_sw[9]|out|pad|padres|vc|vcp|vdd|vddr|vip|vss|z
+ rppd w=0.5u l=3.54u ps=0u b=0 m=1
R$4864 \$132616 anode|guard|iovss
+ BOTTOM|TOP|VGND|VSS|anode|cathode|core|h_sw[0]|h_sw[10]|h_sw[1]|h_sw[2]|h_sw[3]|h_sw[4]|h_sw[5]|h_sw[6]|h_sw[7]|h_sw[8]|h_sw[9]|l_sw[0]|l_sw[10]|l_sw[1]|l_sw[2]|l_sw[3]|l_sw[4]|l_sw[5]|l_sw[6]|l_sw[7]|l_sw[8]|l_sw[9]|out|pad|padres|vc|vcp|vdd|vddr|vip|vss|z
+ rppd w=0.5u l=3.54u ps=0u b=0 m=1
R$4865 \$132617 anode|guard|iovss
+ BOTTOM|TOP|VGND|VSS|anode|cathode|core|h_sw[0]|h_sw[10]|h_sw[1]|h_sw[2]|h_sw[3]|h_sw[4]|h_sw[5]|h_sw[6]|h_sw[7]|h_sw[8]|h_sw[9]|l_sw[0]|l_sw[10]|l_sw[1]|l_sw[2]|l_sw[3]|l_sw[4]|l_sw[5]|l_sw[6]|l_sw[7]|l_sw[8]|l_sw[9]|out|pad|padres|vc|vcp|vdd|vddr|vip|vss|z
+ rppd w=0.5u l=3.54u ps=0u b=0 m=1
R$4866 \$132618 anode|guard|iovss
+ BOTTOM|TOP|VGND|VSS|anode|cathode|core|h_sw[0]|h_sw[10]|h_sw[1]|h_sw[2]|h_sw[3]|h_sw[4]|h_sw[5]|h_sw[6]|h_sw[7]|h_sw[8]|h_sw[9]|l_sw[0]|l_sw[10]|l_sw[1]|l_sw[2]|l_sw[3]|l_sw[4]|l_sw[5]|l_sw[6]|l_sw[7]|l_sw[8]|l_sw[9]|out|pad|padres|vc|vcp|vdd|vddr|vip|vss|z
+ rppd w=0.5u l=3.54u ps=0u b=0 m=1
R$4867 \$132619 anode|guard|iovss
+ BOTTOM|TOP|VGND|VSS|anode|cathode|core|h_sw[0]|h_sw[10]|h_sw[1]|h_sw[2]|h_sw[3]|h_sw[4]|h_sw[5]|h_sw[6]|h_sw[7]|h_sw[8]|h_sw[9]|l_sw[0]|l_sw[10]|l_sw[1]|l_sw[2]|l_sw[3]|l_sw[4]|l_sw[5]|l_sw[6]|l_sw[7]|l_sw[8]|l_sw[9]|out|pad|padres|vc|vcp|vdd|vddr|vip|vss|z
+ rppd w=0.5u l=3.54u ps=0u b=0 m=1
C$4869 \$66428 \$67665 cap_mfringe w=40u l=10u A=0p P=0u m=1
C$4870 A|Y \$67905 cap_mfringe w=8u l=8u A=0p P=0u m=1
C$4871 Y \$67908 cap_mfringe w=8u l=8u A=0p P=0u m=1
C$4872 Y$3 \$73056 cap_mfringe w=8u l=8u A=0p P=0u m=1
C$4873 A|Y$28 \$73055 cap_mfringe w=8u l=8u A=0p P=0u m=1
C$4874 \$73904 \$77595 cap_mfringe w=40u l=10u A=0p P=0u m=1
R$4876
+ BOTTOM|TOP|VGND|VSS|anode|cathode|core|h_sw[0]|h_sw[10]|h_sw[1]|h_sw[2]|h_sw[3]|h_sw[4]|h_sw[5]|h_sw[6]|h_sw[7]|h_sw[8]|h_sw[9]|l_sw[0]|l_sw[10]|l_sw[1]|l_sw[2]|l_sw[3]|l_sw[4]|l_sw[5]|l_sw[6]|l_sw[7]|l_sw[8]|l_sw[9]|out|pad|padres|vc|vcp|vdd|vddr|vip|vss|z
+ \$64988 ntap1 A=26.712p P=178.08u
R$4878
+ BOTTOM|TOP|VGND|VSS|anode|cathode|core|h_sw[0]|h_sw[10]|h_sw[1]|h_sw[2]|h_sw[3]|h_sw[4]|h_sw[5]|h_sw[6]|h_sw[7]|h_sw[8]|h_sw[9]|l_sw[0]|l_sw[10]|l_sw[1]|l_sw[2]|l_sw[3]|l_sw[4]|l_sw[5]|l_sw[6]|l_sw[7]|l_sw[8]|l_sw[9]|out|pad|padres|vc|vcp|vdd|vddr|vip|vss|z
+ \$64989 ntap1 A=16.92p P=112.8u
R$4880
+ BOTTOM|TOP|VGND|VSS|anode|cathode|core|h_sw[0]|h_sw[10]|h_sw[1]|h_sw[2]|h_sw[3]|h_sw[4]|h_sw[5]|h_sw[6]|h_sw[7]|h_sw[8]|h_sw[9]|l_sw[0]|l_sw[10]|l_sw[1]|l_sw[2]|l_sw[3]|l_sw[4]|l_sw[5]|l_sw[6]|l_sw[7]|l_sw[8]|l_sw[9]|out|pad|padres|vc|vcp|vdd|vddr|vip|vss|z
+ \$64990 ntap1 A=16.92p P=112.8u
R$4882
+ BOTTOM|TOP|VGND|VSS|anode|cathode|core|h_sw[0]|h_sw[10]|h_sw[1]|h_sw[2]|h_sw[3]|h_sw[4]|h_sw[5]|h_sw[6]|h_sw[7]|h_sw[8]|h_sw[9]|l_sw[0]|l_sw[10]|l_sw[1]|l_sw[2]|l_sw[3]|l_sw[4]|l_sw[5]|l_sw[6]|l_sw[7]|l_sw[8]|l_sw[9]|out|pad|padres|vc|vcp|vdd|vddr|vip|vss|z
+ \$64991 ntap1 A=24.048p P=160.32u
R$4886
+ BOTTOM|TOP|VGND|VSS|anode|cathode|core|h_sw[0]|h_sw[10]|h_sw[1]|h_sw[2]|h_sw[3]|h_sw[4]|h_sw[5]|h_sw[6]|h_sw[7]|h_sw[8]|h_sw[9]|l_sw[0]|l_sw[10]|l_sw[1]|l_sw[2]|l_sw[3]|l_sw[4]|l_sw[5]|l_sw[6]|l_sw[7]|l_sw[8]|l_sw[9]|out|pad|padres|vc|vcp|vdd|vddr|vip|vss|z
+ \$64992 ntap1 A=21.6p P=144u
R$4890
+ BOTTOM|TOP|VGND|VSS|anode|cathode|core|h_sw[0]|h_sw[10]|h_sw[1]|h_sw[2]|h_sw[3]|h_sw[4]|h_sw[5]|h_sw[6]|h_sw[7]|h_sw[8]|h_sw[9]|l_sw[0]|l_sw[10]|l_sw[1]|l_sw[2]|l_sw[3]|l_sw[4]|l_sw[5]|l_sw[6]|l_sw[7]|l_sw[8]|l_sw[9]|out|pad|padres|vc|vcp|vdd|vddr|vip|vss|z
+ \$64993 ntap1 A=17.928p P=119.52u
R$4894
+ BOTTOM|TOP|VGND|VSS|anode|cathode|core|h_sw[0]|h_sw[10]|h_sw[1]|h_sw[2]|h_sw[3]|h_sw[4]|h_sw[5]|h_sw[6]|h_sw[7]|h_sw[8]|h_sw[9]|l_sw[0]|l_sw[10]|l_sw[1]|l_sw[2]|l_sw[3]|l_sw[4]|l_sw[5]|l_sw[6]|l_sw[7]|l_sw[8]|l_sw[9]|out|pad|padres|vc|vcp|vdd|vddr|vip|vss|z
+ \$64994 ntap1 A=16.092p P=107.28u
R$4898 \$66428 \$70878 ntap1 A=3.57p P=23.8u
R$4899 VDD|VPWR|vdd \$71889 ntap1 A=4.578p P=31.12u
R$4901 VDD|VPWR|vdd \$72817 ntap1 A=4.578p P=31.12u
R$4903 VDD|VPWR|vdd \$73544 ntap1 A=33.083p P=187.86u
R$4907 \$73904 \$73903 ntap1 A=3.57p P=23.8u
R$4908
+ BOTTOM|TOP|VGND|VSS|anode|cathode|core|h_sw[0]|h_sw[10]|h_sw[1]|h_sw[2]|h_sw[3]|h_sw[4]|h_sw[5]|h_sw[6]|h_sw[7]|h_sw[8]|h_sw[9]|l_sw[0]|l_sw[10]|l_sw[1]|l_sw[2]|l_sw[3]|l_sw[4]|l_sw[5]|l_sw[6]|l_sw[7]|l_sw[8]|l_sw[9]|out|pad|padres|vc|vcp|vdd|vddr|vip|vss|z
+ \$77307 ntap1 A=26.712p P=178.08u
R$4910
+ BOTTOM|TOP|VGND|VSS|anode|cathode|core|h_sw[0]|h_sw[10]|h_sw[1]|h_sw[2]|h_sw[3]|h_sw[4]|h_sw[5]|h_sw[6]|h_sw[7]|h_sw[8]|h_sw[9]|l_sw[0]|l_sw[10]|l_sw[1]|l_sw[2]|l_sw[3]|l_sw[4]|l_sw[5]|l_sw[6]|l_sw[7]|l_sw[8]|l_sw[9]|out|pad|padres|vc|vcp|vdd|vddr|vip|vss|z
+ \$78069 ntap1 A=24.048p P=160.32u
R$4914
+ BOTTOM|TOP|VGND|VSS|anode|cathode|core|h_sw[0]|h_sw[10]|h_sw[1]|h_sw[2]|h_sw[3]|h_sw[4]|h_sw[5]|h_sw[6]|h_sw[7]|h_sw[8]|h_sw[9]|l_sw[0]|l_sw[10]|l_sw[1]|l_sw[2]|l_sw[3]|l_sw[4]|l_sw[5]|l_sw[6]|l_sw[7]|l_sw[8]|l_sw[9]|out|pad|padres|vc|vcp|vdd|vddr|vip|vss|z
+ \$78070 ntap1 A=21.6p P=144u
R$4918
+ BOTTOM|TOP|VGND|VSS|anode|cathode|core|h_sw[0]|h_sw[10]|h_sw[1]|h_sw[2]|h_sw[3]|h_sw[4]|h_sw[5]|h_sw[6]|h_sw[7]|h_sw[8]|h_sw[9]|l_sw[0]|l_sw[10]|l_sw[1]|l_sw[2]|l_sw[3]|l_sw[4]|l_sw[5]|l_sw[6]|l_sw[7]|l_sw[8]|l_sw[9]|out|pad|padres|vc|vcp|vdd|vddr|vip|vss|z
+ \$78597 ntap1 A=16.92p P=112.8u
R$4920
+ BOTTOM|TOP|VGND|VSS|anode|cathode|core|h_sw[0]|h_sw[10]|h_sw[1]|h_sw[2]|h_sw[3]|h_sw[4]|h_sw[5]|h_sw[6]|h_sw[7]|h_sw[8]|h_sw[9]|l_sw[0]|l_sw[10]|l_sw[1]|l_sw[2]|l_sw[3]|l_sw[4]|l_sw[5]|l_sw[6]|l_sw[7]|l_sw[8]|l_sw[9]|out|pad|padres|vc|vcp|vdd|vddr|vip|vss|z
+ \$78598 ntap1 A=16.92p P=112.8u
R$4922
+ BOTTOM|TOP|VGND|VSS|anode|cathode|core|h_sw[0]|h_sw[10]|h_sw[1]|h_sw[2]|h_sw[3]|h_sw[4]|h_sw[5]|h_sw[6]|h_sw[7]|h_sw[8]|h_sw[9]|l_sw[0]|l_sw[10]|l_sw[1]|l_sw[2]|l_sw[3]|l_sw[4]|l_sw[5]|l_sw[6]|l_sw[7]|l_sw[8]|l_sw[9]|out|pad|padres|vc|vcp|vdd|vddr|vip|vss|z
+ \$78657 ntap1 A=17.928p P=119.52u
R$4926
+ BOTTOM|TOP|VGND|VSS|anode|cathode|core|h_sw[0]|h_sw[10]|h_sw[1]|h_sw[2]|h_sw[3]|h_sw[4]|h_sw[5]|h_sw[6]|h_sw[7]|h_sw[8]|h_sw[9]|l_sw[0]|l_sw[10]|l_sw[1]|l_sw[2]|l_sw[3]|l_sw[4]|l_sw[5]|l_sw[6]|l_sw[7]|l_sw[8]|l_sw[9]|out|pad|padres|vc|vcp|vdd|vddr|vip|vss|z
+ \$78956 ntap1 A=16.092p P=107.28u
R$4930 anode|guard|iovss
+ BOTTOM|TOP|VGND|VSS|anode|cathode|core|h_sw[0]|h_sw[10]|h_sw[1]|h_sw[2]|h_sw[3]|h_sw[4]|h_sw[5]|h_sw[6]|h_sw[7]|h_sw[8]|h_sw[9]|l_sw[0]|l_sw[10]|l_sw[1]|l_sw[2]|l_sw[3]|l_sw[4]|l_sw[5]|l_sw[6]|l_sw[7]|l_sw[8]|l_sw[9]|out|pad|padres|vc|vcp|vdd|vddr|vip|vss|z
+ ptap1 A=130781.752052p P=33289.133u
R$4951 anode|cathode|vss
+ BOTTOM|TOP|VGND|VSS|anode|cathode|core|h_sw[0]|h_sw[10]|h_sw[1]|h_sw[2]|h_sw[3]|h_sw[4]|h_sw[5]|h_sw[6]|h_sw[7]|h_sw[8]|h_sw[9]|l_sw[0]|l_sw[10]|l_sw[1]|l_sw[2]|l_sw[3]|l_sw[4]|l_sw[5]|l_sw[6]|l_sw[7]|l_sw[8]|l_sw[9]|out|pad|padres|vc|vcp|vdd|vddr|vip|vss|z
+ ptap1 A=530.0736p P=3531.616u
.ENDS MSPHY9932
