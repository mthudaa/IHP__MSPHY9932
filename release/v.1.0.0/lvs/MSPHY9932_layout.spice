* NGSPICE file created from MSPHY9932_flat.ext - technology: ihp-sg13cmos5l

.subckt MSPHY9932_flat vdd cks vip vin vddr data[0] data[1] data[2] cko frame
X0 sg13cmos5l_Corner_1.vss a_86222_175886# dantenna l=1.26u w=27.78u
X1 sg13cmos5l_Corner_1.vss adc8b_0.diff_bsw_0.single_bsw_0.sg13cmos5l_inv_1$1_0.A a_70946_99114# sg13cmos5l_Corner_1.vss sg13_lv_nmos ad=1.02p pd=6.68u as=0.57p ps=3.38u w=3u l=0.13u
X2 a_89146_97322# adc8b_0.sar12b_0.sg13cmos5l_dfrbp_1_6.RESET_B sg13cmos5l_Corner_1.vss sg13cmos5l_Corner_1.vss sg13_lv_nmos ad=37.8f pd=0.6u as=79.8f ps=0.8u w=0.42u l=0.13u
X3 vdd a_94701_97301# a_94803_97444# vdd sg13_lv_pmos ad=1.07253p pd=6.75u as=0.3864p ps=2.93u w=1.12u l=0.13u
X4 a_96764_96572# a_96351_96930# a_96696_96572# vdd sg13_lv_pmos ad=0.191p pd=1.44u as=0.105p ps=1.21u w=1u l=0.13u
X5 sg13cmos5l_Corner_1.vss a_89656_96030# a_89305_95887# sg13cmos5l_Corner_1.vss sg13_lv_nmos ad=79.8f pd=0.8u as=0.1428p ps=1.52u w=0.42u l=0.13u
X6 a_97125_92976# adc8b_0.sar12b_0.sg13cmos5l_dfrbp_1_0.Q vdd vdd sg13_lv_pmos ad=0.2856p pd=2.36u as=0.2198p ps=1.53u w=0.84u l=0.13u
X7 vdd a_90740_100310# adc8b_0.sar12b_0.sg13cmos5l_buf_1_77.X vdd sg13_lv_pmos ad=0.2114p pd=1.54u as=0.42p ps=2.99u w=1.12u l=0.13u
X8 sg13cmos5l_Corner_1.vss adc8b_0.sar12b_0.sg13cmos5l_buf_1_76.X a_87184_100384# sg13cmos5l_Corner_1.vss sg13_lv_nmos ad=0.14875p pd=1.16u as=0.187p ps=1.78u w=0.55u l=0.13u
X9 vdd adc8b_0.sar12b_0.sg13cmos5l_dfrbp_1_6.RESET_B a_89266_99057# vdd sg13_lv_pmos ad=0.1563p pd=1.22u as=0.147p ps=1.54u w=0.42u l=0.13u
X10 adc8b_0.sar12b_0.sg13cmos5l_buf_8_0.X a_100995_95814# vdd vdd sg13_lv_pmos ad=0.2128p pd=1.5u as=0.2128p ps=1.5u w=1.12u l=0.13u
X11 vdd sg13cmos5l_Corner_1.vss vdd vdd sg13_lv_pmos ad=0.34p pd=2.68u as=1.12529n ps=7.72949m w=1u l=1u
X12 sg13cmos5l_Corner_1.vss sg13cmos5l_IOPadVdd$1_0.sg13cmos5l_Clamp_N43N43D4R$1_0.gate vdd sg13cmos5l_Corner_1.vss sg13_hv_nmos ad=1.408p pd=5.04u as=2.596p ps=5.58u w=4.4u l=0.6u
X13 sg13cmos5l_IOPadAnalog_12.pad a_131639_164698# sg13cmos5l_Corner_1.iovdd sg13cmos5l_Corner_1.iovdd sg13_hv_pmos ad=3.9294p pd=7.84u as=2.1312p ps=7.3u w=6.66u l=0.6u
X14 data[1] a_86044_42476# sg13cmos5l_Corner_1.iovdd sg13cmos5l_Corner_1.iovdd sg13_hv_pmos ad=3.9294p pd=7.84u as=2.1312p ps=7.3u w=6.66u l=0.6u
X15 sg13cmos5l_Corner_1.iovdd a_118044_42476# cko sg13cmos5l_Corner_1.iovdd sg13_hv_pmos ad=2.1312p pd=7.3u as=3.9294p ps=7.84u w=6.66u l=0.6u
X16 adc8b_0.side_cap8b_0.buf_32_1.z adc8b_0.side_cap8b_0.in_h_sw[0] vddr vddr sg13_lv_pmos ad=0.19p pd=1.38u as=0.19p ps=1.38u w=1u l=0.13u
X17 vdd adc8b_0.sar12b_0.sg13cmos5l_dfrbp_1_6.RESET_B a_90225_98441# vdd sg13_lv_pmos ad=0.2128p pd=1.5u as=0.2128p ps=1.5u w=1.12u l=0.13u
X18 a_97358_95810# a_98163_95932# a_97618_96033# vdd sg13_lv_pmos ad=0.1428p pd=1.52u as=79.8f ps=0.8u w=0.42u l=0.13u
X19 sg13cmos5l_IOPadVdd$1_0.sg13cmos5l_Clamp_N43N43D4R$1_0.gate sg13cmos5l_IOPadVdd$1_0.sg13cmos5l_RCClampInverter$1_0.in vdd vdd sg13_hv_pmos ad=1.33p pd=7.38u as=1.33p ps=7.38u w=7u l=0.5u
X20 adc8b_0.side_cap8b_0.buf_8_3.z adc8b_0.side_cap8b_0.in_h_sw[3] vddr vddr sg13_lv_pmos ad=0.34p pd=2.68u as=0.19p ps=1.38u w=1u l=0.13u
X21 vddr a_42476_70044# sg13cmos5l_Corner_1.iovdd sg13cmos5l_Corner_1.iovdd sg13_hv_pmos ad=3.9294p pd=7.84u as=2.1312p ps=7.3u w=6.66u l=0.6u
X22 adc8b_0.sar12b_0.sg13cmos5l_buf_1_6.A a_94288_94336# vdd vdd sg13_lv_pmos ad=0.42p pd=2.99u as=0.2114p ps=1.54u w=1.12u l=0.13u
X23 a_90207_97338# adc8b_0.sar12b_0.sg13cmos5l_dlhr_1_5.GATE vdd vdd sg13_lv_pmos ad=0.3234p pd=2.45u as=1.04815p ps=6.595u w=0.84u l=0.13u
X24 sg13cmos5l_Corner_1.vss a_134044_30676# frame sg13cmos5l_Corner_1.vss sg13_hv_nmos ad=1.408p pd=5.04u as=2.596p ps=5.58u w=4.4u l=0.6u
X25 a_36456_134755# a_40542_134425# sg13cmos5l_Corner_1.vss rppd l=20u w=1u
X26 adc8b_0.sar12b_0.sg13cmos5l_buf_1_56.A a_90801_97322# vdd vdd sg13_lv_pmos ad=0.3808p pd=2.92u as=0.2128p ps=1.5u w=1.12u l=0.13u
X27 sg13cmos5l_Corner_1.vss adc8b_0.sar12b_0.sg13cmos5l_dfrbp_1_6.RESET_B a_101596_97308# sg13cmos5l_Corner_1.vss sg13_lv_nmos ad=0.1406p pd=1.12u as=77.7f ps=0.95u w=0.74u l=0.13u
X28 sg13cmos5l_Corner_1.vss sg13cmos5l_IOPadVdd$1_0.sg13cmos5l_Clamp_N43N43D4R$1_0.gate vdd sg13cmos5l_Corner_1.vss sg13_hv_nmos ad=1.408p pd=5.04u as=2.596p ps=5.58u w=4.4u l=0.6u
X29 a_84333_99607# adc8b_0.sar12b_0.sg13cmos5l_inv_1_8.A vdd vdd sg13_lv_pmos ad=0.4088p pd=2.97u as=1.12242p ps=7u w=1.12u l=0.13u
X30 vdd a_99160_96030# a_99105_96125# vdd sg13_lv_pmos ad=1.28962p pd=8.195u as=93.45f ps=0.865u w=0.42u l=0.13u
X31 sg13cmos5l_Corner_1.vss a_94583_95421# a_95420_95060# sg13cmos5l_Corner_1.vss sg13_lv_nmos ad=0.1406p pd=1.12u as=0.2516p ps=2.16u w=0.74u l=0.13u
X32 sg13cmos5l_Corner_1.iovdd a_164624_70044# sg13cmos5l_IOPadAnalog_1.pad sg13cmos5l_Corner_1.iovdd sg13_hv_pmos ad=2.1312p pd=7.3u as=3.9294p ps=7.84u w=6.66u l=0.6u
X33 sg13cmos5l_Corner_1.vss a_30676_86044# vin sg13cmos5l_Corner_1.vss sg13_hv_nmos ad=1.408p pd=5.04u as=2.596p ps=5.58u w=4.4u l=0.6u
X34 a_86718_96859# a_86837_96536# vdd vdd sg13_lv_pmos ad=0.3864p pd=2.93u as=0.2128p ps=1.5u w=1.12u l=0.13u
X35 a_88671_94314# adc8b_0.sar12b_0.sg13cmos5l_dlhr_1_0.GATE vdd vdd sg13_lv_pmos ad=0.3234p pd=2.45u as=1.43437p ps=9.105u w=0.84u l=0.13u
X36 data[0] a_70044_42476# sg13cmos5l_Corner_1.iovdd sg13cmos5l_Corner_1.iovdd sg13_hv_pmos ad=3.9294p pd=7.84u as=2.1312p ps=7.3u w=6.66u l=0.6u
X37 sg13cmos5l_IOPadAnalog_0.pad a_178296_86044# sg13cmos5l_Corner_1.vss sg13cmos5l_Corner_1.vss sg13_hv_nmos ad=2.596p pd=5.58u as=1.408p ps=5.04u w=4.4u l=0.6u
X38 a_96244_93548# a_96022_93604# vdd vdd sg13_lv_pmos ad=0.1176p pd=1.33u as=0.2618p ps=1.63u w=1.12u l=0.13u
X39 adc8b_0.side_cap8b_0.buf_8_2.z adc8b_0.side_cap8b_0.in_h_sw[4] sg13cmos5l_Corner_1.vss sg13cmos5l_Corner_1.vss sg13_lv_nmos ad=95f pd=0.88u as=95f ps=0.88u w=0.5u l=0.13u
X40 sg13cmos5l_Corner_1.vss a_83639_178370# sg13cmos5l_IOPadAnalog_9.pad sg13cmos5l_Corner_1.vss sg13_hv_nmos ad=1.408p pd=5.04u as=2.596p ps=5.58u w=4.4u l=0.6u
X41 a_82476_98088# a_82995_98095# a_83735_98445# sg13cmos5l_Corner_1.vss sg13_lv_nmos ad=0.3473p pd=2.71u as=0.12665p ps=1.145u w=0.74u l=0.13u
X42 a_87564_95064# a_87538_95028# sg13cmos5l_Corner_1.vss sg13cmos5l_Corner_1.vss sg13_lv_nmos ad=0.2516p pd=2.16u as=0.1626p ps=1.415u w=0.74u l=0.13u
X43 vddr adc8b_0.sar12b_0.nh_sw[2] adc8b_0.side_cap8b_1.buf_16_0.z vddr sg13_lv_pmos ad=0.19p pd=1.38u as=0.19p ps=1.38u w=1u l=0.13u
X44 vdd a_98036_94262# adc8b_0.sar12b_0.nl_sw[8] vdd sg13_lv_pmos ad=0.2114p pd=1.54u as=0.42p ps=2.99u w=1.12u l=0.13u
X45 sg13cmos5l_Corner_1.vss a_67639_178370# sg13cmos5l_IOPadAnalog_10.pad sg13cmos5l_Corner_1.vss sg13_hv_nmos ad=2.068p pd=9.74u as=2.596p ps=5.58u w=4.4u l=0.6u
X46 a_87564_95064# a_88083_95071# a_88823_95421# sg13cmos5l_Corner_1.vss sg13_lv_nmos ad=0.3473p pd=2.71u as=0.12665p ps=1.145u w=0.74u l=0.13u
X47 vdd sg13cmos5l_Corner_1.vss vdd vdd sg13_lv_pmos ad=0.34p pd=2.68u as=0 ps=0 w=1u l=1u
X48 sg13cmos5l_Corner_1.vss adc8b_0.sar12b_0.sg13cmos5l_dfrbp_1_8.RESET_B a_88766_96997# sg13cmos5l_Corner_1.vss sg13_lv_nmos ad=0.1701p pd=1.65u as=37.8f ps=0.6u w=0.42u l=0.13u
X49 vdd a_88671_94314# a_88802_94308# vdd sg13_lv_pmos ad=1.43437p pd=9.105u as=0.2856p ps=2.36u w=0.84u l=0.13u
X50 sg13cmos5l_Corner_1.iovdd a_42476_86044# vin sg13cmos5l_Corner_1.iovdd sg13_hv_pmos ad=2.1312p pd=7.3u as=3.9294p ps=7.84u w=6.66u l=0.6u
X51 sg13cmos5l_Corner_1.vss adc8b_0.sar12b_0.sg13cmos5l_buf_1_78.A a_87952_100384# sg13cmos5l_Corner_1.vss sg13_lv_nmos ad=0.14875p pd=1.16u as=0.187p ps=1.78u w=0.55u l=0.13u
X52 vdd adc8b_0.sar12b_0.sg13cmos5l_dlygate4sd2_1_0.A a_82670_94302# vdd sg13_lv_pmos ad=0.2481p pd=1.56u as=0.1428p ps=1.52u w=0.42u l=0.13u
X53 a_98894_92786# adc8b_0.sar12b_0.sg13cmos5l_dfrbp_1_0.D vdd vdd sg13_lv_pmos ad=79.8f pd=0.8u as=0.1428p ps=1.52u w=0.42u l=0.13u
X54 sg13cmos5l_Corner_1.vss a_96568_94518# a_96217_94375# sg13cmos5l_Corner_1.vss sg13_lv_nmos ad=79.8f pd=0.8u as=0.1428p ps=1.52u w=0.42u l=0.13u
X55 a_99825_94689# a_99468_94616# vdd vdd sg13_lv_pmos ad=63f pd=0.72u as=0.1563p ps=1.22u w=0.42u l=0.13u
X56 a_100995_95814# adc8b_0.sar12b_0.sg13cmos5l_buf_8_0.A vdd vdd sg13_lv_pmos ad=0.2128p pd=1.5u as=0.2128p ps=1.5u w=1.12u l=0.13u
X57 a_89242_95498# adc8b_0.sar12b_0.sg13cmos5l_dfrbp_1_6.RESET_B sg13cmos5l_Corner_1.vss sg13cmos5l_Corner_1.vss sg13_lv_nmos ad=37.8f pd=0.6u as=79.8f ps=0.8u w=0.42u l=0.13u
X58 sg13cmos5l_IOPadVdd$1_0.sg13cmos5l_Clamp_N43N43D4R$1_0.gate sg13cmos5l_IOPadVdd$1_0.sg13cmos5l_RCClampInverter$1_0.in vdd vdd sg13_hv_pmos ad=1.33p pd=7.38u as=1.33p ps=7.38u w=7u l=0.5u
X59 cks a_42476_118044# sg13cmos5l_Corner_1.iovdd sg13cmos5l_Corner_1.iovdd sg13_hv_pmos ad=3.9294p pd=7.84u as=3.1302p ps=14.26u w=6.66u l=0.6u
X60 a_83916_95064# a_83890_95028# sg13cmos5l_Corner_1.vss sg13cmos5l_Corner_1.vss sg13_lv_nmos ad=0.2516p pd=2.16u as=0.1626p ps=1.415u w=0.74u l=0.13u
X61 adc8b_0.side_cap8b_1.buf_32_0.z adc8b_0.sar12b_0.nl_sw[0] vddr vddr sg13_lv_pmos ad=0.19p pd=1.38u as=0.19p ps=1.38u w=1u l=0.13u
X62 sg13cmos5l_IOPadAnalog_1.pad a_164624_70044# sg13cmos5l_Corner_1.iovdd sg13cmos5l_Corner_1.iovdd sg13_hv_pmos ad=3.9294p pd=7.84u as=2.1312p ps=7.3u w=6.66u l=0.6u
X63 adc8b_0.side_cap8b_1.buf_16_3.z adc8b_0.sar12b_0.nh_sw[1] vddr vddr sg13_lv_pmos ad=0.19p pd=1.38u as=0.19p ps=1.38u w=1u l=0.13u
X64 sg13cmos5l_IOPadAnalog_10.pad a_67639_178370# sg13cmos5l_Corner_1.vss sg13cmos5l_Corner_1.vss sg13_hv_nmos ad=2.596p pd=5.58u as=1.408p ps=5.04u w=4.4u l=0.6u
X65 vdd adc8b_0.sar12b_0.sg13cmos5l_buf_1_73.X a_87568_100384# vdd sg13_lv_pmos ad=0.2114p pd=1.54u as=0.2856p ps=2.36u w=0.84u l=0.13u
X66 a_90897_99643# a_90540_99600# vdd vdd sg13_lv_pmos ad=63f pd=0.72u as=0.1563p ps=1.22u w=0.42u l=0.13u
X67 sg13cmos5l_Corner_1.vss vdd sg13cmos5l_Corner_1.vss sg13cmos5l_Corner_1.vss sg13_lv_nmos ad=0.1428p pd=1.52u as=25.72481n ps=0.04234 w=0.42u l=1u
X68 adc8b_0.side_cap8b_0.buf_8_4.z adc8b_0.side_cap8b_0.in_l_sw[5] vddr vddr sg13_lv_pmos ad=0.19p pd=1.38u as=0.19p ps=1.38u w=1u l=0.13u
X69 a_99548_99596# a_99266_99960# a_99481_99998# sg13cmos5l_Corner_1.vss sg13_lv_nmos ad=0.141p pd=1.17u as=71.99999f ps=0.865u w=0.64u l=0.13u
X70 vdd a_84525_94277# a_84627_94420# vdd sg13_lv_pmos ad=1.43437p pd=9.105u as=0.3864p ps=2.93u w=1.12u l=0.13u
X71 a_84108_94616# a_84627_94420# a_85367_94375# sg13cmos5l_Corner_1.vss sg13_lv_nmos ad=0.3473p pd=2.71u as=0.12665p ps=1.145u w=0.74u l=0.13u
X72 adc8b_0.sar12b_0.sg13cmos5l_buf_1_59.A a_86193_98441# sg13cmos5l_Corner_1.vss sg13cmos5l_Corner_1.vss sg13_lv_nmos ad=0.2516p pd=2.16u as=0.1406p ps=1.12u w=0.74u l=0.13u
X73 sg13cmos5l_IOPadAnalog_9.pad a_83639_164698# sg13cmos5l_Corner_1.iovdd sg13cmos5l_Corner_1.iovdd sg13_hv_pmos ad=3.9294p pd=7.84u as=2.1312p ps=7.3u w=6.66u l=0.6u
X74 a_90254_100034# adc8b_0.sar12b_0.sg13cmos5l_dfrbp_1_18.Q vdd vdd sg13_lv_pmos ad=79.8f pd=0.8u as=0.1428p ps=1.52u w=0.42u l=0.13u
X75 adc8b_0.sar12b_0.sg13cmos5l_dlhr_1_7.Q_N a_86718_98514# sg13cmos5l_Corner_1.vss sg13cmos5l_Corner_1.vss sg13_lv_nmos ad=0.2516p pd=2.16u as=0.1491p ps=1.18u w=0.74u l=0.13u
X76 a_85594_95498# adc8b_0.sar12b_0.sg13cmos5l_dfrbp_1_8.RESET_B sg13cmos5l_Corner_1.vss sg13cmos5l_Corner_1.vss sg13_lv_nmos ad=37.8f pd=0.6u as=79.8f ps=0.8u w=0.42u l=0.13u
X77 sg13cmos5l_Corner_1.iovdd a_164624_102044# sg13cmos5l_IOPadAnalog_16.pad sg13cmos5l_Corner_1.iovdd sg13_hv_pmos ad=2.1312p pd=7.3u as=3.9294p ps=7.84u w=6.66u l=0.6u
X78 sg13cmos5l_Corner_1.vss a_99639_178370# sg13cmos5l_IOPadAnalog_15.pad sg13cmos5l_Corner_1.vss sg13_hv_nmos ad=1.408p pd=5.04u as=2.596p ps=5.58u w=4.4u l=0.6u
X79 sg13cmos5l_Corner_1.vss adc8b_0.sar12b_0.sg13cmos5l_buf_8_2.X a_101776_98872# sg13cmos5l_Corner_1.vss sg13_lv_nmos ad=0.14875p pd=1.16u as=0.187p ps=1.78u w=0.55u l=0.13u
X80 sg13cmos5l_Corner_1.vss adc8b_0.sar12b_0.sg13cmos5l_dfrbp_1_8.RESET_B a_85694_97335# sg13cmos5l_Corner_1.vss sg13_lv_nmos ad=0.1701p pd=1.65u as=37.8f ps=0.6u w=0.42u l=0.13u
X81 a_92086_96572# adc8b_0.sar12b_0.sg13cmos5l_a221oi_1_0.C1 a_92188_96572# vdd sg13_lv_pmos ad=0.3808p pd=2.92u as=0.2128p ps=1.5u w=1.12u l=0.13u
X82 sg13cmos5l_Corner_1.vss vdd sg13cmos5l_Corner_1.vss sg13cmos5l_Corner_1.vss sg13_lv_nmos ad=0.1428p pd=1.52u as=0 ps=0 w=0.42u l=1u
X83 sg13cmos5l_Corner_1.vss a_115639_178370# sg13cmos5l_IOPadAnalog_13.pad sg13cmos5l_Corner_1.vss sg13_hv_nmos ad=1.408p pd=5.04u as=2.596p ps=5.58u w=4.4u l=0.6u
X84 adc8b_0.side_cap8b_0.buf_4_3.z adc8b_0.side_cap8b_0.in_l_sw[6] sg13cmos5l_Corner_1.vss sg13cmos5l_Corner_1.vss sg13_lv_nmos ad=95f pd=0.88u as=95f ps=0.88u w=0.5u l=0.13u
X85 adc8b_0.sar12b_0.sg13cmos5l_buf_1_101.X a_98032_100384# vdd vdd sg13_lv_pmos ad=0.42p pd=2.99u as=0.2114p ps=1.54u w=1.12u l=0.13u
X86 a_98028_97640# a_98002_97545# vdd vdd sg13_lv_pmos ad=0.34p pd=2.68u as=0.36237p ps=2.605u w=1u l=0.13u
X87 sg13cmos5l_Corner_1.vss a_93741_95071# a_93843_95071# sg13cmos5l_Corner_1.vss sg13_lv_nmos ad=2.41737p pd=15.64u as=0.2516p ps=2.16u w=0.74u l=0.13u
X88 sg13cmos5l_Corner_1.vss a_70044_30676# data[0] sg13cmos5l_Corner_1.vss sg13_hv_nmos ad=1.408p pd=5.04u as=2.596p ps=5.58u w=4.4u l=0.6u
X89 sg13cmos5l_Corner_1.vss adc8b_0.sar12b_0.sg13cmos5l_dfrbp_1_6.RESET_B a_95164_98472# sg13cmos5l_Corner_1.vss sg13_lv_nmos ad=0.1406p pd=1.12u as=77.7f ps=0.95u w=0.74u l=0.13u
X90 vdd a_88863_92802# a_88994_92796# vdd sg13_lv_pmos ad=1.86162p pd=11.935u as=0.2856p ps=2.36u w=0.84u l=0.13u
X91 sg13cmos5l_Corner_1.iovdd a_131639_164698# sg13cmos5l_IOPadAnalog_12.pad sg13cmos5l_Corner_1.iovdd sg13_hv_pmos ad=2.1312p pd=7.3u as=3.9294p ps=7.84u w=6.66u l=0.6u
X92 sg13cmos5l_Corner_1.iovdd a_42476_118044# cks sg13cmos5l_Corner_1.iovdd sg13_hv_pmos ad=2.1312p pd=7.3u as=3.9294p ps=7.84u w=6.66u l=0.6u
X93 sg13cmos5l_Corner_1.vss adc8b_0.sar12b_0.sg13cmos5l_buf_1_62.X a_83632_100384# sg13cmos5l_Corner_1.vss sg13_lv_nmos ad=0.14875p pd=1.16u as=0.187p ps=1.78u w=0.55u l=0.13u
X94 vddr adc8b_0.sar12b_0.nh_sw[0] adc8b_0.side_cap8b_1.buf_32_1.z vddr sg13_lv_pmos ad=0.19p pd=1.38u as=0.19p ps=1.38u w=1u l=0.13u
X95 a_86286_99156# a_86117_98796# a_85844_98784# vdd sg13_lv_pmos ad=0.105p pd=1.21u as=0.191p ps=1.44u w=1u l=0.13u
X96 a_92950_95836# adc8b_0.sar12b_0.sg13cmos5l_a221oi_1_0.A2 sg13cmos5l_Corner_1.vss sg13cmos5l_Corner_1.vss sg13_lv_nmos ad=0.1406p pd=1.12u as=0.2516p ps=2.16u w=0.74u l=0.13u
X97 sg13cmos5l_IOPadAnalog_1.pad a_164624_70044# sg13cmos5l_Corner_1.iovdd sg13cmos5l_Corner_1.iovdd sg13_hv_pmos ad=3.9294p pd=7.84u as=3.1302p ps=14.26u w=6.66u l=0.6u
X98 a_96692_92750# adc8b_0.sar12b_0.sg13cmos5l_buf_1_6.A vdd vdd sg13_lv_pmos ad=0.2856p pd=2.36u as=0.2114p ps=1.54u w=0.84u l=0.13u
X99 adc8b_0.sar12b_0.sg13cmos5l_dlhr_1_16.Q a_100977_96929# sg13cmos5l_Corner_1.vss sg13cmos5l_Corner_1.vss sg13_lv_nmos ad=0.2516p pd=2.16u as=0.1406p ps=1.12u w=0.74u l=0.13u
X100 sg13cmos5l_Corner_1.vss adc8b_0.sar12b_0.nl_sw[4] adc8b_0.side_cap8b_1.buf_8_0.z sg13cmos5l_Corner_1.vss sg13_lv_nmos ad=95f pd=0.88u as=0.17p ps=1.68u w=0.5u l=0.13u
X101 adc8b_0.side_cap8b_0.buf_16_1.z adc8b_0.side_cap8b_0.in_l_sw[2] vddr vddr sg13_lv_pmos ad=0.19p pd=1.38u as=0.19p ps=1.38u w=1u l=0.13u
X102 adc8b_0.sar12b_0.sg13cmos5l_inv_1_29.A a_94172_99132# vdd vdd sg13_lv_pmos ad=0.3808p pd=2.92u as=0.2128p ps=1.5u w=1.12u l=0.13u
X103 sg13cmos5l_IOPadAnalog_0.pad a_164624_86044# sg13cmos5l_Corner_1.iovdd sg13cmos5l_Corner_1.iovdd sg13_hv_pmos ad=3.9294p pd=7.84u as=2.1312p ps=7.3u w=6.66u l=0.6u
X104 sg13cmos5l_Corner_1.vss sg13cmos5l_IOPadAnalog_15.padres dantenna l=3.1u w=0.64u
X105 adc8b_0.sar12b_0.sg13cmos5l_dlhr_1_16.Q_N a_101502_97002# sg13cmos5l_Corner_1.vss sg13cmos5l_Corner_1.vss sg13_lv_nmos ad=0.2516p pd=2.16u as=0.1491p ps=1.18u w=0.74u l=0.13u
X106 a_97972_95498# a_97589_95024# vdd vdd sg13_lv_pmos ad=79.8f pd=0.8u as=0.2639p ps=1.81u w=0.42u l=0.13u
X107 vdd adc8b_0.sar12b_0.sg13cmos5l_dfrbp_1_0.RESET_B a_93298_93009# vdd sg13_lv_pmos ad=0.1563p pd=1.22u as=0.147p ps=1.54u w=0.42u l=0.13u
X108 a_85628_93548# a_85346_93912# a_85561_93950# sg13cmos5l_Corner_1.vss sg13_lv_nmos ad=0.141p pd=1.17u as=71.99999f ps=0.865u w=0.64u l=0.13u
X109 vdd sg13cmos5l_IOPadVdd$1_0.sg13cmos5l_Clamp_N43N43D4R$1_0.gate sg13cmos5l_Corner_1.vss sg13cmos5l_Corner_1.vss sg13_hv_nmos ad=2.596p pd=5.58u as=1.408p ps=5.04u w=4.4u l=0.6u
X110 adc8b_0.side_cap8b_1.buf_16_3.z adc8b_0.sar12b_0.nh_sw[1] sg13cmos5l_Corner_1.vss sg13cmos5l_Corner_1.vss sg13_lv_nmos ad=95f pd=0.88u as=95f ps=0.88u w=0.5u l=0.13u
X111 vdd adc8b_0.sar12b_0.sg13cmos5l_buf_1_74.X a_88336_100384# vdd sg13_lv_pmos ad=0.2114p pd=1.54u as=0.2856p ps=2.36u w=0.84u l=0.13u
X112 sg13cmos5l_IOPadAnalog_1.pad a_164624_70044# sg13cmos5l_Corner_1.iovdd sg13cmos5l_Corner_1.iovdd sg13_hv_pmos ad=3.9294p pd=7.84u as=2.1312p ps=7.3u w=6.66u l=0.6u
X113 sg13cmos5l_IOPadAnalog_16.pad a_164624_102044# sg13cmos5l_Corner_1.iovdd sg13cmos5l_Corner_1.iovdd sg13_hv_pmos ad=3.9294p pd=7.84u as=2.1312p ps=7.3u w=6.66u l=0.6u
X114 a_92076_99152# a_92595_98956# a_93335_98911# sg13cmos5l_Corner_1.vss sg13_lv_nmos ad=0.3473p pd=2.71u as=0.12665p ps=1.145u w=0.74u l=0.13u
X115 a_99468_92799# a_99180_93104# a_99406_92799# sg13cmos5l_Corner_1.vss sg13_lv_nmos ad=0.1428p pd=1.52u as=37.8f ps=0.6u w=0.42u l=0.13u
X116 sg13cmos5l_IOPadAnalog_12.pad a_131639_164698# sg13cmos5l_Corner_1.iovdd sg13cmos5l_Corner_1.iovdd sg13_hv_pmos ad=3.9294p pd=7.84u as=3.1302p ps=14.26u w=6.66u l=0.6u
X117 sg13cmos5l_IOPadAnalog_13.pad a_115639_164698# sg13cmos5l_Corner_1.iovdd sg13cmos5l_Corner_1.iovdd sg13_hv_pmos ad=3.9294p pd=7.84u as=2.1312p ps=7.3u w=6.66u l=0.6u
X118 a_100995_100350# cks vdd vdd sg13_lv_pmos ad=0.2128p pd=1.5u as=0.2128p ps=1.5u w=1.12u l=0.13u
X119 vdd a_83992_98326# a_83937_98207# vdd sg13_lv_pmos ad=1.07253p pd=6.75u as=93.45f ps=0.865u w=0.42u l=0.13u
X120 a_95800_97542# adc8b_0.sar12b_0.sg13cmos5l_dfrbp_1_6.RESET_B vdd vdd sg13_lv_pmos ad=79.8f pd=0.8u as=1.04815p ps=6.595u w=0.42u l=0.13u
X121 vdd a_85773_95789# a_85875_95932# vdd sg13_lv_pmos ad=1.28962p pd=8.195u as=0.3864p ps=2.93u w=1.12u l=0.13u
X122 vdd adc8b_0.cmp_0.clk adc8b_0.cmp_0.outp vdd sg13_lv_pmos ad=95f pd=0.88u as=0.17p ps=1.68u w=0.5u l=0.13u
X123 vdd a_90808_99054# a_90753_99149# vdd sg13_lv_pmos ad=1.15047p pd=7.175u as=93.45f ps=0.865u w=0.42u l=0.13u
X124 sg13cmos5l_Corner_1.vss a_100113_98834# a_100068_98870# sg13cmos5l_Corner_1.vss sg13_lv_nmos ad=0.1428p pd=1.52u as=47.25f ps=0.645u w=0.42u l=0.13u
X125 a_84108_94616# a_84082_94521# vdd vdd sg13_lv_pmos ad=0.34p pd=2.68u as=0.36237p ps=2.605u w=1u l=0.13u
X126 vddr adc8b_0.side_cap8b_0.in_l_sw[9] adc8b_0.side_cap8b_0.buf_2_2.z vddr sg13_lv_pmos ad=0.19p pd=1.38u as=0.34p ps=2.68u w=1u l=0.13u
X127 adc8b_0.side_cap8b_0.buf_4_2.z adc8b_0.side_cap8b_0.in_h_sw[7] sg13cmos5l_Corner_1.vss sg13cmos5l_Corner_1.vss sg13_lv_nmos ad=95f pd=0.88u as=95f ps=0.88u w=0.5u l=0.13u
X128 sg13cmos5l_Corner_1.vss adc8b_0.sar12b_0.sg13cmos5l_buf_1_31.X a_83440_94336# sg13cmos5l_Corner_1.vss sg13_lv_nmos ad=0.14875p pd=1.16u as=0.187p ps=1.78u w=0.55u l=0.13u
X129 adc8b_0.side_cap8b_1.buf_8_2.z adc8b_0.sar12b_0.nh_sw[4] sg13cmos5l_Corner_1.vss sg13cmos5l_Corner_1.vss sg13_lv_nmos ad=0.17p pd=1.68u as=95f ps=0.88u w=0.5u l=0.13u
X130 a_36456_138055# a_40542_137725# sg13cmos5l_Corner_1.vss rppd l=20u w=1u
X131 sg13cmos5l_Corner_1.vss a_95409_98834# a_95364_98870# sg13cmos5l_Corner_1.vss sg13_lv_nmos ad=0.1428p pd=1.52u as=47.25f ps=0.645u w=0.42u l=0.13u
X132 a_86718_96859# a_86837_96536# sg13cmos5l_Corner_1.vss sg13cmos5l_Corner_1.vss sg13_lv_nmos ad=0.2516p pd=2.16u as=0.1406p ps=1.12u w=0.74u l=0.13u
X133 adc8b_0.side_cap8b_1.buf_32_1.z adc8b_0.sar12b_0.nh_sw[0] sg13cmos5l_Corner_1.vss sg13cmos5l_Corner_1.vss sg13_lv_nmos ad=95f pd=0.88u as=95f ps=0.88u w=0.5u l=0.13u
X134 adc8b_0.sar12b_0.sg13cmos5l_a22oi_1_1.B2 adc8b_0.sar12b_0.sg13cmos5l_and3_1_0.X a_95466_96572# vdd sg13_lv_pmos ad=0.3808p pd=2.92u as=0.2128p ps=1.5u w=1.12u l=0.13u
X135 sg13cmos5l_Corner_1.vss adc8b_0.sar12b_0.nh_sw[0] adc8b_0.side_cap8b_1.buf_32_1.z sg13cmos5l_Corner_1.vss sg13_lv_nmos ad=95f pd=0.88u as=95f ps=0.88u w=0.5u l=0.13u
X136 sg13cmos5l_Corner_1.iovdd a_42476_102044# vip sg13cmos5l_Corner_1.iovdd sg13_hv_pmos ad=2.1312p pd=7.3u as=3.9294p ps=7.84u w=6.66u l=0.6u
X137 sg13cmos5l_Corner_1.iovdd a_134044_42476# frame sg13cmos5l_Corner_1.iovdd sg13_hv_pmos ad=2.1312p pd=7.3u as=3.9294p ps=7.84u w=6.66u l=0.6u
X138 adc8b_0.side_cap8b_0.buf_16_3.z adc8b_0.side_cap8b_0.in_h_sw[1] sg13cmos5l_Corner_1.vss sg13cmos5l_Corner_1.vss sg13_lv_nmos ad=95f pd=0.88u as=95f ps=0.88u w=0.5u l=0.13u
X139 adc8b_0.sar12b_0.sg13cmos5l_dlhr_1_0.GATE a_87452_96108# vdd vdd sg13_lv_pmos ad=0.3808p pd=2.92u as=0.2128p ps=1.5u w=1.12u l=0.13u
X140 vdd adc8b_0.sar12b_0.sg13cmos5l_buf_1_39.A a_85456_92824# vdd sg13_lv_pmos ad=0.2114p pd=1.54u as=0.2856p ps=2.36u w=0.84u l=0.13u
X141 sg13cmos5l_IOPadVdd$1_0.sg13cmos5l_Clamp_N43N43D4R$1_0.gate sg13cmos5l_IOPadVdd$1_0.sg13cmos5l_RCClampInverter$1_0.in vdd vdd sg13_hv_pmos ad=1.33p pd=7.38u as=1.33p ps=7.38u w=7u l=0.5u
X142 vdd adc8b_0.sar12b_0.sg13cmos5l_buf_1_34.X adc8b_0.sar12b_0.sg13cmos5l_buf_1_60.A vdd sg13_lv_pmos ad=0.3808p pd=2.92u as=0.3808p ps=2.92u w=1.12u l=0.13u
X143 sg13cmos5l_Corner_1.vss a_67639_178370# sg13cmos5l_IOPadAnalog_10.pad sg13cmos5l_Corner_1.vss sg13_hv_nmos ad=1.408p pd=5.04u as=2.596p ps=5.58u w=4.4u l=0.6u
X144 vddr adc8b_0.side_cap8b_0.in_h_sw[2] adc8b_0.side_cap8b_0.buf_16_0.z vddr sg13_lv_pmos ad=0.19p pd=1.38u as=0.19p ps=1.38u w=1u l=0.13u
X145 a_96476_98084# a_96063_98442# a_96408_98084# vdd sg13_lv_pmos ad=0.191p pd=1.44u as=0.105p ps=1.21u w=1u l=0.13u
X146 sg13cmos5l_IOPadAnalog_11.pad a_164624_118044# sg13cmos5l_Corner_1.iovdd sg13cmos5l_Corner_1.iovdd sg13_hv_pmos ad=3.9294p pd=7.84u as=2.1312p ps=7.3u w=6.66u l=0.6u
X147 vdd sg13cmos5l_IOPadVdd$1_0.sg13cmos5l_Clamp_N43N43D4R$1_0.gate sg13cmos5l_Corner_1.vss sg13cmos5l_Corner_1.vss sg13_hv_nmos ad=2.596p pd=5.58u as=1.408p ps=5.04u w=4.4u l=0.6u
X148 adc8b_0.sar12b_0.sg13cmos5l_dlhr_1_11.Q a_94929_98441# vdd vdd sg13_lv_pmos ad=0.3808p pd=2.92u as=0.2128p ps=1.5u w=1.12u l=0.13u
X149 a_95469_94277# adc8b_0.sar12b_0.sg13cmos5l_dfrbp_1_0.CLK vdd vdd sg13_lv_pmos ad=0.4088p pd=2.97u as=1.38655p ps=8.8u w=1.12u l=0.13u
X150 adc8b_0.side_cap8b_1.buf_16_0.z adc8b_0.sar12b_0.nh_sw[2] vddr vddr sg13_lv_pmos ad=0.19p pd=1.38u as=0.19p ps=1.38u w=1u l=0.13u
X151 sg13cmos5l_Corner_1.iovdd a_118044_42476# cko sg13cmos5l_Corner_1.iovdd sg13_hv_pmos ad=2.1312p pd=7.3u as=3.9294p ps=7.84u w=6.66u l=0.6u
X152 data[1] a_86044_30676# sg13cmos5l_Corner_1.vss sg13cmos5l_Corner_1.vss sg13_hv_nmos ad=2.596p pd=5.58u as=1.408p ps=5.04u w=4.4u l=0.6u
X153 sg13cmos5l_Corner_1.vss adc8b_0.sar12b_0.sg13cmos5l_inv_1_19.A adc8b_0.sar12b_0.sg13cmos5l_buf_1_32.A sg13cmos5l_Corner_1.vss sg13_lv_nmos ad=0.2516p pd=2.16u as=0.2516p ps=2.16u w=0.74u l=0.13u
X154 sg13cmos5l_Corner_1.vss adc8b_0.side_cap8b_0.in_h_sw[2] adc8b_0.side_cap8b_0.buf_16_0.z sg13cmos5l_Corner_1.vss sg13_lv_nmos ad=95f pd=0.88u as=0.17p ps=1.68u w=0.5u l=0.13u
X155 data[1] a_86044_42476# sg13cmos5l_Corner_1.iovdd sg13cmos5l_Corner_1.iovdd sg13_hv_pmos ad=3.9294p pd=7.84u as=2.1312p ps=7.3u w=6.66u l=0.6u
X156 a_90879_95826# adc8b_0.sar12b_0.sg13cmos5l_dfrbp_1_11.Q sg13cmos5l_Corner_1.vss sg13cmos5l_Corner_1.vss sg13_lv_nmos ad=0.2516p pd=2.16u as=0.15055p ps=1.17u w=0.74u l=0.13u
X157 sg13cmos5l_Corner_1.iovdd a_42476_118044# cks sg13cmos5l_Corner_1.iovdd sg13_hv_pmos ad=2.1312p pd=7.3u as=3.9294p ps=7.84u w=6.66u l=0.6u
X158 a_100628_100310# adc8b_0.sar12b_0.sg13cmos5l_buf_1_101.X vdd vdd sg13_lv_pmos ad=0.2856p pd=2.36u as=0.2114p ps=1.54u w=0.84u l=0.13u
X159 a_94906_93986# adc8b_0.sar12b_0.sg13cmos5l_dfrbp_1_0.RESET_B sg13cmos5l_Corner_1.vss sg13cmos5l_Corner_1.vss sg13_lv_nmos ad=37.8f pd=0.6u as=79.8f ps=0.8u w=0.42u l=0.13u
X160 a_93335_98911# a_92493_98813# a_93241_98911# sg13cmos5l_Corner_1.vss sg13_lv_nmos ad=0.12665p pd=1.145u as=0.1428p ps=1.52u w=0.42u l=0.13u
X161 a_82702_98509# adc8b_0.sar12b_0.sg13cmos5l_dfrbp_1_6.RESET_B sg13cmos5l_Corner_1.vss sg13cmos5l_Corner_1.vss sg13_lv_nmos ad=37.8f pd=0.6u as=0.1701p ps=1.65u w=0.42u l=0.13u
X162 cko a_118044_30676# sg13cmos5l_Corner_1.vss sg13cmos5l_Corner_1.vss sg13_hv_nmos ad=2.596p pd=5.58u as=1.408p ps=5.04u w=4.4u l=0.6u
X163 adc8b_0.sar12b_0.sg13cmos5l_nand2_1_2.B adc8b_0.sar12b_0.sg13cmos5l_or2_1_0.A a_82418_95060# vdd sg13_lv_pmos ad=0.3808p pd=2.92u as=0.1176p ps=1.33u w=1.12u l=0.13u
X164 vddr adc8b_0.sar12b_0.nl_sw[0] adc8b_0.side_cap8b_1.buf_32_0.z vddr sg13_lv_pmos ad=0.19p pd=1.38u as=0.19p ps=1.38u w=1u l=0.13u
X165 a_83348_93512# adc8b_0.sar12b_0.sg13cmos5l_buf_1_40.X sg13cmos5l_Corner_1.vss sg13cmos5l_Corner_1.vss sg13_lv_nmos ad=0.187p pd=1.78u as=0.14875p ps=1.16u w=0.55u l=0.13u
X166 vdd sg13cmos5l_IOPadVdd$1_0.sg13cmos5l_Clamp_N43N43D4R$1_0.gate sg13cmos5l_Corner_1.vss sg13cmos5l_Corner_1.vss sg13_hv_nmos ad=2.596p pd=5.58u as=1.408p ps=5.04u w=4.4u l=0.6u
X167 adc8b_0.side_cap8b_0.buf_8_0.z adc8b_0.side_cap8b_0.in_l_sw[4] sg13cmos5l_Corner_1.vss sg13cmos5l_Corner_1.vss sg13_lv_nmos ad=95f pd=0.88u as=95f ps=0.88u w=0.5u l=0.13u
X168 a_98028_97640# a_98002_97545# sg13cmos5l_Corner_1.vss sg13cmos5l_Corner_1.vss sg13_lv_nmos ad=0.2516p pd=2.16u as=0.1626p ps=1.415u w=0.74u l=0.13u
X169 adc8b_0.sar12b_0.sg13cmos5l_buf_1_45.A a_90609_96929# vdd vdd sg13_lv_pmos ad=0.3808p pd=2.92u as=0.2128p ps=1.5u w=1.12u l=0.13u
X170 sg13cmos5l_Corner_1.vss adc8b_0.sar12b_0.nl_sw[3] adc8b_0.side_cap8b_1.buf_8_1.z sg13cmos5l_Corner_1.vss sg13_lv_nmos ad=95f pd=0.88u as=95f ps=0.88u w=0.5u l=0.13u
X171 sg13cmos5l_IOPadAnalog_9.pad a_83639_164698# sg13cmos5l_Corner_1.iovdd sg13cmos5l_Corner_1.iovdd sg13_hv_pmos ad=3.9294p pd=7.84u as=2.1312p ps=7.3u w=6.66u l=0.6u
X172 sg13cmos5l_Corner_1.vss adc8b_0.side_cap8b_0.in_l_sw[0] adc8b_0.side_cap8b_0.buf_32_0.z sg13cmos5l_Corner_1.vss sg13_lv_nmos ad=95f pd=0.88u as=95f ps=0.88u w=0.5u l=0.13u
X173 sg13cmos5l_IOPadVdd$1_0.sg13cmos5l_Clamp_N43N43D4R$1_0.gate sg13cmos5l_IOPadVdd$1_0.sg13cmos5l_RCClampInverter$1_0.in vdd vdd sg13_hv_pmos ad=1.33p pd=7.38u as=1.33p ps=7.38u w=7u l=0.5u
X174 vin a_42476_86044# sg13cmos5l_Corner_1.iovdd sg13cmos5l_Corner_1.iovdd sg13_hv_pmos ad=3.9294p pd=7.84u as=2.1312p ps=7.3u w=6.66u l=0.6u
X175 sg13cmos5l_Corner_1.iovdd a_115639_164698# sg13cmos5l_IOPadAnalog_13.pad sg13cmos5l_Corner_1.iovdd sg13_hv_pmos ad=2.1312p pd=7.3u as=3.9294p ps=7.84u w=6.66u l=0.6u
X176 adc8b_0.side_cap8b_0.buf_16_2.z adc8b_0.side_cap8b_0.in_l_sw[1] vddr vddr sg13_lv_pmos ad=0.19p pd=1.38u as=0.19p ps=1.38u w=1u l=0.13u
X177 sg13cmos5l_Corner_1.vss a_92462_57198# dantenna l=3.1u w=0.64u
X178 sg13cmos5l_Corner_1.iovdd a_164624_86044# sg13cmos5l_IOPadAnalog_0.pad sg13cmos5l_Corner_1.iovdd sg13_hv_pmos ad=2.1312p pd=7.3u as=3.9294p ps=7.84u w=6.66u l=0.6u
X179 adc8b_0.sar12b_0.sg13cmos5l_dfrbp_1_0.D adc8b_0.sar12b_0.sg13cmos5l_nor2_1_1.A sg13cmos5l_Corner_1.vss sg13cmos5l_Corner_1.vss sg13_lv_nmos ad=0.1406p pd=1.12u as=0.2516p ps=2.16u w=0.74u l=0.13u
X180 sg13cmos5l_Corner_1.iovdd a_70044_42476# data[0] sg13cmos5l_Corner_1.iovdd sg13_hv_pmos ad=2.1312p pd=7.3u as=3.9294p ps=7.84u w=6.66u l=0.6u
X181 sg13cmos5l_Corner_1.iovdd a_131639_164698# sg13cmos5l_IOPadAnalog_12.pad sg13cmos5l_Corner_1.iovdd sg13_hv_pmos ad=2.1312p pd=7.3u as=3.9294p ps=7.84u w=6.66u l=0.6u
X182 adc8b_0.side_cap8b_1.buf_8_1.z adc8b_0.sar12b_0.nl_sw[3] vddr vddr sg13_lv_pmos ad=0.19p pd=1.38u as=0.19p ps=1.38u w=1u l=0.13u
X183 sg13cmos5l_Corner_1.vss adc8b_0.sar12b_0.nl_sw[1] adc8b_0.side_cap8b_1.buf_16_2.z sg13cmos5l_Corner_1.vss sg13_lv_nmos ad=95f pd=0.88u as=95f ps=0.88u w=0.5u l=0.13u
X184 vdd a_96311_94375# a_97148_94596# vdd sg13_lv_pmos ad=0.2128p pd=1.5u as=0.3864p ps=2.93u w=1.12u l=0.13u
X185 a_87182_97322# adc8b_0.sar12b_0.sg13cmos5l_dfrbp_1_6.D vdd vdd sg13_lv_pmos ad=79.8f pd=0.8u as=0.1428p ps=1.52u w=0.42u l=0.13u
X186 a_93298_95028# a_93741_95071# a_93681_95107# vdd sg13_lv_pmos ad=79.8f pd=0.8u as=63f ps=0.72u w=0.42u l=0.13u
X187 adc8b_0.side_cap8b_1.buf_8_5.z adc8b_0.sar12b_0.nh_sw[5] vddr vddr sg13_lv_pmos ad=0.19p pd=1.38u as=0.19p ps=1.38u w=1u l=0.13u
X188 a_99468_94616# a_99442_94521# sg13cmos5l_Corner_1.vss sg13cmos5l_Corner_1.vss sg13_lv_nmos ad=0.2516p pd=2.16u as=0.1626p ps=1.415u w=0.74u l=0.13u
X189 vdd sg13cmos5l_IOPadVdd$1_0.sg13cmos5l_Clamp_N43N43D4R$1_0.gate sg13cmos5l_Corner_1.vss sg13cmos5l_Corner_1.vss sg13_hv_nmos ad=2.596p pd=5.58u as=1.408p ps=5.04u w=4.4u l=0.6u
X190 a_76796_95659# adc8b_0.cmp_0.clk vdd vdd sg13_lv_pmos ad=0.17p pd=1.68u as=95f ps=0.88u w=0.5u l=0.13u
X191 sg13cmos5l_Corner_1.vss a_102044_30676# data[2] sg13cmos5l_Corner_1.vss sg13_hv_nmos ad=2.068p pd=9.74u as=2.596p ps=5.58u w=4.4u l=0.6u
X192 sg13cmos5l_Corner_1.vss a_102044_30676# data[2] sg13cmos5l_Corner_1.vss sg13_hv_nmos ad=1.408p pd=5.04u as=2.596p ps=5.58u w=4.4u l=0.6u
X193 data[1] a_86044_42476# sg13cmos5l_Corner_1.iovdd sg13cmos5l_Corner_1.iovdd sg13_hv_pmos ad=3.9294p pd=7.84u as=2.1312p ps=7.3u w=6.66u l=0.6u
X194 adc8b_0.sar12b_0.sg13cmos5l_dlhr_1_0.Q_N a_89982_92768# sg13cmos5l_Corner_1.vss sg13cmos5l_Corner_1.vss sg13_lv_nmos ad=0.2516p pd=2.16u as=0.1491p ps=1.18u w=0.74u l=0.13u
X195 adc8b_0.sar12b_0.sg13cmos5l_nor2_1_1.A a_99356_93548# sg13cmos5l_Corner_1.vss sg13cmos5l_Corner_1.vss sg13_lv_nmos ad=0.2516p pd=2.16u as=0.1406p ps=1.12u w=0.74u l=0.13u
X196 sg13cmos5l_Corner_1.iovdd a_42476_102044# vip sg13cmos5l_Corner_1.iovdd sg13_hv_pmos ad=2.1312p pd=7.3u as=3.9294p ps=7.84u w=6.66u l=0.6u
X197 adc8b_0.sar12b_0.sg13cmos5l_dlhr_1_20.Q_N a_91998_95792# vdd vdd sg13_lv_pmos ad=0.3808p pd=2.92u as=0.1974p ps=1.5u w=1.12u l=0.13u
X198 adc8b_0.side_cap8b_1.buf_16_2.z adc8b_0.sar12b_0.nl_sw[1] vddr vddr sg13_lv_pmos ad=0.19p pd=1.38u as=0.19p ps=1.38u w=1u l=0.13u
X199 vdd adc8b_0.sar12b_0.sg13cmos5l_dfrbp_1_0.RESET_B a_92942_93986# vdd sg13_lv_pmos ad=0.36237p pd=2.605u as=79.8f ps=0.8u w=0.42u l=0.13u
X200 a_91028_93512# adc8b_0.sar12b_0.sg13cmos5l_buf_1_30.X sg13cmos5l_Corner_1.vss sg13cmos5l_Corner_1.vss sg13_lv_nmos ad=0.187p pd=1.78u as=0.14875p ps=1.16u w=0.55u l=0.13u
X201 sg13cmos5l_Corner_1.vss a_87405_93559# a_87507_93559# sg13cmos5l_Corner_1.vss sg13_lv_nmos ad=2.59257p pd=16.445u as=0.2516p ps=2.16u w=0.74u l=0.13u
X202 vdd a_83170_95024# a_82889_95326# vdd sg13_lv_pmos ad=0.1523p pd=1.38u as=0.34p ps=2.68u w=1u l=0.5u
X203 sg13cmos5l_Corner_1.iovdd a_164624_118044# sg13cmos5l_IOPadAnalog_11.pad sg13cmos5l_Corner_1.iovdd sg13_hv_pmos ad=2.1312p pd=7.3u as=3.9294p ps=7.84u w=6.66u l=0.6u
X204 adc8b_0.side_cap8b_1.buf_8_4.z adc8b_0.sar12b_0.nl_sw[5] sg13cmos5l_Corner_1.vss sg13cmos5l_Corner_1.vss sg13_lv_nmos ad=0.17p pd=1.68u as=95f ps=0.88u w=0.5u l=0.13u
X205 sg13cmos5l_Corner_1.vss adc8b_0.sar12b_0.nh_sw[1] adc8b_0.side_cap8b_1.buf_16_3.z sg13cmos5l_Corner_1.vss sg13_lv_nmos ad=95f pd=0.88u as=95f ps=0.88u w=0.5u l=0.13u
X206 sg13cmos5l_Corner_1.vss sg13cmos5l_IOPadVdd$1_0.sg13cmos5l_Clamp_N43N43D4R$1_0.gate vdd sg13cmos5l_Corner_1.vss sg13_hv_nmos ad=1.408p pd=5.04u as=2.596p ps=5.58u w=4.4u l=0.6u
X207 adc8b_0.side_cap8b_1.buf_32_0.z adc8b_0.sar12b_0.nl_sw[0] sg13cmos5l_Corner_1.vss sg13cmos5l_Corner_1.vss sg13_lv_nmos ad=95f pd=0.88u as=95f ps=0.88u w=0.5u l=0.13u
X208 a_95002_92786# adc8b_0.sar12b_0.sg13cmos5l_dfrbp_1_0.RESET_B sg13cmos5l_Corner_1.vss sg13cmos5l_Corner_1.vss sg13_lv_nmos ad=37.8f pd=0.6u as=79.8f ps=0.8u w=0.42u l=0.13u
X209 sg13cmos5l_Corner_1.vss sg13cmos5l_IOPadVdd$1_0.sg13cmos5l_Clamp_N43N43D4R$1_0.gate vdd sg13cmos5l_Corner_1.vss sg13_hv_nmos ad=1.408p pd=5.04u as=2.596p ps=5.58u w=4.4u l=0.6u
X210 sg13cmos5l_IOPadVdd$1_0.sg13cmos5l_Clamp_N43N43D4R$1_0.gate sg13cmos5l_IOPadVdd$1_0.sg13cmos5l_RCClampInverter$1_0.in vdd vdd sg13_hv_pmos ad=1.33p pd=7.38u as=1.33p ps=7.38u w=7u l=0.5u
X211 adc8b_0.side_cap8b_0.in_h_sw[2] a_85744_100384# vdd vdd sg13_lv_pmos ad=0.42p pd=2.99u as=0.2114p ps=1.54u w=1.12u l=0.13u
X212 sg13cmos5l_Corner_1.vss vdd sg13cmos5l_Corner_1.vss sg13cmos5l_Corner_1.vss sg13_lv_nmos ad=0.1428p pd=1.52u as=0 ps=0 w=0.42u l=1u
X213 sg13cmos5l_Corner_1.vss a_178296_118044# sg13cmos5l_IOPadAnalog_11.pad sg13cmos5l_Corner_1.vss sg13_hv_nmos ad=1.408p pd=5.04u as=2.596p ps=5.58u w=4.4u l=0.6u
X214 sg13cmos5l_Corner_1.iovdd a_99639_164698# sg13cmos5l_Corner_1.iovdd rppd l=12.9u w=0.5u
X215 sg13cmos5l_Corner_1.vss a_30676_70044# vddr sg13cmos5l_Corner_1.vss sg13_hv_nmos ad=1.408p pd=5.04u as=2.596p ps=5.58u w=4.4u l=0.6u
X216 a_84500_100310# adc8b_0.sar12b_0.sg13cmos5l_inv_1_20.Y vdd vdd sg13_lv_pmos ad=0.2856p pd=2.36u as=0.2114p ps=1.54u w=0.84u l=0.13u
X217 sg13cmos5l_Corner_1.vss a_84177_95810# a_84702_95792# sg13cmos5l_Corner_1.vss sg13_lv_nmos ad=0.1491p pd=1.18u as=0.187p ps=1.78u w=0.55u l=0.13u
X218 a_100628_98048# adc8b_0.sar12b_0.sg13cmos5l_buf_1_87.A vdd vdd sg13_lv_pmos ad=0.2856p pd=2.36u as=0.2114p ps=1.54u w=0.84u l=0.13u
X219 sg13cmos5l_IOPadAnalog_1.pad a_178296_70044# sg13cmos5l_Corner_1.vss sg13cmos5l_Corner_1.vss sg13_hv_nmos ad=2.596p pd=5.58u as=1.408p ps=5.04u w=4.4u l=0.6u
X220 sg13cmos5l_Corner_1.iovdd a_164624_86044# sg13cmos5l_IOPadAnalog_0.pad sg13cmos5l_Corner_1.iovdd sg13_hv_pmos ad=2.1312p pd=7.3u as=3.9294p ps=7.84u w=6.66u l=0.6u
X221 sg13cmos5l_Corner_1.iovdd a_164624_118044# sg13cmos5l_IOPadAnalog_11.pad sg13cmos5l_Corner_1.iovdd sg13_hv_pmos ad=2.1312p pd=7.3u as=3.9294p ps=7.84u w=6.66u l=0.6u
X222 adc8b_0.side_cap8b_0.buf_32_1.z adc8b_0.side_cap8b_0.in_h_sw[0] vddr vddr sg13_lv_pmos ad=0.19p pd=1.38u as=0.19p ps=1.38u w=1u l=0.13u
X223 adc8b_0.side_cap8b_0.in_l_sw[5] a_89104_100384# sg13cmos5l_Corner_1.vss sg13cmos5l_Corner_1.vss sg13_lv_nmos ad=0.2886p pd=2.26u as=0.14875p ps=1.16u w=0.74u l=0.13u
X224 sg13cmos5l_Corner_1.vss a_90957_99607# a_91059_99607# sg13cmos5l_Corner_1.vss sg13_lv_nmos ad=2.92392p pd=18.89u as=0.2516p ps=2.16u w=0.74u l=0.13u
X225 sg13cmos5l_IOPadAnalog_15.pad a_99639_164698# sg13cmos5l_Corner_1.iovdd sg13cmos5l_Corner_1.iovdd sg13_hv_pmos ad=3.9294p pd=7.84u as=2.1312p ps=7.3u w=6.66u l=0.6u
X226 sg13cmos5l_IOPadAnalog_12.pad sg13cmos5l_IOPadAnalog_12.padres sg13cmos5l_Corner_1.vss rppd l=2u w=1u
X227 cko a_118044_42476# sg13cmos5l_Corner_1.iovdd sg13cmos5l_Corner_1.iovdd sg13_hv_pmos ad=3.9294p pd=7.84u as=2.1312p ps=7.3u w=6.66u l=0.6u
X228 vdd adc8b_0.sar12b_0.sg13cmos5l_buf_1_33.A a_84016_92824# vdd sg13_lv_pmos ad=0.2114p pd=1.54u as=0.2856p ps=2.36u w=0.84u l=0.13u
X229 sg13cmos5l_Corner_1.iovdd a_42476_70044# vddr sg13cmos5l_Corner_1.iovdd sg13_hv_pmos ad=2.1312p pd=7.3u as=3.9294p ps=7.84u w=6.66u l=0.6u
X230 vdd a_96945_96929# a_96878_96572# vdd sg13_lv_pmos ad=0.2387p pd=1.84u as=0.1008p ps=0.9u w=0.42u l=0.13u
X231 sg13cmos5l_IOPadAnalog_13.pad a_115639_164698# sg13cmos5l_Corner_1.iovdd sg13cmos5l_Corner_1.iovdd sg13_hv_pmos ad=3.9294p pd=7.84u as=2.1312p ps=7.3u w=6.66u l=0.6u
X232 a_85432_95302# a_85175_95421# a_85594_95498# sg13cmos5l_Corner_1.vss sg13_lv_nmos ad=0.1428p pd=1.52u as=37.8f ps=0.6u w=0.42u l=0.13u
X233 a_87260_94620# a_86847_94314# a_87192_94620# vdd sg13_lv_pmos ad=0.191p pd=1.44u as=0.105p ps=1.21u w=1u l=0.13u
X234 vdd sg13cmos5l_IOPadVdd$1_0.sg13cmos5l_Clamp_N43N43D4R$1_0.gate sg13cmos5l_Corner_1.vss sg13cmos5l_Corner_1.vss sg13_hv_nmos ad=2.596p pd=5.58u as=1.408p ps=5.04u w=4.4u l=0.6u
X235 a_99135_99954# adc8b_0.sar12b_0.sg13cmos5l_dfrbp_1_22.D vdd vdd sg13_lv_pmos ad=0.3234p pd=2.45u as=1.12242p ps=7u w=0.84u l=0.13u
X236 adc8b_0.diff_bsw_0.single_bsw_1.sg13cmos5l_inv_1$1_0.Y adc8b_0.diff_bsw_0.single_bsw_1.sg13cmos5l_inv_1$1_0.A vdd vdd sg13_lv_pmos ad=0.3808p pd=2.92u as=0.3808p ps=2.92u w=1.12u l=0.13u
X237 sg13cmos5l_Corner_1.iovdd a_83639_164698# sg13cmos5l_IOPadAnalog_9.pad sg13cmos5l_Corner_1.iovdd sg13_hv_pmos ad=2.1312p pd=7.3u as=3.9294p ps=7.84u w=6.66u l=0.6u
X238 vddr adc8b_0.side_cap8b_0.in_l_sw[0] adc8b_0.side_cap8b_0.buf_32_0.z vddr sg13_lv_pmos ad=0.19p pd=1.38u as=0.19p ps=1.38u w=1u l=0.13u
X239 adc8b_0.side_cap8b_0.buf_16_0.z adc8b_0.side_cap8b_0.in_h_sw[2] vddr vddr sg13_lv_pmos ad=0.19p pd=1.38u as=0.19p ps=1.38u w=1u l=0.13u
X240 adc8b_0.side_cap8b_0.buf_8_2.z adc8b_0.side_cap8b_0.in_h_sw[4] sg13cmos5l_Corner_1.vss sg13cmos5l_Corner_1.vss sg13_lv_nmos ad=95f pd=0.88u as=95f ps=0.88u w=0.5u l=0.13u
X241 vip a_42476_102044# sg13cmos5l_Corner_1.iovdd sg13cmos5l_Corner_1.iovdd sg13_hv_pmos ad=3.9294p pd=7.84u as=3.1302p ps=14.26u w=6.66u l=0.6u
X242 vddr adc8b_0.side_cap8b_0.in_h_sw[1] adc8b_0.side_cap8b_0.buf_16_3.z vddr sg13_lv_pmos ad=0.19p pd=1.38u as=0.34p ps=2.68u w=1u l=0.13u
X243 vddr adc8b_0.sar12b_0.nh_sw[4] adc8b_0.side_cap8b_1.buf_8_2.z vddr sg13_lv_pmos ad=0.19p pd=1.38u as=0.19p ps=1.38u w=1u l=0.13u
X244 a_98516_100310# adc8b_0.sar12b_0.sg13cmos5l_buf_1_93.X sg13cmos5l_Corner_1.vss sg13cmos5l_Corner_1.vss sg13_lv_nmos ad=0.187p pd=1.78u as=0.14875p ps=1.16u w=0.55u l=0.13u
X245 a_96110_100034# a_96915_99607# a_96370_99564# vdd sg13_lv_pmos ad=0.1428p pd=1.52u as=79.8f ps=0.8u w=0.42u l=0.13u
X246 data[1] a_86044_42476# sg13cmos5l_Corner_1.iovdd sg13cmos5l_Corner_1.iovdd sg13_hv_pmos ad=3.9294p pd=7.84u as=2.1312p ps=7.3u w=6.66u l=0.6u
X247 vip a_42476_102044# sg13cmos5l_Corner_1.iovdd sg13cmos5l_Corner_1.iovdd sg13_hv_pmos ad=3.9294p pd=7.84u as=2.1312p ps=7.3u w=6.66u l=0.6u
X248 vdd a_90207_97338# a_90338_97332# vdd sg13_lv_pmos ad=1.07253p pd=6.75u as=0.2856p ps=2.36u w=0.84u l=0.13u
X249 sg13cmos5l_IOPadAnalog_15.pad sg13cmos5l_Corner_1.iovdd dpantenna l=1.26u w=27.78u
X250 a_92364_98847# a_92076_99152# a_92302_98847# sg13cmos5l_Corner_1.vss sg13_lv_nmos ad=0.1428p pd=1.52u as=37.8f ps=0.6u w=0.42u l=0.13u
X251 a_96494_98834# a_97299_98956# a_96754_99057# vdd sg13_lv_pmos ad=0.1428p pd=1.52u as=79.8f ps=0.8u w=0.42u l=0.13u
X252 a_94641_97713# a_94284_97640# vdd vdd sg13_lv_pmos ad=63f pd=0.72u as=0.1563p ps=1.22u w=0.42u l=0.13u
X253 adc8b_0.sar12b_0.sg13cmos5l_inv_1_0.A a_95420_95060# vdd vdd sg13_lv_pmos ad=0.3808p pd=2.92u as=0.2128p ps=1.5u w=1.12u l=0.13u
X254 sg13cmos5l_Corner_1.vss a_178296_102044# sg13cmos5l_IOPadAnalog_16.pad sg13cmos5l_Corner_1.vss sg13_hv_nmos ad=1.408p pd=5.04u as=2.596p ps=5.58u w=4.4u l=0.6u
X255 sg13cmos5l_Corner_1.vss a_134044_30676# frame sg13cmos5l_Corner_1.vss sg13_hv_nmos ad=1.408p pd=5.04u as=2.596p ps=5.58u w=4.4u l=0.6u
X256 vddr adc8b_0.sar12b_0.nl_sw[9] adc8b_0.side_cap8b_1.buf_2_2.z vddr sg13_lv_pmos ad=0.19p pd=1.38u as=0.34p ps=2.68u w=1u l=0.13u
X257 vdd a_94929_98441# a_95454_98514# vdd sg13_lv_pmos ad=0.1974p pd=1.5u as=0.2856p ps=2.36u w=0.84u l=0.13u
X258 sg13cmos5l_Corner_1.iovdd a_102044_42476# data[2] sg13cmos5l_Corner_1.iovdd sg13_hv_pmos ad=2.1312p pd=7.3u as=3.9294p ps=7.84u w=6.66u l=0.6u
X259 sg13cmos5l_Corner_1.vss adc8b_0.sar12b_0.nl_sw[6] adc8b_0.side_cap8b_1.buf_4_3.z sg13cmos5l_Corner_1.vss sg13_lv_nmos ad=95f pd=0.88u as=0.17p ps=1.68u w=0.5u l=0.13u
X260 vin a_42476_86044# sg13cmos5l_Corner_1.iovdd sg13cmos5l_Corner_1.iovdd sg13_hv_pmos ad=3.9294p pd=7.84u as=2.1312p ps=7.3u w=6.66u l=0.6u
X261 sg13cmos5l_Corner_1.iovdd a_42476_70044# vddr sg13cmos5l_Corner_1.iovdd sg13_hv_pmos ad=2.1312p pd=7.3u as=3.9294p ps=7.84u w=6.66u l=0.6u
X262 sg13cmos5l_Corner_1.vss a_100995_100350# adc8b_0.sar12b_0.sg13cmos5l_buf_8_2.X sg13cmos5l_Corner_1.vss sg13_lv_nmos ad=0.1406p pd=1.12u as=0.1406p ps=1.12u w=0.74u l=0.13u
X263 a_96110_100034# adc8b_0.sar12b_0.sg13cmos5l_dfrbp_1_23.CLK vdd vdd sg13_lv_pmos ad=79.8f pd=0.8u as=0.1428p ps=1.52u w=0.42u l=0.13u
X264 adc8b_0.side_cap8b_1.buf_16_3.z adc8b_0.sar12b_0.nh_sw[1] vddr vddr sg13_lv_pmos ad=0.19p pd=1.38u as=0.19p ps=1.38u w=1u l=0.13u
X265 vdd a_83348_93512# adc8b_0.sar12b_0.nh_sw[0] vdd sg13_lv_pmos ad=0.2114p pd=1.54u as=0.42p ps=2.99u w=1.12u l=0.13u
X266 vdd sg13cmos5l_IOPadVdd$1_0.sg13cmos5l_Clamp_N43N43D4R$1_0.gate sg13cmos5l_Corner_1.vss sg13cmos5l_Corner_1.vss sg13_hv_nmos ad=2.596p pd=5.58u as=1.408p ps=5.04u w=4.4u l=0.6u
X267 adc8b_0.sar12b_0.sg13cmos5l_buf_1_93.X a_96400_100384# vdd vdd sg13_lv_pmos ad=0.42p pd=2.99u as=0.2114p ps=1.54u w=1.12u l=0.13u
X268 sg13cmos5l_Corner_1.vss adc8b_0.sar12b_0.sg13cmos5l_buf_1_40.A adc8b_0.sar12b_0.sg13cmos5l_buf_1_63.A sg13cmos5l_Corner_1.vss sg13_lv_nmos ad=0.2516p pd=2.16u as=0.2516p ps=2.16u w=0.74u l=0.13u
X269 sg13cmos5l_Corner_1.vss adc8b_0.side_cap8b_0.in_l_sw[2] adc8b_0.side_cap8b_0.buf_16_1.z sg13cmos5l_Corner_1.vss sg13_lv_nmos ad=95f pd=0.88u as=95f ps=0.88u w=0.5u l=0.13u
X270 adc8b_0.sar12b_0.sg13cmos5l_dfrbp_1_23.CLK a_95996_100644# sg13cmos5l_Corner_1.vss sg13cmos5l_Corner_1.vss sg13_lv_nmos ad=0.2516p pd=2.16u as=0.1406p ps=1.12u w=0.74u l=0.13u
X271 sg13cmos5l_Corner_1.vss adc8b_0.sar12b_0.sg13cmos5l_dfrbp_1_6.RESET_B a_90460_98472# sg13cmos5l_Corner_1.vss sg13_lv_nmos ad=0.1406p pd=1.12u as=77.7f ps=0.95u w=0.74u l=0.13u
X272 adc8b_0.sar12b_0.sg13cmos5l_dlhr_1_16.Q_N a_101502_97002# vdd vdd sg13_lv_pmos ad=0.3808p pd=2.92u as=0.1974p ps=1.5u w=1.12u l=0.13u
X273 a_88140_96128# a_88114_96033# sg13cmos5l_Corner_1.vss sg13cmos5l_Corner_1.vss sg13_lv_nmos ad=0.2516p pd=2.16u as=0.1626p ps=1.415u w=0.74u l=0.13u
X274 sg13cmos5l_Corner_1.vss a_134222_32962# dantenna l=1.26u w=27.78u
X275 a_100696_93006# adc8b_0.sar12b_0.sg13cmos5l_dfrbp_1_0.RESET_B vdd vdd sg13_lv_pmos ad=79.8f pd=0.8u as=1.777p ps=11.395u w=0.42u l=0.13u
X276 a_87478_97010# a_87719_96543# a_86837_96536# sg13cmos5l_Corner_1.vss sg13_lv_nmos ad=0.1428p pd=1.52u as=0.12665p ps=1.145u w=0.42u l=0.13u
X277 adc8b_0.sar12b_0.sg13cmos5l_dfrbp_1_1.Q_N a_94583_92863# vdd vdd sg13_lv_pmos ad=0.4312p pd=3.01u as=0.2639p ps=1.81u w=1.12u l=0.13u
X278 adc8b_0.side_cap8b_0.buf_4_3.z adc8b_0.side_cap8b_0.in_l_sw[6] sg13cmos5l_Corner_1.vss sg13cmos5l_Corner_1.vss sg13_lv_nmos ad=0.17p pd=1.68u as=95f ps=0.88u w=0.5u l=0.13u
X279 cko a_118044_42476# sg13cmos5l_Corner_1.iovdd sg13cmos5l_Corner_1.iovdd sg13_hv_pmos ad=3.9294p pd=7.84u as=3.1302p ps=14.26u w=6.66u l=0.6u
X280 sg13cmos5l_IOPadAnalog_13.pad a_115639_164698# sg13cmos5l_Corner_1.iovdd sg13cmos5l_Corner_1.iovdd sg13_hv_pmos ad=3.9294p pd=7.84u as=2.1312p ps=7.3u w=6.66u l=0.6u
X281 data[1] a_86044_30676# sg13cmos5l_Corner_1.vss sg13cmos5l_Corner_1.vss sg13_hv_nmos ad=2.596p pd=5.58u as=1.408p ps=5.04u w=4.4u l=0.6u
X282 sg13cmos5l_Corner_1.vss adc8b_0.sar12b_0.nh_sw[2] adc8b_0.side_cap8b_1.buf_16_0.z sg13cmos5l_Corner_1.vss sg13_lv_nmos ad=95f pd=0.88u as=95f ps=0.88u w=0.5u l=0.13u
X283 adc8b_0.sar12b_0.sg13cmos5l_dfrbp_1_0.Q a_101276_93084# sg13cmos5l_Corner_1.vss sg13cmos5l_Corner_1.vss sg13_lv_nmos ad=0.2516p pd=2.16u as=0.1406p ps=1.12u w=0.74u l=0.13u
X284 sg13cmos5l_IOPadAnalog_12.pad a_131639_164698# sg13cmos5l_Corner_1.iovdd sg13cmos5l_Corner_1.iovdd sg13_hv_pmos ad=3.9294p pd=7.84u as=2.1312p ps=7.3u w=6.66u l=0.6u
X285 a_90540_99600# a_90514_99564# vdd vdd sg13_lv_pmos ad=0.34p pd=2.68u as=0.36237p ps=2.605u w=1u l=0.13u
X286 sg13cmos5l_Corner_1.vss a_97912_99838# a_97561_99957# sg13cmos5l_Corner_1.vss sg13_lv_nmos ad=79.8f pd=0.8u as=0.1428p ps=1.52u w=0.42u l=0.13u
X287 a_94487_93909# a_93645_93559# a_94393_93909# sg13cmos5l_Corner_1.vss sg13_lv_nmos ad=0.12665p pd=1.145u as=0.1428p ps=1.52u w=0.42u l=0.13u
X288 a_87885_97301# adc8b_0.sar12b_0.sg13cmos5l_dlhr_1_5.GATE sg13cmos5l_Corner_1.vss sg13cmos5l_Corner_1.vss sg13_lv_nmos ad=0.2516p pd=2.16u as=1.97045p ps=12.335u w=0.74u l=0.13u
X289 a_82190_97010# a_82995_96583# a_82450_96540# vdd sg13_lv_pmos ad=0.1428p pd=1.52u as=79.8f ps=0.8u w=0.42u l=0.13u
X290 vdd a_90609_96929# a_91134_97002# vdd sg13_lv_pmos ad=0.1974p pd=1.5u as=0.2856p ps=2.36u w=0.84u l=0.13u
X291 adc8b_0.side_cap8b_1.buf_16_2.z adc8b_0.sar12b_0.nl_sw[1] sg13cmos5l_Corner_1.vss sg13cmos5l_Corner_1.vss sg13_lv_nmos ad=95f pd=0.88u as=95f ps=0.88u w=0.5u l=0.13u
X292 vdd adc8b_0.sar12b_0.sg13cmos5l_buf_1_8.X a_93424_94336# vdd sg13_lv_pmos ad=0.2114p pd=1.54u as=0.2856p ps=2.36u w=0.84u l=0.13u
X293 frame a_134044_30676# sg13cmos5l_Corner_1.vss sg13cmos5l_Corner_1.vss sg13_hv_nmos ad=2.596p pd=5.58u as=1.408p ps=5.04u w=4.4u l=0.6u
X294 vddr adc8b_0.sar12b_0.nh_sw[0] adc8b_0.side_cap8b_1.buf_32_1.z vddr sg13_lv_pmos ad=0.19p pd=1.38u as=0.19p ps=1.38u w=1u l=0.13u
X295 sg13cmos5l_IOPadAnalog_10.pad a_67639_164698# sg13cmos5l_Corner_1.iovdd sg13cmos5l_Corner_1.iovdd sg13_hv_pmos ad=3.9294p pd=7.84u as=2.1312p ps=7.3u w=6.66u l=0.6u
X296 sg13cmos5l_Corner_1.vss adc8b_0.sar12b_0.sg13cmos5l_dfrbp_1_12.Q_N a_90673_95864# sg13cmos5l_Corner_1.vss sg13_lv_nmos ad=0.15055p pd=1.17u as=0.187p ps=1.78u w=0.55u l=0.13u
X297 sg13cmos5l_IOPadAnalog_9.pad a_83639_164698# sg13cmos5l_Corner_1.iovdd sg13cmos5l_Corner_1.iovdd sg13_hv_pmos ad=3.9294p pd=7.84u as=2.1312p ps=7.3u w=6.66u l=0.6u
X298 sg13cmos5l_Corner_1.vss sg13cmos5l_IOPadVdd$1_0.sg13cmos5l_Clamp_N43N43D4R$1_0.gate vdd sg13cmos5l_Corner_1.vss sg13_hv_nmos ad=1.408p pd=5.04u as=2.596p ps=5.58u w=4.4u l=0.6u
X299 vdd sg13cmos5l_IOPadVdd$1_0.sg13cmos5l_Clamp_N43N43D4R$1_0.gate sg13cmos5l_Corner_1.vss sg13cmos5l_Corner_1.vss sg13_hv_nmos ad=2.596p pd=5.58u as=1.408p ps=5.04u w=4.4u l=0.6u
X300 sg13cmos5l_Corner_1.iovdd a_42476_86044# vin sg13cmos5l_Corner_1.iovdd sg13_hv_pmos ad=3.1302p pd=14.26u as=3.9294p ps=7.84u w=6.66u l=0.6u
X301 a_99160_96030# a_98903_95887# a_99322_95810# sg13cmos5l_Corner_1.vss sg13_lv_nmos ad=0.1428p pd=1.52u as=37.8f ps=0.6u w=0.42u l=0.13u
X302 a_99284_100310# adc8b_0.sar12b_0.sg13cmos5l_buf_1_103.A vdd vdd sg13_lv_pmos ad=0.2856p pd=2.36u as=0.2114p ps=1.54u w=0.84u l=0.13u
X303 vdd adc8b_0.sar12b_0.sg13cmos5l_inv_1_5.A a_102160_95060# vdd sg13_lv_pmos ad=0.2114p pd=1.54u as=0.2856p ps=2.36u w=0.84u l=0.13u
X304 sg13cmos5l_IOPadAnalog_3.padres cko sg13cmos5l_Corner_1.vss rppd l=2u w=1u
X305 adc8b_0.sar12b_0.sg13cmos5l_dfrbp_1_7.Q_N a_96311_94375# vdd vdd sg13_lv_pmos ad=0.4312p pd=3.01u as=0.2639p ps=1.81u w=1.12u l=0.13u
X306 a_88509_96619# adc8b_0.sar12b_0.sg13cmos5l_dfrbp_1_8.RESET_B vdd vdd sg13_lv_pmos ad=0.147p pd=1.54u as=0.1563p ps=1.22u w=0.42u l=0.13u
X307 sg13cmos5l_IOPadAnalog_16.padres sg13cmos5l_Corner_1.iovdd dpantenna l=4.98u w=0.64u
X308 adc8b_0.side_cap8b_1.buf_16_3.z adc8b_0.sar12b_0.nh_sw[1] sg13cmos5l_Corner_1.vss sg13cmos5l_Corner_1.vss sg13_lv_nmos ad=95f pd=0.88u as=95f ps=0.88u w=0.5u l=0.13u
X309 vddr adc8b_0.sar12b_0.nl_sw[1] adc8b_0.side_cap8b_1.buf_16_2.z vddr sg13_lv_pmos ad=0.19p pd=1.38u as=0.34p ps=2.68u w=1u l=0.13u
X310 vdd adc8b_0.sar12b_0.sg13cmos5l_buf_1_29.A a_91600_92824# vdd sg13_lv_pmos ad=0.2114p pd=1.54u as=0.2856p ps=2.36u w=0.84u l=0.13u
X311 vdd a_91028_93512# adc8b_0.sar12b_0.nh_sw[4] vdd sg13_lv_pmos ad=0.2114p pd=1.54u as=0.42p ps=2.99u w=1.12u l=0.13u
X312 sg13cmos5l_Corner_1.iovdd a_115639_164698# sg13cmos5l_IOPadAnalog_13.pad sg13cmos5l_Corner_1.iovdd sg13_hv_pmos ad=2.1312p pd=7.3u as=3.9294p ps=7.84u w=6.66u l=0.6u
X313 adc8b_0.side_cap8b_0.buf_32_1.z adc8b_0.side_cap8b_0.in_h_sw[0] sg13cmos5l_Corner_1.vss sg13cmos5l_Corner_1.vss sg13_lv_nmos ad=95f pd=0.88u as=95f ps=0.88u w=0.5u l=0.13u
X314 a_100628_98048# adc8b_0.sar12b_0.sg13cmos5l_buf_1_87.A sg13cmos5l_Corner_1.vss sg13cmos5l_Corner_1.vss sg13_lv_nmos ad=0.187p pd=1.78u as=0.14875p ps=1.16u w=0.55u l=0.13u
X315 vdd sg13cmos5l_Corner_1.vss vdd vdd sg13_lv_pmos ad=0.19p pd=1.38u as=0 ps=0 w=1u l=1u
X316 sg13cmos5l_IOPadAnalog_0.pad a_164624_86044# sg13cmos5l_Corner_1.iovdd sg13cmos5l_Corner_1.iovdd sg13_hv_pmos ad=3.9294p pd=7.84u as=2.1312p ps=7.3u w=6.66u l=0.6u
X317 sg13cmos5l_Corner_1.vss adc8b_0.sar12b_0.nl_sw[0] adc8b_0.side_cap8b_1.buf_32_0.z sg13cmos5l_Corner_1.vss sg13_lv_nmos ad=95f pd=0.88u as=95f ps=0.88u w=0.5u l=0.13u
X318 sg13cmos5l_Corner_1.vss a_101396_93512# adc8b_0.sar12b_0.nh_sw[9] sg13cmos5l_Corner_1.vss sg13_lv_nmos ad=0.14875p pd=1.16u as=0.2886p ps=2.26u w=0.74u l=0.13u
X319 sg13cmos5l_Corner_1.vss a_92493_98813# a_92595_98956# sg13cmos5l_Corner_1.vss sg13_lv_nmos ad=1.49685p pd=9.6u as=0.2516p ps=2.16u w=0.74u l=0.13u
X320 frame a_101776_98872# vdd vdd sg13_lv_pmos ad=0.42p pd=2.99u as=0.2114p ps=1.54u w=1.12u l=0.13u
X321 sg13cmos5l_Corner_1.vss a_70044_30676# data[0] sg13cmos5l_Corner_1.vss sg13_hv_nmos ad=1.408p pd=5.04u as=2.596p ps=5.58u w=4.4u l=0.6u
X322 sg13cmos5l_IOPadAnalog_10.pad sg13cmos5l_Corner_1.iovdd dpantenna l=1.26u w=27.78u
X323 adc8b_0.side_cap8b_0.buf_32_1.z adc8b_0.side_cap8b_0.in_h_sw[0] vddr vddr sg13_lv_pmos ad=0.19p pd=1.38u as=0.19p ps=1.38u w=1u l=0.13u
X324 sg13cmos5l_Corner_1.vss adc8b_0.sar12b_0.sg13cmos5l_buf_1_61.X a_82768_100384# sg13cmos5l_Corner_1.vss sg13_lv_nmos ad=0.14875p pd=1.16u as=0.187p ps=1.78u w=0.55u l=0.13u
X325 adc8b_0.sar12b_0.sg13cmos5l_buf_1_57.X a_91216_98084# vdd vdd sg13_lv_pmos ad=0.42p pd=2.99u as=0.2114p ps=1.54u w=1.12u l=0.13u
X326 adc8b_0.side_cap8b_0.buf_4_2.z adc8b_0.side_cap8b_0.in_h_sw[7] sg13cmos5l_Corner_1.vss sg13cmos5l_Corner_1.vss sg13_lv_nmos ad=0.17p pd=1.68u as=95f ps=0.88u w=0.5u l=0.13u
X327 vdd a_98340_95421# a_99363_95107# vdd sg13_lv_pmos ad=0.1563p pd=1.22u as=63f ps=0.72u w=0.42u l=0.13u
X328 a_97677_93559# adc8b_0.sar12b_0.sg13cmos5l_dfrbp_1_0.CLK vdd vdd sg13_lv_pmos ad=0.4088p pd=2.97u as=1.777p ps=11.395u w=1.12u l=0.13u
X329 sg13cmos5l_Corner_1.vss a_70222_32962# dantenna l=1.26u w=27.78u
X330 adc8b_0.side_cap8b_1.buf_1_0.z adc8b_0.sar12b_0.nl_sw[10] vddr vddr sg13_lv_pmos ad=0.34p pd=2.68u as=0.34p ps=2.68u w=1u l=0.13u
X331 sg13cmos5l_Corner_1.vss a_82893_96583# a_82995_96583# sg13cmos5l_Corner_1.vss sg13_lv_nmos ad=1.97045p pd=12.335u as=0.2516p ps=2.16u w=0.74u l=0.13u
X332 sg13cmos5l_Corner_1.iovdd a_134044_42476# frame sg13cmos5l_Corner_1.iovdd sg13_hv_pmos ad=2.1312p pd=7.3u as=3.9294p ps=7.84u w=6.66u l=0.6u
X333 a_70044_30676# sg13cmos5l_Corner_1.vss sg13cmos5l_Corner_1.vss rppd l=3.54u w=0.5u
X334 a_98385_97713# a_98028_97640# vdd vdd sg13_lv_pmos ad=63f pd=0.72u as=0.1563p ps=1.22u w=0.42u l=0.13u
X335 a_92174_100784# a_91778_100356# a_92060_100668# vdd sg13_lv_pmos ad=0.1008p pd=0.9u as=0.191p ps=1.44u w=0.42u l=0.13u
X336 vdd adc8b_0.diff_bsw_0.single_bsw_1.sg13cmos5l_inv_1$1_2.A a_70852_94286# vdd sg13_lv_pmos ad=0.17p pd=1.68u as=0.17p ps=1.68u w=0.5u l=0.13u
X337 a_101396_93512# adc8b_0.sar12b_0.sg13cmos5l_buf_1_19.X sg13cmos5l_Corner_1.vss sg13cmos5l_Corner_1.vss sg13_lv_nmos ad=0.187p pd=1.78u as=0.14875p ps=1.16u w=0.55u l=0.13u
X338 a_95578_100346# adc8b_0.sar12b_0.sg13cmos5l_dfrbp_1_8.RESET_B sg13cmos5l_Corner_1.vss sg13cmos5l_Corner_1.vss sg13_lv_nmos ad=37.8f pd=0.6u as=79.8f ps=0.8u w=0.42u l=0.13u
X339 a_92201_95408# adc8b_0.sar12b_0.sg13cmos5l_dfrbp_1_10.Q adc8b_0.sar12b_0.sg13cmos5l_a22oi_1_1.B1 sg13cmos5l_Corner_1.vss sg13_lv_nmos ad=0.1406p pd=1.12u as=0.1406p ps=1.12u w=0.74u l=0.13u
X340 a_97068_93986# adc8b_0.sar12b_0.sg13cmos5l_nor2b_1_1.Y a_96974_93986# sg13cmos5l_Corner_1.vss sg13_lv_nmos ad=60.89999f pd=0.71u as=0.1428p ps=1.52u w=0.42u l=0.13u
X341 sg13cmos5l_IOPadAnalog_9.pad a_83639_164698# sg13cmos5l_Corner_1.iovdd sg13cmos5l_Corner_1.iovdd sg13_hv_pmos ad=3.9294p pd=7.84u as=2.1312p ps=7.3u w=6.66u l=0.6u
X342 a_82476_98088# a_82450_98052# sg13cmos5l_Corner_1.vss sg13cmos5l_Corner_1.vss sg13_lv_nmos ad=0.2516p pd=2.16u as=0.1626p ps=1.415u w=0.74u l=0.13u
X343 a_90514_99564# a_90957_99607# a_90254_100034# sg13cmos5l_Corner_1.vss sg13_lv_nmos ad=79.8f pd=0.8u as=0.1296p ps=1.52u w=0.42u l=0.13u
X344 sg13cmos5l_Corner_1.vss adc8b_0.sar12b_0.sg13cmos5l_buf_1_104.A a_101392_99596# sg13cmos5l_Corner_1.vss sg13_lv_nmos ad=0.14875p pd=1.16u as=0.187p ps=1.78u w=0.55u l=0.13u
X345 adc8b_0.sar12b_0.sg13cmos5l_dlhr_1_10.Q a_101361_97322# sg13cmos5l_Corner_1.vss sg13cmos5l_Corner_1.vss sg13_lv_nmos ad=0.2516p pd=2.16u as=0.1406p ps=1.12u w=0.74u l=0.13u
X346 adc8b_0.sar12b_0.sg13cmos5l_inv_1_0.A a_95420_95060# sg13cmos5l_Corner_1.vss sg13cmos5l_Corner_1.vss sg13_lv_nmos ad=0.2516p pd=2.16u as=0.1406p ps=1.12u w=0.74u l=0.13u
X347 data[0] a_70044_30676# sg13cmos5l_Corner_1.vss sg13cmos5l_Corner_1.vss sg13_hv_nmos ad=2.596p pd=5.58u as=1.408p ps=5.04u w=4.4u l=0.6u
X348 sg13cmos5l_Corner_1.vss a_93645_93559# a_93747_93559# sg13cmos5l_Corner_1.vss sg13_lv_nmos ad=2.59257p pd=16.445u as=0.2516p ps=2.16u w=0.74u l=0.13u
X349 data[2] sg13cmos5l_Corner_1.iovdd dpantenna l=1.26u w=27.78u
X350 sg13cmos5l_Corner_1.vss a_98516_100310# adc8b_0.side_cap8b_0.in_l_sw[7] sg13cmos5l_Corner_1.vss sg13_lv_nmos ad=0.14875p pd=1.16u as=0.2886p ps=2.26u w=0.74u l=0.13u
X351 a_84154_98522# adc8b_0.sar12b_0.sg13cmos5l_dfrbp_1_6.RESET_B sg13cmos5l_Corner_1.vss sg13cmos5l_Corner_1.vss sg13_lv_nmos ad=37.8f pd=0.6u as=79.8f ps=0.8u w=0.42u l=0.13u
X352 vdd adc8b_0.sar12b_0.sg13cmos5l_o21ai_1_0.B1 adc8b_0.sar12b_0.sg13cmos5l_o21ai_1_0.Y vdd sg13_lv_pmos ad=0.3808p pd=2.92u as=0.2128p ps=1.5u w=1.12u l=0.15u
X353 sg13cmos5l_Corner_1.iovdd a_115639_164698# sg13cmos5l_IOPadAnalog_13.pad sg13cmos5l_Corner_1.iovdd sg13_hv_pmos ad=2.1312p pd=7.3u as=3.9294p ps=7.84u w=6.66u l=0.6u
X354 sg13cmos5l_Corner_1.vss a_100995_100350# adc8b_0.sar12b_0.sg13cmos5l_buf_8_2.X sg13cmos5l_Corner_1.vss sg13_lv_nmos ad=0.1406p pd=1.12u as=0.1406p ps=1.12u w=0.74u l=0.13u
X355 a_84074_98820# adc8b_0.sar12b_0.sg13cmos5l_dfrbp_1_6.RESET_B sg13cmos5l_Corner_1.vss sg13cmos5l_Corner_1.vss sg13_lv_nmos ad=77.7f pd=0.95u as=0.1406p ps=1.12u w=0.74u l=0.13u
X356 sg13cmos5l_Corner_1.vss adc8b_0.sar12b_0.sg13cmos5l_dfrbp_1_20.Q a_91633_98442# sg13cmos5l_Corner_1.vss sg13_lv_nmos ad=0.15055p pd=1.17u as=0.187p ps=1.78u w=0.55u l=0.13u
X357 sg13cmos5l_Corner_1.iovdd a_131639_164698# sg13cmos5l_IOPadAnalog_12.pad sg13cmos5l_Corner_1.iovdd sg13_hv_pmos ad=2.1312p pd=7.3u as=3.9294p ps=7.84u w=6.66u l=0.6u
X358 a_96063_98442# adc8b_0.sar12b_0.sg13cmos5l_dfrbp_1_23.CLK sg13cmos5l_Corner_1.vss sg13cmos5l_Corner_1.vss sg13_lv_nmos ad=0.2516p pd=2.16u as=0.15055p ps=1.17u w=0.74u l=0.13u
X359 sg13cmos5l_Corner_1.vss adc8b_0.sar12b_0.nl_sw[2] adc8b_0.side_cap8b_1.buf_16_1.z sg13cmos5l_Corner_1.vss sg13_lv_nmos ad=95f pd=0.88u as=95f ps=0.88u w=0.5u l=0.13u
X360 vddr a_42476_70044# sg13cmos5l_Corner_1.iovdd sg13cmos5l_Corner_1.iovdd sg13_hv_pmos ad=3.9294p pd=7.84u as=2.1312p ps=7.3u w=6.66u l=0.6u
X361 adc8b_0.sar12b_0.sg13cmos5l_buf_1_46.A a_91473_95810# vdd vdd sg13_lv_pmos ad=0.3808p pd=2.92u as=0.2128p ps=1.5u w=1.12u l=0.13u
X362 a_101108_99560# adc8b_0.sar12b_0.sg13cmos5l_buf_1_107.X sg13cmos5l_Corner_1.vss sg13cmos5l_Corner_1.vss sg13_lv_nmos ad=0.187p pd=1.78u as=0.14875p ps=1.16u w=0.55u l=0.13u
X363 adc8b_0.sar12b_0.sg13cmos5l_dfrbp_1_23.Q_N a_95543_97399# sg13cmos5l_Corner_1.vss sg13cmos5l_Corner_1.vss sg13_lv_nmos ad=0.2849p pd=2.25u as=0.2516p ps=2.16u w=0.74u l=0.13u
X364 vdd sg13cmos5l_IOPadVdd$1_0.sg13cmos5l_Clamp_N43N43D4R$1_0.gate sg13cmos5l_Corner_1.vss sg13cmos5l_Corner_1.vss sg13_hv_nmos ad=2.596p pd=5.58u as=1.408p ps=5.04u w=4.4u l=0.6u
X365 sg13cmos5l_Corner_1.vss adc8b_0.side_cap8b_0.in_l_sw[1] adc8b_0.side_cap8b_0.buf_16_2.z sg13cmos5l_Corner_1.vss sg13_lv_nmos ad=95f pd=0.88u as=95f ps=0.88u w=0.5u l=0.13u
X366 sg13cmos5l_Corner_1.vss a_94929_98441# a_94884_98486# sg13cmos5l_Corner_1.vss sg13_lv_nmos ad=0.1428p pd=1.52u as=47.25f ps=0.645u w=0.42u l=0.13u
X367 sg13cmos5l_Corner_1.iovdd a_164624_70044# sg13cmos5l_IOPadAnalog_1.pad sg13cmos5l_Corner_1.iovdd sg13_hv_pmos ad=2.1312p pd=7.3u as=3.9294p ps=7.84u w=6.66u l=0.6u
X368 sg13cmos5l_Corner_1.iovdd a_83639_164698# sg13cmos5l_IOPadAnalog_9.pad sg13cmos5l_Corner_1.iovdd sg13_hv_pmos ad=2.1312p pd=7.3u as=3.9294p ps=7.84u w=6.66u l=0.6u
X369 sg13cmos5l_Corner_1.vss vdd sg13cmos5l_Corner_1.vss sg13cmos5l_Corner_1.vss sg13_lv_nmos ad=0.1428p pd=1.52u as=0 ps=0 w=0.42u l=1u
X370 a_88247_93909# a_87405_93559# a_86988_93552# vdd sg13_lv_pmos ad=0.2048p pd=1.63u as=0.34p ps=2.68u w=1u l=0.13u
X371 vddr adc8b_0.sar12b_0.nh_sw[1] adc8b_0.side_cap8b_1.buf_16_3.z vddr sg13_lv_pmos ad=0.19p pd=1.38u as=0.34p ps=2.68u w=1u l=0.13u
X372 sg13cmos5l_Corner_1.vss adc8b_0.sar12b_0.sg13cmos5l_inv_1_17.A adc8b_0.sar12b_0.sg13cmos5l_buf_1_37.A sg13cmos5l_Corner_1.vss sg13_lv_nmos ad=0.2516p pd=2.16u as=0.2516p ps=2.16u w=0.74u l=0.13u
X373 adc8b_0.side_cap8b_0.buf_8_0.z adc8b_0.side_cap8b_0.in_l_sw[4] sg13cmos5l_Corner_1.vss sg13cmos5l_Corner_1.vss sg13_lv_nmos ad=95f pd=0.88u as=95f ps=0.88u w=0.5u l=0.13u
X374 a_85582_95823# adc8b_0.sar12b_0.sg13cmos5l_dfrbp_1_8.RESET_B sg13cmos5l_Corner_1.vss sg13cmos5l_Corner_1.vss sg13_lv_nmos ad=37.8f pd=0.6u as=0.1701p ps=1.65u w=0.42u l=0.13u
X375 sg13cmos5l_Corner_1.vss adc8b_0.sar12b_0.nl_sw[3] adc8b_0.side_cap8b_1.buf_8_1.z sg13cmos5l_Corner_1.vss sg13_lv_nmos ad=95f pd=0.88u as=95f ps=0.88u w=0.5u l=0.13u
X376 adc8b_0.side_cap8b_0.buf_16_1.z adc8b_0.side_cap8b_0.in_l_sw[2] sg13cmos5l_Corner_1.vss sg13cmos5l_Corner_1.vss sg13_lv_nmos ad=95f pd=0.88u as=95f ps=0.88u w=0.5u l=0.13u
X377 a_99287_97399# a_98445_97301# a_99193_97399# sg13cmos5l_Corner_1.vss sg13_lv_nmos ad=0.12665p pd=1.145u as=0.1428p ps=1.52u w=0.42u l=0.13u
X378 a_93335_98911# a_92493_98813# a_92076_99152# vdd sg13_lv_pmos ad=0.2048p pd=1.63u as=0.34p ps=2.68u w=1u l=0.13u
X379 a_90044_98084# a_89762_98448# a_89977_98486# sg13cmos5l_Corner_1.vss sg13_lv_nmos ad=0.141p pd=1.17u as=71.99999f ps=0.865u w=0.64u l=0.13u
X380 adc8b_0.sar12b_0.sg13cmos5l_or2_1_0.A a_100131_95430# sg13cmos5l_Corner_1.vss sg13cmos5l_Corner_1.vss sg13_lv_nmos ad=0.1406p pd=1.12u as=0.1406p ps=1.12u w=0.74u l=0.13u
X381 sg13cmos5l_Corner_1.iovdd a_70044_42476# data[0] sg13cmos5l_Corner_1.iovdd sg13_hv_pmos ad=2.1312p pd=7.3u as=3.9294p ps=7.84u w=6.66u l=0.6u
X382 vdd adc8b_0.sar12b_0.sg13cmos5l_dfrbp_1_20.Q a_91633_98442# vdd sg13_lv_pmos ad=1.07253p pd=6.75u as=0.2856p ps=2.36u w=0.84u l=0.13u
X383 sg13cmos5l_Corner_1.vss a_90801_97322# a_90756_97358# sg13cmos5l_Corner_1.vss sg13_lv_nmos ad=0.1428p pd=1.52u as=47.25f ps=0.645u w=0.42u l=0.13u
X384 vdd sg13cmos5l_IOPadVdd$1_0.sg13cmos5l_Clamp_N43N43D4R$1_0.gate sg13cmos5l_Corner_1.vss sg13cmos5l_Corner_1.vss sg13_hv_nmos ad=2.596p pd=5.58u as=1.408p ps=5.04u w=4.4u l=0.6u
X385 sg13cmos5l_Corner_1.vss adc8b_0.sar12b_0.sg13cmos5l_inv_1_5.A a_102160_95060# sg13cmos5l_Corner_1.vss sg13_lv_nmos ad=0.14875p pd=1.16u as=0.187p ps=1.78u w=0.55u l=0.13u
X386 adc8b_0.side_cap8b_1.buf_8_1.z adc8b_0.sar12b_0.nl_sw[3] vddr vddr sg13_lv_pmos ad=0.19p pd=1.38u as=0.19p ps=1.38u w=1u l=0.13u
X387 sg13cmos5l_IOPadAnalog_12.pad sg13cmos5l_Corner_1.iovdd dpantenna l=1.26u w=27.78u
X388 sg13cmos5l_Corner_1.vss a_90609_96929# a_90564_96974# sg13cmos5l_Corner_1.vss sg13_lv_nmos ad=0.1428p pd=1.52u as=47.25f ps=0.645u w=0.42u l=0.13u
X389 adc8b_0.side_cap8b_1.buf_8_5.z adc8b_0.sar12b_0.nh_sw[5] vddr vddr sg13_lv_pmos ad=0.19p pd=1.38u as=0.19p ps=1.38u w=1u l=0.13u
X390 adc8b_0.sar12b_0.sg13cmos5l_dfrbp_1_4.D a_92232_93587# a_92381_93918# sg13cmos5l_Corner_1.vss sg13_lv_nmos ad=0.2516p pd=2.16u as=0.1406p ps=1.12u w=0.74u l=0.13u
X391 a_83252_100310# adc8b_0.sar12b_0.sg13cmos5l_inv_1_19.A sg13cmos5l_Corner_1.vss sg13cmos5l_Corner_1.vss sg13_lv_nmos ad=0.187p pd=1.78u as=0.14875p ps=1.16u w=0.55u l=0.13u
X392 frame a_134044_42476# sg13cmos5l_Corner_1.iovdd sg13cmos5l_Corner_1.iovdd sg13_hv_pmos ad=3.9294p pd=7.84u as=2.1312p ps=7.3u w=6.66u l=0.6u
X393 sg13cmos5l_IOPadAnalog_1.padres sg13cmos5l_Corner_1.iovdd dpantenna l=4.98u w=0.64u
X394 vdd a_86193_98441# a_86718_98514# vdd sg13_lv_pmos ad=0.1974p pd=1.5u as=0.2856p ps=2.36u w=0.84u l=0.13u
X395 sg13cmos5l_Corner_1.vss adc8b_0.sar12b_0.nh_sw[6] adc8b_0.side_cap8b_1.buf_4_1.z sg13cmos5l_Corner_1.vss sg13_lv_nmos ad=95f pd=0.88u as=95f ps=0.88u w=0.5u l=0.13u
X396 adc8b_0.side_cap8b_1.buf_32_1.z adc8b_0.sar12b_0.nh_sw[0] vddr vddr sg13_lv_pmos ad=0.19p pd=1.38u as=0.19p ps=1.38u w=1u l=0.13u
X397 data[1] a_86044_42476# sg13cmos5l_Corner_1.iovdd sg13cmos5l_Corner_1.iovdd sg13_hv_pmos ad=3.9294p pd=7.84u as=2.1312p ps=7.3u w=6.66u l=0.6u
X398 cks a_30676_118044# sg13cmos5l_Corner_1.vss sg13cmos5l_Corner_1.vss sg13_hv_nmos ad=2.596p pd=5.58u as=1.408p ps=5.04u w=4.4u l=0.6u
X399 vdd a_83716_99124# adc8b_0.sar12b_0.sg13cmos5l_buf_1_58.A vdd sg13_lv_pmos ad=0.2128p pd=1.5u as=0.3808p ps=2.92u w=1.12u l=0.13u
X400 adc8b_0.sar12b_0.sg13cmos5l_dlhr_1_11.Q_N a_95454_98514# sg13cmos5l_Corner_1.vss sg13cmos5l_Corner_1.vss sg13_lv_nmos ad=0.2516p pd=2.16u as=0.1491p ps=1.18u w=0.74u l=0.13u
X401 sg13cmos5l_Corner_1.vss a_84177_95810# a_84132_95846# sg13cmos5l_Corner_1.vss sg13_lv_nmos ad=0.1428p pd=1.52u as=47.25f ps=0.645u w=0.42u l=0.13u
X402 a_97618_96033# a_98061_95789# a_97358_95810# sg13cmos5l_Corner_1.vss sg13_lv_nmos ad=79.8f pd=0.8u as=0.1296p ps=1.52u w=0.42u l=0.13u
X403 adc8b_0.sar12b_0.nl_sw[6] a_93424_94336# sg13cmos5l_Corner_1.vss sg13cmos5l_Corner_1.vss sg13_lv_nmos ad=0.2886p pd=2.26u as=0.14875p ps=1.16u w=0.74u l=0.13u
X404 vdd adc8b_0.sar12b_0.sg13cmos5l_buf_1_3.A a_102064_92824# vdd sg13_lv_pmos ad=0.2114p pd=1.54u as=0.2856p ps=2.36u w=0.84u l=0.13u
X405 sg13cmos5l_Corner_1.vss a_89588_93512# adc8b_0.sar12b_0.sg13cmos5l_inv_1_14.A sg13cmos5l_Corner_1.vss sg13_lv_nmos ad=0.14875p pd=1.16u as=0.2886p ps=2.26u w=0.74u l=0.13u
X406 sg13cmos5l_IOPadAnalog_15.pad a_99639_164698# sg13cmos5l_Corner_1.iovdd sg13cmos5l_Corner_1.iovdd sg13_hv_pmos ad=3.9294p pd=7.84u as=2.1312p ps=7.3u w=6.66u l=0.6u
X407 sg13cmos5l_Corner_1.vss sg13cmos5l_IOPadVdd$1_0.sg13cmos5l_Clamp_N43N43D4R$1_0.gate vdd sg13cmos5l_Corner_1.vss sg13_hv_nmos ad=1.408p pd=5.04u as=2.596p ps=5.58u w=4.4u l=0.6u
X408 adc8b_0.sar12b_0.sg13cmos5l_buf_1_57.X a_91216_98084# sg13cmos5l_Corner_1.vss sg13cmos5l_Corner_1.vss sg13_lv_nmos ad=0.2886p pd=2.26u as=0.14875p ps=1.16u w=0.74u l=0.13u
X409 a_84132_95846# a_83583_95826# a_83996_96132# sg13cmos5l_Corner_1.vss sg13_lv_nmos ad=47.25f pd=0.645u as=0.141p ps=1.17u w=0.42u l=0.13u
X410 sg13cmos5l_Corner_1.iovdd a_164624_70044# sg13cmos5l_IOPadAnalog_1.pad sg13cmos5l_Corner_1.iovdd sg13_hv_pmos ad=2.1312p pd=7.3u as=3.9294p ps=7.84u w=6.66u l=0.6u
X411 sg13cmos5l_Corner_1.iovdd a_164624_102044# sg13cmos5l_IOPadAnalog_16.pad sg13cmos5l_Corner_1.iovdd sg13_hv_pmos ad=2.1312p pd=7.3u as=3.9294p ps=7.84u w=6.66u l=0.6u
X412 sg13cmos5l_IOPadAnalog_13.pad a_115639_164698# sg13cmos5l_Corner_1.iovdd sg13cmos5l_Corner_1.iovdd sg13_hv_pmos ad=3.9294p pd=7.84u as=2.1312p ps=7.3u w=6.66u l=0.6u
X413 a_98230_95498# a_97972_95498# sg13cmos5l_Corner_1.vss sg13cmos5l_Corner_1.vss sg13_lv_nmos ad=0.1428p pd=1.52u as=79.8f ps=0.8u w=0.42u l=0.13u
X414 sg13cmos5l_Corner_1.vss adc8b_0.sar12b_0.nh_sw[1] adc8b_0.side_cap8b_1.buf_16_3.z sg13cmos5l_Corner_1.vss sg13_lv_nmos ad=95f pd=0.88u as=95f ps=0.88u w=0.5u l=0.13u
X415 sg13cmos5l_Corner_1.vss sg13cmos5l_IOPadVdd$1_0.sg13cmos5l_Clamp_N43N43D4R$1_0.gate vdd sg13cmos5l_Corner_1.vss sg13_hv_nmos ad=1.408p pd=5.04u as=2.596p ps=5.58u w=4.4u l=0.6u
X416 vdd a_80694_96641# a_80806_96705# vdd sg13_lv_pmos ad=0.2254p pd=1.53u as=0.34p ps=2.68u w=1u l=0.5u
X417 a_86872_96030# a_86615_95887# a_87034_95810# sg13cmos5l_Corner_1.vss sg13_lv_nmos ad=0.1428p pd=1.52u as=37.8f ps=0.6u w=0.42u l=0.13u
X418 sg13cmos5l_Corner_1.iovdd a_83639_164698# sg13cmos5l_IOPadAnalog_9.pad sg13cmos5l_Corner_1.iovdd sg13_hv_pmos ad=2.1312p pd=7.3u as=3.9294p ps=7.84u w=6.66u l=0.6u
X419 adc8b_0.side_cap8b_0.buf_8_1.z adc8b_0.side_cap8b_0.in_l_sw[3] vddr vddr sg13_lv_pmos ad=0.19p pd=1.38u as=0.19p ps=1.38u w=1u l=0.13u
X420 a_85330_96033# a_85773_95789# a_85713_96201# vdd sg13_lv_pmos ad=79.8f pd=0.8u as=63f ps=0.72u w=0.42u l=0.13u
X421 cko a_118044_42476# sg13cmos5l_Corner_1.iovdd sg13cmos5l_Corner_1.iovdd sg13_hv_pmos ad=3.9294p pd=7.84u as=2.1312p ps=7.3u w=6.66u l=0.6u
X422 sg13cmos5l_Corner_1.vss adc8b_0.sar12b_0.sg13cmos5l_dlygate4sd3_1_0.X adc8b_0.sar12b_0.sg13cmos5l_buf_1_43.A sg13cmos5l_Corner_1.vss sg13_lv_nmos ad=0.2516p pd=2.16u as=0.2516p ps=2.16u w=0.74u l=0.13u
X423 sg13cmos5l_Corner_1.vss a_98708_94262# adc8b_0.sar12b_0.nh_sw[8] sg13cmos5l_Corner_1.vss sg13_lv_nmos ad=0.14875p pd=1.16u as=0.2886p ps=2.26u w=0.74u l=0.13u
X424 a_92099_95060# adc8b_0.sar12b_0.sg13cmos5l_a221oi_1_0.C1 vdd vdd sg13_lv_pmos ad=0.3808p pd=2.92u as=0.2128p ps=1.5u w=1.12u l=0.13u
X425 a_85844_98784# a_86117_98796# a_86079_98870# sg13cmos5l_Corner_1.vss sg13_lv_nmos ad=0.141p pd=1.17u as=47.25f ps=0.645u w=0.42u l=0.13u
X426 a_97932_95823# a_97644_96128# a_97870_95823# sg13cmos5l_Corner_1.vss sg13_lv_nmos ad=0.1428p pd=1.52u as=37.8f ps=0.6u w=0.42u l=0.13u
X427 adc8b_0.sar12b_0.sg13cmos5l_dlhr_1_17.Q_N a_91134_97002# sg13cmos5l_Corner_1.vss sg13cmos5l_Corner_1.vss sg13_lv_nmos ad=0.2516p pd=2.16u as=0.1491p ps=1.18u w=0.74u l=0.13u
X428 sg13cmos5l_Corner_1.vss adc8b_0.sar12b_0.nh_sw[4] adc8b_0.side_cap8b_1.buf_8_2.z sg13cmos5l_Corner_1.vss sg13_lv_nmos ad=95f pd=0.88u as=0.17p ps=1.68u w=0.5u l=0.13u
X429 sg13cmos5l_Corner_1.vss a_90551_98911# a_91388_99132# sg13cmos5l_Corner_1.vss sg13_lv_nmos ad=0.1406p pd=1.12u as=0.2516p ps=2.16u w=0.74u l=0.13u
X430 a_82388_93512# adc8b_0.sar12b_0.sg13cmos5l_buf_1_32.X sg13cmos5l_Corner_1.vss sg13cmos5l_Corner_1.vss sg13_lv_nmos ad=0.187p pd=1.78u as=0.14875p ps=1.16u w=0.55u l=0.13u
X431 vdd sg13cmos5l_IOPadVdd$1_0.sg13cmos5l_Clamp_N43N43D4R$1_0.gate sg13cmos5l_Corner_1.vss sg13cmos5l_Corner_1.vss sg13_hv_nmos ad=2.596p pd=5.58u as=1.408p ps=5.04u w=4.4u l=0.6u
X432 adc8b_0.side_cap8b_0.buf_32_0.z adc8b_0.side_cap8b_0.in_l_sw[0] sg13cmos5l_Corner_1.vss sg13cmos5l_Corner_1.vss sg13_lv_nmos ad=95f pd=0.88u as=95f ps=0.88u w=0.5u l=0.13u
X433 sg13cmos5l_Corner_1.vss vdd sg13cmos5l_Corner_1.vss sg13cmos5l_Corner_1.vss sg13_lv_nmos ad=0.1428p pd=1.52u as=0 ps=0 w=0.42u l=1u
X434 vip a_30676_102044# sg13cmos5l_Corner_1.vss sg13cmos5l_Corner_1.vss sg13_hv_nmos ad=2.596p pd=5.58u as=1.408p ps=5.04u w=4.4u l=0.6u
X435 vdd a_85076_96536# adc8b_0.sar12b_0.sg13cmos5l_buf_1_41.A vdd sg13_lv_pmos ad=0.2114p pd=1.54u as=0.42p ps=2.99u w=1.12u l=0.13u
X436 a_87220_97010# a_86837_96536# vdd vdd sg13_lv_pmos ad=79.8f pd=0.8u as=0.2639p ps=1.81u w=0.42u l=0.13u
X437 sg13cmos5l_Corner_1.vss a_86044_30676# data[1] sg13cmos5l_Corner_1.vss sg13_hv_nmos ad=1.408p pd=5.04u as=2.596p ps=5.58u w=4.4u l=0.6u
X438 adc8b_0.side_cap8b_0.buf_16_0.z adc8b_0.side_cap8b_0.in_h_sw[2] vddr vddr sg13_lv_pmos ad=0.19p pd=1.38u as=0.19p ps=1.38u w=1u l=0.13u
X439 a_91790_98834# a_92595_98956# a_92050_99057# vdd sg13_lv_pmos ad=0.1428p pd=1.52u as=79.8f ps=0.8u w=0.42u l=0.13u
X440 data[0] a_70044_42476# sg13cmos5l_Corner_1.iovdd sg13cmos5l_Corner_1.iovdd sg13_hv_pmos ad=3.9294p pd=7.84u as=2.1312p ps=7.3u w=6.66u l=0.6u
X441 sg13cmos5l_Corner_1.iovdd a_102044_42476# data[2] sg13cmos5l_Corner_1.iovdd sg13_hv_pmos ad=2.1312p pd=7.3u as=3.9294p ps=7.84u w=6.66u l=0.6u
X442 a_101780_93512# adc8b_0.sar12b_0.sg13cmos5l_buf_1_0.X vdd vdd sg13_lv_pmos ad=0.2856p pd=2.36u as=0.2114p ps=1.54u w=0.84u l=0.13u
X443 a_93900_100664# a_93874_100569# sg13cmos5l_Corner_1.vss sg13cmos5l_Corner_1.vss sg13_lv_nmos ad=0.2516p pd=2.16u as=0.1626p ps=1.415u w=0.74u l=0.13u
X444 sg13cmos5l_Corner_1.vss a_101361_97322# a_101886_97304# sg13cmos5l_Corner_1.vss sg13_lv_nmos ad=0.1491p pd=1.18u as=0.187p ps=1.78u w=0.55u l=0.13u
X445 vdd a_92840_96507# adc8b_0.sar12b_0.sg13cmos5l_a221oi_1_1.C1 vdd sg13_lv_pmos ad=0.36195p pd=1.84u as=0.3808p ps=2.92u w=1.12u l=0.13u
X446 vddr adc8b_0.sar12b_0.nh_sw[4] adc8b_0.side_cap8b_1.buf_8_2.z vddr sg13_lv_pmos ad=0.19p pd=1.38u as=0.19p ps=1.38u w=1u l=0.13u
X447 vddr a_42476_70044# sg13cmos5l_Corner_1.iovdd sg13cmos5l_Corner_1.iovdd sg13_hv_pmos ad=3.9294p pd=7.84u as=2.1312p ps=7.3u w=6.66u l=0.6u
X448 vdd a_99729_99953# a_99662_99596# vdd sg13_lv_pmos ad=0.2387p pd=1.84u as=0.1008p ps=0.9u w=0.42u l=0.13u
X449 vdd a_90225_98441# a_90750_98514# vdd sg13_lv_pmos ad=0.1974p pd=1.5u as=0.2856p ps=2.36u w=0.84u l=0.13u
X450 a_85945_98486# a_85393_98442# sg13cmos5l_Corner_1.vss sg13cmos5l_Corner_1.vss sg13_lv_nmos ad=71.99999f pd=0.865u as=1.49685p ps=9.6u w=0.64u l=0.13u
X451 a_99105_96125# a_98163_95932# a_98903_95887# vdd sg13_lv_pmos ad=93.45f pd=0.865u as=0.2048p ps=1.63u w=0.42u l=0.13u
X452 sg13cmos5l_Corner_1.vss a_118044_30676# cko sg13cmos5l_Corner_1.vss sg13_hv_nmos ad=1.408p pd=5.04u as=2.596p ps=5.58u w=4.4u l=0.6u
X453 sg13cmos5l_Corner_1.vss a_96668_93512# adc8b_0.sar12b_0.sg13cmos5l_nand2_1_0.A sg13cmos5l_Corner_1.vss sg13_lv_nmos ad=0.17255p pd=1.25u as=0.1406p ps=1.12u w=0.74u l=0.13u
X454 vddr adc8b_0.side_cap8b_0.in_l_sw[4] adc8b_0.side_cap8b_0.buf_8_0.z vddr sg13_lv_pmos ad=0.19p pd=1.38u as=0.19p ps=1.38u w=1u l=0.13u
X455 adc8b_0.sar12b_0.sg13cmos5l_buf_1_94.X a_96784_100384# sg13cmos5l_Corner_1.vss sg13cmos5l_Corner_1.vss sg13_lv_nmos ad=0.2886p pd=2.26u as=0.14875p ps=1.16u w=0.74u l=0.13u
X456 data[2] a_102044_30676# sg13cmos5l_Corner_1.vss sg13cmos5l_Corner_1.vss sg13_hv_nmos ad=2.596p pd=5.58u as=1.408p ps=5.04u w=4.4u l=0.6u
X457 adc8b_0.sar12b_0.sg13cmos5l_dlhr_1_6.Q_N a_91326_97304# vdd vdd sg13_lv_pmos ad=0.3808p pd=2.92u as=0.1974p ps=1.5u w=1.12u l=0.13u
X458 adc8b_0.side_cap8b_1.buf_16_1.z adc8b_0.sar12b_0.nl_sw[2] sg13cmos5l_Corner_1.vss sg13cmos5l_Corner_1.vss sg13_lv_nmos ad=95f pd=0.88u as=95f ps=0.88u w=0.5u l=0.13u
X459 sg13cmos5l_IOPadAnalog_10.pad a_67639_164698# sg13cmos5l_Corner_1.iovdd sg13cmos5l_Corner_1.iovdd sg13_hv_pmos ad=3.9294p pd=7.84u as=2.1312p ps=7.3u w=6.66u l=0.6u
X460 adc8b_0.sar12b_0.sg13cmos5l_dfrbp_1_6.RESET_B cks vdd vdd sg13_lv_pmos ad=0.2184p pd=1.51u as=0.2128p ps=1.5u w=1.12u l=0.13u
X461 vdd a_101108_99560# adc8b_0.side_cap8b_0.in_l_sw[9] vdd sg13_lv_pmos ad=0.2114p pd=1.54u as=0.42p ps=2.99u w=1.12u l=0.13u
X462 sg13cmos5l_Corner_1.vss a_178296_70044# sg13cmos5l_IOPadAnalog_1.pad sg13cmos5l_Corner_1.vss sg13_hv_nmos ad=1.408p pd=5.04u as=2.596p ps=5.58u w=4.4u l=0.6u
X463 a_100910_96572# a_100514_96936# a_100796_96572# vdd sg13_lv_pmos ad=0.1008p pd=0.9u as=0.191p ps=1.44u w=0.42u l=0.13u
X464 sg13cmos5l_IOPadAnalog_0.pad a_178296_86044# sg13cmos5l_Corner_1.vss sg13cmos5l_Corner_1.vss sg13_hv_nmos ad=2.596p pd=5.58u as=1.408p ps=5.04u w=4.4u l=0.6u
X465 sg13cmos5l_IOPadAnalog_15.pad a_99639_178370# sg13cmos5l_Corner_1.vss sg13cmos5l_Corner_1.vss sg13_hv_nmos ad=2.596p pd=5.58u as=1.408p ps=5.04u w=4.4u l=0.6u
X466 sg13cmos5l_IOPadAnalog_9.pad a_83639_164698# sg13cmos5l_Corner_1.iovdd sg13cmos5l_Corner_1.iovdd sg13_hv_pmos ad=3.9294p pd=7.84u as=2.1312p ps=7.3u w=6.66u l=0.6u
X467 vdd adc8b_0.sar12b_0.sg13cmos5l_dfrbp_1_6.RESET_B a_87278_95498# vdd sg13_lv_pmos ad=0.36237p pd=2.605u as=79.8f ps=0.8u w=0.42u l=0.13u
X468 adc8b_0.side_cap8b_1.buf_32_1.z adc8b_0.sar12b_0.nh_sw[0] sg13cmos5l_Corner_1.vss sg13cmos5l_Corner_1.vss sg13_lv_nmos ad=95f pd=0.88u as=95f ps=0.88u w=0.5u l=0.13u
X469 a_36456_138715# a_40542_138385# sg13cmos5l_Corner_1.vss rppd l=20u w=1u
X470 adc8b_0.sar12b_0.sg13cmos5l_buf_1_30.X a_90448_92824# vdd vdd sg13_lv_pmos ad=0.42p pd=2.99u as=0.2114p ps=1.54u w=1.12u l=0.13u
X471 adc8b_0.side_cap8b_0.buf_32_1.z adc8b_0.side_cap8b_0.in_h_sw[0] sg13cmos5l_Corner_1.vss sg13cmos5l_Corner_1.vss sg13_lv_nmos ad=95f pd=0.88u as=95f ps=0.88u w=0.5u l=0.13u
X472 sg13cmos5l_Corner_1.vss a_83639_178370# sg13cmos5l_IOPadAnalog_9.pad sg13cmos5l_Corner_1.vss sg13_hv_nmos ad=1.408p pd=5.04u as=2.596p ps=5.58u w=4.4u l=0.6u
X473 sg13cmos5l_Corner_1.iovdd a_99639_164698# sg13cmos5l_IOPadAnalog_15.pad sg13cmos5l_Corner_1.iovdd sg13_hv_pmos ad=3.1302p pd=14.26u as=3.9294p ps=7.84u w=6.66u l=0.6u
X474 sg13cmos5l_Corner_1.iovdd a_115639_164698# sg13cmos5l_IOPadAnalog_13.pad sg13cmos5l_Corner_1.iovdd sg13_hv_pmos ad=2.1312p pd=7.3u as=3.9294p ps=7.84u w=6.66u l=0.6u
X475 adc8b_0.side_cap8b_0.buf_2_0.z adc8b_0.side_cap8b_0.in_h_sw[8] vddr vddr sg13_lv_pmos ad=0.34p pd=2.68u as=0.19p ps=1.38u w=1u l=0.13u
X476 vdd a_85342_99010# adc8b_0.sar12b_0.sg13cmos5l_dlhr_1_9.Q_N vdd sg13_lv_pmos ad=0.1974p pd=1.5u as=0.3808p ps=2.92u w=1.12u l=0.13u
X477 a_95252_99560# adc8b_0.sar12b_0.sg13cmos5l_dlhr_1_11.Q vdd vdd sg13_lv_pmos ad=0.2856p pd=2.36u as=0.2114p ps=1.54u w=0.84u l=0.13u
X478 a_89399_95887# a_88557_95789# a_89305_95887# sg13cmos5l_Corner_1.vss sg13_lv_nmos ad=0.12665p pd=1.145u as=0.1428p ps=1.52u w=0.42u l=0.13u
X479 adc8b_0.sar12b_0.sg13cmos5l_dfrbp_1_10.Q_N a_85367_94375# vdd vdd sg13_lv_pmos ad=0.4312p pd=3.01u as=0.2639p ps=1.81u w=1.12u l=0.13u
X480 sg13cmos5l_Corner_1.vss adc8b_0.sar12b_0.sg13cmos5l_inv_1_18.A a_91024_100384# sg13cmos5l_Corner_1.vss sg13_lv_nmos ad=0.14875p pd=1.16u as=0.187p ps=1.78u w=0.55u l=0.13u
X481 a_84406_97322# a_84647_97592# a_83765_97286# sg13cmos5l_Corner_1.vss sg13_lv_nmos ad=0.1428p pd=1.52u as=0.12665p ps=1.145u w=0.42u l=0.13u
X482 a_89209_92778# a_88657_92840# sg13cmos5l_Corner_1.vss sg13cmos5l_Corner_1.vss sg13_lv_nmos ad=71.99999f pd=0.865u as=7.01497p ps=46.005u w=0.64u l=0.13u
X483 sg13cmos5l_Corner_1.vss a_30676_118044# cks sg13cmos5l_Corner_1.vss sg13_hv_nmos ad=1.408p pd=5.04u as=2.596p ps=5.58u w=4.4u l=0.6u
X484 vddr adc8b_0.side_cap8b_0.in_l_sw[1] adc8b_0.side_cap8b_0.buf_16_2.z vddr sg13_lv_pmos ad=0.19p pd=1.38u as=0.34p ps=2.68u w=1u l=0.13u
X485 adc8b_0.diff_bsw_0.single_bsw_0.sg13cmos5l_inv_1$1_0.A cks sg13cmos5l_Corner_1.vss sg13cmos5l_Corner_1.vss sg13_lv_nmos ad=0.2516p pd=2.16u as=0.2516p ps=2.16u w=0.74u l=0.13u
X486 vdd sg13cmos5l_IOPadVdd$1_0.sg13cmos5l_Clamp_N43N43D4R$1_0.gate sg13cmos5l_Corner_1.vss sg13cmos5l_Corner_1.vss sg13_hv_nmos ad=2.596p pd=5.58u as=1.408p ps=5.04u w=4.4u l=0.6u
X487 sg13cmos5l_Corner_1.vss adc8b_0.sar12b_0.sg13cmos5l_buf_1_97.A a_93616_99596# sg13cmos5l_Corner_1.vss sg13_lv_nmos ad=0.14875p pd=1.16u as=0.187p ps=1.78u w=0.55u l=0.13u
X488 sg13cmos5l_IOPadAnalog_1.pad a_164624_70044# sg13cmos5l_Corner_1.iovdd sg13cmos5l_Corner_1.iovdd sg13_hv_pmos ad=3.9294p pd=7.84u as=2.1312p ps=7.3u w=6.66u l=0.6u
X489 adc8b_0.side_cap8b_1.buf_16_2.z adc8b_0.sar12b_0.nl_sw[1] sg13cmos5l_Corner_1.vss sg13cmos5l_Corner_1.vss sg13_lv_nmos ad=95f pd=0.88u as=95f ps=0.88u w=0.5u l=0.13u
X490 adc8b_0.side_cap8b_1.buf_32_1.z adc8b_0.sar12b_0.nh_sw[0] sg13cmos5l_Corner_1.vss sg13cmos5l_Corner_1.vss sg13_lv_nmos ad=95f pd=0.88u as=95f ps=0.88u w=0.5u l=0.13u
X491 vin a_30676_86044# sg13cmos5l_Corner_1.vss sg13cmos5l_Corner_1.vss sg13_hv_nmos ad=2.596p pd=5.58u as=1.408p ps=5.04u w=4.4u l=0.6u
X492 sg13cmos5l_Corner_1.vss a_83252_100310# adc8b_0.sar12b_0.sg13cmos5l_buf_1_68.X sg13cmos5l_Corner_1.vss sg13_lv_nmos ad=0.14875p pd=1.16u as=0.2886p ps=2.26u w=0.74u l=0.13u
X493 vdd a_100113_98834# a_100638_98816# vdd sg13_lv_pmos ad=0.1974p pd=1.5u as=0.2856p ps=2.36u w=0.84u l=0.13u
X494 sg13cmos5l_Corner_1.vss a_178296_86044# sg13cmos5l_IOPadAnalog_0.pad sg13cmos5l_Corner_1.vss sg13_hv_nmos ad=2.068p pd=9.74u as=2.596p ps=5.58u w=4.4u l=0.6u
X495 sg13cmos5l_Corner_1.vss adc8b_0.side_cap8b_0.in_h_sw[1] adc8b_0.side_cap8b_0.buf_16_3.z sg13cmos5l_Corner_1.vss sg13_lv_nmos ad=95f pd=0.88u as=95f ps=0.88u w=0.5u l=0.13u
X496 adc8b_0.sar12b_0.sg13cmos5l_buf_1_103.A a_97552_100384# sg13cmos5l_Corner_1.vss sg13cmos5l_Corner_1.vss sg13_lv_nmos ad=0.2886p pd=2.26u as=0.14875p ps=1.16u w=0.74u l=0.13u
X497 sg13cmos5l_Corner_1.vss adc8b_0.sar12b_0.sg13cmos5l_buf_1_29.A adc8b_0.sar12b_0.sg13cmos5l_buf_1_77.A sg13cmos5l_Corner_1.vss sg13_lv_nmos ad=0.2516p pd=2.16u as=0.2516p ps=2.16u w=0.74u l=0.13u
X498 vdd adc8b_0.sar12b_0.sg13cmos5l_and3_1_0.C a_95092_95856# vdd sg13_lv_pmos ad=0.36195p pd=1.84u as=0.1596p ps=1.22u w=0.84u l=0.13u
X499 a_85377_95183# a_84435_95071# a_85175_95421# vdd sg13_lv_pmos ad=93.45f pd=0.865u as=0.2048p ps=1.63u w=0.42u l=0.13u
X500 vdd adc8b_0.sar12b_0.sg13cmos5l_dfrbp_1_0.RESET_B a_93298_95028# vdd sg13_lv_pmos ad=0.1563p pd=1.22u as=0.147p ps=1.54u w=0.42u l=0.13u
X501 sg13cmos5l_IOPadAnalog_15.pad a_99639_164698# sg13cmos5l_Corner_1.iovdd sg13cmos5l_Corner_1.iovdd sg13_hv_pmos ad=3.9294p pd=7.84u as=2.1312p ps=7.3u w=6.66u l=0.6u
X502 vdd a_99287_97399# a_99544_97542# vdd sg13_lv_pmos ad=0.2639p pd=1.81u as=79.8f ps=0.8u w=0.42u l=0.13u
X503 vdd adc8b_0.sar12b_0.sg13cmos5l_nand2_1_1.A adc8b_0.sar12b_0.sg13cmos5l_o21ai_1_0.B1 vdd sg13_lv_pmos ad=0.3808p pd=2.92u as=0.2128p ps=1.5u w=1.12u l=0.13u
X504 adc8b_0.sar12b_0.sg13cmos5l_dlhr_1_9.D a_84572_96572# vdd vdd sg13_lv_pmos ad=0.3808p pd=2.92u as=0.2128p ps=1.5u w=1.12u l=0.13u
X505 cks sg13cmos5l_Corner_1.iovdd dpantenna l=27.78u w=1.26u
X506 sg13cmos5l_Corner_1.iovdd a_164624_102044# sg13cmos5l_IOPadAnalog_16.pad sg13cmos5l_Corner_1.iovdd sg13_hv_pmos ad=2.1312p pd=7.3u as=3.9294p ps=7.84u w=6.66u l=0.6u
X507 vin a_42476_86044# sg13cmos5l_Corner_1.iovdd sg13cmos5l_Corner_1.iovdd sg13_hv_pmos ad=3.9294p pd=7.84u as=2.1312p ps=7.3u w=6.66u l=0.6u
X508 sg13cmos5l_Corner_1.iovdd a_42476_86044# vin sg13cmos5l_Corner_1.iovdd sg13_hv_pmos ad=2.1312p pd=7.3u as=3.9294p ps=7.84u w=6.66u l=0.6u
X509 sg13cmos5l_Corner_1.vss adc8b_0.side_cap8b_0.in_h_sw[5] adc8b_0.side_cap8b_0.buf_8_5.z sg13cmos5l_Corner_1.vss sg13_lv_nmos ad=95f pd=0.88u as=95f ps=0.88u w=0.5u l=0.13u
X510 a_93612_95485# a_93843_95071# a_93298_95028# sg13cmos5l_Corner_1.vss sg13_lv_nmos ad=0.2373p pd=1.97u as=79.8f ps=0.8u w=0.42u l=0.13u
X511 sg13cmos5l_Corner_1.iovdd a_134044_42476# frame sg13cmos5l_Corner_1.iovdd sg13_hv_pmos ad=2.1312p pd=7.3u as=3.9294p ps=7.84u w=6.66u l=0.6u
X512 sg13cmos5l_IOPadAnalog_11.pad a_164624_118044# sg13cmos5l_Corner_1.iovdd sg13cmos5l_Corner_1.iovdd sg13_hv_pmos ad=3.9294p pd=7.84u as=2.1312p ps=7.3u w=6.66u l=0.6u
X513 sg13cmos5l_Corner_1.vss adc8b_0.sar12b_0.sg13cmos5l_buf_1_3.X a_102160_94336# sg13cmos5l_Corner_1.vss sg13_lv_nmos ad=0.14875p pd=1.16u as=0.187p ps=1.78u w=0.55u l=0.13u
X514 vdd a_92355_95852# adc8b_0.sar12b_0.sg13cmos5l_nand2_1_0.B vdd sg13_lv_pmos ad=0.3808p pd=2.92u as=0.2128p ps=1.5u w=1.12u l=0.13u
X515 a_84334_94311# adc8b_0.sar12b_0.sg13cmos5l_dfrbp_1_6.RESET_B sg13cmos5l_Corner_1.vss sg13cmos5l_Corner_1.vss sg13_lv_nmos ad=37.8f pd=0.6u as=0.1701p ps=1.65u w=0.42u l=0.13u
X516 sg13cmos5l_Corner_1.vss adc8b_0.sar12b_0.nl_sw[5] adc8b_0.side_cap8b_1.buf_8_4.z sg13cmos5l_Corner_1.vss sg13_lv_nmos ad=95f pd=0.88u as=0.17p ps=1.68u w=0.5u l=0.13u
X517 sg13cmos5l_Corner_1.vss a_131639_178370# sg13cmos5l_IOPadAnalog_12.pad sg13cmos5l_Corner_1.vss sg13_hv_nmos ad=1.408p pd=5.04u as=2.596p ps=5.58u w=4.4u l=0.6u
X518 a_80694_96641# a_80424_96641# sg13cmos5l_Corner_1.vss sg13cmos5l_Corner_1.vss sg13_lv_nmos ad=0.1428p pd=1.52u as=79.8f ps=0.8u w=0.42u l=0.5u
X519 vdd adc8b_0.sar12b_0.sg13cmos5l_buf_1_34.A a_86608_92824# vdd sg13_lv_pmos ad=0.2114p pd=1.54u as=0.2856p ps=2.36u w=0.84u l=0.13u
X520 sg13cmos5l_Corner_1.iovdd a_42476_118044# cks sg13cmos5l_Corner_1.iovdd sg13_hv_pmos ad=2.1312p pd=7.3u as=3.9294p ps=7.84u w=6.66u l=0.6u
X521 sg13cmos5l_IOPadAnalog_8.padres sg13cmos5l_Corner_1.iovdd dpantenna l=4.98u w=0.64u
X522 adc8b_0.side_cap8b_1.buf_8_3.z adc8b_0.sar12b_0.nh_sw[3] vddr vddr sg13_lv_pmos ad=0.19p pd=1.38u as=0.19p ps=1.38u w=1u l=0.13u
X523 vdd a_82292_95774# adc8b_0.cmp_0.clk vdd sg13_lv_pmos ad=0.2114p pd=1.54u as=0.42p ps=2.99u w=1.12u l=0.13u
X524 sg13cmos5l_Corner_1.vss adc8b_0.sar12b_0.sg13cmos5l_dfrbp_1_0.RESET_B a_93132_92786# sg13cmos5l_Corner_1.vss sg13_lv_nmos ad=0.1626p pd=1.415u as=60.89999f ps=0.71u w=0.42u l=0.13u
X525 a_36456_140035# a_40542_139705# sg13cmos5l_Corner_1.vss rppd l=20u w=1u
X526 adc8b_0.sar12b_0.sg13cmos5l_buf_1_116.A a_96945_96929# vdd vdd sg13_lv_pmos ad=0.3808p pd=2.92u as=0.2128p ps=1.5u w=1.12u l=0.13u
X527 frame a_134044_30676# sg13cmos5l_Corner_1.vss sg13cmos5l_Corner_1.vss sg13_hv_nmos ad=2.596p pd=5.58u as=1.408p ps=5.04u w=4.4u l=0.6u
X528 sg13cmos5l_Corner_1.vss a_85076_96536# adc8b_0.sar12b_0.sg13cmos5l_buf_1_41.A sg13cmos5l_Corner_1.vss sg13_lv_nmos ad=0.14875p pd=1.16u as=0.2886p ps=2.26u w=0.74u l=0.13u
X529 sg13cmos5l_Corner_1.vss vdd sg13cmos5l_Corner_1.vss sg13cmos5l_Corner_1.vss sg13_lv_nmos ad=0.1428p pd=1.52u as=0 ps=0 w=0.42u l=1u
X530 data[2] a_102044_42476# sg13cmos5l_Corner_1.iovdd sg13cmos5l_Corner_1.iovdd sg13_hv_pmos ad=3.9294p pd=7.84u as=3.1302p ps=14.26u w=6.66u l=0.6u
X531 sg13cmos5l_IOPadAnalog_1.padres sg13cmos5l_IOPadAnalog_1.pad sg13cmos5l_Corner_1.vss rppd l=2u w=1u
X532 sg13cmos5l_IOPadAnalog_10.pad a_67639_178370# sg13cmos5l_Corner_1.vss sg13cmos5l_Corner_1.vss sg13_hv_nmos ad=2.596p pd=5.58u as=1.408p ps=5.04u w=4.4u l=0.6u
X533 vdd a_83231_99901# a_83231_99671# vdd sg13_lv_pmos ad=1.15047p pd=7.175u as=0.2442p ps=2.06u w=0.66u l=0.13u
X534 a_94510_97335# adc8b_0.sar12b_0.sg13cmos5l_dfrbp_1_6.RESET_B sg13cmos5l_Corner_1.vss sg13cmos5l_Corner_1.vss sg13_lv_nmos ad=37.8f pd=0.6u as=0.1701p ps=1.65u w=0.42u l=0.13u
X535 a_97486_93973# adc8b_0.sar12b_0.sg13cmos5l_dfrbp_1_0.RESET_B sg13cmos5l_Corner_1.vss sg13cmos5l_Corner_1.vss sg13_lv_nmos ad=37.8f pd=0.6u as=0.1701p ps=1.65u w=0.42u l=0.13u
X536 vdd a_82388_93512# adc8b_0.sar12b_0.nl_sw[0] vdd sg13_lv_pmos ad=0.2114p pd=1.54u as=0.42p ps=2.99u w=1.12u l=0.13u
X537 vdd a_92433_98441# a_92958_98514# vdd sg13_lv_pmos ad=0.1974p pd=1.5u as=0.2856p ps=2.36u w=0.84u l=0.13u
X538 a_95026_94521# a_95469_94277# a_95409_94689# vdd sg13_lv_pmos ad=79.8f pd=0.8u as=63f ps=0.72u w=0.42u l=0.13u
X539 sg13cmos5l_IOPadAnalog_16.pad a_164624_102044# sg13cmos5l_Corner_1.iovdd sg13cmos5l_Corner_1.iovdd sg13_hv_pmos ad=3.9294p pd=7.84u as=2.1312p ps=7.3u w=6.66u l=0.6u
X540 vdd sg13cmos5l_Corner_1.vss vdd vdd sg13_lv_pmos ad=0.19p pd=1.38u as=0 ps=0 w=1u l=1u
X541 sg13cmos5l_Corner_1.vss a_82926_94302# a_83058_94366# sg13cmos5l_Corner_1.vss sg13_lv_nmos ad=0.1405p pd=1.15u as=0.2163p ps=1.87u w=0.42u l=0.18u
X542 sg13cmos5l_Corner_1.vss adc8b_0.sar12b_0.nh_sw[8] adc8b_0.side_cap8b_1.buf_2_0.z sg13cmos5l_Corner_1.vss sg13_lv_nmos ad=95f pd=0.88u as=0.17p ps=1.68u w=0.5u l=0.13u
X543 a_95228_99156# a_94815_98850# a_95160_99156# vdd sg13_lv_pmos ad=0.191p pd=1.44u as=0.105p ps=1.21u w=1u l=0.13u
X544 a_90044_98084# a_89631_98442# a_89976_98084# vdd sg13_lv_pmos ad=0.191p pd=1.44u as=0.105p ps=1.21u w=1u l=0.13u
X545 adc8b_0.side_cap8b_1.buf_8_5.z adc8b_0.sar12b_0.nh_sw[5] sg13cmos5l_Corner_1.vss sg13cmos5l_Corner_1.vss sg13_lv_nmos ad=0.17p pd=1.68u as=95f ps=0.88u w=0.5u l=0.13u
X546 sg13cmos5l_Corner_1.vss a_99639_178370# sg13cmos5l_IOPadAnalog_15.pad sg13cmos5l_Corner_1.vss sg13_hv_nmos ad=1.408p pd=5.04u as=2.596p ps=5.58u w=4.4u l=0.6u
X547 sg13cmos5l_Corner_1.iovdd a_67639_164698# sg13cmos5l_IOPadAnalog_10.pad sg13cmos5l_Corner_1.iovdd sg13_hv_pmos ad=3.1302p pd=14.26u as=3.9294p ps=7.84u w=6.66u l=0.6u
X548 sg13cmos5l_Corner_1.iovdd a_83639_164698# sg13cmos5l_IOPadAnalog_9.pad sg13cmos5l_Corner_1.iovdd sg13_hv_pmos ad=2.1312p pd=7.3u as=3.9294p ps=7.84u w=6.66u l=0.6u
X549 sg13cmos5l_Corner_1.vss adc8b_0.side_cap8b_0.in_l_sw[0] adc8b_0.side_cap8b_0.buf_32_0.z sg13cmos5l_Corner_1.vss sg13_lv_nmos ad=95f pd=0.88u as=0.17p ps=1.68u w=0.5u l=0.13u
X550 a_90753_99149# a_89811_98956# a_90551_98911# vdd sg13_lv_pmos ad=93.45f pd=0.865u as=0.2048p ps=1.63u w=0.42u l=0.13u
X551 adc8b_0.sar12b_0.sg13cmos5l_a22oi_1_0.Y adc8b_0.sar12b_0.sg13cmos5l_a22oi_1_0.B1 a_92551_95036# vdd sg13_lv_pmos ad=0.2128p pd=1.5u as=0.2716p ps=1.605u w=1.12u l=0.13u
X552 vdd a_100131_95430# adc8b_0.sar12b_0.sg13cmos5l_or2_1_0.A vdd sg13_lv_pmos ad=0.2128p pd=1.5u as=0.2128p ps=1.5u w=1.12u l=0.13u
X553 a_83916_94298# adc8b_0.sar12b_0.sg13cmos5l_dfrbp_1_6.D a_83822_94298# sg13cmos5l_Corner_1.vss sg13_lv_nmos ad=60.89999f pd=0.71u as=0.1428p ps=1.52u w=0.42u l=0.13u
X554 sg13cmos5l_Corner_1.iovdd a_164624_118044# sg13cmos5l_IOPadAnalog_11.pad sg13cmos5l_Corner_1.iovdd sg13_hv_pmos ad=2.1312p pd=7.3u as=3.9294p ps=7.84u w=6.66u l=0.6u
X555 sg13cmos5l_Corner_1.iovdd a_86044_42476# data[1] sg13cmos5l_Corner_1.iovdd sg13_hv_pmos ad=2.1312p pd=7.3u as=3.9294p ps=7.84u w=6.66u l=0.6u
X556 sg13cmos5l_Corner_1.vss sg13cmos5l_IOPadVdd$1_0.sg13cmos5l_Clamp_N43N43D4R$1_0.gate vdd sg13cmos5l_Corner_1.vss sg13_hv_nmos ad=1.408p pd=5.04u as=2.596p ps=5.58u w=4.4u l=0.6u
X557 adc8b_0.side_cap8b_0.buf_32_0.z adc8b_0.side_cap8b_0.in_l_sw[0] vddr vddr sg13_lv_pmos ad=0.19p pd=1.38u as=0.19p ps=1.38u w=1u l=0.13u
X558 a_98903_95887# a_98061_95789# a_97644_96128# vdd sg13_lv_pmos ad=0.2048p pd=1.63u as=0.34p ps=2.68u w=1u l=0.13u
X559 a_98036_94262# adc8b_0.sar12b_0.sg13cmos5l_buf_1_2.X sg13cmos5l_Corner_1.vss sg13cmos5l_Corner_1.vss sg13_lv_nmos ad=0.187p pd=1.78u as=0.14875p ps=1.16u w=0.55u l=0.13u
X560 adc8b_0.sar12b_0.sg13cmos5l_buf_1_45.A a_90609_96929# sg13cmos5l_Corner_1.vss sg13cmos5l_Corner_1.vss sg13_lv_nmos ad=0.2516p pd=2.16u as=0.1406p ps=1.12u w=0.74u l=0.13u
X561 sg13cmos5l_Corner_1.vss adc8b_0.sar12b_0.nl_sw[0] adc8b_0.side_cap8b_1.buf_32_0.z sg13cmos5l_Corner_1.vss sg13_lv_nmos ad=95f pd=0.88u as=95f ps=0.88u w=0.5u l=0.13u
X562 sg13cmos5l_IOPadVdd$1_0.sg13cmos5l_Clamp_N43N43D4R$1_0.gate sg13cmos5l_IOPadVdd$1_0.sg13cmos5l_RCClampInverter$1_0.in vdd vdd sg13_hv_pmos ad=1.33p pd=7.38u as=1.33p ps=7.38u w=7u l=0.5u
X563 vddr adc8b_0.side_cap8b_0.in_l_sw[0] adc8b_0.side_cap8b_0.buf_32_0.z vddr sg13_lv_pmos ad=0.19p pd=1.38u as=0.19p ps=1.38u w=1u l=0.13u
X564 a_88823_95421# a_87981_95071# a_88729_95421# sg13cmos5l_Corner_1.vss sg13_lv_nmos ad=0.12665p pd=1.145u as=0.1428p ps=1.52u w=0.42u l=0.13u
X565 sg13cmos5l_Corner_1.vss adc8b_0.sar12b_0.sg13cmos5l_dfrbp_1_8.RESET_B a_90348_100034# sg13cmos5l_Corner_1.vss sg13_lv_nmos ad=0.1626p pd=1.415u as=60.89999f ps=0.71u w=0.42u l=0.13u
X566 sg13cmos5l_Corner_1.vss a_118044_30676# cko sg13cmos5l_Corner_1.vss sg13_hv_nmos ad=1.408p pd=5.04u as=2.596p ps=5.58u w=4.4u l=0.6u
X567 sg13cmos5l_Corner_1.vss sg13cmos5l_IOPadVdd$1_0.sg13cmos5l_Clamp_N43N43D4R$1_0.gate vdd sg13cmos5l_Corner_1.vss sg13_hv_nmos ad=1.408p pd=5.04u as=2.596p ps=5.58u w=4.4u l=0.6u
X568 sg13cmos5l_Corner_1.iovdd a_42476_102044# vip sg13cmos5l_Corner_1.iovdd sg13_hv_pmos ad=2.1312p pd=7.3u as=3.9294p ps=7.84u w=6.66u l=0.6u
X569 sg13cmos5l_Corner_1.vss a_89631_98442# a_89762_98448# sg13cmos5l_Corner_1.vss sg13_lv_nmos ad=1.49685p pd=9.6u as=0.2775p ps=2.23u w=0.74u l=0.13u
X570 sg13cmos5l_IOPadAnalog_15.pad a_99639_178370# sg13cmos5l_Corner_1.vss sg13cmos5l_Corner_1.vss sg13_hv_nmos ad=2.596p pd=5.58u as=1.408p ps=5.04u w=4.4u l=0.6u
X571 sg13cmos5l_IOPadAnalog_10.pad a_67639_164698# sg13cmos5l_Corner_1.iovdd sg13cmos5l_Corner_1.iovdd sg13_hv_pmos ad=3.9294p pd=7.84u as=2.1312p ps=7.3u w=6.66u l=0.6u
X572 sg13cmos5l_Corner_1.iovdd a_70044_42476# data[0] sg13cmos5l_Corner_1.iovdd sg13_hv_pmos ad=2.1312p pd=7.3u as=3.9294p ps=7.84u w=6.66u l=0.6u
X573 sg13cmos5l_IOPadAnalog_13.pad a_115639_178370# sg13cmos5l_Corner_1.vss sg13cmos5l_Corner_1.vss sg13_hv_nmos ad=2.596p pd=5.58u as=1.408p ps=5.04u w=4.4u l=0.6u
X574 sg13cmos5l_Corner_1.vss adc8b_0.side_cap8b_0.in_l_sw[1] adc8b_0.side_cap8b_0.buf_16_2.z sg13cmos5l_Corner_1.vss sg13_lv_nmos ad=95f pd=0.88u as=95f ps=0.88u w=0.5u l=0.13u
X575 adc8b_0.sar12b_0.sg13cmos5l_buf_1_87.A a_100144_100384# vdd vdd sg13_lv_pmos ad=0.42p pd=2.99u as=0.2114p ps=1.54u w=1.12u l=0.13u
X576 sg13cmos5l_Corner_1.vss adc8b_0.sar12b_0.sg13cmos5l_buf_1_2.A a_97552_92824# sg13cmos5l_Corner_1.vss sg13_lv_nmos ad=0.14875p pd=1.16u as=0.187p ps=1.78u w=0.55u l=0.13u
X577 sg13cmos5l_Corner_1.iovdd a_99639_164698# sg13cmos5l_IOPadAnalog_15.pad sg13cmos5l_Corner_1.iovdd sg13_hv_pmos ad=2.1312p pd=7.3u as=3.9294p ps=7.84u w=6.66u l=0.6u
X578 sg13cmos5l_Corner_1.vss adc8b_0.sar12b_0.sg13cmos5l_inv_1_26.Y a_99664_100384# sg13cmos5l_Corner_1.vss sg13_lv_nmos ad=0.14875p pd=1.16u as=0.187p ps=1.78u w=0.55u l=0.13u
X579 adc8b_0.sar12b_0.sg13cmos5l_dlhr_1_11.Q_N a_95454_98514# vdd vdd sg13_lv_pmos ad=0.3808p pd=2.92u as=0.1974p ps=1.5u w=1.12u l=0.13u
X580 sg13cmos5l_Corner_1.vss a_91988_94262# adc8b_0.sar12b_0.nl_sw[5] sg13cmos5l_Corner_1.vss sg13_lv_nmos ad=0.14875p pd=1.16u as=0.2886p ps=2.26u w=0.74u l=0.13u
X581 sg13cmos5l_Corner_1.vss a_86044_30676# data[1] sg13cmos5l_Corner_1.vss sg13_hv_nmos ad=2.068p pd=9.74u as=2.596p ps=5.58u w=4.4u l=0.6u
X582 sg13cmos5l_Corner_1.iovdd a_115639_164698# sg13cmos5l_IOPadAnalog_13.pad sg13cmos5l_Corner_1.iovdd sg13_hv_pmos ad=2.1312p pd=7.3u as=3.9294p ps=7.84u w=6.66u l=0.6u
X583 sg13cmos5l_Corner_1.vss a_101361_97322# a_101316_97358# sg13cmos5l_Corner_1.vss sg13_lv_nmos ad=0.1428p pd=1.52u as=47.25f ps=0.645u w=0.42u l=0.13u
X584 a_93038_92786# adc8b_0.sar12b_0.sg13cmos5l_dfrbp_1_1.D vdd vdd sg13_lv_pmos ad=79.8f pd=0.8u as=0.1428p ps=1.52u w=0.42u l=0.13u
X585 sg13cmos5l_Corner_1.vss adc8b_0.side_cap8b_0.in_h_sw[0] adc8b_0.side_cap8b_0.buf_32_1.z sg13cmos5l_Corner_1.vss sg13_lv_nmos ad=95f pd=0.88u as=95f ps=0.88u w=0.5u l=0.13u
X586 adc8b_0.side_cap8b_0.buf_16_1.z adc8b_0.side_cap8b_0.in_l_sw[2] sg13cmos5l_Corner_1.vss sg13cmos5l_Corner_1.vss sg13_lv_nmos ad=95f pd=0.88u as=95f ps=0.88u w=0.5u l=0.13u
X587 vdd adc8b_0.sar12b_0.sg13cmos5l_dfrbp_1_8.RESET_B a_96110_100034# vdd sg13_lv_pmos ad=0.36237p pd=2.605u as=79.8f ps=0.8u w=0.42u l=0.13u
X588 a_89084_94620# a_88802_94308# a_89017_94290# sg13cmos5l_Corner_1.vss sg13_lv_nmos ad=0.141p pd=1.17u as=71.99999f ps=0.865u w=0.64u l=0.13u
X589 data[0] a_70044_30676# sg13cmos5l_Corner_1.vss sg13cmos5l_Corner_1.vss sg13_hv_nmos ad=2.596p pd=5.58u as=1.408p ps=5.04u w=4.4u l=0.6u
X590 vdd sg13cmos5l_IOPadVdd$1_0.sg13cmos5l_Clamp_N43N43D4R$1_0.gate sg13cmos5l_Corner_1.vss sg13cmos5l_Corner_1.vss sg13_hv_nmos ad=2.596p pd=5.58u as=1.408p ps=5.04u w=4.4u l=0.6u
X591 a_88557_95789# adc8b_0.sar12b_0.sg13cmos5l_inv_1_8.A vdd vdd sg13_lv_pmos ad=0.4088p pd=2.97u as=1.2517p ps=7.955u w=1.12u l=0.13u
X592 vddr adc8b_0.side_cap8b_0.in_h_sw[0] adc8b_0.side_cap8b_0.buf_32_1.z vddr sg13_lv_pmos ad=0.19p pd=1.38u as=0.19p ps=1.38u w=1u l=0.13u
X593 vddr adc8b_0.side_cap8b_0.in_h_sw[3] adc8b_0.side_cap8b_0.buf_8_3.z vddr sg13_lv_pmos ad=0.19p pd=1.38u as=0.34p ps=2.68u w=1u l=0.13u
X594 a_92185_98486# a_91633_98442# sg13cmos5l_Corner_1.vss sg13cmos5l_Corner_1.vss sg13_lv_nmos ad=71.99999f pd=0.865u as=1.49685p ps=9.6u w=0.64u l=0.13u
X595 sg13cmos5l_Corner_1.vss adc8b_0.sar12b_0.sg13cmos5l_dfrbp_1_23.Q a_95857_98442# sg13cmos5l_Corner_1.vss sg13_lv_nmos ad=0.15055p pd=1.17u as=0.187p ps=1.78u w=0.55u l=0.13u
X596 adc8b_0.sar12b_0.sg13cmos5l_dlhr_1_9.D a_84572_96572# sg13cmos5l_Corner_1.vss sg13cmos5l_Corner_1.vss sg13_lv_nmos ad=0.2516p pd=2.16u as=0.1406p ps=1.12u w=0.74u l=0.13u
X597 sg13cmos5l_Corner_1.vss adc8b_0.sar12b_0.nh_sw[0] adc8b_0.side_cap8b_1.buf_32_1.z sg13cmos5l_Corner_1.vss sg13_lv_nmos ad=95f pd=0.88u as=95f ps=0.88u w=0.5u l=0.13u
X598 frame a_134044_42476# sg13cmos5l_Corner_1.iovdd sg13cmos5l_Corner_1.iovdd sg13_hv_pmos ad=3.9294p pd=7.84u as=2.1312p ps=7.3u w=6.66u l=0.6u
X599 sg13cmos5l_Corner_1.vss adc8b_0.side_cap8b_0.in_l_sw[3] adc8b_0.side_cap8b_0.buf_8_1.z sg13cmos5l_Corner_1.vss sg13_lv_nmos ad=95f pd=0.88u as=95f ps=0.88u w=0.5u l=0.13u
X600 vdd adc8b_0.sar12b_0.sg13cmos5l_buf_1_8.A a_92656_92824# vdd sg13_lv_pmos ad=0.2114p pd=1.54u as=0.2856p ps=2.36u w=0.84u l=0.13u
X601 adc8b_0.sar12b_0.sg13cmos5l_dlhr_1_17.Q_N a_91134_97002# vdd vdd sg13_lv_pmos ad=0.3808p pd=2.92u as=0.1974p ps=1.5u w=1.12u l=0.13u
X602 a_94766_94298# adc8b_0.sar12b_0.sg13cmos5l_o21ai_1_0.Y vdd vdd sg13_lv_pmos ad=79.8f pd=0.8u as=0.1428p ps=1.52u w=0.42u l=0.13u
X603 sg13cmos5l_Corner_1.vss a_67639_178370# sg13cmos5l_IOPadAnalog_10.pad sg13cmos5l_Corner_1.vss sg13_hv_nmos ad=1.408p pd=5.04u as=2.596p ps=5.58u w=4.4u l=0.6u
X604 vdd a_100113_98834# a_100046_99272# vdd sg13_lv_pmos ad=0.2387p pd=1.84u as=0.1008p ps=0.9u w=0.42u l=0.13u
X605 sg13cmos5l_Corner_1.vss adc8b_0.side_cap8b_0.in_l_sw[9] adc8b_0.side_cap8b_0.buf_2_2.z sg13cmos5l_Corner_1.vss sg13_lv_nmos ad=95f pd=0.88u as=0.17p ps=1.68u w=0.5u l=0.13u
X606 sg13cmos5l_Corner_1.vss sg13cmos5l_IOPadVdd$1_0.sg13cmos5l_Clamp_N43N43D4R$1_0.gate vdd sg13cmos5l_Corner_1.vss sg13_hv_nmos ad=1.408p pd=5.04u as=2.596p ps=5.58u w=4.4u l=0.6u
X607 vdd a_95409_98834# a_95342_99272# vdd sg13_lv_pmos ad=0.2387p pd=1.84u as=0.1008p ps=0.9u w=0.42u l=0.13u
X608 a_87676_94284# a_87260_94620# a_87441_94298# sg13cmos5l_Corner_1.vss sg13_lv_nmos ad=77.7f pd=0.95u as=0.2516p ps=2.16u w=0.74u l=0.13u
X609 adc8b_0.sar12b_0.sg13cmos5l_nor2_1_0.A a_95324_93548# sg13cmos5l_Corner_1.vss sg13cmos5l_Corner_1.vss sg13_lv_nmos ad=0.2516p pd=2.16u as=0.1406p ps=1.12u w=0.74u l=0.13u
X610 a_86796_93986# adc8b_0.sar12b_0.sg13cmos5l_dfrbp_1_6.D a_86702_93986# sg13cmos5l_Corner_1.vss sg13_lv_nmos ad=60.89999f pd=0.71u as=0.1428p ps=1.52u w=0.42u l=0.13u
X611 a_93324_95064# a_93843_95071# a_94583_95421# sg13cmos5l_Corner_1.vss sg13_lv_nmos ad=0.3473p pd=2.71u as=0.12665p ps=1.145u w=0.74u l=0.13u
X612 a_89025_95183# a_88083_95071# a_88823_95421# vdd sg13_lv_pmos ad=93.45f pd=0.865u as=0.2048p ps=1.63u w=0.42u l=0.13u
X613 sg13cmos5l_Corner_1.vss a_85215_93906# a_85346_93912# sg13cmos5l_Corner_1.vss sg13_lv_nmos ad=2.59257p pd=16.445u as=0.2775p ps=2.23u w=0.74u l=0.13u
X614 vdd sg13cmos5l_IOPadVdd$1_0.sg13cmos5l_RCClampInverter$1_0.in sg13cmos5l_IOPadVdd$1_0.sg13cmos5l_Clamp_N43N43D4R$1_0.gate vdd sg13_hv_pmos ad=1.33p pd=7.38u as=1.33p ps=7.38u w=7u l=0.5u
X615 sg13cmos5l_Corner_1.iovdd a_42476_70044# sg13cmos5l_Corner_1.iovdd rppd l=12.9u w=0.5u
X616 adc8b_0.side_cap8b_0.buf_8_1.z adc8b_0.side_cap8b_0.in_l_sw[3] vddr vddr sg13_lv_pmos ad=0.34p pd=2.68u as=0.19p ps=1.38u w=1u l=0.13u
X617 sg13cmos5l_Corner_1.vss a_99352_98326# a_99001_98445# sg13cmos5l_Corner_1.vss sg13_lv_nmos ad=79.8f pd=0.8u as=0.1428p ps=1.52u w=0.42u l=0.13u
X618 adc8b_0.sar12b_0.sg13cmos5l_dlhr_1_2.Q a_89265_94298# sg13cmos5l_Corner_1.vss sg13cmos5l_Corner_1.vss sg13_lv_nmos ad=0.2516p pd=2.16u as=0.1406p ps=1.12u w=0.74u l=0.13u
X619 sg13cmos5l_Corner_1.vss a_87885_97301# a_87987_97444# sg13cmos5l_Corner_1.vss sg13_lv_nmos ad=1.97045p pd=12.335u as=0.2516p ps=2.16u w=0.74u l=0.13u
X620 cks a_42476_118044# sg13cmos5l_Corner_1.iovdd sg13cmos5l_Corner_1.iovdd sg13_hv_pmos ad=3.9294p pd=7.84u as=2.1312p ps=7.3u w=6.66u l=0.6u
X621 vdd adc8b_0.sar12b_0.sg13cmos5l_dfrbp_1_6.RESET_B a_94258_97545# vdd sg13_lv_pmos ad=0.1563p pd=1.22u as=0.147p ps=1.54u w=0.42u l=0.13u
X622 sg13cmos5l_IOPadAnalog_10.pad a_67639_178370# sg13cmos5l_Corner_1.vss sg13cmos5l_Corner_1.vss sg13_hv_nmos ad=2.596p pd=5.58u as=1.408p ps=5.04u w=4.4u l=0.6u
X623 a_87564_100034# adc8b_0.sar12b_0.sg13cmos5l_dlhr_1_5.GATE a_87470_100034# sg13cmos5l_Corner_1.vss sg13_lv_nmos ad=60.89999f pd=0.71u as=0.1428p ps=1.52u w=0.42u l=0.13u
X624 vdd adc8b_0.sar12b_0.sg13cmos5l_dfrbp_1_23.Q a_95857_98442# vdd sg13_lv_pmos ad=1.07253p pd=6.75u as=0.2856p ps=2.36u w=0.84u l=0.13u
X625 sg13cmos5l_Corner_1.iovdd a_118044_42476# cko sg13cmos5l_Corner_1.iovdd sg13_hv_pmos ad=2.1312p pd=7.3u as=3.9294p ps=7.84u w=6.66u l=0.6u
X626 vdd adc8b_0.sar12b_0.sg13cmos5l_buf_1_29.A adc8b_0.sar12b_0.sg13cmos5l_buf_1_77.A vdd sg13_lv_pmos ad=0.3808p pd=2.92u as=0.3808p ps=2.92u w=1.12u l=0.13u
X627 vdd a_85599_98442# a_85730_98448# vdd sg13_lv_pmos ad=1.07253p pd=6.75u as=0.2856p ps=2.36u w=0.84u l=0.13u
X628 sg13cmos5l_Corner_1.vss a_99639_178370# sg13cmos5l_IOPadAnalog_15.pad sg13cmos5l_Corner_1.vss sg13_hv_nmos ad=1.408p pd=5.04u as=2.596p ps=5.58u w=4.4u l=0.6u
X629 sg13cmos5l_Corner_1.iovdd a_67639_164698# sg13cmos5l_IOPadAnalog_10.pad sg13cmos5l_Corner_1.iovdd sg13_hv_pmos ad=2.1312p pd=7.3u as=3.9294p ps=7.84u w=6.66u l=0.6u
X630 vdd sg13cmos5l_IOPadVdd$1_0.sg13cmos5l_Clamp_N43N43D4R$1_0.gate sg13cmos5l_Corner_1.vss sg13cmos5l_Corner_1.vss sg13_hv_nmos ad=2.596p pd=5.58u as=1.408p ps=5.04u w=4.4u l=0.6u
X631 a_87730_99564# a_88173_99607# a_87470_100034# sg13cmos5l_Corner_1.vss sg13_lv_nmos ad=79.8f pd=0.8u as=0.1296p ps=1.52u w=0.42u l=0.13u
X632 sg13cmos5l_Corner_1.vss a_92433_98441# a_92388_98486# sg13cmos5l_Corner_1.vss sg13_lv_nmos ad=0.1428p pd=1.52u as=47.25f ps=0.645u w=0.42u l=0.13u
X633 sg13cmos5l_Corner_1.vss a_115639_178370# sg13cmos5l_IOPadAnalog_13.pad sg13cmos5l_Corner_1.vss sg13_hv_nmos ad=1.408p pd=5.04u as=2.596p ps=5.58u w=4.4u l=0.6u
X634 sg13cmos5l_Corner_1.vss sg13cmos5l_IOPadVdd$1_0.sg13cmos5l_Clamp_N43N43D4R$1_0.gate vdd sg13cmos5l_Corner_1.vss sg13_hv_nmos ad=1.408p pd=5.04u as=2.596p ps=5.58u w=4.4u l=0.6u
X635 adc8b_0.side_cap8b_0.buf_8_2.z adc8b_0.side_cap8b_0.in_h_sw[4] vddr vddr sg13_lv_pmos ad=0.19p pd=1.38u as=0.19p ps=1.38u w=1u l=0.13u
X636 adc8b_0.side_cap8b_1.buf_32_0.z adc8b_0.sar12b_0.nl_sw[0] vddr vddr sg13_lv_pmos ad=0.19p pd=1.38u as=0.19p ps=1.38u w=1u l=0.13u
X637 sg13cmos5l_Corner_1.vss adc8b_0.sar12b_0.sg13cmos5l_buf_1_73.X a_87568_100384# sg13cmos5l_Corner_1.vss sg13_lv_nmos ad=0.14875p pd=1.16u as=0.187p ps=1.78u w=0.55u l=0.13u
X638 a_83646_97497# a_83765_97286# sg13cmos5l_Corner_1.vss sg13cmos5l_Corner_1.vss sg13_lv_nmos ad=0.2516p pd=2.16u as=0.1406p ps=1.12u w=0.74u l=0.13u
X639 sg13cmos5l_IOPadAnalog_0.pad a_164624_86044# sg13cmos5l_Corner_1.iovdd sg13cmos5l_Corner_1.iovdd sg13_hv_pmos ad=3.9294p pd=7.84u as=2.1312p ps=7.3u w=6.66u l=0.6u
X640 a_97234_93516# a_97677_93559# a_96974_93986# sg13cmos5l_Corner_1.vss sg13_lv_nmos ad=79.8f pd=0.8u as=0.1296p ps=1.52u w=0.42u l=0.13u
X641 a_36456_135415# a_40542_135085# sg13cmos5l_Corner_1.vss rppd l=20u w=1u
X642 vddr adc8b_0.sar12b_0.nl_sw[0] adc8b_0.side_cap8b_1.buf_32_0.z vddr sg13_lv_pmos ad=0.19p pd=1.38u as=0.19p ps=1.38u w=1u l=0.13u
X643 a_98193_98131# a_97836_98088# vdd vdd sg13_lv_pmos ad=63f pd=0.72u as=0.1563p ps=1.22u w=0.42u l=0.13u
X644 data[0] a_70044_42476# sg13cmos5l_Corner_1.iovdd sg13cmos5l_Corner_1.iovdd sg13_hv_pmos ad=3.9294p pd=7.84u as=2.1312p ps=7.3u w=6.66u l=0.6u
X645 adc8b_0.sar12b_0.sg13cmos5l_dlhr_1_10.Q_N a_101886_97304# vdd vdd sg13_lv_pmos ad=0.3808p pd=2.92u as=0.1974p ps=1.5u w=1.12u l=0.13u
X646 vdd adc8b_0.sar12b_0.sg13cmos5l_inv_1_6.A adc8b_0.sar12b_0.sg13cmos5l_buf_1_0.A vdd sg13_lv_pmos ad=0.3808p pd=2.92u as=0.3808p ps=2.92u w=1.12u l=0.13u
X647 sg13cmos5l_IOPadAnalog_1.pad a_178296_70044# sg13cmos5l_Corner_1.vss sg13cmos5l_Corner_1.vss sg13_hv_nmos ad=2.596p pd=5.58u as=1.408p ps=5.04u w=4.4u l=0.6u
X648 vdd sg13cmos5l_IOPadVdd$1_0.sg13cmos5l_RCClampInverter$1_0.in sg13cmos5l_IOPadVdd$1_0.sg13cmos5l_Clamp_N43N43D4R$1_0.gate vdd sg13_hv_pmos ad=1.33p pd=7.38u as=1.33p ps=7.38u w=7u l=0.5u
X649 adc8b_0.sar12b_0.sg13cmos5l_buf_1_89.A a_96657_98441# vdd vdd sg13_lv_pmos ad=0.3808p pd=2.92u as=0.2128p ps=1.5u w=1.12u l=0.13u
X650 vdd a_97677_93559# a_97779_93559# vdd sg13_lv_pmos ad=1.86162p pd=11.935u as=0.3864p ps=2.93u w=1.12u l=0.13u
X651 a_89016_94620# a_88465_94352# vdd vdd sg13_lv_pmos ad=0.105p pd=1.21u as=1.43437p ps=9.105u w=1u l=0.13u
X652 sg13cmos5l_Corner_1.vss a_118044_30676# cko sg13cmos5l_Corner_1.vss sg13_hv_nmos ad=1.408p pd=5.04u as=2.596p ps=5.58u w=4.4u l=0.6u
X653 vip a_42476_102044# sg13cmos5l_Corner_1.iovdd sg13cmos5l_Corner_1.iovdd sg13_hv_pmos ad=3.9294p pd=7.84u as=2.1312p ps=7.3u w=6.66u l=0.6u
X654 sg13cmos5l_Corner_1.vss a_82964_99560# adc8b_0.sar12b_0.sg13cmos5l_buf_1_63.X sg13cmos5l_Corner_1.vss sg13_lv_nmos ad=0.14875p pd=1.16u as=0.2886p ps=2.26u w=0.74u l=0.13u
X655 sg13cmos5l_IOPadAnalog_2.padres frame sg13cmos5l_Corner_1.vss rppd l=2u w=1u
X656 a_88173_99607# adc8b_0.sar12b_0.sg13cmos5l_inv_1_8.A vdd vdd sg13_lv_pmos ad=0.4088p pd=2.97u as=1.12242p ps=7u w=1.12u l=0.13u
X657 adc8b_0.side_cap8b_1.buf_16_1.z adc8b_0.sar12b_0.nl_sw[2] sg13cmos5l_Corner_1.vss sg13cmos5l_Corner_1.vss sg13_lv_nmos ad=95f pd=0.88u as=95f ps=0.88u w=0.5u l=0.13u
X658 vdd sg13cmos5l_IOPadVdd$1_0.sg13cmos5l_Clamp_N43N43D4R$1_0.gate sg13cmos5l_Corner_1.vss sg13cmos5l_Corner_1.vss sg13_hv_nmos ad=2.596p pd=5.58u as=1.408p ps=5.04u w=4.4u l=0.6u
X659 sg13cmos5l_IOPadAnalog_11.pad a_164624_118044# sg13cmos5l_Corner_1.iovdd sg13cmos5l_Corner_1.iovdd sg13_hv_pmos ad=3.9294p pd=7.84u as=2.1312p ps=7.3u w=6.66u l=0.6u
X660 sg13cmos5l_IOPadAnalog_13.pad a_115639_164698# sg13cmos5l_Corner_1.iovdd sg13cmos5l_Corner_1.iovdd sg13_hv_pmos ad=3.9294p pd=7.84u as=2.1312p ps=7.3u w=6.66u l=0.6u
X661 vdd a_92493_98813# a_92595_98956# vdd sg13_lv_pmos ad=1.15047p pd=7.175u as=0.3864p ps=2.93u w=1.12u l=0.13u
X662 sg13cmos5l_IOPadAnalog_12.pad a_131639_164698# sg13cmos5l_Corner_1.iovdd sg13cmos5l_Corner_1.iovdd sg13_hv_pmos ad=3.9294p pd=7.84u as=2.1312p ps=7.3u w=6.66u l=0.6u
X663 sg13cmos5l_Corner_1.vss a_30676_102044# vip sg13cmos5l_Corner_1.vss sg13_hv_nmos ad=1.408p pd=5.04u as=2.596p ps=5.58u w=4.4u l=0.6u
X664 adc8b_0.side_cap8b_0.buf_16_2.z adc8b_0.side_cap8b_0.in_l_sw[1] sg13cmos5l_Corner_1.vss sg13cmos5l_Corner_1.vss sg13_lv_nmos ad=95f pd=0.88u as=95f ps=0.88u w=0.5u l=0.13u
X665 a_89272_99838# a_89015_99957# a_89434_100034# sg13cmos5l_Corner_1.vss sg13_lv_nmos ad=0.1428p pd=1.52u as=37.8f ps=0.6u w=0.42u l=0.13u
X666 adc8b_0.side_cap8b_1.buf_32_1.z adc8b_0.sar12b_0.nh_sw[0] sg13cmos5l_Corner_1.vss sg13cmos5l_Corner_1.vss sg13_lv_nmos ad=95f pd=0.88u as=95f ps=0.88u w=0.5u l=0.13u
X667 a_87396_94334# a_86847_94314# a_87260_94620# sg13cmos5l_Corner_1.vss sg13_lv_nmos ad=47.25f pd=0.645u as=0.141p ps=1.17u w=0.42u l=0.13u
X668 vdd a_98445_97301# a_98547_97444# vdd sg13_lv_pmos ad=1.07253p pd=6.75u as=0.3864p ps=2.93u w=1.12u l=0.13u
X669 a_83630_95498# a_84435_95071# a_83890_95028# vdd sg13_lv_pmos ad=0.1428p pd=1.52u as=79.8f ps=0.8u w=0.42u l=0.13u
X670 sg13cmos5l_Corner_1.vss a_86044_30676# data[1] sg13cmos5l_Corner_1.vss sg13_hv_nmos ad=1.408p pd=5.04u as=2.596p ps=5.58u w=4.4u l=0.6u
X671 sg13cmos5l_IOPadAnalog_11.pad a_178296_118044# sg13cmos5l_Corner_1.vss sg13cmos5l_Corner_1.vss sg13_hv_nmos ad=2.596p pd=5.58u as=1.408p ps=5.04u w=4.4u l=0.6u
X672 vddr a_30676_70044# sg13cmos5l_Corner_1.vss sg13cmos5l_Corner_1.vss sg13_hv_nmos ad=2.596p pd=5.58u as=1.408p ps=5.04u w=4.4u l=0.6u
X673 adc8b_0.side_cap8b_0.buf_32_1.z adc8b_0.side_cap8b_0.in_h_sw[0] sg13cmos5l_Corner_1.vss sg13cmos5l_Corner_1.vss sg13_lv_nmos ad=0.17p pd=1.68u as=95f ps=0.88u w=0.5u l=0.13u
X674 sg13cmos5l_Corner_1.vss adc8b_0.sar12b_0.sg13cmos5l_buf_1_74.X a_88336_100384# sg13cmos5l_Corner_1.vss sg13_lv_nmos ad=0.14875p pd=1.16u as=0.187p ps=1.78u w=0.55u l=0.13u
X675 a_94258_97545# a_94701_97301# a_93998_97322# sg13cmos5l_Corner_1.vss sg13_lv_nmos ad=79.8f pd=0.8u as=0.1296p ps=1.52u w=0.42u l=0.13u
X676 vddr adc8b_0.side_cap8b_0.in_l_sw[2] adc8b_0.side_cap8b_0.buf_16_1.z vddr sg13_lv_pmos ad=0.19p pd=1.38u as=0.19p ps=1.38u w=1u l=0.13u
X677 adc8b_0.sar12b_0.nh_sw[2] a_85456_92824# vdd vdd sg13_lv_pmos ad=0.42p pd=2.99u as=0.2114p ps=1.54u w=1.12u l=0.13u
X678 sg13cmos5l_Corner_1.vss a_86222_32962# dantenna l=1.26u w=27.78u
X679 a_98519_93909# a_97677_93559# a_97260_93552# vdd sg13_lv_pmos ad=0.2048p pd=1.63u as=0.34p ps=2.68u w=1u l=0.13u
X680 vip sg13cmos5l_Corner_1.iovdd dpantenna l=27.78u w=1.26u
X681 a_96588_98834# adc8b_0.sar12b_0.sg13cmos5l_buf_1_57.X a_96494_98834# sg13cmos5l_Corner_1.vss sg13_lv_nmos ad=60.89999f pd=0.71u as=0.1428p ps=1.52u w=0.42u l=0.13u
X682 vdd adc8b_0.sar12b_0.sg13cmos5l_dfrbp_1_6.RESET_B a_92433_98441# vdd sg13_lv_pmos ad=0.2128p pd=1.5u as=0.2128p ps=1.5u w=1.12u l=0.13u
X683 sg13cmos5l_Corner_1.vss a_100131_95430# adc8b_0.sar12b_0.sg13cmos5l_or2_1_0.A sg13cmos5l_Corner_1.vss sg13_lv_nmos ad=0.2516p pd=2.16u as=0.1406p ps=1.12u w=0.74u l=0.13u
X684 sg13cmos5l_Corner_1.vss a_67639_178370# sg13cmos5l_IOPadAnalog_10.pad sg13cmos5l_Corner_1.vss sg13_hv_nmos ad=1.408p pd=5.04u as=2.596p ps=5.58u w=4.4u l=0.6u
X685 vddr a_42476_70044# sg13cmos5l_Corner_1.iovdd sg13cmos5l_Corner_1.iovdd sg13_hv_pmos ad=3.9294p pd=7.84u as=2.1312p ps=7.3u w=6.66u l=0.6u
X686 sg13cmos5l_Corner_1.iovdd a_42476_70044# vddr sg13cmos5l_Corner_1.iovdd sg13_hv_pmos ad=2.1312p pd=7.3u as=3.9294p ps=7.84u w=6.66u l=0.6u
X687 a_91225_95802# a_90673_95864# sg13cmos5l_Corner_1.vss sg13cmos5l_Corner_1.vss sg13_lv_nmos ad=71.99999f pd=0.865u as=2.41737p ps=15.64u w=0.64u l=0.13u
X688 adc8b_0.sar12b_0.sg13cmos5l_dfrbp_1_9.Q_N a_85175_95421# vdd vdd sg13_lv_pmos ad=0.4312p pd=3.01u as=0.2639p ps=1.81u w=1.12u l=0.13u
X689 sg13cmos5l_IOPadAnalog_16.pad a_164624_102044# sg13cmos5l_Corner_1.iovdd sg13cmos5l_Corner_1.iovdd sg13_hv_pmos ad=3.9294p pd=7.84u as=2.1312p ps=7.3u w=6.66u l=0.6u
X690 adc8b_0.side_cap8b_1.buf_32_1.z adc8b_0.sar12b_0.nh_sw[0] sg13cmos5l_Corner_1.vss sg13cmos5l_Corner_1.vss sg13_lv_nmos ad=95f pd=0.88u as=95f ps=0.88u w=0.5u l=0.13u
X691 vdd sg13cmos5l_IOPadVdd$1_0.sg13cmos5l_Clamp_N43N43D4R$1_0.gate sg13cmos5l_Corner_1.vss sg13cmos5l_Corner_1.vss sg13_hv_nmos ad=2.596p pd=5.58u as=1.408p ps=5.04u w=4.4u l=0.6u
X692 sg13cmos5l_Corner_1.vss vdd sg13cmos5l_Corner_1.vss sg13cmos5l_Corner_1.vss sg13_lv_nmos ad=0.1428p pd=1.52u as=0 ps=0 w=0.42u l=1u
X693 vdd adc8b_0.sar12b_0.sg13cmos5l_buf_1_28.A a_91216_92824# vdd sg13_lv_pmos ad=0.2114p pd=1.54u as=0.2856p ps=2.36u w=0.84u l=0.13u
X694 adc8b_0.sar12b_0.sg13cmos5l_nor2_1_2.A adc8b_0.sar12b_0.sg13cmos5l_inv_1_9.Y sg13cmos5l_Corner_1.vss sg13cmos5l_Corner_1.vss sg13_lv_nmos ad=0.2516p pd=2.16u as=0.2516p ps=2.16u w=0.74u l=0.13u
X695 data[1] a_86044_30676# sg13cmos5l_Corner_1.vss sg13cmos5l_Corner_1.vss sg13_hv_nmos ad=2.596p pd=5.58u as=1.408p ps=5.04u w=4.4u l=0.6u
X696 sg13cmos5l_Corner_1.iovdd a_42476_118044# cks sg13cmos5l_Corner_1.iovdd sg13_hv_pmos ad=2.1312p pd=7.3u as=3.9294p ps=7.84u w=6.66u l=0.6u
X697 a_91839_98442# adc8b_0.sar12b_0.sg13cmos5l_dfrbp_1_18.Q sg13cmos5l_Corner_1.vss sg13cmos5l_Corner_1.vss sg13_lv_nmos ad=0.2516p pd=2.16u as=0.15055p ps=1.17u w=0.74u l=0.13u
X698 sg13cmos5l_Corner_1.iovdd a_118044_42476# cko sg13cmos5l_Corner_1.iovdd sg13_hv_pmos ad=2.1312p pd=7.3u as=3.9294p ps=7.84u w=6.66u l=0.6u
X699 sg13cmos5l_Corner_1.vss a_178296_86044# sg13cmos5l_IOPadAnalog_0.pad sg13cmos5l_Corner_1.vss sg13_hv_nmos ad=1.408p pd=5.04u as=2.596p ps=5.58u w=4.4u l=0.6u
X700 vdd adc8b_0.sar12b_0.sg13cmos5l_dfrbp_1_0.RESET_B a_93202_93516# vdd sg13_lv_pmos ad=0.1563p pd=1.22u as=0.147p ps=1.54u w=0.42u l=0.13u
X701 vdd a_86193_98441# a_86126_98084# vdd sg13_lv_pmos ad=0.2387p pd=1.84u as=0.1008p ps=0.9u w=0.42u l=0.13u
X702 data[2] a_102044_42476# sg13cmos5l_Corner_1.iovdd sg13cmos5l_Corner_1.iovdd sg13_hv_pmos ad=3.9294p pd=7.84u as=2.1312p ps=7.3u w=6.66u l=0.6u
X703 cko sg13cmos5l_Corner_1.iovdd dpantenna l=1.26u w=27.78u
X704 sg13cmos5l_Corner_1.vss adc8b_0.sar12b_0.sg13cmos5l_dfrbp_1_10.Q_N a_85009_93906# sg13cmos5l_Corner_1.vss sg13_lv_nmos ad=0.15055p pd=1.17u as=0.187p ps=1.78u w=0.55u l=0.13u
X705 sg13cmos5l_Corner_1.vss adc8b_0.side_cap8b_0.in_h_sw[5] adc8b_0.side_cap8b_0.buf_8_5.z sg13cmos5l_Corner_1.vss sg13_lv_nmos ad=95f pd=0.88u as=95f ps=0.88u w=0.5u l=0.13u
X706 a_84554_98826# a_84364_99156# a_84116_98784# sg13cmos5l_Corner_1.vss sg13_lv_nmos ad=71.99999f pd=0.865u as=0.141p ps=1.17u w=0.64u l=0.13u
X707 sg13cmos5l_Corner_1.vss a_84599_98790# a_84554_98826# sg13cmos5l_Corner_1.vss sg13_lv_nmos ad=1.49685p pd=9.6u as=71.99999f ps=0.865u w=0.64u l=0.13u
X708 a_83765_97286# a_84495_97540# a_84406_97637# vdd sg13_lv_pmos ad=0.2048p pd=1.63u as=93.45f ps=0.865u w=0.42u l=0.13u
X709 sg13cmos5l_IOPadAnalog_6.padres data[0] sg13cmos5l_Corner_1.vss rppd l=2u w=1u
X710 sg13cmos5l_IOPadAnalog_16.pad a_178296_102044# sg13cmos5l_Corner_1.vss sg13cmos5l_Corner_1.vss sg13_hv_nmos ad=2.596p pd=5.58u as=1.408p ps=5.04u w=4.4u l=0.6u
X711 a_79552_97015# adc8b_0.cmp_0.sg13cmos5l_inv_1$1_1.Y sg13cmos5l_Corner_1.vss sg13cmos5l_Corner_1.vss sg13_lv_nmos ad=0.1045p pd=0.93u as=0.187p ps=1.78u w=0.55u l=0.13u
X712 a_93641_96920# adc8b_0.sar12b_0.sg13cmos5l_inv_1_29.Y adc8b_0.sar12b_0.sg13cmos5l_a221oi_1_0.B2 sg13cmos5l_Corner_1.vss sg13_lv_nmos ad=0.1406p pd=1.12u as=0.1406p ps=1.12u w=0.74u l=0.13u
X713 a_93741_92765# adc8b_0.sar12b_0.sg13cmos5l_dfrbp_1_0.CLK vdd vdd sg13_lv_pmos ad=0.4088p pd=2.97u as=1.777p ps=11.395u w=1.12u l=0.13u
X714 vddr adc8b_0.side_cap8b_0.in_l_sw[0] adc8b_0.side_cap8b_0.buf_32_0.z vddr sg13_lv_pmos ad=0.19p pd=1.38u as=0.19p ps=1.38u w=1u l=0.13u
X715 sg13cmos5l_Corner_1.vss a_89265_94298# a_89790_94280# sg13cmos5l_Corner_1.vss sg13_lv_nmos ad=0.1491p pd=1.18u as=0.187p ps=1.78u w=0.55u l=0.13u
X716 sg13cmos5l_Corner_1.vss a_102222_175886# dantenna l=1.26u w=27.78u
X717 a_83996_96132# a_83714_95820# a_83929_95802# sg13cmos5l_Corner_1.vss sg13_lv_nmos ad=0.141p pd=1.17u as=71.99999f ps=0.865u w=0.64u l=0.13u
X718 a_88140_96128# a_88659_95932# a_89399_95887# sg13cmos5l_Corner_1.vss sg13_lv_nmos ad=0.3473p pd=2.71u as=0.12665p ps=1.145u w=0.74u l=0.13u
X719 adc8b_0.side_cap8b_1.buf_4_1.z adc8b_0.sar12b_0.nh_sw[6] vddr vddr sg13_lv_pmos ad=0.19p pd=1.38u as=0.19p ps=1.38u w=1u l=0.13u
X720 sg13cmos5l_IOPadAnalog_9.pad a_83639_164698# sg13cmos5l_Corner_1.iovdd sg13cmos5l_Corner_1.iovdd sg13_hv_pmos ad=3.9294p pd=7.84u as=2.1312p ps=7.3u w=6.66u l=0.6u
X721 vdd sg13cmos5l_IOPadVdd$1_0.sg13cmos5l_RCClampInverter$1_0.in sg13cmos5l_IOPadVdd$1_0.sg13cmos5l_Clamp_N43N43D4R$1_0.gate vdd sg13_hv_pmos ad=1.33p pd=7.38u as=1.33p ps=7.38u w=7u l=0.5u
X722 a_83929_95802# a_83377_95864# sg13cmos5l_Corner_1.vss sg13cmos5l_Corner_1.vss sg13_lv_nmos ad=71.99999f pd=0.865u as=2.41737p ps=15.64u w=0.64u l=0.13u
X723 a_101012_93512# adc8b_0.sar12b_0.sg13cmos5l_buf_1_18.X sg13cmos5l_Corner_1.vss sg13cmos5l_Corner_1.vss sg13_lv_nmos ad=0.187p pd=1.78u as=0.14875p ps=1.16u w=0.55u l=0.13u
X724 adc8b_0.sar12b_0.sg13cmos5l_buf_1_97.A a_92241_100346# sg13cmos5l_Corner_1.vss sg13cmos5l_Corner_1.vss sg13_lv_nmos ad=0.2516p pd=2.16u as=0.1406p ps=1.12u w=0.74u l=0.13u
X725 vdd a_98296_99054# a_98241_99149# vdd sg13_lv_pmos ad=1.15047p pd=7.175u as=93.45f ps=0.865u w=0.42u l=0.13u
X726 vdd adc8b_0.sar12b_0.sg13cmos5l_buf_1_77.X a_89104_100384# vdd sg13_lv_pmos ad=0.2114p pd=1.54u as=0.2856p ps=2.36u w=0.84u l=0.13u
X727 vdd a_100995_100350# adc8b_0.sar12b_0.sg13cmos5l_buf_8_2.X vdd sg13_lv_pmos ad=0.2128p pd=1.5u as=0.2128p ps=1.5u w=1.12u l=0.13u
X728 adc8b_0.sar12b_0.sg13cmos5l_dlhr_1_6.D a_89564_97620# vdd vdd sg13_lv_pmos ad=0.3808p pd=2.92u as=0.2128p ps=1.5u w=1.12u l=0.13u
X729 vdd a_68892_96252# a_68824_96348# sg13cmos5l_Corner_1.vss sg13_lv_nmos ad=0.442p pd=3.28u as=0.442p ps=3.28u w=1.3u l=0.13u
X730 vdd a_100977_96929# a_100910_96572# vdd sg13_lv_pmos ad=0.2387p pd=1.84u as=0.1008p ps=0.9u w=0.42u l=0.13u
X731 a_89198_94736# a_88802_94308# a_89084_94620# vdd sg13_lv_pmos ad=0.1008p pd=0.9u as=0.191p ps=1.44u w=0.42u l=0.13u
X732 adc8b_0.sar12b_0.sg13cmos5l_o21ai_1_0.Y adc8b_0.sar12b_0.sg13cmos5l_o21ai_1_0.B1 a_93790_94294# sg13cmos5l_Corner_1.vss sg13_lv_nmos ad=0.2516p pd=2.16u as=0.1406p ps=1.12u w=0.74u l=0.15u
X733 a_100628_100310# adc8b_0.sar12b_0.sg13cmos5l_buf_1_101.X sg13cmos5l_Corner_1.vss sg13cmos5l_Corner_1.vss sg13_lv_nmos ad=0.187p pd=1.78u as=0.14875p ps=1.16u w=0.55u l=0.13u
X734 a_89015_99957# a_88173_99607# a_87756_99600# vdd sg13_lv_pmos ad=0.2048p pd=1.63u as=0.34p ps=2.68u w=1u l=0.13u
X735 vdd a_83252_97286# adc8b_0.sar12b_0.sg13cmos5l_buf_1_40.A vdd sg13_lv_pmos ad=0.2114p pd=1.54u as=0.42p ps=2.99u w=1.12u l=0.13u
X736 sg13cmos5l_Corner_1.vss a_100696_93006# a_100345_92863# sg13cmos5l_Corner_1.vss sg13_lv_nmos ad=79.8f pd=0.8u as=0.1428p ps=1.52u w=0.42u l=0.13u
X737 sg13cmos5l_Corner_1.iovdd a_115639_164698# sg13cmos5l_IOPadAnalog_13.pad sg13cmos5l_Corner_1.iovdd sg13_hv_pmos ad=2.1312p pd=7.3u as=3.9294p ps=7.84u w=6.66u l=0.6u
X738 sg13cmos5l_Corner_1.iovdd a_131639_164698# sg13cmos5l_IOPadAnalog_12.pad sg13cmos5l_Corner_1.iovdd sg13_hv_pmos ad=2.1312p pd=7.3u as=3.9294p ps=7.84u w=6.66u l=0.6u
X739 sg13cmos5l_Corner_1.vss sg13cmos5l_IOPadVdd$1_0.sg13cmos5l_Clamp_N43N43D4R$1_0.gate vdd sg13cmos5l_Corner_1.vss sg13_hv_nmos ad=1.408p pd=5.04u as=2.596p ps=5.58u w=4.4u l=0.6u
X740 sg13cmos5l_Corner_1.vss adc8b_0.side_cap8b_0.in_l_sw[0] adc8b_0.side_cap8b_0.buf_32_0.z sg13cmos5l_Corner_1.vss sg13_lv_nmos ad=95f pd=0.88u as=95f ps=0.88u w=0.5u l=0.13u
X741 vdd a_97655_99957# a_98492_99596# vdd sg13_lv_pmos ad=0.2128p pd=1.5u as=0.3864p ps=2.93u w=1.12u l=0.13u
X742 adc8b_0.sar12b_0.sg13cmos5l_buf_1_8.A adc8b_0.sar12b_0.sg13cmos5l_inv_1_7.A sg13cmos5l_Corner_1.vss sg13cmos5l_Corner_1.vss sg13_lv_nmos ad=0.2516p pd=2.16u as=0.2516p ps=2.16u w=0.74u l=0.13u
X743 sg13cmos5l_Corner_1.vss sg13cmos5l_IOPadVdd$1_0.sg13cmos5l_RCClampInverter$1_0.in sg13cmos5l_IOPadVdd$1_0.sg13cmos5l_Clamp_N43N43D4R$1_0.gate sg13cmos5l_Corner_1.vss sg13_hv_nmos ad=1.71p pd=9.38u as=1.71p ps=9.38u w=9u l=0.5u
X744 a_98002_97545# a_98445_97301# a_97742_97322# sg13cmos5l_Corner_1.vss sg13_lv_nmos ad=79.8f pd=0.8u as=0.1296p ps=1.52u w=0.42u l=0.13u
X745 vdd adc8b_0.sar12b_0.sg13cmos5l_dfrbp_1_8.RESET_B a_87220_97010# vdd sg13_lv_pmos ad=1.2517p pd=7.955u as=79.8f ps=0.8u w=0.42u l=0.13u
X746 vdd adc8b_0.sar12b_0.sg13cmos5l_dfrbp_1_6.RESET_B a_87441_94298# vdd sg13_lv_pmos ad=0.2128p pd=1.5u as=0.2128p ps=1.5u w=1.12u l=0.13u
X747 sg13cmos5l_Corner_1.vss adc8b_0.sar12b_0.nl_sw[0] adc8b_0.side_cap8b_1.buf_32_0.z sg13cmos5l_Corner_1.vss sg13_lv_nmos ad=95f pd=0.88u as=95f ps=0.88u w=0.5u l=0.13u
X748 sg13cmos5l_Corner_1.vss sg13cmos5l_IOPadVdd$1_0.sg13cmos5l_Clamp_N43N43D4R$1_0.gate vdd sg13cmos5l_Corner_1.vss sg13_hv_nmos ad=1.408p pd=5.04u as=2.596p ps=5.58u w=4.4u l=0.6u
X749 vddr adc8b_0.side_cap8b_0.in_l_sw[0] adc8b_0.side_cap8b_0.buf_32_0.z vddr sg13_lv_pmos ad=0.19p pd=1.38u as=0.19p ps=1.38u w=1u l=0.13u
X750 a_90540_99600# a_91059_99607# a_91799_99957# sg13cmos5l_Corner_1.vss sg13_lv_nmos ad=0.3473p pd=2.71u as=0.12665p ps=1.145u w=0.74u l=0.13u
X751 adc8b_0.sar12b_0.nl_sw[3] a_86224_92824# sg13cmos5l_Corner_1.vss sg13cmos5l_Corner_1.vss sg13_lv_nmos ad=0.2886p pd=2.26u as=0.14875p ps=1.16u w=0.74u l=0.13u
X752 adc8b_0.sar12b_0.sg13cmos5l_dfrbp_1_8.RESET_B cks sg13cmos5l_Corner_1.vss sg13cmos5l_Corner_1.vss sg13_lv_nmos ad=0.2516p pd=2.16u as=0.2516p ps=2.16u w=0.74u l=0.13u
X753 sg13cmos5l_Corner_1.iovdd a_118044_42476# cko sg13cmos5l_Corner_1.iovdd sg13_hv_pmos ad=2.1312p pd=7.3u as=3.9294p ps=7.84u w=6.66u l=0.6u
X754 sg13cmos5l_Corner_1.vss adc8b_0.sar12b_0.sg13cmos5l_dfrbp_1_21.Q_N a_100561_97376# sg13cmos5l_Corner_1.vss sg13_lv_nmos ad=0.15055p pd=1.17u as=0.187p ps=1.78u w=0.55u l=0.13u
X755 vdd a_90225_98441# a_90158_98084# vdd sg13_lv_pmos ad=0.2387p pd=1.84u as=0.1008p ps=0.9u w=0.42u l=0.13u
X756 sg13cmos5l_Corner_1.vss a_178296_118044# sg13cmos5l_IOPadAnalog_11.pad sg13cmos5l_Corner_1.vss sg13_hv_nmos ad=1.408p pd=5.04u as=2.596p ps=5.58u w=4.4u l=0.6u
X757 sg13cmos5l_Corner_1.vss adc8b_0.sar12b_0.nh_sw[3] adc8b_0.side_cap8b_1.buf_8_3.z sg13cmos5l_Corner_1.vss sg13_lv_nmos ad=95f pd=0.88u as=95f ps=0.88u w=0.5u l=0.13u
X758 adc8b_0.side_cap8b_1.buf_16_1.z adc8b_0.sar12b_0.nl_sw[2] vddr vddr sg13_lv_pmos ad=0.19p pd=1.38u as=0.19p ps=1.38u w=1u l=0.13u
X759 sg13cmos5l_Corner_1.vss sg13cmos5l_IOPadVdd$1_0.sg13cmos5l_RCClampInverter$1_0.in sg13cmos5l_IOPadVdd$1_0.sg13cmos5l_Clamp_N43N43D4R$1_0.gate sg13cmos5l_Corner_1.vss sg13_hv_nmos ad=1.71p pd=9.38u as=1.71p ps=9.38u w=9u l=0.5u
X760 vdd sg13cmos5l_IOPadVdd$1_0.sg13cmos5l_RCClampInverter$1_0.in sg13cmos5l_IOPadVdd$1_0.sg13cmos5l_Clamp_N43N43D4R$1_0.gate vdd sg13_hv_pmos ad=1.33p pd=7.38u as=1.33p ps=7.38u w=7u l=0.5u
X761 vdd a_91839_98442# a_91970_98448# vdd sg13_lv_pmos ad=1.07253p pd=6.75u as=0.2856p ps=2.36u w=0.84u l=0.13u
X762 a_98316_97335# a_98028_97640# a_98254_97335# sg13cmos5l_Corner_1.vss sg13_lv_nmos ad=0.1428p pd=1.52u as=37.8f ps=0.6u w=0.42u l=0.13u
X763 adc8b_0.side_cap8b_0.buf_8_3.z adc8b_0.side_cap8b_0.in_h_sw[3] sg13cmos5l_Corner_1.vss sg13cmos5l_Corner_1.vss sg13_lv_nmos ad=95f pd=0.88u as=95f ps=0.88u w=0.5u l=0.13u
X764 vdd a_96657_98441# a_97182_98514# vdd sg13_lv_pmos ad=0.1974p pd=1.5u as=0.2856p ps=2.36u w=0.84u l=0.13u
X765 frame a_134044_42476# sg13cmos5l_Corner_1.iovdd sg13cmos5l_Corner_1.iovdd sg13_hv_pmos ad=3.9294p pd=7.84u as=2.1312p ps=7.3u w=6.66u l=0.6u
X766 sg13cmos5l_Corner_1.vss adc8b_0.sar12b_0.sg13cmos5l_buf_1_40.A a_82960_92824# sg13cmos5l_Corner_1.vss sg13_lv_nmos ad=0.14875p pd=1.16u as=0.187p ps=1.78u w=0.55u l=0.13u
X767 sg13cmos5l_Corner_1.vss adc8b_0.sar12b_0.nl_sw[0] adc8b_0.side_cap8b_1.buf_32_0.z sg13cmos5l_Corner_1.vss sg13_lv_nmos ad=95f pd=0.88u as=95f ps=0.88u w=0.5u l=0.13u
X768 adc8b_0.side_cap8b_0.buf_2_3.z adc8b_0.side_cap8b_0.in_h_sw[9] vddr vddr sg13_lv_pmos ad=0.34p pd=2.68u as=0.19p ps=1.38u w=1u l=0.13u
X769 a_94748_98084# a_94466_98448# a_94681_98486# sg13cmos5l_Corner_1.vss sg13_lv_nmos ad=0.141p pd=1.17u as=71.99999f ps=0.865u w=0.64u l=0.13u
X770 adc8b_0.sar12b_0.sg13cmos5l_buf_1_116.A a_96945_96929# sg13cmos5l_Corner_1.vss sg13cmos5l_Corner_1.vss sg13_lv_nmos ad=0.2516p pd=2.16u as=0.1406p ps=1.12u w=0.74u l=0.13u
X771 sg13cmos5l_Corner_1.vss adc8b_0.side_cap8b_0.in_h_sw[0] adc8b_0.side_cap8b_0.buf_32_1.z sg13cmos5l_Corner_1.vss sg13_lv_nmos ad=95f pd=0.88u as=95f ps=0.88u w=0.5u l=0.13u
X772 adc8b_0.sar12b_0.sg13cmos5l_dfrbp_1_18.Q a_89852_99596# vdd vdd sg13_lv_pmos ad=0.3808p pd=2.92u as=0.2128p ps=1.5u w=1.12u l=0.13u
X773 adc8b_0.sar12b_0.sg13cmos5l_dlhr_1_19.Q_N a_97470_97002# sg13cmos5l_Corner_1.vss sg13cmos5l_Corner_1.vss sg13_lv_nmos ad=0.2516p pd=2.16u as=0.1491p ps=1.18u w=0.74u l=0.13u
X774 adc8b_0.sar12b_0.sg13cmos5l_dfrbp_1_9.Q_N a_85175_95421# sg13cmos5l_Corner_1.vss sg13cmos5l_Corner_1.vss sg13_lv_nmos ad=0.2849p pd=2.25u as=0.2516p ps=2.16u w=0.74u l=0.13u
X775 adc8b_0.sar12b_0.nl_sw[2] a_84016_92824# vdd vdd sg13_lv_pmos ad=0.42p pd=2.99u as=0.2114p ps=1.54u w=1.12u l=0.13u
X776 sg13cmos5l_Corner_1.vss a_70222_175886# dantenna l=1.26u w=27.78u
X777 vddr adc8b_0.sar12b_0.nl_sw[1] adc8b_0.side_cap8b_1.buf_16_2.z vddr sg13_lv_pmos ad=0.19p pd=1.38u as=0.19p ps=1.38u w=1u l=0.13u
X778 adc8b_0.side_cap8b_1.buf_32_0.z adc8b_0.sar12b_0.nl_sw[0] sg13cmos5l_Corner_1.vss sg13cmos5l_Corner_1.vss sg13_lv_nmos ad=95f pd=0.88u as=95f ps=0.88u w=0.5u l=0.13u
X779 sg13cmos5l_IOPadAnalog_15.pad a_99639_164698# sg13cmos5l_Corner_1.iovdd sg13cmos5l_Corner_1.iovdd sg13_hv_pmos ad=3.9294p pd=7.84u as=2.1312p ps=7.3u w=6.66u l=0.6u
X780 sg13cmos5l_IOPadAnalog_13.pad a_115639_164698# sg13cmos5l_Corner_1.iovdd sg13cmos5l_Corner_1.iovdd sg13_hv_pmos ad=3.9294p pd=7.84u as=2.1312p ps=7.3u w=6.66u l=0.6u
X781 a_84500_100310# adc8b_0.sar12b_0.sg13cmos5l_inv_1_20.Y sg13cmos5l_Corner_1.vss sg13cmos5l_Corner_1.vss sg13_lv_nmos ad=0.187p pd=1.78u as=0.14875p ps=1.16u w=0.55u l=0.13u
X782 adc8b_0.sar12b_0.sg13cmos5l_inv_1_20.Y adc8b_0.sar12b_0.sg13cmos5l_buf_1_41.A vdd vdd sg13_lv_pmos ad=0.3808p pd=2.92u as=0.3808p ps=2.92u w=1.12u l=0.13u
X783 sg13cmos5l_Corner_1.iovdd a_83639_164698# sg13cmos5l_IOPadAnalog_9.pad sg13cmos5l_Corner_1.iovdd sg13_hv_pmos ad=2.1312p pd=7.3u as=3.9294p ps=7.84u w=6.66u l=0.6u
X784 sg13cmos5l_Corner_1.vss adc8b_0.sar12b_0.nh_sw[0] adc8b_0.side_cap8b_1.buf_32_1.z sg13cmos5l_Corner_1.vss sg13_lv_nmos ad=95f pd=0.88u as=0.17p ps=1.68u w=0.5u l=0.13u
X785 sg13cmos5l_Corner_1.vss vdd sg13cmos5l_Corner_1.vss sg13cmos5l_Corner_1.vss sg13_lv_nmos ad=79.8f pd=0.8u as=0 ps=0 w=0.42u l=1u
X786 vdd adc8b_0.sar12b_0.sg13cmos5l_buf_1_31.X a_83440_94336# vdd sg13_lv_pmos ad=0.2114p pd=1.54u as=0.2856p ps=2.36u w=0.84u l=0.13u
X787 adc8b_0.diff_bsw_0.single_bsw_1.sg13cmos5l_inv_1$1_2.Y adc8b_0.diff_bsw_0.single_bsw_1.sg13cmos5l_inv_1$1_2.A sg13cmos5l_Corner_1.vss sg13cmos5l_Corner_1.vss sg13_lv_nmos ad=0.2516p pd=2.16u as=0.2516p ps=2.16u w=0.74u l=0.13u
X788 a_99261_95107# a_98319_95147# a_99122_95340# sg13cmos5l_Corner_1.vss sg13_lv_nmos ad=79.8f pd=0.8u as=0.2373p ps=1.97u w=0.42u l=0.13u
X789 vdd sg13cmos5l_IOPadVdd$1_0.sg13cmos5l_RCClampInverter$1_0.in sg13cmos5l_IOPadVdd$1_0.sg13cmos5l_Clamp_N43N43D4R$1_0.gate vdd sg13_hv_pmos ad=1.33p pd=7.38u as=1.33p ps=7.38u w=7u l=0.5u
X790 a_90428_96572# a_90146_96936# a_90361_96974# sg13cmos5l_Corner_1.vss sg13_lv_nmos ad=0.141p pd=1.17u as=71.99999f ps=0.865u w=0.64u l=0.13u
X791 adc8b_0.sar12b_0.sg13cmos5l_dlhr_1_10.Q a_101361_97322# vdd vdd sg13_lv_pmos ad=0.3808p pd=2.92u as=0.2128p ps=1.5u w=1.12u l=0.13u
X792 data[1] a_86044_42476# sg13cmos5l_Corner_1.iovdd sg13cmos5l_Corner_1.iovdd sg13_hv_pmos ad=3.9294p pd=7.84u as=2.1312p ps=7.3u w=6.66u l=0.6u
X793 sg13cmos5l_Corner_1.vss a_82676_92750# adc8b_0.sar12b_0.sg13cmos5l_buf_1_32.X sg13cmos5l_Corner_1.vss sg13_lv_nmos ad=0.14875p pd=1.16u as=0.2886p ps=2.26u w=0.74u l=0.13u
X794 a_99519_98850# adc8b_0.sar12b_0.sg13cmos5l_dfrbp_1_22.D sg13cmos5l_Corner_1.vss sg13cmos5l_Corner_1.vss sg13_lv_nmos ad=0.2516p pd=2.16u as=0.15055p ps=1.17u w=0.74u l=0.13u
X795 sg13cmos5l_Corner_1.vss adc8b_0.sar12b_0.sg13cmos5l_nor2b_1_0.Y a_92822_95452# sg13cmos5l_Corner_1.vss sg13_lv_nmos ad=0.2516p pd=2.16u as=96.2f ps=1u w=0.74u l=0.13u
X796 sg13cmos5l_Corner_1.vss a_100727_94375# a_101564_94596# sg13cmos5l_Corner_1.vss sg13_lv_nmos ad=0.1406p pd=1.12u as=0.2516p ps=2.16u w=0.74u l=0.13u
X797 adc8b_0.side_cap8b_0.in_h_sw[0] a_82384_100384# vdd vdd sg13_lv_pmos ad=0.42p pd=2.99u as=0.2114p ps=1.54u w=1.12u l=0.13u
X798 vdd a_84599_98790# a_84558_99156# vdd sg13_lv_pmos ad=1.15047p pd=7.175u as=0.105p ps=1.21u w=1u l=0.13u
X799 sg13cmos5l_Corner_1.vss a_134044_30676# frame sg13cmos5l_Corner_1.vss sg13_hv_nmos ad=1.408p pd=5.04u as=2.596p ps=5.58u w=4.4u l=0.6u
X800 sg13cmos5l_Corner_1.vss adc8b_0.sar12b_0.sg13cmos5l_dfrbp_1_6.RESET_B a_91708_95796# sg13cmos5l_Corner_1.vss sg13_lv_nmos ad=0.1406p pd=1.12u as=77.7f ps=0.95u w=0.74u l=0.13u
X801 a_87092_92750# adc8b_0.sar12b_0.sg13cmos5l_buf_1_34.X sg13cmos5l_Corner_1.vss sg13cmos5l_Corner_1.vss sg13_lv_nmos ad=0.187p pd=1.78u as=0.14875p ps=1.16u w=0.55u l=0.13u
X802 sg13cmos5l_IOPadAnalog_1.pad a_164624_70044# sg13cmos5l_Corner_1.iovdd sg13cmos5l_Corner_1.iovdd sg13_hv_pmos ad=3.9294p pd=7.84u as=2.1312p ps=7.3u w=6.66u l=0.6u
X803 sg13cmos5l_IOPadAnalog_0.pad a_164624_86044# sg13cmos5l_Corner_1.iovdd sg13cmos5l_Corner_1.iovdd sg13_hv_pmos ad=3.9294p pd=7.84u as=2.1312p ps=7.3u w=6.66u l=0.6u
X804 vdd a_92056_99838# a_92001_99719# vdd sg13_lv_pmos ad=1.15047p pd=7.175u as=93.45f ps=0.865u w=0.42u l=0.13u
X805 sg13cmos5l_IOPadAnalog_11.pad a_164624_118044# sg13cmos5l_Corner_1.iovdd sg13cmos5l_Corner_1.iovdd sg13_hv_pmos ad=3.9294p pd=7.84u as=2.1312p ps=7.3u w=6.66u l=0.6u
X806 cks a_30676_118044# sg13cmos5l_Corner_1.vss sg13cmos5l_Corner_1.vss sg13_hv_nmos ad=2.596p pd=5.58u as=1.408p ps=5.04u w=4.4u l=0.6u
X807 vddr adc8b_0.side_cap8b_0.in_l_sw[7] adc8b_0.side_cap8b_0.buf_4_0.z vddr sg13_lv_pmos ad=0.19p pd=1.38u as=0.34p ps=2.68u w=1u l=0.13u
X808 sg13cmos5l_Corner_1.vss a_93140_94262# adc8b_0.sar12b_0.nh_sw[5] sg13cmos5l_Corner_1.vss sg13_lv_nmos ad=0.14875p pd=1.16u as=0.2886p ps=2.26u w=0.74u l=0.13u
X809 data[0] a_70044_42476# sg13cmos5l_Corner_1.iovdd sg13cmos5l_Corner_1.iovdd sg13_hv_pmos ad=3.9294p pd=7.84u as=2.1312p ps=7.3u w=6.66u l=0.6u
X810 vdd a_101012_93512# adc8b_0.sar12b_0.nl_sw[9] vdd sg13_lv_pmos ad=0.2114p pd=1.54u as=0.42p ps=2.99u w=1.12u l=0.13u
X811 vdd a_88820_100310# adc8b_0.sar12b_0.sg13cmos5l_buf_1_76.X vdd sg13_lv_pmos ad=0.2114p pd=1.54u as=0.42p ps=2.99u w=1.12u l=0.13u
X812 a_90740_95024# adc8b_0.sar12b_0.sg13cmos5l_buf_1_45.A vdd vdd sg13_lv_pmos ad=0.2856p pd=2.36u as=0.2114p ps=1.54u w=0.84u l=0.13u
X813 vdd sg13cmos5l_IOPadVdd$1_0.sg13cmos5l_RCClampInverter$1_0.in sg13cmos5l_IOPadVdd$1_0.sg13cmos5l_Clamp_N43N43D4R$1_0.gate vdd sg13_hv_pmos ad=1.33p pd=7.38u as=1.33p ps=7.38u w=7u l=0.5u
X814 sg13cmos5l_Corner_1.vss a_100628_100310# adc8b_0.side_cap8b_0.in_h_sw[8] sg13cmos5l_Corner_1.vss sg13_lv_nmos ad=0.14875p pd=1.16u as=0.2886p ps=2.26u w=0.74u l=0.13u
X815 data[1] a_86044_30676# sg13cmos5l_Corner_1.vss sg13cmos5l_Corner_1.vss sg13_hv_nmos ad=2.596p pd=5.58u as=1.408p ps=5.04u w=4.4u l=0.6u
X816 a_85624_94518# a_85367_94375# a_85786_94298# sg13cmos5l_Corner_1.vss sg13_lv_nmos ad=0.1428p pd=1.52u as=37.8f ps=0.6u w=0.42u l=0.13u
X817 adc8b_0.sar12b_0.sg13cmos5l_dfrbp_1_1.D adc8b_0.sar12b_0.sg13cmos5l_a22oi_1_2.B2 a_91591_93940# sg13cmos5l_Corner_1.vss sg13_lv_nmos ad=0.2664p pd=1.46u as=0.13875p ps=1.115u w=0.74u l=0.13u
X818 a_99756_94311# a_99987_94420# a_99442_94521# sg13cmos5l_Corner_1.vss sg13_lv_nmos ad=0.2373p pd=1.97u as=79.8f ps=0.8u w=0.42u l=0.13u
X819 a_94766_94298# a_95571_94420# a_95026_94521# vdd sg13_lv_pmos ad=0.1428p pd=1.52u as=79.8f ps=0.8u w=0.42u l=0.13u
X820 sg13cmos5l_Corner_1.vss adc8b_0.sar12b_0.nh_sw[5] adc8b_0.side_cap8b_1.buf_8_5.z sg13cmos5l_Corner_1.vss sg13_lv_nmos ad=95f pd=0.88u as=0.17p ps=1.68u w=0.5u l=0.13u
X821 adc8b_0.sar12b_0.sg13cmos5l_inv_1_26.Y adc8b_0.sar12b_0.sg13cmos5l_buf_1_19.A vdd vdd sg13_lv_pmos ad=0.3808p pd=2.92u as=0.3808p ps=2.92u w=1.12u l=0.13u
X822 sg13cmos5l_IOPadAnalog_10.pad a_67639_164698# sg13cmos5l_Corner_1.iovdd sg13cmos5l_Corner_1.iovdd sg13_hv_pmos ad=3.9294p pd=7.84u as=2.1312p ps=7.3u w=6.66u l=0.6u
X823 a_92822_95452# adc8b_0.sar12b_0.sg13cmos5l_nand2_1_0.A adc8b_0.sar12b_0.sg13cmos5l_a22oi_1_0.Y sg13cmos5l_Corner_1.vss sg13_lv_nmos ad=96.2f pd=1u as=0.2664p ps=1.46u w=0.74u l=0.13u
X824 vddr adc8b_0.sar12b_0.nh_sw[1] adc8b_0.side_cap8b_1.buf_16_3.z vddr sg13_lv_pmos ad=0.19p pd=1.38u as=0.19p ps=1.38u w=1u l=0.13u
X825 sg13cmos5l_IOPadAnalog_9.pad a_83639_164698# sg13cmos5l_Corner_1.iovdd sg13cmos5l_Corner_1.iovdd sg13_hv_pmos ad=3.9294p pd=7.84u as=2.1312p ps=7.3u w=6.66u l=0.6u
X826 a_92551_95036# adc8b_0.sar12b_0.sg13cmos5l_inv_1_0.A adc8b_0.sar12b_0.sg13cmos5l_a22oi_1_0.Y vdd sg13_lv_pmos ad=0.2744p pd=1.61u as=0.2128p ps=1.5u w=1.12u l=0.13u
X827 a_82476_96576# a_82995_96583# a_83735_96933# sg13cmos5l_Corner_1.vss sg13_lv_nmos ad=0.3473p pd=2.71u as=0.12665p ps=1.145u w=0.74u l=0.13u
X828 adc8b_0.side_cap8b_1.buf_1_1.z adc8b_0.sar12b_0.nh_sw[10] sg13cmos5l_Corner_1.vss sg13cmos5l_Corner_1.vss sg13_lv_nmos ad=0.17p pd=1.68u as=0.17p ps=1.68u w=0.5u l=0.13u
X829 adc8b_0.sar12b_0.sg13cmos5l_buf_1_9.A a_91600_92824# vdd vdd sg13_lv_pmos ad=0.42p pd=2.99u as=0.2114p ps=1.54u w=1.12u l=0.13u
X830 adc8b_0.sar12b_0.sg13cmos5l_o21ai_1_0.A2 adc8b_0.sar12b_0.sg13cmos5l_nand2_1_0.A a_92770_94302# sg13cmos5l_Corner_1.vss sg13_lv_nmos ad=0.2516p pd=2.16u as=0.1406p ps=1.12u w=0.74u l=0.13u
X831 vdd sg13cmos5l_IOPadVdd$1_0.sg13cmos5l_Clamp_N43N43D4R$1_0.gate sg13cmos5l_Corner_1.vss sg13cmos5l_Corner_1.vss sg13_hv_nmos ad=2.596p pd=5.58u as=1.408p ps=5.04u w=4.4u l=0.6u
X832 sg13cmos5l_IOPadAnalog_1.pad a_164624_70044# sg13cmos5l_Corner_1.iovdd sg13cmos5l_Corner_1.iovdd sg13_hv_pmos ad=3.9294p pd=7.84u as=2.1312p ps=7.3u w=6.66u l=0.6u
X833 a_164624_86044# sg13cmos5l_Corner_1.iovdd sg13cmos5l_Corner_1.iovdd rppd l=12.9u w=0.5u
X834 sg13cmos5l_Corner_1.iovdd a_99639_164698# sg13cmos5l_IOPadAnalog_15.pad sg13cmos5l_Corner_1.iovdd sg13_hv_pmos ad=3.1302p pd=14.26u as=3.9294p ps=7.84u w=6.66u l=0.6u
X835 sg13cmos5l_Corner_1.iovdd a_115639_164698# sg13cmos5l_IOPadAnalog_13.pad sg13cmos5l_Corner_1.iovdd sg13_hv_pmos ad=2.1312p pd=7.3u as=3.9294p ps=7.84u w=6.66u l=0.6u
X836 sg13cmos5l_IOPadAnalog_16.pad a_164624_102044# sg13cmos5l_Corner_1.iovdd sg13cmos5l_Corner_1.iovdd sg13_hv_pmos ad=3.9294p pd=7.84u as=2.1312p ps=7.3u w=6.66u l=0.6u
X837 adc8b_0.side_cap8b_1.buf_16_0.z adc8b_0.sar12b_0.nh_sw[2] sg13cmos5l_Corner_1.vss sg13cmos5l_Corner_1.vss sg13_lv_nmos ad=95f pd=0.88u as=95f ps=0.88u w=0.5u l=0.13u
X838 sg13cmos5l_IOPadAnalog_13.padres sg13cmos5l_Corner_1.iovdd dpantenna l=0.64u w=4.98u
X839 sg13cmos5l_Corner_1.vss adc8b_0.sar12b_0.sg13cmos5l_dfrbp_1_6.RESET_B a_99964_99984# sg13cmos5l_Corner_1.vss sg13_lv_nmos ad=0.1406p pd=1.12u as=77.7f ps=0.95u w=0.74u l=0.13u
X840 vddr adc8b_0.side_cap8b_0.in_h_sw[6] adc8b_0.side_cap8b_0.buf_4_1.z vddr sg13_lv_pmos ad=0.19p pd=1.38u as=0.34p ps=2.68u w=1u l=0.13u
X841 vdd sg13cmos5l_Corner_1.vss vdd vdd sg13_lv_pmos ad=0.34p pd=2.68u as=0 ps=0 w=1u l=1u
X842 vdd a_89399_95887# a_89656_96030# vdd sg13_lv_pmos ad=0.2639p pd=1.81u as=79.8f ps=0.8u w=0.42u l=0.13u
X843 sg13cmos5l_Corner_1.vss a_70044_30676# data[0] sg13cmos5l_Corner_1.vss sg13_hv_nmos ad=1.408p pd=5.04u as=2.596p ps=5.58u w=4.4u l=0.6u
X844 vddr adc8b_0.sar12b_0.nh_sw[0] adc8b_0.side_cap8b_1.buf_32_1.z vddr sg13_lv_pmos ad=0.19p pd=1.38u as=0.19p ps=1.38u w=1u l=0.13u
X845 a_99284_100310# adc8b_0.sar12b_0.sg13cmos5l_buf_1_103.A sg13cmos5l_Corner_1.vss sg13cmos5l_Corner_1.vss sg13_lv_nmos ad=0.187p pd=1.78u as=0.14875p ps=1.16u w=0.55u l=0.13u
X846 sg13cmos5l_Corner_1.vss a_96657_98441# a_96612_98486# sg13cmos5l_Corner_1.vss sg13_lv_nmos ad=0.1428p pd=1.52u as=47.25f ps=0.645u w=0.42u l=0.13u
X847 vdd adc8b_0.sar12b_0.sg13cmos5l_dfrbp_1_0.RESET_B a_99442_94521# vdd sg13_lv_pmos ad=0.1563p pd=1.22u as=0.147p ps=1.54u w=0.42u l=0.13u
X848 vdd sg13cmos5l_IOPadVdd$1_0.sg13cmos5l_Clamp_N43N43D4R$1_0.gate sg13cmos5l_Corner_1.vss sg13cmos5l_Corner_1.vss sg13_hv_nmos ad=2.596p pd=5.58u as=1.408p ps=5.04u w=4.4u l=0.6u
X849 a_97912_99838# a_97655_99957# a_98074_100034# sg13cmos5l_Corner_1.vss sg13_lv_nmos ad=0.1428p pd=1.52u as=37.8f ps=0.6u w=0.42u l=0.13u
X850 adc8b_0.side_cap8b_1.buf_8_0.z adc8b_0.sar12b_0.nl_sw[4] sg13cmos5l_Corner_1.vss sg13cmos5l_Corner_1.vss sg13_lv_nmos ad=95f pd=0.88u as=95f ps=0.88u w=0.5u l=0.13u
X851 vddr adc8b_0.side_cap8b_0.in_l_sw[2] adc8b_0.side_cap8b_0.buf_16_1.z vddr sg13_lv_pmos ad=0.19p pd=1.38u as=0.19p ps=1.38u w=1u l=0.13u
X852 adc8b_0.side_cap8b_0.buf_32_1.z adc8b_0.side_cap8b_0.in_h_sw[0] sg13cmos5l_Corner_1.vss sg13cmos5l_Corner_1.vss sg13_lv_nmos ad=95f pd=0.88u as=95f ps=0.88u w=0.5u l=0.13u
X853 sg13cmos5l_IOPadAnalog_15.pad a_99639_164698# sg13cmos5l_Corner_1.iovdd sg13cmos5l_Corner_1.iovdd sg13_hv_pmos ad=3.9294p pd=7.84u as=2.1312p ps=7.3u w=6.66u l=0.6u
X854 vdd a_84500_92750# adc8b_0.sar12b_0.sg13cmos5l_buf_1_35.A vdd sg13_lv_pmos ad=0.2114p pd=1.54u as=0.42p ps=2.99u w=1.12u l=0.13u
X855 sg13cmos5l_Corner_1.iovdd a_42476_102044# vip sg13cmos5l_Corner_1.iovdd sg13_hv_pmos ad=2.1312p pd=7.3u as=3.9294p ps=7.84u w=6.66u l=0.6u
X856 sg13cmos5l_Corner_1.vss a_85367_94375# a_86204_94596# sg13cmos5l_Corner_1.vss sg13_lv_nmos ad=0.1406p pd=1.12u as=0.2516p ps=2.16u w=0.74u l=0.13u
X857 sg13cmos5l_Corner_1.vss a_178296_70044# sg13cmos5l_IOPadAnalog_1.pad sg13cmos5l_Corner_1.vss sg13_hv_nmos ad=1.408p pd=5.04u as=2.596p ps=5.58u w=4.4u l=0.6u
X858 cko a_118044_42476# sg13cmos5l_Corner_1.iovdd sg13cmos5l_Corner_1.iovdd sg13_hv_pmos ad=3.9294p pd=7.84u as=3.1302p ps=14.26u w=6.66u l=0.6u
X859 sg13cmos5l_Corner_1.vss adc8b_0.side_cap8b_0.in_h_sw[2] adc8b_0.side_cap8b_0.buf_16_0.z sg13cmos5l_Corner_1.vss sg13_lv_nmos ad=95f pd=0.88u as=95f ps=0.88u w=0.5u l=0.13u
X860 sg13cmos5l_Corner_1.vss adc8b_0.sar12b_0.sg13cmos5l_inv_1_29.A a_94609_98888# sg13cmos5l_Corner_1.vss sg13_lv_nmos ad=0.15055p pd=1.17u as=0.187p ps=1.78u w=0.55u l=0.13u
X861 adc8b_0.side_cap8b_0.buf_32_1.z adc8b_0.side_cap8b_0.in_h_sw[0] vddr vddr sg13_lv_pmos ad=0.19p pd=1.38u as=0.19p ps=1.38u w=1u l=0.13u
X862 sg13cmos5l_Corner_1.vss a_84500_100310# adc8b_0.sar12b_0.sg13cmos5l_buf_1_61.X sg13cmos5l_Corner_1.vss sg13_lv_nmos ad=0.14875p pd=1.16u as=0.2886p ps=2.26u w=0.74u l=0.13u
X863 a_93614_100346# adc8b_0.sar12b_0.sg13cmos5l_dlhr_1_11.GATE vdd vdd sg13_lv_pmos ad=79.8f pd=0.8u as=0.1428p ps=1.52u w=0.42u l=0.13u
X864 vdd adc8b_0.sar12b_0.sg13cmos5l_nand2_1_0.A adc8b_0.sar12b_0.sg13cmos5l_o21ai_1_0.A2 vdd sg13_lv_pmos ad=0.3808p pd=2.92u as=0.2128p ps=1.5u w=1.12u l=0.13u
X865 sg13cmos5l_Corner_1.vss sg13cmos5l_IOPadVdd$1_0.sg13cmos5l_RCClampInverter$1_0.in sg13cmos5l_IOPadVdd$1_0.sg13cmos5l_Clamp_N43N43D4R$1_0.gate sg13cmos5l_Corner_1.vss sg13_hv_nmos ad=3.06p pd=18.68u as=1.71p ps=9.38u w=9u l=0.5u
X866 vddr adc8b_0.side_cap8b_0.in_h_sw[0] adc8b_0.side_cap8b_0.buf_32_1.z vddr sg13_lv_pmos ad=0.19p pd=1.38u as=0.19p ps=1.38u w=1u l=0.13u
X867 sg13cmos5l_Corner_1.vss adc8b_0.sar12b_0.sg13cmos5l_dlhr_1_5.D a_89425_98442# sg13cmos5l_Corner_1.vss sg13_lv_nmos ad=0.15055p pd=1.17u as=0.187p ps=1.78u w=0.55u l=0.13u
X868 a_85070_95810# adc8b_0.sar12b_0.sg13cmos5l_dfrbp_1_9.Q vdd vdd sg13_lv_pmos ad=79.8f pd=0.8u as=0.1428p ps=1.52u w=0.42u l=0.13u
X869 sg13cmos5l_Corner_1.vss a_90207_97338# a_90338_97332# sg13cmos5l_Corner_1.vss sg13_lv_nmos ad=1.97045p pd=12.335u as=0.2775p ps=2.23u w=0.74u l=0.13u
X870 vdd adc8b_0.sar12b_0.sg13cmos5l_buf_1_25.X a_86224_92824# vdd sg13_lv_pmos ad=0.2114p pd=1.54u as=0.2856p ps=2.36u w=0.84u l=0.13u
X871 sg13cmos5l_Corner_1.vss sg13cmos5l_IOPadVdd$1_0.sg13cmos5l_Clamp_N43N43D4R$1_0.gate vdd sg13cmos5l_Corner_1.vss sg13_hv_nmos ad=1.408p pd=5.04u as=2.596p ps=5.58u w=4.4u l=0.6u
X872 adc8b_0.sar12b_0.sg13cmos5l_inv_1_7.A a_93232_99596# sg13cmos5l_Corner_1.vss sg13cmos5l_Corner_1.vss sg13_lv_nmos ad=0.2886p pd=2.26u as=0.14875p ps=1.16u w=0.74u l=0.13u
X873 sg13cmos5l_IOPadAnalog_12.pad a_131639_178370# sg13cmos5l_Corner_1.vss sg13cmos5l_Corner_1.vss sg13_hv_nmos ad=2.596p pd=5.58u as=1.408p ps=5.04u w=4.4u l=0.6u
X874 sg13cmos5l_Corner_1.vss adc8b_0.side_cap8b_0.in_l_sw[0] adc8b_0.side_cap8b_0.buf_32_0.z sg13cmos5l_Corner_1.vss sg13_lv_nmos ad=95f pd=0.88u as=95f ps=0.88u w=0.5u l=0.13u
X875 vdd a_85444_99124# adc8b_0.sar12b_0.sg13cmos5l_dlhr_1_9.Q vdd sg13_lv_pmos ad=0.2128p pd=1.5u as=0.3808p ps=2.92u w=1.12u l=0.13u
X876 sg13cmos5l_Corner_1.iovdd a_164624_86044# sg13cmos5l_IOPadAnalog_0.pad sg13cmos5l_Corner_1.iovdd sg13_hv_pmos ad=2.1312p pd=7.3u as=3.9294p ps=7.84u w=6.66u l=0.6u
X877 a_88504_93790# a_88247_93909# a_88666_93986# sg13cmos5l_Corner_1.vss sg13_lv_nmos ad=0.1428p pd=1.52u as=37.8f ps=0.6u w=0.42u l=0.13u
X878 vddr adc8b_0.side_cap8b_0.in_l_sw[5] adc8b_0.side_cap8b_0.buf_8_4.z vddr sg13_lv_pmos ad=0.19p pd=1.38u as=0.19p ps=1.38u w=1u l=0.13u
X879 sg13cmos5l_Corner_1.vss sg13cmos5l_IOPadVdd$1_0.sg13cmos5l_RCClampInverter$1_0.in sg13cmos5l_IOPadVdd$1_0.sg13cmos5l_Clamp_N43N43D4R$1_0.gate sg13cmos5l_Corner_1.vss sg13_hv_nmos ad=3.06p pd=18.68u as=1.71p ps=9.38u w=9u l=0.5u
X880 vin a_30676_86044# sg13cmos5l_Corner_1.vss sg13cmos5l_Corner_1.vss sg13_hv_nmos ad=2.596p pd=5.58u as=1.408p ps=5.04u w=4.4u l=0.6u
X881 sg13cmos5l_Corner_1.vss adc8b_0.sar12b_0.sg13cmos5l_inv_1_8.A a_84647_97592# sg13cmos5l_Corner_1.vss sg13_lv_nmos ad=1.88087p pd=11.775u as=0.2516p ps=2.16u w=0.74u l=0.13u
X882 a_74586_95659# adc8b_0.diff_bsw_0.vcn a_73970_98361# sg13cmos5l_Corner_1.vss sg13_lv_nmos ad=0.95p pd=5.38u as=1.7p ps=10.68u w=5u l=0.13u
X883 a_90740_95024# adc8b_0.sar12b_0.sg13cmos5l_buf_1_45.A sg13cmos5l_Corner_1.vss sg13cmos5l_Corner_1.vss sg13_lv_nmos ad=0.187p pd=1.78u as=0.14875p ps=1.16u w=0.55u l=0.13u
X884 cko a_118044_30676# sg13cmos5l_Corner_1.vss sg13cmos5l_Corner_1.vss sg13_hv_nmos ad=2.596p pd=5.58u as=1.408p ps=5.04u w=4.4u l=0.6u
X885 sg13cmos5l_Corner_1.iovdd a_83639_164698# sg13cmos5l_IOPadAnalog_9.pad sg13cmos5l_Corner_1.iovdd sg13_hv_pmos ad=2.1312p pd=7.3u as=3.9294p ps=7.84u w=6.66u l=0.6u
X886 adc8b_0.sar12b_0.sg13cmos5l_buf_8_0.X a_100995_95814# sg13cmos5l_Corner_1.vss sg13cmos5l_Corner_1.vss sg13_lv_nmos ad=0.1406p pd=1.12u as=0.1406p ps=1.12u w=0.74u l=0.13u
X887 sg13cmos5l_Corner_1.iovdd a_67639_164698# sg13cmos5l_IOPadAnalog_10.pad sg13cmos5l_Corner_1.iovdd sg13_hv_pmos ad=3.1302p pd=14.26u as=3.9294p ps=7.84u w=6.66u l=0.6u
X888 a_36456_138055# a_40542_138385# sg13cmos5l_Corner_1.vss rppd l=20u w=1u
X889 adc8b_0.sar12b_0.sg13cmos5l_buf_1_105.A a_99729_99953# vdd vdd sg13_lv_pmos ad=0.3808p pd=2.92u as=0.2128p ps=1.5u w=1.12u l=0.13u
X890 a_88428_95823# a_88659_95932# a_88114_96033# sg13cmos5l_Corner_1.vss sg13_lv_nmos ad=0.2373p pd=1.97u as=79.8f ps=0.8u w=0.42u l=0.13u
X891 sg13cmos5l_IOPadAnalog_9.padres sg13cmos5l_Corner_1.iovdd dpantenna l=0.64u w=4.98u
X892 vdd adc8b_0.sar12b_0.sg13cmos5l_dlhr_1_5.D a_89425_98442# vdd sg13_lv_pmos ad=1.07253p pd=6.75u as=0.2856p ps=2.36u w=0.84u l=0.13u
X893 vdd adc8b_0.sar12b_0.sg13cmos5l_dfrbp_1_6.RESET_B a_96657_98441# vdd sg13_lv_pmos ad=0.2128p pd=1.5u as=0.2128p ps=1.5u w=1.12u l=0.13u
X894 sg13cmos5l_Corner_1.vss a_88557_95789# a_88659_95932# sg13cmos5l_Corner_1.vss sg13_lv_nmos ad=2.41737p pd=15.64u as=0.2516p ps=2.16u w=0.74u l=0.13u
X895 sg13cmos5l_Corner_1.iovdd a_115639_164698# sg13cmos5l_Corner_1.iovdd rppd l=12.9u w=0.5u
X896 sg13cmos5l_Corner_1.iovdd a_42476_70044# vddr sg13cmos5l_Corner_1.iovdd sg13_hv_pmos ad=2.1312p pd=7.3u as=3.9294p ps=7.84u w=6.66u l=0.6u
X897 a_93036_96920# adc8b_0.sar12b_0.sg13cmos5l_dlhr_1_15.D sg13cmos5l_Corner_1.vss sg13cmos5l_Corner_1.vss sg13_lv_nmos ad=0.1216p pd=1.02u as=0.1371p ps=1.12u w=0.64u l=0.13u
X898 vin a_42476_86044# sg13cmos5l_Corner_1.iovdd sg13cmos5l_Corner_1.iovdd sg13_hv_pmos ad=3.9294p pd=7.84u as=2.1312p ps=7.3u w=6.66u l=0.6u
X899 sg13cmos5l_Corner_1.vss cks adc8b_0.sar12b_0.sg13cmos5l_dfrbp_1_6.RESET_B sg13cmos5l_Corner_1.vss sg13_lv_nmos ad=0.1406p pd=1.12u as=0.1406p ps=1.12u w=0.74u l=0.13u
X900 sg13cmos5l_Corner_1.vss a_94868_99560# adc8b_0.side_cap8b_0.in_l_sw[6] sg13cmos5l_Corner_1.vss sg13_lv_nmos ad=0.14875p pd=1.16u as=0.2886p ps=2.26u w=0.74u l=0.13u
X901 sg13cmos5l_Corner_1.iovdd a_164624_102044# sg13cmos5l_IOPadAnalog_16.pad sg13cmos5l_Corner_1.iovdd sg13_hv_pmos ad=2.1312p pd=7.3u as=3.9294p ps=7.84u w=6.66u l=0.6u
X902 sg13cmos5l_Corner_1.vss sg13cmos5l_IOPadVdd$1_0.sg13cmos5l_Clamp_N43N43D4R$1_0.gate vdd sg13cmos5l_Corner_1.vss sg13_hv_nmos ad=1.408p pd=5.04u as=2.596p ps=5.58u w=4.4u l=0.6u
X903 a_99932_99156# a_99519_98850# a_99864_99156# vdd sg13_lv_pmos ad=0.191p pd=1.44u as=0.105p ps=1.21u w=1u l=0.13u
X904 data[1] a_86044_30676# sg13cmos5l_Corner_1.vss sg13cmos5l_Corner_1.vss sg13_hv_nmos ad=2.596p pd=5.58u as=1.408p ps=5.04u w=4.4u l=0.6u
X905 adc8b_0.sar12b_0.sg13cmos5l_dfrbp_1_4.D adc8b_0.sar12b_0.sg13cmos5l_nand2_1_1.B a_92475_93548# vdd sg13_lv_pmos ad=0.2408p pd=1.55u as=0.1428p ps=1.375u w=1.12u l=0.13u
X906 sg13cmos5l_IOPadAnalog_10.pad a_67639_164698# sg13cmos5l_Corner_1.iovdd sg13cmos5l_Corner_1.iovdd sg13_hv_pmos ad=3.9294p pd=7.84u as=2.1312p ps=7.3u w=6.66u l=0.6u
X907 sg13cmos5l_Corner_1.vss adc8b_0.sar12b_0.sg13cmos5l_dfrbp_1_6.RESET_B a_92668_98472# sg13cmos5l_Corner_1.vss sg13_lv_nmos ad=0.1406p pd=1.12u as=77.7f ps=0.95u w=0.74u l=0.13u
X908 adc8b_0.sar12b_0.sg13cmos5l_dfrbp_1_21.Q a_100124_97620# sg13cmos5l_Corner_1.vss sg13cmos5l_Corner_1.vss sg13_lv_nmos ad=0.2516p pd=2.16u as=0.1406p ps=1.12u w=0.74u l=0.13u
X909 sg13cmos5l_Corner_1.vss a_178296_102044# sg13cmos5l_IOPadAnalog_16.pad sg13cmos5l_Corner_1.vss sg13_hv_nmos ad=1.408p pd=5.04u as=2.596p ps=5.58u w=4.4u l=0.6u
X910 sg13cmos5l_Corner_1.vss vdd sg13cmos5l_Corner_1.vss sg13cmos5l_Corner_1.vss sg13_lv_nmos ad=79.8f pd=0.8u as=0 ps=0 w=0.42u l=1u
X911 vdd adc8b_0.sar12b_0.sg13cmos5l_dfrbp_1_8.RESET_B a_83630_95498# vdd sg13_lv_pmos ad=0.36237p pd=2.605u as=79.8f ps=0.8u w=0.42u l=0.13u
X912 vdd a_96311_94375# a_96568_94518# vdd sg13_lv_pmos ad=0.2639p pd=1.81u as=79.8f ps=0.8u w=0.42u l=0.13u
X913 adc8b_0.side_cap8b_1.buf_8_4.z adc8b_0.sar12b_0.nl_sw[5] vddr vddr sg13_lv_pmos ad=0.19p pd=1.38u as=0.19p ps=1.38u w=1u l=0.13u
X914 sg13cmos5l_Corner_1.vss sg13cmos5l_IOPadVdd$1_0.sg13cmos5l_Clamp_N43N43D4R$1_0.gate vdd sg13cmos5l_Corner_1.vss sg13_hv_nmos ad=1.408p pd=5.04u as=2.596p ps=5.58u w=4.4u l=0.6u
X915 sg13cmos5l_Corner_1.vss a_30676_86044# vin sg13cmos5l_Corner_1.vss sg13_hv_nmos ad=1.408p pd=5.04u as=2.596p ps=5.58u w=4.4u l=0.6u
X916 sg13cmos5l_Corner_1.vss a_102044_30676# data[2] sg13cmos5l_Corner_1.vss sg13_hv_nmos ad=1.408p pd=5.04u as=2.596p ps=5.58u w=4.4u l=0.6u
X917 sg13cmos5l_Corner_1.vss adc8b_0.sar12b_0.sg13cmos5l_dfrbp_1_6.RESET_B a_87372_95498# sg13cmos5l_Corner_1.vss sg13_lv_nmos ad=0.1626p pd=1.415u as=60.89999f ps=0.71u w=0.42u l=0.13u
X918 adc8b_0.sar12b_0.sg13cmos5l_buf_1_3.X a_102064_92824# vdd vdd sg13_lv_pmos ad=0.42p pd=2.99u as=0.2114p ps=1.54u w=1.12u l=0.13u
X919 vin a_42476_86044# sg13cmos5l_Corner_1.iovdd sg13cmos5l_Corner_1.iovdd sg13_hv_pmos ad=3.9294p pd=7.84u as=3.1302p ps=14.26u w=6.66u l=0.6u
X920 adc8b_0.sar12b_0.sg13cmos5l_dlhr_1_19.Q_N a_97470_97002# vdd vdd sg13_lv_pmos ad=0.3808p pd=2.92u as=0.1974p ps=1.5u w=1.12u l=0.13u
X921 a_178296_70044# sg13cmos5l_Corner_1.vss sg13cmos5l_Corner_1.vss rppd l=3.54u w=0.5u
X922 sg13cmos5l_Corner_1.iovdd a_99639_164698# sg13cmos5l_IOPadAnalog_15.pad sg13cmos5l_Corner_1.iovdd sg13_hv_pmos ad=2.1312p pd=7.3u as=3.9294p ps=7.84u w=6.66u l=0.6u
X923 sg13cmos5l_Corner_1.iovdd a_115639_164698# sg13cmos5l_IOPadAnalog_13.pad sg13cmos5l_Corner_1.iovdd sg13_hv_pmos ad=2.1312p pd=7.3u as=3.9294p ps=7.84u w=6.66u l=0.6u
X924 sg13cmos5l_Corner_1.vss adc8b_0.sar12b_0.sg13cmos5l_buf_1_30.A adc8b_0.sar12b_0.sg13cmos5l_buf_1_73.A sg13cmos5l_Corner_1.vss sg13_lv_nmos ad=0.2516p pd=2.16u as=0.2516p ps=2.16u w=0.74u l=0.13u
X925 adc8b_0.side_cap8b_1.buf_16_1.z adc8b_0.sar12b_0.nl_sw[2] vddr vddr sg13_lv_pmos ad=0.19p pd=1.38u as=0.19p ps=1.38u w=1u l=0.13u
X926 sg13cmos5l_IOPadAnalog_15.pad a_99639_164698# sg13cmos5l_Corner_1.iovdd sg13cmos5l_Corner_1.iovdd sg13_hv_pmos ad=3.9294p pd=7.84u as=2.1312p ps=7.3u w=6.66u l=0.6u
X927 sg13cmos5l_Corner_1.vss sg13cmos5l_IOPadVdd$1_0.sg13cmos5l_RCClampInverter$1_0.in sg13cmos5l_Corner_1.vss sg13cmos5l_Corner_1.vss sg13_hv_nmos ad=1.71p pd=9.38u as=0 ps=0 w=9u l=9.5u
X928 sg13cmos5l_Corner_1.iovdd a_42476_86044# vin sg13cmos5l_Corner_1.iovdd sg13_hv_pmos ad=3.1302p pd=14.26u as=3.9294p ps=7.84u w=6.66u l=0.6u
X929 vdd adc8b_0.sar12b_0.sg13cmos5l_inv_1_3.A a_96784_100384# vdd sg13_lv_pmos ad=0.2114p pd=1.54u as=0.2856p ps=2.36u w=0.84u l=0.13u
X930 vdd adc8b_0.sar12b_0.sg13cmos5l_buf_1_40.A adc8b_0.sar12b_0.sg13cmos5l_buf_1_63.A vdd sg13_lv_pmos ad=0.3808p pd=2.92u as=0.3808p ps=2.92u w=1.12u l=0.13u
X931 adc8b_0.sar12b_0.sg13cmos5l_buf_8_0.X a_100995_95814# sg13cmos5l_Corner_1.vss sg13cmos5l_Corner_1.vss sg13_lv_nmos ad=0.1406p pd=1.12u as=0.1406p ps=1.12u w=0.74u l=0.13u
X932 sg13cmos5l_Corner_1.iovdd a_164624_118044# sg13cmos5l_IOPadAnalog_11.pad sg13cmos5l_Corner_1.iovdd sg13_hv_pmos ad=2.1312p pd=7.3u as=3.9294p ps=7.84u w=6.66u l=0.6u
X933 adc8b_0.sar12b_0.sg13cmos5l_buf_1_1.A a_95824_92824# vdd vdd sg13_lv_pmos ad=0.42p pd=2.99u as=0.2114p ps=1.54u w=1.12u l=0.13u
X934 a_100929_94613# a_99987_94420# a_100727_94375# vdd sg13_lv_pmos ad=93.45f pd=0.865u as=0.2048p ps=1.63u w=0.42u l=0.13u
X935 sg13cmos5l_Corner_1.vss a_83231_99901# a_83231_99901# sg13cmos5l_Corner_1.vss sg13_lv_nmos ad=2.92392p pd=18.89u as=0.111p ps=1.34u w=0.3u l=0.13u
X936 cko a_118044_42476# sg13cmos5l_Corner_1.iovdd sg13cmos5l_Corner_1.iovdd sg13_hv_pmos ad=3.9294p pd=7.84u as=2.1312p ps=7.3u w=6.66u l=0.6u
X937 sg13cmos5l_Corner_1.vss adc8b_0.sar12b_0.nh_sw[2] adc8b_0.side_cap8b_1.buf_16_0.z sg13cmos5l_Corner_1.vss sg13_lv_nmos ad=95f pd=0.88u as=95f ps=0.88u w=0.5u l=0.13u
X938 adc8b_0.side_cap8b_1.buf_16_2.z adc8b_0.sar12b_0.nl_sw[1] sg13cmos5l_Corner_1.vss sg13cmos5l_Corner_1.vss sg13_lv_nmos ad=0.17p pd=1.68u as=95f ps=0.88u w=0.5u l=0.13u
X939 a_99095_98445# a_98253_98095# a_97836_98088# vdd sg13_lv_pmos ad=0.2048p pd=1.63u as=0.34p ps=2.68u w=1u l=0.13u
X940 adc8b_0.sar12b_0.sg13cmos5l_and3_1_0.X a_95092_95856# vdd vdd sg13_lv_pmos ad=0.3808p pd=2.92u as=0.36195p ps=1.84u w=1.12u l=0.13u
X941 sg13cmos5l_Corner_1.vss adc8b_0.sar12b_0.sg13cmos5l_dfrbp_1_8.RESET_B a_83724_95498# sg13cmos5l_Corner_1.vss sg13_lv_nmos ad=0.1626p pd=1.415u as=60.89999f ps=0.71u w=0.42u l=0.13u
X942 vddr adc8b_0.sar12b_0.nl_sw[3] adc8b_0.side_cap8b_1.buf_8_1.z vddr sg13_lv_pmos ad=0.19p pd=1.38u as=0.19p ps=1.38u w=1u l=0.13u
X943 sg13cmos5l_Corner_1.iovdd a_83639_164698# sg13cmos5l_IOPadAnalog_9.pad sg13cmos5l_Corner_1.iovdd sg13_hv_pmos ad=2.1312p pd=7.3u as=3.9294p ps=7.84u w=6.66u l=0.6u
X944 sg13cmos5l_Corner_1.vss sg13cmos5l_IOPadVdd$1_0.sg13cmos5l_Clamp_N43N43D4R$1_0.gate vdd sg13cmos5l_Corner_1.vss sg13_hv_nmos ad=1.408p pd=5.04u as=2.596p ps=5.58u w=4.4u l=0.6u
X945 a_84333_95071# adc8b_0.sar12b_0.sg13cmos5l_inv_1_8.A sg13cmos5l_Corner_1.vss sg13cmos5l_Corner_1.vss sg13_lv_nmos ad=0.2516p pd=2.16u as=2.27517p ps=14.72u w=0.74u l=0.13u
X946 sg13cmos5l_Corner_1.vss a_131639_178370# sg13cmos5l_Corner_1.vss rppd l=3.54u w=0.5u
X947 cks a_42476_118044# sg13cmos5l_Corner_1.iovdd sg13cmos5l_Corner_1.iovdd sg13_hv_pmos ad=3.9294p pd=7.84u as=2.1312p ps=7.3u w=6.66u l=0.6u
X948 sg13cmos5l_Corner_1.vss adc8b_0.side_cap8b_0.in_h_sw[1] adc8b_0.side_cap8b_0.buf_16_3.z sg13cmos5l_Corner_1.vss sg13_lv_nmos ad=95f pd=0.88u as=95f ps=0.88u w=0.5u l=0.13u
X949 a_86327_98790# adc8b_0.sar12b_0.sg13cmos5l_dlhr_1_9.D sg13cmos5l_Corner_1.vss sg13cmos5l_Corner_1.vss sg13_lv_nmos ad=0.187p pd=1.78u as=0.15055p ps=1.17u w=0.55u l=0.13u
X950 sg13cmos5l_Corner_1.vss a_99284_100310# adc8b_0.side_cap8b_0.in_l_sw[8] sg13cmos5l_Corner_1.vss sg13_lv_nmos ad=0.14875p pd=1.16u as=0.2886p ps=2.26u w=0.74u l=0.13u
X951 a_86962_93516# a_87405_93559# a_87345_93595# vdd sg13_lv_pmos ad=79.8f pd=0.8u as=63f ps=0.72u w=0.42u l=0.13u
X952 sg13cmos5l_Corner_1.vss sg13cmos5l_IOPadVdd$1_0.sg13cmos5l_RCClampInverter$1_0.in sg13cmos5l_Corner_1.vss sg13cmos5l_Corner_1.vss sg13_hv_nmos ad=1.71p pd=9.38u as=0 ps=0 w=9u l=9.5u
X953 vddr adc8b_0.side_cap8b_0.in_h_sw[1] adc8b_0.side_cap8b_0.buf_16_3.z vddr sg13_lv_pmos ad=0.19p pd=1.38u as=0.19p ps=1.38u w=1u l=0.13u
X954 a_85773_95789# adc8b_0.sar12b_0.sg13cmos5l_inv_1_8.A sg13cmos5l_Corner_1.vss sg13cmos5l_Corner_1.vss sg13_lv_nmos ad=0.2516p pd=2.16u as=2.27517p ps=14.72u w=0.74u l=0.13u
X955 sg13cmos5l_Corner_1.vss a_86872_96030# a_86521_95887# sg13cmos5l_Corner_1.vss sg13_lv_nmos ad=79.8f pd=0.8u as=0.1428p ps=1.52u w=0.42u l=0.13u
X956 adc8b_0.side_cap8b_1.buf_32_0.z adc8b_0.sar12b_0.nl_sw[0] vddr vddr sg13_lv_pmos ad=0.19p pd=1.38u as=0.19p ps=1.38u w=1u l=0.13u
X957 sg13cmos5l_Corner_1.vss sg13cmos5l_IOPadVdd$1_0.sg13cmos5l_Clamp_N43N43D4R$1_0.gate vdd sg13cmos5l_Corner_1.vss sg13_hv_nmos ad=1.408p pd=5.04u as=2.596p ps=5.58u w=4.4u l=0.6u
X958 sg13cmos5l_Corner_1.iovdd a_42476_86044# vin sg13cmos5l_Corner_1.iovdd sg13_hv_pmos ad=2.1312p pd=7.3u as=3.9294p ps=7.84u w=6.66u l=0.6u
X959 adc8b_0.side_cap8b_0.buf_16_1.z adc8b_0.side_cap8b_0.in_l_sw[2] vddr vddr sg13_lv_pmos ad=0.19p pd=1.38u as=0.19p ps=1.38u w=1u l=0.13u
X960 adc8b_0.sar12b_0.sg13cmos5l_inv_1_2.A a_90256_100384# vdd vdd sg13_lv_pmos ad=0.42p pd=2.99u as=0.2114p ps=1.54u w=1.12u l=0.13u
X961 vddr adc8b_0.sar12b_0.nl_sw[1] adc8b_0.side_cap8b_1.buf_16_2.z vddr sg13_lv_pmos ad=0.19p pd=1.38u as=0.19p ps=1.38u w=1u l=0.13u
X962 sg13cmos5l_Corner_1.vss a_30676_70044# vddr sg13cmos5l_Corner_1.vss sg13_hv_nmos ad=2.068p pd=9.74u as=2.596p ps=5.58u w=4.4u l=0.6u
X963 a_85343_97713# adc8b_0.sar12b_0.sg13cmos5l_dfrbp_1_15.D a_86090_97322# sg13cmos5l_Corner_1.vss sg13_lv_nmos ad=0.1428p pd=1.52u as=60.89999f ps=0.71u w=0.42u l=0.13u
X964 a_89692_92772# a_89276_93108# a_89457_92786# sg13cmos5l_Corner_1.vss sg13_lv_nmos ad=77.7f pd=0.95u as=0.2516p ps=2.16u w=0.74u l=0.13u
X965 vdd a_88173_99607# a_88275_99607# vdd sg13_lv_pmos ad=1.15047p pd=7.175u as=0.3864p ps=2.93u w=1.12u l=0.13u
X966 sg13cmos5l_Corner_1.vss a_100383_96930# a_100514_96936# sg13cmos5l_Corner_1.vss sg13_lv_nmos ad=1.97045p pd=12.335u as=0.2775p ps=2.23u w=0.74u l=0.13u
X967 sg13cmos5l_Corner_1.iovdd a_83639_164698# sg13cmos5l_Corner_1.iovdd rppd l=12.9u w=0.5u
X968 adc8b_0.side_cap8b_0.buf_16_0.z adc8b_0.side_cap8b_0.in_h_sw[2] sg13cmos5l_Corner_1.vss sg13cmos5l_Corner_1.vss sg13_lv_nmos ad=95f pd=0.88u as=95f ps=0.88u w=0.5u l=0.13u
X969 a_96370_99564# a_96813_99607# a_96110_100034# sg13cmos5l_Corner_1.vss sg13_lv_nmos ad=79.8f pd=0.8u as=0.1296p ps=1.52u w=0.42u l=0.13u
X970 a_87468_97640# a_87987_97444# a_88727_97399# sg13cmos5l_Corner_1.vss sg13_lv_nmos ad=0.3473p pd=2.71u as=0.12665p ps=1.145u w=0.74u l=0.13u
X971 vdd adc8b_0.sar12b_0.sg13cmos5l_buf_1_110.A a_97552_100384# vdd sg13_lv_pmos ad=0.2114p pd=1.54u as=0.2856p ps=2.36u w=0.84u l=0.13u
X972 vdd a_100995_95814# adc8b_0.sar12b_0.sg13cmos5l_buf_8_0.X vdd sg13_lv_pmos ad=0.3864p pd=2.93u as=0.2128p ps=1.5u w=1.12u l=0.13u
X973 sg13cmos5l_Corner_1.iovdd a_102044_42476# data[2] sg13cmos5l_Corner_1.iovdd sg13_hv_pmos ad=2.1312p pd=7.3u as=3.9294p ps=7.84u w=6.66u l=0.6u
X974 a_85175_95421# a_84333_95071# a_83916_95064# vdd sg13_lv_pmos ad=0.2048p pd=1.63u as=0.34p ps=2.68u w=1u l=0.13u
X975 vddr adc8b_0.sar12b_0.nl_sw[4] adc8b_0.side_cap8b_1.buf_8_0.z vddr sg13_lv_pmos ad=0.19p pd=1.38u as=0.19p ps=1.38u w=1u l=0.13u
X976 data[1] a_86044_42476# sg13cmos5l_Corner_1.iovdd sg13cmos5l_Corner_1.iovdd sg13_hv_pmos ad=3.9294p pd=7.84u as=2.1312p ps=7.3u w=6.66u l=0.6u
X977 adc8b_0.side_cap8b_1.buf_32_0.z adc8b_0.sar12b_0.nl_sw[0] vddr vddr sg13_lv_pmos ad=0.19p pd=1.38u as=0.19p ps=1.38u w=1u l=0.13u
X978 sg13cmos5l_Corner_1.iovdd a_131639_164698# sg13cmos5l_IOPadAnalog_12.pad sg13cmos5l_Corner_1.iovdd sg13_hv_pmos ad=2.1312p pd=7.3u as=3.9294p ps=7.84u w=6.66u l=0.6u
X979 vdd adc8b_0.sar12b_0.sg13cmos5l_buf_1_96.A a_93232_99596# vdd sg13_lv_pmos ad=0.2114p pd=1.54u as=0.2856p ps=2.36u w=0.84u l=0.13u
X980 a_100995_95814# adc8b_0.sar12b_0.sg13cmos5l_buf_8_0.A sg13cmos5l_Corner_1.vss sg13cmos5l_Corner_1.vss sg13_lv_nmos ad=0.1406p pd=1.12u as=0.1406p ps=1.12u w=0.74u l=0.13u
X981 vip a_42476_102044# sg13cmos5l_Corner_1.iovdd sg13cmos5l_Corner_1.iovdd sg13_hv_pmos ad=3.9294p pd=7.84u as=2.1312p ps=7.3u w=6.66u l=0.6u
X982 adc8b_0.side_cap8b_0.buf_32_0.z adc8b_0.side_cap8b_0.in_l_sw[0] sg13cmos5l_Corner_1.vss sg13cmos5l_Corner_1.vss sg13_lv_nmos ad=95f pd=0.88u as=95f ps=0.88u w=0.5u l=0.13u
X983 a_93754_98834# adc8b_0.sar12b_0.sg13cmos5l_dfrbp_1_6.RESET_B sg13cmos5l_Corner_1.vss sg13cmos5l_Corner_1.vss sg13_lv_nmos ad=37.8f pd=0.6u as=79.8f ps=0.8u w=0.42u l=0.13u
X984 sg13cmos5l_Corner_1.iovdd a_67639_164698# sg13cmos5l_IOPadAnalog_10.pad sg13cmos5l_Corner_1.iovdd sg13_hv_pmos ad=2.1312p pd=7.3u as=3.9294p ps=7.84u w=6.66u l=0.6u
X985 sg13cmos5l_Corner_1.vss a_134044_30676# frame sg13cmos5l_Corner_1.vss sg13_hv_nmos ad=1.408p pd=5.04u as=2.596p ps=5.58u w=4.4u l=0.6u
X986 sg13cmos5l_Corner_1.vss vdd sg13cmos5l_Corner_1.vss sg13cmos5l_Corner_1.vss sg13_lv_nmos ad=79.8f pd=0.8u as=0 ps=0 w=0.42u l=1u
X987 cko a_118044_42476# sg13cmos5l_Corner_1.iovdd sg13cmos5l_Corner_1.iovdd sg13_hv_pmos ad=3.9294p pd=7.84u as=2.1312p ps=7.3u w=6.66u l=0.6u
X988 vdd a_97652_94262# adc8b_0.sar12b_0.nh_sw[7] vdd sg13_lv_pmos ad=0.2114p pd=1.54u as=0.42p ps=2.99u w=1.12u l=0.13u
X989 sg13cmos5l_IOPadAnalog_10.pad a_67639_164698# sg13cmos5l_Corner_1.iovdd sg13cmos5l_Corner_1.iovdd sg13_hv_pmos ad=3.9294p pd=7.84u as=2.1312p ps=7.3u w=6.66u l=0.6u
X990 adc8b_0.side_cap8b_0.buf_32_0.z adc8b_0.side_cap8b_0.in_l_sw[0] vddr vddr sg13_lv_pmos ad=0.19p pd=1.38u as=0.19p ps=1.38u w=1u l=0.13u
X991 adc8b_0.sar12b_0.sg13cmos5l_buf_1_79.X a_91024_100384# vdd vdd sg13_lv_pmos ad=0.42p pd=2.99u as=0.2114p ps=1.54u w=1.12u l=0.13u
X992 adc8b_0.sar12b_0.sg13cmos5l_dfrbp_1_21.Q_N a_99287_97399# sg13cmos5l_Corner_1.vss sg13cmos5l_Corner_1.vss sg13_lv_nmos ad=0.2849p pd=2.25u as=0.2516p ps=2.16u w=0.74u l=0.13u
X993 sg13cmos5l_Corner_1.iovdd a_42476_70044# vddr sg13cmos5l_Corner_1.iovdd sg13_hv_pmos ad=2.1312p pd=7.3u as=3.9294p ps=7.84u w=6.66u l=0.6u
X994 vddr adc8b_0.side_cap8b_0.in_h_sw[2] adc8b_0.side_cap8b_0.buf_16_0.z vddr sg13_lv_pmos ad=0.19p pd=1.38u as=0.19p ps=1.38u w=1u l=0.13u
X995 a_82190_98522# a_82995_98095# a_82450_98052# vdd sg13_lv_pmos ad=0.1428p pd=1.52u as=79.8f ps=0.8u w=0.42u l=0.13u
X996 vdd a_100767_97338# a_100898_97332# vdd sg13_lv_pmos ad=1.07253p pd=6.75u as=0.2856p ps=2.36u w=0.84u l=0.13u
X997 sg13cmos5l_Corner_1.vss sg13cmos5l_IOPadVdd$1_0.sg13cmos5l_Clamp_N43N43D4R$1_0.gate vdd sg13cmos5l_Corner_1.vss sg13_hv_nmos ad=1.408p pd=5.04u as=2.596p ps=5.58u w=4.4u l=0.6u
X998 a_100113_98834# a_99932_99156# vdd vdd sg13_lv_pmos ad=0.2128p pd=1.5u as=0.2387p ps=1.84u w=1.12u l=0.13u
X999 sg13cmos5l_Corner_1.iovdd a_99639_164698# sg13cmos5l_IOPadAnalog_15.pad sg13cmos5l_Corner_1.iovdd sg13_hv_pmos ad=2.1312p pd=7.3u as=3.9294p ps=7.84u w=6.66u l=0.6u
X1000 a_87567_96659# a_87719_96543# sg13cmos5l_Corner_1.vss sg13cmos5l_Corner_1.vss sg13_lv_nmos ad=0.2516p pd=2.16u as=1.97045p ps=12.335u w=0.74u l=0.13u
X1001 a_84273_99643# a_83916_99600# vdd vdd sg13_lv_pmos ad=63f pd=0.72u as=0.1563p ps=1.22u w=0.42u l=0.13u
X1002 a_95409_98834# a_95228_99156# vdd vdd sg13_lv_pmos ad=0.2128p pd=1.5u as=0.2387p ps=1.84u w=1.12u l=0.13u
X1003 a_85569_94613# a_84627_94420# a_85367_94375# vdd sg13_lv_pmos ad=93.45f pd=0.865u as=0.2048p ps=1.63u w=0.42u l=0.13u
X1004 vdd adc8b_0.sar12b_0.sg13cmos5l_dfrbp_1_0.Q a_96022_93604# vdd sg13_lv_pmos ad=0.2618p pd=1.63u as=0.2856p ps=2.36u w=0.84u l=0.13u
X1005 vdd a_99729_99953# a_100254_100026# vdd sg13_lv_pmos ad=0.1974p pd=1.5u as=0.2856p ps=2.36u w=0.84u l=0.13u
X1006 cks a_42476_118044# sg13cmos5l_Corner_1.iovdd sg13cmos5l_Corner_1.iovdd sg13_hv_pmos ad=3.9294p pd=7.84u as=2.1312p ps=7.3u w=6.66u l=0.6u
X1007 a_92252_98084# a_91970_98448# a_92185_98486# sg13cmos5l_Corner_1.vss sg13_lv_nmos ad=0.141p pd=1.17u as=71.99999f ps=0.865u w=0.64u l=0.13u
X1008 adc8b_0.sar12b_0.sg13cmos5l_dlhr_1_6.Q_N a_91326_97304# sg13cmos5l_Corner_1.vss sg13cmos5l_Corner_1.vss sg13_lv_nmos ad=0.2516p pd=2.16u as=0.1491p ps=1.18u w=0.74u l=0.13u
X1009 sg13cmos5l_Corner_1.vss sg13cmos5l_IOPadVdd$1_0.sg13cmos5l_Clamp_N43N43D4R$1_0.gate vdd sg13cmos5l_Corner_1.vss sg13_hv_nmos ad=1.408p pd=5.04u as=2.596p ps=5.58u w=4.4u l=0.6u
X1010 sg13cmos5l_Corner_1.iovdd a_102044_42476# data[2] sg13cmos5l_Corner_1.iovdd sg13_hv_pmos ad=2.1312p pd=7.3u as=3.9294p ps=7.84u w=6.66u l=0.6u
X1011 vddr adc8b_0.sar12b_0.nh_sw[1] adc8b_0.side_cap8b_1.buf_16_3.z vddr sg13_lv_pmos ad=0.19p pd=1.38u as=0.19p ps=1.38u w=1u l=0.13u
X1012 a_89412_92822# a_88863_92802# a_89276_93108# sg13cmos5l_Corner_1.vss sg13_lv_nmos ad=47.25f pd=0.645u as=0.141p ps=1.17u w=0.42u l=0.13u
X1013 a_85437_97480# a_84495_97540# a_85343_97713# vdd sg13_lv_pmos ad=79.8f pd=0.8u as=0.1428p ps=1.52u w=0.42u l=0.13u
X1014 sg13cmos5l_IOPadAnalog_15.pad a_99639_164698# sg13cmos5l_Corner_1.iovdd sg13cmos5l_Corner_1.iovdd sg13_hv_pmos ad=3.9294p pd=7.84u as=2.1312p ps=7.3u w=6.66u l=0.6u
X1015 vdd sg13cmos5l_IOPadVdd$1_0.sg13cmos5l_Clamp_N43N43D4R$1_0.gate sg13cmos5l_Corner_1.vss sg13cmos5l_Corner_1.vss sg13_hv_nmos ad=2.596p pd=5.58u as=1.408p ps=5.04u w=4.4u l=0.6u
X1016 sg13cmos5l_IOPadAnalog_13.pad a_115639_164698# sg13cmos5l_Corner_1.iovdd sg13cmos5l_Corner_1.iovdd sg13_hv_pmos ad=3.9294p pd=7.84u as=2.1312p ps=7.3u w=6.66u l=0.6u
X1017 sg13cmos5l_Corner_1.iovdd a_42476_118044# cks sg13cmos5l_Corner_1.iovdd sg13_hv_pmos ad=2.1312p pd=7.3u as=3.9294p ps=7.84u w=6.66u l=0.6u
X1018 adc8b_0.sar12b_0.nl_sw[1] a_83632_92824# sg13cmos5l_Corner_1.vss sg13cmos5l_Corner_1.vss sg13_lv_nmos ad=0.2886p pd=2.26u as=0.14875p ps=1.16u w=0.74u l=0.13u
X1019 a_85215_93906# adc8b_0.sar12b_0.sg13cmos5l_dfrbp_1_9.Q sg13cmos5l_Corner_1.vss sg13cmos5l_Corner_1.vss sg13_lv_nmos ad=0.2516p pd=2.16u as=0.15055p ps=1.17u w=0.74u l=0.13u
X1020 sg13cmos5l_Corner_1.vss sg13cmos5l_IOPadVdd$1_0.sg13cmos5l_Clamp_N43N43D4R$1_0.gate vdd sg13cmos5l_Corner_1.vss sg13_hv_nmos ad=1.408p pd=5.04u as=2.596p ps=5.58u w=4.4u l=0.6u
X1021 vdd a_95469_94277# a_95571_94420# vdd sg13_lv_pmos ad=1.43437p pd=9.105u as=0.3864p ps=2.93u w=1.12u l=0.13u
X1022 sg13cmos5l_Corner_1.iovdd a_134044_42476# frame sg13cmos5l_Corner_1.iovdd sg13_hv_pmos ad=2.1312p pd=7.3u as=3.9294p ps=7.84u w=6.66u l=0.6u
X1023 sg13cmos5l_Corner_1.iovdd a_164624_70044# sg13cmos5l_IOPadAnalog_1.pad sg13cmos5l_Corner_1.iovdd sg13_hv_pmos ad=2.1312p pd=7.3u as=3.9294p ps=7.84u w=6.66u l=0.6u
X1024 adc8b_0.sar12b_0.sg13cmos5l_buf_1_34.X a_86608_92824# vdd vdd sg13_lv_pmos ad=0.42p pd=2.99u as=0.2114p ps=1.54u w=1.12u l=0.13u
X1025 vddr adc8b_0.side_cap8b_0.in_h_sw[0] adc8b_0.side_cap8b_0.buf_32_1.z vddr sg13_lv_pmos ad=0.19p pd=1.38u as=0.19p ps=1.38u w=1u l=0.13u
X1026 a_70946_94286# vdd a_70852_94286# sg13cmos5l_Corner_1.vss sg13_lv_nmos ad=0.57p pd=3.38u as=1.02p ps=6.68u w=3u l=0.13u
X1027 cko a_118044_42476# sg13cmos5l_Corner_1.iovdd sg13cmos5l_Corner_1.iovdd sg13_hv_pmos ad=3.9294p pd=7.84u as=2.1312p ps=7.3u w=6.66u l=0.6u
X1028 a_134044_42476# sg13cmos5l_Corner_1.iovdd sg13cmos5l_Corner_1.iovdd rppd l=12.9u w=0.5u
X1029 sg13cmos5l_IOPadAnalog_0.pad a_164624_86044# sg13cmos5l_Corner_1.iovdd sg13cmos5l_Corner_1.iovdd sg13_hv_pmos ad=3.9294p pd=7.84u as=2.1312p ps=7.3u w=6.66u l=0.6u
X1030 adc8b_0.side_cap8b_1.buf_16_0.z adc8b_0.sar12b_0.nh_sw[2] sg13cmos5l_Corner_1.vss sg13cmos5l_Corner_1.vss sg13_lv_nmos ad=95f pd=0.88u as=95f ps=0.88u w=0.5u l=0.13u
X1031 vddr adc8b_0.sar12b_0.nl_sw[2] adc8b_0.side_cap8b_1.buf_16_1.z vddr sg13_lv_pmos ad=0.19p pd=1.38u as=0.34p ps=2.68u w=1u l=0.13u
X1032 vdd a_98776_93790# a_98721_93671# vdd sg13_lv_pmos ad=1.86162p pd=11.935u as=93.45f ps=0.865u w=0.42u l=0.13u
X1033 sg13cmos5l_Corner_1.vss a_70044_30676# data[0] sg13cmos5l_Corner_1.vss sg13_hv_nmos ad=1.408p pd=5.04u as=2.596p ps=5.58u w=4.4u l=0.6u
X1034 vdd sg13cmos5l_IOPadVdd$1_0.sg13cmos5l_Clamp_N43N43D4R$1_0.gate sg13cmos5l_Corner_1.vss sg13cmos5l_Corner_1.vss sg13_hv_nmos ad=2.596p pd=5.58u as=1.408p ps=5.04u w=4.4u l=0.6u
X1035 sg13cmos5l_Corner_1.vss adc8b_0.sar12b_0.nl_sw[1] adc8b_0.side_cap8b_1.buf_16_2.z sg13cmos5l_Corner_1.vss sg13_lv_nmos ad=95f pd=0.88u as=95f ps=0.88u w=0.5u l=0.13u
X1036 a_87182_97322# a_87987_97444# a_87442_97545# vdd sg13_lv_pmos ad=0.1428p pd=1.52u as=79.8f ps=0.8u w=0.42u l=0.13u
X1037 adc8b_0.sar12b_0.sg13cmos5l_o21ai_1_0.A1 adc8b_0.sar12b_0.sg13cmos5l_a221oi_1_0.C1 sg13cmos5l_Corner_1.vss sg13cmos5l_Corner_1.vss sg13_lv_nmos ad=0.2516p pd=2.16u as=0.1406p ps=1.12u w=0.74u l=0.13u
X1038 a_96311_94375# a_95469_94277# a_95052_94616# vdd sg13_lv_pmos ad=0.2048p pd=1.63u as=0.34p ps=2.68u w=1u l=0.13u
X1039 frame a_134044_30676# sg13cmos5l_Corner_1.vss sg13cmos5l_Corner_1.vss sg13_hv_nmos ad=2.596p pd=5.58u as=1.408p ps=5.04u w=4.4u l=0.6u
X1040 vdd adc8b_0.sar12b_0.sg13cmos5l_dfrbp_1_8.RESET_B a_96370_99564# vdd sg13_lv_pmos ad=0.1563p pd=1.22u as=0.147p ps=1.54u w=0.42u l=0.13u
X1041 sg13cmos5l_Corner_1.vss sg13cmos5l_IOPadAnalog_5.padres dantenna l=0.64u w=3.1u
X1042 vdd adc8b_0.sar12b_0.sg13cmos5l_dfrbp_1_0.RESET_B a_98894_92786# vdd sg13_lv_pmos ad=0.36237p pd=2.605u as=79.8f ps=0.8u w=0.42u l=0.13u
X1043 adc8b_0.side_cap8b_0.buf_16_3.z adc8b_0.side_cap8b_0.in_h_sw[1] vddr vddr sg13_lv_pmos ad=0.19p pd=1.38u as=0.19p ps=1.38u w=1u l=0.13u
X1044 adc8b_0.side_cap8b_0.buf_8_5.z adc8b_0.side_cap8b_0.in_h_sw[5] vddr vddr sg13_lv_pmos ad=0.19p pd=1.38u as=0.19p ps=1.38u w=1u l=0.13u
X1045 adc8b_0.side_cap8b_1.buf_16_2.z adc8b_0.sar12b_0.nl_sw[1] vddr vddr sg13_lv_pmos ad=0.19p pd=1.38u as=0.19p ps=1.38u w=1u l=0.13u
X1046 a_36456_134755# a_40542_135085# sg13cmos5l_Corner_1.vss rppd l=20u w=1u
X1047 sg13cmos5l_Corner_1.vss adc8b_0.side_cap8b_0.in_h_sw[0] adc8b_0.side_cap8b_0.buf_32_1.z sg13cmos5l_Corner_1.vss sg13_lv_nmos ad=95f pd=0.88u as=95f ps=0.88u w=0.5u l=0.13u
X1048 sg13cmos5l_Corner_1.iovdd a_164624_70044# sg13cmos5l_IOPadAnalog_1.pad sg13cmos5l_Corner_1.iovdd sg13_hv_pmos ad=2.1312p pd=7.3u as=3.9294p ps=7.84u w=6.66u l=0.6u
X1049 a_99597_92765# adc8b_0.sar12b_0.sg13cmos5l_dfrbp_1_0.CLK vdd vdd sg13_lv_pmos ad=0.4088p pd=2.97u as=1.777p ps=11.395u w=1.12u l=0.13u
X1050 sg13cmos5l_Corner_1.iovdd a_67639_164698# sg13cmos5l_IOPadAnalog_10.pad sg13cmos5l_Corner_1.iovdd sg13_hv_pmos ad=2.1312p pd=7.3u as=3.9294p ps=7.84u w=6.66u l=0.6u
X1051 adc8b_0.sar12b_0.sg13cmos5l_dfrbp_1_6.RESET_B cks vdd vdd sg13_lv_pmos ad=0.2128p pd=1.5u as=0.2128p ps=1.5u w=1.12u l=0.13u
X1052 sg13cmos5l_Corner_1.iovdd a_164624_86044# sg13cmos5l_IOPadAnalog_0.pad sg13cmos5l_Corner_1.iovdd sg13_hv_pmos ad=3.1302p pd=14.26u as=3.9294p ps=7.84u w=6.66u l=0.6u
X1053 a_94840_93006# a_94583_92863# a_95002_92786# sg13cmos5l_Corner_1.vss sg13_lv_nmos ad=0.1428p pd=1.52u as=37.8f ps=0.6u w=0.42u l=0.13u
X1054 vdd adc8b_0.sar12b_0.sg13cmos5l_dfrbp_1_8.RESET_B a_97358_95810# vdd sg13_lv_pmos ad=0.36237p pd=2.605u as=79.8f ps=0.8u w=0.42u l=0.13u
X1055 vddr adc8b_0.side_cap8b_0.in_h_sw[0] adc8b_0.side_cap8b_0.buf_32_1.z vddr sg13_lv_pmos ad=0.19p pd=1.38u as=0.19p ps=1.38u w=1u l=0.13u
X1056 sg13cmos5l_Corner_1.vss adc8b_0.side_cap8b_0.in_l_sw[5] adc8b_0.side_cap8b_0.buf_8_4.z sg13cmos5l_Corner_1.vss sg13_lv_nmos ad=95f pd=0.88u as=95f ps=0.88u w=0.5u l=0.13u
X1057 sg13cmos5l_IOPadAnalog_11.pad a_178296_118044# sg13cmos5l_Corner_1.vss sg13cmos5l_Corner_1.vss sg13_hv_nmos ad=2.596p pd=5.58u as=1.408p ps=5.04u w=4.4u l=0.6u
X1058 sg13cmos5l_Corner_1.vss sg13cmos5l_IOPadVdd$1_0.sg13cmos5l_Clamp_N43N43D4R$1_0.gate vdd sg13cmos5l_Corner_1.vss sg13_hv_nmos ad=1.408p pd=5.04u as=2.596p ps=5.58u w=4.4u l=0.6u
X1059 vddr a_30676_70044# sg13cmos5l_Corner_1.vss sg13cmos5l_Corner_1.vss sg13_hv_nmos ad=2.596p pd=5.58u as=1.408p ps=5.04u w=4.4u l=0.6u
X1060 vdd sg13cmos5l_IOPadVdd$1_0.sg13cmos5l_RCClampInverter$1_0.in sg13cmos5l_IOPadVdd$1_0.sg13cmos5l_Clamp_N43N43D4R$1_0.gate vdd sg13_hv_pmos ad=2.38p pd=14.68u as=1.33p ps=7.38u w=7u l=0.5u
X1061 sg13cmos5l_Corner_1.iovdd a_164624_102044# sg13cmos5l_IOPadAnalog_16.pad sg13cmos5l_Corner_1.iovdd sg13_hv_pmos ad=2.1312p pd=7.3u as=3.9294p ps=7.84u w=6.66u l=0.6u
X1062 vddr adc8b_0.sar12b_0.nl_sw[0] adc8b_0.side_cap8b_1.buf_32_0.z vddr sg13_lv_pmos ad=0.19p pd=1.38u as=0.19p ps=1.38u w=1u l=0.13u
X1063 a_99297_98207# a_98355_98095# a_99095_98445# vdd sg13_lv_pmos ad=93.45f pd=0.865u as=0.2048p ps=1.63u w=0.42u l=0.13u
X1064 sg13cmos5l_IOPadAnalog_11.pad a_164624_118044# sg13cmos5l_Corner_1.iovdd sg13cmos5l_Corner_1.iovdd sg13_hv_pmos ad=3.9294p pd=7.84u as=2.1312p ps=7.3u w=6.66u l=0.6u
X1065 sg13cmos5l_IOPadAnalog_10.pad a_67639_164698# sg13cmos5l_Corner_1.iovdd sg13cmos5l_Corner_1.iovdd sg13_hv_pmos ad=3.9294p pd=7.84u as=2.1312p ps=7.3u w=6.66u l=0.6u
X1066 vddr a_42476_70044# sg13cmos5l_Corner_1.iovdd sg13cmos5l_Corner_1.iovdd sg13_hv_pmos ad=3.9294p pd=7.84u as=2.1312p ps=7.3u w=6.66u l=0.6u
X1067 a_89266_99057# a_89709_98813# a_89006_98834# sg13cmos5l_Corner_1.vss sg13_lv_nmos ad=79.8f pd=0.8u as=0.1296p ps=1.52u w=0.42u l=0.13u
X1068 sg13cmos5l_Corner_1.iovdd a_70044_42476# data[0] sg13cmos5l_Corner_1.iovdd sg13_hv_pmos ad=2.1312p pd=7.3u as=3.9294p ps=7.84u w=6.66u l=0.6u
X1069 sg13cmos5l_Corner_1.iovdd a_134044_42476# frame sg13cmos5l_Corner_1.iovdd sg13_hv_pmos ad=2.1312p pd=7.3u as=3.9294p ps=7.84u w=6.66u l=0.6u
X1070 vdd a_98036_92750# adc8b_0.sar12b_0.nl_sw[7] vdd sg13_lv_pmos ad=0.2114p pd=1.54u as=0.42p ps=2.99u w=1.12u l=0.13u
X1071 adc8b_0.sar12b_0.sg13cmos5l_o21ai_1_0.A1 adc8b_0.sar12b_0.sg13cmos5l_inv_1_0.Y a_92950_95836# sg13cmos5l_Corner_1.vss sg13_lv_nmos ad=0.2516p pd=2.16u as=0.1406p ps=1.12u w=0.74u l=0.13u
X1072 sg13cmos5l_Corner_1.vss a_83170_95024# a_82889_95326# sg13cmos5l_Corner_1.vss sg13_lv_nmos ad=79.8f pd=0.8u as=0.1428p ps=1.52u w=0.42u l=0.5u
X1073 sg13cmos5l_Corner_1.iovdd a_99639_164698# sg13cmos5l_IOPadAnalog_15.pad sg13cmos5l_Corner_1.iovdd sg13_hv_pmos ad=2.1312p pd=7.3u as=3.9294p ps=7.84u w=6.66u l=0.6u
X1074 vip a_30676_102044# sg13cmos5l_Corner_1.vss sg13cmos5l_Corner_1.vss sg13_hv_nmos ad=2.596p pd=5.58u as=1.408p ps=5.04u w=4.4u l=0.6u
X1075 vddr adc8b_0.side_cap8b_0.in_l_sw[0] adc8b_0.side_cap8b_0.buf_32_0.z vddr sg13_lv_pmos ad=0.19p pd=1.38u as=0.19p ps=1.38u w=1u l=0.13u
X1076 vdd a_100439_92863# a_101276_93084# vdd sg13_lv_pmos ad=0.2128p pd=1.5u as=0.3864p ps=2.93u w=1.12u l=0.13u
X1077 a_84500_92750# adc8b_0.sar12b_0.sg13cmos5l_buf_1_37.A sg13cmos5l_Corner_1.vss sg13cmos5l_Corner_1.vss sg13_lv_nmos ad=0.187p pd=1.78u as=0.14875p ps=1.16u w=0.55u l=0.13u
X1078 sg13cmos5l_Corner_1.iovdd a_115639_164698# sg13cmos5l_IOPadAnalog_13.pad sg13cmos5l_Corner_1.iovdd sg13_hv_pmos ad=2.1312p pd=7.3u as=3.9294p ps=7.84u w=6.66u l=0.6u
X1079 a_88509_96619# a_87567_96659# a_88415_96619# vdd sg13_lv_pmos ad=79.8f pd=0.8u as=0.1428p ps=1.52u w=0.42u l=0.13u
X1080 data[0] a_70044_30676# sg13cmos5l_Corner_1.vss sg13cmos5l_Corner_1.vss sg13_hv_nmos ad=2.596p pd=5.58u as=1.408p ps=5.04u w=4.4u l=0.6u
X1081 adc8b_0.side_cap8b_1.buf_32_1.z adc8b_0.sar12b_0.nh_sw[0] vddr vddr sg13_lv_pmos ad=0.19p pd=1.38u as=0.19p ps=1.38u w=1u l=0.13u
X1082 a_89580_98847# a_89292_99152# a_89518_98847# sg13cmos5l_Corner_1.vss sg13_lv_nmos ad=0.1428p pd=1.52u as=37.8f ps=0.6u w=0.42u l=0.13u
X1083 sg13cmos5l_Corner_1.iovdd a_164624_118044# sg13cmos5l_IOPadAnalog_11.pad sg13cmos5l_Corner_1.iovdd sg13_hv_pmos ad=3.1302p pd=14.26u as=3.9294p ps=7.84u w=6.66u l=0.6u
X1084 vddr a_42476_70044# sg13cmos5l_Corner_1.iovdd sg13cmos5l_Corner_1.iovdd sg13_hv_pmos ad=3.9294p pd=7.84u as=3.1302p ps=14.26u w=6.66u l=0.6u
X1085 adc8b_0.side_cap8b_0.in_h_sw[3] a_87184_100384# vdd vdd sg13_lv_pmos ad=0.42p pd=2.99u as=0.2114p ps=1.54u w=1.12u l=0.13u
X1086 sg13cmos5l_Corner_1.vss a_95800_97542# a_95449_97399# sg13cmos5l_Corner_1.vss sg13_lv_nmos ad=79.8f pd=0.8u as=0.1428p ps=1.52u w=0.42u l=0.13u
X1087 a_94701_97301# adc8b_0.sar12b_0.sg13cmos5l_dfrbp_1_23.CLK sg13cmos5l_Corner_1.vss sg13cmos5l_Corner_1.vss sg13_lv_nmos ad=0.2516p pd=2.16u as=1.97045p ps=12.335u w=0.74u l=0.13u
X1088 a_164624_118044# sg13cmos5l_Corner_1.iovdd sg13cmos5l_Corner_1.iovdd rppd l=12.9u w=0.5u
X1089 adc8b_0.side_cap8b_1.buf_16_1.z adc8b_0.sar12b_0.nl_sw[2] sg13cmos5l_Corner_1.vss sg13cmos5l_Corner_1.vss sg13_lv_nmos ad=0.17p pd=1.68u as=95f ps=0.88u w=0.5u l=0.13u
X1090 vdd a_86420_97286# adc8b_0.sar12b_0.sg13cmos5l_inv_1_19.A vdd sg13_lv_pmos ad=0.2114p pd=1.54u as=0.42p ps=2.99u w=1.12u l=0.13u
X1091 vdd a_95543_97399# a_95800_97542# vdd sg13_lv_pmos ad=0.2639p pd=1.81u as=79.8f ps=0.8u w=0.42u l=0.13u
X1092 sg13cmos5l_Corner_1.vss vdd sg13cmos5l_Corner_1.vss sg13cmos5l_Corner_1.vss sg13_lv_nmos ad=0.1428p pd=1.52u as=0 ps=0 w=0.42u l=1u
X1093 adc8b_0.sar12b_0.sg13cmos5l_buf_1_8.X a_92656_92824# vdd vdd sg13_lv_pmos ad=0.42p pd=2.99u as=0.2114p ps=1.54u w=1.12u l=0.13u
X1094 a_96878_96572# a_96482_96936# a_96764_96572# vdd sg13_lv_pmos ad=0.1008p pd=0.9u as=0.191p ps=1.44u w=0.42u l=0.13u
X1095 adc8b_0.sar12b_0.sg13cmos5l_a22oi_1_1.Y adc8b_0.sar12b_0.sg13cmos5l_a22oi_1_1.A1 a_96582_95452# sg13cmos5l_Corner_1.vss sg13_lv_nmos ad=0.2664p pd=1.46u as=96.2f ps=1u w=0.74u l=0.13u
X1096 adc8b_0.side_cap8b_1.buf_8_4.z adc8b_0.sar12b_0.nl_sw[5] vddr vddr sg13_lv_pmos ad=0.19p pd=1.38u as=0.19p ps=1.38u w=1u l=0.13u
X1097 a_96974_93986# a_97779_93559# a_97234_93516# vdd sg13_lv_pmos ad=0.1428p pd=1.52u as=79.8f ps=0.8u w=0.42u l=0.13u
X1098 vddr a_42476_70044# sg13cmos5l_Corner_1.iovdd sg13cmos5l_Corner_1.iovdd sg13_hv_pmos ad=3.9294p pd=7.84u as=2.1312p ps=7.3u w=6.66u l=0.6u
X1099 a_98241_99149# a_97299_98956# a_98039_98911# vdd sg13_lv_pmos ad=93.45f pd=0.865u as=0.2048p ps=1.63u w=0.42u l=0.13u
X1100 a_91292_96132# a_91010_95820# a_91225_95802# sg13cmos5l_Corner_1.vss sg13_lv_nmos ad=0.141p pd=1.17u as=71.99999f ps=0.865u w=0.64u l=0.13u
X1101 sg13cmos5l_IOPadAnalog_0.pad a_178296_86044# sg13cmos5l_Corner_1.vss sg13cmos5l_Corner_1.vss sg13_hv_nmos ad=2.596p pd=5.58u as=2.068p ps=9.74u w=4.4u l=0.6u
X1102 vdd adc8b_0.sar12b_0.sg13cmos5l_dfrbp_1_6.RESET_B a_98002_97545# vdd sg13_lv_pmos ad=0.1563p pd=1.22u as=0.147p ps=1.54u w=0.42u l=0.13u
X1103 sg13cmos5l_Corner_1.vss adc8b_0.sar12b_0.sg13cmos5l_buf_8_1.A a_98471_95031# sg13cmos5l_Corner_1.vss sg13_lv_nmos ad=2.41737p pd=15.64u as=0.2516p ps=2.16u w=0.74u l=0.13u
X1104 adc8b_0.side_cap8b_1.buf_16_3.z adc8b_0.sar12b_0.nh_sw[1] vddr vddr sg13_lv_pmos ad=0.19p pd=1.38u as=0.19p ps=1.38u w=1u l=0.13u
X1105 a_82476_96576# a_82450_96540# sg13cmos5l_Corner_1.vss sg13cmos5l_Corner_1.vss sg13_lv_nmos ad=0.2516p pd=2.16u as=0.1626p ps=1.415u w=0.74u l=0.13u
X1106 cks a_30676_118044# sg13cmos5l_Corner_1.vss sg13cmos5l_Corner_1.vss sg13_hv_nmos ad=2.596p pd=5.58u as=1.408p ps=5.04u w=4.4u l=0.6u
X1107 a_86817_96125# a_85875_95932# a_86615_95887# vdd sg13_lv_pmos ad=93.45f pd=0.865u as=0.2048p ps=1.63u w=0.42u l=0.13u
X1108 sg13cmos5l_Corner_1.vss adc8b_0.side_cap8b_0.in_l_sw[2] adc8b_0.side_cap8b_0.buf_16_1.z sg13cmos5l_Corner_1.vss sg13_lv_nmos ad=95f pd=0.88u as=95f ps=0.88u w=0.5u l=0.13u
X1109 adc8b_0.sar12b_0.sg13cmos5l_buf_1_31.X a_82192_92824# sg13cmos5l_Corner_1.vss sg13cmos5l_Corner_1.vss sg13_lv_nmos ad=0.2886p pd=2.26u as=0.14875p ps=1.16u w=0.74u l=0.13u
X1110 a_87756_99600# a_87730_99564# vdd vdd sg13_lv_pmos ad=0.34p pd=2.68u as=0.36237p ps=2.605u w=1u l=0.13u
X1111 vdd a_94929_98441# a_94862_98084# vdd sg13_lv_pmos ad=0.2387p pd=1.84u as=0.1008p ps=0.9u w=0.42u l=0.13u
X1112 sg13cmos5l_Corner_1.vss adc8b_0.side_cap8b_0.in_l_sw[8] adc8b_0.side_cap8b_0.buf_2_1.z sg13cmos5l_Corner_1.vss sg13_lv_nmos ad=95f pd=0.88u as=0.17p ps=1.68u w=0.5u l=0.13u
X1113 sg13cmos5l_Corner_1.vss sg13cmos5l_IOPadVdd$1_0.sg13cmos5l_Clamp_N43N43D4R$1_0.gate vdd sg13cmos5l_Corner_1.vss sg13_hv_nmos ad=1.408p pd=5.04u as=2.596p ps=5.58u w=4.4u l=0.6u
X1114 a_88366_95823# adc8b_0.sar12b_0.sg13cmos5l_dfrbp_1_8.RESET_B sg13cmos5l_Corner_1.vss sg13cmos5l_Corner_1.vss sg13_lv_nmos ad=37.8f pd=0.6u as=0.1701p ps=1.65u w=0.42u l=0.13u
X1115 sg13cmos5l_Corner_1.vss adc8b_0.sar12b_0.nh_sw[2] adc8b_0.side_cap8b_1.buf_16_0.z sg13cmos5l_Corner_1.vss sg13_lv_nmos ad=95f pd=0.88u as=95f ps=0.88u w=0.5u l=0.13u
X1116 adc8b_0.side_cap8b_0.buf_8_3.z adc8b_0.side_cap8b_0.in_h_sw[3] vddr vddr sg13_lv_pmos ad=0.19p pd=1.38u as=0.19p ps=1.38u w=1u l=0.13u
X1117 vdd a_100131_95430# adc8b_0.sar12b_0.sg13cmos5l_or2_1_0.A vdd sg13_lv_pmos ad=0.2128p pd=1.5u as=0.2128p ps=1.5u w=1.12u l=0.13u
X1118 sg13cmos5l_Corner_1.iovdd a_70044_42476# data[0] sg13cmos5l_Corner_1.iovdd sg13_hv_pmos ad=2.1312p pd=7.3u as=3.9294p ps=7.84u w=6.66u l=0.6u
X1119 adc8b_0.side_cap8b_1.buf_32_1.z adc8b_0.sar12b_0.nh_sw[0] sg13cmos5l_Corner_1.vss sg13cmos5l_Corner_1.vss sg13_lv_nmos ad=95f pd=0.88u as=95f ps=0.88u w=0.5u l=0.13u
X1120 a_88449_93671# a_87507_93559# a_88247_93909# vdd sg13_lv_pmos ad=93.45f pd=0.865u as=0.2048p ps=1.63u w=0.42u l=0.13u
X1121 sg13cmos5l_Corner_1.vss a_99729_99953# a_100254_100026# sg13cmos5l_Corner_1.vss sg13_lv_nmos ad=0.1491p pd=1.18u as=0.187p ps=1.78u w=0.55u l=0.13u
X1122 vdd a_89457_92786# a_89982_92768# vdd sg13_lv_pmos ad=0.1974p pd=1.5u as=0.2856p ps=2.36u w=0.84u l=0.13u
X1123 sg13cmos5l_Corner_1.iovdd a_42476_86044# vin sg13cmos5l_Corner_1.iovdd sg13_hv_pmos ad=2.1312p pd=7.3u as=3.9294p ps=7.84u w=6.66u l=0.6u
X1124 adc8b_0.sar12b_0.sg13cmos5l_buf_1_78.X a_87952_100384# vdd vdd sg13_lv_pmos ad=0.42p pd=2.99u as=0.2114p ps=1.54u w=1.12u l=0.13u
X1125 sg13cmos5l_Corner_1.vss a_102260_99560# adc8b_0.side_cap8b_0.in_l_sw[10] sg13cmos5l_Corner_1.vss sg13_lv_nmos ad=0.14875p pd=1.16u as=0.2886p ps=2.26u w=0.74u l=0.13u
X1126 vdd sg13cmos5l_Corner_1.vss vdd vdd sg13_lv_pmos ad=0.34p pd=2.68u as=0 ps=0 w=1u l=1u
X1127 a_74586_95659# adc8b_0.cmp_0.clk sg13cmos5l_Corner_1.vss sg13cmos5l_Corner_1.vss sg13_lv_nmos ad=0.17p pd=1.68u as=95f ps=0.88u w=0.5u l=0.13u
X1128 a_86847_94314# adc8b_0.sar12b_0.sg13cmos5l_dfrbp_1_9.Q sg13cmos5l_Corner_1.vss sg13cmos5l_Corner_1.vss sg13_lv_nmos ad=0.2516p pd=2.16u as=0.15055p ps=1.17u w=0.74u l=0.13u
X1129 vddr adc8b_0.sar12b_0.nl_sw[6] adc8b_0.side_cap8b_1.buf_4_3.z vddr sg13_lv_pmos ad=0.19p pd=1.38u as=0.19p ps=1.38u w=1u l=0.13u
X1130 vdd sg13cmos5l_IOPadVdd$1_0.sg13cmos5l_Clamp_N43N43D4R$1_0.gate sg13cmos5l_Corner_1.vss sg13cmos5l_Corner_1.vss sg13_hv_nmos ad=2.596p pd=5.58u as=1.408p ps=5.04u w=4.4u l=0.6u
X1131 sg13cmos5l_Corner_1.vss adc8b_0.sar12b_0.sg13cmos5l_dfrbp_1_15.D a_84389_98796# sg13cmos5l_Corner_1.vss sg13_lv_nmos ad=0.15055p pd=1.17u as=0.2516p ps=2.16u w=0.74u l=0.13u
X1132 sg13cmos5l_Corner_1.iovdd a_164624_118044# sg13cmos5l_IOPadAnalog_11.pad sg13cmos5l_Corner_1.iovdd sg13_hv_pmos ad=2.1312p pd=7.3u as=3.9294p ps=7.84u w=6.66u l=0.6u
X1133 sg13cmos5l_Corner_1.vss sg13cmos5l_IOPadVdd$1_0.sg13cmos5l_Clamp_N43N43D4R$1_0.gate vdd sg13cmos5l_Corner_1.vss sg13_hv_nmos ad=1.408p pd=5.04u as=2.596p ps=5.58u w=4.4u l=0.6u
X1134 adc8b_0.sar12b_0.sg13cmos5l_dlhr_1_12.Q_N a_100254_100026# sg13cmos5l_Corner_1.vss sg13cmos5l_Corner_1.vss sg13_lv_nmos ad=0.2516p pd=2.16u as=0.1491p ps=1.18u w=0.74u l=0.13u
X1135 sg13cmos5l_Corner_1.vss adc8b_0.sar12b_0.sg13cmos5l_dfrbp_1_6.RESET_B a_96892_98472# sg13cmos5l_Corner_1.vss sg13_lv_nmos ad=0.1406p pd=1.12u as=77.7f ps=0.95u w=0.74u l=0.13u
X1136 a_87276_97322# adc8b_0.sar12b_0.sg13cmos5l_dfrbp_1_6.D a_87182_97322# sg13cmos5l_Corner_1.vss sg13_lv_nmos ad=60.89999f pd=0.71u as=0.1428p ps=1.52u w=0.42u l=0.13u
X1137 a_93038_95498# adc8b_0.sar12b_0.sg13cmos5l_dfrbp_1_2.D vdd vdd sg13_lv_pmos ad=79.8f pd=0.8u as=0.1428p ps=1.52u w=0.42u l=0.13u
X1138 a_96582_95452# adc8b_0.sar12b_0.sg13cmos5l_nand2_1_1.B sg13cmos5l_Corner_1.vss sg13cmos5l_Corner_1.vss sg13_lv_nmos ad=96.2f pd=1u as=0.2516p ps=2.16u w=0.74u l=0.13u
X1139 sg13cmos5l_Corner_1.vss a_178296_86044# sg13cmos5l_IOPadAnalog_0.pad sg13cmos5l_Corner_1.vss sg13_hv_nmos ad=1.408p pd=5.04u as=2.596p ps=5.58u w=4.4u l=0.6u
X1140 vdd sg13cmos5l_IOPadVdd$1_0.sg13cmos5l_Clamp_N43N43D4R$1_0.gate sg13cmos5l_Corner_1.vss sg13cmos5l_Corner_1.vss sg13_hv_nmos ad=2.596p pd=5.58u as=1.408p ps=5.04u w=4.4u l=0.6u
X1141 a_89272_99838# adc8b_0.sar12b_0.sg13cmos5l_dfrbp_1_8.RESET_B vdd vdd sg13_lv_pmos ad=79.8f pd=0.8u as=1.12242p ps=7u w=0.42u l=0.13u
X1142 sg13cmos5l_Corner_1.iovdd a_67639_164698# sg13cmos5l_IOPadAnalog_10.pad sg13cmos5l_Corner_1.iovdd sg13_hv_pmos ad=2.1312p pd=7.3u as=3.9294p ps=7.84u w=6.66u l=0.6u
X1143 vdd a_90609_96929# a_90542_96572# vdd sg13_lv_pmos ad=0.2387p pd=1.84u as=0.1008p ps=0.9u w=0.42u l=0.13u
X1144 adc8b_0.side_cap8b_1.buf_32_0.z adc8b_0.sar12b_0.nl_sw[0] vddr vddr sg13_lv_pmos ad=0.19p pd=1.38u as=0.19p ps=1.38u w=1u l=0.13u
X1145 vdd adc8b_0.sar12b_0.sg13cmos5l_buf_1_3.X a_102160_94336# vdd sg13_lv_pmos ad=0.2114p pd=1.54u as=0.2856p ps=2.36u w=0.84u l=0.13u
X1146 sg13cmos5l_Corner_1.vss a_99639_178370# sg13cmos5l_IOPadAnalog_15.pad sg13cmos5l_Corner_1.vss sg13_hv_nmos ad=1.408p pd=5.04u as=2.596p ps=5.58u w=4.4u l=0.6u
X1147 adc8b_0.side_cap8b_1.buf_2_1.z adc8b_0.sar12b_0.nl_sw[8] sg13cmos5l_Corner_1.vss sg13cmos5l_Corner_1.vss sg13_lv_nmos ad=0.17p pd=1.68u as=95f ps=0.88u w=0.5u l=0.13u
X1148 vddr adc8b_0.sar12b_0.nh_sw[2] adc8b_0.side_cap8b_1.buf_16_0.z vddr sg13_lv_pmos ad=0.19p pd=1.38u as=0.19p ps=1.38u w=1u l=0.13u
X1149 a_92494_96920# adc8b_0.sar12b_0.sg13cmos5l_dfrbp_1_20.Q adc8b_0.sar12b_0.sg13cmos5l_a22oi_1_2.B2 sg13cmos5l_Corner_1.vss sg13_lv_nmos ad=0.1406p pd=1.12u as=0.2516p ps=2.16u w=0.74u l=0.13u
X1150 a_85809_93905# a_85628_93548# vdd vdd sg13_lv_pmos ad=0.2128p pd=1.5u as=0.2387p ps=1.84u w=1.12u l=0.13u
X1151 adc8b_0.side_cap8b_0.buf_16_0.z adc8b_0.side_cap8b_0.in_h_sw[2] sg13cmos5l_Corner_1.vss sg13cmos5l_Corner_1.vss sg13_lv_nmos ad=95f pd=0.88u as=95f ps=0.88u w=0.5u l=0.13u
X1152 vdd sg13cmos5l_Corner_1.vss vdd vdd sg13_lv_pmos ad=0.19p pd=1.38u as=0 ps=0 w=1u l=1u
X1153 cko a_118044_42476# sg13cmos5l_Corner_1.iovdd sg13cmos5l_Corner_1.iovdd sg13_hv_pmos ad=3.9294p pd=7.84u as=2.1312p ps=7.3u w=6.66u l=0.6u
X1154 sg13cmos5l_Corner_1.vss adc8b_0.sar12b_0.sg13cmos5l_dfrbp_1_1.Q a_102160_93548# sg13cmos5l_Corner_1.vss sg13_lv_nmos ad=0.14875p pd=1.16u as=0.187p ps=1.78u w=0.55u l=0.13u
X1155 sg13cmos5l_IOPadVdd$1_0.sg13cmos5l_Clamp_N43N43D4R$1_0.gate sg13cmos5l_IOPadVdd$1_0.sg13cmos5l_RCClampInverter$1_0.in vdd vdd sg13_hv_pmos ad=1.33p pd=7.38u as=1.33p ps=7.38u w=7u l=0.5u
X1156 a_95002_95498# adc8b_0.sar12b_0.sg13cmos5l_dfrbp_1_0.RESET_B sg13cmos5l_Corner_1.vss sg13cmos5l_Corner_1.vss sg13_lv_nmos ad=37.8f pd=0.6u as=79.8f ps=0.8u w=0.42u l=0.13u
X1157 vddr adc8b_0.sar12b_0.nl_sw[4] adc8b_0.side_cap8b_1.buf_8_0.z vddr sg13_lv_pmos ad=0.19p pd=1.38u as=0.19p ps=1.38u w=1u l=0.13u
X1158 vdd sg13cmos5l_IOPadVdd$1_0.sg13cmos5l_Clamp_N43N43D4R$1_0.gate sg13cmos5l_Corner_1.vss sg13cmos5l_Corner_1.vss sg13_hv_nmos ad=2.596p pd=5.58u as=1.408p ps=5.04u w=4.4u l=0.6u
X1159 a_82893_98095# adc8b_0.sar12b_0.sg13cmos5l_dfrbp_1_15.D vdd vdd sg13_lv_pmos ad=0.4088p pd=2.97u as=1.04815p ps=6.595u w=1.12u l=0.13u
X1160 a_92252_98084# a_91839_98442# a_92184_98084# vdd sg13_lv_pmos ad=0.191p pd=1.44u as=0.105p ps=1.21u w=1u l=0.13u
X1161 sg13cmos5l_Corner_1.vss a_92840_96507# adc8b_0.sar12b_0.sg13cmos5l_a221oi_1_1.C1 sg13cmos5l_Corner_1.vss sg13_lv_nmos ad=0.1371p pd=1.12u as=0.2516p ps=2.16u w=0.74u l=0.13u
X1162 vdd adc8b_0.sar12b_0.sg13cmos5l_dfrbp_1_8.RESET_B a_85070_95810# vdd sg13_lv_pmos ad=0.36237p pd=2.605u as=79.8f ps=0.8u w=0.42u l=0.13u
X1163 adc8b_0.side_cap8b_1.buf_32_0.z adc8b_0.sar12b_0.nl_sw[0] vddr vddr sg13_lv_pmos ad=0.19p pd=1.38u as=0.19p ps=1.38u w=1u l=0.13u
X1164 a_87981_95071# adc8b_0.sar12b_0.sg13cmos5l_dfrbp_1_11.Q vdd vdd sg13_lv_pmos ad=0.4088p pd=2.97u as=1.43437p ps=9.105u w=1.12u l=0.13u
X1165 data[2] a_102044_30676# sg13cmos5l_Corner_1.vss sg13cmos5l_Corner_1.vss sg13_hv_nmos ad=2.596p pd=5.58u as=2.068p ps=9.74u w=4.4u l=0.6u
X1166 adc8b_0.side_cap8b_0.buf_32_0.z adc8b_0.side_cap8b_0.in_l_sw[0] sg13cmos5l_Corner_1.vss sg13cmos5l_Corner_1.vss sg13_lv_nmos ad=95f pd=0.88u as=95f ps=0.88u w=0.5u l=0.13u
X1167 sg13cmos5l_Corner_1.vss adc8b_0.side_cap8b_0.in_l_sw[4] adc8b_0.side_cap8b_0.buf_8_0.z sg13cmos5l_Corner_1.vss sg13_lv_nmos ad=95f pd=0.88u as=95f ps=0.88u w=0.5u l=0.13u
X1168 adc8b_0.side_cap8b_0.in_h_sw[1] a_83632_100384# vdd vdd sg13_lv_pmos ad=0.42p pd=2.99u as=0.2114p ps=1.54u w=1.12u l=0.13u
X1169 sg13cmos5l_Corner_1.vss a_99544_97542# a_99193_97399# sg13cmos5l_Corner_1.vss sg13_lv_nmos ad=79.8f pd=0.8u as=0.1428p ps=1.52u w=0.42u l=0.13u
X1170 adc8b_0.side_cap8b_1.buf_8_1.z adc8b_0.sar12b_0.nl_sw[3] sg13cmos5l_Corner_1.vss sg13cmos5l_Corner_1.vss sg13_lv_nmos ad=0.17p pd=1.68u as=95f ps=0.88u w=0.5u l=0.13u
X1171 vddr adc8b_0.side_cap8b_0.in_h_sw[4] adc8b_0.side_cap8b_0.buf_8_2.z vddr sg13_lv_pmos ad=0.19p pd=1.38u as=0.19p ps=1.38u w=1u l=0.13u
X1172 a_93539_96572# adc8b_0.sar12b_0.sg13cmos5l_nor2b_1_0.Y adc8b_0.sar12b_0.sg13cmos5l_a221oi_1_0.B2 vdd sg13_lv_pmos ad=0.2128p pd=1.5u as=0.3808p ps=2.92u w=1.12u l=0.13u
X1173 a_95340_94311# a_95052_94616# a_95278_94311# sg13cmos5l_Corner_1.vss sg13_lv_nmos ad=0.1428p pd=1.52u as=37.8f ps=0.6u w=0.42u l=0.13u
X1174 a_86282_98826# a_86092_99156# a_85844_98784# sg13cmos5l_Corner_1.vss sg13_lv_nmos ad=71.99999f pd=0.865u as=0.141p ps=1.17u w=0.64u l=0.13u
X1175 vip a_72090_98590# adc8b_0.diff_bsw_0.vcp sg13cmos5l_Corner_1.vss sg13_lv_nmos ad=0.85p pd=5.68u as=0.85p ps=5.68u w=2.5u l=0.13u
X1176 sg13cmos5l_Corner_1.vss a_178296_70044# sg13cmos5l_IOPadAnalog_1.pad sg13cmos5l_Corner_1.vss sg13_hv_nmos ad=1.408p pd=5.04u as=2.596p ps=5.58u w=4.4u l=0.6u
X1177 a_93324_93104# a_93298_93009# vdd vdd sg13_lv_pmos ad=0.34p pd=2.68u as=0.36237p ps=2.605u w=1u l=0.13u
X1178 vddr adc8b_0.side_cap8b_0.in_l_sw[1] adc8b_0.side_cap8b_0.buf_16_2.z vddr sg13_lv_pmos ad=0.19p pd=1.38u as=0.19p ps=1.38u w=1u l=0.13u
X1179 sg13cmos5l_Corner_1.vss a_93335_98911# a_94172_99132# sg13cmos5l_Corner_1.vss sg13_lv_nmos ad=0.1406p pd=1.12u as=0.2516p ps=2.16u w=0.74u l=0.13u
X1180 vdd a_83646_97497# adc8b_0.sar12b_0.sg13cmos5l_dlhr_1_1.GATE vdd sg13_lv_pmos ad=0.2128p pd=1.5u as=0.3808p ps=2.92u w=1.12u l=0.13u
X1181 a_98036_94262# adc8b_0.sar12b_0.sg13cmos5l_buf_1_2.X vdd vdd sg13_lv_pmos ad=0.2856p pd=2.36u as=0.2114p ps=1.54u w=0.84u l=0.13u
X1182 vddr adc8b_0.side_cap8b_0.in_h_sw[2] adc8b_0.side_cap8b_0.buf_16_0.z vddr sg13_lv_pmos ad=0.19p pd=1.38u as=0.19p ps=1.38u w=1u l=0.13u
X1183 a_87372_95498# adc8b_0.sar12b_0.sg13cmos5l_dfrbp_1_6.D a_87278_95498# sg13cmos5l_Corner_1.vss sg13_lv_nmos ad=60.89999f pd=0.71u as=0.1428p ps=1.52u w=0.42u l=0.13u
X1184 sg13cmos5l_Corner_1.vss sg13cmos5l_IOPadVdd$1_0.sg13cmos5l_Clamp_N43N43D4R$1_0.gate vdd sg13cmos5l_Corner_1.vss sg13_hv_nmos ad=1.408p pd=5.04u as=2.596p ps=5.58u w=4.4u l=0.6u
X1185 sg13cmos5l_Corner_1.vss a_86044_30676# data[1] sg13cmos5l_Corner_1.vss sg13_hv_nmos ad=1.408p pd=5.04u as=2.596p ps=5.58u w=4.4u l=0.6u
X1186 sg13cmos5l_Corner_1.iovdd a_102044_42476# data[2] sg13cmos5l_Corner_1.iovdd sg13_hv_pmos ad=2.1312p pd=7.3u as=3.9294p ps=7.84u w=6.66u l=0.6u
X1187 a_98124_98509# a_98355_98095# a_97810_98052# sg13cmos5l_Corner_1.vss sg13_lv_nmos ad=0.2373p pd=1.97u as=79.8f ps=0.8u w=0.42u l=0.13u
X1188 sg13cmos5l_Corner_1.vss sg13cmos5l_IOPadVdd$1_0.sg13cmos5l_Clamp_N43N43D4R$1_0.gate vdd sg13cmos5l_Corner_1.vss sg13_hv_nmos ad=2.068p pd=9.74u as=2.596p ps=5.58u w=4.4u l=0.6u
X1189 sg13cmos5l_Corner_1.vss vdd sg13cmos5l_Corner_1.vss sg13cmos5l_Corner_1.vss sg13_lv_nmos ad=79.8f pd=0.8u as=0 ps=0 w=0.42u l=1u
X1190 adc8b_0.sar12b_0.sg13cmos5l_dlhr_1_10.Q_N a_101886_97304# sg13cmos5l_Corner_1.vss sg13cmos5l_Corner_1.vss sg13_lv_nmos ad=0.2516p pd=2.16u as=0.1491p ps=1.18u w=0.74u l=0.13u
X1191 adc8b_0.sar12b_0.sg13cmos5l_dfrbp_1_2.Q_N a_94583_95421# vdd vdd sg13_lv_pmos ad=0.4312p pd=3.01u as=0.2639p ps=1.81u w=1.12u l=0.13u
X1192 sg13cmos5l_IOPadVdd$1_0.sg13cmos5l_Clamp_N43N43D4R$1_0.gate sg13cmos5l_IOPadVdd$1_0.sg13cmos5l_RCClampInverter$1_0.in vdd vdd sg13_hv_pmos ad=1.33p pd=7.38u as=1.33p ps=7.38u w=7u l=0.5u
X1193 sg13cmos5l_Corner_1.iovdd a_42476_102044# vip sg13cmos5l_Corner_1.iovdd sg13_hv_pmos ad=2.1312p pd=7.3u as=3.9294p ps=7.84u w=6.66u l=0.6u
X1194 a_97550_98522# adc8b_0.sar12b_0.sg13cmos5l_dfrbp_1_22.D vdd vdd sg13_lv_pmos ad=79.8f pd=0.8u as=0.1428p ps=1.52u w=0.42u l=0.13u
X1195 a_86837_96536# a_87567_96659# a_87588_96933# sg13cmos5l_Corner_1.vss sg13_lv_nmos ad=0.12665p pd=1.145u as=0.3473p ps=2.71u w=0.74u l=0.13u
X1196 a_83724_95498# adc8b_0.sar12b_0.sg13cmos5l_dlhr_1_1.GATE a_83630_95498# sg13cmos5l_Corner_1.vss sg13_lv_nmos ad=60.89999f pd=0.71u as=0.1428p ps=1.52u w=0.42u l=0.13u
X1197 sg13cmos5l_Corner_1.vss adc8b_0.sar12b_0.nl_sw[2] adc8b_0.side_cap8b_1.buf_16_1.z sg13cmos5l_Corner_1.vss sg13_lv_nmos ad=95f pd=0.88u as=95f ps=0.88u w=0.5u l=0.13u
X1198 adc8b_0.sar12b_0.sg13cmos5l_buf_1_28.X a_91216_92824# vdd vdd sg13_lv_pmos ad=0.42p pd=2.99u as=0.2114p ps=1.54u w=1.12u l=0.13u
X1199 sg13cmos5l_IOPadVdd$1_0.sg13cmos5l_Clamp_N43N43D4R$1_0.gate sg13cmos5l_IOPadVdd$1_0.sg13cmos5l_RCClampInverter$1_0.in vdd vdd sg13_hv_pmos ad=1.33p pd=7.38u as=1.33p ps=7.38u w=7u l=0.5u
X1200 adc8b_0.sar12b_0.sg13cmos5l_a22oi_1_0.B1 adc8b_0.sar12b_0.sg13cmos5l_nor2_1_0.A a_92386_94302# sg13cmos5l_Corner_1.vss sg13_lv_nmos ad=0.2516p pd=2.16u as=0.1406p ps=1.12u w=0.74u l=0.13u
X1201 sg13cmos5l_Corner_1.vss adc8b_0.sar12b_0.sg13cmos5l_dfrbp_1_6.RESET_B a_82284_98522# sg13cmos5l_Corner_1.vss sg13_lv_nmos ad=0.1626p pd=1.415u as=60.89999f ps=0.71u w=0.42u l=0.13u
X1202 sg13cmos5l_IOPadAnalog_1.pad a_164624_70044# sg13cmos5l_Corner_1.iovdd sg13cmos5l_Corner_1.iovdd sg13_hv_pmos ad=3.9294p pd=7.84u as=2.1312p ps=7.3u w=6.66u l=0.6u
X1203 adc8b_0.side_cap8b_1.buf_16_3.z adc8b_0.sar12b_0.nh_sw[1] sg13cmos5l_Corner_1.vss sg13cmos5l_Corner_1.vss sg13_lv_nmos ad=95f pd=0.88u as=95f ps=0.88u w=0.5u l=0.13u
X1204 sg13cmos5l_Corner_1.vss a_67639_178370# sg13cmos5l_IOPadAnalog_10.pad sg13cmos5l_Corner_1.vss sg13_hv_nmos ad=1.408p pd=5.04u as=2.596p ps=5.58u w=4.4u l=0.6u
X1205 sg13cmos5l_Corner_1.vss adc8b_0.sar12b_0.sg13cmos5l_buf_1_34.X adc8b_0.sar12b_0.sg13cmos5l_buf_1_60.A sg13cmos5l_Corner_1.vss sg13_lv_nmos ad=0.2516p pd=2.16u as=0.2516p ps=2.16u w=0.74u l=0.13u
X1206 a_87921_95107# a_87564_95064# vdd vdd sg13_lv_pmos ad=63f pd=0.72u as=0.1563p ps=1.22u w=0.42u l=0.13u
X1207 vddr adc8b_0.sar12b_0.nh_sw[7] adc8b_0.side_cap8b_1.buf_4_2.z vddr sg13_lv_pmos ad=0.19p pd=1.38u as=0.34p ps=2.68u w=1u l=0.13u
X1208 sg13cmos5l_Corner_1.vss adc8b_0.sar12b_0.nl_sw[0] adc8b_0.side_cap8b_1.buf_32_0.z sg13cmos5l_Corner_1.vss sg13_lv_nmos ad=95f pd=0.88u as=95f ps=0.88u w=0.5u l=0.13u
X1209 vddr adc8b_0.side_cap8b_0.in_l_sw[6] adc8b_0.side_cap8b_0.buf_4_3.z vddr sg13_lv_pmos ad=0.19p pd=1.38u as=0.19p ps=1.38u w=1u l=0.13u
X1210 adc8b_0.side_cap8b_0.buf_2_3.z adc8b_0.side_cap8b_0.in_h_sw[9] sg13cmos5l_Corner_1.vss sg13cmos5l_Corner_1.vss sg13_lv_nmos ad=0.17p pd=1.68u as=95f ps=0.88u w=0.5u l=0.13u
X1211 vdd a_89265_94298# a_89790_94280# vdd sg13_lv_pmos ad=0.1974p pd=1.5u as=0.2856p ps=2.36u w=0.84u l=0.13u
X1212 sg13cmos5l_Corner_1.vss a_92056_99838# a_91705_99957# sg13cmos5l_Corner_1.vss sg13_lv_nmos ad=79.8f pd=0.8u as=0.1428p ps=1.52u w=0.42u l=0.13u
X1213 data[2] a_102044_42476# sg13cmos5l_Corner_1.iovdd sg13cmos5l_Corner_1.iovdd sg13_hv_pmos ad=3.9294p pd=7.84u as=2.1312p ps=7.3u w=6.66u l=0.6u
X1214 vdd a_100984_94518# a_100929_94613# vdd sg13_lv_pmos ad=1.43437p pd=9.105u as=93.45f ps=0.865u w=0.42u l=0.13u
X1215 adc8b_0.side_cap8b_1.buf_8_2.z adc8b_0.sar12b_0.nh_sw[4] sg13cmos5l_Corner_1.vss sg13cmos5l_Corner_1.vss sg13_lv_nmos ad=95f pd=0.88u as=95f ps=0.88u w=0.5u l=0.13u
X1216 sg13cmos5l_Corner_1.iovdd a_42476_86044# vin sg13cmos5l_Corner_1.iovdd sg13_hv_pmos ad=2.1312p pd=7.3u as=3.9294p ps=7.84u w=6.66u l=0.6u
X1217 vdd sg13cmos5l_IOPadVdd$1_0.sg13cmos5l_Clamp_N43N43D4R$1_0.gate sg13cmos5l_Corner_1.vss sg13cmos5l_Corner_1.vss sg13_hv_nmos ad=2.596p pd=5.58u as=1.408p ps=5.04u w=4.4u l=0.6u
X1218 vdd a_95543_97399# a_96380_97620# vdd sg13_lv_pmos ad=0.2128p pd=1.5u as=0.3864p ps=2.93u w=1.12u l=0.13u
X1219 a_85343_97713# a_84647_97592# a_85437_97480# sg13cmos5l_Corner_1.vss sg13_lv_nmos ad=0.1296p pd=1.52u as=79.8f ps=0.8u w=0.42u l=0.13u
X1220 sg13cmos5l_Corner_1.vss adc8b_0.sar12b_0.nl_sw[7] adc8b_0.side_cap8b_1.buf_4_0.z sg13cmos5l_Corner_1.vss sg13_lv_nmos ad=95f pd=0.88u as=0.17p ps=1.68u w=0.5u l=0.13u
X1221 sg13cmos5l_Corner_1.vss adc8b_0.sar12b_0.nh_sw[0] adc8b_0.side_cap8b_1.buf_32_1.z sg13cmos5l_Corner_1.vss sg13_lv_nmos ad=95f pd=0.88u as=95f ps=0.88u w=0.5u l=0.13u
X1222 sg13cmos5l_IOPadVdd$1_0.sg13cmos5l_Clamp_N43N43D4R$1_0.gate sg13cmos5l_IOPadVdd$1_0.sg13cmos5l_RCClampInverter$1_0.in vdd vdd sg13_hv_pmos ad=1.33p pd=7.38u as=1.33p ps=7.38u w=7u l=0.5u
X1223 vdd adc8b_0.sar12b_0.sg13cmos5l_nand2_1_1.A a_101776_95060# vdd sg13_lv_pmos ad=0.2114p pd=1.54u as=0.2856p ps=2.36u w=0.84u l=0.13u
X1224 frame a_134044_30676# sg13cmos5l_Corner_1.vss sg13cmos5l_Corner_1.vss sg13_hv_nmos ad=2.596p pd=5.58u as=1.408p ps=5.04u w=4.4u l=0.6u
X1225 adc8b_0.side_cap8b_1.buf_8_5.z adc8b_0.sar12b_0.nh_sw[5] vddr vddr sg13_lv_pmos ad=0.19p pd=1.38u as=0.19p ps=1.38u w=1u l=0.13u
X1226 adc8b_0.side_cap8b_0.buf_16_3.z adc8b_0.side_cap8b_0.in_h_sw[1] sg13cmos5l_Corner_1.vss sg13cmos5l_Corner_1.vss sg13_lv_nmos ad=95f pd=0.88u as=95f ps=0.88u w=0.5u l=0.13u
X1227 adc8b_0.side_cap8b_0.buf_4_2.z adc8b_0.side_cap8b_0.in_h_sw[7] vddr vddr sg13_lv_pmos ad=0.19p pd=1.38u as=0.19p ps=1.38u w=1u l=0.13u
X1228 vdd adc8b_0.sar12b_0.sg13cmos5l_nor2_1_0.A adc8b_0.sar12b_0.sg13cmos5l_a22oi_1_0.B1 vdd sg13_lv_pmos ad=0.3808p pd=2.92u as=0.2128p ps=1.5u w=1.12u l=0.13u
X1229 adc8b_0.side_cap8b_0.buf_16_3.z adc8b_0.side_cap8b_0.in_h_sw[1] vddr vddr sg13_lv_pmos ad=0.19p pd=1.38u as=0.19p ps=1.38u w=1u l=0.13u
X1230 adc8b_0.sar12b_0.sg13cmos5l_dfrbp_1_6.RESET_B cks sg13cmos5l_Corner_1.vss sg13cmos5l_Corner_1.vss sg13_lv_nmos ad=0.1406p pd=1.12u as=0.2516p ps=2.16u w=0.74u l=0.13u
X1231 a_96476_98084# a_96194_98448# a_96409_98486# sg13cmos5l_Corner_1.vss sg13_lv_nmos ad=0.141p pd=1.17u as=71.99999f ps=0.865u w=0.64u l=0.13u
X1232 sg13cmos5l_Corner_1.vss a_94335_98442# a_94466_98448# sg13cmos5l_Corner_1.vss sg13_lv_nmos ad=1.49685p pd=9.6u as=0.2775p ps=2.23u w=0.74u l=0.13u
X1233 sg13cmos5l_IOPadAnalog_16.pad a_164624_102044# sg13cmos5l_Corner_1.iovdd sg13cmos5l_Corner_1.iovdd sg13_hv_pmos ad=3.9294p pd=7.84u as=2.1312p ps=7.3u w=6.66u l=0.6u
X1234 vdd a_92232_93587# adc8b_0.sar12b_0.sg13cmos5l_dfrbp_1_4.D vdd sg13_lv_pmos ad=0.3808p pd=2.92u as=0.2408p ps=1.55u w=1.12u l=0.13u
X1235 sg13cmos5l_Corner_1.vss a_93984_96888# adc8b_0.sar12b_0.sg13cmos5l_a221oi_1_0.B1 sg13cmos5l_Corner_1.vss sg13_lv_nmos ad=0.1469p pd=1.155u as=0.2516p ps=2.16u w=0.74u l=0.13u
X1236 adc8b_0.side_cap8b_1.buf_8_4.z adc8b_0.sar12b_0.nl_sw[5] sg13cmos5l_Corner_1.vss sg13cmos5l_Corner_1.vss sg13_lv_nmos ad=95f pd=0.88u as=95f ps=0.88u w=0.5u l=0.13u
X1237 adc8b_0.side_cap8b_1.buf_16_0.z adc8b_0.sar12b_0.nh_sw[2] vddr vddr sg13_lv_pmos ad=0.19p pd=1.38u as=0.19p ps=1.38u w=1u l=0.13u
X1238 sg13cmos5l_Corner_1.vss sg13cmos5l_IOPadVdd$1_0.sg13cmos5l_Clamp_N43N43D4R$1_0.gate vdd sg13cmos5l_Corner_1.vss sg13_hv_nmos ad=1.408p pd=5.04u as=2.596p ps=5.58u w=4.4u l=0.6u
X1239 adc8b_0.side_cap8b_0.buf_8_1.z adc8b_0.side_cap8b_0.in_l_sw[3] vddr vddr sg13_lv_pmos ad=0.19p pd=1.38u as=0.19p ps=1.38u w=1u l=0.13u
X1240 sg13cmos5l_Corner_1.vss adc8b_0.sar12b_0.sg13cmos5l_dfrbp_1_6.RESET_B a_86044_93936# sg13cmos5l_Corner_1.vss sg13_lv_nmos ad=0.1406p pd=1.12u as=77.7f ps=0.95u w=0.74u l=0.13u
X1241 adc8b_0.sar12b_0.sg13cmos5l_buf_1_4.A a_97360_97360# sg13cmos5l_Corner_1.vss sg13cmos5l_Corner_1.vss sg13_lv_nmos ad=0.2886p pd=2.26u as=0.14875p ps=1.16u w=0.74u l=0.13u
X1242 sg13cmos5l_Corner_1.vss adc8b_0.sar12b_0.sg13cmos5l_buf_1_77.X a_89104_100384# sg13cmos5l_Corner_1.vss sg13_lv_nmos ad=0.14875p pd=1.16u as=0.187p ps=1.78u w=0.55u l=0.13u
X1243 sg13cmos5l_Corner_1.vss a_118044_30676# cko sg13cmos5l_Corner_1.vss sg13_hv_nmos ad=1.408p pd=5.04u as=2.596p ps=5.58u w=4.4u l=0.6u
X1244 sg13cmos5l_Corner_1.iovdd a_164624_86044# sg13cmos5l_IOPadAnalog_0.pad sg13cmos5l_Corner_1.iovdd sg13_hv_pmos ad=2.1312p pd=7.3u as=3.9294p ps=7.84u w=6.66u l=0.6u
X1245 sg13cmos5l_Corner_1.vss a_152182_76462# dantenna l=0.64u w=3.1u
X1246 sg13cmos5l_Corner_1.vss adc8b_0.sar12b_0.sg13cmos5l_buf_1_4.A adc8b_0.sar12b_0.sg13cmos5l_buf_1_110.A sg13cmos5l_Corner_1.vss sg13_lv_nmos ad=0.2516p pd=2.16u as=0.2516p ps=2.16u w=0.74u l=0.13u
X1247 sg13cmos5l_Corner_1.vss a_85773_95789# a_85875_95932# sg13cmos5l_Corner_1.vss sg13_lv_nmos ad=2.41737p pd=15.64u as=0.2516p ps=2.16u w=0.74u l=0.13u
X1248 sg13cmos5l_Corner_1.iovdd a_118044_42476# cko sg13cmos5l_Corner_1.iovdd sg13_hv_pmos ad=2.1312p pd=7.3u as=3.9294p ps=7.84u w=6.66u l=0.6u
X1249 vddr adc8b_0.sar12b_0.nl_sw[0] adc8b_0.side_cap8b_1.buf_32_0.z vddr sg13_lv_pmos ad=0.19p pd=1.38u as=0.34p ps=2.68u w=1u l=0.13u
X1250 sg13cmos5l_IOPadVdd$1_0.sg13cmos5l_Clamp_N43N43D4R$1_0.gate sg13cmos5l_IOPadVdd$1_0.sg13cmos5l_RCClampInverter$1_0.in vdd vdd sg13_hv_pmos ad=1.33p pd=7.38u as=1.33p ps=7.38u w=7u l=0.5u
X1251 sg13cmos5l_Corner_1.vss a_90015_96930# a_90146_96936# sg13cmos5l_Corner_1.vss sg13_lv_nmos ad=1.97045p pd=12.335u as=0.2775p ps=2.23u w=0.74u l=0.13u
X1252 data[2] a_102044_42476# sg13cmos5l_Corner_1.iovdd sg13cmos5l_Corner_1.iovdd sg13_hv_pmos ad=3.9294p pd=7.84u as=2.1312p ps=7.3u w=6.66u l=0.6u
X1253 sg13cmos5l_Corner_1.vss adc8b_0.side_cap8b_0.in_l_sw[0] adc8b_0.side_cap8b_0.buf_32_0.z sg13cmos5l_Corner_1.vss sg13_lv_nmos ad=95f pd=0.88u as=95f ps=0.88u w=0.5u l=0.13u
X1254 a_84177_95810# a_83996_96132# vdd vdd sg13_lv_pmos ad=0.2128p pd=1.5u as=0.2387p ps=1.84u w=1.12u l=0.13u
X1255 sg13cmos5l_Corner_1.vss a_100131_95430# adc8b_0.sar12b_0.sg13cmos5l_or2_1_0.A sg13cmos5l_Corner_1.vss sg13_lv_nmos ad=0.1406p pd=1.12u as=0.1406p ps=1.12u w=0.74u l=0.13u
X1256 a_36456_140035# a_40542_140365# sg13cmos5l_Corner_1.vss rppd l=20u w=1u
X1257 adc8b_0.side_cap8b_0.buf_32_0.z adc8b_0.side_cap8b_0.in_l_sw[0] sg13cmos5l_Corner_1.vss sg13cmos5l_Corner_1.vss sg13_lv_nmos ad=95f pd=0.88u as=95f ps=0.88u w=0.5u l=0.13u
X1258 sg13cmos5l_Corner_1.vss a_94484_99560# adc8b_0.side_cap8b_0.in_h_sw[5] sg13cmos5l_Corner_1.vss sg13_lv_nmos ad=0.14875p pd=1.16u as=0.2886p ps=2.26u w=0.74u l=0.13u
X1259 sg13cmos5l_Corner_1.vss adc8b_0.sar12b_0.sg13cmos5l_a221oi_1_0.A2 a_89809_96930# sg13cmos5l_Corner_1.vss sg13_lv_nmos ad=0.15055p pd=1.17u as=0.187p ps=1.78u w=0.55u l=0.13u
X1260 a_164624_102044# sg13cmos5l_Corner_1.iovdd sg13cmos5l_Corner_1.iovdd rppd l=12.9u w=0.5u
X1261 a_100995_100350# cks sg13cmos5l_Corner_1.vss sg13cmos5l_Corner_1.vss sg13_lv_nmos ad=0.1406p pd=1.12u as=0.1406p ps=1.12u w=0.74u l=0.13u
X1262 adc8b_0.sar12b_0.sg13cmos5l_dfrbp_1_2.Q_N a_94583_95421# sg13cmos5l_Corner_1.vss sg13cmos5l_Corner_1.vss sg13_lv_nmos ad=0.2849p pd=2.25u as=0.2516p ps=2.16u w=0.74u l=0.13u
X1263 frame a_134044_42476# sg13cmos5l_Corner_1.iovdd sg13cmos5l_Corner_1.iovdd sg13_hv_pmos ad=3.9294p pd=7.84u as=2.1312p ps=7.3u w=6.66u l=0.6u
X1264 vddr adc8b_0.side_cap8b_0.in_l_sw[0] adc8b_0.side_cap8b_0.buf_32_0.z vddr sg13_lv_pmos ad=0.19p pd=1.38u as=0.19p ps=1.38u w=1u l=0.13u
X1265 adc8b_0.side_cap8b_0.buf_16_2.z adc8b_0.side_cap8b_0.in_l_sw[1] vddr vddr sg13_lv_pmos ad=0.19p pd=1.38u as=0.19p ps=1.38u w=1u l=0.13u
X1266 a_93228_93552# a_93202_93516# sg13cmos5l_Corner_1.vss sg13cmos5l_Corner_1.vss sg13_lv_nmos ad=0.2516p pd=2.16u as=0.1626p ps=1.415u w=0.74u l=0.13u
X1267 adc8b_0.side_cap8b_0.buf_16_0.z adc8b_0.side_cap8b_0.in_h_sw[2] vddr vddr sg13_lv_pmos ad=0.19p pd=1.38u as=0.19p ps=1.38u w=1u l=0.13u
X1268 vddr adc8b_0.side_cap8b_0.in_h_sw[6] adc8b_0.side_cap8b_0.buf_4_1.z vddr sg13_lv_pmos ad=0.19p pd=1.38u as=0.19p ps=1.38u w=1u l=0.13u
X1269 data[0] a_70044_30676# sg13cmos5l_Corner_1.vss sg13cmos5l_Corner_1.vss sg13_hv_nmos ad=2.596p pd=5.58u as=1.408p ps=5.04u w=4.4u l=0.6u
X1270 sg13cmos5l_Corner_1.vss a_87956_92750# adc8b_0.sar12b_0.sg13cmos5l_buf_1_25.X sg13cmos5l_Corner_1.vss sg13_lv_nmos ad=0.14875p pd=1.16u as=0.2886p ps=2.26u w=0.74u l=0.13u
X1271 a_97836_98088# a_98355_98095# a_99095_98445# sg13cmos5l_Corner_1.vss sg13_lv_nmos ad=0.3473p pd=2.71u as=0.12665p ps=1.145u w=0.74u l=0.13u
X1272 sg13cmos5l_IOPadAnalog_1.pad a_178296_70044# sg13cmos5l_Corner_1.vss sg13cmos5l_Corner_1.vss sg13_hv_nmos ad=2.596p pd=5.58u as=2.068p ps=9.74u w=4.4u l=0.6u
X1273 adc8b_0.side_cap8b_1.buf_32_0.z adc8b_0.sar12b_0.nl_sw[0] sg13cmos5l_Corner_1.vss sg13cmos5l_Corner_1.vss sg13_lv_nmos ad=0.17p pd=1.68u as=95f ps=0.88u w=0.5u l=0.13u
X1274 a_93537_99149# a_92595_98956# a_93335_98911# vdd sg13_lv_pmos ad=93.45f pd=0.865u as=0.2048p ps=1.63u w=0.42u l=0.13u
X1275 adc8b_0.side_cap8b_1.buf_32_1.z adc8b_0.sar12b_0.nh_sw[0] vddr vddr sg13_lv_pmos ad=0.19p pd=1.38u as=0.19p ps=1.38u w=1u l=0.13u
X1276 a_84322_99272# a_83716_99124# vdd vdd sg13_lv_pmos ad=0.1008p pd=0.9u as=0.2387p ps=1.84u w=0.42u l=0.13u
X1277 adc8b_0.sar12b_0.sg13cmos5l_or2_1_1.B adc8b_0.sar12b_0.sg13cmos5l_nor2_1_0.A sg13cmos5l_Corner_1.vss sg13cmos5l_Corner_1.vss sg13_lv_nmos ad=0.1406p pd=1.12u as=0.2516p ps=2.16u w=0.74u l=0.13u
X1278 sg13cmos5l_IOPadAnalog_15.pad a_99639_164698# sg13cmos5l_Corner_1.iovdd sg13cmos5l_Corner_1.iovdd sg13_hv_pmos ad=3.9294p pd=7.84u as=2.1312p ps=7.3u w=6.66u l=0.6u
X1279 vip a_42476_102044# sg13cmos5l_Corner_1.iovdd sg13cmos5l_Corner_1.iovdd sg13_hv_pmos ad=3.9294p pd=7.84u as=2.1312p ps=7.3u w=6.66u l=0.6u
X1280 adc8b_0.sar12b_0.sg13cmos5l_buf_1_95.X a_94000_99596# vdd vdd sg13_lv_pmos ad=0.42p pd=2.99u as=0.2114p ps=1.54u w=1.12u l=0.13u
X1281 adc8b_0.sar12b_0.sg13cmos5l_dfrbp_1_6.D a_83440_94336# vdd vdd sg13_lv_pmos ad=0.42p pd=2.99u as=0.2114p ps=1.54u w=1.12u l=0.13u
X1282 sg13cmos5l_IOPadAnalog_1.pad a_178296_70044# sg13cmos5l_Corner_1.vss sg13cmos5l_Corner_1.vss sg13_hv_nmos ad=2.596p pd=5.58u as=1.408p ps=5.04u w=4.4u l=0.6u
X1283 vdd adc8b_0.sar12b_0.sg13cmos5l_dfrbp_1_6.RESET_B a_95409_98834# vdd sg13_lv_pmos ad=0.2128p pd=1.5u as=0.2128p ps=1.5u w=1.12u l=0.13u
X1284 a_99182_94298# adc8b_0.sar12b_0.sg13cmos5l_a22oi_1_1.Y vdd vdd sg13_lv_pmos ad=79.8f pd=0.8u as=0.1428p ps=1.52u w=0.42u l=0.13u
X1285 sg13cmos5l_Corner_1.vss adc8b_0.side_cap8b_0.in_h_sw[3] adc8b_0.side_cap8b_0.buf_8_3.z sg13cmos5l_Corner_1.vss sg13_lv_nmos ad=95f pd=0.88u as=95f ps=0.88u w=0.5u l=0.13u
X1286 adc8b_0.sar12b_0.sg13cmos5l_dlhr_1_12.Q_N a_100254_100026# vdd vdd sg13_lv_pmos ad=0.3808p pd=2.92u as=0.1974p ps=1.5u w=1.12u l=0.13u
X1287 vdd adc8b_0.sar12b_0.sg13cmos5l_a221oi_1_0.A2 a_89809_96930# vdd sg13_lv_pmos ad=1.28962p pd=8.195u as=0.2856p ps=2.36u w=0.84u l=0.13u
X1288 a_83583_95826# adc8b_0.sar12b_0.sg13cmos5l_dlhr_1_1.GATE vdd vdd sg13_lv_pmos ad=0.3234p pd=2.45u as=1.2517p ps=7.955u w=0.84u l=0.13u
X1289 sg13cmos5l_Corner_1.iovdd a_83639_164698# sg13cmos5l_IOPadAnalog_9.pad sg13cmos5l_Corner_1.iovdd sg13_hv_pmos ad=2.1312p pd=7.3u as=3.9294p ps=7.84u w=6.66u l=0.6u
X1290 sg13cmos5l_IOPadVdd$1_0.sg13cmos5l_Clamp_N43N43D4R$1_0.gate sg13cmos5l_IOPadVdd$1_0.sg13cmos5l_RCClampInverter$1_0.in vdd vdd sg13_hv_pmos ad=1.33p pd=7.38u as=1.33p ps=7.38u w=7u l=0.5u
X1291 adc8b_0.side_cap8b_1.buf_32_0.z adc8b_0.sar12b_0.nl_sw[0] sg13cmos5l_Corner_1.vss sg13cmos5l_Corner_1.vss sg13_lv_nmos ad=95f pd=0.88u as=95f ps=0.88u w=0.5u l=0.13u
X1292 sg13cmos5l_Corner_1.iovdd a_42476_70044# vddr sg13cmos5l_Corner_1.iovdd sg13_hv_pmos ad=2.1312p pd=7.3u as=3.9294p ps=7.84u w=6.66u l=0.6u
X1293 sg13cmos5l_Corner_1.iovdd a_118044_42476# cko sg13cmos5l_Corner_1.iovdd sg13_hv_pmos ad=2.1312p pd=7.3u as=3.9294p ps=7.84u w=6.66u l=0.6u
X1294 vddr adc8b_0.sar12b_0.nh_sw[3] adc8b_0.side_cap8b_1.buf_8_3.z vddr sg13_lv_pmos ad=0.19p pd=1.38u as=0.19p ps=1.38u w=1u l=0.13u
X1295 a_98036_92750# adc8b_0.sar12b_0.sg13cmos5l_buf_1_1.A sg13cmos5l_Corner_1.vss sg13cmos5l_Corner_1.vss sg13_lv_nmos ad=0.187p pd=1.78u as=0.14875p ps=1.16u w=0.55u l=0.13u
X1296 adc8b_0.side_cap8b_0.buf_32_1.z adc8b_0.side_cap8b_0.in_h_sw[0] sg13cmos5l_Corner_1.vss sg13cmos5l_Corner_1.vss sg13_lv_nmos ad=95f pd=0.88u as=95f ps=0.88u w=0.5u l=0.13u
X1297 sg13cmos5l_Corner_1.vss adc8b_0.side_cap8b_0.in_l_sw[2] adc8b_0.side_cap8b_0.buf_16_1.z sg13cmos5l_Corner_1.vss sg13_lv_nmos ad=95f pd=0.88u as=95f ps=0.88u w=0.5u l=0.13u
X1298 sg13cmos5l_Corner_1.iovdd a_164624_102044# sg13cmos5l_IOPadAnalog_16.pad sg13cmos5l_Corner_1.iovdd sg13_hv_pmos ad=2.1312p pd=7.3u as=3.9294p ps=7.84u w=6.66u l=0.6u
X1299 sg13cmos5l_Corner_1.vss sg13cmos5l_IOPadVdd$1_0.sg13cmos5l_Clamp_N43N43D4R$1_0.gate vdd sg13cmos5l_Corner_1.vss sg13_hv_nmos ad=1.408p pd=5.04u as=2.596p ps=5.58u w=4.4u l=0.6u
X1300 sg13cmos5l_Corner_1.vss adc8b_0.sar12b_0.sg13cmos5l_inv_1_8.A a_87719_96543# sg13cmos5l_Corner_1.vss sg13_lv_nmos ad=1.88087p pd=11.775u as=0.2516p ps=2.16u w=0.74u l=0.13u
X1301 sg13cmos5l_Corner_1.vss adc8b_0.sar12b_0.sg13cmos5l_buf_8_1.A a_100131_95430# sg13cmos5l_Corner_1.vss sg13_lv_nmos ad=0.1406p pd=1.12u as=0.1406p ps=1.12u w=0.74u l=0.13u
X1302 sg13cmos5l_Corner_1.vss adc8b_0.sar12b_0.sg13cmos5l_nand2_1_1.A a_101776_95060# sg13cmos5l_Corner_1.vss sg13_lv_nmos ad=0.14875p pd=1.16u as=0.187p ps=1.78u w=0.55u l=0.13u
X1303 sg13cmos5l_IOPadAnalog_0.pad a_164624_86044# sg13cmos5l_Corner_1.iovdd sg13cmos5l_Corner_1.iovdd sg13_hv_pmos ad=3.9294p pd=7.84u as=2.1312p ps=7.3u w=6.66u l=0.6u
X1304 a_99662_99596# a_99266_99960# a_99548_99596# vdd sg13_lv_pmos ad=0.1008p pd=0.9u as=0.191p ps=1.44u w=0.42u l=0.13u
X1305 cks a_30676_118044# sg13cmos5l_Corner_1.vss sg13cmos5l_Corner_1.vss sg13_hv_nmos ad=2.596p pd=5.58u as=1.408p ps=5.04u w=4.4u l=0.6u
X1306 a_92196_100382# a_91647_100362# a_92060_100668# sg13cmos5l_Corner_1.vss sg13_lv_nmos ad=47.25f pd=0.645u as=0.141p ps=1.17u w=0.42u l=0.13u
X1307 vdd a_89080_95302# a_89025_95183# vdd sg13_lv_pmos ad=1.43437p pd=9.105u as=93.45f ps=0.865u w=0.42u l=0.13u
X1308 sg13cmos5l_Corner_1.vss a_118222_176786# dantenna l=1.26u w=27.78u
X1309 adc8b_0.side_cap8b_0.buf_32_1.z adc8b_0.side_cap8b_0.in_h_sw[0] vddr vddr sg13_lv_pmos ad=0.19p pd=1.38u as=0.19p ps=1.38u w=1u l=0.13u
X1310 adc8b_0.side_cap8b_0.buf_8_3.z adc8b_0.side_cap8b_0.in_h_sw[3] vddr vddr sg13_lv_pmos ad=0.19p pd=1.38u as=0.19p ps=1.38u w=1u l=0.13u
X1311 a_85076_100310# adc8b_0.sar12b_0.sg13cmos5l_buf_1_65.X vdd vdd sg13_lv_pmos ad=0.2856p pd=2.36u as=0.2114p ps=1.54u w=0.84u l=0.13u
X1312 sg13cmos5l_Corner_1.vss adc8b_0.sar12b_0.sg13cmos5l_dfrbp_1_8.RESET_B a_83724_100034# sg13cmos5l_Corner_1.vss sg13_lv_nmos ad=0.1626p pd=1.415u as=60.89999f ps=0.71u w=0.42u l=0.13u
X1313 adc8b_0.sar12b_0.sg13cmos5l_dfrbp_1_15.D a_86012_99596# vdd vdd sg13_lv_pmos ad=0.3808p pd=2.92u as=0.2128p ps=1.5u w=1.12u l=0.13u
X1314 sg13cmos5l_Corner_1.vss adc8b_0.sar12b_0.sg13cmos5l_dfrbp_1_0.RESET_B a_97068_93986# sg13cmos5l_Corner_1.vss sg13_lv_nmos ad=0.1626p pd=1.415u as=60.89999f ps=0.71u w=0.42u l=0.13u
X1315 a_90828_100021# a_91059_99607# a_90514_99564# sg13cmos5l_Corner_1.vss sg13_lv_nmos ad=0.2373p pd=1.97u as=79.8f ps=0.8u w=0.42u l=0.13u
X1316 sg13cmos5l_Corner_1.vss sg13cmos5l_IOPadVdd$1_0.sg13cmos5l_Clamp_N43N43D4R$1_0.gate vdd sg13cmos5l_Corner_1.vss sg13_hv_nmos ad=1.408p pd=5.04u as=2.596p ps=5.58u w=4.4u l=0.6u
X1317 cks a_42476_118044# sg13cmos5l_Corner_1.iovdd sg13cmos5l_Corner_1.iovdd sg13_hv_pmos ad=3.9294p pd=7.84u as=2.1312p ps=7.3u w=6.66u l=0.6u
X1318 a_85560_93548# a_85009_93906# vdd vdd sg13_lv_pmos ad=0.105p pd=1.21u as=1.86162p ps=11.935u w=1u l=0.13u
X1319 a_96568_94518# a_96311_94375# a_96730_94298# sg13cmos5l_Corner_1.vss sg13_lv_nmos ad=0.1428p pd=1.52u as=37.8f ps=0.6u w=0.42u l=0.13u
X1320 vdd adc8b_0.sar12b_0.sg13cmos5l_buf_1_105.A a_100624_99596# vdd sg13_lv_pmos ad=0.2114p pd=1.54u as=0.2856p ps=2.36u w=0.84u l=0.13u
X1321 data[0] a_70044_42476# sg13cmos5l_Corner_1.iovdd sg13cmos5l_Corner_1.iovdd sg13_hv_pmos ad=3.9294p pd=7.84u as=2.1312p ps=7.3u w=6.66u l=0.6u
X1322 frame a_134044_42476# sg13cmos5l_Corner_1.iovdd sg13cmos5l_Corner_1.iovdd sg13_hv_pmos ad=3.9294p pd=7.84u as=2.1312p ps=7.3u w=6.66u l=0.6u
X1323 vdd sg13cmos5l_IOPadVdd$1_0.sg13cmos5l_Clamp_N43N43D4R$1_0.gate sg13cmos5l_Corner_1.vss sg13cmos5l_Corner_1.vss sg13_hv_nmos ad=2.596p pd=5.58u as=1.408p ps=5.04u w=4.4u l=0.6u
X1324 a_91992_100668# a_91441_100400# vdd vdd sg13_lv_pmos ad=0.105p pd=1.21u as=4.11675p ps=27.17u w=1u l=0.13u
X1325 vdd a_85432_95302# a_85377_95183# vdd sg13_lv_pmos ad=1.43437p pd=9.105u as=93.45f ps=0.865u w=0.42u l=0.13u
X1326 adc8b_0.side_cap8b_0.buf_8_2.z adc8b_0.side_cap8b_0.in_h_sw[4] sg13cmos5l_Corner_1.vss sg13cmos5l_Corner_1.vss sg13_lv_nmos ad=95f pd=0.88u as=95f ps=0.88u w=0.5u l=0.13u
X1327 vdd adc8b_0.sar12b_0.sg13cmos5l_buf_1_10.A adc8b_0.sar12b_0.sg13cmos5l_inv_1_28.Y vdd sg13_lv_pmos ad=0.3808p pd=2.92u as=0.3808p ps=2.92u w=1.12u l=0.13u
X1328 sg13cmos5l_Corner_1.iovdd a_131639_164698# sg13cmos5l_IOPadAnalog_12.pad sg13cmos5l_Corner_1.iovdd sg13_hv_pmos ad=2.1312p pd=7.3u as=3.9294p ps=7.84u w=6.66u l=0.6u
X1329 sg13cmos5l_Corner_1.vss a_85175_99957# a_86012_99596# sg13cmos5l_Corner_1.vss sg13_lv_nmos ad=0.1406p pd=1.12u as=0.2516p ps=2.16u w=0.74u l=0.13u
X1330 sg13cmos5l_Corner_1.vss a_98253_98095# a_98355_98095# sg13cmos5l_Corner_1.vss sg13_lv_nmos ad=1.49685p pd=9.6u as=0.2516p ps=2.16u w=0.74u l=0.13u
X1331 vdd adc8b_0.sar12b_0.sg13cmos5l_dfrbp_1_21.Q_N a_100561_97376# vdd sg13_lv_pmos ad=1.07253p pd=6.75u as=0.2856p ps=2.36u w=0.84u l=0.13u
X1332 sg13cmos5l_IOPadAnalog_16.pad a_164624_102044# sg13cmos5l_Corner_1.iovdd sg13cmos5l_Corner_1.iovdd sg13_hv_pmos ad=3.9294p pd=7.84u as=2.1312p ps=7.3u w=6.66u l=0.6u
X1333 vdd adc8b_0.sar12b_0.sg13cmos5l_dfrbp_1_6.RESET_B a_89457_92786# vdd sg13_lv_pmos ad=0.2128p pd=1.5u as=0.2128p ps=1.5u w=1.12u l=0.13u
X1334 sg13cmos5l_IOPadVdd$1_0.sg13cmos5l_Clamp_N43N43D4R$1_0.gate sg13cmos5l_IOPadVdd$1_0.sg13cmos5l_RCClampInverter$1_0.in vdd vdd sg13_hv_pmos ad=1.33p pd=7.38u as=1.33p ps=7.38u w=7u l=0.5u
X1335 sg13cmos5l_Corner_1.vss sg13cmos5l_IOPadVdd$1_0.sg13cmos5l_Clamp_N43N43D4R$1_0.gate vdd sg13cmos5l_Corner_1.vss sg13_hv_nmos ad=1.408p pd=5.04u as=3.256p ps=10.28u w=4.4u l=0.6u
X1336 sg13cmos5l_Corner_1.vss a_30676_118044# cks sg13cmos5l_Corner_1.vss sg13_hv_nmos ad=1.408p pd=5.04u as=2.596p ps=5.58u w=4.4u l=0.6u
X1337 cks a_42476_118044# sg13cmos5l_Corner_1.iovdd sg13cmos5l_Corner_1.iovdd sg13_hv_pmos ad=3.9294p pd=7.84u as=2.1312p ps=7.3u w=6.66u l=0.6u
X1338 sg13cmos5l_Corner_1.vss a_86847_94314# a_86978_94308# sg13cmos5l_Corner_1.vss sg13_lv_nmos ad=2.59257p pd=16.445u as=0.2775p ps=2.23u w=0.74u l=0.13u
X1339 sg13cmos5l_IOPadAnalog_16.pad a_178296_102044# sg13cmos5l_Corner_1.vss sg13cmos5l_Corner_1.vss sg13_hv_nmos ad=2.596p pd=5.58u as=1.408p ps=5.04u w=4.4u l=0.6u
X1340 sg13cmos5l_Corner_1.vss adc8b_0.sar12b_0.nh_sw[7] adc8b_0.side_cap8b_1.buf_4_2.z sg13cmos5l_Corner_1.vss sg13_lv_nmos ad=95f pd=0.88u as=95f ps=0.88u w=0.5u l=0.13u
X1341 sg13cmos5l_IOPadAnalog_12.pad a_131639_164698# sg13cmos5l_Corner_1.iovdd sg13cmos5l_Corner_1.iovdd sg13_hv_pmos ad=3.9294p pd=7.84u as=2.1312p ps=7.3u w=6.66u l=0.6u
X1342 vdd sg13cmos5l_IOPadVdd$1_0.sg13cmos5l_Clamp_N43N43D4R$1_0.gate sg13cmos5l_Corner_1.vss sg13cmos5l_Corner_1.vss sg13_hv_nmos ad=2.596p pd=5.58u as=1.408p ps=5.04u w=4.4u l=0.6u
X1343 adc8b_0.sar12b_0.sg13cmos5l_buf_1_19.A a_100624_99596# vdd vdd sg13_lv_pmos ad=0.42p pd=2.99u as=0.2114p ps=1.54u w=1.12u l=0.13u
X1344 adc8b_0.sar12b_0.sg13cmos5l_buf_1_18.A adc8b_0.sar12b_0.sg13cmos5l_buf_1_111.A sg13cmos5l_Corner_1.vss sg13cmos5l_Corner_1.vss sg13_lv_nmos ad=0.2516p pd=2.16u as=0.2516p ps=2.16u w=0.74u l=0.13u
X1345 a_92840_96507# adc8b_0.sar12b_0.sg13cmos5l_dlhr_1_15.D vdd vdd sg13_lv_pmos ad=0.1596p pd=1.22u as=0.36195p ps=1.84u w=0.84u l=0.13u
X1346 sg13cmos5l_IOPadAnalog_10.pad a_67639_164698# sg13cmos5l_Corner_1.iovdd sg13cmos5l_Corner_1.iovdd sg13_hv_pmos ad=3.9294p pd=7.84u as=2.1312p ps=7.3u w=6.66u l=0.6u
X1347 adc8b_0.side_cap8b_0.buf_16_2.z adc8b_0.side_cap8b_0.in_l_sw[1] sg13cmos5l_Corner_1.vss sg13cmos5l_Corner_1.vss sg13_lv_nmos ad=95f pd=0.88u as=95f ps=0.88u w=0.5u l=0.13u
X1348 sg13cmos5l_Corner_1.vss a_92241_100346# a_92196_100382# sg13cmos5l_Corner_1.vss sg13_lv_nmos ad=0.1428p pd=1.52u as=47.25f ps=0.645u w=0.42u l=0.13u
X1349 a_93038_92786# a_93843_92908# a_93298_93009# vdd sg13_lv_pmos ad=0.1428p pd=1.52u as=79.8f ps=0.8u w=0.42u l=0.13u
X1350 a_82476_98088# a_82450_98052# vdd vdd sg13_lv_pmos ad=0.34p pd=2.68u as=0.36237p ps=2.605u w=1u l=0.13u
X1351 vddr adc8b_0.sar12b_0.nh_sw[0] adc8b_0.side_cap8b_1.buf_32_1.z vddr sg13_lv_pmos ad=0.19p pd=1.38u as=0.19p ps=1.38u w=1u l=0.13u
X1352 sg13cmos5l_Corner_1.iovdd a_99639_164698# sg13cmos5l_IOPadAnalog_15.pad sg13cmos5l_Corner_1.iovdd sg13_hv_pmos ad=2.1312p pd=7.3u as=3.9294p ps=7.84u w=6.66u l=0.6u
X1353 a_96204_100034# adc8b_0.sar12b_0.sg13cmos5l_dfrbp_1_23.CLK a_96110_100034# sg13cmos5l_Corner_1.vss sg13_lv_nmos ad=60.89999f pd=0.71u as=0.1428p ps=1.52u w=0.42u l=0.13u
X1354 a_91428_95846# a_90879_95826# a_91292_96132# sg13cmos5l_Corner_1.vss sg13_lv_nmos ad=47.25f pd=0.645u as=0.141p ps=1.17u w=0.42u l=0.13u
X1355 sg13cmos5l_Corner_1.vss a_91473_95810# a_91428_95846# sg13cmos5l_Corner_1.vss sg13_lv_nmos ad=0.1428p pd=1.52u as=47.25f ps=0.645u w=0.42u l=0.13u
X1356 vddr adc8b_0.side_cap8b_0.in_h_sw[4] adc8b_0.side_cap8b_0.buf_8_2.z vddr sg13_lv_pmos ad=0.19p pd=1.38u as=0.19p ps=1.38u w=1u l=0.13u
X1357 vdd a_83765_97286# adc8b_0.sar12b_0.sg13cmos5l_dfrbp_1_15.Q_N vdd sg13_lv_pmos ad=0.2639p pd=1.81u as=0.4312p ps=3.01u w=1.12u l=0.13u
X1358 a_87790_95485# adc8b_0.sar12b_0.sg13cmos5l_dfrbp_1_6.RESET_B sg13cmos5l_Corner_1.vss sg13cmos5l_Corner_1.vss sg13_lv_nmos ad=37.8f pd=0.6u as=0.1701p ps=1.65u w=0.42u l=0.13u
X1359 vdd a_99597_92765# a_99699_92908# vdd sg13_lv_pmos ad=1.86162p pd=11.935u as=0.3864p ps=2.93u w=1.12u l=0.13u
X1360 adc8b_0.sar12b_0.sg13cmos5l_dlhr_1_1.Q a_84177_95810# sg13cmos5l_Corner_1.vss sg13cmos5l_Corner_1.vss sg13_lv_nmos ad=0.2516p pd=2.16u as=0.1406p ps=1.12u w=0.74u l=0.13u
X1361 sg13cmos5l_IOPadAnalog_11.pad a_164624_118044# sg13cmos5l_Corner_1.iovdd sg13cmos5l_Corner_1.iovdd sg13_hv_pmos ad=3.9294p pd=7.84u as=2.1312p ps=7.3u w=6.66u l=0.6u
X1362 sg13cmos5l_Corner_1.vss sg13cmos5l_IOPadVdd$1_0.sg13cmos5l_Clamp_N43N43D4R$1_0.gate vdd sg13cmos5l_Corner_1.vss sg13_hv_nmos ad=1.408p pd=5.04u as=2.596p ps=5.58u w=4.4u l=0.6u
X1363 a_84154_97010# adc8b_0.sar12b_0.sg13cmos5l_dfrbp_1_6.RESET_B sg13cmos5l_Corner_1.vss sg13cmos5l_Corner_1.vss sg13_lv_nmos ad=37.8f pd=0.6u as=79.8f ps=0.8u w=0.42u l=0.13u
X1364 vdd sg13cmos5l_Corner_1.vss vdd vdd sg13_lv_pmos ad=0.34p pd=2.68u as=0 ps=0 w=1u l=1u
X1365 a_89580_98847# a_89811_98956# a_89266_99057# sg13cmos5l_Corner_1.vss sg13_lv_nmos ad=0.2373p pd=1.97u as=79.8f ps=0.8u w=0.42u l=0.13u
X1366 a_91796_97286# adc8b_0.sar12b_0.sg13cmos5l_buf_1_56.A vdd vdd sg13_lv_pmos ad=0.2856p pd=2.36u as=0.2114p ps=1.54u w=0.84u l=0.13u
X1367 vdd sg13cmos5l_IOPadVdd$1_0.sg13cmos5l_Clamp_N43N43D4R$1_0.gate sg13cmos5l_Corner_1.vss sg13cmos5l_Corner_1.vss sg13_hv_nmos ad=2.596p pd=5.58u as=1.408p ps=5.04u w=4.4u l=0.6u
X1368 a_92099_93084# adc8b_0.sar12b_0.sg13cmos5l_nand2_1_1.B adc8b_0.sar12b_0.sg13cmos5l_a22oi_1_2.B1 vdd sg13_lv_pmos ad=0.2128p pd=1.5u as=0.3808p ps=2.92u w=1.12u l=0.13u
X1369 sg13cmos5l_Corner_1.vss a_86222_176786# dantenna l=1.26u w=27.78u
X1370 sg13cmos5l_Corner_1.vss sg13cmos5l_IOPadVdd$1_0.sg13cmos5l_Clamp_N43N43D4R$1_0.gate vdd sg13cmos5l_Corner_1.vss sg13_hv_nmos ad=2.068p pd=9.74u as=2.596p ps=5.58u w=4.4u l=0.6u
X1371 vdd a_85460_100310# adc8b_0.sar12b_0.sg13cmos5l_buf_1_62.X vdd sg13_lv_pmos ad=0.2114p pd=1.54u as=0.42p ps=2.99u w=1.12u l=0.13u
X1372 a_83716_99124# adc8b_0.sar12b_0.sg13cmos5l_dfrbp_1_6.RESET_B vdd vdd sg13_lv_pmos ad=0.2128p pd=1.5u as=0.2128p ps=1.5u w=1.12u l=0.13u
X1373 vdd a_92433_98441# a_92366_98084# vdd sg13_lv_pmos ad=0.2387p pd=1.84u as=0.1008p ps=0.9u w=0.42u l=0.13u
X1374 a_83916_95064# a_83890_95028# vdd vdd sg13_lv_pmos ad=0.34p pd=2.68u as=0.36237p ps=2.605u w=1u l=0.13u
X1375 data[0] a_70044_42476# sg13cmos5l_Corner_1.iovdd sg13cmos5l_Corner_1.iovdd sg13_hv_pmos ad=3.9294p pd=7.84u as=2.1312p ps=7.3u w=6.66u l=0.6u
X1376 sg13cmos5l_IOPadAnalog_11.pad a_178296_118044# sg13cmos5l_Corner_1.vss sg13cmos5l_Corner_1.vss sg13_hv_nmos ad=2.596p pd=5.58u as=1.408p ps=5.04u w=4.4u l=0.6u
X1377 vddr adc8b_0.sar12b_0.nh_sw[0] adc8b_0.side_cap8b_1.buf_32_1.z vddr sg13_lv_pmos ad=0.19p pd=1.38u as=0.19p ps=1.38u w=1u l=0.13u
X1378 sg13cmos5l_IOPadAnalog_15.pad a_99639_164698# sg13cmos5l_Corner_1.iovdd sg13cmos5l_Corner_1.iovdd sg13_hv_pmos ad=3.9294p pd=7.84u as=2.1312p ps=7.3u w=6.66u l=0.6u
X1379 sg13cmos5l_Corner_1.vss a_30676_102044# vip sg13cmos5l_Corner_1.vss sg13_hv_nmos ad=2.068p pd=9.74u as=2.596p ps=5.58u w=4.4u l=0.6u
X1380 adc8b_0.side_cap8b_0.in_l_sw[1] a_82768_100384# vdd vdd sg13_lv_pmos ad=0.42p pd=2.99u as=0.2114p ps=1.54u w=1.12u l=0.13u
X1381 a_92060_100668# a_91778_100356# a_91993_100338# sg13cmos5l_Corner_1.vss sg13_lv_nmos ad=0.141p pd=1.17u as=71.99999f ps=0.865u w=0.64u l=0.13u
X1382 sg13cmos5l_Corner_1.vss a_57198_85410# dantenna l=0.64u w=3.1u
X1383 sg13cmos5l_IOPadAnalog_13.pad a_115639_164698# sg13cmos5l_Corner_1.iovdd sg13cmos5l_Corner_1.iovdd sg13_hv_pmos ad=3.9294p pd=7.84u as=2.1312p ps=7.3u w=6.66u l=0.6u
X1384 a_90828_100021# a_90540_99600# a_90766_100021# sg13cmos5l_Corner_1.vss sg13_lv_nmos ad=0.1428p pd=1.52u as=37.8f ps=0.6u w=0.42u l=0.13u
X1385 vdd adc8b_0.sar12b_0.sg13cmos5l_buf_1_4.A adc8b_0.sar12b_0.sg13cmos5l_buf_1_110.A vdd sg13_lv_pmos ad=0.3808p pd=2.92u as=0.3808p ps=2.92u w=1.12u l=0.13u
X1386 sg13cmos5l_Corner_1.vss a_118044_30676# cko sg13cmos5l_Corner_1.vss sg13_hv_nmos ad=1.408p pd=5.04u as=2.596p ps=5.58u w=4.4u l=0.6u
X1387 a_36456_135415# a_40542_135745# sg13cmos5l_Corner_1.vss rppd l=20u w=1u
X1388 adc8b_0.cmp_0.sg13cmos5l_inv_1$1_1.Y adc8b_0.cmp_0.outn vdd vdd sg13_lv_pmos ad=0.3808p pd=2.92u as=0.3808p ps=2.92u w=1.12u l=0.13u
X1389 a_85802_98820# adc8b_0.sar12b_0.sg13cmos5l_dfrbp_1_6.RESET_B sg13cmos5l_Corner_1.vss sg13cmos5l_Corner_1.vss sg13_lv_nmos ad=77.7f pd=0.95u as=0.1406p ps=1.12u w=0.74u l=0.13u
X1390 a_99180_93104# a_99699_92908# a_100439_92863# sg13cmos5l_Corner_1.vss sg13_lv_nmos ad=0.3473p pd=2.71u as=0.12665p ps=1.145u w=0.74u l=0.13u
X1391 sg13cmos5l_Corner_1.iovdd a_42476_70044# vddr sg13cmos5l_Corner_1.iovdd sg13_hv_pmos ad=2.1312p pd=7.3u as=3.9294p ps=7.84u w=6.66u l=0.6u
X1392 a_91790_98834# adc8b_0.sar12b_0.sg13cmos5l_buf_1_57.X vdd vdd sg13_lv_pmos ad=79.8f pd=0.8u as=0.1428p ps=1.52u w=0.42u l=0.13u
X1393 adc8b_0.sar12b_0.sg13cmos5l_dlhr_1_2.D a_88247_93909# sg13cmos5l_Corner_1.vss sg13cmos5l_Corner_1.vss sg13_lv_nmos ad=0.2849p pd=2.25u as=0.2516p ps=2.16u w=0.74u l=0.13u
X1394 a_88415_96619# a_87719_96543# a_88509_96619# sg13cmos5l_Corner_1.vss sg13_lv_nmos ad=0.1296p pd=1.52u as=79.8f ps=0.8u w=0.42u l=0.13u
X1395 adc8b_0.side_cap8b_1.buf_16_3.z adc8b_0.sar12b_0.nh_sw[1] sg13cmos5l_Corner_1.vss sg13cmos5l_Corner_1.vss sg13_lv_nmos ad=95f pd=0.88u as=95f ps=0.88u w=0.5u l=0.13u
X1396 sg13cmos5l_Corner_1.vss vdd sg13cmos5l_Corner_1.vss sg13cmos5l_Corner_1.vss sg13_lv_nmos ad=0.1428p pd=1.52u as=0 ps=0 w=0.42u l=1u
X1397 sg13cmos5l_Corner_1.vss adc8b_0.sar12b_0.nl_sw[0] adc8b_0.side_cap8b_1.buf_32_0.z sg13cmos5l_Corner_1.vss sg13_lv_nmos ad=95f pd=0.88u as=95f ps=0.88u w=0.5u l=0.13u
X1398 vin a_70852_94286# a_70096_94286# sg13cmos5l_Corner_1.vss sg13_lv_nmos ad=1.02p pd=6.68u as=1.02p ps=6.68u w=3u l=0.13u
X1399 a_96626_93548# adc8b_0.sar12b_0.sg13cmos5l_dfrbp_1_0.Q adc8b_0.sar12b_0.sg13cmos5l_nand2_1_0.A vdd sg13_lv_pmos ad=0.1176p pd=1.33u as=0.3808p ps=2.92u w=1.12u l=0.13u
X1400 sg13cmos5l_IOPadAnalog_12.pad a_131639_178370# sg13cmos5l_Corner_1.vss sg13cmos5l_Corner_1.vss sg13_hv_nmos ad=2.596p pd=5.58u as=1.408p ps=5.04u w=4.4u l=0.6u
X1401 vdd a_90801_97322# a_91326_97304# vdd sg13_lv_pmos ad=0.1974p pd=1.5u as=0.2856p ps=2.36u w=0.84u l=0.13u
X1402 sg13cmos5l_Corner_1.vss a_178296_86044# sg13cmos5l_IOPadAnalog_0.pad sg13cmos5l_Corner_1.vss sg13_hv_nmos ad=1.408p pd=5.04u as=2.596p ps=5.58u w=4.4u l=0.6u
X1403 adc8b_0.side_cap8b_0.buf_16_1.z adc8b_0.side_cap8b_0.in_l_sw[2] sg13cmos5l_Corner_1.vss sg13cmos5l_Corner_1.vss sg13_lv_nmos ad=95f pd=0.88u as=95f ps=0.88u w=0.5u l=0.13u
X1404 adc8b_0.diff_bsw_0.single_bsw_0.sg13cmos5l_inv_1$1_2.Y adc8b_0.diff_bsw_0.single_bsw_0.sg13cmos5l_inv_1$1_2.A sg13cmos5l_Corner_1.vss sg13cmos5l_Corner_1.vss sg13_lv_nmos ad=0.2516p pd=2.16u as=0.2516p ps=2.16u w=0.74u l=0.13u
X1405 adc8b_0.sar12b_0.sg13cmos5l_nand2_1_0.B a_92355_95852# a_92557_95814# sg13cmos5l_Corner_1.vss sg13_lv_nmos ad=0.333p pd=2.38u as=0.1406p ps=1.12u w=0.74u l=0.13u
X1406 vdd adc8b_0.sar12b_0.sg13cmos5l_dfrbp_1_8.RESET_B a_97810_98052# vdd sg13_lv_pmos ad=0.1563p pd=1.22u as=0.147p ps=1.54u w=0.42u l=0.13u
X1407 sg13cmos5l_Corner_1.vss a_94701_97301# a_94803_97444# sg13cmos5l_Corner_1.vss sg13_lv_nmos ad=1.97045p pd=12.335u as=0.2516p ps=2.16u w=0.74u l=0.13u
X1408 adc8b_0.side_cap8b_1.buf_8_2.z adc8b_0.sar12b_0.nh_sw[4] sg13cmos5l_Corner_1.vss sg13cmos5l_Corner_1.vss sg13_lv_nmos ad=95f pd=0.88u as=95f ps=0.88u w=0.5u l=0.13u
X1409 vddr adc8b_0.side_cap8b_0.in_h_sw[0] adc8b_0.side_cap8b_0.buf_32_1.z vddr sg13_lv_pmos ad=0.19p pd=1.38u as=0.19p ps=1.38u w=1u l=0.13u
X1410 adc8b_0.cmp_0.outp adc8b_0.cmp_0.outn vdd vdd sg13_lv_pmos ad=0.425p pd=3.18u as=0.2375p ps=1.63u w=1.25u l=0.13u
X1411 adc8b_0.sar12b_0.sg13cmos5l_a22oi_1_2.B1 adc8b_0.sar12b_0.sg13cmos5l_nand2_1_1.B sg13cmos5l_Corner_1.vss sg13cmos5l_Corner_1.vss sg13_lv_nmos ad=0.1406p pd=1.12u as=0.2516p ps=2.16u w=0.74u l=0.13u
X1412 sg13cmos5l_Corner_1.vss adc8b_0.sar12b_0.nh_sw[0] adc8b_0.side_cap8b_1.buf_32_1.z sg13cmos5l_Corner_1.vss sg13_lv_nmos ad=95f pd=0.88u as=95f ps=0.88u w=0.5u l=0.13u
X1413 sg13cmos5l_Corner_1.iovdd a_67639_164698# sg13cmos5l_IOPadAnalog_10.pad sg13cmos5l_Corner_1.iovdd sg13_hv_pmos ad=2.1312p pd=7.3u as=3.9294p ps=7.84u w=6.66u l=0.6u
X1414 vdd a_82926_94302# a_83058_94366# vdd sg13_lv_pmos ad=0.2245p pd=1.53u as=0.445p ps=2.89u w=1u l=0.25u
X1415 a_86044_42476# sg13cmos5l_Corner_1.iovdd sg13cmos5l_Corner_1.iovdd rppd l=12.9u w=0.5u
X1416 adc8b_0.side_cap8b_0.buf_4_2.z adc8b_0.side_cap8b_0.in_h_sw[7] vddr vddr sg13_lv_pmos ad=0.34p pd=2.68u as=0.19p ps=1.38u w=1u l=0.13u
X1417 vdd sg13cmos5l_Corner_1.vss vdd vdd sg13_lv_pmos ad=0.34p pd=2.68u as=0 ps=0 w=1u l=1u
X1418 vdd adc8b_0.sar12b_0.sg13cmos5l_dlhr_1_1.D a_83377_95864# vdd sg13_lv_pmos ad=1.28962p pd=8.195u as=0.2856p ps=2.36u w=0.84u l=0.13u
X1419 adc8b_0.sar12b_0.sg13cmos5l_or2_1_0.A a_100131_95430# vdd vdd sg13_lv_pmos ad=0.2128p pd=1.5u as=0.2128p ps=1.5u w=1.12u l=0.13u
X1420 sg13cmos5l_Corner_1.vss adc8b_0.sar12b_0.sg13cmos5l_dfrbp_1_8.RESET_B a_97452_95810# sg13cmos5l_Corner_1.vss sg13_lv_nmos ad=0.1626p pd=1.415u as=60.89999f ps=0.71u w=0.42u l=0.13u
X1421 sg13cmos5l_Corner_1.vss sg13cmos5l_IOPadVdd$1_0.sg13cmos5l_Clamp_N43N43D4R$1_0.gate vdd sg13cmos5l_Corner_1.vss sg13_hv_nmos ad=1.408p pd=5.04u as=2.596p ps=5.58u w=4.4u l=0.6u
X1422 sg13cmos5l_IOPadVdd$1_0.sg13cmos5l_Clamp_N43N43D4R$1_0.gate sg13cmos5l_IOPadVdd$1_0.sg13cmos5l_RCClampInverter$1_0.in sg13cmos5l_Corner_1.vss sg13cmos5l_Corner_1.vss sg13_hv_nmos ad=1.71p pd=9.38u as=1.71p ps=9.38u w=9u l=0.5u
X1423 sg13cmos5l_Corner_1.iovdd a_118044_42476# cko sg13cmos5l_Corner_1.iovdd sg13_hv_pmos ad=3.1302p pd=14.26u as=3.9294p ps=7.84u w=6.66u l=0.6u
X1424 data[1] a_86044_30676# sg13cmos5l_Corner_1.vss sg13cmos5l_Corner_1.vss sg13_hv_nmos ad=2.596p pd=5.58u as=1.408p ps=5.04u w=4.4u l=0.6u
X1425 sg13cmos5l_Corner_1.iovdd a_164624_70044# sg13cmos5l_IOPadAnalog_1.pad sg13cmos5l_Corner_1.iovdd sg13_hv_pmos ad=2.1312p pd=7.3u as=3.9294p ps=7.84u w=6.66u l=0.6u
X1426 vdd a_89015_99957# a_89272_99838# vdd sg13_lv_pmos ad=0.2639p pd=1.81u as=79.8f ps=0.8u w=0.42u l=0.13u
X1427 data[2] a_102044_42476# sg13cmos5l_Corner_1.iovdd sg13cmos5l_Corner_1.iovdd sg13_hv_pmos ad=3.9294p pd=7.84u as=2.1312p ps=7.3u w=6.66u l=0.6u
X1428 a_85377_99719# a_84435_99607# a_85175_99957# vdd sg13_lv_pmos ad=93.45f pd=0.865u as=0.2048p ps=1.63u w=0.42u l=0.13u
X1429 adc8b_0.side_cap8b_1.buf_16_0.z adc8b_0.sar12b_0.nh_sw[2] vddr vddr sg13_lv_pmos ad=0.19p pd=1.38u as=0.19p ps=1.38u w=1u l=0.13u
X1430 sg13cmos5l_IOPadAnalog_10.pad a_67639_164698# sg13cmos5l_Corner_1.iovdd sg13cmos5l_Corner_1.iovdd sg13_hv_pmos ad=3.9294p pd=7.84u as=2.1312p ps=7.3u w=6.66u l=0.6u
X1431 adc8b_0.cmp_0.sg13cmos5l_dlygate4sd3_1$1_0.A a_79552_97015# vdd vdd sg13_lv_pmos ad=0.3976p pd=2.95u as=0.2226p ps=1.535u w=1.12u l=0.13u
X1432 a_89265_94298# a_89084_94620# vdd vdd sg13_lv_pmos ad=0.2128p pd=1.5u as=0.2387p ps=1.84u w=1.12u l=0.13u
X1433 adc8b_0.side_cap8b_0.buf_8_1.z adc8b_0.side_cap8b_0.in_l_sw[3] vddr vddr sg13_lv_pmos ad=0.19p pd=1.38u as=0.19p ps=1.38u w=1u l=0.13u
X1434 sg13cmos5l_Corner_1.vss adc8b_0.sar12b_0.sg13cmos5l_or2_1_1.B a_92494_96920# sg13cmos5l_Corner_1.vss sg13_lv_nmos ad=0.2516p pd=2.16u as=0.1406p ps=1.12u w=0.74u l=0.13u
X1435 a_100439_92863# a_99597_92765# a_100345_92863# sg13cmos5l_Corner_1.vss sg13_lv_nmos ad=0.12665p pd=1.145u as=0.1428p ps=1.52u w=0.42u l=0.13u
X1436 vdd adc8b_0.sar12b_0.sg13cmos5l_dfrbp_1_6.RESET_B a_85809_93905# vdd sg13_lv_pmos ad=0.2128p pd=1.5u as=0.2128p ps=1.5u w=1.12u l=0.13u
X1437 sg13cmos5l_IOPadVdd$1_0.sg13cmos5l_Clamp_N43N43D4R$1_0.gate sg13cmos5l_IOPadVdd$1_0.sg13cmos5l_RCClampInverter$1_0.in sg13cmos5l_Corner_1.vss sg13cmos5l_Corner_1.vss sg13_hv_nmos ad=1.71p pd=9.38u as=1.71p ps=9.38u w=9u l=0.5u
X1438 sg13cmos5l_Corner_1.vss a_83583_95826# a_83714_95820# sg13cmos5l_Corner_1.vss sg13_lv_nmos ad=2.41737p pd=15.64u as=0.2775p ps=2.23u w=0.74u l=0.13u
X1439 a_95186_95856# adc8b_0.sar12b_0.sg13cmos5l_nor2_1_0.A a_95092_95856# sg13cmos5l_Corner_1.vss sg13_lv_nmos ad=0.1216p pd=1.02u as=0.2176p ps=1.96u w=0.64u l=0.13u
X1440 vdd sg13cmos5l_IOPadVdd$1_0.sg13cmos5l_Clamp_N43N43D4R$1_0.gate sg13cmos5l_Corner_1.vss sg13cmos5l_Corner_1.vss sg13_hv_nmos ad=2.596p pd=5.58u as=1.408p ps=5.04u w=4.4u l=0.6u
X1441 sg13cmos5l_Corner_1.iovdd a_164624_118044# sg13cmos5l_IOPadAnalog_11.pad sg13cmos5l_Corner_1.iovdd sg13_hv_pmos ad=2.1312p pd=7.3u as=3.9294p ps=7.84u w=6.66u l=0.6u
X1442 adc8b_0.side_cap8b_1.buf_1_0.z adc8b_0.sar12b_0.nl_sw[10] sg13cmos5l_Corner_1.vss sg13cmos5l_Corner_1.vss sg13_lv_nmos ad=0.17p pd=1.68u as=0.17p ps=1.68u w=0.5u l=0.13u
X1443 vdd adc8b_0.sar12b_0.sg13cmos5l_buf_1_2.A a_97552_92824# vdd sg13_lv_pmos ad=0.2114p pd=1.54u as=0.2856p ps=2.36u w=0.84u l=0.13u
X1444 sg13cmos5l_Corner_1.iovdd a_99639_164698# sg13cmos5l_IOPadAnalog_15.pad sg13cmos5l_Corner_1.iovdd sg13_hv_pmos ad=2.1312p pd=7.3u as=3.9294p ps=7.84u w=6.66u l=0.6u
X1445 sg13cmos5l_Corner_1.vss adc8b_0.side_cap8b_0.in_l_sw[1] adc8b_0.side_cap8b_0.buf_16_2.z sg13cmos5l_Corner_1.vss sg13_lv_nmos ad=95f pd=0.88u as=95f ps=0.88u w=0.5u l=0.13u
X1446 vdd a_88340_92750# adc8b_0.sar12b_0.sg13cmos5l_buf_1_24.X vdd sg13_lv_pmos ad=0.2114p pd=1.54u as=0.42p ps=2.99u w=1.12u l=0.13u
X1447 sg13cmos5l_Corner_1.iovdd a_115639_164698# sg13cmos5l_IOPadAnalog_13.pad sg13cmos5l_Corner_1.iovdd sg13_hv_pmos ad=2.1312p pd=7.3u as=3.9294p ps=7.84u w=6.66u l=0.6u
X1448 a_100046_99272# a_99650_98844# a_99932_99156# vdd sg13_lv_pmos ad=0.1008p pd=0.9u as=0.191p ps=1.44u w=0.42u l=0.13u
X1449 sg13cmos5l_Corner_1.vss adc8b_0.sar12b_0.sg13cmos5l_dfrbp_1_0.RESET_B a_93132_95498# sg13cmos5l_Corner_1.vss sg13_lv_nmos ad=0.1626p pd=1.415u as=60.89999f ps=0.71u w=0.42u l=0.13u
X1450 a_95342_99272# a_94946_98844# a_95228_99156# vdd sg13_lv_pmos ad=0.1008p pd=0.9u as=0.191p ps=1.44u w=0.42u l=0.13u
X1451 vdd adc8b_0.sar12b_0.sg13cmos5l_dfrbp_1_8.RESET_B a_88114_96033# vdd sg13_lv_pmos ad=0.1563p pd=1.22u as=0.147p ps=1.54u w=0.42u l=0.13u
X1452 a_93741_95071# adc8b_0.sar12b_0.sg13cmos5l_dfrbp_1_0.CLK sg13cmos5l_Corner_1.vss sg13cmos5l_Corner_1.vss sg13_lv_nmos ad=0.2516p pd=2.16u as=2.41737p ps=15.64u w=0.74u l=0.13u
X1453 sg13cmos5l_Corner_1.vss adc8b_0.sar12b_0.nl_sw[3] adc8b_0.side_cap8b_1.buf_8_1.z sg13cmos5l_Corner_1.vss sg13_lv_nmos ad=95f pd=0.88u as=0.17p ps=1.68u w=0.5u l=0.13u
X1454 a_87214_93973# adc8b_0.sar12b_0.sg13cmos5l_dfrbp_1_6.RESET_B sg13cmos5l_Corner_1.vss sg13cmos5l_Corner_1.vss sg13_lv_nmos ad=37.8f pd=0.6u as=0.1701p ps=1.65u w=0.42u l=0.13u
X1455 a_97652_94262# adc8b_0.sar12b_0.sg13cmos5l_buf_1_5.X sg13cmos5l_Corner_1.vss sg13cmos5l_Corner_1.vss sg13_lv_nmos ad=0.187p pd=1.78u as=0.14875p ps=1.16u w=0.55u l=0.13u
X1456 adc8b_0.side_cap8b_0.buf_32_0.z adc8b_0.side_cap8b_0.in_l_sw[0] sg13cmos5l_Corner_1.vss sg13cmos5l_Corner_1.vss sg13_lv_nmos ad=95f pd=0.88u as=95f ps=0.88u w=0.5u l=0.13u
X1457 a_82284_98522# adc8b_0.sar12b_0.sg13cmos5l_dfrbp_1_6.D a_82190_98522# sg13cmos5l_Corner_1.vss sg13_lv_nmos ad=60.89999f pd=0.71u as=0.1428p ps=1.52u w=0.42u l=0.13u
X1458 a_98445_97301# adc8b_0.sar12b_0.sg13cmos5l_dfrbp_1_8.D vdd vdd sg13_lv_pmos ad=0.4088p pd=2.97u as=1.04815p ps=6.595u w=1.12u l=0.13u
X1459 a_99706_97322# adc8b_0.sar12b_0.sg13cmos5l_dfrbp_1_6.RESET_B sg13cmos5l_Corner_1.vss sg13cmos5l_Corner_1.vss sg13_lv_nmos ad=37.8f pd=0.6u as=79.8f ps=0.8u w=0.42u l=0.13u
X1460 a_100131_95430# adc8b_0.sar12b_0.sg13cmos5l_buf_8_1.A vdd vdd sg13_lv_pmos ad=0.2128p pd=1.5u as=0.2128p ps=1.5u w=1.12u l=0.13u
X1461 adc8b_0.side_cap8b_0.buf_16_2.z adc8b_0.side_cap8b_0.in_l_sw[1] vddr vddr sg13_lv_pmos ad=0.19p pd=1.38u as=0.19p ps=1.38u w=1u l=0.13u
X1462 vdd a_99287_97399# a_100124_97620# vdd sg13_lv_pmos ad=0.2128p pd=1.5u as=0.3864p ps=2.93u w=1.12u l=0.13u
X1463 sg13cmos5l_Corner_1.iovdd a_164624_102044# sg13cmos5l_IOPadAnalog_16.pad sg13cmos5l_Corner_1.iovdd sg13_hv_pmos ad=2.1312p pd=7.3u as=3.9294p ps=7.84u w=6.66u l=0.6u
X1464 a_36456_138715# a_40542_139045# sg13cmos5l_Corner_1.vss rppd l=20u w=1u
X1465 vddr adc8b_0.sar12b_0.nh_sw[9] adc8b_0.side_cap8b_1.buf_2_3.z vddr sg13_lv_pmos ad=0.19p pd=1.38u as=0.34p ps=2.68u w=1u l=0.13u
X1466 sg13cmos5l_Corner_1.vss adc8b_0.sar12b_0.nl_sw[1] adc8b_0.side_cap8b_1.buf_16_2.z sg13cmos5l_Corner_1.vss sg13_lv_nmos ad=95f pd=0.88u as=95f ps=0.88u w=0.5u l=0.13u
X1467 sg13cmos5l_Corner_1.vss adc8b_0.sar12b_0.sg13cmos5l_inv_1_3.A a_96784_100384# sg13cmos5l_Corner_1.vss sg13_lv_nmos ad=0.14875p pd=1.16u as=0.187p ps=1.78u w=0.55u l=0.13u
X1468 vdd a_82893_98095# a_82995_98095# vdd sg13_lv_pmos ad=1.07253p pd=6.75u as=0.3864p ps=2.93u w=1.12u l=0.13u
X1469 sg13cmos5l_Corner_1.vss a_131639_178370# sg13cmos5l_IOPadAnalog_12.pad sg13cmos5l_Corner_1.vss sg13_hv_nmos ad=2.068p pd=9.74u as=2.596p ps=5.58u w=4.4u l=0.6u
X1470 vdd a_87981_95071# a_88083_95071# vdd sg13_lv_pmos ad=1.43437p pd=9.105u as=0.3864p ps=2.93u w=1.12u l=0.13u
X1471 adc8b_0.side_cap8b_1.buf_8_3.z adc8b_0.sar12b_0.nh_sw[3] sg13cmos5l_Corner_1.vss sg13cmos5l_Corner_1.vss sg13_lv_nmos ad=0.17p pd=1.68u as=95f ps=0.88u w=0.5u l=0.13u
X1472 adc8b_0.side_cap8b_1.buf_32_1.z adc8b_0.sar12b_0.nh_sw[0] vddr vddr sg13_lv_pmos ad=0.19p pd=1.38u as=0.19p ps=1.38u w=1u l=0.13u
X1473 vddr adc8b_0.sar12b_0.nl_sw[2] adc8b_0.side_cap8b_1.buf_16_1.z vddr sg13_lv_pmos ad=0.19p pd=1.38u as=0.19p ps=1.38u w=1u l=0.13u
X1474 a_92188_96920# adc8b_0.sar12b_0.sg13cmos5l_dfrbp_1_16.Q sg13cmos5l_Corner_1.vss sg13cmos5l_Corner_1.vss sg13_lv_nmos ad=0.1406p pd=1.12u as=0.1406p ps=1.12u w=0.74u l=0.13u
X1475 vdd a_90879_95826# a_91010_95820# vdd sg13_lv_pmos ad=1.28962p pd=8.195u as=0.2856p ps=2.36u w=0.84u l=0.13u
X1476 sg13cmos5l_IOPadAnalog_1.pad a_164624_70044# sg13cmos5l_Corner_1.iovdd sg13cmos5l_Corner_1.iovdd sg13_hv_pmos ad=3.9294p pd=7.84u as=2.1312p ps=7.3u w=6.66u l=0.6u
X1477 vdd adc8b_0.sar12b_0.sg13cmos5l_dlhr_1_15.Q a_101008_98872# vdd sg13_lv_pmos ad=0.2114p pd=1.54u as=0.2856p ps=2.36u w=0.84u l=0.13u
X1478 vip a_30676_102044# sg13cmos5l_Corner_1.vss sg13cmos5l_Corner_1.vss sg13_hv_nmos ad=2.596p pd=5.58u as=1.408p ps=5.04u w=4.4u l=0.6u
X1479 vdd adc8b_0.sar12b_0.sg13cmos5l_dfrbp_1_8.RESET_B a_97550_98522# vdd sg13_lv_pmos ad=0.36237p pd=2.605u as=79.8f ps=0.8u w=0.42u l=0.13u
X1480 sg13cmos5l_Corner_1.vss adc8b_0.sar12b_0.sg13cmos5l_dfrbp_1_0.Q a_96022_93604# sg13cmos5l_Corner_1.vss sg13_lv_nmos ad=0.17255p pd=1.25u as=0.187p ps=1.78u w=0.55u l=0.13u
X1481 sg13cmos5l_Corner_1.vss adc8b_0.side_cap8b_0.in_h_sw[3] adc8b_0.side_cap8b_0.buf_8_3.z sg13cmos5l_Corner_1.vss sg13_lv_nmos ad=95f pd=0.88u as=95f ps=0.88u w=0.5u l=0.13u
X1482 sg13cmos5l_Corner_1.vss adc8b_0.sar12b_0.nh_sw[1] adc8b_0.side_cap8b_1.buf_16_3.z sg13cmos5l_Corner_1.vss sg13_lv_nmos ad=95f pd=0.88u as=0.17p ps=1.68u w=0.5u l=0.13u
X1483 adc8b_0.sar12b_0.sg13cmos5l_buf_1_5.X a_96208_92824# sg13cmos5l_Corner_1.vss sg13cmos5l_Corner_1.vss sg13_lv_nmos ad=0.2886p pd=2.26u as=0.14875p ps=1.16u w=0.74u l=0.13u
X1484 sg13cmos5l_IOPadAnalog_13.pad a_115639_178370# sg13cmos5l_Corner_1.vss sg13cmos5l_Corner_1.vss sg13_hv_nmos ad=2.596p pd=5.58u as=1.408p ps=5.04u w=4.4u l=0.6u
X1485 sg13cmos5l_Corner_1.vss sg13cmos5l_IOPadVdd$1_0.sg13cmos5l_RCClampInverter$1_0.in sg13cmos5l_Corner_1.vss sg13cmos5l_Corner_1.vss sg13_hv_nmos ad=1.71p pd=9.38u as=0 ps=0 w=9u l=9.5u
X1486 vdd a_84333_95071# a_84435_95071# vdd sg13_lv_pmos ad=1.43437p pd=9.105u as=0.3864p ps=2.93u w=1.12u l=0.13u
X1487 adc8b_0.side_cap8b_1.buf_32_0.z adc8b_0.sar12b_0.nl_sw[0] sg13cmos5l_Corner_1.vss sg13cmos5l_Corner_1.vss sg13_lv_nmos ad=95f pd=0.88u as=95f ps=0.88u w=0.5u l=0.13u
X1488 sg13cmos5l_Corner_1.vss a_90932_92750# adc8b_0.sar12b_0.sg13cmos5l_buf_1_26.X sg13cmos5l_Corner_1.vss sg13_lv_nmos ad=0.14875p pd=1.16u as=0.2886p ps=2.26u w=0.74u l=0.13u
X1489 a_88863_92802# adc8b_0.sar12b_0.sg13cmos5l_dlhr_1_0.GATE sg13cmos5l_Corner_1.vss sg13cmos5l_Corner_1.vss sg13_lv_nmos ad=0.2516p pd=2.16u as=0.15055p ps=1.17u w=0.74u l=0.13u
X1490 sg13cmos5l_Corner_1.vss a_87092_92750# adc8b_0.sar12b_0.sg13cmos5l_buf_1_39.A sg13cmos5l_Corner_1.vss sg13_lv_nmos ad=0.14875p pd=1.16u as=0.2886p ps=2.26u w=0.74u l=0.13u
X1491 sg13cmos5l_IOPadAnalog_12.pad a_131639_178370# sg13cmos5l_Corner_1.vss sg13cmos5l_Corner_1.vss sg13_hv_nmos ad=2.596p pd=5.58u as=1.408p ps=5.04u w=4.4u l=0.6u
X1492 frame a_134044_42476# sg13cmos5l_Corner_1.iovdd sg13cmos5l_Corner_1.iovdd sg13_hv_pmos ad=3.9294p pd=7.84u as=2.1312p ps=7.3u w=6.66u l=0.6u
X1493 vddr adc8b_0.sar12b_0.nh_sw[3] adc8b_0.side_cap8b_1.buf_8_3.z vddr sg13_lv_pmos ad=0.19p pd=1.38u as=0.19p ps=1.38u w=1u l=0.13u
X1494 a_91839_98442# adc8b_0.sar12b_0.sg13cmos5l_dfrbp_1_18.Q vdd vdd sg13_lv_pmos ad=0.3234p pd=2.45u as=1.07253p ps=6.75u w=0.84u l=0.13u
X1495 adc8b_0.side_cap8b_0.buf_32_1.z adc8b_0.side_cap8b_0.in_h_sw[0] sg13cmos5l_Corner_1.vss sg13cmos5l_Corner_1.vss sg13_lv_nmos ad=95f pd=0.88u as=95f ps=0.88u w=0.5u l=0.13u
X1496 a_89976_98084# a_89425_98442# vdd vdd sg13_lv_pmos ad=0.105p pd=1.21u as=1.07253p ps=6.75u w=1u l=0.13u
X1497 sg13cmos5l_Corner_1.iovdd a_67639_164698# sg13cmos5l_IOPadAnalog_10.pad sg13cmos5l_Corner_1.iovdd sg13_hv_pmos ad=2.1312p pd=7.3u as=3.9294p ps=7.84u w=6.66u l=0.6u
X1498 sg13cmos5l_Corner_1.vss sg13cmos5l_IOPadVdd$1_0.sg13cmos5l_RCClampInverter$1_0.in sg13cmos5l_Corner_1.vss sg13cmos5l_Corner_1.vss sg13_hv_nmos ad=1.71p pd=9.38u as=0 ps=0 w=9u l=9.5u
X1499 a_88823_95421# a_87981_95071# a_87564_95064# vdd sg13_lv_pmos ad=0.2048p pd=1.63u as=0.34p ps=2.68u w=1u l=0.13u
X1500 sg13cmos5l_Corner_1.vss adc8b_0.sar12b_0.sg13cmos5l_dfrbp_1_6.RESET_B a_83916_94298# sg13cmos5l_Corner_1.vss sg13_lv_nmos ad=0.1626p pd=1.415u as=60.89999f ps=0.71u w=0.42u l=0.13u
X1501 cko a_118044_30676# sg13cmos5l_Corner_1.vss sg13cmos5l_Corner_1.vss sg13_hv_nmos ad=2.596p pd=5.58u as=2.068p ps=9.74u w=4.4u l=0.6u
X1502 a_100984_94518# adc8b_0.sar12b_0.sg13cmos5l_dfrbp_1_0.RESET_B vdd vdd sg13_lv_pmos ad=79.8f pd=0.8u as=1.38655p ps=8.8u w=0.42u l=0.13u
X1503 sg13cmos5l_Corner_1.vss adc8b_0.sar12b_0.sg13cmos5l_buf_1_110.A a_97552_100384# sg13cmos5l_Corner_1.vss sg13_lv_nmos ad=0.14875p pd=1.16u as=0.187p ps=1.78u w=0.55u l=0.13u
X1504 vdd adc8b_0.sar12b_0.sg13cmos5l_dfrbp_1_6.RESET_B a_96494_98834# vdd sg13_lv_pmos ad=0.36237p pd=2.605u as=79.8f ps=0.8u w=0.42u l=0.13u
X1505 a_96513_94613# a_95571_94420# a_96311_94375# vdd sg13_lv_pmos ad=93.45f pd=0.865u as=0.2048p ps=1.63u w=0.42u l=0.13u
X1506 cko a_118044_42476# sg13cmos5l_Corner_1.iovdd sg13cmos5l_Corner_1.iovdd sg13_hv_pmos ad=3.9294p pd=7.84u as=2.1312p ps=7.3u w=6.66u l=0.6u
X1507 adc8b_0.sar12b_0.sg13cmos5l_dfrbp_1_23.Q a_96380_97620# vdd vdd sg13_lv_pmos ad=0.3808p pd=2.92u as=0.2128p ps=1.5u w=1.12u l=0.13u
X1508 adc8b_0.side_cap8b_1.buf_32_1.z adc8b_0.sar12b_0.nh_sw[0] sg13cmos5l_Corner_1.vss sg13cmos5l_Corner_1.vss sg13_lv_nmos ad=95f pd=0.88u as=95f ps=0.88u w=0.5u l=0.13u
X1509 sg13cmos5l_IOPadVdd$1_0.sg13cmos5l_Clamp_N43N43D4R$1_0.gate sg13cmos5l_IOPadVdd$1_0.sg13cmos5l_RCClampInverter$1_0.in vdd vdd sg13_hv_pmos ad=1.33p pd=7.38u as=1.33p ps=7.38u w=7u l=0.5u
X1510 sg13cmos5l_Corner_1.vss adc8b_0.side_cap8b_0.in_h_sw[1] adc8b_0.side_cap8b_0.buf_16_3.z sg13cmos5l_Corner_1.vss sg13_lv_nmos ad=95f pd=0.88u as=0.17p ps=1.68u w=0.5u l=0.13u
X1511 a_83716_99124# a_84116_98784# a_84074_98820# sg13cmos5l_Corner_1.vss sg13_lv_nmos ad=0.2516p pd=2.16u as=77.7f ps=0.95u w=0.74u l=0.13u
X1512 sg13cmos5l_Corner_1.vss a_67639_178370# sg13cmos5l_Corner_1.vss rppd l=3.54u w=0.5u
X1513 cks a_42476_118044# sg13cmos5l_Corner_1.iovdd sg13cmos5l_Corner_1.iovdd sg13_hv_pmos ad=3.9294p pd=7.84u as=2.1312p ps=7.3u w=6.66u l=0.6u
X1514 adc8b_0.sar12b_0.sg13cmos5l_dfrbp_1_4.Q_N a_94487_93909# sg13cmos5l_Corner_1.vss sg13cmos5l_Corner_1.vss sg13_lv_nmos ad=0.2849p pd=2.25u as=0.2516p ps=2.16u w=0.74u l=0.13u
X1515 sg13cmos5l_Corner_1.vss sg13cmos5l_IOPadVdd$1_0.sg13cmos5l_Clamp_N43N43D4R$1_0.gate vdd sg13cmos5l_Corner_1.vss sg13_hv_nmos ad=1.408p pd=5.04u as=3.256p ps=10.28u w=4.4u l=0.6u
X1516 adc8b_0.side_cap8b_0.buf_32_0.z adc8b_0.side_cap8b_0.in_l_sw[0] vddr vddr sg13_lv_pmos ad=0.19p pd=1.38u as=0.19p ps=1.38u w=1u l=0.13u
X1517 adc8b_0.diff_bsw_0.single_bsw_0.sg13cmos5l_inv_1$1_2.Y adc8b_0.diff_bsw_0.single_bsw_0.sg13cmos5l_inv_1$1_2.A vdd vdd sg13_lv_pmos ad=0.3808p pd=2.92u as=0.3808p ps=2.92u w=1.12u l=0.13u
X1518 adc8b_0.cmp_0.rdy a_80806_96705# sg13cmos5l_Corner_1.vss sg13cmos5l_Corner_1.vss sg13_lv_nmos ad=0.2516p pd=2.16u as=0.1426p ps=1.16u w=0.74u l=0.13u
X1519 vddr adc8b_0.sar12b_0.nh_sw[4] adc8b_0.side_cap8b_1.buf_8_2.z vddr sg13_lv_pmos ad=0.19p pd=1.38u as=0.19p ps=1.38u w=1u l=0.13u
X1520 adc8b_0.side_cap8b_0.buf_4_0.z adc8b_0.side_cap8b_0.in_l_sw[7] sg13cmos5l_Corner_1.vss sg13cmos5l_Corner_1.vss sg13_lv_nmos ad=95f pd=0.88u as=95f ps=0.88u w=0.5u l=0.13u
X1521 vdd adc8b_0.sar12b_0.sg13cmos5l_dlhr_1_15.D a_99313_98888# vdd sg13_lv_pmos ad=1.15047p pd=7.175u as=0.2856p ps=2.36u w=0.84u l=0.13u
X1522 vdd sg13cmos5l_IOPadVdd$1_0.sg13cmos5l_Clamp_N43N43D4R$1_0.gate sg13cmos5l_Corner_1.vss sg13cmos5l_Corner_1.vss sg13_hv_nmos ad=2.596p pd=5.58u as=1.408p ps=5.04u w=4.4u l=0.6u
X1523 sg13cmos5l_Corner_1.vss adc8b_0.sar12b_0.sg13cmos5l_dfrbp_1_23.Q a_95560_96920# sg13cmos5l_Corner_1.vss sg13_lv_nmos ad=0.1406p pd=1.12u as=0.1406p ps=1.12u w=0.74u l=0.13u
X1524 a_98894_92786# a_99699_92908# a_99154_93009# vdd sg13_lv_pmos ad=0.1428p pd=1.52u as=79.8f ps=0.8u w=0.42u l=0.13u
X1525 sg13cmos5l_Corner_1.iovdd a_102044_42476# data[2] sg13cmos5l_Corner_1.iovdd sg13_hv_pmos ad=2.1312p pd=7.3u as=3.9294p ps=7.84u w=6.66u l=0.6u
X1526 a_95543_97399# a_94701_97301# a_95449_97399# sg13cmos5l_Corner_1.vss sg13_lv_nmos ad=0.12665p pd=1.145u as=0.1428p ps=1.52u w=0.42u l=0.13u
X1527 adc8b_0.side_cap8b_0.buf_16_2.z adc8b_0.side_cap8b_0.in_l_sw[1] sg13cmos5l_Corner_1.vss sg13cmos5l_Corner_1.vss sg13_lv_nmos ad=0.17p pd=1.68u as=95f ps=0.88u w=0.5u l=0.13u
X1528 sg13cmos5l_Corner_1.vss adc8b_0.sar12b_0.sg13cmos5l_dfrbp_1_6.RESET_B a_92476_100332# sg13cmos5l_Corner_1.vss sg13_lv_nmos ad=0.1406p pd=1.12u as=77.7f ps=0.95u w=0.74u l=0.13u
X1529 a_83822_94298# a_84627_94420# a_84082_94521# vdd sg13_lv_pmos ad=0.1428p pd=1.52u as=79.8f ps=0.8u w=0.42u l=0.13u
X1530 adc8b_0.sar12b_0.sg13cmos5l_buf_8_2.X a_100995_100350# vdd vdd sg13_lv_pmos ad=0.2128p pd=1.5u as=0.2128p ps=1.5u w=1.12u l=0.13u
X1531 data[0] a_70044_42476# sg13cmos5l_Corner_1.iovdd sg13cmos5l_Corner_1.iovdd sg13_hv_pmos ad=3.9294p pd=7.84u as=2.1312p ps=7.3u w=6.66u l=0.6u
X1532 a_83252_97286# adc8b_0.sar12b_0.sg13cmos5l_buf_1_58.A vdd vdd sg13_lv_pmos ad=0.2856p pd=2.36u as=0.2114p ps=1.54u w=0.84u l=0.13u
X1533 a_101180_97644# a_100898_97332# a_101113_97314# sg13cmos5l_Corner_1.vss sg13_lv_nmos ad=0.141p pd=1.17u as=71.99999f ps=0.865u w=0.64u l=0.13u
X1534 a_97617_93595# a_97260_93552# vdd vdd sg13_lv_pmos ad=63f pd=0.72u as=0.1563p ps=1.22u w=0.42u l=0.13u
X1535 sg13cmos5l_IOPadAnalog_9.pad a_83639_178370# sg13cmos5l_Corner_1.vss sg13cmos5l_Corner_1.vss sg13_hv_nmos ad=2.596p pd=5.58u as=1.408p ps=5.04u w=4.4u l=0.6u
X1536 sg13cmos5l_Corner_1.iovdd a_42476_118044# cks sg13cmos5l_Corner_1.iovdd sg13_hv_pmos ad=2.1312p pd=7.3u as=3.9294p ps=7.84u w=6.66u l=0.6u
X1537 adc8b_0.sar12b_0.sg13cmos5l_dfrbp_1_1.D adc8b_0.sar12b_0.sg13cmos5l_a22oi_1_2.B1 a_91591_93524# vdd sg13_lv_pmos ad=0.2128p pd=1.5u as=0.2716p ps=1.605u w=1.12u l=0.13u
X1538 vin a_42476_86044# sg13cmos5l_Corner_1.iovdd sg13cmos5l_Corner_1.iovdd sg13_hv_pmos ad=3.9294p pd=7.84u as=3.1302p ps=14.26u w=6.66u l=0.6u
X1539 sg13cmos5l_Corner_1.vss adc8b_0.side_cap8b_0.in_h_sw[6] adc8b_0.side_cap8b_0.buf_4_1.z sg13cmos5l_Corner_1.vss sg13_lv_nmos ad=95f pd=0.88u as=0.17p ps=1.68u w=0.5u l=0.13u
X1540 a_86126_98084# a_85730_98448# a_86012_98084# vdd sg13_lv_pmos ad=0.1008p pd=0.9u as=0.191p ps=1.44u w=0.42u l=0.13u
X1541 cko a_118044_42476# sg13cmos5l_Corner_1.iovdd sg13cmos5l_Corner_1.iovdd sg13_hv_pmos ad=3.9294p pd=7.84u as=2.1312p ps=7.3u w=6.66u l=0.6u
X1542 a_96974_93986# adc8b_0.sar12b_0.sg13cmos5l_nor2b_1_1.Y vdd vdd sg13_lv_pmos ad=79.8f pd=0.8u as=0.1428p ps=1.52u w=0.42u l=0.13u
X1543 adc8b_0.sar12b_0.sg13cmos5l_buf_1_65.X a_82192_99596# vdd vdd sg13_lv_pmos ad=0.42p pd=2.99u as=0.2114p ps=1.54u w=1.12u l=0.13u
X1544 vdd sg13cmos5l_Corner_1.vss vdd vdd sg13_lv_pmos ad=0.34p pd=2.68u as=0 ps=0 w=1u l=1u
X1545 vdd sg13cmos5l_IOPadVdd$1_0.sg13cmos5l_Clamp_N43N43D4R$1_0.gate sg13cmos5l_Corner_1.vss sg13cmos5l_Corner_1.vss sg13_hv_nmos ad=2.596p pd=5.58u as=1.408p ps=5.04u w=4.4u l=0.6u
X1546 a_84204_100021# a_84435_99607# a_83890_99564# sg13cmos5l_Corner_1.vss sg13_lv_nmos ad=0.2373p pd=1.97u as=79.8f ps=0.8u w=0.42u l=0.13u
X1547 sg13cmos5l_Corner_1.vss a_98039_98911# a_98876_99132# sg13cmos5l_Corner_1.vss sg13_lv_nmos ad=0.1406p pd=1.12u as=0.2516p ps=2.16u w=0.74u l=0.13u
X1548 sg13cmos5l_Corner_1.vss sg13cmos5l_IOPadVdd$1_0.sg13cmos5l_Clamp_N43N43D4R$1_0.gate vdd sg13cmos5l_Corner_1.vss sg13_hv_nmos ad=2.068p pd=9.74u as=2.596p ps=5.58u w=4.4u l=0.6u
X1549 sg13cmos5l_Corner_1.vss a_131639_178370# sg13cmos5l_IOPadAnalog_12.pad sg13cmos5l_Corner_1.vss sg13_hv_nmos ad=1.408p pd=5.04u as=2.596p ps=5.58u w=4.4u l=0.6u
X1550 a_90620_97644# a_90207_97338# a_90552_97644# vdd sg13_lv_pmos ad=0.191p pd=1.44u as=0.105p ps=1.21u w=1u l=0.13u
X1551 a_89818_95810# adc8b_0.sar12b_0.sg13cmos5l_dfrbp_1_8.RESET_B sg13cmos5l_Corner_1.vss sg13cmos5l_Corner_1.vss sg13_lv_nmos ad=37.8f pd=0.6u as=79.8f ps=0.8u w=0.42u l=0.13u
X1552 vdd a_100995_95814# adc8b_0.sar12b_0.sg13cmos5l_buf_8_0.X vdd sg13_lv_pmos ad=0.2128p pd=1.5u as=0.2128p ps=1.5u w=1.12u l=0.13u
X1553 vdd sg13cmos5l_IOPadVdd$1_0.sg13cmos5l_Clamp_N43N43D4R$1_0.gate sg13cmos5l_Corner_1.vss sg13cmos5l_Corner_1.vss sg13_hv_nmos ad=2.596p pd=5.58u as=1.408p ps=5.04u w=4.4u l=0.6u
X1554 sg13cmos5l_Corner_1.vss adc8b_0.sar12b_0.sg13cmos5l_buf_1_18.A a_100144_93548# sg13cmos5l_Corner_1.vss sg13_lv_nmos ad=0.14875p pd=1.16u as=0.187p ps=1.78u w=0.55u l=0.13u
X1555 a_94744_93790# a_94487_93909# a_94906_93986# sg13cmos5l_Corner_1.vss sg13_lv_nmos ad=0.1428p pd=1.52u as=37.8f ps=0.6u w=0.42u l=0.13u
X1556 a_82764_98509# a_82476_98088# a_82702_98509# sg13cmos5l_Corner_1.vss sg13_lv_nmos ad=0.1428p pd=1.52u as=37.8f ps=0.6u w=0.42u l=0.13u
X1557 w_71686_98280# a_68824_97392# vdd sg13cmos5l_Corner_1.vss sg13_lv_nmos ad=0.442p pd=3.28u as=0.442p ps=3.28u w=1.3u l=0.13u
X1558 sg13cmos5l_IOPadAnalog_15.padres sg13cmos5l_Corner_1.iovdd dpantenna l=0.64u w=4.98u
X1559 adc8b_0.sar12b_0.sg13cmos5l_dlhr_1_5.Q a_90225_98441# vdd vdd sg13_lv_pmos ad=0.3808p pd=2.92u as=0.2128p ps=1.5u w=1.12u l=0.13u
X1560 sg13cmos5l_Corner_1.vss adc8b_0.sar12b_0.sg13cmos5l_dfrbp_1_6.RESET_B a_86796_93986# sg13cmos5l_Corner_1.vss sg13_lv_nmos ad=0.1626p pd=1.415u as=60.89999f ps=0.71u w=0.42u l=0.13u
X1561 sg13cmos5l_Corner_1.vss sg13cmos5l_Corner_1.iovdd dpantenna l=1.26u w=27.78u
X1562 a_95254_96920# adc8b_0.sar12b_0.sg13cmos5l_nor2b_1_0.Y sg13cmos5l_Corner_1.vss sg13cmos5l_Corner_1.vss sg13_lv_nmos ad=0.1406p pd=1.12u as=0.2516p ps=2.16u w=0.74u l=0.13u
X1563 sg13cmos5l_IOPadAnalog_11.pad a_178296_118044# sg13cmos5l_Corner_1.vss sg13cmos5l_Corner_1.vss sg13_hv_nmos ad=2.596p pd=5.58u as=1.408p ps=5.04u w=4.4u l=0.6u
X1564 a_94583_92863# a_93741_92765# a_93324_93104# vdd sg13_lv_pmos ad=0.2048p pd=1.63u as=0.34p ps=2.68u w=1u l=0.13u
X1565 sg13cmos5l_Corner_1.vss a_178296_70044# sg13cmos5l_IOPadAnalog_1.pad sg13cmos5l_Corner_1.vss sg13_hv_nmos ad=1.408p pd=5.04u as=2.596p ps=5.58u w=4.4u l=0.6u
X1566 adc8b_0.sar12b_0.sg13cmos5l_dfrbp_1_3.Q_N a_100727_94375# sg13cmos5l_Corner_1.vss sg13cmos5l_Corner_1.vss sg13_lv_nmos ad=0.2849p pd=2.25u as=0.2516p ps=2.16u w=0.74u l=0.13u
X1567 a_99167_95107# adc8b_0.sar12b_0.sg13cmos5l_dfrbp_1_6.D a_99914_95498# sg13cmos5l_Corner_1.vss sg13_lv_nmos ad=0.1428p pd=1.52u as=60.89999f ps=0.71u w=0.42u l=0.13u
X1568 sg13cmos5l_Corner_1.iovdd a_42476_86044# vin sg13cmos5l_Corner_1.iovdd sg13_hv_pmos ad=2.1312p pd=7.3u as=3.9294p ps=7.84u w=6.66u l=0.6u
X1569 sg13cmos5l_Corner_1.vss sg13cmos5l_IOPadAnalog_12.padres dantenna l=3.1u w=0.64u
X1570 vdd adc8b_0.sar12b_0.sg13cmos5l_buf_1_30.A adc8b_0.sar12b_0.sg13cmos5l_buf_1_73.A vdd sg13_lv_pmos ad=0.3808p pd=2.92u as=0.3808p ps=2.92u w=1.12u l=0.13u
X1571 a_99160_96030# adc8b_0.sar12b_0.sg13cmos5l_dfrbp_1_8.RESET_B vdd vdd sg13_lv_pmos ad=79.8f pd=0.8u as=1.2517p ps=7.955u w=0.42u l=0.13u
X1572 adc8b_0.sar12b_0.sg13cmos5l_o21ai_1_0.Y adc8b_0.sar12b_0.sg13cmos5l_o21ai_1_0.A2 a_93888_94616# vdd sg13_lv_pmos ad=0.2128p pd=1.5u as=0.2128p ps=1.5u w=1.12u l=0.15u
X1573 adc8b_0.side_cap8b_0.buf_32_1.z adc8b_0.side_cap8b_0.in_h_sw[0] sg13cmos5l_Corner_1.vss sg13cmos5l_Corner_1.vss sg13_lv_nmos ad=95f pd=0.88u as=95f ps=0.88u w=0.5u l=0.13u
X1574 sg13cmos5l_Corner_1.iovdd a_42476_102044# vip sg13cmos5l_Corner_1.iovdd sg13_hv_pmos ad=3.1302p pd=14.26u as=3.9294p ps=7.84u w=6.66u l=0.6u
X1575 sg13cmos5l_Corner_1.vss adc8b_0.sar12b_0.nl_sw[0] adc8b_0.side_cap8b_1.buf_32_0.z sg13cmos5l_Corner_1.vss sg13_lv_nmos ad=95f pd=0.88u as=95f ps=0.88u w=0.5u l=0.13u
X1576 a_88113_99643# a_87756_99600# vdd vdd sg13_lv_pmos ad=63f pd=0.72u as=0.1563p ps=1.22u w=0.42u l=0.13u
X1577 a_90957_99607# adc8b_0.sar12b_0.sg13cmos5l_inv_1_2.A sg13cmos5l_Corner_1.vss sg13cmos5l_Corner_1.vss sg13_lv_nmos ad=0.2516p pd=2.16u as=2.71505p ps=17.54u w=0.74u l=0.13u
X1578 sg13cmos5l_Corner_1.vss cks adc8b_0.sar12b_0.sg13cmos5l_dfrbp_1_0.RESET_B sg13cmos5l_Corner_1.vss sg13_lv_nmos ad=0.2516p pd=2.16u as=0.2516p ps=2.16u w=0.74u l=0.13u
X1579 vddr adc8b_0.side_cap8b_0.in_h_sw[5] adc8b_0.side_cap8b_0.buf_8_5.z vddr sg13_lv_pmos ad=0.19p pd=1.38u as=0.19p ps=1.38u w=1u l=0.13u
X1580 vdd a_96657_98441# a_96590_98084# vdd sg13_lv_pmos ad=0.2387p pd=1.84u as=0.1008p ps=0.9u w=0.42u l=0.13u
X1581 sg13cmos5l_Corner_1.vss sg13cmos5l_IOPadVdd$1_0.sg13cmos5l_Clamp_N43N43D4R$1_0.gate vdd sg13cmos5l_Corner_1.vss sg13_hv_nmos ad=1.408p pd=5.04u as=2.596p ps=5.58u w=4.4u l=0.6u
X1582 adc8b_0.cmp_0.outp adc8b_0.cmp_0.outn a_73970_98361# sg13cmos5l_Corner_1.vss sg13_lv_nmos ad=0.95p pd=5.38u as=1.7p ps=10.68u w=5u l=0.13u
X1583 sg13cmos5l_Corner_1.vss a_96351_96930# a_96482_96936# sg13cmos5l_Corner_1.vss sg13_lv_nmos ad=1.97045p pd=12.335u as=0.2775p ps=2.23u w=0.74u l=0.13u
X1584 sg13cmos5l_Corner_1.iovdd a_134044_42476# frame sg13cmos5l_Corner_1.iovdd sg13_hv_pmos ad=2.1312p pd=7.3u as=3.9294p ps=7.84u w=6.66u l=0.6u
X1585 sg13cmos5l_Corner_1.vss a_178296_118044# sg13cmos5l_IOPadAnalog_11.pad sg13cmos5l_Corner_1.vss sg13_hv_nmos ad=1.408p pd=5.04u as=2.596p ps=5.58u w=4.4u l=0.6u
X1586 a_96730_94298# adc8b_0.sar12b_0.sg13cmos5l_dfrbp_1_0.RESET_B sg13cmos5l_Corner_1.vss sg13cmos5l_Corner_1.vss sg13_lv_nmos ad=37.8f pd=0.6u as=79.8f ps=0.8u w=0.42u l=0.13u
X1587 sg13cmos5l_Corner_1.vss a_30676_70044# vddr sg13cmos5l_Corner_1.vss sg13_hv_nmos ad=1.408p pd=5.04u as=2.596p ps=5.58u w=4.4u l=0.6u
X1588 vddr adc8b_0.side_cap8b_0.in_h_sw[0] adc8b_0.side_cap8b_0.buf_32_1.z vddr sg13_lv_pmos ad=0.19p pd=1.38u as=0.19p ps=1.38u w=1u l=0.13u
X1589 a_90158_98084# a_89762_98448# a_90044_98084# vdd sg13_lv_pmos ad=0.1008p pd=0.9u as=0.191p ps=1.44u w=0.42u l=0.13u
X1590 vdd adc8b_0.sar12b_0.sg13cmos5l_buf_8_0.A a_100995_95814# vdd sg13_lv_pmos ad=0.2128p pd=1.5u as=0.2128p ps=1.5u w=1.12u l=0.13u
X1591 cko a_118044_42476# sg13cmos5l_Corner_1.iovdd sg13cmos5l_Corner_1.iovdd sg13_hv_pmos ad=3.9294p pd=7.84u as=2.1312p ps=7.3u w=6.66u l=0.6u
X1592 adc8b_0.sar12b_0.sg13cmos5l_buf_1_4.X a_98320_92824# sg13cmos5l_Corner_1.vss sg13cmos5l_Corner_1.vss sg13_lv_nmos ad=0.2886p pd=2.26u as=0.14875p ps=1.16u w=0.74u l=0.13u
X1593 vin a_30676_86044# sg13cmos5l_Corner_1.vss sg13cmos5l_Corner_1.vss sg13_hv_nmos ad=2.596p pd=5.58u as=1.408p ps=5.04u w=4.4u l=0.6u
X1594 sg13cmos5l_Corner_1.vss a_100767_97338# a_100898_97332# sg13cmos5l_Corner_1.vss sg13_lv_nmos ad=1.97045p pd=12.335u as=0.2775p ps=2.23u w=0.74u l=0.13u
X1595 a_90015_96930# adc8b_0.sar12b_0.sg13cmos5l_dfrbp_1_11.Q sg13cmos5l_Corner_1.vss sg13cmos5l_Corner_1.vss sg13_lv_nmos ad=0.2516p pd=2.16u as=0.15055p ps=1.17u w=0.74u l=0.13u
X1596 sg13cmos5l_IOPadAnalog_13.pad a_115639_178370# sg13cmos5l_Corner_1.vss sg13cmos5l_Corner_1.vss sg13_hv_nmos ad=2.596p pd=5.58u as=1.408p ps=5.04u w=4.4u l=0.6u
X1597 adc8b_0.diff_bsw_0.single_bsw_0.sg13cmos5l_inv_1$1_0.Y adc8b_0.diff_bsw_0.single_bsw_0.sg13cmos5l_inv_1$1_0.A sg13cmos5l_Corner_1.vss sg13cmos5l_Corner_1.vss sg13_lv_nmos ad=0.2516p pd=2.16u as=0.2516p ps=2.16u w=0.74u l=0.13u
X1598 adc8b_0.side_cap8b_1.buf_8_5.z adc8b_0.sar12b_0.nh_sw[5] sg13cmos5l_Corner_1.vss sg13cmos5l_Corner_1.vss sg13_lv_nmos ad=95f pd=0.88u as=95f ps=0.88u w=0.5u l=0.13u
X1599 a_87276_93973# a_86988_93552# a_87214_93973# sg13cmos5l_Corner_1.vss sg13_lv_nmos ad=0.1428p pd=1.52u as=37.8f ps=0.6u w=0.42u l=0.13u
X1600 sg13cmos5l_Corner_1.iovdd a_99639_164698# sg13cmos5l_IOPadAnalog_15.pad sg13cmos5l_Corner_1.iovdd sg13_hv_pmos ad=2.1312p pd=7.3u as=3.9294p ps=7.84u w=6.66u l=0.6u
X1601 sg13cmos5l_Corner_1.vss adc8b_0.sar12b_0.sg13cmos5l_dlhr_1_1.GATE a_86117_98796# sg13cmos5l_Corner_1.vss sg13_lv_nmos ad=0.15055p pd=1.17u as=0.2516p ps=2.16u w=0.74u l=0.13u
X1602 adc8b_0.side_cap8b_1.buf_32_0.z adc8b_0.sar12b_0.nl_sw[0] vddr vddr sg13_lv_pmos ad=0.19p pd=1.38u as=0.19p ps=1.38u w=1u l=0.13u
X1603 adc8b_0.sar12b_0.nh_sw[3] a_87472_92824# sg13cmos5l_Corner_1.vss sg13cmos5l_Corner_1.vss sg13_lv_nmos ad=0.2886p pd=2.26u as=0.14875p ps=1.16u w=0.74u l=0.13u
X1604 sg13cmos5l_Corner_1.iovdd a_42476_70044# vddr sg13cmos5l_Corner_1.iovdd sg13_hv_pmos ad=2.1312p pd=7.3u as=3.9294p ps=7.84u w=6.66u l=0.6u
X1605 adc8b_0.sar12b_0.sg13cmos5l_inv_1_1.A a_96976_97360# sg13cmos5l_Corner_1.vss sg13cmos5l_Corner_1.vss sg13_lv_nmos ad=0.2886p pd=2.26u as=0.14875p ps=1.16u w=0.74u l=0.13u
X1606 data[1] a_86044_30676# sg13cmos5l_Corner_1.vss sg13cmos5l_Corner_1.vss sg13_hv_nmos ad=2.596p pd=5.58u as=1.408p ps=5.04u w=4.4u l=0.6u
X1607 vdd adc8b_0.sar12b_0.sg13cmos5l_dfrbp_1_8.RESET_B a_90254_100034# vdd sg13_lv_pmos ad=0.36237p pd=2.605u as=79.8f ps=0.8u w=0.42u l=0.13u
X1608 sg13cmos5l_Corner_1.iovdd a_164624_102044# sg13cmos5l_IOPadAnalog_16.pad sg13cmos5l_Corner_1.iovdd sg13_hv_pmos ad=2.1312p pd=7.3u as=3.9294p ps=7.84u w=6.66u l=0.6u
X1609 sg13cmos5l_Corner_1.vss adc8b_0.sar12b_0.sg13cmos5l_dlhr_1_0.D a_88657_92840# sg13cmos5l_Corner_1.vss sg13_lv_nmos ad=0.15055p pd=1.17u as=0.187p ps=1.78u w=0.55u l=0.13u
X1610 sg13cmos5l_IOPadVdd$1_0.sg13cmos5l_Clamp_N43N43D4R$1_0.gate sg13cmos5l_IOPadVdd$1_0.sg13cmos5l_RCClampInverter$1_0.in vdd vdd sg13_hv_pmos ad=1.33p pd=7.38u as=1.33p ps=7.38u w=7u l=0.5u
X1611 sg13cmos5l_Corner_1.vss a_134222_33862# dantenna l=1.26u w=27.78u
X1612 vddr adc8b_0.side_cap8b_0.in_l_sw[0] adc8b_0.side_cap8b_0.buf_32_0.z vddr sg13_lv_pmos ad=0.19p pd=1.38u as=0.34p ps=2.68u w=1u l=0.13u
X1613 adc8b_0.sar12b_0.sg13cmos5l_buf_1_107.X a_99664_100384# vdd vdd sg13_lv_pmos ad=0.42p pd=2.99u as=0.2114p ps=1.54u w=1.12u l=0.13u
X1614 vip a_42476_102044# sg13cmos5l_Corner_1.iovdd sg13cmos5l_Corner_1.iovdd sg13_hv_pmos ad=3.9294p pd=7.84u as=2.1312p ps=7.3u w=6.66u l=0.6u
X1615 adc8b_0.sar12b_0.sg13cmos5l_dfrbp_1_24.Q_N a_95159_100423# vdd vdd sg13_lv_pmos ad=0.4312p pd=3.01u as=0.2639p ps=1.81u w=1.12u l=0.13u
X1616 adc8b_0.sar12b_0.sg13cmos5l_buf_8_2.X a_100995_100350# vdd vdd sg13_lv_pmos ad=0.2128p pd=1.5u as=0.2128p ps=1.5u w=1.12u l=0.13u
X1617 vdd adc8b_0.sar12b_0.sg13cmos5l_dfrbp_1_10.Q a_86641_94352# vdd sg13_lv_pmos ad=1.43437p pd=9.105u as=0.2856p ps=2.36u w=0.84u l=0.13u
X1618 adc8b_0.sar12b_0.sg13cmos5l_dlhr_1_0.Q a_89457_92786# vdd vdd sg13_lv_pmos ad=0.3808p pd=2.92u as=0.2128p ps=1.5u w=1.12u l=0.13u
X1619 a_93202_93516# a_93645_93559# a_93585_93595# vdd sg13_lv_pmos ad=79.8f pd=0.8u as=63f ps=0.72u w=0.42u l=0.13u
X1620 adc8b_0.sar12b_0.sg13cmos5l_dlhr_1_11.Q a_94929_98441# sg13cmos5l_Corner_1.vss sg13cmos5l_Corner_1.vss sg13_lv_nmos ad=0.2516p pd=2.16u as=0.1406p ps=1.12u w=0.74u l=0.13u
X1621 vdd a_92180_97286# adc8b_0.sar12b_0.sg13cmos5l_buf_1_29.A vdd sg13_lv_pmos ad=0.2114p pd=1.54u as=0.42p ps=2.99u w=1.12u l=0.13u
X1622 cko a_118044_30676# sg13cmos5l_Corner_1.vss sg13cmos5l_Corner_1.vss sg13_hv_nmos ad=2.596p pd=5.58u as=1.408p ps=5.04u w=4.4u l=0.6u
X1623 adc8b_0.side_cap8b_1.buf_4_0.z adc8b_0.sar12b_0.nl_sw[7] vddr vddr sg13_lv_pmos ad=0.19p pd=1.38u as=0.19p ps=1.38u w=1u l=0.13u
X1624 sg13cmos5l_Corner_1.vss adc8b_0.sar12b_0.nl_sw[2] adc8b_0.side_cap8b_1.buf_16_1.z sg13cmos5l_Corner_1.vss sg13_lv_nmos ad=95f pd=0.88u as=95f ps=0.88u w=0.5u l=0.13u
X1625 sg13cmos5l_Corner_1.vss a_30676_86044# vin sg13cmos5l_Corner_1.vss sg13_hv_nmos ad=1.408p pd=5.04u as=2.596p ps=5.58u w=4.4u l=0.6u
X1626 vdd adc8b_0.sar12b_0.sg13cmos5l_buf_1_40.A a_82960_92824# vdd sg13_lv_pmos ad=0.2114p pd=1.54u as=0.2856p ps=2.36u w=0.84u l=0.13u
X1627 sg13cmos5l_Corner_1.vss adc8b_0.side_cap8b_0.in_l_sw[1] adc8b_0.side_cap8b_0.buf_16_2.z sg13cmos5l_Corner_1.vss sg13_lv_nmos ad=95f pd=0.88u as=95f ps=0.88u w=0.5u l=0.13u
X1628 sg13cmos5l_Corner_1.vss adc8b_0.sar12b_0.sg13cmos5l_dfrbp_1_6.RESET_B a_100348_98820# sg13cmos5l_Corner_1.vss sg13_lv_nmos ad=0.1406p pd=1.12u as=77.7f ps=0.95u w=0.74u l=0.13u
X1629 sg13cmos5l_Corner_1.vss a_178296_102044# sg13cmos5l_IOPadAnalog_16.pad sg13cmos5l_Corner_1.vss sg13_hv_nmos ad=2.068p pd=9.74u as=2.596p ps=5.58u w=4.4u l=0.6u
X1630 vdd sg13cmos5l_IOPadVdd$1_0.sg13cmos5l_Clamp_N43N43D4R$1_0.gate sg13cmos5l_Corner_1.vss sg13cmos5l_Corner_1.vss sg13_hv_nmos ad=2.596p pd=5.58u as=1.408p ps=5.04u w=4.4u l=0.6u
X1631 sg13cmos5l_Corner_1.vss a_89272_99838# a_88921_99957# sg13cmos5l_Corner_1.vss sg13_lv_nmos ad=79.8f pd=0.8u as=0.1428p ps=1.52u w=0.42u l=0.13u
X1632 sg13cmos5l_Corner_1.vss adc8b_0.sar12b_0.sg13cmos5l_dfrbp_1_6.RESET_B a_95644_98820# sg13cmos5l_Corner_1.vss sg13_lv_nmos ad=0.1406p pd=1.12u as=77.7f ps=0.95u w=0.74u l=0.13u
X1633 vdd adc8b_0.sar12b_0.sg13cmos5l_dfrbp_1_6.RESET_B a_97972_95498# vdd sg13_lv_pmos ad=1.38655p pd=8.8u as=79.8f ps=0.8u w=0.42u l=0.13u
X1634 adc8b_0.sar12b_0.nh_sw[1] a_84592_93548# vdd vdd sg13_lv_pmos ad=0.42p pd=2.99u as=0.2114p ps=1.54u w=1.12u l=0.13u
X1635 vdd a_94840_93006# a_94785_93101# vdd sg13_lv_pmos ad=1.86162p pd=11.935u as=93.45f ps=0.865u w=0.42u l=0.13u
X1636 adc8b_0.side_cap8b_0.buf_16_1.z adc8b_0.side_cap8b_0.in_l_sw[2] vddr vddr sg13_lv_pmos ad=0.19p pd=1.38u as=0.19p ps=1.38u w=1u l=0.13u
X1637 adc8b_0.sar12b_0.sg13cmos5l_dfrbp_1_20.Q_N a_90551_98911# sg13cmos5l_Corner_1.vss sg13cmos5l_Corner_1.vss sg13_lv_nmos ad=0.2849p pd=2.25u as=0.2516p ps=2.16u w=0.74u l=0.13u
X1638 sg13cmos5l_Corner_1.vss adc8b_0.sar12b_0.sg13cmos5l_dfrbp_1_6.RESET_B a_96588_98834# sg13cmos5l_Corner_1.vss sg13_lv_nmos ad=0.1626p pd=1.415u as=60.89999f ps=0.71u w=0.42u l=0.13u
X1639 a_83916_99600# a_84435_99607# a_85175_99957# sg13cmos5l_Corner_1.vss sg13_lv_nmos ad=0.3473p pd=2.71u as=0.12665p ps=1.145u w=0.74u l=0.13u
X1640 sg13cmos5l_Corner_1.iovdd a_70044_42476# data[0] sg13cmos5l_Corner_1.iovdd sg13_hv_pmos ad=2.1312p pd=7.3u as=3.9294p ps=7.84u w=6.66u l=0.6u
X1641 vddr adc8b_0.sar12b_0.nl_sw[5] adc8b_0.side_cap8b_1.buf_8_4.z vddr sg13_lv_pmos ad=0.19p pd=1.38u as=0.19p ps=1.38u w=1u l=0.13u
X1642 sg13cmos5l_Corner_1.vss a_94583_92863# a_95420_93084# sg13cmos5l_Corner_1.vss sg13_lv_nmos ad=0.1406p pd=1.12u as=0.2516p ps=2.16u w=0.74u l=0.13u
X1643 cks a_42476_118044# sg13cmos5l_Corner_1.iovdd sg13cmos5l_Corner_1.iovdd sg13_hv_pmos ad=3.9294p pd=7.84u as=2.1312p ps=7.3u w=6.66u l=0.6u
X1644 a_83992_98326# adc8b_0.sar12b_0.sg13cmos5l_dfrbp_1_6.RESET_B vdd vdd sg13_lv_pmos ad=79.8f pd=0.8u as=1.04815p ps=6.595u w=0.42u l=0.13u
X1645 vip sg13cmos5l_IOPadAnalog_14.padres sg13cmos5l_Corner_1.vss rppd l=2u w=1u
X1646 adc8b_0.cmp_0.outp adc8b_0.cmp_0.clk vdd vdd sg13_lv_pmos ad=0.17p pd=1.68u as=95f ps=0.88u w=0.5u l=0.13u
X1647 a_90808_99054# adc8b_0.sar12b_0.sg13cmos5l_dfrbp_1_6.RESET_B vdd vdd sg13_lv_pmos ad=79.8f pd=0.8u as=1.12242p ps=7u w=0.42u l=0.13u
X1648 sg13cmos5l_Corner_1.vss a_102044_30676# data[2] sg13cmos5l_Corner_1.vss sg13_hv_nmos ad=1.408p pd=5.04u as=2.596p ps=5.58u w=4.4u l=0.6u
X1649 adc8b_0.sar12b_0.nh_sw[10] a_102160_94336# vdd vdd sg13_lv_pmos ad=0.42p pd=2.99u as=0.2114p ps=1.54u w=1.12u l=0.13u
X1650 a_89006_98834# adc8b_0.sar12b_0.sg13cmos5l_dfrbp_1_6.D vdd vdd sg13_lv_pmos ad=79.8f pd=0.8u as=0.1428p ps=1.52u w=0.42u l=0.13u
X1651 data[1] a_86044_42476# sg13cmos5l_Corner_1.iovdd sg13cmos5l_Corner_1.iovdd sg13_hv_pmos ad=3.9294p pd=7.84u as=2.1312p ps=7.3u w=6.66u l=0.6u
X1652 sg13cmos5l_Corner_1.vss adc8b_0.sar12b_0.nh_sw[6] adc8b_0.side_cap8b_1.buf_4_1.z sg13cmos5l_Corner_1.vss sg13_lv_nmos ad=95f pd=0.88u as=0.17p ps=1.68u w=0.5u l=0.13u
X1653 adc8b_0.side_cap8b_1.buf_32_1.z adc8b_0.sar12b_0.nh_sw[0] vddr vddr sg13_lv_pmos ad=0.19p pd=1.38u as=0.19p ps=1.38u w=1u l=0.13u
X1654 sg13cmos5l_Corner_1.iovdd a_67639_164698# sg13cmos5l_IOPadAnalog_10.pad sg13cmos5l_Corner_1.iovdd sg13_hv_pmos ad=2.1312p pd=7.3u as=3.9294p ps=7.84u w=6.66u l=0.6u
X1655 vddr adc8b_0.sar12b_0.nl_sw[2] adc8b_0.side_cap8b_1.buf_16_1.z vddr sg13_lv_pmos ad=0.19p pd=1.38u as=0.19p ps=1.38u w=1u l=0.13u
X1656 sg13cmos5l_Corner_1.vss a_70222_33862# dantenna l=1.26u w=27.78u
X1657 a_95161_98826# a_94609_98888# sg13cmos5l_Corner_1.vss sg13cmos5l_Corner_1.vss sg13_lv_nmos ad=71.99999f pd=0.865u as=1.49685p ps=9.6u w=0.64u l=0.13u
X1658 a_85175_95421# a_84333_95071# a_85081_95421# sg13cmos5l_Corner_1.vss sg13_lv_nmos ad=0.12665p pd=1.145u as=0.1428p ps=1.52u w=0.42u l=0.13u
X1659 a_84108_94616# a_84082_94521# sg13cmos5l_Corner_1.vss sg13cmos5l_Corner_1.vss sg13_lv_nmos ad=0.2516p pd=2.16u as=0.1626p ps=1.415u w=0.74u l=0.13u
X1660 cko a_118044_42476# sg13cmos5l_Corner_1.iovdd sg13cmos5l_Corner_1.iovdd sg13_hv_pmos ad=3.9294p pd=7.84u as=2.1312p ps=7.3u w=6.66u l=0.6u
X1661 sg13cmos5l_IOPadAnalog_0.pad a_164624_86044# sg13cmos5l_Corner_1.iovdd sg13cmos5l_Corner_1.iovdd sg13_hv_pmos ad=3.9294p pd=7.84u as=3.1302p ps=14.26u w=6.66u l=0.6u
X1662 a_88340_92750# adc8b_0.sar12b_0.sg13cmos5l_buf_1_24.A sg13cmos5l_Corner_1.vss sg13cmos5l_Corner_1.vss sg13_lv_nmos ad=0.187p pd=1.78u as=0.14875p ps=1.16u w=0.55u l=0.13u
X1663 a_92950_96108# adc8b_0.sar12b_0.sg13cmos5l_a221oi_1_0.B1 a_93162_96108# vdd sg13_lv_pmos ad=0.2128p pd=1.5u as=0.3808p ps=2.92u w=1.12u l=0.13u
X1664 vdd adc8b_0.sar12b_0.sg13cmos5l_dfrbp_1_6.RESET_B a_91790_98834# vdd sg13_lv_pmos ad=0.36237p pd=2.605u as=79.8f ps=0.8u w=0.42u l=0.13u
X1665 sg13cmos5l_Corner_1.vss a_95409_98834# a_95934_98816# sg13cmos5l_Corner_1.vss sg13_lv_nmos ad=0.1491p pd=1.18u as=0.187p ps=1.78u w=0.55u l=0.13u
X1666 a_87092_92750# adc8b_0.sar12b_0.sg13cmos5l_buf_1_34.X vdd vdd sg13_lv_pmos ad=0.2856p pd=2.36u as=0.2114p ps=1.54u w=0.84u l=0.13u
X1667 a_97452_95810# adc8b_0.sar12b_0.sg13cmos5l_dfrbp_1_8.D a_97358_95810# sg13cmos5l_Corner_1.vss sg13_lv_nmos ad=60.89999f pd=0.71u as=0.1428p ps=1.52u w=0.42u l=0.13u
X1668 sg13cmos5l_Corner_1.vss a_85940_92750# adc8b_0.sar12b_0.sg13cmos5l_buf_1_33.A sg13cmos5l_Corner_1.vss sg13_lv_nmos ad=0.14875p pd=1.16u as=0.2886p ps=2.26u w=0.74u l=0.13u
X1669 adc8b_0.side_cap8b_0.in_l_sw[4] a_87568_100384# vdd vdd sg13_lv_pmos ad=0.42p pd=2.99u as=0.2114p ps=1.54u w=1.12u l=0.13u
X1670 adc8b_0.sar12b_0.sg13cmos5l_buf_1_25.A adc8b_0.sar12b_0.sg13cmos5l_inv_1_14.A sg13cmos5l_Corner_1.vss sg13cmos5l_Corner_1.vss sg13_lv_nmos ad=0.2516p pd=2.16u as=0.2516p ps=2.16u w=0.74u l=0.13u
X1671 a_82450_98052# a_82893_98095# a_82190_98522# sg13cmos5l_Corner_1.vss sg13_lv_nmos ad=79.8f pd=0.8u as=0.1296p ps=1.52u w=0.42u l=0.13u
X1672 vip a_42476_102044# sg13cmos5l_Corner_1.iovdd sg13cmos5l_Corner_1.iovdd sg13_hv_pmos ad=3.9294p pd=7.84u as=2.1312p ps=7.3u w=6.66u l=0.6u
X1673 a_87588_96933# a_87719_96543# a_86837_96536# vdd sg13_lv_pmos ad=0.34p pd=2.68u as=0.2048p ps=1.63u w=1u l=0.13u
X1674 a_87538_95028# a_87981_95071# a_87278_95498# sg13cmos5l_Corner_1.vss sg13_lv_nmos ad=79.8f pd=0.8u as=0.1296p ps=1.52u w=0.42u l=0.13u
X1675 sg13cmos5l_Corner_1.vss adc8b_0.side_cap8b_0.in_h_sw[2] adc8b_0.side_cap8b_0.buf_16_0.z sg13cmos5l_Corner_1.vss sg13_lv_nmos ad=95f pd=0.88u as=95f ps=0.88u w=0.5u l=0.13u
X1676 sg13cmos5l_Corner_1.vss adc8b_0.sar12b_0.sg13cmos5l_dfrbp_1_0.RESET_B a_93036_93986# sg13cmos5l_Corner_1.vss sg13_lv_nmos ad=0.1626p pd=1.415u as=60.89999f ps=0.71u w=0.42u l=0.13u
X1677 a_88557_95789# adc8b_0.sar12b_0.sg13cmos5l_inv_1_8.A sg13cmos5l_Corner_1.vss sg13cmos5l_Corner_1.vss sg13_lv_nmos ad=0.2516p pd=2.16u as=2.27517p ps=14.72u w=0.74u l=0.13u
X1678 sg13cmos5l_Corner_1.iovdd a_164624_86044# sg13cmos5l_IOPadAnalog_0.pad sg13cmos5l_Corner_1.iovdd sg13_hv_pmos ad=2.1312p pd=7.3u as=3.9294p ps=7.84u w=6.66u l=0.6u
X1679 a_93645_93559# adc8b_0.sar12b_0.sg13cmos5l_dfrbp_1_0.CLK sg13cmos5l_Corner_1.vss sg13cmos5l_Corner_1.vss sg13_lv_nmos ad=0.2516p pd=2.16u as=2.43055p ps=15.415u w=0.74u l=0.13u
X1680 sg13cmos5l_Corner_1.vss a_84333_99607# a_84435_99607# sg13cmos5l_Corner_1.vss sg13_lv_nmos ad=2.92392p pd=18.89u as=0.2516p ps=2.16u w=0.74u l=0.13u
X1681 adc8b_0.sar12b_0.sg13cmos5l_buf_1_86.A a_101776_99596# vdd vdd sg13_lv_pmos ad=0.42p pd=2.99u as=0.2114p ps=1.54u w=1.12u l=0.13u
X1682 vdd adc8b_0.cmp_0.outp adc8b_0.cmp_0.outn vdd sg13_lv_pmos ad=0.2375p pd=1.63u as=0.425p ps=3.18u w=1.25u l=0.13u
X1683 sg13cmos5l_Corner_1.vss a_91796_97286# adc8b_0.sar12b_0.sg13cmos5l_inv_1_18.A sg13cmos5l_Corner_1.vss sg13_lv_nmos ad=0.14875p pd=1.16u as=0.2886p ps=2.26u w=0.74u l=0.13u
X1684 a_93984_96888# adc8b_0.sar12b_0.sg13cmos5l_dfrbp_1_21.Q sg13cmos5l_Corner_1.vss sg13cmos5l_Corner_1.vss sg13_lv_nmos ad=0.1045p pd=0.93u as=0.1469p ps=1.155u w=0.55u l=0.13u
X1685 sg13cmos5l_Corner_1.iovdd a_102044_42476# data[2] sg13cmos5l_Corner_1.iovdd sg13_hv_pmos ad=2.1312p pd=7.3u as=3.9294p ps=7.84u w=6.66u l=0.6u
X1686 sg13cmos5l_IOPadAnalog_12.pad a_131639_164698# sg13cmos5l_Corner_1.iovdd sg13cmos5l_Corner_1.iovdd sg13_hv_pmos ad=3.9294p pd=7.84u as=2.1312p ps=7.3u w=6.66u l=0.6u
X1687 adc8b_0.sar12b_0.sg13cmos5l_buf_8_2.X a_100995_100350# vdd vdd sg13_lv_pmos ad=0.2128p pd=1.5u as=0.2128p ps=1.5u w=1.12u l=0.13u
X1688 vddr adc8b_0.sar12b_0.nl_sw[0] adc8b_0.side_cap8b_1.buf_32_0.z vddr sg13_lv_pmos ad=0.19p pd=1.38u as=0.19p ps=1.38u w=1u l=0.13u
X1689 sg13cmos5l_Corner_1.vss sg13cmos5l_IOPadVdd$1_0.sg13cmos5l_Clamp_N43N43D4R$1_0.gate vdd sg13cmos5l_Corner_1.vss sg13_hv_nmos ad=1.408p pd=5.04u as=3.256p ps=10.28u w=4.4u l=0.6u
X1690 a_86193_98441# a_86012_98084# vdd vdd sg13_lv_pmos ad=0.2128p pd=1.5u as=0.2387p ps=1.84u w=1.12u l=0.13u
X1691 sg13cmos5l_IOPadAnalog_0.pad a_164624_86044# sg13cmos5l_Corner_1.iovdd sg13cmos5l_Corner_1.iovdd sg13_hv_pmos ad=3.9294p pd=7.84u as=2.1312p ps=7.3u w=6.66u l=0.6u
X1692 a_90356_93512# adc8b_0.sar12b_0.sg13cmos5l_buf_1_26.X vdd vdd sg13_lv_pmos ad=0.2856p pd=2.36u as=0.2114p ps=1.54u w=0.84u l=0.13u
X1693 a_92551_95452# adc8b_0.sar12b_0.sg13cmos5l_a22oi_1_0.B1 sg13cmos5l_Corner_1.vss sg13cmos5l_Corner_1.vss sg13_lv_nmos ad=0.13875p pd=1.115u as=0.2553p ps=2.17u w=0.74u l=0.13u
X1694 sg13cmos5l_IOPadAnalog_11.pad a_164624_118044# sg13cmos5l_Corner_1.iovdd sg13cmos5l_Corner_1.iovdd sg13_hv_pmos ad=3.9294p pd=7.84u as=3.1302p ps=14.26u w=6.66u l=0.6u
X1695 sg13cmos5l_Corner_1.vss adc8b_0.side_cap8b_0.in_l_sw[0] adc8b_0.side_cap8b_0.buf_32_0.z sg13cmos5l_Corner_1.vss sg13_lv_nmos ad=95f pd=0.88u as=95f ps=0.88u w=0.5u l=0.13u
X1696 adc8b_0.sar12b_0.sg13cmos5l_inv_1_3.A a_95536_99596# vdd vdd sg13_lv_pmos ad=0.42p pd=2.99u as=0.2114p ps=1.54u w=1.12u l=0.13u
X1697 adc8b_0.side_cap8b_0.buf_4_0.z adc8b_0.side_cap8b_0.in_l_sw[7] sg13cmos5l_Corner_1.vss sg13cmos5l_Corner_1.vss sg13_lv_nmos ad=0.17p pd=1.68u as=95f ps=0.88u w=0.5u l=0.13u
X1698 a_84110_96248# a_83714_95820# a_83996_96132# vdd sg13_lv_pmos ad=0.1008p pd=0.9u as=0.191p ps=1.44u w=0.42u l=0.13u
X1699 sg13cmos5l_Corner_1.vss a_134044_30676# frame sg13cmos5l_Corner_1.vss sg13_hv_nmos ad=1.408p pd=5.04u as=2.596p ps=5.58u w=4.4u l=0.6u
X1700 sg13cmos5l_Corner_1.vss adc8b_0.sar12b_0.sg13cmos5l_dfrbp_1_0.Q adc8b_0.sar12b_0.sg13cmos5l_dfrbp_1_0.D sg13cmos5l_Corner_1.vss sg13_lv_nmos ad=0.2516p pd=2.16u as=0.1406p ps=1.12u w=0.74u l=0.13u
X1701 vdd cks adc8b_0.sar12b_0.sg13cmos5l_dfrbp_1_0.RESET_B vdd sg13_lv_pmos ad=0.3808p pd=2.92u as=0.3808p ps=2.92u w=1.12u l=0.13u
X1702 vddr a_42476_70044# sg13cmos5l_Corner_1.iovdd sg13cmos5l_Corner_1.iovdd sg13_hv_pmos ad=3.9294p pd=7.84u as=3.1302p ps=14.26u w=6.66u l=0.6u
X1703 adc8b_0.side_cap8b_0.in_h_sw[4] a_88336_100384# vdd vdd sg13_lv_pmos ad=0.42p pd=2.99u as=0.2114p ps=1.54u w=1.12u l=0.13u
X1704 adc8b_0.sar12b_0.sg13cmos5l_nand2_1_1.A a_97148_94596# vdd vdd sg13_lv_pmos ad=0.3808p pd=2.92u as=0.2128p ps=1.5u w=1.12u l=0.13u
X1705 vdd adc8b_0.sar12b_0.sg13cmos5l_dfrbp_1_6.RESET_B a_87182_97322# vdd sg13_lv_pmos ad=0.36237p pd=2.605u as=79.8f ps=0.8u w=0.42u l=0.13u
X1706 a_94844_96536# adc8b_0.sar12b_0.sg13cmos5l_inv_1_0.A sg13cmos5l_Corner_1.vss sg13cmos5l_Corner_1.vss sg13_lv_nmos ad=0.187p pd=1.78u as=0.17255p ps=1.25u w=0.55u l=0.13u
X1707 a_93038_95498# a_93843_95071# a_93298_95028# vdd sg13_lv_pmos ad=0.1428p pd=1.52u as=79.8f ps=0.8u w=0.42u l=0.13u
X1708 cko a_118044_42476# sg13cmos5l_Corner_1.iovdd sg13cmos5l_Corner_1.iovdd sg13_hv_pmos ad=3.9294p pd=7.84u as=2.1312p ps=7.3u w=6.66u l=0.6u
X1709 vddr adc8b_0.side_cap8b_0.in_l_sw[4] adc8b_0.side_cap8b_0.buf_8_0.z vddr sg13_lv_pmos ad=0.19p pd=1.38u as=0.19p ps=1.38u w=1u l=0.13u
X1710 vdd a_95159_100423# a_95416_100566# vdd sg13_lv_pmos ad=0.2639p pd=1.81u as=79.8f ps=0.8u w=0.42u l=0.13u
X1711 sg13cmos5l_IOPadAnalog_12.pad sg13cmos5l_Corner_1.iovdd dpantenna l=1.26u w=27.78u
X1712 a_100977_96929# a_100796_96572# vdd vdd sg13_lv_pmos ad=0.2128p pd=1.5u as=0.2387p ps=1.84u w=1.12u l=0.13u
X1713 vddr a_42476_70044# sg13cmos5l_Corner_1.iovdd sg13cmos5l_Corner_1.iovdd sg13_hv_pmos ad=3.9294p pd=7.84u as=2.1312p ps=7.3u w=6.66u l=0.6u
X1714 sg13cmos5l_IOPadAnalog_16.pad a_164624_102044# sg13cmos5l_Corner_1.iovdd sg13cmos5l_Corner_1.iovdd sg13_hv_pmos ad=3.9294p pd=7.84u as=2.1312p ps=7.3u w=6.66u l=0.6u
X1715 adc8b_0.side_cap8b_0.buf_2_0.z adc8b_0.side_cap8b_0.in_h_sw[8] sg13cmos5l_Corner_1.vss sg13cmos5l_Corner_1.vss sg13_lv_nmos ad=0.17p pd=1.68u as=95f ps=0.88u w=0.5u l=0.13u
X1716 sg13cmos5l_Corner_1.iovdd a_164624_86044# sg13cmos5l_IOPadAnalog_0.pad sg13cmos5l_Corner_1.iovdd sg13_hv_pmos ad=2.1312p pd=7.3u as=3.9294p ps=7.84u w=6.66u l=0.6u
X1717 vdd sg13cmos5l_IOPadVdd$1_0.sg13cmos5l_Clamp_N43N43D4R$1_0.gate sg13cmos5l_Corner_1.vss sg13cmos5l_Corner_1.vss sg13_hv_nmos ad=2.596p pd=5.58u as=1.408p ps=5.04u w=4.4u l=0.6u
X1718 sg13cmos5l_Corner_1.iovdd a_164624_70044# sg13cmos5l_IOPadAnalog_1.pad sg13cmos5l_Corner_1.iovdd sg13_hv_pmos ad=2.1312p pd=7.3u as=3.9294p ps=7.84u w=6.66u l=0.6u
X1719 sg13cmos5l_Corner_1.iovdd a_164624_118044# sg13cmos5l_IOPadAnalog_11.pad sg13cmos5l_Corner_1.iovdd sg13_hv_pmos ad=2.1312p pd=7.3u as=3.9294p ps=7.84u w=6.66u l=0.6u
X1720 a_85844_96536# adc8b_0.sar12b_0.sg13cmos5l_dlhr_1_9.Q vdd vdd sg13_lv_pmos ad=0.2856p pd=2.36u as=0.2114p ps=1.54u w=0.84u l=0.13u
X1721 sg13cmos5l_Corner_1.vss a_30676_118044# cks sg13cmos5l_Corner_1.vss sg13_hv_nmos ad=1.408p pd=5.04u as=2.596p ps=5.58u w=4.4u l=0.6u
X1722 vddr adc8b_0.side_cap8b_0.in_l_sw[2] adc8b_0.side_cap8b_0.buf_16_1.z vddr sg13_lv_pmos ad=0.19p pd=1.38u as=0.19p ps=1.38u w=1u l=0.13u
X1723 sg13cmos5l_Corner_1.vss adc8b_0.sar12b_0.sg13cmos5l_inv_1_29.A adc8b_0.sar12b_0.sg13cmos5l_inv_1_29.Y sg13cmos5l_Corner_1.vss sg13_lv_nmos ad=0.2516p pd=2.16u as=0.2516p ps=2.16u w=0.74u l=0.13u
X1724 sg13cmos5l_IOPadAnalog_16.pad a_178296_102044# sg13cmos5l_Corner_1.vss sg13cmos5l_Corner_1.vss sg13_hv_nmos ad=2.596p pd=5.58u as=1.408p ps=5.04u w=4.4u l=0.6u
X1725 vdd sg13cmos5l_IOPadVdd$1_0.sg13cmos5l_Clamp_N43N43D4R$1_0.gate sg13cmos5l_Corner_1.vss sg13cmos5l_Corner_1.vss sg13_hv_nmos ad=2.596p pd=5.58u as=1.408p ps=5.04u w=4.4u l=0.6u
X1726 sg13cmos5l_Corner_1.vss adc8b_0.sar12b_0.sg13cmos5l_dfrbp_1_1.Q adc8b_0.sar12b_0.sg13cmos5l_inv_1_11.Y sg13cmos5l_Corner_1.vss sg13_lv_nmos ad=0.2516p pd=2.16u as=0.2516p ps=2.16u w=0.74u l=0.13u
X1727 vin a_30676_86044# sg13cmos5l_Corner_1.vss sg13cmos5l_Corner_1.vss sg13_hv_nmos ad=2.596p pd=5.58u as=1.408p ps=5.04u w=4.4u l=0.6u
X1728 a_97260_93552# a_97234_93516# vdd vdd sg13_lv_pmos ad=0.34p pd=2.68u as=0.36237p ps=2.605u w=1u l=0.13u
X1729 vdd a_88247_93909# a_89084_93548# vdd sg13_lv_pmos ad=0.2128p pd=1.5u as=0.3864p ps=2.93u w=1.12u l=0.13u
X1730 a_86044_93936# a_85628_93548# a_85809_93905# sg13cmos5l_Corner_1.vss sg13_lv_nmos ad=77.7f pd=0.95u as=0.2516p ps=2.16u w=0.74u l=0.13u
X1731 vdd adc8b_0.sar12b_0.sg13cmos5l_inv_1_19.A adc8b_0.sar12b_0.sg13cmos5l_buf_1_32.A vdd sg13_lv_pmos ad=0.3808p pd=2.92u as=0.3808p ps=2.92u w=1.12u l=0.13u
X1732 a_92001_99719# a_91059_99607# a_91799_99957# vdd sg13_lv_pmos ad=93.45f pd=0.865u as=0.2048p ps=1.63u w=0.42u l=0.13u
X1733 adc8b_0.side_cap8b_1.buf_4_2.z adc8b_0.sar12b_0.nh_sw[7] vddr vddr sg13_lv_pmos ad=0.34p pd=2.68u as=0.19p ps=1.38u w=1u l=0.13u
X1734 vdd sg13cmos5l_IOPadVdd$1_0.sg13cmos5l_RCClampInverter$1_0.in sg13cmos5l_IOPadVdd$1_0.sg13cmos5l_Clamp_N43N43D4R$1_0.gate vdd sg13_hv_pmos ad=1.33p pd=7.38u as=1.33p ps=7.38u w=7u l=0.5u
X1735 sg13cmos5l_Corner_1.iovdd a_102044_42476# data[2] sg13cmos5l_Corner_1.iovdd sg13_hv_pmos ad=2.1312p pd=7.3u as=3.9294p ps=7.84u w=6.66u l=0.6u
X1736 a_95361_100661# a_94419_100468# a_95159_100423# vdd sg13_lv_pmos ad=93.45f pd=0.865u as=0.2048p ps=1.63u w=0.42u l=0.13u
X1737 a_85644_95823# a_85356_96128# a_85582_95823# sg13cmos5l_Corner_1.vss sg13_lv_nmos ad=0.1428p pd=1.52u as=37.8f ps=0.6u w=0.42u l=0.13u
X1738 sg13cmos5l_Corner_1.vss adc8b_0.sar12b_0.nh_sw[3] adc8b_0.side_cap8b_1.buf_8_3.z sg13cmos5l_Corner_1.vss sg13_lv_nmos ad=95f pd=0.88u as=0.17p ps=1.68u w=0.5u l=0.13u
X1739 a_94284_97640# a_94803_97444# a_95543_97399# sg13cmos5l_Corner_1.vss sg13_lv_nmos ad=0.3473p pd=2.71u as=0.12665p ps=1.145u w=0.74u l=0.13u
X1740 sg13cmos5l_Corner_1.iovdd a_134044_42476# frame sg13cmos5l_Corner_1.iovdd sg13_hv_pmos ad=3.1302p pd=14.26u as=3.9294p ps=7.84u w=6.66u l=0.6u
X1741 adc8b_0.side_cap8b_1.buf_16_1.z adc8b_0.sar12b_0.nl_sw[2] vddr vddr sg13_lv_pmos ad=0.19p pd=1.38u as=0.19p ps=1.38u w=1u l=0.13u
X1742 sg13cmos5l_Corner_1.iovdd a_134044_42476# frame sg13cmos5l_Corner_1.iovdd sg13_hv_pmos ad=2.1312p pd=7.3u as=3.9294p ps=7.84u w=6.66u l=0.6u
X1743 vdd sg13cmos5l_IOPadVdd$1_0.sg13cmos5l_Clamp_N43N43D4R$1_0.gate sg13cmos5l_Corner_1.vss sg13cmos5l_Corner_1.vss sg13_hv_nmos ad=2.596p pd=5.58u as=1.408p ps=5.04u w=4.4u l=0.6u
X1744 vdd a_91799_99957# a_92636_99596# vdd sg13_lv_pmos ad=0.2128p pd=1.5u as=0.3864p ps=2.93u w=1.12u l=0.13u
X1745 sg13cmos5l_Corner_1.vss a_70044_30676# data[0] sg13cmos5l_Corner_1.vss sg13_hv_nmos ad=1.408p pd=5.04u as=2.596p ps=5.58u w=4.4u l=0.6u
X1746 sg13cmos5l_Corner_1.vss adc8b_0.side_cap8b_0.in_h_sw[5] adc8b_0.side_cap8b_0.buf_8_5.z sg13cmos5l_Corner_1.vss sg13_lv_nmos ad=95f pd=0.88u as=95f ps=0.88u w=0.5u l=0.13u
X1747 vdd adc8b_0.sar12b_0.sg13cmos5l_dfrbp_1_8.RESET_B a_83890_99564# vdd sg13_lv_pmos ad=0.1563p pd=1.22u as=0.147p ps=1.54u w=0.42u l=0.13u
X1748 a_96813_99607# adc8b_0.sar12b_0.sg13cmos5l_inv_1_2.A sg13cmos5l_Corner_1.vss sg13cmos5l_Corner_1.vss sg13_lv_nmos ad=0.2516p pd=2.16u as=2.71505p ps=17.54u w=0.74u l=0.13u
X1749 vddr a_30676_70044# sg13cmos5l_Corner_1.vss sg13cmos5l_Corner_1.vss sg13_hv_nmos ad=2.596p pd=5.58u as=1.408p ps=5.04u w=4.4u l=0.6u
X1750 sg13cmos5l_Corner_1.iovdd a_164624_70044# sg13cmos5l_IOPadAnalog_1.pad sg13cmos5l_Corner_1.iovdd sg13_hv_pmos ad=3.1302p pd=14.26u as=3.9294p ps=7.84u w=6.66u l=0.6u
X1751 a_95543_97399# a_94701_97301# a_94284_97640# vdd sg13_lv_pmos ad=0.2048p pd=1.63u as=0.34p ps=2.68u w=1u l=0.13u
X1752 sg13cmos5l_Corner_1.iovdd a_164624_102044# sg13cmos5l_IOPadAnalog_16.pad sg13cmos5l_Corner_1.iovdd sg13_hv_pmos ad=2.1312p pd=7.3u as=3.9294p ps=7.84u w=6.66u l=0.6u
X1753 sg13cmos5l_Corner_1.vss sg13cmos5l_IOPadVdd$1_0.sg13cmos5l_Clamp_N43N43D4R$1_0.gate vdd sg13cmos5l_Corner_1.vss sg13_hv_nmos ad=1.408p pd=5.04u as=2.596p ps=5.58u w=4.4u l=0.6u
X1754 vdd sg13cmos5l_IOPadVdd$1_0.sg13cmos5l_RCClampInverter$1_0.in sg13cmos5l_IOPadVdd$1_0.sg13cmos5l_Clamp_N43N43D4R$1_0.gate vdd sg13_hv_pmos ad=1.33p pd=7.38u as=1.33p ps=7.38u w=7u l=0.5u
X1755 vin a_42476_86044# sg13cmos5l_Corner_1.iovdd sg13cmos5l_Corner_1.iovdd sg13_hv_pmos ad=3.9294p pd=7.84u as=2.1312p ps=7.3u w=6.66u l=0.6u
X1756 data[2] a_102044_42476# sg13cmos5l_Corner_1.iovdd sg13cmos5l_Corner_1.iovdd sg13_hv_pmos ad=3.9294p pd=7.84u as=2.1312p ps=7.3u w=6.66u l=0.6u
X1757 vdd sg13cmos5l_IOPadVdd$1_0.sg13cmos5l_Clamp_N43N43D4R$1_0.gate sg13cmos5l_Corner_1.vss sg13cmos5l_Corner_1.vss sg13_hv_nmos ad=2.596p pd=5.58u as=1.408p ps=5.04u w=4.4u l=0.6u
X1758 vddr adc8b_0.side_cap8b_0.in_h_sw[1] adc8b_0.side_cap8b_0.buf_16_3.z vddr sg13_lv_pmos ad=0.19p pd=1.38u as=0.19p ps=1.38u w=1u l=0.13u
X1759 vddr adc8b_0.side_cap8b_0.in_h_sw[5] adc8b_0.side_cap8b_0.buf_8_5.z vddr sg13_lv_pmos ad=0.19p pd=1.38u as=0.19p ps=1.38u w=1u l=0.13u
X1760 a_99180_93104# a_99154_93009# vdd vdd sg13_lv_pmos ad=0.34p pd=2.68u as=0.36237p ps=2.605u w=1u l=0.13u
X1761 a_99442_94521# a_99885_94277# a_99825_94689# vdd sg13_lv_pmos ad=79.8f pd=0.8u as=63f ps=0.72u w=0.42u l=0.13u
X1762 vdd sg13cmos5l_IOPadVdd$1_0.sg13cmos5l_RCClampInverter$1_0.in sg13cmos5l_IOPadVdd$1_0.sg13cmos5l_Clamp_N43N43D4R$1_0.gate vdd sg13_hv_pmos ad=1.33p pd=7.38u as=1.33p ps=7.38u w=7u l=0.5u
X1763 a_83937_96695# a_82995_96583# a_83735_96933# vdd sg13_lv_pmos ad=93.45f pd=0.865u as=0.2048p ps=1.63u w=0.42u l=0.13u
X1764 adc8b_0.side_cap8b_0.in_h_sw[10] a_102160_98084# vdd vdd sg13_lv_pmos ad=0.42p pd=2.99u as=0.2114p ps=1.54u w=1.12u l=0.13u
X1765 adc8b_0.side_cap8b_1.buf_8_5.z adc8b_0.sar12b_0.nh_sw[5] sg13cmos5l_Corner_1.vss sg13cmos5l_Corner_1.vss sg13_lv_nmos ad=95f pd=0.88u as=95f ps=0.88u w=0.5u l=0.13u
X1766 a_36456_139375# a_40542_139705# sg13cmos5l_Corner_1.vss rppd l=20u w=1u
X1767 a_97644_96128# a_97618_96033# vdd vdd sg13_lv_pmos ad=0.34p pd=2.68u as=0.36237p ps=2.605u w=1u l=0.13u
X1768 a_93708_100346# adc8b_0.sar12b_0.sg13cmos5l_dlhr_1_11.GATE a_93614_100346# sg13cmos5l_Corner_1.vss sg13_lv_nmos ad=60.89999f pd=0.71u as=0.1428p ps=1.52u w=0.42u l=0.13u
X1769 vdd a_100439_92863# a_100696_93006# vdd sg13_lv_pmos ad=0.2639p pd=1.81u as=79.8f ps=0.8u w=0.42u l=0.13u
X1770 a_86702_93986# adc8b_0.sar12b_0.sg13cmos5l_dfrbp_1_6.D vdd vdd sg13_lv_pmos ad=79.8f pd=0.8u as=0.1428p ps=1.52u w=0.42u l=0.13u
X1771 adc8b_0.sar12b_0.sg13cmos5l_dlhr_1_5.Q a_90225_98441# sg13cmos5l_Corner_1.vss sg13cmos5l_Corner_1.vss sg13_lv_nmos ad=0.2516p pd=2.16u as=0.1406p ps=1.12u w=0.74u l=0.13u
X1772 adc8b_0.sar12b_0.sg13cmos5l_dlhr_1_5.Q_N a_90750_98514# sg13cmos5l_Corner_1.vss sg13cmos5l_Corner_1.vss sg13_lv_nmos ad=0.2516p pd=2.16u as=0.1491p ps=1.18u w=0.74u l=0.13u
X1773 a_94689_93671# a_93747_93559# a_94487_93909# vdd sg13_lv_pmos ad=93.45f pd=0.865u as=0.2048p ps=1.63u w=0.42u l=0.13u
X1774 adc8b_0.side_cap8b_0.buf_32_0.z adc8b_0.side_cap8b_0.in_l_sw[0] sg13cmos5l_Corner_1.vss sg13cmos5l_Corner_1.vss sg13_lv_nmos ad=95f pd=0.88u as=95f ps=0.88u w=0.5u l=0.13u
X1775 vdd a_95416_100566# a_95361_100661# vdd sg13_lv_pmos ad=4.11675p pd=27.17u as=93.45f ps=0.865u w=0.42u l=0.13u
X1776 a_87405_93559# adc8b_0.sar12b_0.sg13cmos5l_dlhr_1_0.GATE vdd vdd sg13_lv_pmos ad=0.4088p pd=2.97u as=1.777p ps=11.395u w=1.12u l=0.13u
X1777 vddr adc8b_0.side_cap8b_0.in_l_sw[0] adc8b_0.side_cap8b_0.buf_32_0.z vddr sg13_lv_pmos ad=0.19p pd=1.38u as=0.19p ps=1.38u w=1u l=0.13u
X1778 adc8b_0.sar12b_0.sg13cmos5l_buf_1_25.A adc8b_0.sar12b_0.sg13cmos5l_inv_1_14.A vdd vdd sg13_lv_pmos ad=0.3808p pd=2.92u as=0.3808p ps=2.92u w=1.12u l=0.13u
X1779 a_82964_99560# adc8b_0.sar12b_0.sg13cmos5l_buf_1_63.A vdd vdd sg13_lv_pmos ad=0.2856p pd=2.36u as=0.2114p ps=1.54u w=0.84u l=0.13u
X1780 sg13cmos5l_Corner_1.iovdd a_70044_42476# data[0] sg13cmos5l_Corner_1.iovdd sg13_hv_pmos ad=3.1302p pd=14.26u as=3.9294p ps=7.84u w=6.66u l=0.6u
X1781 vdd sg13cmos5l_IOPadVdd$1_0.sg13cmos5l_RCClampInverter$1_0.in sg13cmos5l_IOPadVdd$1_0.sg13cmos5l_Clamp_N43N43D4R$1_0.gate vdd sg13_hv_pmos ad=1.33p pd=7.38u as=1.33p ps=7.38u w=7u l=0.5u
X1782 sg13cmos5l_Corner_1.iovdd a_70044_42476# data[0] sg13cmos5l_Corner_1.iovdd sg13_hv_pmos ad=2.1312p pd=7.3u as=3.9294p ps=7.84u w=6.66u l=0.6u
X1783 sg13cmos5l_Corner_1.vss a_83348_93512# adc8b_0.sar12b_0.nh_sw[0] sg13cmos5l_Corner_1.vss sg13_lv_nmos ad=0.14875p pd=1.16u as=0.2886p ps=2.26u w=0.74u l=0.13u
X1784 vddr a_42476_70044# sg13cmos5l_Corner_1.iovdd sg13cmos5l_Corner_1.iovdd sg13_hv_pmos ad=3.9294p pd=7.84u as=2.1312p ps=7.3u w=6.66u l=0.6u
X1785 sg13cmos5l_Corner_1.vss adc8b_0.sar12b_0.sg13cmos5l_dfrbp_1_6.RESET_B a_91884_98834# sg13cmos5l_Corner_1.vss sg13_lv_nmos ad=0.1626p pd=1.415u as=60.89999f ps=0.71u w=0.42u l=0.13u
X1786 adc8b_0.side_cap8b_1.buf_4_0.z adc8b_0.sar12b_0.nl_sw[7] vddr vddr sg13_lv_pmos ad=0.34p pd=2.68u as=0.19p ps=1.38u w=1u l=0.13u
X1787 a_85844_96536# adc8b_0.sar12b_0.sg13cmos5l_dlhr_1_9.Q sg13cmos5l_Corner_1.vss sg13cmos5l_Corner_1.vss sg13_lv_nmos ad=0.187p pd=1.78u as=0.14875p ps=1.16u w=0.55u l=0.13u
X1788 a_68892_97356# a_68824_97392# vdd sg13cmos5l_Corner_1.vss sg13_lv_nmos ad=0.442p pd=3.28u as=0.442p ps=3.28u w=1.3u l=0.13u
X1789 vddr adc8b_0.sar12b_0.nh_sw[0] adc8b_0.side_cap8b_1.buf_32_1.z vddr sg13_lv_pmos ad=0.19p pd=1.38u as=0.19p ps=1.38u w=1u l=0.13u
X1790 sg13cmos5l_Corner_1.vss a_30676_86044# vin sg13cmos5l_Corner_1.vss sg13_hv_nmos ad=1.408p pd=5.04u as=2.596p ps=5.58u w=4.4u l=0.6u
X1791 sg13cmos5l_Corner_1.vss vdd sg13cmos5l_Corner_1.vss sg13cmos5l_Corner_1.vss sg13_lv_nmos ad=0.1428p pd=1.52u as=0 ps=0 w=0.42u l=1u
X1792 adc8b_0.side_cap8b_0.buf_16_1.z adc8b_0.side_cap8b_0.in_l_sw[2] vddr vddr sg13_lv_pmos ad=0.34p pd=2.68u as=0.19p ps=1.38u w=1u l=0.13u
X1793 a_99914_95498# adc8b_0.sar12b_0.sg13cmos5l_dfrbp_1_6.RESET_B sg13cmos5l_Corner_1.vss sg13cmos5l_Corner_1.vss sg13_lv_nmos ad=60.89999f pd=0.71u as=0.1626p ps=1.415u w=0.42u l=0.13u
X1794 vdd a_85624_94518# a_85569_94613# vdd sg13_lv_pmos ad=1.43437p pd=9.105u as=93.45f ps=0.865u w=0.42u l=0.13u
X1795 sg13cmos5l_Corner_1.vss sg13cmos5l_IOPadVdd$1_0.sg13cmos5l_RCClampInverter$1_0.in sg13cmos5l_Corner_1.vss sg13cmos5l_Corner_1.vss sg13_hv_nmos ad=1.71p pd=9.38u as=0 ps=0 w=9u l=9.5u
X1796 a_91036_97308# a_90620_97644# a_90801_97322# sg13cmos5l_Corner_1.vss sg13_lv_nmos ad=77.7f pd=0.95u as=0.2516p ps=2.16u w=0.74u l=0.13u
X1797 a_98028_97640# a_98547_97444# a_99287_97399# sg13cmos5l_Corner_1.vss sg13_lv_nmos ad=0.3473p pd=2.71u as=0.12665p ps=1.145u w=0.74u l=0.13u
X1798 sg13cmos5l_Corner_1.vss adc8b_0.side_cap8b_0.in_h_sw[0] adc8b_0.side_cap8b_0.buf_32_1.z sg13cmos5l_Corner_1.vss sg13_lv_nmos ad=95f pd=0.88u as=95f ps=0.88u w=0.5u l=0.13u
X1799 a_91591_93524# adc8b_0.sar12b_0.sg13cmos5l_a22oi_1_2.B2 adc8b_0.sar12b_0.sg13cmos5l_dfrbp_1_1.D vdd sg13_lv_pmos ad=0.2744p pd=1.61u as=0.2128p ps=1.5u w=1.12u l=0.13u
X1800 a_101972_96536# adc8b_0.sar12b_0.sg13cmos5l_dlhr_1_16.Q vdd vdd sg13_lv_pmos ad=0.2856p pd=2.36u as=0.2114p ps=1.54u w=0.84u l=0.13u
X1801 sg13cmos5l_Corner_1.iovdd a_42476_86044# vin sg13cmos5l_Corner_1.iovdd sg13_hv_pmos ad=2.1312p pd=7.3u as=3.9294p ps=7.84u w=6.66u l=0.6u
X1802 sg13cmos5l_Corner_1.vss a_89399_95887# a_90236_96108# sg13cmos5l_Corner_1.vss sg13_lv_nmos ad=0.1406p pd=1.12u as=0.2516p ps=2.16u w=0.74u l=0.13u
X1803 sg13cmos5l_Corner_1.vss a_90879_95826# a_91010_95820# sg13cmos5l_Corner_1.vss sg13_lv_nmos ad=2.41737p pd=15.64u as=0.2775p ps=2.23u w=0.74u l=0.13u
X1804 frame a_134044_42476# sg13cmos5l_Corner_1.iovdd sg13cmos5l_Corner_1.iovdd sg13_hv_pmos ad=3.9294p pd=7.84u as=2.1312p ps=7.3u w=6.66u l=0.6u
X1805 vdd sg13cmos5l_IOPadVdd$1_0.sg13cmos5l_Clamp_N43N43D4R$1_0.gate sg13cmos5l_Corner_1.vss sg13cmos5l_Corner_1.vss sg13_hv_nmos ad=2.596p pd=5.58u as=1.408p ps=5.04u w=4.4u l=0.6u
X1806 a_36456_140695# vdd sg13cmos5l_Corner_1.vss rppd l=20u w=1u
X1807 sg13cmos5l_IOPadAnalog_1.pad a_164624_70044# sg13cmos5l_Corner_1.iovdd sg13cmos5l_Corner_1.iovdd sg13_hv_pmos ad=3.9294p pd=7.84u as=3.1302p ps=14.26u w=6.66u l=0.6u
X1808 a_92232_93587# adc8b_0.sar12b_0.sg13cmos5l_nor2_1_0.A vdd vdd sg13_lv_pmos ad=0.1596p pd=1.22u as=0.4536p ps=2.76u w=0.84u l=0.13u
X1809 sg13cmos5l_Corner_1.vss sg13cmos5l_IOPadVdd$1_0.sg13cmos5l_RCClampInverter$1_0.in sg13cmos5l_Corner_1.vss sg13cmos5l_Corner_1.vss sg13_hv_nmos ad=1.71p pd=9.38u as=0 ps=0 w=9u l=9.5u
X1810 adc8b_0.side_cap8b_0.buf_32_1.z adc8b_0.side_cap8b_0.in_h_sw[0] vddr vddr sg13_lv_pmos ad=0.19p pd=1.38u as=0.19p ps=1.38u w=1u l=0.13u
X1811 cks a_42476_118044# sg13cmos5l_Corner_1.iovdd sg13cmos5l_Corner_1.iovdd sg13_hv_pmos ad=3.9294p pd=7.84u as=2.1312p ps=7.3u w=6.66u l=0.6u
X1812 sg13cmos5l_Corner_1.vss adc8b_0.side_cap8b_0.in_l_sw[3] adc8b_0.side_cap8b_0.buf_8_1.z sg13cmos5l_Corner_1.vss sg13_lv_nmos ad=95f pd=0.88u as=95f ps=0.88u w=0.5u l=0.13u
X1813 a_85076_100310# adc8b_0.sar12b_0.sg13cmos5l_buf_1_65.X sg13cmos5l_Corner_1.vss sg13cmos5l_Corner_1.vss sg13_lv_nmos ad=0.187p pd=1.78u as=0.14875p ps=1.16u w=0.55u l=0.13u
X1814 sg13cmos5l_Corner_1.vss a_100995_100350# adc8b_0.sar12b_0.sg13cmos5l_buf_8_2.X sg13cmos5l_Corner_1.vss sg13_lv_nmos ad=0.1406p pd=1.12u as=0.1406p ps=1.12u w=0.74u l=0.13u
X1815 vdd adc8b_0.sar12b_0.sg13cmos5l_dfrbp_1_8.RESET_B a_83630_100034# vdd sg13_lv_pmos ad=0.36237p pd=2.605u as=79.8f ps=0.8u w=0.42u l=0.13u
X1816 sg13cmos5l_Corner_1.vss a_91028_93512# adc8b_0.sar12b_0.nh_sw[4] sg13cmos5l_Corner_1.vss sg13_lv_nmos ad=0.14875p pd=1.16u as=0.2886p ps=2.26u w=0.74u l=0.13u
X1817 vdd sg13cmos5l_IOPadVdd$1_0.sg13cmos5l_RCClampInverter$1_0.in sg13cmos5l_IOPadVdd$1_0.sg13cmos5l_Clamp_N43N43D4R$1_0.gate vdd sg13_hv_pmos ad=1.33p pd=7.38u as=1.33p ps=7.38u w=7u l=0.5u
X1818 sg13cmos5l_IOPadAnalog_1.pad a_164624_70044# sg13cmos5l_Corner_1.iovdd sg13cmos5l_Corner_1.iovdd sg13_hv_pmos ad=3.9294p pd=7.84u as=2.1312p ps=7.3u w=6.66u l=0.6u
X1819 sg13cmos5l_Corner_1.vss a_100995_95814# adc8b_0.sar12b_0.sg13cmos5l_buf_8_0.X sg13cmos5l_Corner_1.vss sg13_lv_nmos ad=0.2516p pd=2.16u as=0.1406p ps=1.12u w=0.74u l=0.13u
X1820 sg13cmos5l_Corner_1.iovdd a_42476_86044# vin sg13cmos5l_Corner_1.iovdd sg13_hv_pmos ad=2.1312p pd=7.3u as=3.9294p ps=7.84u w=6.66u l=0.6u
X1821 vdd sg13cmos5l_Corner_1.vss vdd vdd sg13_lv_pmos ad=0.34p pd=2.68u as=0 ps=0 w=1u l=1u
X1822 adc8b_0.sar12b_0.sg13cmos5l_a22oi_1_1.B2 adc8b_0.sar12b_0.sg13cmos5l_dlhr_1_6.D a_95254_96920# sg13cmos5l_Corner_1.vss sg13_lv_nmos ad=0.2516p pd=2.16u as=0.1406p ps=1.12u w=0.74u l=0.13u
X1823 sg13cmos5l_Corner_1.vss a_91473_95810# a_91998_95792# sg13cmos5l_Corner_1.vss sg13_lv_nmos ad=0.1491p pd=1.18u as=0.187p ps=1.78u w=0.55u l=0.13u
X1824 sg13cmos5l_Corner_1.vss adc8b_0.sar12b_0.sg13cmos5l_a221oi_1_0.C1 a_92201_95408# sg13cmos5l_Corner_1.vss sg13_lv_nmos ad=0.2516p pd=2.16u as=0.1406p ps=1.12u w=0.74u l=0.13u
X1825 sg13cmos5l_IOPadAnalog_12.pad a_131639_164698# sg13cmos5l_Corner_1.iovdd sg13cmos5l_Corner_1.iovdd sg13_hv_pmos ad=3.9294p pd=7.84u as=2.1312p ps=7.3u w=6.66u l=0.6u
X1826 sg13cmos5l_Corner_1.vss sg13cmos5l_IOPadAnalog_14.padres dantenna l=0.64u w=3.1u
X1827 sg13cmos5l_Corner_1.vss a_92241_100346# a_92766_100328# sg13cmos5l_Corner_1.vss sg13_lv_nmos ad=0.1491p pd=1.18u as=0.187p ps=1.78u w=0.55u l=0.13u
X1828 vdd a_100628_98048# adc8b_0.side_cap8b_0.in_h_sw[9] vdd sg13_lv_pmos ad=0.2114p pd=1.54u as=0.42p ps=2.99u w=1.12u l=0.13u
X1829 vdd a_101780_92750# adc8b_0.sar12b_0.sg13cmos5l_buf_1_0.X vdd sg13_lv_pmos ad=0.2114p pd=1.54u as=0.42p ps=2.99u w=1.12u l=0.13u
X1830 a_99890_93548# adc8b_0.sar12b_0.sg13cmos5l_nor2_1_1.A vdd vdd sg13_lv_pmos ad=0.1176p pd=1.33u as=0.4032p ps=2.96u w=1.12u l=0.13u
X1831 sg13cmos5l_Corner_1.vss adc8b_0.sar12b_0.sg13cmos5l_a22oi_1_1.B1 a_96830_95452# sg13cmos5l_Corner_1.vss sg13_lv_nmos ad=0.2553p pd=2.17u as=0.13875p ps=1.115u w=0.74u l=0.13u
X1832 vdd adc8b_0.sar12b_0.sg13cmos5l_dfrbp_1_1.Q adc8b_0.sar12b_0.sg13cmos5l_inv_1_11.Y vdd sg13_lv_pmos ad=0.3808p pd=2.92u as=0.3808p ps=2.92u w=1.12u l=0.13u
X1833 sg13cmos5l_Corner_1.iovdd a_118044_42476# cko sg13cmos5l_Corner_1.iovdd sg13_hv_pmos ad=2.1312p pd=7.3u as=3.9294p ps=7.84u w=6.66u l=0.6u
X1834 adc8b_0.sar12b_0.sg13cmos5l_dfrbp_1_0.Q_N a_100439_92863# vdd vdd sg13_lv_pmos ad=0.4312p pd=3.01u as=0.2639p ps=1.81u w=1.12u l=0.13u
X1835 a_92076_99152# a_92050_99057# vdd vdd sg13_lv_pmos ad=0.34p pd=2.68u as=0.36237p ps=2.605u w=1u l=0.13u
X1836 a_86615_95887# a_85773_95789# a_85356_96128# vdd sg13_lv_pmos ad=0.2048p pd=1.63u as=0.34p ps=2.68u w=1u l=0.13u
X1837 adc8b_0.side_cap8b_0.in_h_sw[10] a_102160_98084# sg13cmos5l_Corner_1.vss sg13cmos5l_Corner_1.vss sg13_lv_nmos ad=0.2886p pd=2.26u as=0.14875p ps=1.16u w=0.74u l=0.13u
X1838 a_88929_97637# a_87987_97444# a_88727_97399# vdd sg13_lv_pmos ad=93.45f pd=0.865u as=0.2048p ps=1.63u w=0.42u l=0.13u
X1839 sg13cmos5l_Corner_1.iovdd a_42476_118044# cks sg13cmos5l_Corner_1.iovdd sg13_hv_pmos ad=2.1312p pd=7.3u as=3.9294p ps=7.84u w=6.66u l=0.6u
X1840 sg13cmos5l_Corner_1.vss adc8b_0.side_cap8b_0.in_h_sw[4] adc8b_0.side_cap8b_0.buf_8_2.z sg13cmos5l_Corner_1.vss sg13_lv_nmos ad=95f pd=0.88u as=95f ps=0.88u w=0.5u l=0.13u
X1841 sg13cmos5l_IOPadAnalog_1.pad a_164624_70044# sg13cmos5l_Corner_1.iovdd sg13cmos5l_Corner_1.iovdd sg13_hv_pmos ad=3.9294p pd=7.84u as=2.1312p ps=7.3u w=6.66u l=0.6u
X1842 adc8b_0.side_cap8b_1.buf_16_0.z adc8b_0.sar12b_0.nh_sw[2] vddr vddr sg13_lv_pmos ad=0.34p pd=2.68u as=0.19p ps=1.38u w=1u l=0.13u
X1843 sg13cmos5l_Corner_1.vss sg13cmos5l_IOPadVdd$1_0.sg13cmos5l_Clamp_N43N43D4R$1_0.gate vdd sg13cmos5l_Corner_1.vss sg13_hv_nmos ad=1.408p pd=5.04u as=2.596p ps=5.58u w=4.4u l=0.6u
X1844 sg13cmos5l_IOPadAnalog_16.pad a_164624_102044# sg13cmos5l_Corner_1.iovdd sg13cmos5l_Corner_1.iovdd sg13_hv_pmos ad=3.9294p pd=7.84u as=3.1302p ps=14.26u w=6.66u l=0.6u
X1845 sg13cmos5l_Corner_1.vss sg13cmos5l_IOPadVdd$1_0.sg13cmos5l_Clamp_N43N43D4R$1_0.gate dantenna l=0.48u w=0.48u
X1846 sg13cmos5l_Corner_1.vss adc8b_0.side_cap8b_0.in_h_sw[2] adc8b_0.side_cap8b_0.buf_16_0.z sg13cmos5l_Corner_1.vss sg13_lv_nmos ad=95f pd=0.88u as=95f ps=0.88u w=0.5u l=0.13u
X1847 adc8b_0.sar12b_0.sg13cmos5l_dlhr_1_18.Q_N a_92958_98514# sg13cmos5l_Corner_1.vss sg13cmos5l_Corner_1.vss sg13_lv_nmos ad=0.2516p pd=2.16u as=0.1491p ps=1.18u w=0.74u l=0.13u
X1848 a_95159_100423# a_94317_100325# a_95065_100423# sg13cmos5l_Corner_1.vss sg13_lv_nmos ad=0.12665p pd=1.145u as=0.1428p ps=1.52u w=0.42u l=0.13u
X1849 adc8b_0.sar12b_0.sg13cmos5l_buf_1_104.A adc8b_0.sar12b_0.sg13cmos5l_buf_1_3.A vdd vdd sg13_lv_pmos ad=0.3808p pd=2.92u as=0.3808p ps=2.92u w=1.12u l=0.13u
X1850 a_90207_97338# adc8b_0.sar12b_0.sg13cmos5l_dlhr_1_5.GATE sg13cmos5l_Corner_1.vss sg13cmos5l_Corner_1.vss sg13_lv_nmos ad=0.2516p pd=2.16u as=0.15055p ps=1.17u w=0.74u l=0.13u
X1851 sg13cmos5l_Corner_1.vss vdd sg13cmos5l_Corner_1.vss sg13cmos5l_Corner_1.vss sg13_lv_nmos ad=79.8f pd=0.8u as=0 ps=0 w=0.42u l=1u
X1852 adc8b_0.sar12b_0.sg13cmos5l_buf_8_0.X a_100995_95814# vdd vdd sg13_lv_pmos ad=0.2128p pd=1.5u as=0.2128p ps=1.5u w=1.12u l=0.13u
X1853 sg13cmos5l_Corner_1.iovdd a_102044_42476# data[2] sg13cmos5l_Corner_1.iovdd sg13_hv_pmos ad=2.1312p pd=7.3u as=3.9294p ps=7.84u w=6.66u l=0.6u
X1854 sg13cmos5l_Corner_1.vss adc8b_0.side_cap8b_0.in_l_sw[5] adc8b_0.side_cap8b_0.buf_8_4.z sg13cmos5l_Corner_1.vss sg13_lv_nmos ad=95f pd=0.88u as=0.17p ps=1.68u w=0.5u l=0.13u
X1855 data[0] a_70044_42476# sg13cmos5l_Corner_1.iovdd sg13cmos5l_Corner_1.iovdd sg13_hv_pmos ad=3.9294p pd=7.84u as=2.1312p ps=7.3u w=6.66u l=0.6u
X1856 sg13cmos5l_IOPadAnalog_16.pad a_164624_102044# sg13cmos5l_Corner_1.iovdd sg13cmos5l_Corner_1.iovdd sg13_hv_pmos ad=3.9294p pd=7.84u as=2.1312p ps=7.3u w=6.66u l=0.6u
X1857 vdd a_99352_98326# a_99297_98207# vdd sg13_lv_pmos ad=1.07253p pd=6.75u as=93.45f ps=0.865u w=0.42u l=0.13u
X1858 vddr adc8b_0.sar12b_0.nl_sw[0] adc8b_0.side_cap8b_1.buf_32_0.z vddr sg13_lv_pmos ad=0.19p pd=1.38u as=0.19p ps=1.38u w=1u l=0.13u
X1859 sg13cmos5l_Corner_1.vss adc8b_0.side_cap8b_0.in_l_sw[0] adc8b_0.side_cap8b_0.buf_32_0.z sg13cmos5l_Corner_1.vss sg13_lv_nmos ad=95f pd=0.88u as=95f ps=0.88u w=0.5u l=0.13u
X1860 sg13cmos5l_Corner_1.vss a_118044_30676# cko sg13cmos5l_Corner_1.vss sg13_hv_nmos ad=1.408p pd=5.04u as=2.596p ps=5.58u w=4.4u l=0.6u
X1861 a_89208_93108# a_88657_92840# vdd vdd sg13_lv_pmos ad=0.105p pd=1.21u as=1.86162p ps=11.935u w=1u l=0.13u
X1862 data[2] a_102044_30676# sg13cmos5l_Corner_1.vss sg13cmos5l_Corner_1.vss sg13_hv_nmos ad=2.596p pd=5.58u as=1.408p ps=5.04u w=4.4u l=0.6u
X1863 sg13cmos5l_Corner_1.vss sg13cmos5l_IOPadVdd$1_0.sg13cmos5l_Clamp_N43N43D4R$1_0.gate vdd sg13cmos5l_Corner_1.vss sg13_hv_nmos ad=1.408p pd=5.04u as=2.596p ps=5.58u w=4.4u l=0.6u
X1864 a_94572_97335# a_94284_97640# a_94510_97335# sg13cmos5l_Corner_1.vss sg13_lv_nmos ad=0.1428p pd=1.52u as=37.8f ps=0.6u w=0.42u l=0.13u
X1865 a_85356_96128# a_85330_96033# vdd vdd sg13_lv_pmos ad=0.34p pd=2.68u as=0.36237p ps=2.605u w=1u l=0.13u
X1866 adc8b_0.sar12b_0.sg13cmos5l_buf_8_0.A a_100248_96188# vdd vdd sg13_lv_pmos ad=0.3976p pd=2.95u as=0.2226p ps=1.535u w=1.12u l=0.13u
X1867 a_97548_93973# a_97260_93552# a_97486_93973# sg13cmos5l_Corner_1.vss sg13_lv_nmos ad=0.1428p pd=1.52u as=37.8f ps=0.6u w=0.42u l=0.13u
X1868 a_90801_97322# a_90620_97644# vdd vdd sg13_lv_pmos ad=0.2128p pd=1.5u as=0.2387p ps=1.84u w=1.12u l=0.13u
X1869 sg13cmos5l_Corner_1.vss adc8b_0.side_cap8b_0.in_l_sw[6] adc8b_0.side_cap8b_0.buf_4_3.z sg13cmos5l_Corner_1.vss sg13_lv_nmos ad=95f pd=0.88u as=95f ps=0.88u w=0.5u l=0.13u
X1870 adc8b_0.side_cap8b_1.buf_16_0.z adc8b_0.sar12b_0.nh_sw[2] sg13cmos5l_Corner_1.vss sg13cmos5l_Corner_1.vss sg13_lv_nmos ad=95f pd=0.88u as=95f ps=0.88u w=0.5u l=0.13u
X1871 sg13cmos5l_Corner_1.iovdd a_42476_102044# vip sg13cmos5l_Corner_1.iovdd sg13_hv_pmos ad=3.1302p pd=14.26u as=3.9294p ps=7.84u w=6.66u l=0.6u
X1872 adc8b_0.sar12b_0.sg13cmos5l_dlhr_1_7.Q_N a_86718_98514# vdd vdd sg13_lv_pmos ad=0.3808p pd=2.92u as=0.1974p ps=1.5u w=1.12u l=0.13u
X1873 a_87034_95810# adc8b_0.sar12b_0.sg13cmos5l_dfrbp_1_8.RESET_B sg13cmos5l_Corner_1.vss sg13cmos5l_Corner_1.vss sg13_lv_nmos ad=37.8f pd=0.6u as=79.8f ps=0.8u w=0.42u l=0.13u
X1874 a_101972_96536# adc8b_0.sar12b_0.sg13cmos5l_dlhr_1_16.Q sg13cmos5l_Corner_1.vss sg13cmos5l_Corner_1.vss sg13_lv_nmos ad=0.187p pd=1.78u as=0.14875p ps=1.16u w=0.55u l=0.13u
X1875 a_97932_95823# a_98163_95932# a_97618_96033# sg13cmos5l_Corner_1.vss sg13_lv_nmos ad=0.2373p pd=1.97u as=79.8f ps=0.8u w=0.42u l=0.13u
X1876 a_100439_92863# a_99597_92765# a_99180_93104# vdd sg13_lv_pmos ad=0.2048p pd=1.63u as=0.34p ps=2.68u w=1u l=0.13u
X1877 sg13cmos5l_IOPadAnalog_12.pad a_131639_178370# sg13cmos5l_Corner_1.vss sg13cmos5l_Corner_1.vss sg13_hv_nmos ad=2.596p pd=5.58u as=1.408p ps=5.04u w=4.4u l=0.6u
X1878 a_89588_100310# adc8b_0.sar12b_0.sg13cmos5l_buf_1_73.A vdd vdd sg13_lv_pmos ad=0.2856p pd=2.36u as=0.2114p ps=1.54u w=0.84u l=0.13u
X1879 a_86420_97286# adc8b_0.sar12b_0.sg13cmos5l_buf_1_59.A vdd vdd sg13_lv_pmos ad=0.2856p pd=2.36u as=0.2114p ps=1.54u w=0.84u l=0.13u
X1880 a_82893_96583# adc8b_0.sar12b_0.sg13cmos5l_dlhr_1_1.GATE vdd vdd sg13_lv_pmos ad=0.4088p pd=2.97u as=1.2517p ps=7.955u w=1.12u l=0.13u
X1881 adc8b_0.side_cap8b_1.buf_8_0.z adc8b_0.sar12b_0.nl_sw[4] sg13cmos5l_Corner_1.vss sg13cmos5l_Corner_1.vss sg13_lv_nmos ad=95f pd=0.88u as=95f ps=0.88u w=0.5u l=0.13u
X1882 vdd sg13cmos5l_IOPadVdd$1_0.sg13cmos5l_Clamp_N43N43D4R$1_0.gate sg13cmos5l_Corner_1.vss sg13cmos5l_Corner_1.vss sg13_hv_nmos ad=2.596p pd=5.58u as=1.408p ps=5.04u w=4.4u l=0.6u
X1883 vddr adc8b_0.side_cap8b_0.in_l_sw[2] adc8b_0.side_cap8b_0.buf_16_1.z vddr sg13_lv_pmos ad=0.19p pd=1.38u as=0.19p ps=1.38u w=1u l=0.13u
X1884 a_96753_99643# a_96396_99600# vdd vdd sg13_lv_pmos ad=63f pd=0.72u as=0.1563p ps=1.22u w=0.42u l=0.13u
X1885 sg13cmos5l_Corner_1.vss a_84980_92750# adc8b_0.sar12b_0.sg13cmos5l_buf_1_41.X sg13cmos5l_Corner_1.vss sg13_lv_nmos ad=0.14875p pd=1.16u as=0.2886p ps=2.26u w=0.74u l=0.13u
X1886 a_85070_95810# a_85875_95932# a_85330_96033# vdd sg13_lv_pmos ad=0.1428p pd=1.52u as=79.8f ps=0.8u w=0.42u l=0.13u
X1887 vdd adc8b_0.sar12b_0.sg13cmos5l_nor2b_1_0.Y a_92551_95036# vdd sg13_lv_pmos ad=0.3808p pd=2.92u as=0.2744p ps=1.61u w=1.12u l=0.13u
X1888 a_93790_94294# adc8b_0.sar12b_0.sg13cmos5l_o21ai_1_0.A2 sg13cmos5l_Corner_1.vss sg13cmos5l_Corner_1.vss sg13_lv_nmos ad=0.1406p pd=1.12u as=0.1406p ps=1.12u w=0.74u l=0.15u
X1889 sg13cmos5l_Corner_1.vss vdd sg13cmos5l_Corner_1.vss sg13cmos5l_Corner_1.vss sg13_lv_nmos ad=0.1428p pd=1.52u as=0 ps=0 w=0.42u l=1u
X1890 sg13cmos5l_Corner_1.vss adc8b_0.sar12b_0.nh_sw[1] adc8b_0.side_cap8b_1.buf_16_3.z sg13cmos5l_Corner_1.vss sg13_lv_nmos ad=95f pd=0.88u as=95f ps=0.88u w=0.5u l=0.13u
X1891 sg13cmos5l_Corner_1.iovdd a_131639_164698# sg13cmos5l_IOPadAnalog_12.pad sg13cmos5l_Corner_1.iovdd sg13_hv_pmos ad=3.1302p pd=14.26u as=3.9294p ps=7.84u w=6.66u l=0.6u
X1892 a_86228_100310# adc8b_0.sar12b_0.sg13cmos5l_buf_1_60.A vdd vdd sg13_lv_pmos ad=0.2856p pd=2.36u as=0.2114p ps=1.54u w=0.84u l=0.13u
X1893 sg13cmos5l_Corner_1.vss vdd sg13cmos5l_Corner_1.vss sg13cmos5l_Corner_1.vss sg13_lv_nmos ad=0.1428p pd=1.52u as=0 ps=0 w=0.42u l=1u
X1894 a_98988_92786# adc8b_0.sar12b_0.sg13cmos5l_dfrbp_1_0.D a_98894_92786# sg13cmos5l_Corner_1.vss sg13_lv_nmos ad=60.89999f pd=0.71u as=0.1428p ps=1.52u w=0.42u l=0.13u
X1895 sg13cmos5l_Corner_1.vss adc8b_0.sar12b_0.sg13cmos5l_buf_1_35.A a_83632_92824# sg13cmos5l_Corner_1.vss sg13_lv_nmos ad=0.14875p pd=1.16u as=0.187p ps=1.78u w=0.55u l=0.13u
X1896 adc8b_0.sar12b_0.sg13cmos5l_dfrbp_1_1.Q a_95420_93084# sg13cmos5l_Corner_1.vss sg13cmos5l_Corner_1.vss sg13_lv_nmos ad=0.2516p pd=2.16u as=0.1406p ps=1.12u w=0.74u l=0.13u
X1897 sg13cmos5l_Corner_1.iovdd a_42476_118044# cks sg13cmos5l_Corner_1.iovdd sg13_hv_pmos ad=2.1312p pd=7.3u as=3.9294p ps=7.84u w=6.66u l=0.6u
X1898 vdd a_82388_98798# adc8b_0.side_cap8b_0.in_l_sw[0] vdd sg13_lv_pmos ad=0.2114p pd=1.54u as=0.42p ps=2.99u w=1.12u l=0.13u
X1899 vdd a_83735_98445# a_83992_98326# vdd sg13_lv_pmos ad=0.2639p pd=1.81u as=79.8f ps=0.8u w=0.42u l=0.13u
X1900 vddr adc8b_0.side_cap8b_0.in_h_sw[0] adc8b_0.side_cap8b_0.buf_32_1.z vddr sg13_lv_pmos ad=0.19p pd=1.38u as=0.34p ps=2.68u w=1u l=0.13u
X1901 sg13cmos5l_Corner_1.vss a_85076_100310# adc8b_0.sar12b_0.sg13cmos5l_inv_1_8.A sg13cmos5l_Corner_1.vss sg13_lv_nmos ad=0.14875p pd=1.16u as=0.2886p ps=2.26u w=0.74u l=0.13u
X1902 adc8b_0.sar12b_0.sg13cmos5l_dfrbp_1_20.Q a_91388_99132# sg13cmos5l_Corner_1.vss sg13cmos5l_Corner_1.vss sg13_lv_nmos ad=0.2516p pd=2.16u as=0.1406p ps=1.12u w=0.74u l=0.13u
X1903 sg13cmos5l_Corner_1.vss a_100628_98048# adc8b_0.side_cap8b_0.in_h_sw[9] sg13cmos5l_Corner_1.vss sg13_lv_nmos ad=0.14875p pd=1.16u as=0.2886p ps=2.26u w=0.74u l=0.13u
X1904 a_92086_96572# adc8b_0.sar12b_0.sg13cmos5l_a221oi_1_1.C1 adc8b_0.sar12b_0.sg13cmos5l_a22oi_1_2.B2 vdd sg13_lv_pmos ad=0.2128p pd=1.5u as=0.3808p ps=2.92u w=1.12u l=0.13u
X1905 data[2] a_102044_42476# sg13cmos5l_Corner_1.iovdd sg13cmos5l_Corner_1.iovdd sg13_hv_pmos ad=3.9294p pd=7.84u as=2.1312p ps=7.3u w=6.66u l=0.6u
X1906 adc8b_0.side_cap8b_1.buf_8_0.z adc8b_0.sar12b_0.nl_sw[4] vddr vddr sg13_lv_pmos ad=0.34p pd=2.68u as=0.19p ps=1.38u w=1u l=0.13u
X1907 vdd sg13cmos5l_IOPadVdd$1_0.sg13cmos5l_Clamp_N43N43D4R$1_0.gate sg13cmos5l_Corner_1.vss sg13cmos5l_Corner_1.vss sg13_hv_nmos ad=2.596p pd=5.58u as=1.408p ps=5.04u w=4.4u l=0.6u
X1908 sg13cmos5l_Corner_1.vss adc8b_0.sar12b_0.nh_sw[0] adc8b_0.side_cap8b_1.buf_32_1.z sg13cmos5l_Corner_1.vss sg13_lv_nmos ad=95f pd=0.88u as=95f ps=0.88u w=0.5u l=0.13u
X1909 vdd adc8b_0.sar12b_0.sg13cmos5l_inv_1_17.A adc8b_0.sar12b_0.sg13cmos5l_buf_1_37.A vdd sg13_lv_pmos ad=0.3808p pd=2.92u as=0.3808p ps=2.92u w=1.12u l=0.13u
X1910 sg13cmos5l_IOPadAnalog_13.pad a_115639_164698# sg13cmos5l_Corner_1.iovdd sg13cmos5l_Corner_1.iovdd sg13_hv_pmos ad=3.9294p pd=7.84u as=2.1312p ps=7.3u w=6.66u l=0.6u
X1911 sg13cmos5l_IOPadAnalog_12.pad a_131639_164698# sg13cmos5l_Corner_1.iovdd sg13cmos5l_Corner_1.iovdd sg13_hv_pmos ad=3.9294p pd=7.84u as=2.1312p ps=7.3u w=6.66u l=0.6u
X1912 a_36456_136075# a_40542_136405# sg13cmos5l_Corner_1.vss rppd l=20u w=1u
X1913 vdd adc8b_0.sar12b_0.sg13cmos5l_buf_1_31.X a_91216_98084# vdd sg13_lv_pmos ad=0.2114p pd=1.54u as=0.2856p ps=2.36u w=0.84u l=0.13u
X1914 vdd a_88504_93790# a_88449_93671# vdd sg13_lv_pmos ad=1.86162p pd=11.935u as=93.45f ps=0.865u w=0.42u l=0.13u
X1915 vdd sg13cmos5l_IOPadVdd$1_0.sg13cmos5l_RCClampInverter$1_0.in sg13cmos5l_IOPadVdd$1_0.sg13cmos5l_Clamp_N43N43D4R$1_0.gate vdd sg13_hv_pmos ad=1.33p pd=7.38u as=1.33p ps=7.38u w=7u l=0.5u
X1916 vdd a_86837_96536# adc8b_0.sar12b_0.sg13cmos5l_dfrbp_1_29.Q_N vdd sg13_lv_pmos ad=0.2639p pd=1.81u as=0.4312p ps=3.01u w=1.12u l=0.13u
X1917 adc8b_0.sar12b_0.sg13cmos5l_buf_1_2.X a_97552_92824# vdd vdd sg13_lv_pmos ad=0.42p pd=2.99u as=0.2114p ps=1.54u w=1.12u l=0.13u
X1918 vdd sg13cmos5l_IOPadVdd$1_0.sg13cmos5l_Clamp_N43N43D4R$1_0.gate sg13cmos5l_Corner_1.vss sg13cmos5l_Corner_1.vss sg13_hv_nmos ad=2.596p pd=5.58u as=1.408p ps=5.04u w=4.4u l=0.6u
X1919 a_100696_93006# a_100439_92863# a_100858_92786# sg13cmos5l_Corner_1.vss sg13_lv_nmos ad=0.1428p pd=1.52u as=37.8f ps=0.6u w=0.42u l=0.13u
X1920 sg13cmos5l_Corner_1.vss sg13cmos5l_IOPadVdd$1_0.sg13cmos5l_Clamp_N43N43D4R$1_0.gate vdd sg13cmos5l_Corner_1.vss sg13_hv_nmos ad=1.408p pd=5.04u as=2.596p ps=5.58u w=4.4u l=0.6u
X1921 frame a_134044_30676# sg13cmos5l_Corner_1.vss sg13cmos5l_Corner_1.vss sg13_hv_nmos ad=2.596p pd=5.58u as=1.408p ps=5.04u w=4.4u l=0.6u
X1922 sg13cmos5l_IOPadAnalog_0.pad a_178296_86044# sg13cmos5l_Corner_1.vss sg13cmos5l_Corner_1.vss sg13_hv_nmos ad=2.596p pd=5.58u as=1.408p ps=5.04u w=4.4u l=0.6u
X1923 sg13cmos5l_Corner_1.iovdd a_164624_86044# sg13cmos5l_IOPadAnalog_0.pad sg13cmos5l_Corner_1.iovdd sg13_hv_pmos ad=2.1312p pd=7.3u as=3.9294p ps=7.84u w=6.66u l=0.6u
X1924 vddr sg13cmos5l_IOPadAnalog_5.padres sg13cmos5l_Corner_1.vss rppd l=2u w=1u
X1925 a_84500_92750# adc8b_0.sar12b_0.sg13cmos5l_buf_1_37.A vdd vdd sg13_lv_pmos ad=0.2856p pd=2.36u as=0.2114p ps=1.54u w=0.84u l=0.13u
X1926 vddr adc8b_0.side_cap8b_0.in_l_sw[0] adc8b_0.side_cap8b_0.buf_32_0.z vddr sg13_lv_pmos ad=0.19p pd=1.38u as=0.19p ps=1.38u w=1u l=0.13u
X1927 adc8b_0.side_cap8b_0.buf_16_0.z adc8b_0.side_cap8b_0.in_h_sw[2] vddr vddr sg13_lv_pmos ad=0.19p pd=1.38u as=0.19p ps=1.38u w=1u l=0.13u
X1928 adc8b_0.sar12b_0.sg13cmos5l_dlhr_1_5.Q_N a_90750_98514# vdd vdd sg13_lv_pmos ad=0.3808p pd=2.92u as=0.1974p ps=1.5u w=1.12u l=0.13u
X1929 sg13cmos5l_Corner_1.iovdd a_99639_164698# sg13cmos5l_IOPadAnalog_15.pad sg13cmos5l_Corner_1.iovdd sg13_hv_pmos ad=2.1312p pd=7.3u as=3.9294p ps=7.84u w=6.66u l=0.6u
X1930 vddr adc8b_0.side_cap8b_0.in_h_sw[1] adc8b_0.side_cap8b_0.buf_16_3.z vddr sg13_lv_pmos ad=0.19p pd=1.38u as=0.19p ps=1.38u w=1u l=0.13u
X1931 vdd sg13cmos5l_Corner_1.vss vdd vdd sg13_lv_pmos ad=0.34p pd=2.68u as=0 ps=0 w=1u l=1u
X1932 a_94862_98084# a_94466_98448# a_94748_98084# vdd sg13_lv_pmos ad=0.1008p pd=0.9u as=0.191p ps=1.44u w=0.42u l=0.13u
X1933 a_94258_97545# a_94701_97301# a_94641_97713# vdd sg13_lv_pmos ad=79.8f pd=0.8u as=63f ps=0.72u w=0.42u l=0.13u
X1934 a_92232_93587# adc8b_0.sar12b_0.sg13cmos5l_nand2_1_1.B a_92195_93896# sg13cmos5l_Corner_1.vss sg13_lv_nmos ad=0.2176p pd=1.96u as=78.39999f ps=0.885u w=0.64u l=0.13u
X1935 vddr adc8b_0.sar12b_0.nh_sw[2] adc8b_0.side_cap8b_1.buf_16_0.z vddr sg13_lv_pmos ad=0.19p pd=1.38u as=0.19p ps=1.38u w=1u l=0.13u
X1936 sg13cmos5l_Corner_1.vss sg13cmos5l_IOPadVdd$1_0.sg13cmos5l_RCClampInverter$1_0.in sg13cmos5l_Corner_1.vss sg13cmos5l_Corner_1.vss sg13_hv_nmos ad=1.71p pd=9.38u as=0 ps=0 w=9u l=9.5u
X1937 a_94317_100325# adc8b_0.sar12b_0.sg13cmos5l_inv_1_2.A sg13cmos5l_Corner_1.vss sg13cmos5l_Corner_1.vss sg13_lv_nmos ad=0.2516p pd=2.16u as=2.71505p ps=17.54u w=0.74u l=0.13u
X1938 cko a_102160_98872# sg13cmos5l_Corner_1.vss sg13cmos5l_Corner_1.vss sg13_lv_nmos ad=0.2886p pd=2.26u as=0.14875p ps=1.16u w=0.74u l=0.13u
X1939 adc8b_0.side_cap8b_0.buf_16_0.z adc8b_0.side_cap8b_0.in_h_sw[2] sg13cmos5l_Corner_1.vss sg13cmos5l_Corner_1.vss sg13_lv_nmos ad=95f pd=0.88u as=95f ps=0.88u w=0.5u l=0.13u
X1940 sg13cmos5l_Corner_1.vss adc8b_0.side_cap8b_0.in_h_sw[6] adc8b_0.side_cap8b_0.buf_4_1.z sg13cmos5l_Corner_1.vss sg13_lv_nmos ad=95f pd=0.88u as=95f ps=0.88u w=0.5u l=0.13u
X1941 vdd a_89972_100310# adc8b_0.sar12b_0.sg13cmos5l_buf_1_74.X vdd sg13_lv_pmos ad=0.2114p pd=1.54u as=0.42p ps=2.99u w=1.12u l=0.13u
X1942 a_101780_93512# adc8b_0.sar12b_0.sg13cmos5l_buf_1_0.X sg13cmos5l_Corner_1.vss sg13cmos5l_Corner_1.vss sg13_lv_nmos ad=0.187p pd=1.78u as=0.14875p ps=1.16u w=0.55u l=0.13u
X1943 a_84364_99156# a_84389_98796# sg13cmos5l_Corner_1.vss sg13cmos5l_Corner_1.vss sg13_lv_nmos ad=0.2775p pd=2.23u as=1.49685p ps=9.6u w=0.74u l=0.13u
X1944 a_86962_93516# a_87405_93559# a_86702_93986# sg13cmos5l_Corner_1.vss sg13_lv_nmos ad=79.8f pd=0.8u as=0.1296p ps=1.52u w=0.42u l=0.13u
X1945 a_93298_93009# a_93741_92765# a_93038_92786# sg13cmos5l_Corner_1.vss sg13_lv_nmos ad=79.8f pd=0.8u as=0.1296p ps=1.52u w=0.42u l=0.13u
X1946 a_94840_95302# a_94583_95421# a_95002_95498# sg13cmos5l_Corner_1.vss sg13_lv_nmos ad=0.1428p pd=1.52u as=37.8f ps=0.6u w=0.42u l=0.13u
X1947 sg13cmos5l_Corner_1.vss adc8b_0.sar12b_0.sg13cmos5l_inv_1_5.A adc8b_0.sar12b_0.sg13cmos5l_a22oi_1_1.A1 sg13cmos5l_Corner_1.vss sg13_lv_nmos ad=0.2516p pd=2.16u as=0.2516p ps=2.16u w=0.74u l=0.13u
X1948 sg13cmos5l_Corner_1.vss a_152182_124462# dantenna l=0.64u w=3.1u
X1949 sg13cmos5l_Corner_1.vss a_131639_178370# sg13cmos5l_IOPadAnalog_12.pad sg13cmos5l_Corner_1.vss sg13_hv_nmos ad=1.408p pd=5.04u as=2.596p ps=5.58u w=4.4u l=0.6u
X1950 adc8b_0.sar12b_0.sg13cmos5l_dlhr_1_2.Q_N a_89790_94280# sg13cmos5l_Corner_1.vss sg13cmos5l_Corner_1.vss sg13_lv_nmos ad=0.2516p pd=2.16u as=0.1491p ps=1.18u w=0.74u l=0.13u
X1951 adc8b_0.side_cap8b_1.buf_32_0.z adc8b_0.sar12b_0.nl_sw[0] vddr vddr sg13_lv_pmos ad=0.19p pd=1.38u as=0.19p ps=1.38u w=1u l=0.13u
X1952 vdd adc8b_0.sar12b_0.sg13cmos5l_dlygate4sd3_1_0.X adc8b_0.sar12b_0.sg13cmos5l_buf_1_43.A vdd sg13_lv_pmos ad=0.3808p pd=2.92u as=0.3808p ps=2.92u w=1.12u l=0.13u
X1953 sg13cmos5l_Corner_1.vss sg13cmos5l_IOPadVdd$1_0.sg13cmos5l_RCClampInverter$1_0.in sg13cmos5l_Corner_1.vss sg13cmos5l_Corner_1.vss sg13_hv_nmos ad=1.71p pd=9.38u as=0 ps=0 w=9u l=9.5u
X1954 adc8b_0.cmp_0.outn adc8b_0.cmp_0.outp vdd vdd sg13_lv_pmos ad=0.425p pd=3.18u as=0.2375p ps=1.63u w=1.25u l=0.13u
X1955 adc8b_0.sar12b_0.sg13cmos5l_buf_1_18.A adc8b_0.sar12b_0.sg13cmos5l_buf_1_111.A vdd vdd sg13_lv_pmos ad=0.3808p pd=2.92u as=0.3808p ps=2.92u w=1.12u l=0.13u
X1956 a_90542_96572# a_90146_96936# a_90428_96572# vdd sg13_lv_pmos ad=0.1008p pd=0.9u as=0.191p ps=1.44u w=0.42u l=0.13u
X1957 sg13cmos5l_Corner_1.vss adc8b_0.diff_bsw_0.single_bsw_1.sg13cmos5l_inv_1$1_0.A a_70946_94286# sg13cmos5l_Corner_1.vss sg13_lv_nmos ad=1.02p pd=6.68u as=0.57p ps=3.38u w=3u l=0.13u
X1958 a_99261_95107# a_98319_95147# a_99167_95107# vdd sg13_lv_pmos ad=79.8f pd=0.8u as=0.1428p ps=1.52u w=0.42u l=0.13u
X1959 sg13cmos5l_Corner_1.iovdd a_118044_42476# cko sg13cmos5l_Corner_1.iovdd sg13_hv_pmos ad=3.1302p pd=14.26u as=3.9294p ps=7.84u w=6.66u l=0.6u
X1960 sg13cmos5l_Corner_1.vss a_178296_118044# sg13cmos5l_IOPadAnalog_11.pad sg13cmos5l_Corner_1.vss sg13_hv_nmos ad=1.408p pd=5.04u as=2.596p ps=5.58u w=4.4u l=0.6u
X1961 sg13cmos5l_Corner_1.vss a_30676_70044# vddr sg13cmos5l_Corner_1.vss sg13_hv_nmos ad=1.408p pd=5.04u as=2.596p ps=5.58u w=4.4u l=0.6u
X1962 adc8b_0.side_cap8b_0.buf_32_0.z adc8b_0.side_cap8b_0.in_l_sw[0] sg13cmos5l_Corner_1.vss sg13cmos5l_Corner_1.vss sg13_lv_nmos ad=95f pd=0.88u as=95f ps=0.88u w=0.5u l=0.13u
X1963 sg13cmos5l_Corner_1.vss a_101108_99560# adc8b_0.side_cap8b_0.in_l_sw[9] sg13cmos5l_Corner_1.vss sg13_lv_nmos ad=0.14875p pd=1.16u as=0.2886p ps=2.26u w=0.74u l=0.13u
X1964 a_95254_96572# adc8b_0.sar12b_0.sg13cmos5l_or2_1_1.B a_95466_96572# vdd sg13_lv_pmos ad=0.2128p pd=1.5u as=0.3808p ps=2.92u w=1.12u l=0.13u
X1965 data[2] a_102044_42476# sg13cmos5l_Corner_1.iovdd sg13cmos5l_Corner_1.iovdd sg13_hv_pmos ad=3.9294p pd=7.84u as=2.1312p ps=7.3u w=6.66u l=0.6u
X1966 a_86988_93552# a_86962_93516# vdd vdd sg13_lv_pmos ad=0.34p pd=2.68u as=0.36237p ps=2.605u w=1u l=0.13u
X1967 vdd a_93741_95071# a_93843_95071# vdd sg13_lv_pmos ad=1.43437p pd=9.105u as=0.3864p ps=2.93u w=1.12u l=0.13u
X1968 sg13cmos5l_IOPadAnalog_1.pad a_178296_70044# sg13cmos5l_Corner_1.vss sg13cmos5l_Corner_1.vss sg13_hv_nmos ad=2.596p pd=5.58u as=1.408p ps=5.04u w=4.4u l=0.6u
X1969 sg13cmos5l_Corner_1.vss a_86222_33862# dantenna l=1.26u w=27.78u
X1970 vddr adc8b_0.side_cap8b_0.in_l_sw[1] adc8b_0.side_cap8b_0.buf_16_2.z vddr sg13_lv_pmos ad=0.19p pd=1.38u as=0.19p ps=1.38u w=1u l=0.13u
X1971 sg13cmos5l_IOPadAnalog_11.pad a_164624_118044# sg13cmos5l_Corner_1.iovdd sg13cmos5l_Corner_1.iovdd sg13_hv_pmos ad=3.9294p pd=7.84u as=2.1312p ps=7.3u w=6.66u l=0.6u
X1972 sg13cmos5l_IOPadAnalog_13.pad a_115639_178370# sg13cmos5l_Corner_1.vss sg13cmos5l_Corner_1.vss sg13_hv_nmos ad=2.596p pd=5.58u as=2.068p ps=9.74u w=4.4u l=0.6u
X1973 sg13cmos5l_IOPadAnalog_9.pad a_83639_164698# sg13cmos5l_Corner_1.iovdd sg13cmos5l_Corner_1.iovdd sg13_hv_pmos ad=3.9294p pd=7.84u as=2.1312p ps=7.3u w=6.66u l=0.6u
X1974 sg13cmos5l_IOPadAnalog_12.pad a_131639_178370# sg13cmos5l_Corner_1.vss sg13cmos5l_Corner_1.vss sg13_hv_nmos ad=2.596p pd=5.58u as=1.408p ps=5.04u w=4.4u l=0.6u
X1975 frame a_134044_42476# sg13cmos5l_Corner_1.iovdd sg13cmos5l_Corner_1.iovdd sg13_hv_pmos ad=3.9294p pd=7.84u as=2.1312p ps=7.3u w=6.66u l=0.6u
X1976 adc8b_0.side_cap8b_1.buf_16_2.z adc8b_0.sar12b_0.nl_sw[1] sg13cmos5l_Corner_1.vss sg13cmos5l_Corner_1.vss sg13_lv_nmos ad=95f pd=0.88u as=95f ps=0.88u w=0.5u l=0.13u
X1977 sg13cmos5l_Corner_1.iovdd a_42476_70044# vddr sg13cmos5l_Corner_1.iovdd sg13_hv_pmos ad=2.1312p pd=7.3u as=3.9294p ps=7.84u w=6.66u l=0.6u
X1978 sg13cmos5l_Corner_1.vss a_88727_97399# a_89564_97620# sg13cmos5l_Corner_1.vss sg13_lv_nmos ad=0.1406p pd=1.12u as=0.2516p ps=2.16u w=0.74u l=0.13u
X1979 data[0] a_70044_30676# sg13cmos5l_Corner_1.vss sg13cmos5l_Corner_1.vss sg13_hv_nmos ad=2.596p pd=5.58u as=1.408p ps=5.04u w=4.4u l=0.6u
X1980 vddr adc8b_0.sar12b_0.nl_sw[3] adc8b_0.side_cap8b_1.buf_8_1.z vddr sg13_lv_pmos ad=0.19p pd=1.38u as=0.19p ps=1.38u w=1u l=0.13u
X1981 a_95252_99560# adc8b_0.sar12b_0.sg13cmos5l_dlhr_1_11.Q sg13cmos5l_Corner_1.vss sg13cmos5l_Corner_1.vss sg13_lv_nmos ad=0.187p pd=1.78u as=0.14875p ps=1.16u w=0.55u l=0.13u
X1982 sg13cmos5l_Corner_1.vss adc8b_0.cmp_0.clk a_74586_95659# sg13cmos5l_Corner_1.vss sg13_lv_nmos ad=95f pd=0.88u as=0.17p ps=1.68u w=0.5u l=0.13u
X1983 vddr adc8b_0.sar12b_0.nh_sw[5] adc8b_0.side_cap8b_1.buf_8_5.z vddr sg13_lv_pmos ad=0.19p pd=1.38u as=0.19p ps=1.38u w=1u l=0.13u
X1984 sg13cmos5l_Corner_1.vss a_100977_96929# a_101502_97002# sg13cmos5l_Corner_1.vss sg13_lv_nmos ad=0.1491p pd=1.18u as=0.187p ps=1.78u w=0.55u l=0.13u
X1985 a_36456_140695# a_40542_140365# sg13cmos5l_Corner_1.vss rppd l=20u w=1u
X1986 a_89217_99719# a_88275_99607# a_89015_99957# vdd sg13_lv_pmos ad=93.45f pd=0.865u as=0.2048p ps=1.63u w=0.42u l=0.13u
X1987 sg13cmos5l_Corner_1.iovdd a_131639_164698# sg13cmos5l_IOPadAnalog_12.pad sg13cmos5l_Corner_1.iovdd sg13_hv_pmos ad=2.1312p pd=7.3u as=3.9294p ps=7.84u w=6.66u l=0.6u
X1988 cks a_30676_118044# sg13cmos5l_Corner_1.vss sg13cmos5l_Corner_1.vss sg13_hv_nmos ad=2.596p pd=5.58u as=1.408p ps=5.04u w=4.4u l=0.6u
X1989 sg13cmos5l_Corner_1.vss a_30676_102044# vip sg13cmos5l_Corner_1.vss sg13_hv_nmos ad=1.408p pd=5.04u as=2.596p ps=5.58u w=4.4u l=0.6u
X1990 vip a_42476_102044# sg13cmos5l_Corner_1.iovdd sg13cmos5l_Corner_1.iovdd sg13_hv_pmos ad=3.9294p pd=7.84u as=2.1312p ps=7.3u w=6.66u l=0.6u
X1991 sg13cmos5l_Corner_1.iovdd a_67639_164698# sg13cmos5l_IOPadAnalog_10.pad sg13cmos5l_Corner_1.iovdd sg13_hv_pmos ad=2.1312p pd=7.3u as=3.9294p ps=7.84u w=6.66u l=0.6u
X1992 sg13cmos5l_Corner_1.vss a_99135_99954# a_99266_99960# sg13cmos5l_Corner_1.vss sg13_lv_nmos ad=2.92392p pd=18.89u as=0.2775p ps=2.23u w=0.74u l=0.13u
X1993 sg13cmos5l_Corner_1.vss a_98445_97301# a_98547_97444# sg13cmos5l_Corner_1.vss sg13_lv_nmos ad=1.97045p pd=12.335u as=0.2516p ps=2.16u w=0.74u l=0.13u
X1994 frame sg13cmos5l_Corner_1.iovdd dpantenna l=1.26u w=27.78u
X1995 vddr adc8b_0.sar12b_0.nl_sw[1] adc8b_0.side_cap8b_1.buf_16_2.z vddr sg13_lv_pmos ad=0.19p pd=1.38u as=0.19p ps=1.38u w=1u l=0.13u
X1996 adc8b_0.side_cap8b_1.buf_32_0.z adc8b_0.sar12b_0.nl_sw[0] sg13cmos5l_Corner_1.vss sg13cmos5l_Corner_1.vss sg13_lv_nmos ad=95f pd=0.88u as=95f ps=0.88u w=0.5u l=0.13u
X1997 sg13cmos5l_Corner_1.iovdd a_42476_70044# vddr sg13cmos5l_Corner_1.iovdd sg13_hv_pmos ad=2.1312p pd=7.3u as=3.9294p ps=7.84u w=6.66u l=0.6u
X1998 vdd a_98061_95789# a_98163_95932# vdd sg13_lv_pmos ad=1.28962p pd=8.195u as=0.3864p ps=2.93u w=1.12u l=0.13u
X1999 sg13cmos5l_Corner_1.vss adc8b_0.cmp_0.outp a_82192_92824# sg13cmos5l_Corner_1.vss sg13_lv_nmos ad=0.14875p pd=1.16u as=0.187p ps=1.78u w=0.55u l=0.13u
X2000 sg13cmos5l_Corner_1.vss adc8b_0.sar12b_0.nl_sw[0] adc8b_0.side_cap8b_1.buf_32_0.z sg13cmos5l_Corner_1.vss sg13_lv_nmos ad=95f pd=0.88u as=95f ps=0.88u w=0.5u l=0.13u
X2001 sg13cmos5l_IOPadAnalog_4.padres sg13cmos5l_Corner_1.iovdd dpantenna l=4.98u w=0.64u
X2002 a_94785_93101# a_93843_92908# a_94583_92863# vdd sg13_lv_pmos ad=93.45f pd=0.865u as=0.2048p ps=1.63u w=0.42u l=0.13u
X2003 sg13cmos5l_Corner_1.vss a_102222_176786# dantenna l=1.26u w=27.78u
X2004 a_83430_99534# a_83231_99671# sg13cmos5l_Corner_1.vss sg13cmos5l_Corner_1.vss sg13_lv_nmos ad=0.27427p pd=2.28u as=2.92392p ps=18.89u w=0.795u l=0.13u
X2005 vdd a_88148_98798# adc8b_0.side_cap8b_0.in_l_sw[3] vdd sg13_lv_pmos ad=0.2114p pd=1.54u as=0.42p ps=2.99u w=1.12u l=0.13u
X2006 sg13cmos5l_Corner_1.vss adc8b_0.sar12b_0.sg13cmos5l_buf_1_31.X a_91216_98084# sg13cmos5l_Corner_1.vss sg13_lv_nmos ad=0.14875p pd=1.16u as=0.187p ps=1.78u w=0.55u l=0.13u
X2007 sg13cmos5l_Corner_1.vss a_86837_96536# adc8b_0.sar12b_0.sg13cmos5l_dfrbp_1_29.Q_N sg13cmos5l_Corner_1.vss sg13_lv_nmos ad=0.2516p pd=2.16u as=0.2849p ps=2.25u w=0.74u l=0.13u
X2008 a_99865_98826# a_99313_98888# sg13cmos5l_Corner_1.vss sg13cmos5l_Corner_1.vss sg13_lv_nmos ad=71.99999f pd=0.865u as=1.49685p ps=9.6u w=0.64u l=0.13u
X2009 a_98002_97545# a_98445_97301# a_98385_97713# vdd sg13_lv_pmos ad=79.8f pd=0.8u as=63f ps=0.72u w=0.42u l=0.13u
X2010 vdd sg13cmos5l_Corner_1.vss vdd vdd sg13_lv_pmos ad=0.19p pd=1.38u as=0 ps=0 w=1u l=1u
X2011 sg13cmos5l_Corner_1.vss a_178296_86044# sg13cmos5l_IOPadAnalog_0.pad sg13cmos5l_Corner_1.vss sg13_hv_nmos ad=1.408p pd=5.04u as=2.596p ps=5.58u w=4.4u l=0.6u
X2012 sg13cmos5l_IOPadAnalog_16.pad a_164624_102044# sg13cmos5l_Corner_1.iovdd sg13cmos5l_Corner_1.iovdd sg13_hv_pmos ad=3.9294p pd=7.84u as=2.1312p ps=7.3u w=6.66u l=0.6u
X2013 vdd sg13cmos5l_IOPadVdd$1_0.sg13cmos5l_Clamp_N43N43D4R$1_0.gate sg13cmos5l_Corner_1.vss sg13cmos5l_Corner_1.vss sg13_hv_nmos ad=2.596p pd=5.58u as=1.408p ps=5.04u w=4.4u l=0.6u
X2014 adc8b_0.sar12b_0.sg13cmos5l_dlhr_1_18.Q_N a_92958_98514# vdd vdd sg13_lv_pmos ad=0.3808p pd=2.92u as=0.1974p ps=1.5u w=1.12u l=0.13u
X2015 adc8b_0.cmp_0.sg13cmos5l_dlygate4sd3_1$1_0.A a_79552_97015# sg13cmos5l_Corner_1.vss sg13cmos5l_Corner_1.vss sg13_lv_nmos ad=0.2516p pd=2.16u as=0.1469p ps=1.155u w=0.74u l=0.13u
X2016 vdd a_98519_93909# a_99356_93548# vdd sg13_lv_pmos ad=0.2128p pd=1.5u as=0.3864p ps=2.93u w=1.12u l=0.13u
X2017 vdd a_97268_100310# adc8b_0.side_cap8b_0.in_h_sw[6] vdd sg13_lv_pmos ad=0.2114p pd=1.54u as=0.42p ps=2.99u w=1.12u l=0.13u
X2018 sg13cmos5l_Corner_1.vss a_30676_118044# cks sg13cmos5l_Corner_1.vss sg13_hv_nmos ad=1.408p pd=5.04u as=2.596p ps=5.58u w=4.4u l=0.6u
X2019 adc8b_0.sar12b_0.sg13cmos5l_or2_1_0.A a_100131_95430# vdd vdd sg13_lv_pmos ad=0.2128p pd=1.5u as=0.2128p ps=1.5u w=1.12u l=0.13u
X2020 sg13cmos5l_Corner_1.vss adc8b_0.sar12b_0.sg13cmos5l_dlhr_1_15.Q a_101008_98872# sg13cmos5l_Corner_1.vss sg13_lv_nmos ad=0.14875p pd=1.16u as=0.187p ps=1.78u w=0.55u l=0.13u
X2021 sg13cmos5l_Corner_1.vss adc8b_0.sar12b_0.sg13cmos5l_dfrbp_1_8.RESET_B a_84242_97322# sg13cmos5l_Corner_1.vss sg13_lv_nmos ad=79.8f pd=0.8u as=37.8f ps=0.6u w=0.42u l=0.13u
X2022 vdd a_90801_97322# a_90734_97760# vdd sg13_lv_pmos ad=0.2387p pd=1.84u as=0.1008p ps=0.9u w=0.42u l=0.13u
X2023 a_90552_97644# a_90001_97376# vdd vdd sg13_lv_pmos ad=0.105p pd=1.21u as=1.07253p ps=6.75u w=1u l=0.13u
X2024 frame a_134044_42476# sg13cmos5l_Corner_1.iovdd sg13cmos5l_Corner_1.iovdd sg13_hv_pmos ad=3.9294p pd=7.84u as=2.1312p ps=7.3u w=6.66u l=0.6u
X2025 adc8b_0.diff_bsw_0.single_bsw_0.sg13cmos5l_inv_1$1_0.A cks vdd vdd sg13_lv_pmos ad=0.3808p pd=2.92u as=0.3808p ps=2.92u w=1.12u l=0.13u
X2026 data[0] a_70044_42476# sg13cmos5l_Corner_1.iovdd sg13cmos5l_Corner_1.iovdd sg13_hv_pmos ad=3.9294p pd=7.84u as=2.1312p ps=7.3u w=6.66u l=0.6u
X2027 sg13cmos5l_Corner_1.vss a_82388_93512# adc8b_0.sar12b_0.nl_sw[0] sg13cmos5l_Corner_1.vss sg13_lv_nmos ad=0.14875p pd=1.16u as=0.2886p ps=2.26u w=0.74u l=0.13u
X2028 adc8b_0.side_cap8b_0.buf_32_0.z adc8b_0.side_cap8b_0.in_l_sw[0] vddr vddr sg13_lv_pmos ad=0.19p pd=1.38u as=0.19p ps=1.38u w=1u l=0.13u
X2029 sg13cmos5l_IOPadAnalog_9.pad a_83639_178370# sg13cmos5l_Corner_1.vss sg13cmos5l_Corner_1.vss sg13_hv_nmos ad=2.596p pd=5.58u as=2.068p ps=9.74u w=4.4u l=0.6u
X2030 adc8b_0.side_cap8b_0.buf_16_3.z adc8b_0.side_cap8b_0.in_h_sw[1] vddr vddr sg13_lv_pmos ad=0.19p pd=1.38u as=0.19p ps=1.38u w=1u l=0.13u
X2031 vddr adc8b_0.side_cap8b_0.in_h_sw[2] adc8b_0.side_cap8b_0.buf_16_0.z vddr sg13_lv_pmos ad=0.19p pd=1.38u as=0.19p ps=1.38u w=1u l=0.13u
X2032 sg13cmos5l_Corner_1.vss adc8b_0.side_cap8b_0.in_h_sw[4] adc8b_0.side_cap8b_0.buf_8_2.z sg13cmos5l_Corner_1.vss sg13_lv_nmos ad=95f pd=0.88u as=95f ps=0.88u w=0.5u l=0.13u
X2033 sg13cmos5l_Corner_1.vss sg13cmos5l_IOPadVdd$1_0.sg13cmos5l_Clamp_N43N43D4R$1_0.gate vdd sg13cmos5l_Corner_1.vss sg13_hv_nmos ad=1.408p pd=5.04u as=2.596p ps=5.58u w=4.4u l=0.6u
X2034 a_94317_100325# adc8b_0.sar12b_0.sg13cmos5l_inv_1_2.A vdd vdd sg13_lv_pmos ad=0.4088p pd=2.97u as=4.11675p ps=27.17u w=1.12u l=0.13u
X2035 adc8b_0.sar12b_0.sg13cmos5l_buf_1_104.X a_101392_99596# vdd vdd sg13_lv_pmos ad=0.42p pd=2.99u as=0.2114p ps=1.54u w=1.12u l=0.13u
X2036 sg13cmos5l_IOPadAnalog_13.pad a_115639_164698# sg13cmos5l_Corner_1.iovdd sg13cmos5l_Corner_1.iovdd sg13_hv_pmos ad=3.9294p pd=7.84u as=2.1312p ps=7.3u w=6.66u l=0.6u
X2037 vdd a_83992_96814# a_83937_96695# vdd sg13_lv_pmos ad=1.28962p pd=8.195u as=93.45f ps=0.865u w=0.42u l=0.13u
X2038 a_89972_93512# adc8b_0.sar12b_0.sg13cmos5l_dlhr_1_2.Q vdd vdd sg13_lv_pmos ad=0.2856p pd=2.36u as=0.2114p ps=1.54u w=0.84u l=0.13u
X2039 sg13cmos5l_IOPadAnalog_17.padres sg13cmos5l_Corner_1.iovdd dpantenna l=0.64u w=4.98u
X2040 a_91884_98834# adc8b_0.sar12b_0.sg13cmos5l_buf_1_57.X a_91790_98834# sg13cmos5l_Corner_1.vss sg13_lv_nmos ad=60.89999f pd=0.71u as=0.1428p ps=1.52u w=0.42u l=0.13u
X2041 a_89977_98486# a_89425_98442# sg13cmos5l_Corner_1.vss sg13cmos5l_Corner_1.vss sg13_lv_nmos ad=71.99999f pd=0.865u as=1.49685p ps=9.6u w=0.64u l=0.13u
X2042 sg13cmos5l_Corner_1.vss a_131639_178370# sg13cmos5l_IOPadAnalog_12.pad sg13cmos5l_Corner_1.vss sg13_hv_nmos ad=1.408p pd=5.04u as=2.596p ps=5.58u w=4.4u l=0.6u
X2043 sg13cmos5l_Corner_1.vss a_96813_99607# a_96915_99607# sg13cmos5l_Corner_1.vss sg13_lv_nmos ad=2.92392p pd=18.89u as=0.2516p ps=2.16u w=0.74u l=0.13u
X2044 vdd sg13cmos5l_Corner_1.vss vdd vdd sg13_lv_pmos ad=0.19p pd=1.38u as=0 ps=0 w=1u l=1u
X2045 data[0] sg13cmos5l_Corner_1.iovdd dpantenna l=1.26u w=27.78u
X2046 vdd a_101780_93512# adc8b_0.sar12b_0.nl_sw[10] vdd sg13_lv_pmos ad=0.2114p pd=1.54u as=0.42p ps=2.99u w=1.12u l=0.13u
X2047 sg13cmos5l_Corner_1.vss adc8b_0.side_cap8b_0.in_l_sw[5] adc8b_0.side_cap8b_0.buf_8_4.z sg13cmos5l_Corner_1.vss sg13_lv_nmos ad=95f pd=0.88u as=95f ps=0.88u w=0.5u l=0.13u
X2048 a_96754_99057# a_97197_98813# a_96494_98834# sg13cmos5l_Corner_1.vss sg13_lv_nmos ad=79.8f pd=0.8u as=0.1296p ps=1.52u w=0.42u l=0.13u
X2049 a_96780_99152# a_96754_99057# sg13cmos5l_Corner_1.vss sg13cmos5l_Corner_1.vss sg13_lv_nmos ad=0.2516p pd=2.16u as=0.1626p ps=1.415u w=0.74u l=0.13u
X2050 adc8b_0.side_cap8b_1.buf_2_2.z adc8b_0.sar12b_0.nl_sw[9] vddr vddr sg13_lv_pmos ad=0.34p pd=2.68u as=0.19p ps=1.38u w=1u l=0.13u
X2051 a_93900_100664# a_94419_100468# a_95159_100423# sg13cmos5l_Corner_1.vss sg13_lv_nmos ad=0.3473p pd=2.71u as=0.12665p ps=1.145u w=0.74u l=0.13u
X2052 a_90766_100021# adc8b_0.sar12b_0.sg13cmos5l_dfrbp_1_8.RESET_B sg13cmos5l_Corner_1.vss sg13cmos5l_Corner_1.vss sg13_lv_nmos ad=37.8f pd=0.6u as=0.1701p ps=1.65u w=0.42u l=0.13u
X2053 vdd adc8b_0.sar12b_0.sg13cmos5l_dfrbp_1_8.RESET_B a_90514_99564# vdd sg13_lv_pmos ad=0.1563p pd=1.22u as=0.147p ps=1.54u w=0.42u l=0.13u
X2054 a_84116_98784# a_84364_99156# a_84322_99272# vdd sg13_lv_pmos ad=0.191p pd=1.44u as=0.1008p ps=0.9u w=0.42u l=0.13u
X2055 adc8b_0.side_cap8b_1.buf_4_3.z adc8b_0.sar12b_0.nl_sw[6] sg13cmos5l_Corner_1.vss sg13cmos5l_Corner_1.vss sg13_lv_nmos ad=95f pd=0.88u as=95f ps=0.88u w=0.5u l=0.13u
X2056 vdd adc8b_0.sar12b_0.sg13cmos5l_dfrbp_1_0.RESET_B a_93038_92786# vdd sg13_lv_pmos ad=0.36237p pd=2.605u as=79.8f ps=0.8u w=0.42u l=0.13u
X2057 sg13cmos5l_Corner_1.vss sg13cmos5l_IOPadVdd$1_0.sg13cmos5l_Clamp_N43N43D4R$1_0.gate vdd sg13cmos5l_Corner_1.vss sg13_hv_nmos ad=1.408p pd=5.04u as=2.596p ps=5.58u w=4.4u l=0.6u
X2058 vddr adc8b_0.sar12b_0.nh_sw[1] adc8b_0.side_cap8b_1.buf_16_3.z vddr sg13_lv_pmos ad=0.19p pd=1.38u as=0.19p ps=1.38u w=1u l=0.13u
X2059 vdd sg13cmos5l_IOPadVdd$1_0.sg13cmos5l_Clamp_N43N43D4R$1_0.gate sg13cmos5l_Corner_1.vss sg13cmos5l_Corner_1.vss sg13_hv_nmos ad=2.596p pd=5.58u as=1.408p ps=5.04u w=4.4u l=0.6u
X2060 a_97652_94262# adc8b_0.sar12b_0.sg13cmos5l_buf_1_5.X vdd vdd sg13_lv_pmos ad=0.2856p pd=2.36u as=0.2114p ps=1.54u w=0.84u l=0.13u
X2061 adc8b_0.side_cap8b_0.buf_16_1.z adc8b_0.side_cap8b_0.in_l_sw[2] sg13cmos5l_Corner_1.vss sg13cmos5l_Corner_1.vss sg13_lv_nmos ad=95f pd=0.88u as=95f ps=0.88u w=0.5u l=0.13u
X2062 a_101780_92750# adc8b_0.sar12b_0.sg13cmos5l_buf_1_0.A sg13cmos5l_Corner_1.vss sg13cmos5l_Corner_1.vss sg13_lv_nmos ad=0.187p pd=1.78u as=0.14875p ps=1.16u w=0.55u l=0.13u
X2063 sg13cmos5l_Corner_1.vss a_70222_176786# dantenna l=1.26u w=27.78u
X2064 a_100248_96188# adc8b_0.sar12b_0.sg13cmos5l_dfrbp_1_0.D sg13cmos5l_Corner_1.vss sg13cmos5l_Corner_1.vss sg13_lv_nmos ad=0.1045p pd=0.93u as=0.187p ps=1.78u w=0.55u l=0.13u
X2065 a_97589_95024# a_98319_95147# a_98340_95421# sg13cmos5l_Corner_1.vss sg13_lv_nmos ad=0.12665p pd=1.145u as=0.3473p ps=2.71u w=0.74u l=0.13u
X2066 adc8b_0.sar12b_0.sg13cmos5l_buf_1_89.A a_96657_98441# sg13cmos5l_Corner_1.vss sg13cmos5l_Corner_1.vss sg13_lv_nmos ad=0.2516p pd=2.16u as=0.1406p ps=1.12u w=0.74u l=0.13u
X2067 vdd adc8b_0.sar12b_0.sg13cmos5l_nor2_1_0.A a_93748_96108# vdd sg13_lv_pmos ad=0.4032p pd=2.96u as=0.1176p ps=1.33u w=1.12u l=0.13u
X2068 adc8b_0.sar12b_0.sg13cmos5l_dlhr_1_4.Q_N a_87966_94280# vdd vdd sg13_lv_pmos ad=0.3808p pd=2.92u as=0.1974p ps=1.5u w=1.12u l=0.13u
X2069 adc8b_0.side_cap8b_1.buf_16_0.z adc8b_0.sar12b_0.nh_sw[2] sg13cmos5l_Corner_1.vss sg13cmos5l_Corner_1.vss sg13_lv_nmos ad=95f pd=0.88u as=95f ps=0.88u w=0.5u l=0.13u
X2070 sg13cmos5l_Corner_1.vss adc8b_0.sar12b_0.sg13cmos5l_dfrbp_1_6.RESET_B a_87276_97322# sg13cmos5l_Corner_1.vss sg13_lv_nmos ad=0.1626p pd=1.415u as=60.89999f ps=0.71u w=0.42u l=0.13u
X2071 sg13cmos5l_Corner_1.vss a_173384_130682# dantenna l=1.26u w=27.78u
X2072 a_72090_98590# adc8b_0.diff_bsw_0.single_bsw_0.sg13cmos5l_inv_1$1_2.Y w_71686_98280# w_71686_98280# sg13_lv_pmos ad=0.17p pd=1.68u as=0.17p ps=1.68u w=0.5u l=0.13u
X2073 adc8b_0.sar12b_0.sg13cmos5l_dlhr_1_13.Q_N a_97182_98514# sg13cmos5l_Corner_1.vss sg13cmos5l_Corner_1.vss sg13_lv_nmos ad=0.2516p pd=2.16u as=0.1491p ps=1.18u w=0.74u l=0.13u
X2074 vdd adc8b_0.sar12b_0.sg13cmos5l_dfrbp_1_0.RESET_B a_94766_94298# vdd sg13_lv_pmos ad=0.36237p pd=2.605u as=79.8f ps=0.8u w=0.42u l=0.13u
X2075 adc8b_0.sar12b_0.sg13cmos5l_dfrbp_1_17.D a_83430_99534# vdd vdd sg13_lv_pmos ad=0.3927p pd=2.99u as=1.15047p ps=7.175u w=1.155u l=0.13u
X2076 data[0] a_70044_42476# sg13cmos5l_Corner_1.iovdd sg13cmos5l_Corner_1.iovdd sg13_hv_pmos ad=3.9294p pd=7.84u as=2.1312p ps=7.3u w=6.66u l=0.6u
X2077 sg13cmos5l_Corner_1.vss adc8b_0.sar12b_0.nl_sw[1] adc8b_0.side_cap8b_1.buf_16_2.z sg13cmos5l_Corner_1.vss sg13_lv_nmos ad=95f pd=0.88u as=95f ps=0.88u w=0.5u l=0.13u
X2078 sg13cmos5l_Corner_1.vss adc8b_0.sar12b_0.sg13cmos5l_dfrbp_1_6.RESET_B a_89692_92772# sg13cmos5l_Corner_1.vss sg13_lv_nmos ad=0.1406p pd=1.12u as=77.7f ps=0.95u w=0.74u l=0.13u
X2079 vdd a_95252_99560# adc8b_0.sar12b_0.sg13cmos5l_buf_1_5.A vdd sg13_lv_pmos ad=0.2114p pd=1.54u as=0.42p ps=2.99u w=1.12u l=0.13u
X2080 vdd adc8b_0.sar12b_0.sg13cmos5l_inv_1_5.A adc8b_0.sar12b_0.sg13cmos5l_a22oi_1_1.A1 vdd sg13_lv_pmos ad=0.3808p pd=2.92u as=0.3808p ps=2.92u w=1.12u l=0.13u
X2081 adc8b_0.side_cap8b_1.buf_32_1.z adc8b_0.sar12b_0.nh_sw[0] vddr vddr sg13_lv_pmos ad=0.19p pd=1.38u as=0.19p ps=1.38u w=1u l=0.13u
X2082 a_36456_132775# a_40542_133105# sg13cmos5l_Corner_1.vss rppd l=20u w=1u
X2083 vdd a_93592_99054# a_93537_99149# vdd sg13_lv_pmos ad=1.15047p pd=7.175u as=93.45f ps=0.865u w=0.42u l=0.13u
X2084 adc8b_0.sar12b_0.sg13cmos5l_nand2_1_1.B a_97125_92976# vdd vdd sg13_lv_pmos ad=0.2128p pd=1.5u as=0.3808p ps=2.92u w=1.12u l=0.13u
X2085 a_82476_96576# a_82450_96540# vdd vdd sg13_lv_pmos ad=0.34p pd=2.68u as=0.36237p ps=2.605u w=1u l=0.13u
X2086 adc8b_0.sar12b_0.sg13cmos5l_dfrbp_1_8.Q_N a_98903_95887# sg13cmos5l_Corner_1.vss sg13cmos5l_Corner_1.vss sg13_lv_nmos ad=0.2849p pd=2.25u as=0.2516p ps=2.16u w=0.74u l=0.13u
X2087 adc8b_0.side_cap8b_1.buf_8_0.z adc8b_0.sar12b_0.nl_sw[4] sg13cmos5l_Corner_1.vss sg13cmos5l_Corner_1.vss sg13_lv_nmos ad=95f pd=0.88u as=95f ps=0.88u w=0.5u l=0.13u
X2088 vdd a_87405_93559# a_87507_93559# vdd sg13_lv_pmos ad=1.86162p pd=11.935u as=0.3864p ps=2.93u w=1.12u l=0.13u
X2089 a_82702_96997# adc8b_0.sar12b_0.sg13cmos5l_dfrbp_1_6.RESET_B sg13cmos5l_Corner_1.vss sg13cmos5l_Corner_1.vss sg13_lv_nmos ad=37.8f pd=0.6u as=0.1701p ps=1.65u w=0.42u l=0.13u
X2090 cko a_118044_42476# sg13cmos5l_Corner_1.iovdd sg13cmos5l_Corner_1.iovdd sg13_hv_pmos ad=3.9294p pd=7.84u as=2.1312p ps=7.3u w=6.66u l=0.6u
X2091 a_99514_98522# adc8b_0.sar12b_0.sg13cmos5l_dfrbp_1_8.RESET_B sg13cmos5l_Corner_1.vss sg13cmos5l_Corner_1.vss sg13_lv_nmos ad=37.8f pd=0.6u as=79.8f ps=0.8u w=0.42u l=0.13u
X2092 adc8b_0.side_cap8b_0.buf_32_1.z adc8b_0.side_cap8b_0.in_h_sw[0] sg13cmos5l_Corner_1.vss sg13cmos5l_Corner_1.vss sg13_lv_nmos ad=95f pd=0.88u as=95f ps=0.88u w=0.5u l=0.13u
X2093 a_85624_94518# adc8b_0.sar12b_0.sg13cmos5l_dfrbp_1_6.RESET_B vdd vdd sg13_lv_pmos ad=79.8f pd=0.8u as=1.38655p ps=8.8u w=0.42u l=0.13u
X2094 vdd a_96668_93512# a_96626_93548# vdd sg13_lv_pmos ad=0.2618p pd=1.63u as=0.1176p ps=1.33u w=1.12u l=0.13u
X2095 a_89588_93512# adc8b_0.sar12b_0.sg13cmos5l_dlhr_1_0.Q vdd vdd sg13_lv_pmos ad=0.2856p pd=2.36u as=0.2114p ps=1.54u w=0.84u l=0.13u
X2096 sg13cmos5l_IOPadAnalog_13.pad a_115639_178370# sg13cmos5l_Corner_1.vss sg13cmos5l_Corner_1.vss sg13_hv_nmos ad=2.596p pd=5.58u as=1.408p ps=5.04u w=4.4u l=0.6u
X2097 sg13cmos5l_Corner_1.vss adc8b_0.sar12b_0.nh_sw[1] adc8b_0.side_cap8b_1.buf_16_3.z sg13cmos5l_Corner_1.vss sg13_lv_nmos ad=95f pd=0.88u as=95f ps=0.88u w=0.5u l=0.13u
X2098 adc8b_0.side_cap8b_1.buf_16_2.z adc8b_0.sar12b_0.nl_sw[1] vddr vddr sg13_lv_pmos ad=0.19p pd=1.38u as=0.19p ps=1.38u w=1u l=0.13u
X2099 sg13cmos5l_IOPadAnalog_15.pad a_99639_178370# sg13cmos5l_Corner_1.vss sg13cmos5l_Corner_1.vss sg13_hv_nmos ad=2.596p pd=5.58u as=1.408p ps=5.04u w=4.4u l=0.6u
X2100 sg13cmos5l_Corner_1.vss adc8b_0.side_cap8b_0.in_h_sw[0] adc8b_0.side_cap8b_0.buf_32_1.z sg13cmos5l_Corner_1.vss sg13_lv_nmos ad=95f pd=0.88u as=95f ps=0.88u w=0.5u l=0.13u
X2101 a_95159_100423# a_94317_100325# a_93900_100664# vdd sg13_lv_pmos ad=0.2048p pd=1.63u as=0.34p ps=2.68u w=1u l=0.13u
X2102 vdd a_101361_97322# a_101886_97304# vdd sg13_lv_pmos ad=0.1974p pd=1.5u as=0.2856p ps=2.36u w=0.84u l=0.13u
X2103 a_92060_100668# a_91647_100362# a_91992_100668# vdd sg13_lv_pmos ad=0.191p pd=1.44u as=0.105p ps=1.21u w=1u l=0.13u
X2104 sg13cmos5l_Corner_1.vss vdd sg13cmos5l_Corner_1.vss sg13cmos5l_Corner_1.vss sg13_lv_nmos ad=79.8f pd=0.8u as=0 ps=0 w=0.42u l=1u
X2105 vdd sg13cmos5l_IOPadVdd$1_0.sg13cmos5l_Clamp_N43N43D4R$1_0.gate sg13cmos5l_Corner_1.vss sg13cmos5l_Corner_1.vss sg13_hv_nmos ad=2.596p pd=5.58u as=1.408p ps=5.04u w=4.4u l=0.6u
X2106 vddr adc8b_0.side_cap8b_0.in_h_sw[0] adc8b_0.side_cap8b_0.buf_32_1.z vddr sg13_lv_pmos ad=0.19p pd=1.38u as=0.19p ps=1.38u w=1u l=0.13u
X2107 vdd a_90957_99607# a_91059_99607# vdd sg13_lv_pmos ad=1.15047p pd=7.175u as=0.3864p ps=2.93u w=1.12u l=0.13u
X2108 a_100348_98820# a_99932_99156# a_100113_98834# sg13cmos5l_Corner_1.vss sg13_lv_nmos ad=77.7f pd=0.95u as=0.2516p ps=2.16u w=0.74u l=0.13u
X2109 sg13cmos5l_Corner_1.iovdd a_164624_70044# sg13cmos5l_IOPadAnalog_1.pad sg13cmos5l_Corner_1.iovdd sg13_hv_pmos ad=2.1312p pd=7.3u as=3.9294p ps=7.84u w=6.66u l=0.6u
X2110 sg13cmos5l_Corner_1.vss a_83639_178370# sg13cmos5l_IOPadAnalog_9.pad sg13cmos5l_Corner_1.vss sg13_hv_nmos ad=1.408p pd=5.04u as=2.596p ps=5.58u w=4.4u l=0.6u
X2111 data[2] a_102044_42476# sg13cmos5l_Corner_1.iovdd sg13cmos5l_Corner_1.iovdd sg13_hv_pmos ad=3.9294p pd=7.84u as=2.1312p ps=7.3u w=6.66u l=0.6u
X2112 sg13cmos5l_Corner_1.iovdd a_164624_118044# sg13cmos5l_IOPadAnalog_11.pad sg13cmos5l_Corner_1.iovdd sg13_hv_pmos ad=2.1312p pd=7.3u as=3.9294p ps=7.84u w=6.66u l=0.6u
X2113 a_89276_93108# a_88994_92796# a_89209_92778# sg13cmos5l_Corner_1.vss sg13_lv_nmos ad=0.141p pd=1.17u as=71.99999f ps=0.865u w=0.64u l=0.13u
X2114 a_88044_100021# a_88275_99607# a_87730_99564# sg13cmos5l_Corner_1.vss sg13_lv_nmos ad=0.2373p pd=1.97u as=79.8f ps=0.8u w=0.42u l=0.13u
X2115 a_95644_98820# a_95228_99156# a_95409_98834# sg13cmos5l_Corner_1.vss sg13_lv_nmos ad=77.7f pd=0.95u as=0.2516p ps=2.16u w=0.74u l=0.13u
X2116 vdd sg13cmos5l_IOPadVdd$1_0.sg13cmos5l_Clamp_N43N43D4R$1_0.gate sg13cmos5l_Corner_1.vss sg13cmos5l_Corner_1.vss sg13_hv_nmos ad=2.596p pd=5.58u as=1.408p ps=5.04u w=4.4u l=0.6u
X2117 vddr adc8b_0.side_cap8b_0.in_l_sw[5] adc8b_0.side_cap8b_0.buf_8_4.z vddr sg13_lv_pmos ad=0.19p pd=1.38u as=0.19p ps=1.38u w=1u l=0.13u
X2118 a_87470_100034# adc8b_0.sar12b_0.sg13cmos5l_dlhr_1_5.GATE vdd vdd sg13_lv_pmos ad=79.8f pd=0.8u as=0.1428p ps=1.52u w=0.42u l=0.13u
X2119 vdd adc8b_0.sar12b_0.sg13cmos5l_inv_1_29.A adc8b_0.sar12b_0.sg13cmos5l_inv_1_29.Y vdd sg13_lv_pmos ad=0.3808p pd=2.92u as=0.3808p ps=2.92u w=1.12u l=0.13u
X2120 cko a_118044_30676# sg13cmos5l_Corner_1.vss sg13cmos5l_Corner_1.vss sg13_hv_nmos ad=2.596p pd=5.58u as=1.408p ps=5.04u w=4.4u l=0.6u
X2121 adc8b_0.sar12b_0.sg13cmos5l_buf_1_40.X a_82960_92824# vdd vdd sg13_lv_pmos ad=0.42p pd=2.99u as=0.2114p ps=1.54u w=1.12u l=0.13u
X2122 a_97548_93973# a_97779_93559# a_97234_93516# sg13cmos5l_Corner_1.vss sg13_lv_nmos ad=0.2373p pd=1.97u as=79.8f ps=0.8u w=0.42u l=0.13u
X2123 sg13cmos5l_Corner_1.iovdd a_86044_42476# data[1] sg13cmos5l_Corner_1.iovdd sg13_hv_pmos ad=2.1312p pd=7.3u as=3.9294p ps=7.84u w=6.66u l=0.6u
X2124 sg13cmos5l_Corner_1.vss sg13cmos5l_IOPadAnalog_10.padres dantenna l=3.1u w=0.64u
X2125 vdd a_88984_97542# a_88929_97637# vdd sg13_lv_pmos ad=1.07253p pd=6.75u as=93.45f ps=0.865u w=0.42u l=0.13u
X2126 adc8b_0.sar12b_0.sg13cmos5l_dlygate4sd2_1_0.A adc8b_0.sar12b_0.sg13cmos5l_inv_1_8.Y vdd vdd sg13_lv_pmos ad=0.2128p pd=1.5u as=0.3808p ps=2.92u w=1.12u l=0.13u
X2127 adc8b_0.side_cap8b_0.buf_16_0.z adc8b_0.side_cap8b_0.in_h_sw[2] vddr vddr sg13_lv_pmos ad=0.34p pd=2.68u as=0.19p ps=1.38u w=1u l=0.13u
X2128 adc8b_0.sar12b_0.sg13cmos5l_a22oi_1_1.Y adc8b_0.sar12b_0.sg13cmos5l_a22oi_1_1.B2 a_96582_95036# vdd sg13_lv_pmos ad=0.2128p pd=1.5u as=0.2744p ps=1.61u w=1.12u l=0.13u
X2129 sg13cmos5l_Corner_1.vss a_134222_175886# dantenna l=1.26u w=27.78u
X2130 vdd a_89972_93512# adc8b_0.sar12b_0.sg13cmos5l_buf_1_24.A vdd sg13_lv_pmos ad=0.2114p pd=1.54u as=0.42p ps=2.99u w=1.12u l=0.13u
X2131 vdd sg13cmos5l_IOPadVdd$1_0.sg13cmos5l_Clamp_N43N43D4R$1_0.gate sg13cmos5l_Corner_1.vss sg13cmos5l_Corner_1.vss sg13_hv_nmos ad=2.596p pd=5.58u as=1.408p ps=5.04u w=4.4u l=0.6u
X2132 cks a_30676_118044# sg13cmos5l_Corner_1.vss sg13cmos5l_Corner_1.vss sg13_hv_nmos ad=2.596p pd=5.58u as=1.408p ps=5.04u w=4.4u l=0.6u
X2133 a_87854_95810# adc8b_0.sar12b_0.sg13cmos5l_dlhr_1_0.GATE vdd vdd sg13_lv_pmos ad=79.8f pd=0.8u as=0.1428p ps=1.52u w=0.42u l=0.13u
X2134 a_99154_93009# a_99597_92765# a_98894_92786# sg13cmos5l_Corner_1.vss sg13_lv_nmos ad=79.8f pd=0.8u as=0.1296p ps=1.52u w=0.42u l=0.13u
X2135 a_85594_100034# adc8b_0.sar12b_0.sg13cmos5l_dfrbp_1_8.RESET_B sg13cmos5l_Corner_1.vss sg13cmos5l_Corner_1.vss sg13_lv_nmos ad=37.8f pd=0.6u as=79.8f ps=0.8u w=0.42u l=0.13u
X2136 adc8b_0.side_cap8b_1.buf_16_1.z adc8b_0.sar12b_0.nl_sw[2] sg13cmos5l_Corner_1.vss sg13cmos5l_Corner_1.vss sg13_lv_nmos ad=95f pd=0.88u as=95f ps=0.88u w=0.5u l=0.13u
X2137 sg13cmos5l_Corner_1.vss a_102044_30676# data[2] sg13cmos5l_Corner_1.vss sg13_hv_nmos ad=1.408p pd=5.04u as=2.596p ps=5.58u w=4.4u l=0.6u
X2138 sg13cmos5l_Corner_1.iovdd a_164624_102044# sg13cmos5l_IOPadAnalog_16.pad sg13cmos5l_Corner_1.iovdd sg13_hv_pmos ad=2.1312p pd=7.3u as=3.9294p ps=7.84u w=6.66u l=0.6u
X2139 adc8b_0.side_cap8b_0.buf_16_2.z adc8b_0.side_cap8b_0.in_l_sw[1] sg13cmos5l_Corner_1.vss sg13cmos5l_Corner_1.vss sg13_lv_nmos ad=95f pd=0.88u as=95f ps=0.88u w=0.5u l=0.13u
X2140 a_94572_97335# a_94803_97444# a_94258_97545# sg13cmos5l_Corner_1.vss sg13_lv_nmos ad=0.2373p pd=1.97u as=79.8f ps=0.8u w=0.42u l=0.13u
X2141 vdd sg13cmos5l_Corner_1.vss vdd vdd sg13_lv_pmos ad=0.19p pd=1.38u as=0 ps=0 w=1u l=1u
X2142 a_98036_92750# adc8b_0.sar12b_0.sg13cmos5l_buf_1_1.A vdd vdd sg13_lv_pmos ad=0.2856p pd=2.36u as=0.2114p ps=1.54u w=0.84u l=0.13u
X2143 sg13cmos5l_IOPadAnalog_10.pad a_67639_178370# sg13cmos5l_Corner_1.vss sg13cmos5l_Corner_1.vss sg13_hv_nmos ad=2.596p pd=5.58u as=1.408p ps=5.04u w=4.4u l=0.6u
X2144 a_91796_97286# adc8b_0.sar12b_0.sg13cmos5l_buf_1_56.A sg13cmos5l_Corner_1.vss sg13cmos5l_Corner_1.vss sg13_lv_nmos ad=0.187p pd=1.78u as=0.14875p ps=1.16u w=0.55u l=0.13u
X2145 vdd sg13cmos5l_Corner_1.vss vdd vdd sg13_lv_pmos ad=0.34p pd=2.68u as=0 ps=0 w=1u l=1u
X2146 adc8b_0.side_cap8b_1.buf_8_1.z adc8b_0.sar12b_0.nl_sw[3] sg13cmos5l_Corner_1.vss sg13cmos5l_Corner_1.vss sg13_lv_nmos ad=95f pd=0.88u as=95f ps=0.88u w=0.5u l=0.13u
X2147 adc8b_0.side_cap8b_1.buf_16_3.z adc8b_0.sar12b_0.nh_sw[1] vddr vddr sg13_lv_pmos ad=0.19p pd=1.38u as=0.19p ps=1.38u w=1u l=0.13u
X2148 vdd a_86847_94314# a_86978_94308# vdd sg13_lv_pmos ad=1.43437p pd=9.105u as=0.2856p ps=2.36u w=0.84u l=0.13u
X2149 sg13cmos5l_Corner_1.vss adc8b_0.side_cap8b_0.in_l_sw[2] adc8b_0.side_cap8b_0.buf_16_1.z sg13cmos5l_Corner_1.vss sg13_lv_nmos ad=95f pd=0.88u as=95f ps=0.88u w=0.5u l=0.13u
X2150 a_94815_98850# adc8b_0.sar12b_0.sg13cmos5l_dlhr_1_11.GATE sg13cmos5l_Corner_1.vss sg13cmos5l_Corner_1.vss sg13_lv_nmos ad=0.2516p pd=2.16u as=0.15055p ps=1.17u w=0.74u l=0.13u
X2151 sg13cmos5l_Corner_1.vss a_99639_178370# sg13cmos5l_IOPadAnalog_15.pad sg13cmos5l_Corner_1.vss sg13_hv_nmos ad=1.408p pd=5.04u as=2.596p ps=5.58u w=4.4u l=0.6u
X2152 vip a_30676_102044# sg13cmos5l_Corner_1.vss sg13cmos5l_Corner_1.vss sg13_hv_nmos ad=2.596p pd=5.58u as=1.408p ps=5.04u w=4.4u l=0.6u
X2153 adc8b_0.sar12b_0.sg13cmos5l_buf_1_96.A a_92433_98441# vdd vdd sg13_lv_pmos ad=0.3808p pd=2.92u as=0.2128p ps=1.5u w=1.12u l=0.13u
X2154 sg13cmos5l_Corner_1.vss a_115639_178370# sg13cmos5l_IOPadAnalog_13.pad sg13cmos5l_Corner_1.vss sg13_hv_nmos ad=2.068p pd=9.74u as=2.596p ps=5.58u w=4.4u l=0.6u
X2155 vddr adc8b_0.side_cap8b_0.in_l_sw[1] adc8b_0.side_cap8b_0.buf_16_2.z vddr sg13_lv_pmos ad=0.19p pd=1.38u as=0.19p ps=1.38u w=1u l=0.13u
X2156 a_83735_98445# a_82893_98095# a_83641_98445# sg13cmos5l_Corner_1.vss sg13_lv_nmos ad=0.12665p pd=1.145u as=0.1428p ps=1.52u w=0.42u l=0.13u
X2157 a_96226_95430# adc8b_0.sar12b_0.sg13cmos5l_nand2_1_1.B sg13cmos5l_Corner_1.vss sg13cmos5l_Corner_1.vss sg13_lv_nmos ad=0.1406p pd=1.12u as=0.2516p ps=2.16u w=0.74u l=0.13u
X2158 sg13cmos5l_Corner_1.vss adc8b_0.sar12b_0.nh_sw[2] adc8b_0.side_cap8b_1.buf_16_0.z sg13cmos5l_Corner_1.vss sg13_lv_nmos ad=95f pd=0.88u as=0.17p ps=1.68u w=0.5u l=0.13u
X2159 sg13cmos5l_Corner_1.vss a_57198_117410# dantenna l=0.64u w=3.1u
X2160 vddr adc8b_0.sar12b_0.nl_sw[3] adc8b_0.side_cap8b_1.buf_8_1.z vddr sg13_lv_pmos ad=0.19p pd=1.38u as=0.19p ps=1.38u w=1u l=0.13u
X2161 adc8b_0.side_cap8b_1.buf_16_2.z adc8b_0.sar12b_0.nl_sw[1] sg13cmos5l_Corner_1.vss sg13cmos5l_Corner_1.vss sg13_lv_nmos ad=95f pd=0.88u as=95f ps=0.88u w=0.5u l=0.13u
X2162 adc8b_0.side_cap8b_1.buf_32_1.z adc8b_0.sar12b_0.nh_sw[0] sg13cmos5l_Corner_1.vss sg13cmos5l_Corner_1.vss sg13_lv_nmos ad=95f pd=0.88u as=95f ps=0.88u w=0.5u l=0.13u
X2163 a_84204_95485# a_83916_95064# a_84142_95485# sg13cmos5l_Corner_1.vss sg13_lv_nmos ad=0.1428p pd=1.52u as=37.8f ps=0.6u w=0.42u l=0.13u
X2164 vddr adc8b_0.sar12b_0.nh_sw[5] adc8b_0.side_cap8b_1.buf_8_5.z vddr sg13_lv_pmos ad=0.19p pd=1.38u as=0.19p ps=1.38u w=1u l=0.13u
X2165 sg13cmos5l_Corner_1.vss adc8b_0.side_cap8b_0.in_h_sw[1] adc8b_0.side_cap8b_0.buf_16_3.z sg13cmos5l_Corner_1.vss sg13_lv_nmos ad=95f pd=0.88u as=95f ps=0.88u w=0.5u l=0.13u
X2166 adc8b_0.sar12b_0.sg13cmos5l_buf_1_10.A a_93616_99596# vdd vdd sg13_lv_pmos ad=0.42p pd=2.99u as=0.2114p ps=1.54u w=1.12u l=0.13u
X2167 sg13cmos5l_Corner_1.vss adc8b_0.sar12b_0.sg13cmos5l_dfrbp_1_6.RESET_B a_82284_97010# sg13cmos5l_Corner_1.vss sg13_lv_nmos ad=0.1626p pd=1.415u as=60.89999f ps=0.71u w=0.42u l=0.13u
X2168 adc8b_0.side_cap8b_1.buf_4_1.z adc8b_0.sar12b_0.nh_sw[6] sg13cmos5l_Corner_1.vss sg13cmos5l_Corner_1.vss sg13_lv_nmos ad=0.17p pd=1.68u as=95f ps=0.88u w=0.5u l=0.13u
X2169 vddr adc8b_0.sar12b_0.nh_sw[0] adc8b_0.side_cap8b_1.buf_32_1.z vddr sg13_lv_pmos ad=0.19p pd=1.38u as=0.19p ps=1.38u w=1u l=0.13u
X2170 vdd sg13cmos5l_IOPadVdd$1_0.sg13cmos5l_RCClampInverter$1_0.in sg13cmos5l_IOPadVdd$1_0.sg13cmos5l_Clamp_N43N43D4R$1_0.gate vdd sg13_hv_pmos ad=1.33p pd=7.38u as=1.33p ps=7.38u w=7u l=0.5u
X2171 sg13cmos5l_IOPadAnalog_15.pad a_99639_178370# sg13cmos5l_Corner_1.vss sg13cmos5l_Corner_1.vss sg13_hv_nmos ad=2.596p pd=5.58u as=1.408p ps=5.04u w=4.4u l=0.6u
X2172 vdd a_84177_95810# a_84702_95792# vdd sg13_lv_pmos ad=0.1974p pd=1.5u as=0.2856p ps=2.36u w=0.84u l=0.13u
X2173 sg13cmos5l_Corner_1.vss adc8b_0.cmp_0.sg13cmos5l_inv_1$1_0.Y a_79552_97015# sg13cmos5l_Corner_1.vss sg13_lv_nmos ad=0.1469p pd=1.155u as=0.1045p ps=0.93u w=0.55u l=0.13u
X2174 sg13cmos5l_Corner_1.vss adc8b_0.sar12b_0.sg13cmos5l_or2_1_1.B a_93641_96920# sg13cmos5l_Corner_1.vss sg13_lv_nmos ad=0.2516p pd=2.16u as=0.1406p ps=1.12u w=0.74u l=0.13u
X2175 a_91473_95810# a_91292_96132# vdd vdd sg13_lv_pmos ad=0.2128p pd=1.5u as=0.2387p ps=1.84u w=1.12u l=0.13u
X2176 sg13cmos5l_Corner_1.vss a_178296_70044# sg13cmos5l_IOPadAnalog_1.pad sg13cmos5l_Corner_1.vss sg13_hv_nmos ad=1.408p pd=5.04u as=2.596p ps=5.58u w=4.4u l=0.6u
X2177 a_36456_139375# a_40542_139045# sg13cmos5l_Corner_1.vss rppd l=20u w=1u
X2178 adc8b_0.side_cap8b_1.buf_16_3.z adc8b_0.sar12b_0.nh_sw[1] sg13cmos5l_Corner_1.vss sg13cmos5l_Corner_1.vss sg13_lv_nmos ad=95f pd=0.88u as=95f ps=0.88u w=0.5u l=0.13u
X2179 vddr adc8b_0.side_cap8b_0.in_l_sw[3] adc8b_0.side_cap8b_0.buf_8_1.z vddr sg13_lv_pmos ad=0.19p pd=1.38u as=0.19p ps=1.38u w=1u l=0.13u
X2180 sg13cmos5l_IOPadAnalog_12.pad a_131639_164698# sg13cmos5l_Corner_1.iovdd sg13cmos5l_Corner_1.iovdd sg13_hv_pmos ad=3.9294p pd=7.84u as=2.1312p ps=7.3u w=6.66u l=0.6u
X2181 sg13cmos5l_Corner_1.vss a_30676_86044# vin sg13cmos5l_Corner_1.vss sg13_hv_nmos ad=1.408p pd=5.04u as=2.596p ps=5.58u w=4.4u l=0.6u
X2182 a_90740_100310# adc8b_0.sar12b_0.sg13cmos5l_buf_1_77.A vdd vdd sg13_lv_pmos ad=0.2856p pd=2.36u as=0.2114p ps=1.54u w=0.84u l=0.13u
X2183 cks a_42476_118044# sg13cmos5l_Corner_1.iovdd sg13cmos5l_Corner_1.iovdd sg13_hv_pmos ad=3.9294p pd=7.84u as=2.1312p ps=7.3u w=6.66u l=0.6u
X2184 sg13cmos5l_Corner_1.iovdd a_42476_102044# vip sg13cmos5l_Corner_1.iovdd sg13_hv_pmos ad=2.1312p pd=7.3u as=3.9294p ps=7.84u w=6.66u l=0.6u
X2185 a_98296_99054# adc8b_0.sar12b_0.sg13cmos5l_dfrbp_1_6.RESET_B vdd vdd sg13_lv_pmos ad=79.8f pd=0.8u as=1.12242p ps=7u w=0.42u l=0.13u
X2186 a_92366_98084# a_91970_98448# a_92252_98084# vdd sg13_lv_pmos ad=0.1008p pd=0.9u as=0.191p ps=1.44u w=0.42u l=0.13u
X2187 a_93998_97322# adc8b_0.sar12b_0.sg13cmos5l_buf_1_57.X vdd vdd sg13_lv_pmos ad=79.8f pd=0.8u as=0.1428p ps=1.52u w=0.42u l=0.13u
X2188 data[1] a_86044_42476# sg13cmos5l_Corner_1.iovdd sg13cmos5l_Corner_1.iovdd sg13_hv_pmos ad=3.9294p pd=7.84u as=2.1312p ps=7.3u w=6.66u l=0.6u
X2189 vdd a_101361_97322# a_101294_97760# vdd sg13_lv_pmos ad=0.2387p pd=1.84u as=0.1008p ps=0.9u w=0.42u l=0.13u
X2190 a_87756_99600# a_88275_99607# a_89015_99957# sg13cmos5l_Corner_1.vss sg13_lv_nmos ad=0.3473p pd=2.71u as=0.12665p ps=1.145u w=0.74u l=0.13u
X2191 vdd a_82893_96583# a_82995_96583# vdd sg13_lv_pmos ad=1.28962p pd=8.195u as=0.3864p ps=2.93u w=1.12u l=0.13u
X2192 adc8b_0.sar12b_0.sg13cmos5l_inv_1_9.Y cks sg13cmos5l_Corner_1.vss sg13cmos5l_Corner_1.vss sg13_lv_nmos ad=0.2516p pd=2.16u as=0.2516p ps=2.16u w=0.74u l=0.13u
X2193 a_101112_97644# a_100561_97376# vdd vdd sg13_lv_pmos ad=0.105p pd=1.21u as=1.07253p ps=6.75u w=1u l=0.13u
X2194 vddr adc8b_0.sar12b_0.nl_sw[4] adc8b_0.side_cap8b_1.buf_8_0.z vddr sg13_lv_pmos ad=0.19p pd=1.38u as=0.34p ps=2.68u w=1u l=0.13u
X2195 adc8b_0.side_cap8b_1.buf_8_2.z adc8b_0.sar12b_0.nh_sw[4] sg13cmos5l_Corner_1.vss sg13cmos5l_Corner_1.vss sg13_lv_nmos ad=95f pd=0.88u as=95f ps=0.88u w=0.5u l=0.13u
X2196 a_100858_92786# adc8b_0.sar12b_0.sg13cmos5l_dfrbp_1_0.RESET_B sg13cmos5l_Corner_1.vss sg13cmos5l_Corner_1.vss sg13_lv_nmos ad=37.8f pd=0.6u as=79.8f ps=0.8u w=0.42u l=0.13u
X2197 sg13cmos5l_Corner_1.vss a_134044_30676# frame sg13cmos5l_Corner_1.vss sg13_hv_nmos ad=1.408p pd=5.04u as=2.596p ps=5.58u w=4.4u l=0.6u
X2198 vdd a_96692_92750# adc8b_0.sar12b_0.nh_sw[6] vdd sg13_lv_pmos ad=0.2114p pd=1.54u as=0.42p ps=2.99u w=1.12u l=0.13u
X2199 cko a_118044_30676# sg13cmos5l_Corner_1.vss sg13cmos5l_Corner_1.vss sg13_hv_nmos ad=2.596p pd=5.58u as=1.408p ps=5.04u w=4.4u l=0.6u
X2200 adc8b_0.sar12b_0.sg13cmos5l_dfrbp_1_22.D a_98492_99596# vdd vdd sg13_lv_pmos ad=0.3808p pd=2.92u as=0.2128p ps=1.5u w=1.12u l=0.13u
X2201 sg13cmos5l_Corner_1.vss a_99261_95107# a_98340_95421# sg13cmos5l_Corner_1.vss sg13_lv_nmos ad=0.1626p pd=1.415u as=0.2516p ps=2.16u w=0.74u l=0.13u
X2202 cko a_118044_42476# sg13cmos5l_Corner_1.iovdd sg13cmos5l_Corner_1.iovdd sg13_hv_pmos ad=3.9294p pd=7.84u as=2.1312p ps=7.3u w=6.66u l=0.6u
X2203 sg13cmos5l_Corner_1.iovdd a_86044_42476# data[1] sg13cmos5l_Corner_1.iovdd sg13_hv_pmos ad=2.1312p pd=7.3u as=3.9294p ps=7.84u w=6.66u l=0.6u
X2204 sg13cmos5l_Corner_1.vss adc8b_0.side_cap8b_0.in_l_sw[0] adc8b_0.side_cap8b_0.buf_32_0.z sg13cmos5l_Corner_1.vss sg13_lv_nmos ad=95f pd=0.88u as=95f ps=0.88u w=0.5u l=0.13u
X2205 a_96780_99152# a_96754_99057# vdd vdd sg13_lv_pmos ad=0.34p pd=2.68u as=0.36237p ps=2.605u w=1u l=0.13u
X2206 adc8b_0.sar12b_0.sg13cmos5l_nand2_1_2.B adc8b_0.sar12b_0.sg13cmos5l_nor2_1_2.A sg13cmos5l_Corner_1.vss sg13cmos5l_Corner_1.vss sg13_lv_nmos ad=0.1406p pd=1.12u as=0.2516p ps=2.16u w=0.74u l=0.13u
X2207 a_93888_94616# adc8b_0.sar12b_0.sg13cmos5l_o21ai_1_0.A1 vdd vdd sg13_lv_pmos ad=0.2128p pd=1.5u as=0.3808p ps=2.92u w=1.12u l=0.15u
X2208 vdd a_93645_93559# a_93747_93559# vdd sg13_lv_pmos ad=1.86162p pd=11.935u as=0.3864p ps=2.93u w=1.12u l=0.13u
X2209 a_88504_93790# adc8b_0.sar12b_0.sg13cmos5l_dfrbp_1_6.RESET_B vdd vdd sg13_lv_pmos ad=79.8f pd=0.8u as=1.86162p ps=11.935u w=0.42u l=0.13u
X2210 a_98316_97335# a_98547_97444# a_98002_97545# sg13cmos5l_Corner_1.vss sg13_lv_nmos ad=0.2373p pd=1.97u as=79.8f ps=0.8u w=0.42u l=0.13u
X2211 a_87478_96695# a_87220_97010# vdd vdd sg13_lv_pmos ad=93.45f pd=0.865u as=1.28962p ps=8.195u w=0.42u l=0.13u
X2212 adc8b_0.sar12b_0.sg13cmos5l_buf_1_44.A a_87441_94298# vdd vdd sg13_lv_pmos ad=0.3808p pd=2.92u as=0.2128p ps=1.5u w=1.12u l=0.13u
X2213 sg13cmos5l_Corner_1.vss a_67639_178370# sg13cmos5l_IOPadAnalog_10.pad sg13cmos5l_Corner_1.vss sg13_hv_nmos ad=1.408p pd=5.04u as=2.596p ps=5.58u w=4.4u l=0.6u
X2214 a_98254_97335# adc8b_0.sar12b_0.sg13cmos5l_dfrbp_1_6.RESET_B sg13cmos5l_Corner_1.vss sg13cmos5l_Corner_1.vss sg13_lv_nmos ad=37.8f pd=0.6u as=0.1701p ps=1.65u w=0.42u l=0.13u
X2215 sg13cmos5l_Corner_1.vss a_83639_178370# sg13cmos5l_IOPadAnalog_9.pad sg13cmos5l_Corner_1.vss sg13_hv_nmos ad=2.068p pd=9.74u as=2.596p ps=5.58u w=4.4u l=0.6u
X2216 adc8b_0.side_cap8b_0.buf_32_0.z adc8b_0.side_cap8b_0.in_l_sw[0] vddr vddr sg13_lv_pmos ad=0.19p pd=1.38u as=0.19p ps=1.38u w=1u l=0.13u
X2217 vddr adc8b_0.side_cap8b_0.in_h_sw[2] adc8b_0.side_cap8b_0.buf_16_0.z vddr sg13_lv_pmos ad=0.19p pd=1.38u as=0.19p ps=1.38u w=1u l=0.13u
X2218 a_93324_95064# a_93298_95028# sg13cmos5l_Corner_1.vss sg13cmos5l_Corner_1.vss sg13_lv_nmos ad=0.2516p pd=2.16u as=0.1626p ps=1.415u w=0.74u l=0.13u
X2219 sg13cmos5l_Corner_1.iovdd a_42476_118044# cks sg13cmos5l_Corner_1.iovdd sg13_hv_pmos ad=2.1312p pd=7.3u as=3.9294p ps=7.84u w=6.66u l=0.6u
X2220 a_92050_99057# a_92493_98813# a_91790_98834# sg13cmos5l_Corner_1.vss sg13_lv_nmos ad=79.8f pd=0.8u as=0.1296p ps=1.52u w=0.42u l=0.13u
X2221 adc8b_0.sar12b_0.sg13cmos5l_nor2_1_2.A adc8b_0.sar12b_0.sg13cmos5l_inv_1_9.Y vdd vdd sg13_lv_pmos ad=0.3808p pd=2.92u as=0.3808p ps=2.92u w=1.12u l=0.13u
X2222 adc8b_0.side_cap8b_1.buf_8_2.z adc8b_0.sar12b_0.nh_sw[4] vddr vddr sg13_lv_pmos ad=0.34p pd=2.68u as=0.19p ps=1.38u w=1u l=0.13u
X2223 sg13cmos5l_Corner_1.vss a_97655_99957# a_98492_99596# sg13cmos5l_Corner_1.vss sg13_lv_nmos ad=0.1406p pd=1.12u as=0.2516p ps=2.16u w=0.74u l=0.13u
X2224 vdd a_85432_99838# a_85377_99719# vdd sg13_lv_pmos ad=1.15047p pd=7.175u as=93.45f ps=0.865u w=0.42u l=0.13u
X2225 vdd adc8b_0.diff_bsw_0.single_bsw_0.sg13cmos5l_inv_1$1_2.A a_70852_97472# vdd sg13_lv_pmos ad=0.17p pd=1.68u as=0.17p ps=1.68u w=0.5u l=0.13u
X2226 a_83735_96933# a_82893_96583# a_82476_96576# vdd sg13_lv_pmos ad=0.2048p pd=1.63u as=0.34p ps=2.68u w=1u l=0.13u
X2227 a_98001_96201# a_97644_96128# vdd vdd sg13_lv_pmos ad=63f pd=0.72u as=0.1563p ps=1.22u w=0.42u l=0.13u
X2228 adc8b_0.sar12b_0.sg13cmos5l_dlhr_1_13.Q_N a_97182_98514# vdd vdd sg13_lv_pmos ad=0.3808p pd=2.92u as=0.1974p ps=1.5u w=1.12u l=0.13u
X2229 a_92099_95060# adc8b_0.sar12b_0.sg13cmos5l_nand2_1_1.B adc8b_0.sar12b_0.sg13cmos5l_a22oi_1_1.B1 vdd sg13_lv_pmos ad=0.2128p pd=1.5u as=0.3808p ps=2.92u w=1.12u l=0.13u
X2230 sg13cmos5l_IOPadAnalog_10.pad a_67639_178370# sg13cmos5l_Corner_1.vss sg13cmos5l_Corner_1.vss sg13_hv_nmos ad=2.596p pd=5.58u as=1.408p ps=5.04u w=4.4u l=0.6u
X2231 sg13cmos5l_Corner_1.vss a_124462_57198# dantenna l=3.1u w=0.64u
X2232 sg13cmos5l_Corner_1.iovdd a_164624_102044# sg13cmos5l_IOPadAnalog_16.pad sg13cmos5l_Corner_1.iovdd sg13_hv_pmos ad=2.1312p pd=7.3u as=3.9294p ps=7.84u w=6.66u l=0.6u
X2233 sg13cmos5l_IOPadAnalog_11.pad a_164624_118044# sg13cmos5l_Corner_1.iovdd sg13cmos5l_Corner_1.iovdd sg13_hv_pmos ad=3.9294p pd=7.84u as=2.1312p ps=7.3u w=6.66u l=0.6u
X2234 sg13cmos5l_Corner_1.vss adc8b_0.sar12b_0.nl_sw[2] adc8b_0.side_cap8b_1.buf_16_1.z sg13cmos5l_Corner_1.vss sg13_lv_nmos ad=95f pd=0.88u as=95f ps=0.88u w=0.5u l=0.13u
X2235 a_99694_94311# adc8b_0.sar12b_0.sg13cmos5l_dfrbp_1_0.RESET_B sg13cmos5l_Corner_1.vss sg13cmos5l_Corner_1.vss sg13_lv_nmos ad=37.8f pd=0.6u as=0.1701p ps=1.65u w=0.42u l=0.13u
X2236 sg13cmos5l_Corner_1.vss sg13cmos5l_IOPadVdd$1_0.sg13cmos5l_Clamp_N43N43D4R$1_0.gate vdd sg13cmos5l_Corner_1.vss sg13_hv_nmos ad=1.408p pd=5.04u as=2.596p ps=5.58u w=4.4u l=0.6u
X2237 sg13cmos5l_Corner_1.vss cks adc8b_0.sar12b_0.sg13cmos5l_dfrbp_1_6.RESET_B sg13cmos5l_Corner_1.vss sg13_lv_nmos ad=0.2516p pd=2.16u as=0.1443p ps=1.13u w=0.74u l=0.13u
X2238 a_99352_98326# a_99095_98445# a_99514_98522# sg13cmos5l_Corner_1.vss sg13_lv_nmos ad=0.1428p pd=1.52u as=37.8f ps=0.6u w=0.42u l=0.13u
X2239 sg13cmos5l_Corner_1.iovdd a_102044_42476# data[2] sg13cmos5l_Corner_1.iovdd sg13_hv_pmos ad=2.1312p pd=7.3u as=3.9294p ps=7.84u w=6.66u l=0.6u
X2240 adc8b_0.sar12b_0.sg13cmos5l_buf_1_97.A a_92241_100346# vdd vdd sg13_lv_pmos ad=0.3808p pd=2.92u as=0.2128p ps=1.5u w=1.12u l=0.13u
X2241 adc8b_0.sar12b_0.sg13cmos5l_buf_1_111.A a_101008_98872# vdd vdd sg13_lv_pmos ad=0.42p pd=2.99u as=0.2114p ps=1.54u w=1.12u l=0.13u
X2242 a_99287_97399# a_98445_97301# a_98028_97640# vdd sg13_lv_pmos ad=0.2048p pd=1.63u as=0.34p ps=2.68u w=1u l=0.13u
X2243 sg13cmos5l_Corner_1.iovdd a_42476_118044# cks sg13cmos5l_Corner_1.iovdd sg13_hv_pmos ad=2.1312p pd=7.3u as=3.9294p ps=7.84u w=6.66u l=0.6u
X2244 a_96582_95036# adc8b_0.sar12b_0.sg13cmos5l_nand2_1_1.B vdd vdd sg13_lv_pmos ad=0.2744p pd=1.61u as=0.3808p ps=2.92u w=1.12u l=0.13u
X2245 sg13cmos5l_Corner_1.vss a_178296_102044# sg13cmos5l_IOPadAnalog_16.pad sg13cmos5l_Corner_1.vss sg13_hv_nmos ad=1.408p pd=5.04u as=2.596p ps=5.58u w=4.4u l=0.6u
X2246 adc8b_0.side_cap8b_1.buf_4_3.z adc8b_0.sar12b_0.nl_sw[6] sg13cmos5l_Corner_1.vss sg13cmos5l_Corner_1.vss sg13_lv_nmos ad=0.17p pd=1.68u as=95f ps=0.88u w=0.5u l=0.13u
X2247 sg13cmos5l_IOPadAnalog_11.pad a_178296_118044# sg13cmos5l_Corner_1.vss sg13cmos5l_Corner_1.vss sg13_hv_nmos ad=2.596p pd=5.58u as=1.408p ps=5.04u w=4.4u l=0.6u
X2248 sg13cmos5l_Corner_1.vss adc8b_0.side_cap8b_0.in_h_sw[0] adc8b_0.side_cap8b_0.buf_32_1.z sg13cmos5l_Corner_1.vss sg13_lv_nmos ad=95f pd=0.88u as=95f ps=0.88u w=0.5u l=0.13u
X2249 adc8b_0.side_cap8b_0.buf_16_1.z adc8b_0.side_cap8b_0.in_l_sw[2] sg13cmos5l_Corner_1.vss sg13cmos5l_Corner_1.vss sg13_lv_nmos ad=0.17p pd=1.68u as=95f ps=0.88u w=0.5u l=0.13u
X2250 cko a_118044_42476# sg13cmos5l_Corner_1.iovdd sg13cmos5l_Corner_1.iovdd sg13_hv_pmos ad=3.9294p pd=7.84u as=2.1312p ps=7.3u w=6.66u l=0.6u
X2251 sg13cmos5l_Corner_1.vss a_70044_30676# data[0] sg13cmos5l_Corner_1.vss sg13_hv_nmos ad=1.408p pd=5.04u as=2.596p ps=5.58u w=4.4u l=0.6u
X2252 a_93516_93973# a_93228_93552# a_93454_93973# sg13cmos5l_Corner_1.vss sg13_lv_nmos ad=0.1428p pd=1.52u as=37.8f ps=0.6u w=0.42u l=0.13u
X2253 vin a_42476_86044# sg13cmos5l_Corner_1.iovdd sg13cmos5l_Corner_1.iovdd sg13_hv_pmos ad=3.9294p pd=7.84u as=2.1312p ps=7.3u w=6.66u l=0.6u
X2254 a_85330_96033# a_85773_95789# a_85070_95810# sg13cmos5l_Corner_1.vss sg13_lv_nmos ad=79.8f pd=0.8u as=0.1296p ps=1.52u w=0.42u l=0.13u
X2255 a_36456_132775# sg13cmos5l_IOPadVdd$1_0.sg13cmos5l_RCClampInverter$1_0.in sg13cmos5l_Corner_1.vss rppd l=20u w=1u
X2256 vddr adc8b_0.side_cap8b_0.in_h_sw[0] adc8b_0.side_cap8b_0.buf_32_1.z vddr sg13_lv_pmos ad=0.19p pd=1.38u as=0.19p ps=1.38u w=1u l=0.13u
X2257 adc8b_0.side_cap8b_0.buf_16_2.z adc8b_0.side_cap8b_0.in_l_sw[1] vddr vddr sg13_lv_pmos ad=0.19p pd=1.38u as=0.19p ps=1.38u w=1u l=0.13u
X2258 sg13cmos5l_Corner_1.vss a_99160_96030# a_98809_95887# sg13cmos5l_Corner_1.vss sg13_lv_nmos ad=79.8f pd=0.8u as=0.1428p ps=1.52u w=0.42u l=0.13u
X2259 sg13cmos5l_Corner_1.iovdd a_131639_164698# sg13cmos5l_IOPadAnalog_12.pad sg13cmos5l_Corner_1.iovdd sg13_hv_pmos ad=3.1302p pd=14.26u as=3.9294p ps=7.84u w=6.66u l=0.6u
X2260 adc8b_0.sar12b_0.sg13cmos5l_dfrbp_1_18.Q a_89852_99596# sg13cmos5l_Corner_1.vss sg13cmos5l_Corner_1.vss sg13_lv_nmos ad=0.2516p pd=2.16u as=0.1406p ps=1.12u w=0.74u l=0.13u
X2261 a_88415_96619# adc8b_0.sar12b_0.sg13cmos5l_dfrbp_1_11.Q a_89162_97010# sg13cmos5l_Corner_1.vss sg13_lv_nmos ad=0.1428p pd=1.52u as=60.89999f ps=0.71u w=0.42u l=0.13u
X2262 sg13cmos5l_Corner_1.vss vdd sg13cmos5l_Corner_1.vss sg13cmos5l_Corner_1.vss sg13_lv_nmos ad=0.1428p pd=1.52u as=0 ps=0 w=0.42u l=1u
X2263 a_99167_95107# a_98471_95031# a_99261_95107# sg13cmos5l_Corner_1.vss sg13_lv_nmos ad=0.1296p pd=1.52u as=79.8f ps=0.8u w=0.42u l=0.13u
X2264 a_95052_94616# a_95026_94521# vdd vdd sg13_lv_pmos ad=0.34p pd=2.68u as=0.36237p ps=2.605u w=1u l=0.13u
X2265 sg13cmos5l_Corner_1.vss adc8b_0.sar12b_0.nl_sw[1] adc8b_0.side_cap8b_1.buf_16_2.z sg13cmos5l_Corner_1.vss sg13_lv_nmos ad=95f pd=0.88u as=95f ps=0.88u w=0.5u l=0.13u
X2266 vdd adc8b_0.sar12b_0.sg13cmos5l_nor2_1_0.A a_94582_95852# vdd sg13_lv_pmos ad=0.2618p pd=1.63u as=0.2856p ps=2.36u w=0.84u l=0.13u
X2267 sg13cmos5l_Corner_1.iovdd a_164624_118044# sg13cmos5l_IOPadAnalog_11.pad sg13cmos5l_Corner_1.iovdd sg13_hv_pmos ad=3.1302p pd=14.26u as=3.9294p ps=7.84u w=6.66u l=0.6u
X2268 adc8b_0.sar12b_0.sg13cmos5l_buf_1_8.A adc8b_0.sar12b_0.sg13cmos5l_inv_1_7.A vdd vdd sg13_lv_pmos ad=0.3808p pd=2.92u as=0.3808p ps=2.92u w=1.12u l=0.13u
X2269 adc8b_0.side_cap8b_0.buf_16_3.z adc8b_0.side_cap8b_0.in_h_sw[1] sg13cmos5l_Corner_1.vss sg13cmos5l_Corner_1.vss sg13_lv_nmos ad=95f pd=0.88u as=95f ps=0.88u w=0.5u l=0.13u
X2270 adc8b_0.side_cap8b_0.in_l_sw[5] a_89104_100384# vdd vdd sg13_lv_pmos ad=0.42p pd=2.99u as=0.2114p ps=1.54u w=1.12u l=0.13u
X2271 sg13cmos5l_Corner_1.vss sg13cmos5l_IOPadVdd$1_0.sg13cmos5l_Clamp_N43N43D4R$1_0.gate vdd sg13cmos5l_Corner_1.vss sg13_hv_nmos ad=1.408p pd=5.04u as=2.596p ps=5.58u w=4.4u l=0.6u
X2272 sg13cmos5l_Corner_1.vss a_178296_118044# sg13cmos5l_IOPadAnalog_11.pad sg13cmos5l_Corner_1.vss sg13_hv_nmos ad=1.408p pd=5.04u as=2.596p ps=5.58u w=4.4u l=0.6u
X2273 adc8b_0.sar12b_0.sg13cmos5l_inv_1_5.A a_101564_94596# sg13cmos5l_Corner_1.vss sg13cmos5l_Corner_1.vss sg13_lv_nmos ad=0.2516p pd=2.16u as=0.1406p ps=1.12u w=0.74u l=0.13u
X2274 sg13cmos5l_IOPadAnalog_13.pad a_115639_164698# sg13cmos5l_Corner_1.iovdd sg13cmos5l_Corner_1.iovdd sg13_hv_pmos ad=3.9294p pd=7.84u as=2.1312p ps=7.3u w=6.66u l=0.6u
X2275 adc8b_0.sar12b_0.sg13cmos5l_dfrbp_1_8.RESET_B cks vdd vdd sg13_lv_pmos ad=0.3808p pd=2.92u as=0.3808p ps=2.92u w=1.12u l=0.13u
X2276 adc8b_0.sar12b_0.sg13cmos5l_buf_1_46.A a_91473_95810# sg13cmos5l_Corner_1.vss sg13cmos5l_Corner_1.vss sg13_lv_nmos ad=0.2516p pd=2.16u as=0.1406p ps=1.12u w=0.74u l=0.13u
X2277 sg13cmos5l_Corner_1.vss a_87441_94298# a_87396_94334# sg13cmos5l_Corner_1.vss sg13_lv_nmos ad=0.1428p pd=1.52u as=47.25f ps=0.645u w=0.42u l=0.13u
X2278 adc8b_0.side_cap8b_1.buf_16_2.z adc8b_0.sar12b_0.nl_sw[1] vddr vddr sg13_lv_pmos ad=0.19p pd=1.38u as=0.19p ps=1.38u w=1u l=0.13u
X2279 sg13cmos5l_IOPadAnalog_12.pad a_131639_164698# sg13cmos5l_Corner_1.iovdd sg13cmos5l_Corner_1.iovdd sg13_hv_pmos ad=3.9294p pd=7.84u as=2.1312p ps=7.3u w=6.66u l=0.6u
X2280 sg13cmos5l_Corner_1.vss adc8b_0.side_cap8b_0.in_h_sw[0] adc8b_0.side_cap8b_0.buf_32_1.z sg13cmos5l_Corner_1.vss sg13_lv_nmos ad=95f pd=0.88u as=95f ps=0.88u w=0.5u l=0.13u
X2281 vdd adc8b_0.sar12b_0.sg13cmos5l_dfrbp_1_6.RESET_B a_84082_94521# vdd sg13_lv_pmos ad=0.1563p pd=1.22u as=0.147p ps=1.54u w=0.42u l=0.13u
X2282 a_92056_99838# adc8b_0.sar12b_0.sg13cmos5l_dfrbp_1_8.RESET_B vdd vdd sg13_lv_pmos ad=79.8f pd=0.8u as=1.12242p ps=7u w=0.42u l=0.13u
X2283 adc8b_0.side_cap8b_1.buf_8_4.z adc8b_0.sar12b_0.nl_sw[5] sg13cmos5l_Corner_1.vss sg13cmos5l_Corner_1.vss sg13_lv_nmos ad=95f pd=0.88u as=95f ps=0.88u w=0.5u l=0.13u
X2284 a_84273_95107# a_83916_95064# vdd vdd sg13_lv_pmos ad=63f pd=0.72u as=0.1563p ps=1.22u w=0.42u l=0.13u
X2285 vdd sg13cmos5l_IOPadVdd$1_0.sg13cmos5l_Clamp_N43N43D4R$1_0.gate sg13cmos5l_Corner_1.vss sg13cmos5l_Corner_1.vss sg13_hv_nmos ad=2.596p pd=5.58u as=1.408p ps=5.04u w=4.4u l=0.6u
X2286 a_84242_97322# a_83765_97286# a_84148_97322# sg13cmos5l_Corner_1.vss sg13_lv_nmos ad=37.8f pd=0.6u as=0.1428p ps=1.52u w=0.42u l=0.13u
X2287 adc8b_0.side_cap8b_0.in_l_sw[2] a_84016_100384# sg13cmos5l_Corner_1.vss sg13cmos5l_Corner_1.vss sg13_lv_nmos ad=0.2886p pd=2.26u as=0.14875p ps=1.16u w=0.74u l=0.13u
X2288 a_101212_96960# a_100796_96572# a_100977_96929# sg13cmos5l_Corner_1.vss sg13_lv_nmos ad=77.7f pd=0.95u as=0.2516p ps=2.16u w=0.74u l=0.13u
X2289 a_70096_94286# adc8b_0.diff_bsw_0.single_bsw_1.sg13cmos5l_inv_1$1_0.A sg13cmos5l_Corner_1.vss sg13cmos5l_Corner_1.vss sg13_lv_nmos ad=0.442p pd=3.28u as=0.442p ps=3.28u w=1.3u l=0.4u
X2290 sg13cmos5l_Corner_1.iovdd a_134044_42476# frame sg13cmos5l_Corner_1.iovdd sg13_hv_pmos ad=2.1312p pd=7.3u as=3.9294p ps=7.84u w=6.66u l=0.6u
X2291 sg13cmos5l_Corner_1.iovdd a_134044_42476# frame sg13cmos5l_Corner_1.iovdd sg13_hv_pmos ad=3.1302p pd=14.26u as=3.9294p ps=7.84u w=6.66u l=0.6u
X2292 sg13cmos5l_IOPadAnalog_11.padres sg13cmos5l_IOPadAnalog_11.pad sg13cmos5l_Corner_1.vss rppd l=2u w=1u
X2293 adc8b_0.sar12b_0.sg13cmos5l_dlhr_1_12.D a_98039_98911# sg13cmos5l_Corner_1.vss sg13cmos5l_Corner_1.vss sg13_lv_nmos ad=0.2849p pd=2.25u as=0.2516p ps=2.16u w=0.74u l=0.13u
X2294 a_95800_97542# a_95543_97399# a_95962_97322# sg13cmos5l_Corner_1.vss sg13_lv_nmos ad=0.1428p pd=1.52u as=37.8f ps=0.6u w=0.42u l=0.13u
X2295 vddr adc8b_0.side_cap8b_0.in_h_sw[10] adc8b_0.side_cap8b_0.buf_1_1.z vddr sg13_lv_pmos ad=0.34p pd=2.68u as=0.34p ps=2.68u w=1u l=0.13u
X2296 a_97810_98052# a_98253_98095# a_98193_98131# vdd sg13_lv_pmos ad=79.8f pd=0.8u as=63f ps=0.72u w=0.42u l=0.13u
X2297 sg13cmos5l_Corner_1.vss a_101012_93512# adc8b_0.sar12b_0.nl_sw[9] sg13cmos5l_Corner_1.vss sg13_lv_nmos ad=0.14875p pd=1.16u as=0.2886p ps=2.26u w=0.74u l=0.13u
X2298 sg13cmos5l_Corner_1.vss vdd sg13cmos5l_Corner_1.vss sg13cmos5l_Corner_1.vss sg13_lv_nmos ad=0.1428p pd=1.52u as=0 ps=0 w=0.42u l=1u
X2299 vdd adc8b_0.sar12b_0.sg13cmos5l_nor2_1_0.A a_95092_95856# vdd sg13_lv_pmos ad=0.1596p pd=1.22u as=0.2856p ps=2.36u w=0.84u l=0.13u
X2300 vdd a_100131_95430# adc8b_0.sar12b_0.sg13cmos5l_or2_1_0.A vdd sg13_lv_pmos ad=0.3864p pd=2.93u as=0.2128p ps=1.5u w=1.12u l=0.13u
X2301 a_84406_97322# a_84148_97322# sg13cmos5l_Corner_1.vss sg13cmos5l_Corner_1.vss sg13_lv_nmos ad=0.1428p pd=1.52u as=79.8f ps=0.8u w=0.42u l=0.13u
X2302 a_89100_98834# adc8b_0.sar12b_0.sg13cmos5l_dfrbp_1_6.D a_89006_98834# sg13cmos5l_Corner_1.vss sg13_lv_nmos ad=60.89999f pd=0.71u as=0.1428p ps=1.52u w=0.42u l=0.13u
X2303 vddr adc8b_0.side_cap8b_0.in_l_sw[0] adc8b_0.side_cap8b_0.buf_32_0.z vddr sg13_lv_pmos ad=0.19p pd=1.38u as=0.19p ps=1.38u w=1u l=0.13u
X2304 adc8b_0.sar12b_0.sg13cmos5l_dfrbp_1_23.CLK a_95996_100644# vdd vdd sg13_lv_pmos ad=0.3808p pd=2.92u as=0.2128p ps=1.5u w=1.12u l=0.13u
X2305 vdd sg13cmos5l_IOPadVdd$1_0.sg13cmos5l_Clamp_N43N43D4R$1_0.gate sg13cmos5l_Corner_1.vss sg13cmos5l_Corner_1.vss sg13_hv_nmos ad=2.596p pd=5.58u as=1.408p ps=5.04u w=4.4u l=0.6u
X2306 adc8b_0.side_cap8b_0.buf_32_0.z adc8b_0.side_cap8b_0.in_l_sw[0] vddr vddr sg13_lv_pmos ad=0.19p pd=1.38u as=0.19p ps=1.38u w=1u l=0.13u
X2307 adc8b_0.side_cap8b_1.buf_2_3.z adc8b_0.sar12b_0.nh_sw[9] sg13cmos5l_Corner_1.vss sg13cmos5l_Corner_1.vss sg13_lv_nmos ad=0.17p pd=1.68u as=95f ps=0.88u w=0.5u l=0.13u
X2308 adc8b_0.side_cap8b_1.buf_32_0.z adc8b_0.sar12b_0.nl_sw[0] sg13cmos5l_Corner_1.vss sg13cmos5l_Corner_1.vss sg13_lv_nmos ad=95f pd=0.88u as=95f ps=0.88u w=0.5u l=0.13u
X2309 sg13cmos5l_Corner_1.vss adc8b_0.sar12b_0.sg13cmos5l_dfrbp_1_0.RESET_B a_98988_92786# sg13cmos5l_Corner_1.vss sg13_lv_nmos ad=0.1626p pd=1.415u as=60.89999f ps=0.71u w=0.42u l=0.13u
X2310 a_91647_100362# adc8b_0.sar12b_0.sg13cmos5l_dfrbp_1_18.Q vdd vdd sg13_lv_pmos ad=0.3234p pd=2.45u as=4.11675p ps=27.17u w=0.84u l=0.13u
X2311 a_92241_100346# a_92060_100668# vdd vdd sg13_lv_pmos ad=0.2128p pd=1.5u as=0.2387p ps=1.84u w=1.12u l=0.13u
X2312 a_97857_99719# a_96915_99607# a_97655_99957# vdd sg13_lv_pmos ad=93.45f pd=0.865u as=0.2048p ps=1.63u w=0.42u l=0.13u
X2313 adc8b_0.sar12b_0.sg13cmos5l_buf_1_105.A a_99729_99953# sg13cmos5l_Corner_1.vss sg13cmos5l_Corner_1.vss sg13_lv_nmos ad=0.2516p pd=2.16u as=0.1406p ps=1.12u w=0.74u l=0.13u
X2314 a_97137_99225# a_96780_99152# vdd vdd sg13_lv_pmos ad=63f pd=0.72u as=0.1563p ps=1.22u w=0.42u l=0.13u
X2315 a_83252_97286# adc8b_0.sar12b_0.sg13cmos5l_buf_1_58.A sg13cmos5l_Corner_1.vss sg13cmos5l_Corner_1.vss sg13_lv_nmos ad=0.187p pd=1.78u as=0.14875p ps=1.16u w=0.55u l=0.13u
X2316 adc8b_0.side_cap8b_1.buf_16_1.z adc8b_0.sar12b_0.nl_sw[2] sg13cmos5l_Corner_1.vss sg13cmos5l_Corner_1.vss sg13_lv_nmos ad=95f pd=0.88u as=95f ps=0.88u w=0.5u l=0.13u
X2317 a_94188_100359# a_94419_100468# a_93874_100569# sg13cmos5l_Corner_1.vss sg13_lv_nmos ad=0.2373p pd=1.97u as=79.8f ps=0.8u w=0.42u l=0.13u
X2318 cko a_118044_30676# sg13cmos5l_Corner_1.vss sg13cmos5l_Corner_1.vss sg13_hv_nmos ad=2.596p pd=5.58u as=1.408p ps=5.04u w=4.4u l=0.6u
X2319 sg13cmos5l_Corner_1.vss a_85809_93905# a_86334_93978# sg13cmos5l_Corner_1.vss sg13_lv_nmos ad=0.1491p pd=1.18u as=0.187p ps=1.78u w=0.55u l=0.13u
X2320 sg13cmos5l_IOPadAnalog_9.pad a_83639_164698# sg13cmos5l_Corner_1.iovdd sg13cmos5l_Corner_1.iovdd sg13_hv_pmos ad=3.9294p pd=7.84u as=2.1312p ps=7.3u w=6.66u l=0.6u
X2321 adc8b_0.side_cap8b_0.buf_16_2.z adc8b_0.side_cap8b_0.in_l_sw[1] sg13cmos5l_Corner_1.vss sg13cmos5l_Corner_1.vss sg13_lv_nmos ad=95f pd=0.88u as=95f ps=0.88u w=0.5u l=0.13u
X2322 vdd adc8b_0.sar12b_0.sg13cmos5l_dfrbp_1_12.Q_N a_90673_95864# vdd sg13_lv_pmos ad=1.28962p pd=8.195u as=0.2856p ps=2.36u w=0.84u l=0.13u
X2323 a_96945_96929# a_96764_96572# vdd vdd sg13_lv_pmos ad=0.2128p pd=1.5u as=0.2387p ps=1.84u w=1.12u l=0.13u
X2324 cks a_42476_118044# sg13cmos5l_Corner_1.iovdd sg13cmos5l_Corner_1.iovdd sg13_hv_pmos ad=3.9294p pd=7.84u as=2.1312p ps=7.3u w=6.66u l=0.6u
X2325 sg13cmos5l_Corner_1.vss a_90808_99054# a_90457_98911# sg13cmos5l_Corner_1.vss sg13_lv_nmos ad=79.8f pd=0.8u as=0.1428p ps=1.52u w=0.42u l=0.13u
X2326 a_89709_98813# adc8b_0.sar12b_0.sg13cmos5l_dfrbp_1_18.Q sg13cmos5l_Corner_1.vss sg13cmos5l_Corner_1.vss sg13_lv_nmos ad=0.2516p pd=2.16u as=1.49685p ps=9.6u w=0.74u l=0.13u
X2327 a_134044_30676# sg13cmos5l_Corner_1.vss sg13cmos5l_Corner_1.vss rppd l=3.54u w=0.5u
X2328 adc8b_0.side_cap8b_1.buf_16_3.z adc8b_0.sar12b_0.nh_sw[1] vddr vddr sg13_lv_pmos ad=0.19p pd=1.38u as=0.19p ps=1.38u w=1u l=0.13u
X2329 adc8b_0.side_cap8b_1.buf_32_0.z adc8b_0.sar12b_0.nl_sw[0] sg13cmos5l_Corner_1.vss sg13cmos5l_Corner_1.vss sg13_lv_nmos ad=95f pd=0.88u as=95f ps=0.88u w=0.5u l=0.13u
X2330 a_36456_136075# a_40542_135745# sg13cmos5l_Corner_1.vss rppd l=20u w=1u
X2331 adc8b_0.sar12b_0.sg13cmos5l_dfrbp_1_10.Q a_86204_94596# sg13cmos5l_Corner_1.vss sg13cmos5l_Corner_1.vss sg13_lv_nmos ad=0.2516p pd=2.16u as=0.1406p ps=1.12u w=0.74u l=0.13u
X2332 sg13cmos5l_Corner_1.vss sg13cmos5l_IOPadVdd$1_0.sg13cmos5l_Clamp_N43N43D4R$1_0.gate vdd sg13cmos5l_Corner_1.vss sg13_hv_nmos ad=1.408p pd=5.04u as=2.596p ps=5.58u w=4.4u l=0.6u
X2333 sg13cmos5l_Corner_1.vss adc8b_0.side_cap8b_0.in_l_sw[2] adc8b_0.side_cap8b_0.buf_16_1.z sg13cmos5l_Corner_1.vss sg13_lv_nmos ad=95f pd=0.88u as=95f ps=0.88u w=0.5u l=0.13u
X2334 sg13cmos5l_Corner_1.iovdd a_131639_164698# sg13cmos5l_IOPadAnalog_12.pad sg13cmos5l_Corner_1.iovdd sg13_hv_pmos ad=2.1312p pd=7.3u as=3.9294p ps=7.84u w=6.66u l=0.6u
X2335 vdd a_93984_96888# adc8b_0.sar12b_0.sg13cmos5l_a221oi_1_0.B1 vdd sg13_lv_pmos ad=0.2226p pd=1.535u as=0.3976p ps=2.95u w=1.12u l=0.13u
X2336 sg13cmos5l_Corner_1.iovdd a_70044_42476# data[0] sg13cmos5l_Corner_1.iovdd sg13_hv_pmos ad=2.1312p pd=7.3u as=3.9294p ps=7.84u w=6.66u l=0.6u
X2337 sg13cmos5l_Corner_1.iovdd a_70044_42476# data[0] sg13cmos5l_Corner_1.iovdd sg13_hv_pmos ad=3.1302p pd=14.26u as=3.9294p ps=7.84u w=6.66u l=0.6u
X2338 a_93036_93986# adc8b_0.sar12b_0.sg13cmos5l_dfrbp_1_4.D a_92942_93986# sg13cmos5l_Corner_1.vss sg13_lv_nmos ad=60.89999f pd=0.71u as=0.1428p ps=1.52u w=0.42u l=0.13u
X2339 adc8b_0.side_cap8b_0.buf_32_1.z adc8b_0.side_cap8b_0.in_h_sw[0] vddr vddr sg13_lv_pmos ad=0.19p pd=1.38u as=0.19p ps=1.38u w=1u l=0.13u
X2340 vdd adc8b_0.sar12b_0.sg13cmos5l_dfrbp_1_15.D a_84389_98796# vdd sg13_lv_pmos ad=1.15047p pd=7.175u as=0.3234p ps=2.45u w=0.84u l=0.13u
X2341 a_88114_96033# a_88557_95789# a_88497_96201# vdd sg13_lv_pmos ad=79.8f pd=0.8u as=63f ps=0.72u w=0.42u l=0.13u
X2342 sg13cmos5l_IOPadAnalog_12.pad a_131639_164698# sg13cmos5l_Corner_1.iovdd sg13cmos5l_Corner_1.iovdd sg13_hv_pmos ad=3.9294p pd=7.84u as=2.1312p ps=7.3u w=6.66u l=0.6u
X2343 sg13cmos5l_Corner_1.vss sg13cmos5l_IOPadVdd$1_0.sg13cmos5l_Clamp_N43N43D4R$1_0.gate vdd sg13cmos5l_Corner_1.vss sg13_hv_nmos ad=1.408p pd=5.04u as=2.596p ps=5.58u w=4.4u l=0.6u
X2344 adc8b_0.side_cap8b_0.buf_8_3.z adc8b_0.side_cap8b_0.in_h_sw[3] vddr vddr sg13_lv_pmos ad=0.19p pd=1.38u as=0.19p ps=1.38u w=1u l=0.13u
X2345 vdd a_94840_95302# a_94785_95183# vdd sg13_lv_pmos ad=1.43437p pd=9.105u as=93.45f ps=0.865u w=0.42u l=0.13u
X2346 adc8b_0.side_cap8b_1.buf_32_1.z adc8b_0.sar12b_0.nh_sw[0] sg13cmos5l_Corner_1.vss sg13cmos5l_Corner_1.vss sg13_lv_nmos ad=95f pd=0.88u as=95f ps=0.88u w=0.5u l=0.13u
X2347 sg13cmos5l_Corner_1.vss a_102044_30676# data[2] sg13cmos5l_Corner_1.vss sg13_hv_nmos ad=1.408p pd=5.04u as=2.596p ps=5.58u w=4.4u l=0.6u
X2348 vddr adc8b_0.sar12b_0.nl_sw[6] adc8b_0.side_cap8b_1.buf_4_3.z vddr sg13_lv_pmos ad=0.19p pd=1.38u as=0.34p ps=2.68u w=1u l=0.13u
X2349 sg13cmos5l_Corner_1.vss a_30676_70044# vddr sg13cmos5l_Corner_1.vss sg13_hv_nmos ad=1.408p pd=5.04u as=2.596p ps=5.58u w=4.4u l=0.6u
X2350 a_85444_99124# adc8b_0.sar12b_0.sg13cmos5l_dfrbp_1_6.RESET_B vdd vdd sg13_lv_pmos ad=0.2128p pd=1.5u as=0.2128p ps=1.5u w=1.12u l=0.13u
X2351 a_98066_95498# a_97589_95024# a_97972_95498# sg13cmos5l_Corner_1.vss sg13_lv_nmos ad=37.8f pd=0.6u as=0.1428p ps=1.52u w=0.42u l=0.13u
X2352 vip a_42476_102044# sg13cmos5l_Corner_1.iovdd sg13cmos5l_Corner_1.iovdd sg13_hv_pmos ad=3.9294p pd=7.84u as=2.1312p ps=7.3u w=6.66u l=0.6u
X2353 a_90356_95024# adc8b_0.sar12b_0.sg13cmos5l_buf_1_46.A vdd vdd sg13_lv_pmos ad=0.2856p pd=2.36u as=0.2114p ps=1.54u w=0.84u l=0.13u
X2354 sg13cmos5l_Corner_1.vss adc8b_0.sar12b_0.sg13cmos5l_buf_1_5.A a_96208_92824# sg13cmos5l_Corner_1.vss sg13_lv_nmos ad=0.14875p pd=1.16u as=0.187p ps=1.78u w=0.55u l=0.13u
X2355 vin a_42476_86044# sg13cmos5l_Corner_1.iovdd sg13cmos5l_Corner_1.iovdd sg13_hv_pmos ad=3.9294p pd=7.84u as=2.1312p ps=7.3u w=6.66u l=0.6u
X2356 sg13cmos5l_Corner_1.vss a_102222_32962# dantenna l=1.26u w=27.78u
X2357 sg13cmos5l_IOPadVdd$1_0.sg13cmos5l_Clamp_N43N43D4R$1_0.gate sg13cmos5l_IOPadVdd$1_0.sg13cmos5l_RCClampInverter$1_0.in vdd vdd sg13_hv_pmos ad=1.33p pd=7.38u as=1.33p ps=7.38u w=7u l=0.5u
X2358 a_73970_98361# adc8b_0.diff_bsw_0.vcn a_74586_95659# sg13cmos5l_Corner_1.vss sg13_lv_nmos ad=1.7p pd=10.68u as=0.95p ps=5.38u w=5u l=0.13u
X2359 vddr adc8b_0.sar12b_0.nh_sw[2] adc8b_0.side_cap8b_1.buf_16_0.z vddr sg13_lv_pmos ad=0.19p pd=1.38u as=0.19p ps=1.38u w=1u l=0.13u
X2360 data[1] sg13cmos5l_Corner_1.iovdd dpantenna l=1.26u w=27.78u
X2361 vdd sg13cmos5l_IOPadVdd$1_0.sg13cmos5l_Clamp_N43N43D4R$1_0.gate sg13cmos5l_Corner_1.vss sg13cmos5l_Corner_1.vss sg13_hv_nmos ad=2.596p pd=5.58u as=1.408p ps=5.04u w=4.4u l=0.6u
X2362 sg13cmos5l_Corner_1.iovdd a_164624_70044# sg13cmos5l_IOPadAnalog_1.pad sg13cmos5l_Corner_1.iovdd sg13_hv_pmos ad=2.1312p pd=7.3u as=3.9294p ps=7.84u w=6.66u l=0.6u
X2363 sg13cmos5l_Corner_1.vss a_86900_100310# adc8b_0.sar12b_0.sg13cmos5l_buf_1_64.A sg13cmos5l_Corner_1.vss sg13_lv_nmos ad=0.14875p pd=1.16u as=0.2886p ps=2.26u w=0.74u l=0.13u
X2364 sg13cmos5l_IOPadAnalog_0.pad a_164624_86044# sg13cmos5l_Corner_1.iovdd sg13cmos5l_Corner_1.iovdd sg13_hv_pmos ad=3.9294p pd=7.84u as=2.1312p ps=7.3u w=6.66u l=0.6u
X2365 sg13cmos5l_Corner_1.vss a_30676_102044# vip sg13cmos5l_Corner_1.vss sg13_hv_nmos ad=1.408p pd=5.04u as=2.596p ps=5.58u w=4.4u l=0.6u
X2366 adc8b_0.sar12b_0.sg13cmos5l_dfrbp_1_6.RESET_B cks sg13cmos5l_Corner_1.vss sg13cmos5l_Corner_1.vss sg13_lv_nmos ad=0.1406p pd=1.12u as=0.1406p ps=1.12u w=0.74u l=0.13u
X2367 adc8b_0.sar12b_0.sg13cmos5l_dfrbp_1_22.Q_N a_99095_98445# vdd vdd sg13_lv_pmos ad=0.4312p pd=3.01u as=0.2639p ps=1.81u w=1.12u l=0.13u
X2368 a_93138_96920# adc8b_0.sar12b_0.sg13cmos5l_inv_1_0.A a_93036_96920# sg13cmos5l_Corner_1.vss sg13_lv_nmos ad=0.1216p pd=1.02u as=0.1216p ps=1.02u w=0.64u l=0.13u
X2369 a_84082_94521# a_84525_94277# a_83822_94298# sg13cmos5l_Corner_1.vss sg13_lv_nmos ad=79.8f pd=0.8u as=0.1296p ps=1.52u w=0.42u l=0.13u
X2370 vdd a_98516_100310# adc8b_0.side_cap8b_0.in_l_sw[7] vdd sg13_lv_pmos ad=0.2114p pd=1.54u as=0.42p ps=2.99u w=1.12u l=0.13u
X2371 data[2] a_102044_30676# sg13cmos5l_Corner_1.vss sg13cmos5l_Corner_1.vss sg13_hv_nmos ad=2.596p pd=5.58u as=1.408p ps=5.04u w=4.4u l=0.6u
X2372 sg13cmos5l_IOPadAnalog_7.padres sg13cmos5l_Corner_1.iovdd dpantenna l=0.64u w=4.98u
X2373 sg13cmos5l_IOPadAnalog_11.pad a_178296_118044# sg13cmos5l_Corner_1.vss sg13cmos5l_Corner_1.vss sg13_hv_nmos ad=2.596p pd=5.58u as=1.408p ps=5.04u w=4.4u l=0.6u
X2374 a_99756_94311# a_99468_94616# a_99694_94311# sg13cmos5l_Corner_1.vss sg13_lv_nmos ad=0.1428p pd=1.52u as=37.8f ps=0.6u w=0.42u l=0.13u
X2375 vddr a_30676_70044# sg13cmos5l_Corner_1.vss sg13cmos5l_Corner_1.vss sg13_hv_nmos ad=2.596p pd=5.58u as=1.408p ps=5.04u w=4.4u l=0.6u
X2376 a_93132_92786# adc8b_0.sar12b_0.sg13cmos5l_dfrbp_1_1.D a_93038_92786# sg13cmos5l_Corner_1.vss sg13_lv_nmos ad=60.89999f pd=0.71u as=0.1428p ps=1.52u w=0.42u l=0.13u
X2377 vdd a_94487_93909# a_95324_93548# vdd sg13_lv_pmos ad=0.2128p pd=1.5u as=0.3864p ps=2.93u w=1.12u l=0.13u
X2378 sg13cmos5l_IOPadAnalog_13.pad a_115639_164698# sg13cmos5l_Corner_1.iovdd sg13cmos5l_Corner_1.iovdd sg13_hv_pmos ad=3.9294p pd=7.84u as=2.1312p ps=7.3u w=6.66u l=0.6u
X2379 sg13cmos5l_Corner_1.vss adc8b_0.side_cap8b_0.in_l_sw[4] adc8b_0.side_cap8b_0.buf_8_0.z sg13cmos5l_Corner_1.vss sg13_lv_nmos ad=95f pd=0.88u as=95f ps=0.88u w=0.5u l=0.13u
X2380 adc8b_0.sar12b_0.sg13cmos5l_buf_1_96.A a_92433_98441# sg13cmos5l_Corner_1.vss sg13cmos5l_Corner_1.vss sg13_lv_nmos ad=0.2516p pd=2.16u as=0.1406p ps=1.12u w=0.74u l=0.13u
X2381 adc8b_0.cmp_0.sg13cmos5l_inv_1$1_1.Y adc8b_0.cmp_0.outn sg13cmos5l_Corner_1.vss sg13cmos5l_Corner_1.vss sg13_lv_nmos ad=0.2516p pd=2.16u as=0.2516p ps=2.16u w=0.74u l=0.13u
X2382 vddr adc8b_0.sar12b_0.nh_sw[0] adc8b_0.side_cap8b_1.buf_32_1.z vddr sg13_lv_pmos ad=0.19p pd=1.38u as=0.19p ps=1.38u w=1u l=0.13u
X2383 adc8b_0.sar12b_0.sg13cmos5l_dfrbp_1_23.Q_N a_95543_97399# vdd vdd sg13_lv_pmos ad=0.4312p pd=3.01u as=0.2639p ps=1.81u w=1.12u l=0.13u
X2384 vddr adc8b_0.side_cap8b_0.in_h_sw[4] adc8b_0.side_cap8b_0.buf_8_2.z vddr sg13_lv_pmos ad=0.19p pd=1.38u as=0.19p ps=1.38u w=1u l=0.13u
X2385 vddr adc8b_0.sar12b_0.nl_sw[0] adc8b_0.side_cap8b_1.buf_32_0.z vddr sg13_lv_pmos ad=0.19p pd=1.38u as=0.19p ps=1.38u w=1u l=0.13u
X2386 vdd adc8b_0.sar12b_0.sg13cmos5l_dfrbp_1_8.RESET_B a_87470_100034# vdd sg13_lv_pmos ad=0.36237p pd=2.605u as=79.8f ps=0.8u w=0.42u l=0.13u
X2387 a_100767_97338# adc8b_0.sar12b_0.sg13cmos5l_dfrbp_1_8.D vdd vdd sg13_lv_pmos ad=0.3234p pd=2.45u as=1.04815p ps=6.595u w=0.84u l=0.13u
X2388 vdd sg13cmos5l_Corner_1.vss vdd vdd sg13_lv_pmos ad=0.34p pd=2.68u as=0 ps=0 w=1u l=1u
X2389 vdd a_90740_95024# adc8b_0.sar12b_0.sg13cmos5l_buf_1_45.X vdd sg13_lv_pmos ad=0.2114p pd=1.54u as=0.42p ps=2.99u w=1.12u l=0.13u
X2390 vddr a_42476_70044# sg13cmos5l_Corner_1.iovdd sg13cmos5l_Corner_1.iovdd sg13_hv_pmos ad=3.9294p pd=7.84u as=2.1312p ps=7.3u w=6.66u l=0.6u
X2391 a_94804_96108# a_94582_95852# vdd vdd sg13_lv_pmos ad=0.1176p pd=1.33u as=0.2618p ps=1.63u w=1.12u l=0.13u
X2392 sg13cmos5l_IOPadAnalog_16.pad a_164624_102044# sg13cmos5l_Corner_1.iovdd sg13cmos5l_Corner_1.iovdd sg13_hv_pmos ad=3.9294p pd=7.84u as=2.1312p ps=7.3u w=6.66u l=0.6u
X2393 a_88984_97542# adc8b_0.sar12b_0.sg13cmos5l_dfrbp_1_6.RESET_B vdd vdd sg13_lv_pmos ad=79.8f pd=0.8u as=1.04815p ps=6.595u w=0.42u l=0.13u
X2394 sg13cmos5l_Corner_1.iovdd a_164624_86044# sg13cmos5l_IOPadAnalog_0.pad sg13cmos5l_Corner_1.iovdd sg13_hv_pmos ad=2.1312p pd=7.3u as=3.9294p ps=7.84u w=6.66u l=0.6u
X2395 a_93874_100569# a_94317_100325# a_94257_100737# vdd sg13_lv_pmos ad=79.8f pd=0.8u as=63f ps=0.72u w=0.42u l=0.13u
X2396 sg13cmos5l_Corner_1.vss a_30676_118044# cks sg13cmos5l_Corner_1.vss sg13_hv_nmos ad=1.408p pd=5.04u as=2.596p ps=5.58u w=4.4u l=0.6u
X2397 a_96590_98084# a_96194_98448# a_96476_98084# vdd sg13_lv_pmos ad=0.1008p pd=0.9u as=0.191p ps=1.44u w=0.42u l=0.13u
X2398 a_82450_96540# a_82893_96583# a_82190_97010# sg13cmos5l_Corner_1.vss sg13_lv_nmos ad=79.8f pd=0.8u as=0.1296p ps=1.52u w=0.42u l=0.13u
X2399 sg13cmos5l_Corner_1.vss sg13cmos5l_IOPadVdd$1_0.sg13cmos5l_RCClampInverter$1_0.in sg13cmos5l_Corner_1.vss sg13cmos5l_Corner_1.vss sg13_hv_nmos ad=1.71p pd=9.38u as=0 ps=0 w=9u l=9.5u
X2400 a_92180_97286# adc8b_0.sar12b_0.sg13cmos5l_dlhr_1_5.Q vdd vdd sg13_lv_pmos ad=0.2856p pd=2.36u as=0.2114p ps=1.54u w=0.84u l=0.13u
X2401 sg13cmos5l_Corner_1.vss a_100995_95814# adc8b_0.sar12b_0.sg13cmos5l_buf_8_0.X sg13cmos5l_Corner_1.vss sg13_lv_nmos ad=0.1406p pd=1.12u as=0.1406p ps=1.12u w=0.74u l=0.13u
X2402 sg13cmos5l_IOPadAnalog_16.pad a_178296_102044# sg13cmos5l_Corner_1.vss sg13cmos5l_Corner_1.vss sg13_hv_nmos ad=2.596p pd=5.58u as=1.408p ps=5.04u w=4.4u l=0.6u
X2403 sg13cmos5l_Corner_1.iovdd a_131639_164698# sg13cmos5l_IOPadAnalog_12.pad sg13cmos5l_Corner_1.iovdd sg13_hv_pmos ad=2.1312p pd=7.3u as=3.9294p ps=7.84u w=6.66u l=0.6u
X2404 vin a_30676_86044# sg13cmos5l_Corner_1.vss sg13cmos5l_Corner_1.vss sg13_hv_nmos ad=2.596p pd=5.58u as=1.408p ps=5.04u w=4.4u l=0.6u
X2405 a_98319_95147# a_98471_95031# sg13cmos5l_Corner_1.vss sg13cmos5l_Corner_1.vss sg13_lv_nmos ad=0.2516p pd=2.16u as=2.41737p ps=15.64u w=0.74u l=0.13u
X2406 sg13cmos5l_Corner_1.iovdd a_102044_42476# data[2] sg13cmos5l_Corner_1.iovdd sg13_hv_pmos ad=2.1312p pd=7.3u as=3.9294p ps=7.84u w=6.66u l=0.6u
X2407 sg13cmos5l_Corner_1.vss adc8b_0.sar12b_0.nl_sw[2] adc8b_0.side_cap8b_1.buf_16_1.z sg13cmos5l_Corner_1.vss sg13_lv_nmos ad=95f pd=0.88u as=95f ps=0.88u w=0.5u l=0.13u
X2408 vddr a_42476_70044# sg13cmos5l_Corner_1.iovdd sg13cmos5l_Corner_1.iovdd sg13_hv_pmos ad=3.9294p pd=7.84u as=2.1312p ps=7.3u w=6.66u l=0.6u
X2409 a_89588_100310# adc8b_0.sar12b_0.sg13cmos5l_buf_1_73.A sg13cmos5l_Corner_1.vss sg13cmos5l_Corner_1.vss sg13_lv_nmos ad=0.187p pd=1.78u as=0.14875p ps=1.16u w=0.55u l=0.13u
X2410 a_86092_99156# a_86117_98796# sg13cmos5l_Corner_1.vss sg13cmos5l_Corner_1.vss sg13_lv_nmos ad=0.2775p pd=2.23u as=1.49685p ps=9.6u w=0.74u l=0.13u
X2411 a_86702_93986# a_87507_93559# a_86962_93516# vdd sg13_lv_pmos ad=0.1428p pd=1.52u as=79.8f ps=0.8u w=0.42u l=0.13u
X2412 a_87468_97640# a_87442_97545# vdd vdd sg13_lv_pmos ad=0.34p pd=2.68u as=0.36237p ps=2.605u w=1u l=0.13u
X2413 a_82284_97010# adc8b_0.sar12b_0.sg13cmos5l_dfrbp_1_6.D a_82190_97010# sg13cmos5l_Corner_1.vss sg13_lv_nmos ad=60.89999f pd=0.71u as=0.1428p ps=1.52u w=0.42u l=0.13u
X2414 a_86900_95024# adc8b_0.sar12b_0.sg13cmos5l_buf_1_44.A vdd vdd sg13_lv_pmos ad=0.2856p pd=2.36u as=0.2114p ps=1.54u w=0.84u l=0.13u
X2415 sg13cmos5l_Corner_1.vss adc8b_0.sar12b_0.nh_sw[0] adc8b_0.side_cap8b_1.buf_32_1.z sg13cmos5l_Corner_1.vss sg13_lv_nmos ad=95f pd=0.88u as=95f ps=0.88u w=0.5u l=0.13u
X2416 sg13cmos5l_Corner_1.vss adc8b_0.sar12b_0.nl_sw[0] adc8b_0.side_cap8b_1.buf_32_0.z sg13cmos5l_Corner_1.vss sg13_lv_nmos ad=95f pd=0.88u as=95f ps=0.88u w=0.5u l=0.13u
X2417 sg13cmos5l_Corner_1.vss sg13cmos5l_IOPadVdd$1_0.sg13cmos5l_RCClampInverter$1_0.in sg13cmos5l_Corner_1.vss sg13cmos5l_Corner_1.vss sg13_hv_nmos ad=1.71p pd=9.38u as=0 ps=0 w=9u l=9.5u
X2418 vdd a_94815_98850# a_94946_98844# vdd sg13_lv_pmos ad=1.15047p pd=7.175u as=0.2856p ps=2.36u w=0.84u l=0.13u
X2419 sg13cmos5l_Corner_1.vss a_30676_102044# sg13cmos5l_Corner_1.vss rppd l=3.54u w=0.5u
X2420 vddr adc8b_0.side_cap8b_0.in_l_sw[6] adc8b_0.side_cap8b_0.buf_4_3.z vddr sg13_lv_pmos ad=0.19p pd=1.38u as=0.34p ps=2.68u w=1u l=0.13u
X2421 a_89084_94620# a_88671_94314# a_89016_94620# vdd sg13_lv_pmos ad=0.191p pd=1.44u as=0.105p ps=1.21u w=1u l=0.13u
X2422 adc8b_0.sar12b_0.nl_sw[6] a_93424_94336# vdd vdd sg13_lv_pmos ad=0.42p pd=2.99u as=0.2114p ps=1.54u w=1.12u l=0.13u
X2423 sg13cmos5l_Corner_1.iovdd a_134044_42476# frame sg13cmos5l_Corner_1.iovdd sg13_hv_pmos ad=2.1312p pd=7.3u as=3.9294p ps=7.84u w=6.66u l=0.6u
X2424 sg13cmos5l_IOPadAnalog_13.pad a_115639_164698# sg13cmos5l_Corner_1.iovdd sg13cmos5l_Corner_1.iovdd sg13_hv_pmos ad=3.9294p pd=7.84u as=3.1302p ps=14.26u w=6.66u l=0.6u
X2425 adc8b_0.side_cap8b_0.buf_16_1.z adc8b_0.side_cap8b_0.in_l_sw[2] vddr vddr sg13_lv_pmos ad=0.19p pd=1.38u as=0.19p ps=1.38u w=1u l=0.13u
X2426 a_86228_100310# adc8b_0.sar12b_0.sg13cmos5l_buf_1_60.A sg13cmos5l_Corner_1.vss sg13cmos5l_Corner_1.vss sg13_lv_nmos ad=0.187p pd=1.78u as=0.14875p ps=1.16u w=0.55u l=0.13u
X2427 a_99932_99156# a_99650_98844# a_99865_98826# sg13cmos5l_Corner_1.vss sg13_lv_nmos ad=0.141p pd=1.17u as=71.99999f ps=0.865u w=0.64u l=0.13u
X2428 sg13cmos5l_IOPadAnalog_0.pad a_178296_86044# sg13cmos5l_Corner_1.vss sg13cmos5l_Corner_1.vss sg13_hv_nmos ad=2.596p pd=5.58u as=1.408p ps=5.04u w=4.4u l=0.6u
X2429 sg13cmos5l_IOPadAnalog_12.pad a_131639_164698# sg13cmos5l_Corner_1.iovdd sg13cmos5l_Corner_1.iovdd sg13_hv_pmos ad=3.9294p pd=7.84u as=2.1312p ps=7.3u w=6.66u l=0.6u
X2430 a_83916_99600# a_83890_99564# sg13cmos5l_Corner_1.vss sg13cmos5l_Corner_1.vss sg13_lv_nmos ad=0.2516p pd=2.16u as=0.1626p ps=1.415u w=0.74u l=0.13u
X2431 a_85628_93548# a_85215_93906# a_85560_93548# vdd sg13_lv_pmos ad=0.191p pd=1.44u as=0.105p ps=1.21u w=1u l=0.13u
X2432 a_96684_100021# a_96915_99607# a_96370_99564# sg13cmos5l_Corner_1.vss sg13_lv_nmos ad=0.2373p pd=1.97u as=79.8f ps=0.8u w=0.42u l=0.13u
X2433 a_84142_95485# adc8b_0.sar12b_0.sg13cmos5l_dfrbp_1_8.RESET_B sg13cmos5l_Corner_1.vss sg13cmos5l_Corner_1.vss sg13_lv_nmos ad=37.8f pd=0.6u as=0.1701p ps=1.65u w=0.42u l=0.13u
X2434 a_90356_95024# adc8b_0.sar12b_0.sg13cmos5l_buf_1_46.A sg13cmos5l_Corner_1.vss sg13cmos5l_Corner_1.vss sg13_lv_nmos ad=0.187p pd=1.78u as=0.14875p ps=1.16u w=0.55u l=0.13u
X2435 a_95409_94689# a_95052_94616# vdd vdd sg13_lv_pmos ad=63f pd=0.72u as=0.1563p ps=1.22u w=0.42u l=0.13u
X2436 vdd a_98708_94262# adc8b_0.sar12b_0.nh_sw[8] vdd sg13_lv_pmos ad=0.2114p pd=1.54u as=0.42p ps=2.99u w=1.12u l=0.13u
X2437 vdd a_99095_98445# a_99932_98084# vdd sg13_lv_pmos ad=0.2128p pd=1.5u as=0.3864p ps=2.93u w=1.12u l=0.13u
X2438 sg13cmos5l_Corner_1.vss adc8b_0.sar12b_0.sg13cmos5l_dfrbp_1_10.Q a_86641_94352# sg13cmos5l_Corner_1.vss sg13_lv_nmos ad=0.15055p pd=1.17u as=0.187p ps=1.78u w=0.55u l=0.13u
X2439 frame a_134044_30676# sg13cmos5l_Corner_1.vss sg13cmos5l_Corner_1.vss sg13_hv_nmos ad=2.596p pd=5.58u as=1.408p ps=5.04u w=4.4u l=0.6u
X2440 sg13cmos5l_Corner_1.iovdd a_42476_86044# vin sg13cmos5l_Corner_1.iovdd sg13_hv_pmos ad=2.1312p pd=7.3u as=3.9294p ps=7.84u w=6.66u l=0.6u
X2441 sg13cmos5l_Corner_1.vss sg13cmos5l_IOPadVdd$1_0.sg13cmos5l_Clamp_N43N43D4R$1_0.gate vdd sg13cmos5l_Corner_1.vss sg13_hv_nmos ad=1.408p pd=5.04u as=2.596p ps=5.58u w=4.4u l=0.6u
X2442 sg13cmos5l_Corner_1.vss adc8b_0.sar12b_0.nh_sw[0] adc8b_0.side_cap8b_1.buf_32_1.z sg13cmos5l_Corner_1.vss sg13_lv_nmos ad=95f pd=0.88u as=95f ps=0.88u w=0.5u l=0.13u
X2443 vdd sg13cmos5l_IOPadVdd$1_0.sg13cmos5l_Clamp_N43N43D4R$1_0.gate sg13cmos5l_Corner_1.vss sg13cmos5l_Corner_1.vss sg13_hv_nmos ad=2.596p pd=5.58u as=1.408p ps=5.04u w=4.4u l=0.6u
X2444 adc8b_0.side_cap8b_0.buf_16_3.z adc8b_0.side_cap8b_0.in_h_sw[1] sg13cmos5l_Corner_1.vss sg13cmos5l_Corner_1.vss sg13_lv_nmos ad=95f pd=0.88u as=95f ps=0.88u w=0.5u l=0.13u
X2445 sg13cmos5l_Corner_1.vss adc8b_0.sar12b_0.sg13cmos5l_buf_8_0.A a_100995_95814# sg13cmos5l_Corner_1.vss sg13_lv_nmos ad=0.1406p pd=1.12u as=0.1406p ps=1.12u w=0.74u l=0.13u
X2446 sg13cmos5l_IOPadVdd$1_0.sg13cmos5l_Clamp_N43N43D4R$1_0.gate sg13cmos5l_IOPadVdd$1_0.sg13cmos5l_RCClampInverter$1_0.in sg13cmos5l_Corner_1.vss sg13cmos5l_Corner_1.vss sg13_hv_nmos ad=1.71p pd=9.38u as=1.71p ps=9.38u w=9u l=0.5u
X2447 vdd a_86327_98790# a_86286_99156# vdd sg13_lv_pmos ad=1.15047p pd=7.175u as=0.105p ps=1.21u w=1u l=0.13u
X2448 adc8b_0.sar12b_0.sg13cmos5l_dfrbp_1_22.Q_N a_99095_98445# sg13cmos5l_Corner_1.vss sg13cmos5l_Corner_1.vss sg13_lv_nmos ad=0.2849p pd=2.25u as=0.2516p ps=2.16u w=0.74u l=0.13u
X2449 adc8b_0.side_cap8b_0.buf_8_5.z adc8b_0.side_cap8b_0.in_h_sw[5] sg13cmos5l_Corner_1.vss sg13cmos5l_Corner_1.vss sg13_lv_nmos ad=0.17p pd=1.68u as=95f ps=0.88u w=0.5u l=0.13u
X2450 a_88428_95823# a_88140_96128# a_88366_95823# sg13cmos5l_Corner_1.vss sg13_lv_nmos ad=0.1428p pd=1.52u as=37.8f ps=0.6u w=0.42u l=0.13u
X2451 sg13cmos5l_Corner_1.vss sg13cmos5l_Corner_1.iovdd dpantenna l=1.26u w=27.78u
X2452 adc8b_0.side_cap8b_1.buf_8_4.z adc8b_0.sar12b_0.nl_sw[5] sg13cmos5l_Corner_1.vss sg13cmos5l_Corner_1.vss sg13_lv_nmos ad=95f pd=0.88u as=95f ps=0.88u w=0.5u l=0.13u
X2453 a_92195_93896# adc8b_0.sar12b_0.sg13cmos5l_nor2_1_0.A sg13cmos5l_Corner_1.vss sg13cmos5l_Corner_1.vss sg13_lv_nmos ad=78.39999f pd=0.885u as=0.2272p ps=1.99u w=0.64u l=0.13u
X2454 sg13cmos5l_Corner_1.vss adc8b_0.sar12b_0.sg13cmos5l_buf_1_96.A a_93232_99596# sg13cmos5l_Corner_1.vss sg13_lv_nmos ad=0.14875p pd=1.16u as=0.187p ps=1.78u w=0.55u l=0.13u
X2455 sg13cmos5l_IOPadVdd$1_0.sg13cmos5l_Clamp_N43N43D4R$1_0.gate sg13cmos5l_IOPadVdd$1_0.sg13cmos5l_RCClampInverter$1_0.in sg13cmos5l_Corner_1.vss sg13cmos5l_Corner_1.vss sg13_hv_nmos ad=1.71p pd=9.38u as=1.71p ps=9.38u w=9u l=0.5u
X2456 sg13cmos5l_IOPadVdd$1_0.sg13cmos5l_Clamp_N43N43D4R$1_0.gate sg13cmos5l_IOPadVdd$1_0.sg13cmos5l_RCClampInverter$1_0.in vdd vdd sg13_hv_pmos ad=1.33p pd=7.38u as=1.33p ps=7.38u w=7u l=0.5u
X2457 adc8b_0.sar12b_0.sg13cmos5l_dlhr_1_11.D a_93335_98911# sg13cmos5l_Corner_1.vss sg13cmos5l_Corner_1.vss sg13_lv_nmos ad=0.2849p pd=2.25u as=0.2516p ps=2.16u w=0.74u l=0.13u
X2458 sg13cmos5l_Corner_1.vss adc8b_0.sar12b_0.sg13cmos5l_buf_1_4.A a_98320_92824# sg13cmos5l_Corner_1.vss sg13_lv_nmos ad=0.14875p pd=1.16u as=0.187p ps=1.78u w=0.55u l=0.13u
X2459 sg13cmos5l_Corner_1.vss a_118044_30676# cko sg13cmos5l_Corner_1.vss sg13_hv_nmos ad=1.408p pd=5.04u as=2.596p ps=5.58u w=4.4u l=0.6u
X2460 vdd adc8b_0.sar12b_0.sg13cmos5l_dfrbp_1_6.RESET_B a_100113_98834# vdd sg13_lv_pmos ad=0.2128p pd=1.5u as=0.2128p ps=1.5u w=1.12u l=0.13u
X2461 vdd a_84177_95810# a_84110_96248# vdd sg13_lv_pmos ad=0.2387p pd=1.84u as=0.1008p ps=0.9u w=0.42u l=0.13u
X2462 vddr adc8b_0.sar12b_0.nh_sw[6] adc8b_0.side_cap8b_1.buf_4_1.z vddr sg13_lv_pmos ad=0.19p pd=1.38u as=0.19p ps=1.38u w=1u l=0.13u
X2463 adc8b_0.sar12b_0.sg13cmos5l_dlhr_1_15.D a_98876_99132# sg13cmos5l_Corner_1.vss sg13cmos5l_Corner_1.vss sg13_lv_nmos ad=0.2516p pd=2.16u as=0.1406p ps=1.12u w=0.74u l=0.13u
X2464 vdd adc8b_0.sar12b_0.sg13cmos5l_buf_1_116.A a_97360_97360# vdd sg13_lv_pmos ad=0.2114p pd=1.54u as=0.2856p ps=2.36u w=0.84u l=0.13u
X2465 data[2] a_102044_42476# sg13cmos5l_Corner_1.iovdd sg13cmos5l_Corner_1.iovdd sg13_hv_pmos ad=3.9294p pd=7.84u as=2.1312p ps=7.3u w=6.66u l=0.6u
X2466 sg13cmos5l_Corner_1.vss a_90740_95024# adc8b_0.sar12b_0.sg13cmos5l_buf_1_45.X sg13cmos5l_Corner_1.vss sg13_lv_nmos ad=0.14875p pd=1.16u as=0.2886p ps=2.26u w=0.74u l=0.13u
X2467 vdd a_87441_94298# a_87374_94736# vdd sg13_lv_pmos ad=0.2387p pd=1.84u as=0.1008p ps=0.9u w=0.42u l=0.13u
X2468 sg13cmos5l_Corner_1.iovdd a_70044_42476# data[0] sg13cmos5l_Corner_1.iovdd sg13_hv_pmos ad=2.1312p pd=7.3u as=3.9294p ps=7.84u w=6.66u l=0.6u
X2469 adc8b_0.sar12b_0.sg13cmos5l_buf_1_94.X a_96784_100384# vdd vdd sg13_lv_pmos ad=0.42p pd=2.99u as=0.2114p ps=1.54u w=1.12u l=0.13u
X2470 sg13cmos5l_Corner_1.vss adc8b_0.sar12b_0.sg13cmos5l_buf_1_24.X a_87472_92824# sg13cmos5l_Corner_1.vss sg13_lv_nmos ad=0.14875p pd=1.16u as=0.187p ps=1.78u w=0.55u l=0.13u
X2471 sg13cmos5l_IOPadAnalog_9.pad a_83639_164698# sg13cmos5l_Corner_1.iovdd sg13cmos5l_Corner_1.iovdd sg13_hv_pmos ad=3.9294p pd=7.84u as=3.1302p ps=14.26u w=6.66u l=0.6u
X2472 sg13cmos5l_IOPadAnalog_0.pad a_164624_86044# sg13cmos5l_Corner_1.iovdd sg13cmos5l_Corner_1.iovdd sg13_hv_pmos ad=3.9294p pd=7.84u as=2.1312p ps=7.3u w=6.66u l=0.6u
X2473 adc8b_0.side_cap8b_0.buf_32_0.z adc8b_0.side_cap8b_0.in_l_sw[0] sg13cmos5l_Corner_1.vss sg13cmos5l_Corner_1.vss sg13_lv_nmos ad=95f pd=0.88u as=95f ps=0.88u w=0.5u l=0.13u
X2474 vdd cks a_100995_100350# vdd sg13_lv_pmos ad=0.2128p pd=1.5u as=0.2128p ps=1.5u w=1.12u l=0.13u
X2475 sg13cmos5l_Corner_1.vss adc8b_0.sar12b_0.sg13cmos5l_buf_1_5.A adc8b_0.sar12b_0.sg13cmos5l_inv_1_27.Y sg13cmos5l_Corner_1.vss sg13_lv_nmos ad=0.2516p pd=2.16u as=0.2516p ps=2.16u w=0.74u l=0.13u
X2476 a_85539_97713# a_84647_97592# a_85437_97480# vdd sg13_lv_pmos ad=63f pd=0.72u as=79.8f ps=0.8u w=0.42u l=0.13u
X2477 data[0] a_70044_30676# sg13cmos5l_Corner_1.vss sg13cmos5l_Corner_1.vss sg13_hv_nmos ad=2.596p pd=5.58u as=1.408p ps=5.04u w=4.4u l=0.6u
X2478 vdd sg13cmos5l_IOPadVdd$1_0.sg13cmos5l_Clamp_N43N43D4R$1_0.gate sg13cmos5l_Corner_1.vss sg13cmos5l_Corner_1.vss sg13_hv_nmos ad=2.596p pd=5.58u as=1.408p ps=5.04u w=4.4u l=0.6u
X2479 sg13cmos5l_Corner_1.vss a_30676_86044# vin sg13cmos5l_Corner_1.vss sg13_hv_nmos ad=1.408p pd=5.04u as=2.596p ps=5.58u w=4.4u l=0.6u
X2480 sg13cmos5l_Corner_1.iovdd a_131639_164698# sg13cmos5l_IOPadAnalog_12.pad sg13cmos5l_Corner_1.iovdd sg13_hv_pmos ad=2.1312p pd=7.3u as=3.9294p ps=7.84u w=6.66u l=0.6u
X2481 a_85444_99124# a_85844_98784# a_85802_98820# sg13cmos5l_Corner_1.vss sg13_lv_nmos ad=0.2516p pd=2.16u as=77.7f ps=0.95u w=0.74u l=0.13u
X2482 a_96696_96572# a_96145_96930# vdd vdd sg13_lv_pmos ad=0.105p pd=1.21u as=1.28962p ps=8.195u w=1u l=0.13u
X2483 adc8b_0.side_cap8b_1.buf_32_0.z adc8b_0.sar12b_0.nl_sw[0] sg13cmos5l_Corner_1.vss sg13cmos5l_Corner_1.vss sg13_lv_nmos ad=95f pd=0.88u as=95f ps=0.88u w=0.5u l=0.13u
X2484 adc8b_0.side_cap8b_0.buf_32_0.z adc8b_0.side_cap8b_0.in_l_sw[0] vddr vddr sg13_lv_pmos ad=0.19p pd=1.38u as=0.19p ps=1.38u w=1u l=0.13u
X2485 a_87468_97640# a_87442_97545# sg13cmos5l_Corner_1.vss sg13cmos5l_Corner_1.vss sg13_lv_nmos ad=0.2516p pd=2.16u as=0.1626p ps=1.415u w=0.74u l=0.13u
X2486 vddr adc8b_0.sar12b_0.nh_sw[4] adc8b_0.side_cap8b_1.buf_8_2.z vddr sg13_lv_pmos ad=0.19p pd=1.38u as=0.34p ps=2.68u w=1u l=0.13u
X2487 a_98776_93790# adc8b_0.sar12b_0.sg13cmos5l_dfrbp_1_0.RESET_B vdd vdd sg13_lv_pmos ad=79.8f pd=0.8u as=1.777p ps=11.395u w=0.42u l=0.13u
X2488 sg13cmos5l_IOPadVdd$1_0.sg13cmos5l_Clamp_N43N43D4R$1_0.gate sg13cmos5l_IOPadVdd$1_0.sg13cmos5l_RCClampInverter$1_0.in vdd vdd sg13_hv_pmos ad=1.33p pd=7.38u as=1.33p ps=7.38u w=7u l=0.5u
X2489 sg13cmos5l_IOPadAnalog_14.padres sg13cmos5l_Corner_1.iovdd dpantenna l=4.98u w=0.64u
X2490 a_86900_95024# adc8b_0.sar12b_0.sg13cmos5l_buf_1_44.A sg13cmos5l_Corner_1.vss sg13cmos5l_Corner_1.vss sg13_lv_nmos ad=0.187p pd=1.78u as=0.14875p ps=1.16u w=0.55u l=0.13u
X2491 adc8b_0.side_cap8b_1.buf_8_3.z adc8b_0.sar12b_0.nh_sw[3] sg13cmos5l_Corner_1.vss sg13cmos5l_Corner_1.vss sg13_lv_nmos ad=95f pd=0.88u as=95f ps=0.88u w=0.5u l=0.13u
X2492 adc8b_0.sar12b_0.sg13cmos5l_dfrbp_1_27.Q_N a_91799_99957# vdd vdd sg13_lv_pmos ad=0.4312p pd=3.01u as=0.2639p ps=1.81u w=1.12u l=0.13u
X2493 sg13cmos5l_Corner_1.vss vdd sg13cmos5l_Corner_1.vss sg13cmos5l_Corner_1.vss sg13_lv_nmos ad=79.8f pd=0.8u as=0 ps=0 w=0.42u l=1u
X2494 a_91988_94262# adc8b_0.sar12b_0.sg13cmos5l_buf_1_28.X sg13cmos5l_Corner_1.vss sg13cmos5l_Corner_1.vss sg13_lv_nmos ad=0.187p pd=1.78u as=0.14875p ps=1.16u w=0.55u l=0.13u
X2495 a_88340_92750# adc8b_0.sar12b_0.sg13cmos5l_buf_1_24.A vdd vdd sg13_lv_pmos ad=0.2856p pd=2.36u as=0.2114p ps=1.54u w=0.84u l=0.13u
X2496 vddr adc8b_0.side_cap8b_0.in_l_sw[4] adc8b_0.side_cap8b_0.buf_8_0.z vddr sg13_lv_pmos ad=0.19p pd=1.38u as=0.34p ps=2.68u w=1u l=0.13u
X2497 sg13cmos5l_Corner_1.vss vdd sg13cmos5l_Corner_1.vss sg13cmos5l_Corner_1.vss sg13_lv_nmos ad=0.1428p pd=1.52u as=0 ps=0 w=0.42u l=1u
X2498 a_89162_97010# adc8b_0.sar12b_0.sg13cmos5l_dfrbp_1_8.RESET_B sg13cmos5l_Corner_1.vss sg13cmos5l_Corner_1.vss sg13_lv_nmos ad=60.89999f pd=0.71u as=0.1626p ps=1.415u w=0.42u l=0.13u
X2499 a_178296_118044# sg13cmos5l_Corner_1.vss sg13cmos5l_Corner_1.vss rppd l=3.54u w=0.5u
X2500 sg13cmos5l_Corner_1.vss a_89588_100310# adc8b_0.sar12b_0.sg13cmos5l_buf_1_73.X sg13cmos5l_Corner_1.vss sg13_lv_nmos ad=0.14875p pd=1.16u as=0.2886p ps=2.26u w=0.74u l=0.13u
X2501 adc8b_0.sar12b_0.sg13cmos5l_buf_1_3.A a_101296_98084# vdd vdd sg13_lv_pmos ad=0.42p pd=2.99u as=0.2114p ps=1.54u w=1.12u l=0.13u
X2502 sg13cmos5l_Corner_1.iovdd a_42476_102044# vip sg13cmos5l_Corner_1.iovdd sg13_hv_pmos ad=2.1312p pd=7.3u as=3.9294p ps=7.84u w=6.66u l=0.6u
X2503 vdd a_83252_100310# adc8b_0.sar12b_0.sg13cmos5l_buf_1_68.X vdd sg13_lv_pmos ad=0.2114p pd=1.54u as=0.42p ps=2.99u w=1.12u l=0.13u
X2504 adc8b_0.sar12b_0.sg13cmos5l_buf_1_103.A a_97552_100384# vdd vdd sg13_lv_pmos ad=0.42p pd=2.99u as=0.2114p ps=1.54u w=1.12u l=0.13u
X2505 sg13cmos5l_Corner_1.vss adc8b_0.sar12b_0.sg13cmos5l_dfrbp_1_6.RESET_B a_91036_97308# sg13cmos5l_Corner_1.vss sg13_lv_nmos ad=0.1406p pd=1.12u as=77.7f ps=0.95u w=0.74u l=0.13u
X2506 sg13cmos5l_Corner_1.vss vdd sg13cmos5l_Corner_1.vss sg13cmos5l_Corner_1.vss sg13_lv_nmos ad=0.1428p pd=1.52u as=0 ps=0 w=0.42u l=1u
X2507 sg13cmos5l_Corner_1.vss a_98903_95887# a_99740_96108# sg13cmos5l_Corner_1.vss sg13_lv_nmos ad=0.1406p pd=1.12u as=0.2516p ps=2.16u w=0.74u l=0.13u
X2508 cks a_42476_118044# sg13cmos5l_Corner_1.iovdd sg13cmos5l_Corner_1.iovdd sg13_hv_pmos ad=3.9294p pd=7.84u as=2.1312p ps=7.3u w=6.66u l=0.6u
X2509 sg13cmos5l_Corner_1.vss adc8b_0.side_cap8b_0.in_h_sw[3] adc8b_0.side_cap8b_0.buf_8_3.z sg13cmos5l_Corner_1.vss sg13_lv_nmos ad=95f pd=0.88u as=95f ps=0.88u w=0.5u l=0.13u
X2510 a_85844_98784# a_86092_99156# a_86050_99272# vdd sg13_lv_pmos ad=0.191p pd=1.44u as=0.1008p ps=0.9u w=0.42u l=0.13u
X2511 a_101596_97308# a_101180_97644# a_101361_97322# sg13cmos5l_Corner_1.vss sg13_lv_nmos ad=77.7f pd=0.95u as=0.2516p ps=2.16u w=0.74u l=0.13u
X2512 sg13cmos5l_Corner_1.vss a_99095_98445# a_99932_98084# sg13cmos5l_Corner_1.vss sg13_lv_nmos ad=0.1406p pd=1.12u as=0.2516p ps=2.16u w=0.74u l=0.13u
X2513 sg13cmos5l_IOPadAnalog_1.pad a_164624_70044# sg13cmos5l_Corner_1.iovdd sg13cmos5l_Corner_1.iovdd sg13_hv_pmos ad=3.9294p pd=7.84u as=2.1312p ps=7.3u w=6.66u l=0.6u
X2514 sg13cmos5l_IOPadAnalog_0.pad a_164624_86044# sg13cmos5l_Corner_1.iovdd sg13cmos5l_Corner_1.iovdd sg13_hv_pmos ad=3.9294p pd=7.84u as=2.1312p ps=7.3u w=6.66u l=0.6u
X2515 adc8b_0.side_cap8b_1.buf_32_0.z adc8b_0.sar12b_0.nl_sw[0] sg13cmos5l_Corner_1.vss sg13cmos5l_Corner_1.vss sg13_lv_nmos ad=95f pd=0.88u as=95f ps=0.88u w=0.5u l=0.13u
X2516 sg13cmos5l_IOPadAnalog_11.pad a_164624_118044# sg13cmos5l_Corner_1.iovdd sg13cmos5l_Corner_1.iovdd sg13_hv_pmos ad=3.9294p pd=7.84u as=2.1312p ps=7.3u w=6.66u l=0.6u
X2517 vddr adc8b_0.sar12b_0.nh_sw[3] adc8b_0.side_cap8b_1.buf_8_3.z vddr sg13_lv_pmos ad=0.19p pd=1.38u as=0.19p ps=1.38u w=1u l=0.13u
X2518 adc8b_0.side_cap8b_0.buf_32_1.z adc8b_0.side_cap8b_0.in_h_sw[0] sg13cmos5l_Corner_1.vss sg13cmos5l_Corner_1.vss sg13_lv_nmos ad=95f pd=0.88u as=95f ps=0.88u w=0.5u l=0.13u
X2519 sg13cmos5l_Corner_1.vss a_86228_100310# adc8b_0.sar12b_0.sg13cmos5l_buf_1_60.X sg13cmos5l_Corner_1.vss sg13_lv_nmos ad=0.14875p pd=1.16u as=0.2886p ps=2.26u w=0.74u l=0.13u
X2520 vdd cks adc8b_0.sar12b_0.sg13cmos5l_dfrbp_1_6.RESET_B vdd sg13_lv_pmos ad=0.2128p pd=1.5u as=0.2128p ps=1.5u w=1.12u l=0.13u
X2521 a_96396_99600# a_96915_99607# a_97655_99957# sg13cmos5l_Corner_1.vss sg13_lv_nmos ad=0.3473p pd=2.71u as=0.12665p ps=1.145u w=0.74u l=0.13u
X2522 vdd a_85175_95421# a_86012_95060# vdd sg13_lv_pmos ad=0.2128p pd=1.5u as=0.3864p ps=2.93u w=1.12u l=0.13u
X2523 adc8b_0.side_cap8b_0.buf_32_1.z adc8b_0.side_cap8b_0.in_h_sw[0] vddr vddr sg13_lv_pmos ad=0.19p pd=1.38u as=0.19p ps=1.38u w=1u l=0.13u
X2524 frame a_134044_42476# sg13cmos5l_Corner_1.iovdd sg13cmos5l_Corner_1.iovdd sg13_hv_pmos ad=3.9294p pd=7.84u as=2.1312p ps=7.3u w=6.66u l=0.6u
X2525 a_84204_100021# a_83916_99600# a_84142_100021# sg13cmos5l_Corner_1.vss sg13_lv_nmos ad=0.1428p pd=1.52u as=37.8f ps=0.6u w=0.42u l=0.13u
X2526 a_87564_95064# a_87538_95028# vdd vdd sg13_lv_pmos ad=0.34p pd=2.68u as=0.36237p ps=2.605u w=1u l=0.13u
X2527 sg13cmos5l_Corner_1.vss a_89457_92786# a_89982_92768# sg13cmos5l_Corner_1.vss sg13_lv_nmos ad=0.1491p pd=1.18u as=0.187p ps=1.78u w=0.55u l=0.13u
X2528 a_84364_99156# a_84389_98796# vdd vdd sg13_lv_pmos ad=0.2856p pd=2.36u as=1.15047p ps=7.175u w=0.84u l=0.13u
X2529 vdd sg13cmos5l_Corner_1.vss vdd vdd sg13_lv_pmos ad=0.19p pd=1.38u as=0 ps=0 w=1u l=1u
X2530 vdd sg13cmos5l_Corner_1.vss vdd vdd sg13_lv_pmos ad=0.34p pd=2.68u as=0 ps=0 w=1u l=1u
X2531 vdd adc8b_0.sar12b_0.sg13cmos5l_dlhr_1_9.D a_92355_95852# vdd sg13_lv_pmos ad=0.2198p pd=1.53u as=0.2856p ps=2.36u w=0.84u l=0.13u
X2532 adc8b_0.side_cap8b_1.buf_32_1.z adc8b_0.sar12b_0.nh_sw[0] sg13cmos5l_Corner_1.vss sg13cmos5l_Corner_1.vss sg13_lv_nmos ad=95f pd=0.88u as=95f ps=0.88u w=0.5u l=0.13u
X2533 sg13cmos5l_Corner_1.iovdd a_42476_118044# cks sg13cmos5l_Corner_1.iovdd sg13_hv_pmos ad=2.1312p pd=7.3u as=3.9294p ps=7.84u w=6.66u l=0.6u
X2534 sg13cmos5l_Corner_1.vss a_85599_98442# a_85730_98448# sg13cmos5l_Corner_1.vss sg13_lv_nmos ad=1.49685p pd=9.6u as=0.2775p ps=2.23u w=0.74u l=0.13u
X2535 sg13cmos5l_IOPadAnalog_9.pad a_83639_178370# sg13cmos5l_Corner_1.vss sg13cmos5l_Corner_1.vss sg13_hv_nmos ad=2.596p pd=5.58u as=1.408p ps=5.04u w=4.4u l=0.6u
X2536 sg13cmos5l_IOPadAnalog_15.pad a_99639_164698# sg13cmos5l_Corner_1.iovdd sg13cmos5l_Corner_1.iovdd sg13_hv_pmos ad=3.9294p pd=7.84u as=2.1312p ps=7.3u w=6.66u l=0.6u
X2537 sg13cmos5l_IOPadAnalog_13.pad a_115639_164698# sg13cmos5l_Corner_1.iovdd sg13cmos5l_Corner_1.iovdd sg13_hv_pmos ad=3.9294p pd=7.84u as=2.1312p ps=7.3u w=6.66u l=0.6u
X2538 vdd a_89015_99957# a_89852_99596# vdd sg13_lv_pmos ad=0.2128p pd=1.5u as=0.3864p ps=2.93u w=1.12u l=0.13u
X2539 sg13cmos5l_IOPadAnalog_1.pad a_164624_70044# sg13cmos5l_Corner_1.iovdd sg13cmos5l_Corner_1.iovdd sg13_hv_pmos ad=3.9294p pd=7.84u as=2.1312p ps=7.3u w=6.66u l=0.6u
X2540 sg13cmos5l_Corner_1.iovdd a_83639_164698# sg13cmos5l_IOPadAnalog_9.pad sg13cmos5l_Corner_1.iovdd sg13_hv_pmos ad=2.1312p pd=7.3u as=3.9294p ps=7.84u w=6.66u l=0.6u
X2541 vdd sg13cmos5l_IOPadVdd$1_0.sg13cmos5l_Clamp_N43N43D4R$1_0.gate sg13cmos5l_Corner_1.vss sg13cmos5l_Corner_1.vss sg13_hv_nmos ad=2.596p pd=5.58u as=1.408p ps=5.04u w=4.4u l=0.6u
X2542 sg13cmos5l_Corner_1.vss a_131639_178370# sg13cmos5l_IOPadAnalog_12.pad sg13cmos5l_Corner_1.vss sg13_hv_nmos ad=1.408p pd=5.04u as=2.596p ps=5.58u w=4.4u l=0.6u
X2543 sg13cmos5l_Corner_1.vss a_98900_100310# adc8b_0.side_cap8b_0.in_h_sw[7] sg13cmos5l_Corner_1.vss sg13_lv_nmos ad=0.14875p pd=1.16u as=0.2886p ps=2.26u w=0.74u l=0.13u
X2544 vdd sg13cmos5l_Corner_1.vss vdd vdd sg13_lv_pmos ad=0.34p pd=2.68u as=0 ps=0 w=1u l=1u
X2545 a_93748_96108# adc8b_0.sar12b_0.sg13cmos5l_inv_1_0.A adc8b_0.sar12b_0.sg13cmos5l_a221oi_1_0.C1 vdd sg13_lv_pmos ad=0.1176p pd=1.33u as=0.3808p ps=2.92u w=1.12u l=0.13u
X2546 sg13cmos5l_Corner_1.vss adc8b_0.sar12b_0.sg13cmos5l_o21ai_1_0.A1 a_93790_94294# sg13cmos5l_Corner_1.vss sg13_lv_nmos ad=0.1406p pd=1.12u as=0.2516p ps=2.16u w=0.74u l=0.15u
X2547 sg13cmos5l_IOPadAnalog_16.pad a_164624_102044# sg13cmos5l_Corner_1.iovdd sg13cmos5l_Corner_1.iovdd sg13_hv_pmos ad=3.9294p pd=7.84u as=2.1312p ps=7.3u w=6.66u l=0.6u
X2548 adc8b_0.sar12b_0.sg13cmos5l_dfrbp_1_0.Q a_101276_93084# vdd vdd sg13_lv_pmos ad=0.3808p pd=2.92u as=0.2128p ps=1.5u w=1.12u l=0.13u
X2549 sg13cmos5l_Corner_1.vss adc8b_0.sar12b_0.nh_sw[7] adc8b_0.side_cap8b_1.buf_4_2.z sg13cmos5l_Corner_1.vss sg13_lv_nmos ad=95f pd=0.88u as=0.17p ps=1.68u w=0.5u l=0.13u
X2550 a_88611_96619# a_87719_96543# a_88509_96619# vdd sg13_lv_pmos ad=63f pd=0.72u as=79.8f ps=0.8u w=0.42u l=0.13u
X2551 sg13cmos5l_Corner_1.iovdd a_164624_86044# sg13cmos5l_IOPadAnalog_0.pad sg13cmos5l_Corner_1.iovdd sg13_hv_pmos ad=2.1312p pd=7.3u as=3.9294p ps=7.84u w=6.66u l=0.6u
X2552 a_95962_97322# adc8b_0.sar12b_0.sg13cmos5l_dfrbp_1_6.RESET_B sg13cmos5l_Corner_1.vss sg13cmos5l_Corner_1.vss sg13_lv_nmos ad=37.8f pd=0.6u as=79.8f ps=0.8u w=0.42u l=0.13u
X2553 vdd a_91473_95810# a_91998_95792# vdd sg13_lv_pmos ad=0.1974p pd=1.5u as=0.2856p ps=2.36u w=0.84u l=0.13u
X2554 adc8b_0.side_cap8b_0.buf_4_0.z adc8b_0.side_cap8b_0.in_l_sw[7] vddr vddr sg13_lv_pmos ad=0.19p pd=1.38u as=0.19p ps=1.38u w=1u l=0.13u
X2555 vdd cks a_100995_100350# vdd sg13_lv_pmos ad=0.2128p pd=1.5u as=0.3808p ps=2.92u w=1.12u l=0.13u
X2556 adc8b_0.sar12b_0.sg13cmos5l_buf_1_90.X a_93232_100384# sg13cmos5l_Corner_1.vss sg13cmos5l_Corner_1.vss sg13_lv_nmos ad=0.2886p pd=2.26u as=0.14875p ps=1.16u w=0.74u l=0.13u
X2557 a_89399_95887# a_88557_95789# a_88140_96128# vdd sg13_lv_pmos ad=0.2048p pd=1.63u as=0.34p ps=2.68u w=1u l=0.13u
X2558 vddr adc8b_0.sar12b_0.nh_sw[0] adc8b_0.side_cap8b_1.buf_32_1.z vddr sg13_lv_pmos ad=0.19p pd=1.38u as=0.19p ps=1.38u w=1u l=0.13u
X2559 a_94868_99560# adc8b_0.sar12b_0.sg13cmos5l_buf_1_90.X vdd vdd sg13_lv_pmos ad=0.2856p pd=2.36u as=0.2114p ps=1.54u w=0.84u l=0.13u
X2560 vdd a_90551_98911# a_90808_99054# vdd sg13_lv_pmos ad=0.2639p pd=1.81u as=79.8f ps=0.8u w=0.42u l=0.13u
X2561 sg13cmos5l_Corner_1.iovdd a_42476_102044# vip sg13cmos5l_Corner_1.iovdd sg13_hv_pmos ad=2.1312p pd=7.3u as=3.9294p ps=7.84u w=6.66u l=0.6u
X2562 adc8b_0.sar12b_0.sg13cmos5l_dfrbp_1_11.Q_N a_89399_95887# sg13cmos5l_Corner_1.vss sg13cmos5l_Corner_1.vss sg13_lv_nmos ad=0.2849p pd=2.25u as=0.2516p ps=2.16u w=0.74u l=0.13u
X2563 data[0] a_70044_42476# sg13cmos5l_Corner_1.iovdd sg13cmos5l_Corner_1.iovdd sg13_hv_pmos ad=3.9294p pd=7.84u as=2.1312p ps=7.3u w=6.66u l=0.6u
X2564 sg13cmos5l_Corner_1.iovdd a_102044_42476# data[2] sg13cmos5l_Corner_1.iovdd sg13_hv_pmos ad=2.1312p pd=7.3u as=3.9294p ps=7.84u w=6.66u l=0.6u
X2565 adc8b_0.side_cap8b_1.buf_8_5.z adc8b_0.sar12b_0.nh_sw[5] sg13cmos5l_Corner_1.vss sg13cmos5l_Corner_1.vss sg13_lv_nmos ad=95f pd=0.88u as=95f ps=0.88u w=0.5u l=0.13u
X2566 a_89266_99057# a_89709_98813# a_89649_99225# vdd sg13_lv_pmos ad=79.8f pd=0.8u as=63f ps=0.72u w=0.42u l=0.13u
X2567 vdd a_68892_97356# a_68824_97392# sg13cmos5l_Corner_1.vss sg13_lv_nmos ad=0.442p pd=3.28u as=0.442p ps=3.28u w=1.3u l=0.13u
X2568 vdd a_91988_94262# adc8b_0.sar12b_0.nl_sw[5] vdd sg13_lv_pmos ad=0.2114p pd=1.54u as=0.42p ps=2.99u w=1.12u l=0.13u
X2569 a_101361_97322# a_101180_97644# vdd vdd sg13_lv_pmos ad=0.2128p pd=1.5u as=0.2387p ps=1.84u w=1.12u l=0.13u
X2570 vdd a_94744_93790# a_94689_93671# vdd sg13_lv_pmos ad=1.86162p pd=11.935u as=93.45f ps=0.865u w=0.42u l=0.13u
X2571 sg13cmos5l_Corner_1.vss a_118044_30676# cko sg13cmos5l_Corner_1.vss sg13_hv_nmos ad=2.068p pd=9.74u as=2.596p ps=5.58u w=4.4u l=0.6u
X2572 adc8b_0.sar12b_0.sg13cmos5l_buf_1_3.A a_101296_98084# sg13cmos5l_Corner_1.vss sg13cmos5l_Corner_1.vss sg13_lv_nmos ad=0.2886p pd=2.26u as=0.14875p ps=1.16u w=0.74u l=0.13u
X2573 data[2] a_102044_30676# sg13cmos5l_Corner_1.vss sg13cmos5l_Corner_1.vss sg13_hv_nmos ad=2.596p pd=5.58u as=1.408p ps=5.04u w=4.4u l=0.6u
X2574 vddr adc8b_0.sar12b_0.nh_sw[0] adc8b_0.side_cap8b_1.buf_32_1.z vddr sg13_lv_pmos ad=0.19p pd=1.38u as=0.19p ps=1.38u w=1u l=0.13u
X2575 vdd a_100383_96930# a_100514_96936# vdd sg13_lv_pmos ad=1.28962p pd=8.195u as=0.2856p ps=2.36u w=0.84u l=0.13u
X2576 sg13cmos5l_IOPadAnalog_1.pad a_178296_70044# sg13cmos5l_Corner_1.vss sg13cmos5l_Corner_1.vss sg13_hv_nmos ad=2.596p pd=5.58u as=1.408p ps=5.04u w=4.4u l=0.6u
X2577 sg13cmos5l_Corner_1.iovdd a_164624_86044# sg13cmos5l_IOPadAnalog_0.pad sg13cmos5l_Corner_1.iovdd sg13_hv_pmos ad=2.1312p pd=7.3u as=3.9294p ps=7.84u w=6.66u l=0.6u
X2578 sg13cmos5l_Corner_1.iovdd a_164624_118044# sg13cmos5l_IOPadAnalog_11.pad sg13cmos5l_Corner_1.iovdd sg13_hv_pmos ad=2.1312p pd=7.3u as=3.9294p ps=7.84u w=6.66u l=0.6u
X2579 sg13cmos5l_IOPadAnalog_15.pad a_99639_178370# sg13cmos5l_Corner_1.vss sg13cmos5l_Corner_1.vss sg13_hv_nmos ad=2.596p pd=5.58u as=1.408p ps=5.04u w=4.4u l=0.6u
X2580 sg13cmos5l_IOPadAnalog_10.pad a_67639_164698# sg13cmos5l_Corner_1.iovdd sg13cmos5l_Corner_1.iovdd sg13_hv_pmos ad=3.9294p pd=7.84u as=2.1312p ps=7.3u w=6.66u l=0.6u
X2581 sg13cmos5l_Corner_1.vss a_30676_86044# sg13cmos5l_Corner_1.vss rppd l=3.54u w=0.5u
X2582 sg13cmos5l_Corner_1.vss adc8b_0.sar12b_0.nh_sw[2] adc8b_0.side_cap8b_1.buf_16_0.z sg13cmos5l_Corner_1.vss sg13_lv_nmos ad=95f pd=0.88u as=95f ps=0.88u w=0.5u l=0.13u
X2583 sg13cmos5l_IOPadAnalog_13.pad a_115639_178370# sg13cmos5l_Corner_1.vss sg13cmos5l_Corner_1.vss sg13_hv_nmos ad=2.596p pd=5.58u as=1.408p ps=5.04u w=4.4u l=0.6u
X2584 sg13cmos5l_Corner_1.vss a_30676_118044# cks sg13cmos5l_Corner_1.vss sg13_hv_nmos ad=1.408p pd=5.04u as=2.596p ps=5.58u w=4.4u l=0.6u
X2585 adc8b_0.side_cap8b_1.buf_32_1.z adc8b_0.sar12b_0.nh_sw[0] vddr vddr sg13_lv_pmos ad=0.19p pd=1.38u as=0.19p ps=1.38u w=1u l=0.13u
X2586 vdd adc8b_0.sar12b_0.sg13cmos5l_dfrbp_1_0.RESET_B a_93038_95498# vdd sg13_lv_pmos ad=0.36237p pd=2.605u as=79.8f ps=0.8u w=0.42u l=0.13u
X2587 sg13cmos5l_Corner_1.iovdd a_42476_118044# cks sg13cmos5l_Corner_1.iovdd sg13_hv_pmos ad=2.1312p pd=7.3u as=3.9294p ps=7.84u w=6.66u l=0.6u
X2588 vin a_30676_86044# sg13cmos5l_Corner_1.vss sg13cmos5l_Corner_1.vss sg13_hv_nmos ad=2.596p pd=5.58u as=1.408p ps=5.04u w=4.4u l=0.6u
X2589 sg13cmos5l_Corner_1.vss a_85175_95421# a_86012_95060# sg13cmos5l_Corner_1.vss sg13_lv_nmos ad=0.1406p pd=1.12u as=0.2516p ps=2.16u w=0.74u l=0.13u
X2590 sg13cmos5l_Corner_1.vss a_83639_178370# sg13cmos5l_IOPadAnalog_9.pad sg13cmos5l_Corner_1.vss sg13_hv_nmos ad=1.408p pd=5.04u as=2.596p ps=5.58u w=4.4u l=0.6u
X2591 sg13cmos5l_Corner_1.iovdd a_99639_164698# sg13cmos5l_IOPadAnalog_15.pad sg13cmos5l_Corner_1.iovdd sg13_hv_pmos ad=2.1312p pd=7.3u as=3.9294p ps=7.84u w=6.66u l=0.6u
X2592 sg13cmos5l_Corner_1.iovdd a_42476_70044# vddr sg13cmos5l_Corner_1.iovdd sg13_hv_pmos ad=2.1312p pd=7.3u as=3.9294p ps=7.84u w=6.66u l=0.6u
X2593 a_87852_95485# a_88083_95071# a_87538_95028# sg13cmos5l_Corner_1.vss sg13_lv_nmos ad=0.2373p pd=1.97u as=79.8f ps=0.8u w=0.42u l=0.13u
X2594 sg13cmos5l_Corner_1.vss a_76462_57198# dantenna l=3.1u w=0.64u
X2595 a_82190_98522# adc8b_0.sar12b_0.sg13cmos5l_dfrbp_1_6.D vdd vdd sg13_lv_pmos ad=79.8f pd=0.8u as=0.1428p ps=1.52u w=0.42u l=0.13u
X2596 sg13cmos5l_Corner_1.vss adc8b_0.sar12b_0.nl_sw[4] adc8b_0.side_cap8b_1.buf_8_0.z sg13cmos5l_Corner_1.vss sg13_lv_nmos ad=95f pd=0.88u as=95f ps=0.88u w=0.5u l=0.13u
X2597 sg13cmos5l_Corner_1.iovdd a_115639_164698# sg13cmos5l_IOPadAnalog_13.pad sg13cmos5l_Corner_1.iovdd sg13_hv_pmos ad=3.1302p pd=14.26u as=3.9294p ps=7.84u w=6.66u l=0.6u
X2598 sg13cmos5l_Corner_1.vss adc8b_0.sar12b_0.nl_sw[0] adc8b_0.side_cap8b_1.buf_32_0.z sg13cmos5l_Corner_1.vss sg13_lv_nmos ad=95f pd=0.88u as=0.17p ps=1.68u w=0.5u l=0.13u
X2599 adc8b_0.side_cap8b_0.buf_16_1.z adc8b_0.side_cap8b_0.in_l_sw[2] vddr vddr sg13_lv_pmos ad=0.19p pd=1.38u as=0.19p ps=1.38u w=1u l=0.13u
X2600 adc8b_0.sar12b_0.sg13cmos5l_dlhr_1_14.Q_N a_95934_98816# vdd vdd sg13_lv_pmos ad=0.3808p pd=2.92u as=0.1974p ps=1.5u w=1.12u l=0.13u
X2601 sg13cmos5l_Corner_1.vss a_86615_95887# a_87452_96108# sg13cmos5l_Corner_1.vss sg13_lv_nmos ad=0.1406p pd=1.12u as=0.2516p ps=2.16u w=0.74u l=0.13u
X2602 sg13cmos5l_Corner_1.vss adc8b_0.side_cap8b_0.in_h_sw[0] adc8b_0.side_cap8b_0.buf_32_1.z sg13cmos5l_Corner_1.vss sg13_lv_nmos ad=95f pd=0.88u as=95f ps=0.88u w=0.5u l=0.13u
X2603 a_91406_96248# a_91010_95820# a_91292_96132# vdd sg13_lv_pmos ad=0.1008p pd=0.9u as=0.191p ps=1.44u w=0.42u l=0.13u
X2604 a_93202_93516# a_93645_93559# a_92942_93986# sg13cmos5l_Corner_1.vss sg13_lv_nmos ad=79.8f pd=0.8u as=0.1296p ps=1.52u w=0.42u l=0.13u
X2605 sg13cmos5l_Corner_1.vss adc8b_0.sar12b_0.sg13cmos5l_dlhr_1_12.D a_98929_99954# sg13cmos5l_Corner_1.vss sg13_lv_nmos ad=0.15055p pd=1.17u as=0.187p ps=1.78u w=0.55u l=0.13u
X2606 sg13cmos5l_Corner_1.iovdd a_164624_102044# sg13cmos5l_IOPadAnalog_16.pad sg13cmos5l_Corner_1.iovdd sg13_hv_pmos ad=2.1312p pd=7.3u as=3.9294p ps=7.84u w=6.66u l=0.6u
X2607 sg13cmos5l_Corner_1.vss a_89457_92786# a_89412_92822# sg13cmos5l_Corner_1.vss sg13_lv_nmos ad=0.1428p pd=1.52u as=47.25f ps=0.645u w=0.42u l=0.13u
X2608 a_97260_93552# a_97779_93559# a_98519_93909# sg13cmos5l_Corner_1.vss sg13_lv_nmos ad=0.3473p pd=2.71u as=0.12665p ps=1.145u w=0.74u l=0.13u
X2609 a_90540_99600# a_90514_99564# sg13cmos5l_Corner_1.vss sg13cmos5l_Corner_1.vss sg13_lv_nmos ad=0.2516p pd=2.16u as=0.1626p ps=1.415u w=0.74u l=0.13u
X2610 sg13cmos5l_Corner_1.vss sg13cmos5l_IOPadVdd$1_0.sg13cmos5l_Clamp_N43N43D4R$1_0.gate vdd sg13cmos5l_Corner_1.vss sg13_hv_nmos ad=1.408p pd=5.04u as=2.596p ps=5.58u w=4.4u l=0.6u
X2611 vddr adc8b_0.side_cap8b_0.in_h_sw[0] adc8b_0.side_cap8b_0.buf_32_1.z vddr sg13_lv_pmos ad=0.19p pd=1.38u as=0.19p ps=1.38u w=1u l=0.13u
X2612 adc8b_0.side_cap8b_0.buf_16_0.z adc8b_0.side_cap8b_0.in_h_sw[2] sg13cmos5l_Corner_1.vss sg13cmos5l_Corner_1.vss sg13_lv_nmos ad=95f pd=0.88u as=95f ps=0.88u w=0.5u l=0.13u
X2613 a_82926_94302# a_82670_94302# sg13cmos5l_Corner_1.vss sg13cmos5l_Corner_1.vss sg13_lv_nmos ad=0.1428p pd=1.52u as=0.1323p ps=1.05u w=0.42u l=0.18u
X2614 sg13cmos5l_IOPadAnalog_15.pad a_99639_164698# sg13cmos5l_Corner_1.iovdd sg13cmos5l_Corner_1.iovdd sg13_hv_pmos ad=3.9294p pd=7.84u as=2.1312p ps=7.3u w=6.66u l=0.6u
X2615 adc8b_0.side_cap8b_0.buf_32_1.z adc8b_0.side_cap8b_0.in_h_sw[0] vddr vddr sg13_lv_pmos ad=0.19p pd=1.38u as=0.19p ps=1.38u w=1u l=0.13u
X2616 adc8b_0.sar12b_0.sg13cmos5l_buf_8_2.X a_100995_100350# sg13cmos5l_Corner_1.vss sg13cmos5l_Corner_1.vss sg13_lv_nmos ad=0.1406p pd=1.12u as=0.1406p ps=1.12u w=0.74u l=0.13u
X2617 sg13cmos5l_Corner_1.vss a_178296_102044# sg13cmos5l_IOPadAnalog_16.pad sg13cmos5l_Corner_1.vss sg13_hv_nmos ad=1.408p pd=5.04u as=2.596p ps=5.58u w=4.4u l=0.6u
X2618 sg13cmos5l_Corner_1.vss a_89709_98813# a_89811_98956# sg13cmos5l_Corner_1.vss sg13_lv_nmos ad=1.49685p pd=9.6u as=0.2516p ps=2.16u w=0.74u l=0.13u
X2619 vdd a_97470_95347# adc8b_0.sar12b_0.sg13cmos5l_and3_1_0.C vdd sg13_lv_pmos ad=0.2128p pd=1.5u as=0.3808p ps=2.92u w=1.12u l=0.13u
X2620 sg13cmos5l_Corner_1.vss adc8b_0.side_cap8b_0.in_l_sw[3] adc8b_0.side_cap8b_0.buf_8_1.z sg13cmos5l_Corner_1.vss sg13_lv_nmos ad=95f pd=0.88u as=0.17p ps=1.68u w=0.5u l=0.13u
X2621 a_98253_98095# adc8b_0.sar12b_0.sg13cmos5l_inv_1_2.A sg13cmos5l_Corner_1.vss sg13cmos5l_Corner_1.vss sg13_lv_nmos ad=0.2516p pd=2.16u as=1.49685p ps=9.6u w=0.74u l=0.13u
X2622 adc8b_0.side_cap8b_1.buf_2_0.z adc8b_0.sar12b_0.nh_sw[8] vddr vddr sg13_lv_pmos ad=0.34p pd=2.68u as=0.19p ps=1.38u w=1u l=0.13u
X2623 vdd sg13cmos5l_Corner_1.vss vdd vdd sg13_lv_pmos ad=0.34p pd=2.68u as=0 ps=0 w=1u l=1u
X2624 vdd adc8b_0.sar12b_0.sg13cmos5l_inv_1_29.Y a_93539_96572# vdd sg13_lv_pmos ad=0.2128p pd=1.5u as=0.2128p ps=1.5u w=1.12u l=0.13u
X2625 adc8b_0.side_cap8b_1.buf_32_0.z adc8b_0.sar12b_0.nl_sw[0] vddr vddr sg13_lv_pmos ad=0.19p pd=1.38u as=0.19p ps=1.38u w=1u l=0.13u
X2626 vin a_42476_86044# sg13cmos5l_Corner_1.iovdd sg13cmos5l_Corner_1.iovdd sg13_hv_pmos ad=3.9294p pd=7.84u as=2.1312p ps=7.3u w=6.66u l=0.6u
X2627 vdd sg13cmos5l_IOPadVdd$1_0.sg13cmos5l_Clamp_N43N43D4R$1_0.gate sg13cmos5l_Corner_1.vss sg13cmos5l_Corner_1.vss sg13_hv_nmos ad=2.596p pd=5.58u as=1.408p ps=5.04u w=4.4u l=0.6u
X2628 adc8b_0.side_cap8b_0.buf_32_0.z adc8b_0.side_cap8b_0.in_l_sw[0] sg13cmos5l_Corner_1.vss sg13cmos5l_Corner_1.vss sg13_lv_nmos ad=95f pd=0.88u as=95f ps=0.88u w=0.5u l=0.13u
X2629 vdd a_89656_96030# a_89601_96125# vdd sg13_lv_pmos ad=1.28962p pd=8.195u as=93.45f ps=0.865u w=0.42u l=0.13u
X2630 a_83646_97497# a_83765_97286# vdd vdd sg13_lv_pmos ad=0.3864p pd=2.93u as=0.2128p ps=1.5u w=1.12u l=0.13u
X2631 a_94860_94298# adc8b_0.sar12b_0.sg13cmos5l_o21ai_1_0.Y a_94766_94298# sg13cmos5l_Corner_1.vss sg13_lv_nmos ad=60.89999f pd=0.71u as=0.1428p ps=1.52u w=0.42u l=0.13u
X2632 sg13cmos5l_Corner_1.vss adc8b_0.sar12b_0.sg13cmos5l_nor2_1_0.A a_92381_93918# sg13cmos5l_Corner_1.vss sg13_lv_nmos ad=0.1898p pd=1.36u as=0.2516p ps=2.16u w=0.74u l=0.13u
X2633 adc8b_0.sar12b_0.sg13cmos5l_inv_1_29.A a_94172_99132# sg13cmos5l_Corner_1.vss sg13cmos5l_Corner_1.vss sg13_lv_nmos ad=0.2516p pd=2.16u as=0.1406p ps=1.12u w=0.74u l=0.13u
X2634 vdd a_89399_95887# a_90236_96108# vdd sg13_lv_pmos ad=0.2128p pd=1.5u as=0.3864p ps=2.93u w=1.12u l=0.13u
X2635 a_87825_97713# a_87468_97640# vdd vdd sg13_lv_pmos ad=63f pd=0.72u as=0.1563p ps=1.22u w=0.42u l=0.13u
X2636 frame a_134044_30676# sg13cmos5l_Corner_1.vss sg13cmos5l_Corner_1.vss sg13_hv_nmos ad=2.596p pd=5.58u as=1.408p ps=5.04u w=4.4u l=0.6u
X2637 sg13cmos5l_IOPadAnalog_10.pad a_67639_178370# sg13cmos5l_Corner_1.vss sg13cmos5l_Corner_1.vss sg13_hv_nmos ad=2.596p pd=5.58u as=1.408p ps=5.04u w=4.4u l=0.6u
X2638 sg13cmos5l_Corner_1.vss sg13cmos5l_IOPadVdd$1_0.sg13cmos5l_Clamp_N43N43D4R$1_0.gate vdd sg13cmos5l_Corner_1.vss sg13_hv_nmos ad=1.408p pd=5.04u as=2.596p ps=5.58u w=4.4u l=0.6u
X2639 a_83890_99564# a_84333_99607# a_84273_99643# vdd sg13_lv_pmos ad=79.8f pd=0.8u as=63f ps=0.72u w=0.42u l=0.13u
X2640 adc8b_0.sar12b_0.sg13cmos5l_a221oi_1_0.C1 adc8b_0.sar12b_0.sg13cmos5l_inv_1_0.A sg13cmos5l_Corner_1.vss sg13cmos5l_Corner_1.vss sg13_lv_nmos ad=0.1406p pd=1.12u as=0.2516p ps=2.16u w=0.74u l=0.13u
X2641 data[2] a_102044_42476# sg13cmos5l_Corner_1.iovdd sg13cmos5l_Corner_1.iovdd sg13_hv_pmos ad=3.9294p pd=7.84u as=2.1312p ps=7.3u w=6.66u l=0.6u
X2642 sg13cmos5l_IOPadAnalog_9.pad a_83639_178370# sg13cmos5l_Corner_1.vss sg13cmos5l_Corner_1.vss sg13_hv_nmos ad=2.596p pd=5.58u as=1.408p ps=5.04u w=4.4u l=0.6u
X2643 a_36456_136735# a_40542_136405# sg13cmos5l_Corner_1.vss rppd l=20u w=1u
X2644 cks a_42476_118044# sg13cmos5l_Corner_1.iovdd sg13cmos5l_Corner_1.iovdd sg13_hv_pmos ad=3.9294p pd=7.84u as=2.1312p ps=7.3u w=6.66u l=0.6u
X2645 a_89709_98813# adc8b_0.sar12b_0.sg13cmos5l_dfrbp_1_18.Q vdd vdd sg13_lv_pmos ad=0.4088p pd=2.97u as=1.15047p ps=7.175u w=1.12u l=0.13u
X2646 sg13cmos5l_Corner_1.vss a_178296_118044# sg13cmos5l_IOPadAnalog_11.pad sg13cmos5l_Corner_1.vss sg13_hv_nmos ad=1.408p pd=5.04u as=2.596p ps=5.58u w=4.4u l=0.6u
X2647 a_94487_93909# a_93645_93559# a_93228_93552# vdd sg13_lv_pmos ad=0.2048p pd=1.63u as=0.34p ps=2.68u w=1u l=0.13u
X2648 sg13cmos5l_Corner_1.vss a_30676_70044# vddr sg13cmos5l_Corner_1.vss sg13_hv_nmos ad=1.408p pd=5.04u as=2.596p ps=5.58u w=4.4u l=0.6u
X2649 sg13cmos5l_Corner_1.vss adc8b_0.side_cap8b_0.in_l_sw[1] adc8b_0.side_cap8b_0.buf_16_2.z sg13cmos5l_Corner_1.vss sg13_lv_nmos ad=95f pd=0.88u as=95f ps=0.88u w=0.5u l=0.13u
X2650 sg13cmos5l_Corner_1.vss cks adc8b_0.sar12b_0.sg13cmos5l_dfrbp_1_6.RESET_B sg13cmos5l_Corner_1.vss sg13_lv_nmos ad=0.1406p pd=1.12u as=0.1406p ps=1.12u w=0.74u l=0.13u
X2651 a_99167_95107# adc8b_0.sar12b_0.sg13cmos5l_dfrbp_1_6.RESET_B vdd vdd sg13_lv_pmos ad=79.8f pd=0.8u as=0.36237p ps=2.605u w=0.42u l=0.13u
X2652 sg13cmos5l_Corner_1.vss a_99639_178370# sg13cmos5l_IOPadAnalog_15.pad sg13cmos5l_Corner_1.vss sg13_hv_nmos ad=1.408p pd=5.04u as=2.596p ps=5.58u w=4.4u l=0.6u
X2653 sg13cmos5l_Corner_1.iovdd a_67639_164698# sg13cmos5l_IOPadAnalog_10.pad sg13cmos5l_Corner_1.iovdd sg13_hv_pmos ad=2.1312p pd=7.3u as=3.9294p ps=7.84u w=6.66u l=0.6u
X2654 sg13cmos5l_Corner_1.vss a_115639_178370# sg13cmos5l_IOPadAnalog_13.pad sg13cmos5l_Corner_1.vss sg13_hv_nmos ad=1.408p pd=5.04u as=2.596p ps=5.58u w=4.4u l=0.6u
X2655 sg13cmos5l_Corner_1.iovdd a_83639_164698# sg13cmos5l_IOPadAnalog_9.pad sg13cmos5l_Corner_1.iovdd sg13_hv_pmos ad=3.1302p pd=14.26u as=3.9294p ps=7.84u w=6.66u l=0.6u
X2656 sg13cmos5l_Corner_1.vss sg13cmos5l_IOPadVdd$1_0.sg13cmos5l_Clamp_N43N43D4R$1_0.gate vdd sg13cmos5l_Corner_1.vss sg13_hv_nmos ad=1.408p pd=5.04u as=2.596p ps=5.58u w=4.4u l=0.6u
X2657 sg13cmos5l_Corner_1.iovdd a_42476_86044# vin sg13cmos5l_Corner_1.iovdd sg13_hv_pmos ad=2.1312p pd=7.3u as=3.9294p ps=7.84u w=6.66u l=0.6u
X2658 sg13cmos5l_Corner_1.vss adc8b_0.sar12b_0.sg13cmos5l_dfrbp_1_8.RESET_B a_93708_100346# sg13cmos5l_Corner_1.vss sg13_lv_nmos ad=0.1626p pd=1.415u as=60.89999f ps=0.71u w=0.42u l=0.13u
X2659 frame a_134044_42476# sg13cmos5l_Corner_1.iovdd sg13cmos5l_Corner_1.iovdd sg13_hv_pmos ad=3.9294p pd=7.84u as=3.1302p ps=14.26u w=6.66u l=0.6u
X2660 sg13cmos5l_Corner_1.vss a_91839_98442# a_91970_98448# sg13cmos5l_Corner_1.vss sg13_lv_nmos ad=1.49685p pd=9.6u as=0.2775p ps=2.23u w=0.74u l=0.13u
X2661 vdd a_100995_100350# adc8b_0.sar12b_0.sg13cmos5l_buf_8_2.X vdd sg13_lv_pmos ad=0.3864p pd=2.93u as=0.2128p ps=1.5u w=1.12u l=0.13u
X2662 sg13cmos5l_Corner_1.vss a_88509_96619# a_87588_96933# sg13cmos5l_Corner_1.vss sg13_lv_nmos ad=0.1626p pd=1.415u as=0.2516p ps=2.16u w=0.74u l=0.13u
X2663 sg13cmos5l_Corner_1.iovdd a_86044_42476# data[1] sg13cmos5l_Corner_1.iovdd sg13_hv_pmos ad=2.1312p pd=7.3u as=3.9294p ps=7.84u w=6.66u l=0.6u
X2664 a_91591_93940# adc8b_0.sar12b_0.sg13cmos5l_a22oi_1_2.B1 sg13cmos5l_Corner_1.vss sg13cmos5l_Corner_1.vss sg13_lv_nmos ad=0.13875p pd=1.115u as=0.2553p ps=2.17u w=0.74u l=0.13u
X2665 a_178296_102044# sg13cmos5l_Corner_1.vss sg13cmos5l_Corner_1.vss rppd l=3.54u w=0.5u
X2666 vddr adc8b_0.sar12b_0.nl_sw[5] adc8b_0.side_cap8b_1.buf_8_4.z vddr sg13_lv_pmos ad=0.19p pd=1.38u as=0.19p ps=1.38u w=1u l=0.13u
X2667 sg13cmos5l_Corner_1.vss a_93741_92765# a_93843_92908# sg13cmos5l_Corner_1.vss sg13_lv_nmos ad=7.01497p pd=46.005u as=0.2516p ps=2.16u w=0.74u l=0.13u
X2668 vdd adc8b_0.sar12b_0.sg13cmos5l_dfrbp_1_6.RESET_B a_82450_96540# vdd sg13_lv_pmos ad=0.1563p pd=1.22u as=0.147p ps=1.54u w=0.42u l=0.13u
X2669 a_96900_96974# a_96351_96930# a_96764_96572# sg13cmos5l_Corner_1.vss sg13_lv_nmos ad=47.25f pd=0.645u as=0.141p ps=1.17u w=0.42u l=0.13u
X2670 a_94583_95421# a_93741_95071# a_94489_95421# sg13cmos5l_Corner_1.vss sg13_lv_nmos ad=0.12665p pd=1.145u as=0.1428p ps=1.52u w=0.42u l=0.13u
X2671 a_86847_94314# adc8b_0.sar12b_0.sg13cmos5l_dfrbp_1_9.Q vdd vdd sg13_lv_pmos ad=0.3234p pd=2.45u as=1.38655p ps=8.8u w=0.84u l=0.13u
X2672 sg13cmos5l_IOPadAnalog_15.pad a_99639_178370# sg13cmos5l_Corner_1.vss sg13cmos5l_Corner_1.vss sg13_hv_nmos ad=2.596p pd=5.58u as=2.068p ps=9.74u w=4.4u l=0.6u
X2673 sg13cmos5l_IOPadAnalog_10.pad a_67639_164698# sg13cmos5l_Corner_1.iovdd sg13cmos5l_Corner_1.iovdd sg13_hv_pmos ad=3.9294p pd=7.84u as=2.1312p ps=7.3u w=6.66u l=0.6u
X2674 vip a_42476_102044# sg13cmos5l_Corner_1.iovdd sg13cmos5l_Corner_1.iovdd sg13_hv_pmos ad=3.9294p pd=7.84u as=2.1312p ps=7.3u w=6.66u l=0.6u
X2675 a_84142_100021# adc8b_0.sar12b_0.sg13cmos5l_dfrbp_1_8.RESET_B sg13cmos5l_Corner_1.vss sg13cmos5l_Corner_1.vss sg13_lv_nmos ad=37.8f pd=0.6u as=0.1701p ps=1.65u w=0.42u l=0.13u
X2676 a_87852_95485# a_87564_95064# a_87790_95485# sg13cmos5l_Corner_1.vss sg13_lv_nmos ad=0.1428p pd=1.52u as=37.8f ps=0.6u w=0.42u l=0.13u
X2677 vdd a_90551_98911# a_91388_99132# vdd sg13_lv_pmos ad=0.2128p pd=1.5u as=0.3864p ps=2.93u w=1.12u l=0.13u
X2678 vddr adc8b_0.sar12b_0.nl_sw[2] adc8b_0.side_cap8b_1.buf_16_1.z vddr sg13_lv_pmos ad=0.19p pd=1.38u as=0.19p ps=1.38u w=1u l=0.13u
X2679 adc8b_0.side_cap8b_1.buf_8_3.z adc8b_0.sar12b_0.nh_sw[3] sg13cmos5l_Corner_1.vss sg13cmos5l_Corner_1.vss sg13_lv_nmos ad=95f pd=0.88u as=95f ps=0.88u w=0.5u l=0.13u
X2680 a_86420_97286# adc8b_0.sar12b_0.sg13cmos5l_buf_1_59.A sg13cmos5l_Corner_1.vss sg13cmos5l_Corner_1.vss sg13_lv_nmos ad=0.187p pd=1.78u as=0.14875p ps=1.16u w=0.55u l=0.13u
X2681 a_99489_97637# a_98547_97444# a_99287_97399# vdd sg13_lv_pmos ad=93.45f pd=0.865u as=0.2048p ps=1.63u w=0.42u l=0.13u
X2682 sg13cmos5l_Corner_1.vss a_118222_32962# dantenna l=1.26u w=27.78u
X2683 vddr adc8b_0.side_cap8b_0.in_l_sw[4] adc8b_0.side_cap8b_0.buf_8_0.z vddr sg13_lv_pmos ad=0.19p pd=1.38u as=0.19p ps=1.38u w=1u l=0.13u
X2684 a_99480_99596# a_98929_99954# vdd vdd sg13_lv_pmos ad=0.105p pd=1.21u as=1.15047p ps=7.175u w=1u l=0.13u
X2685 sg13cmos5l_IOPadAnalog_12.pad a_131639_164698# sg13cmos5l_Corner_1.iovdd sg13cmos5l_Corner_1.iovdd sg13_hv_pmos ad=3.9294p pd=7.84u as=2.1312p ps=7.3u w=6.66u l=0.6u
X2686 sg13cmos5l_IOPadAnalog_11.padres sg13cmos5l_Corner_1.iovdd dpantenna l=4.98u w=0.64u
X2687 adc8b_0.sar12b_0.sg13cmos5l_dlhr_1_1.Q_N a_84702_95792# sg13cmos5l_Corner_1.vss sg13cmos5l_Corner_1.vss sg13_lv_nmos ad=0.2516p pd=2.16u as=0.1491p ps=1.18u w=0.74u l=0.13u
X2688 data[0] a_70044_30676# sg13cmos5l_Corner_1.vss sg13cmos5l_Corner_1.vss sg13_hv_nmos ad=2.596p pd=5.58u as=1.408p ps=5.04u w=4.4u l=0.6u
X2689 sg13cmos5l_Corner_1.iovdd a_42476_70044# vddr sg13cmos5l_Corner_1.iovdd sg13_hv_pmos ad=3.1302p pd=14.26u as=3.9294p ps=7.84u w=6.66u l=0.6u
X2690 sg13cmos5l_Corner_1.vss cks adc8b_0.sar12b_0.sg13cmos5l_dfrbp_1_6.RESET_B sg13cmos5l_Corner_1.vss sg13_lv_nmos ad=0.1406p pd=1.12u as=0.1406p ps=1.12u w=0.74u l=0.13u
X2691 sg13cmos5l_Corner_1.vss adc8b_0.sar12b_0.sg13cmos5l_dfrbp_1_8.RESET_B a_85164_95810# sg13cmos5l_Corner_1.vss sg13_lv_nmos ad=0.1626p pd=1.415u as=60.89999f ps=0.71u w=0.42u l=0.13u
X2692 adc8b_0.side_cap8b_0.buf_16_3.z adc8b_0.side_cap8b_0.in_h_sw[1] vddr vddr sg13_lv_pmos ad=0.19p pd=1.38u as=0.19p ps=1.38u w=1u l=0.13u
X2693 cko a_118044_30676# sg13cmos5l_Corner_1.vss sg13cmos5l_Corner_1.vss sg13_hv_nmos ad=2.596p pd=5.58u as=1.408p ps=5.04u w=4.4u l=0.6u
X2694 sg13cmos5l_Corner_1.vss sg13cmos5l_IOPadVdd$1_0.sg13cmos5l_Clamp_N43N43D4R$1_0.gate vdd sg13cmos5l_Corner_1.vss sg13_hv_nmos ad=1.408p pd=5.04u as=2.596p ps=5.58u w=4.4u l=0.6u
X2695 adc8b_0.sar12b_0.sg13cmos5l_buf_8_2.X a_100995_100350# sg13cmos5l_Corner_1.vss sg13cmos5l_Corner_1.vss sg13_lv_nmos ad=0.1406p pd=1.12u as=0.1406p ps=1.12u w=0.74u l=0.13u
X2696 sg13cmos5l_Corner_1.vss a_97470_95347# adc8b_0.sar12b_0.sg13cmos5l_and3_1_0.C sg13cmos5l_Corner_1.vss sg13_lv_nmos ad=0.1406p pd=1.12u as=0.2516p ps=2.16u w=0.74u l=0.13u
X2697 a_86044_30676# sg13cmos5l_Corner_1.vss sg13cmos5l_Corner_1.vss rppd l=3.54u w=0.5u
X2698 adc8b_0.side_cap8b_1.buf_16_2.z adc8b_0.sar12b_0.nl_sw[1] vddr vddr sg13_lv_pmos ad=0.34p pd=2.68u as=0.19p ps=1.38u w=1u l=0.13u
X2699 adc8b_0.sar12b_0.sg13cmos5l_buf_1_34.A a_85809_93905# sg13cmos5l_Corner_1.vss sg13cmos5l_Corner_1.vss sg13_lv_nmos ad=0.2516p pd=2.16u as=0.1406p ps=1.12u w=0.74u l=0.13u
X2700 a_90740_100310# adc8b_0.sar12b_0.sg13cmos5l_buf_1_77.A sg13cmos5l_Corner_1.vss sg13cmos5l_Corner_1.vss sg13_lv_nmos ad=0.187p pd=1.78u as=0.14875p ps=1.16u w=0.55u l=0.13u
X2701 sg13cmos5l_Corner_1.vss a_95159_100423# a_95996_100644# sg13cmos5l_Corner_1.vss sg13_lv_nmos ad=0.1406p pd=1.12u as=0.2516p ps=2.16u w=0.74u l=0.13u
X2702 vdd a_96568_94518# a_96513_94613# vdd sg13_lv_pmos ad=1.43437p pd=9.105u as=93.45f ps=0.865u w=0.42u l=0.13u
X2703 data[0] a_70044_42476# sg13cmos5l_Corner_1.iovdd sg13cmos5l_Corner_1.iovdd sg13_hv_pmos ad=3.9294p pd=7.84u as=3.1302p ps=14.26u w=6.66u l=0.6u
X2704 a_82388_98798# adc8b_0.sar12b_0.sg13cmos5l_buf_1_63.X vdd vdd sg13_lv_pmos ad=0.2856p pd=2.36u as=0.2114p ps=1.54u w=0.84u l=0.13u
X2705 sg13cmos5l_IOPadAnalog_17.padres data[2] sg13cmos5l_Corner_1.vss rppd l=2u w=1u
X2706 sg13cmos5l_Corner_1.vss a_67639_178370# sg13cmos5l_IOPadAnalog_10.pad sg13cmos5l_Corner_1.vss sg13_hv_nmos ad=1.408p pd=5.04u as=2.596p ps=5.58u w=4.4u l=0.6u
X2707 sg13cmos5l_Corner_1.vss adc8b_0.side_cap8b_0.in_h_sw[2] adc8b_0.side_cap8b_0.buf_16_0.z sg13cmos5l_Corner_1.vss sg13_lv_nmos ad=95f pd=0.88u as=95f ps=0.88u w=0.5u l=0.13u
X2708 sg13cmos5l_Corner_1.vss a_83639_178370# sg13cmos5l_IOPadAnalog_9.pad sg13cmos5l_Corner_1.vss sg13_hv_nmos ad=1.408p pd=5.04u as=2.596p ps=5.58u w=4.4u l=0.6u
X2709 a_98124_98509# a_97836_98088# a_98062_98509# sg13cmos5l_Corner_1.vss sg13_lv_nmos ad=0.1428p pd=1.52u as=37.8f ps=0.6u w=0.42u l=0.13u
X2710 adc8b_0.side_cap8b_1.buf_32_1.z adc8b_0.sar12b_0.nh_sw[0] sg13cmos5l_Corner_1.vss sg13cmos5l_Corner_1.vss sg13_lv_nmos ad=95f pd=0.88u as=95f ps=0.88u w=0.5u l=0.13u
X2711 sg13cmos5l_Corner_1.vss sg13cmos5l_IOPadVdd$1_0.sg13cmos5l_Clamp_N43N43D4R$1_0.gate vdd sg13cmos5l_Corner_1.vss sg13_hv_nmos ad=1.408p pd=5.04u as=2.596p ps=5.58u w=4.4u l=0.6u
X2712 sg13cmos5l_Corner_1.iovdd a_164624_70044# sg13cmos5l_IOPadAnalog_1.pad sg13cmos5l_Corner_1.iovdd sg13_hv_pmos ad=2.1312p pd=7.3u as=3.9294p ps=7.84u w=6.66u l=0.6u
X2713 sg13cmos5l_Corner_1.vss adc8b_0.sar12b_0.nl_sw[9] adc8b_0.side_cap8b_1.buf_2_2.z sg13cmos5l_Corner_1.vss sg13_lv_nmos ad=95f pd=0.88u as=0.17p ps=1.68u w=0.5u l=0.13u
X2714 vdd sg13cmos5l_IOPadVdd$1_0.sg13cmos5l_Clamp_N43N43D4R$1_0.gate sg13cmos5l_Corner_1.vss sg13cmos5l_Corner_1.vss sg13_hv_nmos ad=2.596p pd=5.58u as=1.408p ps=5.04u w=4.4u l=0.6u
X2715 sg13cmos5l_Corner_1.vss adc8b_0.sar12b_0.sg13cmos5l_dlhr_1_11.D a_94129_98442# sg13cmos5l_Corner_1.vss sg13_lv_nmos ad=0.15055p pd=1.17u as=0.187p ps=1.78u w=0.55u l=0.13u
X2716 vdd adc8b_0.sar12b_0.sg13cmos5l_dfrbp_1_6.RESET_B a_84177_95810# vdd sg13_lv_pmos ad=0.2128p pd=1.5u as=0.2128p ps=1.5u w=1.12u l=0.13u
X2717 adc8b_0.sar12b_0.sg13cmos5l_buf_8_0.X a_100995_95814# sg13cmos5l_Corner_1.vss sg13cmos5l_Corner_1.vss sg13_lv_nmos ad=0.1406p pd=1.12u as=0.1406p ps=1.12u w=0.74u l=0.13u
X2718 adc8b_0.sar12b_0.sg13cmos5l_or2_1_0.A a_100131_95430# sg13cmos5l_Corner_1.vss sg13cmos5l_Corner_1.vss sg13_lv_nmos ad=0.1406p pd=1.12u as=0.1406p ps=1.12u w=0.74u l=0.13u
X2719 adc8b_0.sar12b_0.sg13cmos5l_dfrbp_1_17.Q_N a_85175_99957# vdd vdd sg13_lv_pmos ad=0.4312p pd=3.01u as=0.2639p ps=1.81u w=1.12u l=0.13u
X2720 a_94785_95183# a_93843_95071# a_94583_95421# vdd sg13_lv_pmos ad=93.45f pd=0.865u as=0.2048p ps=1.63u w=0.42u l=0.13u
X2721 a_99885_94277# adc8b_0.sar12b_0.sg13cmos5l_dfrbp_1_0.CLK sg13cmos5l_Corner_1.vss sg13cmos5l_Corner_1.vss sg13_lv_nmos ad=0.2516p pd=2.16u as=2.43055p ps=15.415u w=0.74u l=0.13u
X2722 sg13cmos5l_Corner_1.vss adc8b_0.side_cap8b_0.in_l_sw[0] adc8b_0.side_cap8b_0.buf_32_0.z sg13cmos5l_Corner_1.vss sg13_lv_nmos ad=95f pd=0.88u as=95f ps=0.88u w=0.5u l=0.13u
X2723 sg13cmos5l_IOPadAnalog_10.pad a_67639_178370# sg13cmos5l_Corner_1.vss sg13cmos5l_Corner_1.vss sg13_hv_nmos ad=2.596p pd=5.58u as=2.068p ps=9.74u w=4.4u l=0.6u
X2724 sg13cmos5l_Corner_1.vss sg13cmos5l_IOPadVdd$1_0.sg13cmos5l_Clamp_N43N43D4R$1_0.gate vdd sg13cmos5l_Corner_1.vss sg13_hv_nmos ad=1.408p pd=5.04u as=2.596p ps=5.58u w=4.4u l=0.6u
X2725 vdd sg13cmos5l_Corner_1.vss vdd vdd sg13_lv_pmos ad=0.34p pd=2.68u as=0 ps=0 w=1u l=1u
X2726 vddr adc8b_0.side_cap8b_0.in_l_sw[0] adc8b_0.side_cap8b_0.buf_32_0.z vddr sg13_lv_pmos ad=0.19p pd=1.38u as=0.19p ps=1.38u w=1u l=0.13u
X2727 adc8b_0.sar12b_0.sg13cmos5l_dlhr_1_5.D a_88727_97399# sg13cmos5l_Corner_1.vss sg13cmos5l_Corner_1.vss sg13_lv_nmos ad=0.2849p pd=2.25u as=0.2516p ps=2.16u w=0.74u l=0.13u
X2728 adc8b_0.side_cap8b_0.buf_16_0.z adc8b_0.side_cap8b_0.in_h_sw[2] vddr vddr sg13_lv_pmos ad=0.19p pd=1.38u as=0.19p ps=1.38u w=1u l=0.13u
X2729 a_83996_96132# a_83583_95826# a_83928_96132# vdd sg13_lv_pmos ad=0.191p pd=1.44u as=0.105p ps=1.21u w=1u l=0.13u
X2730 adc8b_0.side_cap8b_0.buf_4_0.z adc8b_0.side_cap8b_0.in_l_sw[7] vddr vddr sg13_lv_pmos ad=0.34p pd=2.68u as=0.19p ps=1.38u w=1u l=0.13u
X2731 vdd adc8b_0.sar12b_0.sg13cmos5l_buf_1_60.X a_84016_100384# vdd sg13_lv_pmos ad=0.2114p pd=1.54u as=0.2856p ps=2.36u w=0.84u l=0.13u
X2732 sg13cmos5l_Corner_1.vss a_99639_178370# sg13cmos5l_IOPadAnalog_15.pad sg13cmos5l_Corner_1.vss sg13_hv_nmos ad=1.408p pd=5.04u as=2.596p ps=5.58u w=4.4u l=0.6u
X2733 sg13cmos5l_Corner_1.vss a_94844_96536# adc8b_0.sar12b_0.sg13cmos5l_or2_1_1.B sg13cmos5l_Corner_1.vss sg13_lv_nmos ad=0.17255p pd=1.25u as=0.1406p ps=1.12u w=0.74u l=0.13u
X2734 a_87193_94290# a_86641_94352# sg13cmos5l_Corner_1.vss sg13cmos5l_Corner_1.vss sg13_lv_nmos ad=71.99999f pd=0.865u as=2.59257p ps=16.445u w=0.64u l=0.13u
X2735 vdd sg13cmos5l_Corner_1.vss vdd vdd sg13_lv_pmos ad=0.34p pd=2.68u as=0 ps=0 w=1u l=1u
X2736 adc8b_0.sar12b_0.sg13cmos5l_buf_1_98.A a_95409_98834# vdd vdd sg13_lv_pmos ad=0.3808p pd=2.92u as=0.2128p ps=1.5u w=1.12u l=0.13u
X2737 a_83890_95028# a_84333_95071# a_83630_95498# sg13cmos5l_Corner_1.vss sg13_lv_nmos ad=79.8f pd=0.8u as=0.1296p ps=1.52u w=0.42u l=0.13u
X2738 vdd adc8b_0.sar12b_0.sg13cmos5l_dfrbp_1_0.RESET_B a_99182_94298# vdd sg13_lv_pmos ad=0.36237p pd=2.605u as=79.8f ps=0.8u w=0.42u l=0.13u
X2739 vdd adc8b_0.sar12b_0.sg13cmos5l_dlhr_1_11.D a_94129_98442# vdd sg13_lv_pmos ad=1.07253p pd=6.75u as=0.2856p ps=2.36u w=0.84u l=0.13u
X2740 sg13cmos5l_Corner_1.vss a_87441_94298# a_87966_94280# sg13cmos5l_Corner_1.vss sg13_lv_nmos ad=0.1491p pd=1.18u as=0.187p ps=1.78u w=0.55u l=0.13u
X2741 a_89500_94284# a_89084_94620# a_89265_94298# sg13cmos5l_Corner_1.vss sg13_lv_nmos ad=77.7f pd=0.95u as=0.2516p ps=2.16u w=0.74u l=0.13u
X2742 sg13cmos5l_Corner_1.iovdd a_86044_42476# data[1] sg13cmos5l_Corner_1.iovdd sg13_hv_pmos ad=2.1312p pd=7.3u as=3.9294p ps=7.84u w=6.66u l=0.6u
X2743 sg13cmos5l_Corner_1.iovdd a_131639_164698# sg13cmos5l_IOPadAnalog_12.pad sg13cmos5l_Corner_1.iovdd sg13_hv_pmos ad=2.1312p pd=7.3u as=3.9294p ps=7.84u w=6.66u l=0.6u
X2744 sg13cmos5l_Corner_1.iovdd a_164624_70044# sg13cmos5l_IOPadAnalog_1.pad sg13cmos5l_Corner_1.iovdd sg13_hv_pmos ad=2.1312p pd=7.3u as=3.9294p ps=7.84u w=6.66u l=0.6u
X2745 sg13cmos5l_Corner_1.iovdd a_164624_102044# sg13cmos5l_IOPadAnalog_16.pad sg13cmos5l_Corner_1.iovdd sg13_hv_pmos ad=2.1312p pd=7.3u as=3.9294p ps=7.84u w=6.66u l=0.6u
X2746 vdd adc8b_0.sar12b_0.sg13cmos5l_buf_1_35.A a_83632_92824# vdd sg13_lv_pmos ad=0.2114p pd=1.54u as=0.2856p ps=2.36u w=0.84u l=0.13u
X2747 sg13cmos5l_Corner_1.vss a_83614_99010# adc8b_0.sar12b_0.sg13cmos5l_dlhr_1_8.Q_N sg13cmos5l_Corner_1.vss sg13_lv_nmos ad=0.1491p pd=1.18u as=0.2516p ps=2.16u w=0.74u l=0.13u
X2748 sg13cmos5l_Corner_1.vss a_30676_102044# vip sg13cmos5l_Corner_1.vss sg13_hv_nmos ad=1.408p pd=5.04u as=2.596p ps=5.58u w=4.4u l=0.6u
X2749 a_84516_97286# a_84647_97592# a_83765_97286# vdd sg13_lv_pmos ad=0.34p pd=2.68u as=0.2048p ps=1.63u w=1u l=0.13u
X2750 vdd sg13cmos5l_Corner_1.vss vdd vdd sg13_lv_pmos ad=0.34p pd=2.68u as=0 ps=0 w=1u l=1u
X2751 a_94188_100359# a_93900_100664# a_94126_100359# sg13cmos5l_Corner_1.vss sg13_lv_nmos ad=0.1428p pd=1.52u as=37.8f ps=0.6u w=0.42u l=0.13u
X2752 sg13cmos5l_Corner_1.vss a_86327_98790# a_86282_98826# sg13cmos5l_Corner_1.vss sg13_lv_nmos ad=1.49685p pd=9.6u as=71.99999f ps=0.865u w=0.64u l=0.13u
X2753 a_98445_97301# adc8b_0.sar12b_0.sg13cmos5l_dfrbp_1_8.D sg13cmos5l_Corner_1.vss sg13cmos5l_Corner_1.vss sg13_lv_nmos ad=0.2516p pd=2.16u as=1.97045p ps=12.335u w=0.74u l=0.13u
X2754 adc8b_0.side_cap8b_1.buf_16_3.z adc8b_0.sar12b_0.nh_sw[1] vddr vddr sg13_lv_pmos ad=0.34p pd=2.68u as=0.19p ps=1.38u w=1u l=0.13u
X2755 vddr a_30676_70044# sg13cmos5l_Corner_1.vss sg13cmos5l_Corner_1.vss sg13_hv_nmos ad=2.596p pd=5.58u as=1.408p ps=5.04u w=4.4u l=0.6u
X2756 adc8b_0.sar12b_0.sg13cmos5l_buf_1_95.X a_94000_99596# sg13cmos5l_Corner_1.vss sg13cmos5l_Corner_1.vss sg13_lv_nmos ad=0.2886p pd=2.26u as=0.14875p ps=1.16u w=0.74u l=0.13u
X2757 adc8b_0.sar12b_0.sg13cmos5l_or2_1_0.A a_100131_95430# sg13cmos5l_Corner_1.vss sg13cmos5l_Corner_1.vss sg13_lv_nmos ad=0.1406p pd=1.12u as=0.1406p ps=1.12u w=0.74u l=0.13u
X2758 a_89080_95302# adc8b_0.sar12b_0.sg13cmos5l_dfrbp_1_6.RESET_B vdd vdd sg13_lv_pmos ad=79.8f pd=0.8u as=1.38655p ps=8.8u w=0.42u l=0.13u
X2759 a_99518_95485# a_98340_95421# a_99122_95340# sg13cmos5l_Corner_1.vss sg13_lv_nmos ad=37.8f pd=0.6u as=0.1428p ps=1.52u w=0.42u l=0.13u
X2760 adc8b_0.sar12b_0.sg13cmos5l_dfrbp_1_5.Q_N a_98519_93909# vdd vdd sg13_lv_pmos ad=0.4312p pd=3.01u as=0.2639p ps=1.81u w=1.12u l=0.13u
X2761 sg13cmos5l_IOPadVdd$1_0.sg13cmos5l_Clamp_N43N43D4R$1_0.gate sg13cmos5l_IOPadVdd$1_0.sg13cmos5l_RCClampInverter$1_0.in vdd vdd sg13_hv_pmos ad=1.33p pd=7.38u as=1.33p ps=7.38u w=7u l=0.5u
X2762 sg13cmos5l_Corner_1.vss a_95416_100566# a_95065_100423# sg13cmos5l_Corner_1.vss sg13_lv_nmos ad=79.8f pd=0.8u as=0.1428p ps=1.52u w=0.42u l=0.13u
X2763 sg13cmos5l_Corner_1.vss a_94815_98850# a_94946_98844# sg13cmos5l_Corner_1.vss sg13_lv_nmos ad=1.49685p pd=9.6u as=0.2775p ps=2.23u w=0.74u l=0.13u
X2764 sg13cmos5l_IOPadAnalog_13.pad a_115639_164698# sg13cmos5l_Corner_1.iovdd sg13cmos5l_Corner_1.iovdd sg13_hv_pmos ad=3.9294p pd=7.84u as=3.1302p ps=14.26u w=6.66u l=0.6u
X2765 vin sg13cmos5l_Corner_1.iovdd dpantenna l=27.78u w=1.26u
X2766 sg13cmos5l_IOPadAnalog_0.padres sg13cmos5l_Corner_1.iovdd dpantenna l=4.98u w=0.64u
X2767 sg13cmos5l_IOPadAnalog_12.pad a_131639_164698# sg13cmos5l_Corner_1.iovdd sg13cmos5l_Corner_1.iovdd sg13_hv_pmos ad=3.9294p pd=7.84u as=2.1312p ps=7.3u w=6.66u l=0.6u
X2768 sg13cmos5l_Corner_1.vss sg13cmos5l_IOPadVdd$1_0.sg13cmos5l_Clamp_N43N43D4R$1_0.gate vdd sg13cmos5l_Corner_1.vss sg13_hv_nmos ad=1.408p pd=5.04u as=2.596p ps=5.58u w=4.4u l=0.6u
X2769 sg13cmos5l_Corner_1.vss adc8b_0.sar12b_0.nh_sw[2] adc8b_0.side_cap8b_1.buf_16_0.z sg13cmos5l_Corner_1.vss sg13_lv_nmos ad=95f pd=0.88u as=95f ps=0.88u w=0.5u l=0.13u
X2770 adc8b_0.side_cap8b_1.buf_16_1.z adc8b_0.sar12b_0.nl_sw[2] vddr vddr sg13_lv_pmos ad=0.19p pd=1.38u as=0.19p ps=1.38u w=1u l=0.13u
X2771 a_99544_97542# a_99287_97399# a_99706_97322# sg13cmos5l_Corner_1.vss sg13_lv_nmos ad=0.1428p pd=1.52u as=37.8f ps=0.6u w=0.42u l=0.13u
X2772 a_84333_95071# adc8b_0.sar12b_0.sg13cmos5l_inv_1_8.A vdd vdd sg13_lv_pmos ad=0.4088p pd=2.97u as=1.43437p ps=9.105u w=1.12u l=0.13u
X2773 a_100383_96930# adc8b_0.sar12b_0.sg13cmos5l_dfrbp_1_8.D vdd vdd sg13_lv_pmos ad=0.3234p pd=2.45u as=1.28962p ps=8.195u w=0.84u l=0.13u
X2774 adc8b_0.sar12b_0.sg13cmos5l_buf_8_2.X a_100995_100350# sg13cmos5l_Corner_1.vss sg13cmos5l_Corner_1.vss sg13_lv_nmos ad=0.1406p pd=1.12u as=0.1406p ps=1.12u w=0.74u l=0.13u
X2775 vdd a_99519_98850# a_99650_98844# vdd sg13_lv_pmos ad=1.15047p pd=7.175u as=0.2856p ps=2.36u w=0.84u l=0.13u
X2776 a_85432_95302# adc8b_0.sar12b_0.sg13cmos5l_dfrbp_1_8.RESET_B vdd vdd sg13_lv_pmos ad=79.8f pd=0.8u as=1.43437p ps=9.105u w=0.42u l=0.13u
X2777 a_102260_99560# adc8b_0.sar12b_0.sg13cmos5l_buf_1_104.X vdd vdd sg13_lv_pmos ad=0.2856p pd=2.36u as=0.2114p ps=1.54u w=0.84u l=0.13u
X2778 vip a_30676_102044# sg13cmos5l_Corner_1.vss sg13cmos5l_Corner_1.vss sg13_hv_nmos ad=2.596p pd=5.58u as=1.408p ps=5.04u w=4.4u l=0.6u
X2779 adc8b_0.sar12b_0.sg13cmos5l_dfrbp_1_15.D a_86012_99596# sg13cmos5l_Corner_1.vss sg13cmos5l_Corner_1.vss sg13_lv_nmos ad=0.2516p pd=2.16u as=0.1406p ps=1.12u w=0.74u l=0.13u
X2780 adc8b_0.sar12b_0.sg13cmos5l_buf_1_56.A a_90801_97322# sg13cmos5l_Corner_1.vss sg13cmos5l_Corner_1.vss sg13_lv_nmos ad=0.2516p pd=2.16u as=0.1406p ps=1.12u w=0.74u l=0.13u
X2781 adc8b_0.sar12b_0.sg13cmos5l_buf_8_1.A a_99740_96108# sg13cmos5l_Corner_1.vss sg13cmos5l_Corner_1.vss sg13_lv_nmos ad=0.2516p pd=2.16u as=0.1406p ps=1.12u w=0.74u l=0.13u
X2782 a_96396_99600# a_96370_99564# sg13cmos5l_Corner_1.vss sg13cmos5l_Corner_1.vss sg13_lv_nmos ad=0.2516p pd=2.16u as=0.1626p ps=1.415u w=0.74u l=0.13u
X2783 a_92551_95036# adc8b_0.sar12b_0.sg13cmos5l_nand2_1_0.A vdd vdd sg13_lv_pmos ad=0.2716p pd=1.605u as=0.3808p ps=2.92u w=1.12u l=0.13u
X2784 sg13cmos5l_Corner_1.iovdd a_42476_118044# cks sg13cmos5l_Corner_1.iovdd sg13_hv_pmos ad=2.1312p pd=7.3u as=3.9294p ps=7.84u w=6.66u l=0.6u
X2785 vddr adc8b_0.side_cap8b_0.in_h_sw[1] adc8b_0.side_cap8b_0.buf_16_3.z vddr sg13_lv_pmos ad=0.19p pd=1.38u as=0.19p ps=1.38u w=1u l=0.13u
X2786 cko a_118044_42476# sg13cmos5l_Corner_1.iovdd sg13cmos5l_Corner_1.iovdd sg13_hv_pmos ad=3.9294p pd=7.84u as=2.1312p ps=7.3u w=6.66u l=0.6u
X2787 vdd a_100727_94375# a_101564_94596# vdd sg13_lv_pmos ad=0.2128p pd=1.5u as=0.3864p ps=2.93u w=1.12u l=0.13u
X2788 sg13cmos5l_Corner_1.vss adc8b_0.side_cap8b_0.in_h_sw[0] adc8b_0.side_cap8b_0.buf_32_1.z sg13cmos5l_Corner_1.vss sg13_lv_nmos ad=95f pd=0.88u as=95f ps=0.88u w=0.5u l=0.13u
X2789 vddr adc8b_0.side_cap8b_0.in_h_sw[5] adc8b_0.side_cap8b_0.buf_8_5.z vddr sg13_lv_pmos ad=0.19p pd=1.38u as=0.19p ps=1.38u w=1u l=0.13u
X2790 sg13cmos5l_Corner_1.vss adc8b_0.sar12b_0.sg13cmos5l_buf_1_105.A a_100624_99596# sg13cmos5l_Corner_1.vss sg13_lv_nmos ad=0.14875p pd=1.16u as=0.187p ps=1.78u w=0.55u l=0.13u
X2791 a_89631_98442# adc8b_0.sar12b_0.sg13cmos5l_dlhr_1_5.GATE sg13cmos5l_Corner_1.vss sg13cmos5l_Corner_1.vss sg13_lv_nmos ad=0.2516p pd=2.16u as=0.15055p ps=1.17u w=0.74u l=0.13u
X2792 a_84525_94277# adc8b_0.sar12b_0.sg13cmos5l_dfrbp_1_9.Q sg13cmos5l_Corner_1.vss sg13cmos5l_Corner_1.vss sg13_lv_nmos ad=0.2516p pd=2.16u as=2.59257p ps=16.445u w=0.74u l=0.13u
X2793 sg13cmos5l_Corner_1.iovdd a_86044_42476# data[1] sg13cmos5l_Corner_1.iovdd sg13_hv_pmos ad=2.1312p pd=7.3u as=3.9294p ps=7.84u w=6.66u l=0.6u
X2794 vddr a_42476_70044# sg13cmos5l_Corner_1.iovdd sg13cmos5l_Corner_1.iovdd sg13_hv_pmos ad=3.9294p pd=7.84u as=2.1312p ps=7.3u w=6.66u l=0.6u
X2795 sg13cmos5l_Corner_1.vss a_90740_100310# adc8b_0.sar12b_0.sg13cmos5l_buf_1_77.X sg13cmos5l_Corner_1.vss sg13_lv_nmos ad=0.14875p pd=1.16u as=0.2886p ps=2.26u w=0.74u l=0.13u
X2796 vddr adc8b_0.sar12b_0.nl_sw[1] adc8b_0.side_cap8b_1.buf_16_2.z vddr sg13_lv_pmos ad=0.19p pd=1.38u as=0.19p ps=1.38u w=1u l=0.13u
X2797 sg13cmos5l_Corner_1.vss a_67639_178370# sg13cmos5l_IOPadAnalog_10.pad sg13cmos5l_Corner_1.vss sg13_hv_nmos ad=1.408p pd=5.04u as=2.596p ps=5.58u w=4.4u l=0.6u
X2798 sg13cmos5l_Corner_1.vss sg13cmos5l_IOPadVdd$1_0.sg13cmos5l_RCClampInverter$1_0.in sg13cmos5l_Corner_1.vss sg13cmos5l_Corner_1.vss sg13_hv_nmos ad=1.71p pd=9.38u as=0 ps=0 w=9u l=9.5u
X2799 vdd adc8b_0.sar12b_0.sg13cmos5l_inv_1_0.A a_92840_96507# vdd sg13_lv_pmos ad=0.1596p pd=1.22u as=0.1596p ps=1.22u w=0.84u l=0.13u
X2800 a_36456_133435# a_40542_133105# sg13cmos5l_Corner_1.vss rppd l=20u w=1u
X2801 adc8b_0.side_cap8b_0.buf_16_0.z adc8b_0.side_cap8b_0.in_h_sw[2] sg13cmos5l_Corner_1.vss sg13cmos5l_Corner_1.vss sg13_lv_nmos ad=0.17p pd=1.68u as=95f ps=0.88u w=0.5u l=0.13u
X2802 a_88148_98798# adc8b_0.sar12b_0.sg13cmos5l_buf_1_78.X vdd vdd sg13_lv_pmos ad=0.2856p pd=2.36u as=0.2114p ps=1.54u w=0.84u l=0.13u
X2803 adc8b_0.sar12b_0.sg13cmos5l_dfrbp_1_1.Q_N a_94583_92863# sg13cmos5l_Corner_1.vss sg13cmos5l_Corner_1.vss sg13_lv_nmos ad=0.2849p pd=2.25u as=0.2516p ps=2.16u w=0.74u l=0.13u
X2804 a_91799_99957# a_90957_99607# a_91705_99957# sg13cmos5l_Corner_1.vss sg13_lv_nmos ad=0.12665p pd=1.145u as=0.1428p ps=1.52u w=0.42u l=0.13u
X2805 adc8b_0.side_cap8b_0.buf_32_1.z adc8b_0.side_cap8b_0.in_h_sw[0] vddr vddr sg13_lv_pmos ad=0.19p pd=1.38u as=0.19p ps=1.38u w=1u l=0.13u
X2806 adc8b_0.side_cap8b_0.buf_8_4.z adc8b_0.side_cap8b_0.in_l_sw[5] sg13cmos5l_Corner_1.vss sg13cmos5l_Corner_1.vss sg13_lv_nmos ad=95f pd=0.88u as=95f ps=0.88u w=0.5u l=0.13u
X2807 vdd a_93140_94262# adc8b_0.sar12b_0.nh_sw[5] vdd sg13_lv_pmos ad=0.2114p pd=1.54u as=0.42p ps=2.99u w=1.12u l=0.13u
X2808 data[1] a_86044_30676# sg13cmos5l_Corner_1.vss sg13cmos5l_Corner_1.vss sg13_hv_nmos ad=2.596p pd=5.58u as=1.408p ps=5.04u w=4.4u l=0.6u
X2809 sg13cmos5l_Corner_1.iovdd a_42476_102044# sg13cmos5l_Corner_1.iovdd rppd l=12.9u w=0.5u
X2810 sg13cmos5l_Corner_1.vss adc8b_0.side_cap8b_0.in_l_sw[3] adc8b_0.side_cap8b_0.buf_8_1.z sg13cmos5l_Corner_1.vss sg13_lv_nmos ad=95f pd=0.88u as=95f ps=0.88u w=0.5u l=0.13u
X2811 adc8b_0.sar12b_0.sg13cmos5l_buf_1_6.A a_94288_94336# sg13cmos5l_Corner_1.vss sg13cmos5l_Corner_1.vss sg13_lv_nmos ad=0.2886p pd=2.26u as=0.14875p ps=1.16u w=0.74u l=0.13u
X2812 sg13cmos5l_Corner_1.iovdd a_118044_42476# cko sg13cmos5l_Corner_1.iovdd sg13_hv_pmos ad=2.1312p pd=7.3u as=3.9294p ps=7.84u w=6.66u l=0.6u
X2813 sg13cmos5l_Corner_1.vss a_88863_92802# a_88994_92796# sg13cmos5l_Corner_1.vss sg13_lv_nmos ad=7.01497p pd=46.005u as=0.2775p ps=2.23u w=0.74u l=0.13u
X2814 data[0] a_102160_93548# vdd vdd sg13_lv_pmos ad=0.42p pd=2.99u as=0.2114p ps=1.54u w=1.12u l=0.13u
X2815 data[2] a_102044_42476# sg13cmos5l_Corner_1.iovdd sg13cmos5l_Corner_1.iovdd sg13_hv_pmos ad=3.9294p pd=7.84u as=2.1312p ps=7.3u w=6.66u l=0.6u
X2816 sg13cmos5l_IOPadAnalog_0.pad a_178296_86044# sg13cmos5l_Corner_1.vss sg13cmos5l_Corner_1.vss sg13_hv_nmos ad=2.596p pd=5.58u as=1.408p ps=5.04u w=4.4u l=0.6u
X2817 adc8b_0.side_cap8b_1.buf_32_0.z adc8b_0.sar12b_0.nl_sw[0] vddr vddr sg13_lv_pmos ad=0.19p pd=1.38u as=0.19p ps=1.38u w=1u l=0.13u
X2818 sg13cmos5l_Corner_1.vss sg13cmos5l_IOPadVdd$1_0.sg13cmos5l_RCClampInverter$1_0.in sg13cmos5l_Corner_1.vss sg13cmos5l_Corner_1.vss sg13_hv_nmos ad=1.71p pd=9.38u as=0 ps=0 w=9u l=9.5u
X2819 vdd adc8b_0.sar12b_0.sg13cmos5l_dfrbp_1_6.RESET_B a_92050_99057# vdd sg13_lv_pmos ad=0.1563p pd=1.22u as=0.147p ps=1.54u w=0.42u l=0.13u
X2820 a_89220_94334# a_88671_94314# a_89084_94620# sg13cmos5l_Corner_1.vss sg13_lv_nmos ad=47.25f pd=0.645u as=0.141p ps=1.17u w=0.42u l=0.13u
X2821 cks a_30676_118044# sg13cmos5l_Corner_1.vss sg13cmos5l_Corner_1.vss sg13_hv_nmos ad=2.596p pd=5.58u as=1.408p ps=5.04u w=4.4u l=0.6u
X2822 adc8b_0.side_cap8b_0.buf_32_0.z adc8b_0.side_cap8b_0.in_l_sw[0] sg13cmos5l_Corner_1.vss sg13cmos5l_Corner_1.vss sg13_lv_nmos ad=0.17p pd=1.68u as=95f ps=0.88u w=0.5u l=0.13u
X2823 vdd a_100628_100310# adc8b_0.side_cap8b_0.in_h_sw[8] vdd sg13_lv_pmos ad=0.2114p pd=1.54u as=0.42p ps=2.99u w=1.12u l=0.13u
X2824 adc8b_0.sar12b_0.sg13cmos5l_buf_1_19.A a_100624_99596# sg13cmos5l_Corner_1.vss sg13cmos5l_Corner_1.vss sg13_lv_nmos ad=0.2886p pd=2.26u as=0.14875p ps=1.16u w=0.74u l=0.13u
X2825 vdd adc8b_0.sar12b_0.sg13cmos5l_buf_1_89.A a_96976_97360# vdd sg13_lv_pmos ad=0.2114p pd=1.54u as=0.2856p ps=2.36u w=0.84u l=0.13u
X2826 adc8b_0.sar12b_0.sg13cmos5l_inv_1_9.Y cks vdd vdd sg13_lv_pmos ad=0.3808p pd=2.92u as=0.3808p ps=2.92u w=1.12u l=0.13u
X2827 cko a_118044_30676# sg13cmos5l_Corner_1.vss sg13cmos5l_Corner_1.vss sg13_hv_nmos ad=2.596p pd=5.58u as=1.408p ps=5.04u w=4.4u l=0.6u
X2828 vdd adc8b_0.sar12b_0.sg13cmos5l_dlhr_1_0.D a_92099_93084# vdd sg13_lv_pmos ad=0.2128p pd=1.5u as=0.2128p ps=1.5u w=1.12u l=0.13u
X2829 sg13cmos5l_Corner_1.vss a_98036_94262# adc8b_0.sar12b_0.nl_sw[8] sg13cmos5l_Corner_1.vss sg13_lv_nmos ad=0.14875p pd=1.16u as=0.2886p ps=2.26u w=0.74u l=0.13u
X2830 sg13cmos5l_IOPadAnalog_9.pad a_83639_164698# sg13cmos5l_Corner_1.iovdd sg13cmos5l_Corner_1.iovdd sg13_hv_pmos ad=3.9294p pd=7.84u as=3.1302p ps=14.26u w=6.66u l=0.6u
X2831 sg13cmos5l_Corner_1.vss sg13cmos5l_IOPadVdd$1_0.sg13cmos5l_Clamp_N43N43D4R$1_0.gate vdd sg13cmos5l_Corner_1.vss sg13_hv_nmos ad=1.408p pd=5.04u as=2.596p ps=5.58u w=4.4u l=0.6u
X2832 vdd a_84116_98784# a_83716_99124# vdd sg13_lv_pmos ad=0.2387p pd=1.84u as=0.2128p ps=1.5u w=1.12u l=0.13u
X2833 a_93256_95836# adc8b_0.sar12b_0.sg13cmos5l_a221oi_1_0.B1 adc8b_0.sar12b_0.sg13cmos5l_o21ai_1_0.A1 sg13cmos5l_Corner_1.vss sg13_lv_nmos ad=0.1406p pd=1.12u as=0.2516p ps=2.16u w=0.74u l=0.13u
X2834 vdd adc8b_0.sar12b_0.sg13cmos5l_buf_1_19.A a_100528_93548# vdd sg13_lv_pmos ad=0.2114p pd=1.54u as=0.2856p ps=2.36u w=0.84u l=0.13u
X2835 adc8b_0.side_cap8b_0.buf_32_0.z adc8b_0.side_cap8b_0.in_l_sw[0] vddr vddr sg13_lv_pmos ad=0.19p pd=1.38u as=0.19p ps=1.38u w=1u l=0.13u
X2836 adc8b_0.side_cap8b_0.buf_4_1.z adc8b_0.side_cap8b_0.in_h_sw[6] vddr vddr sg13_lv_pmos ad=0.19p pd=1.38u as=0.19p ps=1.38u w=1u l=0.13u
X2837 frame a_101776_98872# sg13cmos5l_Corner_1.vss sg13cmos5l_Corner_1.vss sg13_lv_nmos ad=0.2886p pd=2.26u as=0.14875p ps=1.16u w=0.74u l=0.13u
X2838 a_87567_96659# a_87719_96543# vdd vdd sg13_lv_pmos ad=0.3864p pd=2.93u as=1.28962p ps=8.195u w=1.12u l=0.13u
X2839 sg13cmos5l_Corner_1.vss a_178296_86044# sg13cmos5l_IOPadAnalog_0.pad sg13cmos5l_Corner_1.vss sg13_hv_nmos ad=1.408p pd=5.04u as=2.596p ps=5.58u w=4.4u l=0.6u
X2840 sg13cmos5l_Corner_1.iovdd a_131639_164698# sg13cmos5l_IOPadAnalog_12.pad sg13cmos5l_Corner_1.iovdd sg13_hv_pmos ad=2.1312p pd=7.3u as=3.9294p ps=7.84u w=6.66u l=0.6u
X2841 sg13cmos5l_Corner_1.vss adc8b_0.sar12b_0.sg13cmos5l_dfrbp_1_6.RESET_B a_94092_97322# sg13cmos5l_Corner_1.vss sg13_lv_nmos ad=0.1626p pd=1.415u as=60.89999f ps=0.71u w=0.42u l=0.13u
X2842 adc8b_0.sar12b_0.sg13cmos5l_dfrbp_1_6.RESET_B cks vdd vdd sg13_lv_pmos ad=0.2128p pd=1.5u as=0.3808p ps=2.92u w=1.12u l=0.13u
X2843 sg13cmos5l_Corner_1.vss a_80694_96641# a_80806_96705# sg13cmos5l_Corner_1.vss sg13_lv_nmos ad=0.1426p pd=1.16u as=0.1428p ps=1.52u w=0.42u l=0.5u
X2844 sg13cmos5l_Corner_1.vss a_178296_118044# sg13cmos5l_IOPadAnalog_11.pad sg13cmos5l_Corner_1.vss sg13_hv_nmos ad=1.408p pd=5.04u as=2.596p ps=5.58u w=4.4u l=0.6u
X2845 a_92056_99838# a_91799_99957# a_92218_100034# sg13cmos5l_Corner_1.vss sg13_lv_nmos ad=0.1428p pd=1.52u as=37.8f ps=0.6u w=0.42u l=0.13u
X2846 sg13cmos5l_Corner_1.vss adc8b_0.sar12b_0.sg13cmos5l_dfrbp_1_16.Q a_85393_98442# sg13cmos5l_Corner_1.vss sg13_lv_nmos ad=0.15055p pd=1.17u as=0.187p ps=1.78u w=0.55u l=0.13u
X2847 a_87538_95028# a_87981_95071# a_87921_95107# vdd sg13_lv_pmos ad=79.8f pd=0.8u as=63f ps=0.72u w=0.42u l=0.13u
X2848 vdd adc8b_0.sar12b_0.sg13cmos5l_dfrbp_1_8.RESET_B a_87730_99564# vdd sg13_lv_pmos ad=0.1563p pd=1.22u as=0.147p ps=1.54u w=0.42u l=0.13u
X2849 vdd adc8b_0.cmp_0.outp a_82192_92824# vdd sg13_lv_pmos ad=0.2114p pd=1.54u as=0.2856p ps=2.36u w=0.84u l=0.13u
X2850 adc8b_0.sar12b_0.sg13cmos5l_buf_1_19.X a_100528_93548# vdd vdd sg13_lv_pmos ad=0.42p pd=2.99u as=0.2114p ps=1.54u w=1.12u l=0.13u
X2851 vin a_42476_86044# sg13cmos5l_Corner_1.iovdd sg13cmos5l_Corner_1.iovdd sg13_hv_pmos ad=3.9294p pd=7.84u as=2.1312p ps=7.3u w=6.66u l=0.6u
X2852 sg13cmos5l_Corner_1.vss a_102044_30676# data[2] sg13cmos5l_Corner_1.vss sg13_hv_nmos ad=1.408p pd=5.04u as=2.596p ps=5.58u w=4.4u l=0.6u
X2853 sg13cmos5l_IOPadAnalog_11.pad a_164624_118044# sg13cmos5l_Corner_1.iovdd sg13cmos5l_Corner_1.iovdd sg13_hv_pmos ad=3.9294p pd=7.84u as=3.1302p ps=14.26u w=6.66u l=0.6u
X2854 vddr adc8b_0.sar12b_0.nl_sw[5] adc8b_0.side_cap8b_1.buf_8_4.z vddr sg13_lv_pmos ad=0.19p pd=1.38u as=0.19p ps=1.38u w=1u l=0.13u
X2855 vddr adc8b_0.sar12b_0.nh_sw[1] adc8b_0.side_cap8b_1.buf_16_3.z vddr sg13_lv_pmos ad=0.19p pd=1.38u as=0.19p ps=1.38u w=1u l=0.13u
X2856 vdd adc8b_0.sar12b_0.sg13cmos5l_inv_1_7.A a_94000_99596# vdd sg13_lv_pmos ad=0.2114p pd=1.54u as=0.2856p ps=2.36u w=0.84u l=0.13u
X2857 sg13cmos5l_Corner_1.vss vdd sg13cmos5l_Corner_1.vss sg13cmos5l_Corner_1.vss sg13_lv_nmos ad=79.8f pd=0.8u as=0 ps=0 w=0.42u l=1u
X2858 a_97006_98847# adc8b_0.sar12b_0.sg13cmos5l_dfrbp_1_6.RESET_B sg13cmos5l_Corner_1.vss sg13cmos5l_Corner_1.vss sg13_lv_nmos ad=37.8f pd=0.6u as=0.1701p ps=1.65u w=0.42u l=0.13u
X2859 adc8b_0.sar12b_0.sg13cmos5l_buf_1_101.X a_98032_100384# sg13cmos5l_Corner_1.vss sg13cmos5l_Corner_1.vss sg13_lv_nmos ad=0.2886p pd=2.26u as=0.14875p ps=1.16u w=0.74u l=0.13u
X2860 a_89006_98834# a_89811_98956# a_89266_99057# vdd sg13_lv_pmos ad=0.1428p pd=1.52u as=79.8f ps=0.8u w=0.42u l=0.13u
X2861 adc8b_0.side_cap8b_0.buf_16_1.z adc8b_0.side_cap8b_0.in_l_sw[2] sg13cmos5l_Corner_1.vss sg13cmos5l_Corner_1.vss sg13_lv_nmos ad=95f pd=0.88u as=95f ps=0.88u w=0.5u l=0.13u
X2862 vdd a_85367_94375# a_86204_94596# vdd sg13_lv_pmos ad=0.2128p pd=1.5u as=0.3864p ps=2.93u w=1.12u l=0.13u
X2863 a_95026_94521# a_95469_94277# a_94766_94298# sg13cmos5l_Corner_1.vss sg13_lv_nmos ad=79.8f pd=0.8u as=0.1296p ps=1.52u w=0.42u l=0.13u
X2864 a_92201_92812# adc8b_0.sar12b_0.sg13cmos5l_dlhr_1_0.D adc8b_0.sar12b_0.sg13cmos5l_a22oi_1_2.B1 sg13cmos5l_Corner_1.vss sg13_lv_nmos ad=0.1406p pd=1.12u as=0.1406p ps=1.12u w=0.74u l=0.13u
X2865 a_94744_93790# adc8b_0.sar12b_0.sg13cmos5l_dfrbp_1_0.RESET_B vdd vdd sg13_lv_pmos ad=79.8f pd=0.8u as=1.777p ps=11.395u w=0.42u l=0.13u
X2866 vdd adc8b_0.sar12b_0.sg13cmos5l_inv_1_29.A a_94609_98888# vdd sg13_lv_pmos ad=1.15047p pd=7.175u as=0.2856p ps=2.36u w=0.84u l=0.13u
X2867 sg13cmos5l_Corner_1.vss adc8b_0.sar12b_0.sg13cmos5l_dfrbp_1_21.Q a_100177_96930# sg13cmos5l_Corner_1.vss sg13_lv_nmos ad=0.15055p pd=1.17u as=0.187p ps=1.78u w=0.55u l=0.13u
X2868 vddr adc8b_0.side_cap8b_0.in_h_sw[3] adc8b_0.side_cap8b_0.buf_8_3.z vddr sg13_lv_pmos ad=0.19p pd=1.38u as=0.19p ps=1.38u w=1u l=0.13u
X2869 vdd a_84500_100310# adc8b_0.sar12b_0.sg13cmos5l_buf_1_61.X vdd sg13_lv_pmos ad=0.2114p pd=1.54u as=0.42p ps=2.99u w=1.12u l=0.13u
X2870 adc8b_0.sar12b_0.sg13cmos5l_buf_1_104.A adc8b_0.sar12b_0.sg13cmos5l_buf_1_3.A sg13cmos5l_Corner_1.vss sg13cmos5l_Corner_1.vss sg13_lv_nmos ad=0.2516p pd=2.16u as=0.2516p ps=2.16u w=0.74u l=0.13u
X2871 a_99684_99998# a_99135_99954# a_99548_99596# sg13cmos5l_Corner_1.vss sg13_lv_nmos ad=47.25f pd=0.645u as=0.141p ps=1.17u w=0.42u l=0.13u
X2872 a_92076_99152# a_92050_99057# sg13cmos5l_Corner_1.vss sg13cmos5l_Corner_1.vss sg13_lv_nmos ad=0.2516p pd=2.16u as=0.1626p ps=1.415u w=0.74u l=0.13u
X2873 vdd a_100131_95430# adc8b_0.sar12b_0.sg13cmos5l_or2_1_0.A vdd sg13_lv_pmos ad=0.2128p pd=1.5u as=0.2128p ps=1.5u w=1.12u l=0.13u
X2874 adc8b_0.side_cap8b_1.buf_16_0.z adc8b_0.sar12b_0.nh_sw[2] sg13cmos5l_Corner_1.vss sg13cmos5l_Corner_1.vss sg13_lv_nmos ad=95f pd=0.88u as=95f ps=0.88u w=0.5u l=0.13u
X2875 a_89656_96030# a_89399_95887# a_89818_95810# sg13cmos5l_Corner_1.vss sg13_lv_nmos ad=0.1428p pd=1.52u as=37.8f ps=0.6u w=0.42u l=0.13u
X2876 sg13cmos5l_Corner_1.vss adc8b_0.sar12b_0.nh_sw[0] adc8b_0.side_cap8b_1.buf_32_1.z sg13cmos5l_Corner_1.vss sg13_lv_nmos ad=95f pd=0.88u as=95f ps=0.88u w=0.5u l=0.13u
X2877 vdd adc8b_0.sar12b_0.sg13cmos5l_dfrbp_1_16.Q a_85393_98442# vdd sg13_lv_pmos ad=1.07253p pd=6.75u as=0.2856p ps=2.36u w=0.84u l=0.13u
X2878 sg13cmos5l_Corner_1.vss adc8b_0.sar12b_0.sg13cmos5l_inv_1_1.A adc8b_0.sar12b_0.sg13cmos5l_buf_1_2.A sg13cmos5l_Corner_1.vss sg13_lv_nmos ad=0.2516p pd=2.16u as=0.2516p ps=2.16u w=0.74u l=0.13u
X2879 sg13cmos5l_Corner_1.vss a_178296_70044# sg13cmos5l_IOPadAnalog_1.pad sg13cmos5l_Corner_1.vss sg13_hv_nmos ad=2.068p pd=9.74u as=2.596p ps=5.58u w=4.4u l=0.6u
X2880 sg13cmos5l_Corner_1.vss a_96063_98442# a_96194_98448# sg13cmos5l_Corner_1.vss sg13_lv_nmos ad=1.49685p pd=9.6u as=0.2775p ps=2.23u w=0.74u l=0.13u
X2881 sg13cmos5l_Corner_1.vss adc8b_0.sar12b_0.sg13cmos5l_inv_1_8.A adc8b_0.sar12b_0.sg13cmos5l_inv_1_8.Y sg13cmos5l_Corner_1.vss sg13_lv_nmos ad=0.2516p pd=2.16u as=0.2516p ps=2.16u w=0.74u l=0.13u
X2882 a_84599_98790# adc8b_0.sar12b_0.sg13cmos5l_dfrbp_1_16.Q_N vdd vdd sg13_lv_pmos ad=0.2856p pd=2.36u as=1.15047p ps=7.175u w=0.84u l=0.13u
X2883 sg13cmos5l_Corner_1.vss a_98296_99054# a_97945_98911# sg13cmos5l_Corner_1.vss sg13_lv_nmos ad=79.8f pd=0.8u as=0.1428p ps=1.52u w=0.42u l=0.13u
X2884 a_84148_97322# a_83765_97286# vdd vdd sg13_lv_pmos ad=79.8f pd=0.8u as=0.2639p ps=1.81u w=0.42u l=0.13u
X2885 sg13cmos5l_Corner_1.iovdd a_164624_118044# sg13cmos5l_IOPadAnalog_11.pad sg13cmos5l_Corner_1.iovdd sg13_hv_pmos ad=2.1312p pd=7.3u as=3.9294p ps=7.84u w=6.66u l=0.6u
X2886 sg13cmos5l_IOPadAnalog_13.pad sg13cmos5l_IOPadAnalog_13.padres sg13cmos5l_Corner_1.vss rppd l=2u w=1u
X2887 sg13cmos5l_Corner_1.vss sg13cmos5l_IOPadVdd$1_0.sg13cmos5l_Clamp_N43N43D4R$1_0.gate vdd sg13cmos5l_Corner_1.vss sg13_hv_nmos ad=1.408p pd=5.04u as=2.596p ps=5.58u w=4.4u l=0.6u
X2888 adc8b_0.side_cap8b_0.buf_16_3.z adc8b_0.side_cap8b_0.in_h_sw[1] vddr vddr sg13_lv_pmos ad=0.34p pd=2.68u as=0.19p ps=1.38u w=1u l=0.13u
X2889 sg13cmos5l_Corner_1.vss a_90801_97322# a_91326_97304# sg13cmos5l_Corner_1.vss sg13_lv_nmos ad=0.1491p pd=1.18u as=0.187p ps=1.78u w=0.55u l=0.13u
X2890 a_82774_95327# a_82889_95326# sg13cmos5l_Corner_1.vss sg13cmos5l_Corner_1.vss sg13_lv_nmos ad=0.1428p pd=1.52u as=0.1426p ps=1.16u w=0.42u l=0.5u
X2891 sg13cmos5l_IOPadAnalog_15.pad a_99639_164698# sg13cmos5l_Corner_1.iovdd sg13cmos5l_Corner_1.iovdd sg13_hv_pmos ad=3.9294p pd=7.84u as=2.1312p ps=7.3u w=6.66u l=0.6u
X2892 sg13cmos5l_IOPadAnalog_13.pad a_115639_164698# sg13cmos5l_Corner_1.iovdd sg13cmos5l_Corner_1.iovdd sg13_hv_pmos ad=3.9294p pd=7.84u as=2.1312p ps=7.3u w=6.66u l=0.6u
X2893 vdd adc8b_0.sar12b_0.sg13cmos5l_dfrbp_1_6.RESET_B a_82190_98522# vdd sg13_lv_pmos ad=0.36237p pd=2.605u as=79.8f ps=0.8u w=0.42u l=0.13u
X2894 vddr adc8b_0.sar12b_0.nl_sw[0] adc8b_0.side_cap8b_1.buf_32_0.z vddr sg13_lv_pmos ad=0.19p pd=1.38u as=0.19p ps=1.38u w=1u l=0.13u
X2895 vdd adc8b_0.sar12b_0.sg13cmos5l_dfrbp_1_6.RESET_B a_89265_94298# vdd sg13_lv_pmos ad=0.2128p pd=1.5u as=0.2128p ps=1.5u w=1.12u l=0.13u
X2896 a_98708_94262# adc8b_0.sar12b_0.sg13cmos5l_buf_1_4.X sg13cmos5l_Corner_1.vss sg13cmos5l_Corner_1.vss sg13_lv_nmos ad=0.187p pd=1.78u as=0.14875p ps=1.16u w=0.55u l=0.13u
X2897 a_83735_98445# a_82893_98095# a_82476_98088# vdd sg13_lv_pmos ad=0.2048p pd=1.63u as=0.34p ps=2.68u w=1u l=0.13u
X2898 adc8b_0.side_cap8b_1.buf_16_0.z adc8b_0.sar12b_0.nh_sw[2] vddr vddr sg13_lv_pmos ad=0.19p pd=1.38u as=0.19p ps=1.38u w=1u l=0.13u
X2899 adc8b_0.sar12b_0.sg13cmos5l_buf_1_34.A a_85809_93905# vdd vdd sg13_lv_pmos ad=0.3808p pd=2.92u as=0.2128p ps=1.5u w=1.12u l=0.13u
X2900 a_95288_95856# adc8b_0.sar12b_0.sg13cmos5l_inv_1_0.A a_95186_95856# sg13cmos5l_Corner_1.vss sg13_lv_nmos ad=0.1216p pd=1.02u as=0.1216p ps=1.02u w=0.64u l=0.13u
X2901 sg13cmos5l_Corner_1.iovdd a_83639_164698# sg13cmos5l_IOPadAnalog_9.pad sg13cmos5l_Corner_1.iovdd sg13_hv_pmos ad=2.1312p pd=7.3u as=3.9294p ps=7.84u w=6.66u l=0.6u
X2902 sg13cmos5l_Corner_1.vss sg13cmos5l_IOPadVdd$1_0.sg13cmos5l_Clamp_N43N43D4R$1_0.gate vdd sg13cmos5l_Corner_1.vss sg13_hv_nmos ad=1.408p pd=5.04u as=2.596p ps=5.58u w=4.4u l=0.6u
X2903 sg13cmos5l_Corner_1.vss a_30676_118044# cks sg13cmos5l_Corner_1.vss sg13_hv_nmos ad=1.408p pd=5.04u as=2.596p ps=5.58u w=4.4u l=0.6u
X2904 sg13cmos5l_Corner_1.iovdd a_42476_102044# vip sg13cmos5l_Corner_1.iovdd sg13_hv_pmos ad=2.1312p pd=7.3u as=3.9294p ps=7.84u w=6.66u l=0.6u
X2905 sg13cmos5l_Corner_1.vss adc8b_0.side_cap8b_0.in_h_sw[2] adc8b_0.side_cap8b_0.buf_16_0.z sg13cmos5l_Corner_1.vss sg13_lv_nmos ad=95f pd=0.88u as=95f ps=0.88u w=0.5u l=0.13u
X2906 vdd adc8b_0.sar12b_0.sg13cmos5l_dfrbp_1_21.Q a_100177_96930# vdd sg13_lv_pmos ad=1.28962p pd=8.195u as=0.2856p ps=2.36u w=0.84u l=0.13u
X2907 sg13cmos5l_IOPadAnalog_0.padres sg13cmos5l_IOPadAnalog_0.pad sg13cmos5l_Corner_1.vss rppd l=2u w=1u
X2908 a_83735_96933# a_82893_96583# a_83641_96933# sg13cmos5l_Corner_1.vss sg13_lv_nmos ad=0.12665p pd=1.145u as=0.1428p ps=1.52u w=0.42u l=0.13u
X2909 a_85764_93950# a_85215_93906# a_85628_93548# sg13cmos5l_Corner_1.vss sg13_lv_nmos ad=47.25f pd=0.645u as=0.141p ps=1.17u w=0.42u l=0.13u
X2910 vdd sg13cmos5l_Corner_1.vss vdd vdd sg13_lv_pmos ad=0.34p pd=2.68u as=0 ps=0 w=1u l=1u
X2911 sg13cmos5l_IOPadAnalog_11.pad a_164624_118044# sg13cmos5l_Corner_1.iovdd sg13cmos5l_Corner_1.iovdd sg13_hv_pmos ad=3.9294p pd=7.84u as=2.1312p ps=7.3u w=6.66u l=0.6u
X2912 vin a_30676_86044# sg13cmos5l_Corner_1.vss sg13cmos5l_Corner_1.vss sg13_hv_nmos ad=2.596p pd=5.58u as=1.408p ps=5.04u w=4.4u l=0.6u
X2913 adc8b_0.sar12b_0.sg13cmos5l_dlhr_1_14.Q_N a_95934_98816# sg13cmos5l_Corner_1.vss sg13cmos5l_Corner_1.vss sg13_lv_nmos ad=0.2516p pd=2.16u as=0.1491p ps=1.18u w=0.74u l=0.13u
X2914 a_97180_96960# a_96764_96572# a_96945_96929# sg13cmos5l_Corner_1.vss sg13_lv_nmos ad=77.7f pd=0.95u as=0.2516p ps=2.16u w=0.74u l=0.13u
X2915 adc8b_0.side_cap8b_1.buf_8_0.z adc8b_0.sar12b_0.nl_sw[4] vddr vddr sg13_lv_pmos ad=0.19p pd=1.38u as=0.19p ps=1.38u w=1u l=0.13u
X2916 sg13cmos5l_Corner_1.vss adc8b_0.side_cap8b_0.in_h_sw[7] adc8b_0.side_cap8b_0.buf_4_2.z sg13cmos5l_Corner_1.vss sg13_lv_nmos ad=95f pd=0.88u as=0.17p ps=1.68u w=0.5u l=0.13u
X2917 adc8b_0.sar12b_0.sg13cmos5l_dfrbp_1_8.Q_N a_98903_95887# vdd vdd sg13_lv_pmos ad=0.4312p pd=3.01u as=0.2639p ps=1.81u w=1.12u l=0.13u
X2918 vddr adc8b_0.sar12b_0.nl_sw[0] adc8b_0.side_cap8b_1.buf_32_0.z vddr sg13_lv_pmos ad=0.19p pd=1.38u as=0.19p ps=1.38u w=1u l=0.13u
X2919 sg13cmos5l_Corner_1.vss a_99639_178370# sg13cmos5l_Corner_1.vss rppd l=3.54u w=0.5u
X2920 sg13cmos5l_Corner_1.vss a_134044_30676# frame sg13cmos5l_Corner_1.vss sg13_hv_nmos ad=2.068p pd=9.74u as=2.596p ps=5.58u w=4.4u l=0.6u
X2921 sg13cmos5l_Corner_1.vss a_134044_30676# frame sg13cmos5l_Corner_1.vss sg13_hv_nmos ad=1.408p pd=5.04u as=2.596p ps=5.58u w=4.4u l=0.6u
X2922 sg13cmos5l_Corner_1.vss adc8b_0.side_cap8b_0.in_l_sw[0] adc8b_0.side_cap8b_0.buf_32_0.z sg13cmos5l_Corner_1.vss sg13_lv_nmos ad=95f pd=0.88u as=95f ps=0.88u w=0.5u l=0.13u
X2923 vddr adc8b_0.side_cap8b_0.in_l_sw[5] adc8b_0.side_cap8b_0.buf_8_4.z vddr sg13_lv_pmos ad=0.19p pd=1.38u as=0.34p ps=2.68u w=1u l=0.13u
X2924 sg13cmos5l_Corner_1.vss a_86193_98441# a_86718_98514# sg13cmos5l_Corner_1.vss sg13_lv_nmos ad=0.1491p pd=1.18u as=0.187p ps=1.78u w=0.55u l=0.13u
X2925 vdd adc8b_0.sar12b_0.sg13cmos5l_buf_8_1.A a_100131_95430# vdd sg13_lv_pmos ad=0.2128p pd=1.5u as=0.2128p ps=1.5u w=1.12u l=0.13u
X2926 sg13cmos5l_Corner_1.vss adc8b_0.sar12b_0.sg13cmos5l_dfrbp_1_6.RESET_B a_87676_94284# sg13cmos5l_Corner_1.vss sg13_lv_nmos ad=0.1406p pd=1.12u as=77.7f ps=0.95u w=0.74u l=0.13u
X2927 a_101780_92750# adc8b_0.sar12b_0.sg13cmos5l_buf_1_0.A vdd vdd sg13_lv_pmos ad=0.2856p pd=2.36u as=0.2114p ps=1.54u w=0.84u l=0.13u
X2928 a_94126_100359# adc8b_0.sar12b_0.sg13cmos5l_dfrbp_1_8.RESET_B sg13cmos5l_Corner_1.vss sg13cmos5l_Corner_1.vss sg13_lv_nmos ad=37.8f pd=0.6u as=0.1701p ps=1.65u w=0.42u l=0.13u
X2929 adc8b_0.sar12b_0.sg13cmos5l_dfrbp_1_21.Q a_100124_97620# vdd vdd sg13_lv_pmos ad=0.3808p pd=2.92u as=0.2128p ps=1.5u w=1.12u l=0.13u
X2930 a_72090_94286# adc8b_0.diff_bsw_0.single_bsw_1.sg13cmos5l_inv_1$1_2.Y w_71686_95000# w_71686_95000# sg13_lv_pmos ad=0.17p pd=1.68u as=0.17p ps=1.68u w=0.5u l=0.13u
X2931 sg13cmos5l_Corner_1.iovdd a_164624_102044# sg13cmos5l_IOPadAnalog_16.pad sg13cmos5l_Corner_1.iovdd sg13_hv_pmos ad=2.1312p pd=7.3u as=3.9294p ps=7.84u w=6.66u l=0.6u
X2932 a_74586_95659# adc8b_0.cmp_0.clk sg13cmos5l_Corner_1.vss sg13cmos5l_Corner_1.vss sg13_lv_nmos ad=95f pd=0.88u as=95f ps=0.88u w=0.5u l=0.13u
X2933 sg13cmos5l_Corner_1.iovdd a_86044_42476# data[1] sg13cmos5l_Corner_1.iovdd sg13_hv_pmos ad=2.1312p pd=7.3u as=3.9294p ps=7.84u w=6.66u l=0.6u
X2934 adc8b_0.side_cap8b_0.buf_16_2.z adc8b_0.side_cap8b_0.in_l_sw[1] vddr vddr sg13_lv_pmos ad=0.19p pd=1.38u as=0.19p ps=1.38u w=1u l=0.13u
X2935 a_94484_99560# adc8b_0.sar12b_0.sg13cmos5l_buf_1_79.X vdd vdd sg13_lv_pmos ad=0.2856p pd=2.36u as=0.2114p ps=1.54u w=0.84u l=0.13u
X2936 sg13cmos5l_Corner_1.iovdd a_42476_118044# cks sg13cmos5l_Corner_1.iovdd sg13_hv_pmos ad=2.1312p pd=7.3u as=3.9294p ps=7.84u w=6.66u l=0.6u
X2937 vddr adc8b_0.side_cap8b_0.in_l_sw[0] adc8b_0.side_cap8b_0.buf_32_0.z vddr sg13_lv_pmos ad=0.19p pd=1.38u as=0.19p ps=1.38u w=1u l=0.13u
X2938 adc8b_0.side_cap8b_0.buf_16_0.z adc8b_0.side_cap8b_0.in_h_sw[2] vddr vddr sg13_lv_pmos ad=0.19p pd=1.38u as=0.19p ps=1.38u w=1u l=0.13u
X2939 adc8b_0.side_cap8b_1.buf_8_1.z adc8b_0.sar12b_0.nl_sw[3] vddr vddr sg13_lv_pmos ad=0.34p pd=2.68u as=0.19p ps=1.38u w=1u l=0.13u
X2940 a_88820_100310# adc8b_0.sar12b_0.sg13cmos5l_inv_1_14.A vdd vdd sg13_lv_pmos ad=0.2856p pd=2.36u as=0.2114p ps=1.54u w=0.84u l=0.13u
X2941 vdd adc8b_0.cmp_0.clk adc8b_0.cmp_0.outn vdd sg13_lv_pmos ad=95f pd=0.88u as=0.17p ps=1.68u w=0.5u l=0.13u
X2942 adc8b_0.sar12b_0.sg13cmos5l_a22oi_1_2.B2 adc8b_0.sar12b_0.sg13cmos5l_a221oi_1_0.C1 a_92188_96920# sg13cmos5l_Corner_1.vss sg13_lv_nmos ad=0.2516p pd=2.16u as=0.1406p ps=1.12u w=0.74u l=0.13u
X2943 sg13cmos5l_Corner_1.vss adc8b_0.sar12b_0.sg13cmos5l_nor2_1_0.A adc8b_0.sar12b_0.sg13cmos5l_a221oi_1_0.C1 sg13cmos5l_Corner_1.vss sg13_lv_nmos ad=0.2516p pd=2.16u as=0.1406p ps=1.12u w=0.74u l=0.13u
X2944 vdd sg13cmos5l_IOPadVdd$1_0.sg13cmos5l_Clamp_N43N43D4R$1_0.gate sg13cmos5l_Corner_1.vss sg13cmos5l_Corner_1.vss sg13_hv_nmos ad=2.596p pd=5.58u as=1.408p ps=5.04u w=4.4u l=0.6u
X2945 vdd sg13cmos5l_IOPadVdd$1_0.sg13cmos5l_RCClampInverter$1_0.in sg13cmos5l_IOPadVdd$1_0.sg13cmos5l_Clamp_N43N43D4R$1_0.gate vdd sg13_hv_pmos ad=1.33p pd=7.38u as=1.33p ps=7.38u w=7u l=0.5u
X2946 vdd sg13cmos5l_Corner_1.vss vdd vdd sg13_lv_pmos ad=0.19p pd=1.38u as=0 ps=0 w=1u l=1u
X2947 sg13cmos5l_IOPadAnalog_9.pad sg13cmos5l_IOPadAnalog_9.padres sg13cmos5l_Corner_1.vss rppd l=2u w=1u
X2948 vdd sg13cmos5l_Corner_1.vss vdd vdd sg13_lv_pmos ad=0.19p pd=1.38u as=0 ps=0 w=1u l=1u
X2949 vddr sg13cmos5l_Corner_1.iovdd dpantenna l=27.78u w=1.26u
X2950 vddr adc8b_0.side_cap8b_0.in_l_sw[2] adc8b_0.side_cap8b_0.buf_16_1.z vddr sg13_lv_pmos ad=0.19p pd=1.38u as=0.19p ps=1.38u w=1u l=0.13u
X2951 vdd adc8b_0.sar12b_0.sg13cmos5l_buf_8_1.A a_98471_95031# vdd sg13_lv_pmos ad=1.43437p pd=9.105u as=0.4088p ps=2.97u w=1.12u l=0.13u
X2952 sg13cmos5l_IOPadAnalog_10.pad a_67639_164698# sg13cmos5l_Corner_1.iovdd sg13cmos5l_Corner_1.iovdd sg13_hv_pmos ad=3.9294p pd=7.84u as=2.1312p ps=7.3u w=6.66u l=0.6u
X2953 a_97207_92790# a_97125_92976# adc8b_0.sar12b_0.sg13cmos5l_nand2_1_1.B sg13cmos5l_Corner_1.vss sg13_lv_nmos ad=0.1406p pd=1.12u as=0.333p ps=2.38u w=0.74u l=0.13u
X2954 vdd a_99284_100310# adc8b_0.side_cap8b_0.in_l_sw[8] vdd sg13_lv_pmos ad=0.2114p pd=1.54u as=0.42p ps=2.99u w=1.12u l=0.13u
X2955 a_80694_96641# a_80424_96641# vdd vdd sg13_lv_pmos ad=0.34p pd=2.68u as=0.1523p ps=1.38u w=1u l=0.5u
X2956 a_85164_95810# adc8b_0.sar12b_0.sg13cmos5l_dfrbp_1_9.Q a_85070_95810# sg13cmos5l_Corner_1.vss sg13_lv_nmos ad=60.89999f pd=0.71u as=0.1428p ps=1.52u w=0.42u l=0.13u
X2957 vdd adc8b_0.sar12b_0.sg13cmos5l_a22oi_1_1.A1 a_96582_95036# vdd sg13_lv_pmos ad=0.3808p pd=2.92u as=0.2716p ps=1.605u w=1.12u l=0.13u
X2958 adc8b_0.side_cap8b_1.buf_4_2.z adc8b_0.sar12b_0.nh_sw[7] vddr vddr sg13_lv_pmos ad=0.19p pd=1.38u as=0.19p ps=1.38u w=1u l=0.13u
X2959 adc8b_0.side_cap8b_1.buf_32_0.z adc8b_0.sar12b_0.nl_sw[0] sg13cmos5l_Corner_1.vss sg13cmos5l_Corner_1.vss sg13_lv_nmos ad=95f pd=0.88u as=95f ps=0.88u w=0.5u l=0.13u
X2960 a_93681_93177# a_93324_93104# vdd vdd sg13_lv_pmos ad=63f pd=0.72u as=0.1563p ps=1.22u w=0.42u l=0.13u
X2961 vdd a_89709_98813# a_89811_98956# vdd sg13_lv_pmos ad=1.15047p pd=7.175u as=0.3864p ps=2.93u w=1.12u l=0.13u
X2962 a_100342_96188# adc8b_0.sar12b_0.sg13cmos5l_dfrbp_1_0.D a_100248_96188# vdd sg13_lv_pmos ad=0.1596p pd=1.22u as=0.2856p ps=2.36u w=0.84u l=0.13u
X2963 sg13cmos5l_Corner_1.iovdd a_99639_164698# sg13cmos5l_IOPadAnalog_15.pad sg13cmos5l_Corner_1.iovdd sg13_hv_pmos ad=2.1312p pd=7.3u as=3.9294p ps=7.84u w=6.66u l=0.6u
X2964 a_71988_94286# adc8b_0.diff_bsw_0.single_bsw_1.sg13cmos5l_inv_1$1_0.A sg13cmos5l_Corner_1.vss sg13cmos5l_Corner_1.vss sg13_lv_nmos ad=95f pd=0.88u as=0.17p ps=1.68u w=0.5u l=0.13u
X2965 vdd a_100727_94375# a_100984_94518# vdd sg13_lv_pmos ad=0.2639p pd=1.81u as=79.8f ps=0.8u w=0.42u l=0.13u
X2966 sg13cmos5l_Corner_1.vss a_96311_94375# a_97148_94596# sg13cmos5l_Corner_1.vss sg13_lv_nmos ad=0.1406p pd=1.12u as=0.2516p ps=2.16u w=0.74u l=0.13u
X2967 sg13cmos5l_Corner_1.iovdd a_115639_164698# sg13cmos5l_IOPadAnalog_13.pad sg13cmos5l_Corner_1.iovdd sg13_hv_pmos ad=3.1302p pd=14.26u as=3.9294p ps=7.84u w=6.66u l=0.6u
X2968 sg13cmos5l_IOPadAnalog_12.padres sg13cmos5l_Corner_1.iovdd dpantenna l=0.64u w=4.98u
X2969 a_90514_99564# a_90957_99607# a_90897_99643# vdd sg13_lv_pmos ad=79.8f pd=0.8u as=63f ps=0.72u w=0.42u l=0.13u
X2970 adc8b_0.sar12b_0.sg13cmos5l_dfrbp_1_0.D adc8b_0.sar12b_0.sg13cmos5l_dfrbp_1_0.Q a_99890_93548# vdd sg13_lv_pmos ad=0.3808p pd=2.92u as=0.1176p ps=1.33u w=1.12u l=0.13u
X2971 sg13cmos5l_Corner_1.vss a_70044_30676# data[0] sg13cmos5l_Corner_1.vss sg13_hv_nmos ad=1.408p pd=5.04u as=2.596p ps=5.58u w=4.4u l=0.6u
X2972 sg13cmos5l_Corner_1.vss a_70044_30676# data[0] sg13cmos5l_Corner_1.vss sg13_hv_nmos ad=2.068p pd=9.74u as=2.596p ps=5.58u w=4.4u l=0.6u
X2973 sg13cmos5l_Corner_1.vss adc8b_0.sar12b_0.nh_sw[4] adc8b_0.side_cap8b_1.buf_8_2.z sg13cmos5l_Corner_1.vss sg13_lv_nmos ad=95f pd=0.88u as=95f ps=0.88u w=0.5u l=0.13u
X2974 sg13cmos5l_Corner_1.iovdd a_42476_102044# vip sg13cmos5l_Corner_1.iovdd sg13_hv_pmos ad=2.1312p pd=7.3u as=3.9294p ps=7.84u w=6.66u l=0.6u
X2975 adc8b_0.side_cap8b_1.buf_16_1.z adc8b_0.sar12b_0.nl_sw[2] vddr vddr sg13_lv_pmos ad=0.19p pd=1.38u as=0.19p ps=1.38u w=1u l=0.13u
X2976 sg13cmos5l_Corner_1.vss sg13cmos5l_IOPadVdd$1_0.sg13cmos5l_Clamp_N43N43D4R$1_0.gate vdd sg13cmos5l_Corner_1.vss sg13_hv_nmos ad=2.068p pd=9.74u as=2.596p ps=5.58u w=4.4u l=0.6u
X2977 sg13cmos5l_IOPadAnalog_11.pad sg13cmos5l_Corner_1.iovdd dpantenna l=27.78u w=1.26u
X2978 adc8b_0.side_cap8b_1.buf_4_0.z adc8b_0.sar12b_0.nl_sw[7] sg13cmos5l_Corner_1.vss sg13cmos5l_Corner_1.vss sg13_lv_nmos ad=95f pd=0.88u as=95f ps=0.88u w=0.5u l=0.13u
X2979 sg13cmos5l_Corner_1.vss adc8b_0.side_cap8b_0.in_h_sw[5] adc8b_0.side_cap8b_0.buf_8_5.z sg13cmos5l_Corner_1.vss sg13_lv_nmos ad=95f pd=0.88u as=0.17p ps=1.68u w=0.5u l=0.13u
X2980 sg13cmos5l_Corner_1.vss adc8b_0.sar12b_0.sg13cmos5l_buf_1_24.A adc8b_0.sar12b_0.sg13cmos5l_buf_1_78.A sg13cmos5l_Corner_1.vss sg13_lv_nmos ad=0.2516p pd=2.16u as=0.2516p ps=2.16u w=0.74u l=0.13u
X2981 sg13cmos5l_IOPadAnalog_0.pad a_164624_86044# sg13cmos5l_Corner_1.iovdd sg13cmos5l_Corner_1.iovdd sg13_hv_pmos ad=3.9294p pd=7.84u as=2.1312p ps=7.3u w=6.66u l=0.6u
X2982 sg13cmos5l_IOPadAnalog_15.pad a_99639_164698# sg13cmos5l_Corner_1.iovdd sg13cmos5l_Corner_1.iovdd sg13_hv_pmos ad=3.9294p pd=7.84u as=2.1312p ps=7.3u w=6.66u l=0.6u
X2983 sg13cmos5l_Corner_1.vss adc8b_0.side_cap8b_0.in_h_sw[1] adc8b_0.side_cap8b_0.buf_16_3.z sg13cmos5l_Corner_1.vss sg13_lv_nmos ad=95f pd=0.88u as=95f ps=0.88u w=0.5u l=0.13u
X2984 sg13cmos5l_Corner_1.iovdd a_134044_42476# frame sg13cmos5l_Corner_1.iovdd sg13_hv_pmos ad=2.1312p pd=7.3u as=3.9294p ps=7.84u w=6.66u l=0.6u
X2985 a_89292_99152# a_89811_98956# a_90551_98911# sg13cmos5l_Corner_1.vss sg13_lv_nmos ad=0.3473p pd=2.71u as=0.12665p ps=1.145u w=0.74u l=0.13u
X2986 vin a_72090_94286# adc8b_0.diff_bsw_0.vcn sg13cmos5l_Corner_1.vss sg13_lv_nmos ad=0.85p pd=5.68u as=0.85p ps=5.68u w=2.5u l=0.13u
X2987 sg13cmos5l_Corner_1.iovdd a_164624_86044# sg13cmos5l_IOPadAnalog_0.pad sg13cmos5l_Corner_1.iovdd sg13_hv_pmos ad=2.1312p pd=7.3u as=3.9294p ps=7.84u w=6.66u l=0.6u
X2988 vddr adc8b_0.side_cap8b_0.in_h_sw[1] adc8b_0.side_cap8b_0.buf_16_3.z vddr sg13_lv_pmos ad=0.19p pd=1.38u as=0.19p ps=1.38u w=1u l=0.13u
X2989 adc8b_0.side_cap8b_0.in_h_sw[2] a_85744_100384# sg13cmos5l_Corner_1.vss sg13cmos5l_Corner_1.vss sg13_lv_nmos ad=0.2886p pd=2.26u as=0.14875p ps=1.16u w=0.74u l=0.13u
X2990 adc8b_0.sar12b_0.sg13cmos5l_a22oi_1_1.B2 adc8b_0.sar12b_0.sg13cmos5l_and3_1_0.X sg13cmos5l_Corner_1.vss sg13cmos5l_Corner_1.vss sg13_lv_nmos ad=0.2516p pd=2.16u as=0.1406p ps=1.12u w=0.74u l=0.13u
X2991 sg13cmos5l_IOPadAnalog_1.pad a_178296_70044# sg13cmos5l_Corner_1.vss sg13cmos5l_Corner_1.vss sg13_hv_nmos ad=2.596p pd=5.58u as=1.408p ps=5.04u w=4.4u l=0.6u
X2992 sg13cmos5l_Corner_1.vss a_173384_129782# dantenna l=1.26u w=27.78u
X2993 adc8b_0.sar12b_0.sg13cmos5l_buf_1_30.X a_90448_92824# sg13cmos5l_Corner_1.vss sg13cmos5l_Corner_1.vss sg13_lv_nmos ad=0.2886p pd=2.26u as=0.14875p ps=1.16u w=0.74u l=0.13u
X2994 adc8b_0.sar12b_0.nl_sw[3] a_86224_92824# vdd vdd sg13_lv_pmos ad=0.42p pd=2.99u as=0.2114p ps=1.54u w=1.12u l=0.13u
X2995 a_84333_99607# adc8b_0.sar12b_0.sg13cmos5l_inv_1_8.A sg13cmos5l_Corner_1.vss sg13cmos5l_Corner_1.vss sg13_lv_nmos ad=0.2516p pd=2.16u as=2.71505p ps=17.54u w=0.74u l=0.13u
X2996 a_98062_98509# adc8b_0.sar12b_0.sg13cmos5l_dfrbp_1_8.RESET_B sg13cmos5l_Corner_1.vss sg13cmos5l_Corner_1.vss sg13_lv_nmos ad=37.8f pd=0.6u as=0.1701p ps=1.65u w=0.42u l=0.13u
X2997 a_82978_95814# adc8b_0.sar12b_0.sg13cmos5l_inv_1_8.Y adc8b_0.sar12b_0.sg13cmos5l_dlygate4sd2_1_0.A sg13cmos5l_Corner_1.vss sg13_lv_nmos ad=0.1406p pd=1.12u as=0.2516p ps=2.16u w=0.74u l=0.13u
X2998 sg13cmos5l_IOPadAnalog_9.pad a_83639_164698# sg13cmos5l_Corner_1.iovdd sg13cmos5l_Corner_1.iovdd sg13_hv_pmos ad=3.9294p pd=7.84u as=2.1312p ps=7.3u w=6.66u l=0.6u
X2999 adc8b_0.sar12b_0.sg13cmos5l_dfrbp_1_21.Q_N a_99287_97399# vdd vdd sg13_lv_pmos ad=0.4312p pd=3.01u as=0.2639p ps=1.81u w=1.12u l=0.13u
X3000 sg13cmos5l_Corner_1.vss adc8b_0.sar12b_0.nl_sw[5] adc8b_0.side_cap8b_1.buf_8_4.z sg13cmos5l_Corner_1.vss sg13_lv_nmos ad=95f pd=0.88u as=95f ps=0.88u w=0.5u l=0.13u
X3001 vddr adc8b_0.sar12b_0.nh_sw[2] adc8b_0.side_cap8b_1.buf_16_0.z vddr sg13_lv_pmos ad=0.19p pd=1.38u as=0.19p ps=1.38u w=1u l=0.13u
X3002 vip a_42476_102044# sg13cmos5l_Corner_1.iovdd sg13cmos5l_Corner_1.iovdd sg13_hv_pmos ad=3.9294p pd=7.84u as=2.1312p ps=7.3u w=6.66u l=0.6u
X3003 a_100796_96572# a_100383_96930# a_100728_96572# vdd sg13_lv_pmos ad=0.191p pd=1.44u as=0.105p ps=1.21u w=1u l=0.13u
X3004 a_89276_93108# a_88863_92802# a_89208_93108# vdd sg13_lv_pmos ad=0.191p pd=1.44u as=0.105p ps=1.21u w=1u l=0.13u
X3005 adc8b_0.side_cap8b_0.buf_8_4.z adc8b_0.side_cap8b_0.in_l_sw[5] sg13cmos5l_Corner_1.vss sg13cmos5l_Corner_1.vss sg13_lv_nmos ad=0.17p pd=1.68u as=95f ps=0.88u w=0.5u l=0.13u
X3006 vdd sg13cmos5l_IOPadVdd$1_0.sg13cmos5l_RCClampInverter$1_0.in sg13cmos5l_IOPadVdd$1_0.sg13cmos5l_Clamp_N43N43D4R$1_0.gate vdd sg13_hv_pmos ad=1.33p pd=7.38u as=1.33p ps=7.38u w=7u l=0.5u
X3007 a_87982_100021# adc8b_0.sar12b_0.sg13cmos5l_dfrbp_1_8.RESET_B sg13cmos5l_Corner_1.vss sg13cmos5l_Corner_1.vss sg13_lv_nmos ad=37.8f pd=0.6u as=0.1701p ps=1.65u w=0.42u l=0.13u
X3008 vdd adc8b_0.sar12b_0.sg13cmos5l_dfrbp_1_0.RESET_B a_96974_93986# vdd sg13_lv_pmos ad=0.36237p pd=2.605u as=79.8f ps=0.8u w=0.42u l=0.13u
X3009 sg13cmos5l_Corner_1.iovdd a_131639_164698# sg13cmos5l_IOPadAnalog_12.pad sg13cmos5l_Corner_1.iovdd sg13_hv_pmos ad=2.1312p pd=7.3u as=3.9294p ps=7.84u w=6.66u l=0.6u
X3010 vdd a_91647_100362# a_91778_100356# vdd sg13_lv_pmos ad=4.11675p pd=27.17u as=0.2856p ps=2.36u w=0.84u l=0.13u
X3011 a_79646_97015# adc8b_0.cmp_0.sg13cmos5l_inv_1$1_1.Y a_79552_97015# vdd sg13_lv_pmos ad=0.1596p pd=1.22u as=0.2856p ps=2.36u w=0.84u l=0.13u
X3012 vdd adc8b_0.sar12b_0.sg13cmos5l_inv_1_8.A adc8b_0.sar12b_0.sg13cmos5l_inv_1_8.Y vdd sg13_lv_pmos ad=0.3808p pd=2.92u as=0.3808p ps=2.92u w=1.12u l=0.13u
X3013 adc8b_0.side_cap8b_1.buf_32_0.z adc8b_0.sar12b_0.nl_sw[0] vddr vddr sg13_lv_pmos ad=0.19p pd=1.38u as=0.19p ps=1.38u w=1u l=0.13u
X3014 vdd a_85809_93905# a_86334_93978# vdd sg13_lv_pmos ad=0.1974p pd=1.5u as=0.2856p ps=2.36u w=0.84u l=0.13u
X3015 sg13cmos5l_Corner_1.vss sg13cmos5l_IOPadVdd$1_0.sg13cmos5l_Clamp_N43N43D4R$1_0.gate vdd sg13cmos5l_Corner_1.vss sg13_hv_nmos ad=1.408p pd=5.04u as=2.596p ps=5.58u w=4.4u l=0.6u
X3016 sg13cmos5l_Corner_1.vss adc8b_0.sar12b_0.sg13cmos5l_inv_1_0.A adc8b_0.sar12b_0.sg13cmos5l_inv_1_0.Y sg13cmos5l_Corner_1.vss sg13_lv_nmos ad=0.2516p pd=2.16u as=0.2516p ps=2.16u w=0.74u l=0.13u
X3017 sg13cmos5l_Corner_1.iovdd a_67639_164698# sg13cmos5l_IOPadAnalog_10.pad sg13cmos5l_Corner_1.iovdd sg13_hv_pmos ad=2.1312p pd=7.3u as=3.9294p ps=7.84u w=6.66u l=0.6u
X3018 adc8b_0.side_cap8b_0.buf_32_0.z adc8b_0.side_cap8b_0.in_l_sw[0] sg13cmos5l_Corner_1.vss sg13cmos5l_Corner_1.vss sg13_lv_nmos ad=95f pd=0.88u as=95f ps=0.88u w=0.5u l=0.13u
X3019 adc8b_0.sar12b_0.sg13cmos5l_dlhr_1_1.Q a_84177_95810# vdd vdd sg13_lv_pmos ad=0.3808p pd=2.92u as=0.2128p ps=1.5u w=1.12u l=0.13u
X3020 adc8b_0.sar12b_0.sg13cmos5l_buf_8_0.X a_100995_95814# vdd vdd sg13_lv_pmos ad=0.2128p pd=1.5u as=0.2128p ps=1.5u w=1.12u l=0.13u
X3021 a_99180_93104# a_99154_93009# sg13cmos5l_Corner_1.vss sg13cmos5l_Corner_1.vss sg13_lv_nmos ad=0.2516p pd=2.16u as=0.1626p ps=1.415u w=0.74u l=0.13u
X3022 sg13cmos5l_Corner_1.iovdd a_83639_164698# sg13cmos5l_IOPadAnalog_9.pad sg13cmos5l_Corner_1.iovdd sg13_hv_pmos ad=3.1302p pd=14.26u as=3.9294p ps=7.84u w=6.66u l=0.6u
X3023 sg13cmos5l_Corner_1.vss a_178296_102044# sg13cmos5l_IOPadAnalog_16.pad sg13cmos5l_Corner_1.vss sg13_hv_nmos ad=1.408p pd=5.04u as=2.596p ps=5.58u w=4.4u l=0.6u
X3024 vddr adc8b_0.side_cap8b_0.in_l_sw[1] adc8b_0.side_cap8b_0.buf_16_2.z vddr sg13_lv_pmos ad=0.19p pd=1.38u as=0.19p ps=1.38u w=1u l=0.13u
X3025 a_86837_96536# a_87567_96659# a_87478_96695# vdd sg13_lv_pmos ad=0.2048p pd=1.63u as=93.45f ps=0.865u w=0.42u l=0.13u
X3026 cks a_42476_118044# sg13cmos5l_Corner_1.iovdd sg13cmos5l_Corner_1.iovdd sg13_hv_pmos ad=3.9294p pd=7.84u as=2.1312p ps=7.3u w=6.66u l=0.6u
X3027 adc8b_0.side_cap8b_0.buf_32_0.z adc8b_0.side_cap8b_0.in_l_sw[0] vddr vddr sg13_lv_pmos ad=0.19p pd=1.38u as=0.19p ps=1.38u w=1u l=0.13u
X3028 adc8b_0.side_cap8b_0.buf_4_1.z adc8b_0.side_cap8b_0.in_h_sw[6] vddr vddr sg13_lv_pmos ad=0.34p pd=2.68u as=0.19p ps=1.38u w=1u l=0.13u
X3029 sg13cmos5l_Corner_1.iovdd a_131639_164698# sg13cmos5l_Corner_1.iovdd rppd l=12.9u w=0.5u
X3030 vddr a_42476_70044# sg13cmos5l_Corner_1.iovdd sg13cmos5l_Corner_1.iovdd sg13_hv_pmos ad=3.9294p pd=7.84u as=2.1312p ps=7.3u w=6.66u l=0.6u
X3031 adc8b_0.sar12b_0.sg13cmos5l_buf_1_65.X a_82192_99596# sg13cmos5l_Corner_1.vss sg13cmos5l_Corner_1.vss sg13_lv_nmos ad=0.2886p pd=2.26u as=0.14875p ps=1.16u w=0.74u l=0.13u
X3032 a_89601_96125# a_88659_95932# a_89399_95887# vdd sg13_lv_pmos ad=93.45f pd=0.865u as=0.2048p ps=1.63u w=0.42u l=0.13u
X3033 sg13cmos5l_IOPadAnalog_16.pad a_164624_102044# sg13cmos5l_Corner_1.iovdd sg13cmos5l_Corner_1.iovdd sg13_hv_pmos ad=3.9294p pd=7.84u as=3.1302p ps=14.26u w=6.66u l=0.6u
X3034 adc8b_0.side_cap8b_1.buf_16_2.z adc8b_0.sar12b_0.nl_sw[1] sg13cmos5l_Corner_1.vss sg13cmos5l_Corner_1.vss sg13_lv_nmos ad=95f pd=0.88u as=95f ps=0.88u w=0.5u l=0.13u
X3035 a_97644_96128# a_97618_96033# sg13cmos5l_Corner_1.vss sg13cmos5l_Corner_1.vss sg13_lv_nmos ad=0.2516p pd=2.16u as=0.1626p ps=1.415u w=0.74u l=0.13u
X3036 sg13cmos5l_Corner_1.iovdd a_70044_42476# data[0] sg13cmos5l_Corner_1.iovdd sg13_hv_pmos ad=2.1312p pd=7.3u as=3.9294p ps=7.84u w=6.66u l=0.6u
X3037 vddr adc8b_0.sar12b_0.nh_sw[0] adc8b_0.side_cap8b_1.buf_32_1.z vddr sg13_lv_pmos ad=0.19p pd=1.38u as=0.19p ps=1.38u w=1u l=0.13u
X3038 sg13cmos5l_IOPadAnalog_10.pad a_67639_164698# sg13cmos5l_Corner_1.iovdd sg13cmos5l_Corner_1.iovdd sg13_hv_pmos ad=3.9294p pd=7.84u as=2.1312p ps=7.3u w=6.66u l=0.6u
X3039 vdd adc8b_0.sar12b_0.sg13cmos5l_inv_1_28.Y a_93232_100384# vdd sg13_lv_pmos ad=0.2114p pd=1.54u as=0.2856p ps=2.36u w=0.84u l=0.13u
X3040 a_90551_98911# a_89709_98813# a_90457_98911# sg13cmos5l_Corner_1.vss sg13_lv_nmos ad=0.12665p pd=1.145u as=0.1428p ps=1.52u w=0.42u l=0.13u
X3041 a_87442_97545# a_87885_97301# a_87182_97322# sg13cmos5l_Corner_1.vss sg13_lv_nmos ad=79.8f pd=0.8u as=0.1296p ps=1.52u w=0.42u l=0.13u
X3042 vdd adc8b_0.sar12b_0.sg13cmos5l_dfrbp_1_8.RESET_B a_83890_95028# vdd sg13_lv_pmos ad=0.1563p pd=1.22u as=0.147p ps=1.54u w=0.42u l=0.13u
X3043 vdd a_82676_92750# adc8b_0.sar12b_0.sg13cmos5l_buf_1_32.X vdd sg13_lv_pmos ad=0.2114p pd=1.54u as=0.42p ps=2.99u w=1.12u l=0.13u
X3044 sg13cmos5l_Corner_1.vss a_99885_94277# a_99987_94420# sg13cmos5l_Corner_1.vss sg13_lv_nmos ad=2.59257p pd=16.445u as=0.2516p ps=2.16u w=0.74u l=0.13u
X3045 sg13cmos5l_IOPadAnalog_13.pad sg13cmos5l_Corner_1.iovdd dpantenna l=1.26u w=27.78u
X3046 vdd a_98903_95887# a_99160_96030# vdd sg13_lv_pmos ad=0.2639p pd=1.81u as=79.8f ps=0.8u w=0.42u l=0.13u
X3047 sg13cmos5l_IOPadAnalog_16.pad a_164624_102044# sg13cmos5l_Corner_1.iovdd sg13cmos5l_Corner_1.iovdd sg13_hv_pmos ad=3.9294p pd=7.84u as=2.1312p ps=7.3u w=6.66u l=0.6u
X3048 vdd sg13cmos5l_IOPadVdd$1_0.sg13cmos5l_RCClampInverter$1_0.in sg13cmos5l_IOPadVdd$1_0.sg13cmos5l_Clamp_N43N43D4R$1_0.gate vdd sg13_hv_pmos ad=1.33p pd=7.38u as=1.33p ps=7.38u w=7u l=0.5u
X3049 adc8b_0.sar12b_0.sg13cmos5l_buf_1_93.X a_96400_100384# sg13cmos5l_Corner_1.vss sg13cmos5l_Corner_1.vss sg13_lv_nmos ad=0.2886p pd=2.26u as=0.14875p ps=1.16u w=0.74u l=0.13u
X3050 sg13cmos5l_Corner_1.vss a_102044_30676# data[2] sg13cmos5l_Corner_1.vss sg13_hv_nmos ad=1.408p pd=5.04u as=2.596p ps=5.58u w=4.4u l=0.6u
X3051 data[1] a_86044_42476# sg13cmos5l_Corner_1.iovdd sg13cmos5l_Corner_1.iovdd sg13_hv_pmos ad=3.9294p pd=7.84u as=3.1302p ps=14.26u w=6.66u l=0.6u
X3052 sg13cmos5l_Corner_1.vss sg13cmos5l_IOPadVdd$1_0.sg13cmos5l_Clamp_N43N43D4R$1_0.gate vdd sg13cmos5l_Corner_1.vss sg13_hv_nmos ad=1.408p pd=5.04u as=2.596p ps=5.58u w=4.4u l=0.6u
X3053 adc8b_0.side_cap8b_0.buf_32_1.z adc8b_0.side_cap8b_0.in_h_sw[0] sg13cmos5l_Corner_1.vss sg13cmos5l_Corner_1.vss sg13_lv_nmos ad=95f pd=0.88u as=95f ps=0.88u w=0.5u l=0.13u
X3054 a_96684_100021# a_96396_99600# a_96622_100021# sg13cmos5l_Corner_1.vss sg13_lv_nmos ad=0.1428p pd=1.52u as=37.8f ps=0.6u w=0.42u l=0.13u
X3055 vdd a_83735_98445# a_84572_98084# vdd sg13_lv_pmos ad=0.2128p pd=1.5u as=0.3864p ps=2.93u w=1.12u l=0.13u
X3056 sg13cmos5l_IOPadAnalog_16.pad a_178296_102044# sg13cmos5l_Corner_1.vss sg13cmos5l_Corner_1.vss sg13_hv_nmos ad=2.596p pd=5.58u as=1.408p ps=5.04u w=4.4u l=0.6u
X3057 a_93324_95064# a_93298_95028# vdd vdd sg13_lv_pmos ad=0.34p pd=2.68u as=0.36237p ps=2.605u w=1u l=0.13u
X3058 vddr adc8b_0.sar12b_0.nl_sw[8] adc8b_0.side_cap8b_1.buf_2_1.z vddr sg13_lv_pmos ad=0.19p pd=1.38u as=0.34p ps=2.68u w=1u l=0.13u
X3059 sg13cmos5l_Corner_1.vss adc8b_0.sar12b_0.nl_sw[0] adc8b_0.side_cap8b_1.buf_32_0.z sg13cmos5l_Corner_1.vss sg13_lv_nmos ad=95f pd=0.88u as=95f ps=0.88u w=0.5u l=0.13u
X3060 sg13cmos5l_IOPadAnalog_15.pad a_99639_164698# sg13cmos5l_Corner_1.iovdd sg13cmos5l_Corner_1.iovdd sg13_hv_pmos ad=3.9294p pd=7.84u as=2.1312p ps=7.3u w=6.66u l=0.6u
X3061 a_73970_98361# adc8b_0.cmp_0.outn adc8b_0.cmp_0.outp sg13cmos5l_Corner_1.vss sg13_lv_nmos ad=1.7p pd=10.68u as=0.95p ps=5.38u w=5u l=0.13u
X3062 sg13cmos5l_IOPadAnalog_13.pad a_115639_164698# sg13cmos5l_Corner_1.iovdd sg13cmos5l_Corner_1.iovdd sg13_hv_pmos ad=3.9294p pd=7.84u as=2.1312p ps=7.3u w=6.66u l=0.6u
X3063 adc8b_0.side_cap8b_0.buf_16_1.z adc8b_0.side_cap8b_0.in_l_sw[2] sg13cmos5l_Corner_1.vss sg13cmos5l_Corner_1.vss sg13_lv_nmos ad=95f pd=0.88u as=95f ps=0.88u w=0.5u l=0.13u
X3064 adc8b_0.sar12b_0.sg13cmos5l_buf_8_2.X a_100995_100350# vdd vdd sg13_lv_pmos ad=0.2128p pd=1.5u as=0.2128p ps=1.5u w=1.12u l=0.13u
X3065 frame sg13cmos5l_Corner_1.iovdd dpantenna l=1.26u w=27.78u
X3066 sg13cmos5l_Corner_1.iovdd a_83639_164698# sg13cmos5l_IOPadAnalog_9.pad sg13cmos5l_Corner_1.iovdd sg13_hv_pmos ad=2.1312p pd=7.3u as=3.9294p ps=7.84u w=6.66u l=0.6u
X3067 a_96697_96974# a_96145_96930# sg13cmos5l_Corner_1.vss sg13cmos5l_Corner_1.vss sg13_lv_nmos ad=71.99999f pd=0.865u as=1.97045p ps=12.335u w=0.64u l=0.13u
X3068 vdd adc8b_0.sar12b_0.sg13cmos5l_nand2_1_2.B adc8b_0.sar12b_0.sg13cmos5l_dlygate4sd2_1_0.A vdd sg13_lv_pmos ad=0.3808p pd=2.92u as=0.2128p ps=1.5u w=1.12u l=0.13u
X3069 vddr adc8b_0.side_cap8b_0.in_h_sw[0] adc8b_0.side_cap8b_0.buf_32_1.z vddr sg13_lv_pmos ad=0.19p pd=1.38u as=0.19p ps=1.38u w=1u l=0.13u
X3070 a_85432_99838# a_85175_99957# a_85594_100034# sg13cmos5l_Corner_1.vss sg13_lv_nmos ad=0.1428p pd=1.52u as=37.8f ps=0.6u w=0.42u l=0.13u
X3071 sg13cmos5l_IOPadAnalog_7.padres data[1] sg13cmos5l_Corner_1.vss rppd l=2u w=1u
X3072 vdd a_89457_92786# a_89390_93224# vdd sg13_lv_pmos ad=0.2387p pd=1.84u as=0.1008p ps=0.9u w=0.42u l=0.13u
X3073 vddr adc8b_0.side_cap8b_0.in_h_sw[3] adc8b_0.side_cap8b_0.buf_8_3.z vddr sg13_lv_pmos ad=0.19p pd=1.38u as=0.19p ps=1.38u w=1u l=0.13u
X3074 sg13cmos5l_Corner_1.vss a_91647_100362# a_91778_100356# sg13cmos5l_Corner_1.vss sg13_lv_nmos ad=2.92392p pd=18.89u as=0.2775p ps=2.23u w=0.74u l=0.13u
X3075 a_99729_99953# a_99548_99596# vdd vdd sg13_lv_pmos ad=0.2128p pd=1.5u as=0.2387p ps=1.84u w=1.12u l=0.13u
X3076 adc8b_0.side_cap8b_0.buf_2_1.z adc8b_0.side_cap8b_0.in_l_sw[8] vddr vddr sg13_lv_pmos ad=0.34p pd=2.68u as=0.19p ps=1.38u w=1u l=0.13u
X3077 sg13cmos5l_Corner_1.vss sg13cmos5l_IOPadVdd$1_0.sg13cmos5l_Clamp_N43N43D4R$1_0.gate vdd sg13cmos5l_Corner_1.vss sg13_hv_nmos ad=1.408p pd=5.04u as=2.596p ps=5.58u w=4.4u l=0.6u
X3078 adc8b_0.sar12b_0.sg13cmos5l_dfrbp_1_7.Q_N a_96311_94375# sg13cmos5l_Corner_1.vss sg13cmos5l_Corner_1.vss sg13_lv_nmos ad=0.2849p pd=2.25u as=0.2516p ps=2.16u w=0.74u l=0.13u
X3079 sg13cmos5l_Corner_1.vss a_30676_102044# vip sg13cmos5l_Corner_1.vss sg13_hv_nmos ad=1.408p pd=5.04u as=2.596p ps=5.58u w=4.4u l=0.6u
X3080 a_92188_96572# adc8b_0.sar12b_0.sg13cmos5l_dfrbp_1_20.Q vdd vdd sg13_lv_pmos ad=0.2128p pd=1.5u as=0.3808p ps=2.92u w=1.12u l=0.13u
X3081 vdd adc8b_0.sar12b_0.sg13cmos5l_dfrbp_1_8.RESET_B a_87854_95810# vdd sg13_lv_pmos ad=0.36237p pd=2.605u as=79.8f ps=0.8u w=0.42u l=0.13u
X3082 vdd a_85175_95421# a_85432_95302# vdd sg13_lv_pmos ad=0.2639p pd=1.81u as=79.8f ps=0.8u w=0.42u l=0.13u
X3083 sg13cmos5l_IOPadAnalog_11.pad a_178296_118044# sg13cmos5l_Corner_1.vss sg13cmos5l_Corner_1.vss sg13_hv_nmos ad=2.596p pd=5.58u as=1.408p ps=5.04u w=4.4u l=0.6u
X3084 vddr a_30676_70044# sg13cmos5l_Corner_1.vss sg13cmos5l_Corner_1.vss sg13_hv_nmos ad=2.596p pd=5.58u as=1.408p ps=5.04u w=4.4u l=0.6u
X3085 sg13cmos5l_Corner_1.vss vdd sg13cmos5l_Corner_1.vss sg13cmos5l_Corner_1.vss sg13_lv_nmos ad=0.1428p pd=1.52u as=0 ps=0 w=0.42u l=1u
X3086 sg13cmos5l_Corner_1.vss adc8b_0.side_cap8b_0.in_h_sw[4] adc8b_0.side_cap8b_0.buf_8_2.z sg13cmos5l_Corner_1.vss sg13_lv_nmos ad=95f pd=0.88u as=95f ps=0.88u w=0.5u l=0.13u
X3087 a_92942_93986# a_93747_93559# a_93202_93516# vdd sg13_lv_pmos ad=0.1428p pd=1.52u as=79.8f ps=0.8u w=0.42u l=0.13u
X3088 sg13cmos5l_Corner_1.vss sg13cmos5l_IOPadVdd$1_0.sg13cmos5l_Clamp_N43N43D4R$1_0.gate vdd sg13cmos5l_Corner_1.vss sg13_hv_nmos ad=1.408p pd=5.04u as=2.596p ps=5.58u w=4.4u l=0.6u
X3089 a_98519_93909# a_97677_93559# a_98425_93909# sg13cmos5l_Corner_1.vss sg13_lv_nmos ad=0.12665p pd=1.145u as=0.1428p ps=1.52u w=0.42u l=0.13u
X3090 adc8b_0.side_cap8b_1.buf_16_0.z adc8b_0.sar12b_0.nh_sw[2] vddr vddr sg13_lv_pmos ad=0.19p pd=1.38u as=0.19p ps=1.38u w=1u l=0.13u
X3091 sg13cmos5l_Corner_1.iovdd a_102044_42476# data[2] sg13cmos5l_Corner_1.iovdd sg13_hv_pmos ad=2.1312p pd=7.3u as=3.9294p ps=7.84u w=6.66u l=0.6u
X3092 a_102044_42476# sg13cmos5l_Corner_1.iovdd sg13cmos5l_Corner_1.iovdd rppd l=12.9u w=0.5u
X3093 sg13cmos5l_IOPadAnalog_9.pad sg13cmos5l_Corner_1.iovdd dpantenna l=1.26u w=27.78u
X3094 adc8b_0.sar12b_0.sg13cmos5l_dlhr_1_15.Q a_100113_98834# sg13cmos5l_Corner_1.vss sg13cmos5l_Corner_1.vss sg13_lv_nmos ad=0.2516p pd=2.16u as=0.1406p ps=1.12u w=0.74u l=0.13u
X3095 adc8b_0.side_cap8b_1.buf_4_2.z adc8b_0.sar12b_0.nh_sw[7] sg13cmos5l_Corner_1.vss sg13cmos5l_Corner_1.vss sg13_lv_nmos ad=0.17p pd=1.68u as=95f ps=0.88u w=0.5u l=0.13u
X3096 adc8b_0.sar12b_0.sg13cmos5l_dlhr_1_20.Q_N a_91998_95792# sg13cmos5l_Corner_1.vss sg13cmos5l_Corner_1.vss sg13_lv_nmos ad=0.2516p pd=2.16u as=0.1491p ps=1.18u w=0.74u l=0.13u
X3097 sg13cmos5l_Corner_1.vss a_98061_95789# a_98163_95932# sg13cmos5l_Corner_1.vss sg13_lv_nmos ad=2.41737p pd=15.64u as=0.2516p ps=2.16u w=0.74u l=0.13u
X3098 adc8b_0.sar12b_0.sg13cmos5l_buf_1_98.A a_95409_98834# sg13cmos5l_Corner_1.vss sg13cmos5l_Corner_1.vss sg13_lv_nmos ad=0.2516p pd=2.16u as=0.1406p ps=1.12u w=0.74u l=0.13u
X3099 sg13cmos5l_Corner_1.vss adc8b_0.side_cap8b_0.in_l_sw[1] adc8b_0.side_cap8b_0.buf_16_2.z sg13cmos5l_Corner_1.vss sg13_lv_nmos ad=95f pd=0.88u as=95f ps=0.88u w=0.5u l=0.13u
X3100 a_98230_95183# a_97972_95498# vdd vdd sg13_lv_pmos ad=93.45f pd=0.865u as=1.43437p ps=9.105u w=0.42u l=0.13u
X3101 sg13cmos5l_Corner_1.vss adc8b_0.sar12b_0.sg13cmos5l_buf_8_1.A a_100131_95430# sg13cmos5l_Corner_1.vss sg13_lv_nmos ad=0.1406p pd=1.12u as=0.2553p ps=2.17u w=0.74u l=0.13u
X3102 a_94840_93006# adc8b_0.sar12b_0.sg13cmos5l_dfrbp_1_0.RESET_B vdd vdd sg13_lv_pmos ad=79.8f pd=0.8u as=1.777p ps=11.395u w=0.42u l=0.13u
X3103 a_94092_97322# adc8b_0.sar12b_0.sg13cmos5l_buf_1_57.X a_93998_97322# sg13cmos5l_Corner_1.vss sg13_lv_nmos ad=60.89999f pd=0.71u as=0.1428p ps=1.52u w=0.42u l=0.13u
X3104 data[2] a_102044_30676# sg13cmos5l_Corner_1.vss sg13cmos5l_Corner_1.vss sg13_hv_nmos ad=2.596p pd=5.58u as=1.408p ps=5.04u w=4.4u l=0.6u
X3105 adc8b_0.sar12b_0.sg13cmos5l_dfrbp_1_25.Q_N a_97655_99957# vdd vdd sg13_lv_pmos ad=0.4312p pd=3.01u as=0.2639p ps=1.81u w=1.12u l=0.13u
X3106 sg13cmos5l_Corner_1.iovdd a_42476_118044# cks sg13cmos5l_Corner_1.iovdd sg13_hv_pmos ad=2.1312p pd=7.3u as=3.9294p ps=7.84u w=6.66u l=0.6u
X3107 adc8b_0.side_cap8b_1.buf_32_1.z adc8b_0.sar12b_0.nh_sw[0] vddr vddr sg13_lv_pmos ad=0.34p pd=2.68u as=0.19p ps=1.38u w=1u l=0.13u
X3108 sg13cmos5l_Corner_1.vss a_98776_93790# a_98425_93909# sg13cmos5l_Corner_1.vss sg13_lv_nmos ad=79.8f pd=0.8u as=0.1428p ps=1.52u w=0.42u l=0.13u
X3109 sg13cmos5l_IOPadAnalog_10.pad a_67639_164698# sg13cmos5l_Corner_1.iovdd sg13cmos5l_Corner_1.iovdd sg13_hv_pmos ad=3.9294p pd=7.84u as=2.1312p ps=7.3u w=6.66u l=0.6u
X3110 vddr adc8b_0.side_cap8b_0.in_l_sw[5] adc8b_0.side_cap8b_0.buf_8_4.z vddr sg13_lv_pmos ad=0.19p pd=1.38u as=0.19p ps=1.38u w=1u l=0.13u
X3111 data[0] sg13cmos5l_Corner_1.iovdd dpantenna l=1.26u w=27.78u
X3112 adc8b_0.side_cap8b_0.buf_8_2.z adc8b_0.side_cap8b_0.in_h_sw[4] vddr vddr sg13_lv_pmos ad=0.34p pd=2.68u as=0.19p ps=1.38u w=1u l=0.13u
X3113 sg13cmos5l_IOPadAnalog_9.pad a_83639_164698# sg13cmos5l_Corner_1.iovdd sg13cmos5l_Corner_1.iovdd sg13_hv_pmos ad=3.9294p pd=7.84u as=2.1312p ps=7.3u w=6.66u l=0.6u
X3114 a_86148_98486# a_85599_98442# a_86012_98084# sg13cmos5l_Corner_1.vss sg13_lv_nmos ad=47.25f pd=0.645u as=0.141p ps=1.17u w=0.42u l=0.13u
X3115 sg13cmos5l_Corner_1.vss a_86193_98441# a_86148_98486# sg13cmos5l_Corner_1.vss sg13_lv_nmos ad=0.1428p pd=1.52u as=47.25f ps=0.645u w=0.42u l=0.13u
X3116 adc8b_0.side_cap8b_0.buf_16_2.z adc8b_0.side_cap8b_0.in_l_sw[1] vddr vddr sg13_lv_pmos ad=0.34p pd=2.68u as=0.19p ps=1.38u w=1u l=0.13u
X3117 a_84351_98870# a_83716_99124# sg13cmos5l_Corner_1.vss sg13cmos5l_Corner_1.vss sg13_lv_nmos ad=47.25f pd=0.645u as=0.1428p ps=1.52u w=0.42u l=0.13u
X3118 a_84116_98784# a_84389_98796# a_84351_98870# sg13cmos5l_Corner_1.vss sg13_lv_nmos ad=0.141p pd=1.17u as=47.25f ps=0.645u w=0.42u l=0.13u
X3119 adc8b_0.sar12b_0.nh_sw[1] a_84592_93548# sg13cmos5l_Corner_1.vss sg13cmos5l_Corner_1.vss sg13_lv_nmos ad=0.2886p pd=2.26u as=0.14875p ps=1.16u w=0.74u l=0.13u
X3120 sg13cmos5l_Corner_1.vss adc8b_0.side_cap8b_0.in_l_sw[6] adc8b_0.side_cap8b_0.buf_4_3.z sg13cmos5l_Corner_1.vss sg13_lv_nmos ad=95f pd=0.88u as=0.17p ps=1.68u w=0.5u l=0.13u
X3121 vdd adc8b_0.sar12b_0.sg13cmos5l_dfrbp_1_6.RESET_B a_89006_98834# vdd sg13_lv_pmos ad=0.36237p pd=2.605u as=79.8f ps=0.8u w=0.42u l=0.13u
X3122 sg13cmos5l_Corner_1.iovdd a_99639_164698# sg13cmos5l_IOPadAnalog_15.pad sg13cmos5l_Corner_1.iovdd sg13_hv_pmos ad=2.1312p pd=7.3u as=3.9294p ps=7.84u w=6.66u l=0.6u
X3123 sg13cmos5l_Corner_1.vss sg13cmos5l_IOPadVdd$1_0.sg13cmos5l_Clamp_N43N43D4R$1_0.gate vdd sg13cmos5l_Corner_1.vss sg13_hv_nmos ad=1.408p pd=5.04u as=3.256p ps=10.28u w=4.4u l=0.6u
X3124 vddr adc8b_0.side_cap8b_0.in_l_sw[10] adc8b_0.side_cap8b_0.buf_1_0.z vddr sg13_lv_pmos ad=0.34p pd=2.68u as=0.34p ps=2.68u w=1u l=0.13u
X3125 sg13cmos5l_Corner_1.iovdd a_115639_164698# sg13cmos5l_IOPadAnalog_13.pad sg13cmos5l_Corner_1.iovdd sg13_hv_pmos ad=2.1312p pd=7.3u as=3.9294p ps=7.84u w=6.66u l=0.6u
X3126 adc8b_0.diff_bsw_0.single_bsw_0.sg13cmos5l_inv_1$1_0.Y adc8b_0.diff_bsw_0.single_bsw_0.sg13cmos5l_inv_1$1_0.A vdd vdd sg13_lv_pmos ad=0.3808p pd=2.92u as=0.3808p ps=2.92u w=1.12u l=0.13u
X3127 vdd adc8b_0.cmp_0.rdy a_82192_99596# vdd sg13_lv_pmos ad=0.2114p pd=1.54u as=0.2856p ps=2.36u w=0.84u l=0.13u
X3128 sg13cmos5l_Corner_1.vss adc8b_0.sar12b_0.sg13cmos5l_dfrbp_1_8.RESET_B a_87564_100034# sg13cmos5l_Corner_1.vss sg13_lv_nmos ad=0.1626p pd=1.415u as=60.89999f ps=0.71u w=0.42u l=0.13u
X3129 sg13cmos5l_Corner_1.iovdd a_42476_118044# cks sg13cmos5l_Corner_1.iovdd sg13_hv_pmos ad=2.1312p pd=7.3u as=3.9294p ps=7.84u w=6.66u l=0.6u
X3130 sg13cmos5l_Corner_1.vss a_83735_98445# a_84572_98084# sg13cmos5l_Corner_1.vss sg13_lv_nmos ad=0.1406p pd=1.12u as=0.2516p ps=2.16u w=0.74u l=0.13u
X3131 adc8b_0.side_cap8b_1.buf_32_1.z adc8b_0.sar12b_0.nh_sw[0] vddr vddr sg13_lv_pmos ad=0.19p pd=1.38u as=0.19p ps=1.38u w=1u l=0.13u
X3132 vdd a_97912_99838# a_97857_99719# vdd sg13_lv_pmos ad=1.15047p pd=7.175u as=93.45f ps=0.865u w=0.42u l=0.13u
X3133 a_91988_94262# adc8b_0.sar12b_0.sg13cmos5l_buf_1_28.X vdd vdd sg13_lv_pmos ad=0.2856p pd=2.36u as=0.2114p ps=1.54u w=0.84u l=0.13u
X3134 a_93162_96108# adc8b_0.sar12b_0.sg13cmos5l_a221oi_1_0.B2 a_92950_96108# vdd sg13_lv_pmos ad=0.2128p pd=1.5u as=0.2128p ps=1.5u w=1.12u l=0.13u
X3135 vdd adc8b_0.sar12b_0.sg13cmos5l_dfrbp_1_6.RESET_B a_87538_95028# vdd sg13_lv_pmos ad=0.1563p pd=1.22u as=0.147p ps=1.54u w=0.42u l=0.13u
X3136 sg13cmos5l_Corner_1.iovdd a_102044_42476# data[2] sg13cmos5l_Corner_1.iovdd sg13_hv_pmos ad=2.1312p pd=7.3u as=3.9294p ps=7.84u w=6.66u l=0.6u
X3137 sg13cmos5l_IOPadAnalog_15.pad a_99639_164698# sg13cmos5l_Corner_1.iovdd sg13cmos5l_Corner_1.iovdd sg13_hv_pmos ad=3.9294p pd=7.84u as=3.1302p ps=14.26u w=6.66u l=0.6u
X3138 vdd a_85437_97480# a_84516_97286# vdd sg13_lv_pmos ad=0.36237p pd=2.605u as=0.34p ps=2.68u w=1u l=0.13u
X3139 vdd sg13cmos5l_Corner_1.vss vdd vdd sg13_lv_pmos ad=0.34p pd=2.68u as=0 ps=0 w=1u l=1u
X3140 sg13cmos5l_IOPadAnalog_16.pad sg13cmos5l_Corner_1.iovdd dpantenna l=27.78u w=1.26u
X3141 sg13cmos5l_Corner_1.vss adc8b_0.sar12b_0.nh_sw[1] adc8b_0.side_cap8b_1.buf_16_3.z sg13cmos5l_Corner_1.vss sg13_lv_nmos ad=95f pd=0.88u as=95f ps=0.88u w=0.5u l=0.13u
X3142 sg13cmos5l_Corner_1.vss adc8b_0.side_cap8b_0.in_h_sw[0] adc8b_0.side_cap8b_0.buf_32_1.z sg13cmos5l_Corner_1.vss sg13_lv_nmos ad=95f pd=0.88u as=0.17p ps=1.68u w=0.5u l=0.13u
X3143 vdd adc8b_0.sar12b_0.sg13cmos5l_inv_1_8.A a_87719_96543# vdd sg13_lv_pmos ad=1.2517p pd=7.955u as=0.4088p ps=2.97u w=1.12u l=0.13u
X3144 a_84465_94689# a_84108_94616# vdd vdd sg13_lv_pmos ad=63f pd=0.72u as=0.1563p ps=1.22u w=0.42u l=0.13u
X3145 sg13cmos5l_Corner_1.vss a_99519_98850# a_99650_98844# sg13cmos5l_Corner_1.vss sg13_lv_nmos ad=1.49685p pd=9.6u as=0.2775p ps=2.23u w=0.74u l=0.13u
X3146 a_82764_98509# a_82995_98095# a_82450_98052# sg13cmos5l_Corner_1.vss sg13_lv_nmos ad=0.2373p pd=1.97u as=79.8f ps=0.8u w=0.42u l=0.13u
X3147 vdd sg13cmos5l_IOPadVdd$1_0.sg13cmos5l_Clamp_N43N43D4R$1_0.gate sg13cmos5l_Corner_1.vss sg13cmos5l_Corner_1.vss sg13_hv_nmos ad=2.596p pd=5.58u as=1.408p ps=5.04u w=4.4u l=0.6u
X3148 sg13cmos5l_Corner_1.iovdd a_134044_42476# frame sg13cmos5l_Corner_1.iovdd sg13_hv_pmos ad=2.1312p pd=7.3u as=3.9294p ps=7.84u w=6.66u l=0.6u
X3149 sg13cmos5l_IOPadAnalog_1.pad a_164624_70044# sg13cmos5l_Corner_1.iovdd sg13cmos5l_Corner_1.iovdd sg13_hv_pmos ad=3.9294p pd=7.84u as=2.1312p ps=7.3u w=6.66u l=0.6u
X3150 sg13cmos5l_Corner_1.vss a_115639_178370# sg13cmos5l_IOPadAnalog_13.pad sg13cmos5l_Corner_1.vss sg13_hv_nmos ad=1.408p pd=5.04u as=2.596p ps=5.58u w=4.4u l=0.6u
X3151 vdd sg13cmos5l_Corner_1.vss vdd vdd sg13_lv_pmos ad=0.34p pd=2.68u as=0 ps=0 w=1u l=1u
X3152 sg13cmos5l_Corner_1.iovdd a_164624_70044# sg13cmos5l_IOPadAnalog_1.pad sg13cmos5l_Corner_1.iovdd sg13_hv_pmos ad=2.1312p pd=7.3u as=3.9294p ps=7.84u w=6.66u l=0.6u
X3153 sg13cmos5l_Corner_1.vss adc8b_0.sar12b_0.nh_sw[4] adc8b_0.side_cap8b_1.buf_8_2.z sg13cmos5l_Corner_1.vss sg13_lv_nmos ad=95f pd=0.88u as=95f ps=0.88u w=0.5u l=0.13u
X3154 a_95340_94311# a_95571_94420# a_95026_94521# sg13cmos5l_Corner_1.vss sg13_lv_nmos ad=0.2373p pd=1.97u as=79.8f ps=0.8u w=0.42u l=0.13u
X3155 sg13cmos5l_Corner_1.vss a_178296_118044# sg13cmos5l_IOPadAnalog_11.pad sg13cmos5l_Corner_1.vss sg13_hv_nmos ad=1.408p pd=5.04u as=2.596p ps=5.58u w=4.4u l=0.6u
X3156 adc8b_0.side_cap8b_0.buf_32_1.z adc8b_0.side_cap8b_0.in_h_sw[0] vddr vddr sg13_lv_pmos ad=0.19p pd=1.38u as=0.19p ps=1.38u w=1u l=0.13u
X3157 vdd adc8b_0.sar12b_0.sg13cmos5l_dfrbp_1_20.Q_N a_91441_100400# vdd sg13_lv_pmos ad=4.11675p pd=27.17u as=0.2856p ps=2.36u w=0.84u l=0.13u
X3158 sg13cmos5l_Corner_1.vss adc8b_0.sar12b_0.sg13cmos5l_or2_1_1.B a_93984_96888# sg13cmos5l_Corner_1.vss sg13_lv_nmos ad=0.187p pd=1.78u as=0.1045p ps=0.93u w=0.55u l=0.13u
X3159 frame a_134044_30676# sg13cmos5l_Corner_1.vss sg13cmos5l_Corner_1.vss sg13_hv_nmos ad=2.596p pd=5.58u as=1.408p ps=5.04u w=4.4u l=0.6u
X3160 adc8b_0.side_cap8b_1.buf_4_0.z adc8b_0.sar12b_0.nl_sw[7] sg13cmos5l_Corner_1.vss sg13cmos5l_Corner_1.vss sg13_lv_nmos ad=0.17p pd=1.68u as=95f ps=0.88u w=0.5u l=0.13u
X3161 a_99261_95107# adc8b_0.sar12b_0.sg13cmos5l_dfrbp_1_6.RESET_B vdd vdd sg13_lv_pmos ad=0.147p pd=1.54u as=0.1563p ps=1.22u w=0.42u l=0.13u
X3162 adc8b_0.side_cap8b_1.buf_32_1.z adc8b_0.sar12b_0.nh_sw[0] sg13cmos5l_Corner_1.vss sg13cmos5l_Corner_1.vss sg13_lv_nmos ad=95f pd=0.88u as=95f ps=0.88u w=0.5u l=0.13u
X3163 vdd adc8b_0.sar12b_0.sg13cmos5l_dfrbp_1_6.RESET_B a_86193_98441# vdd sg13_lv_pmos ad=0.2128p pd=1.5u as=0.2128p ps=1.5u w=1.12u l=0.13u
X3164 a_90180_98486# a_89631_98442# a_90044_98084# sg13cmos5l_Corner_1.vss sg13_lv_nmos ad=47.25f pd=0.645u as=0.141p ps=1.17u w=0.42u l=0.13u
X3165 sg13cmos5l_Corner_1.vss adc8b_0.side_cap8b_0.in_h_sw[1] adc8b_0.side_cap8b_0.buf_16_3.z sg13cmos5l_Corner_1.vss sg13_lv_nmos ad=95f pd=0.88u as=95f ps=0.88u w=0.5u l=0.13u
X3166 vdd adc8b_0.sar12b_0.sg13cmos5l_dfrbp_1_8.RESET_B a_93874_100569# vdd sg13_lv_pmos ad=0.1563p pd=1.22u as=0.147p ps=1.54u w=0.42u l=0.13u
X3167 sg13cmos5l_Corner_1.vss adc8b_0.sar12b_0.sg13cmos5l_inv_1_18.A adc8b_0.sar12b_0.sg13cmos5l_buf_1_28.A sg13cmos5l_Corner_1.vss sg13_lv_nmos ad=0.2516p pd=2.16u as=0.2516p ps=2.16u w=0.74u l=0.13u
X3168 vdd a_98253_98095# a_98355_98095# vdd sg13_lv_pmos ad=1.07253p pd=6.75u as=0.3864p ps=2.93u w=1.12u l=0.13u
X3169 data[1] a_86044_42476# sg13cmos5l_Corner_1.iovdd sg13cmos5l_Corner_1.iovdd sg13_hv_pmos ad=3.9294p pd=7.84u as=2.1312p ps=7.3u w=6.66u l=0.6u
X3170 vdd sg13cmos5l_Corner_1.vss vdd vdd sg13_lv_pmos ad=0.34p pd=2.68u as=0 ps=0 w=1u l=1u
X3171 sg13cmos5l_Corner_1.iovdd a_67639_164698# sg13cmos5l_IOPadAnalog_10.pad sg13cmos5l_Corner_1.iovdd sg13_hv_pmos ad=2.1312p pd=7.3u as=3.9294p ps=7.84u w=6.66u l=0.6u
X3172 vdd adc8b_0.sar12b_0.sg13cmos5l_dfrbp_1_6.RESET_B a_86962_93516# vdd sg13_lv_pmos ad=0.1563p pd=1.22u as=0.147p ps=1.54u w=0.42u l=0.13u
X3173 sg13cmos5l_Corner_1.iovdd a_83639_164698# sg13cmos5l_IOPadAnalog_9.pad sg13cmos5l_Corner_1.iovdd sg13_hv_pmos ad=2.1312p pd=7.3u as=3.9294p ps=7.84u w=6.66u l=0.6u
X3174 adc8b_0.sar12b_0.sg13cmos5l_buf_1_86.A a_101776_99596# sg13cmos5l_Corner_1.vss sg13cmos5l_Corner_1.vss sg13_lv_nmos ad=0.2886p pd=2.26u as=0.14875p ps=1.16u w=0.74u l=0.13u
X3175 a_85599_98442# adc8b_0.sar12b_0.sg13cmos5l_dfrbp_1_15.D sg13cmos5l_Corner_1.vss sg13cmos5l_Corner_1.vss sg13_lv_nmos ad=0.2516p pd=2.16u as=0.15055p ps=1.17u w=0.74u l=0.13u
X3176 a_94929_98441# a_94748_98084# vdd vdd sg13_lv_pmos ad=0.2128p pd=1.5u as=0.2387p ps=1.84u w=1.12u l=0.13u
X3177 sg13cmos5l_Corner_1.vss adc8b_0.sar12b_0.sg13cmos5l_dlhr_1_6.D a_90001_97376# sg13cmos5l_Corner_1.vss sg13_lv_nmos ad=0.15055p pd=1.17u as=0.187p ps=1.78u w=0.55u l=0.13u
X3178 a_87314_97010# a_86837_96536# a_87220_97010# sg13cmos5l_Corner_1.vss sg13_lv_nmos ad=37.8f pd=0.6u as=0.1428p ps=1.52u w=0.42u l=0.13u
X3179 vddr adc8b_0.sar12b_0.nh_sw[2] adc8b_0.side_cap8b_1.buf_16_0.z vddr sg13_lv_pmos ad=0.19p pd=1.38u as=0.19p ps=1.38u w=1u l=0.13u
X3180 adc8b_0.sar12b_0.nh_sw[2] a_85456_92824# sg13cmos5l_Corner_1.vss sg13cmos5l_Corner_1.vss sg13_lv_nmos ad=0.2886p pd=2.26u as=0.14875p ps=1.16u w=0.74u l=0.13u
X3181 sg13cmos5l_IOPadAnalog_1.pad a_164624_70044# sg13cmos5l_Corner_1.iovdd sg13cmos5l_Corner_1.iovdd sg13_hv_pmos ad=3.9294p pd=7.84u as=2.1312p ps=7.3u w=6.66u l=0.6u
X3182 a_90356_93512# adc8b_0.sar12b_0.sg13cmos5l_buf_1_26.X sg13cmos5l_Corner_1.vss sg13cmos5l_Corner_1.vss sg13_lv_nmos ad=0.187p pd=1.78u as=0.14875p ps=1.16u w=0.55u l=0.13u
X3183 sg13cmos5l_IOPadAnalog_16.pad a_164624_102044# sg13cmos5l_Corner_1.iovdd sg13cmos5l_Corner_1.iovdd sg13_hv_pmos ad=3.9294p pd=7.84u as=2.1312p ps=7.3u w=6.66u l=0.6u
X3184 vdd adc8b_0.sar12b_0.sg13cmos5l_dfrbp_1_6.RESET_B a_100977_96929# vdd sg13_lv_pmos ad=0.2128p pd=1.5u as=0.2128p ps=1.5u w=1.12u l=0.13u
X3185 adc8b_0.side_cap8b_1.buf_16_1.z adc8b_0.sar12b_0.nl_sw[2] sg13cmos5l_Corner_1.vss sg13cmos5l_Corner_1.vss sg13_lv_nmos ad=95f pd=0.88u as=95f ps=0.88u w=0.5u l=0.13u
X3186 vip a_30676_102044# sg13cmos5l_Corner_1.vss sg13cmos5l_Corner_1.vss sg13_hv_nmos ad=2.596p pd=5.58u as=1.408p ps=5.04u w=4.4u l=0.6u
X3187 adc8b_0.sar12b_0.sg13cmos5l_inv_1_3.A a_95536_99596# sg13cmos5l_Corner_1.vss sg13cmos5l_Corner_1.vss sg13_lv_nmos ad=0.2886p pd=2.26u as=0.14875p ps=1.16u w=0.74u l=0.13u
X3188 vdd adc8b_0.sar12b_0.sg13cmos5l_dfrbp_1_6.RESET_B a_96754_99057# vdd sg13_lv_pmos ad=0.1563p pd=1.22u as=0.147p ps=1.54u w=0.42u l=0.13u
X3189 sg13cmos5l_IOPadAnalog_10.pad a_67639_164698# sg13cmos5l_Corner_1.iovdd sg13cmos5l_Corner_1.iovdd sg13_hv_pmos ad=3.9294p pd=7.84u as=3.1302p ps=14.26u w=6.66u l=0.6u
X3190 sg13cmos5l_IOPadAnalog_15.pad a_99639_178370# sg13cmos5l_Corner_1.vss sg13cmos5l_Corner_1.vss sg13_hv_nmos ad=2.596p pd=5.58u as=1.408p ps=5.04u w=4.4u l=0.6u
X3191 sg13cmos5l_Corner_1.iovdd a_70044_42476# data[0] sg13cmos5l_Corner_1.iovdd sg13_hv_pmos ad=2.1312p pd=7.3u as=3.9294p ps=7.84u w=6.66u l=0.6u
X3192 adc8b_0.side_cap8b_1.buf_32_0.z adc8b_0.sar12b_0.nl_sw[0] vddr vddr sg13_lv_pmos ad=0.19p pd=1.38u as=0.19p ps=1.38u w=1u l=0.13u
X3193 sg13cmos5l_Corner_1.vss adc8b_0.side_cap8b_0.in_l_sw[4] adc8b_0.side_cap8b_0.buf_8_0.z sg13cmos5l_Corner_1.vss sg13_lv_nmos ad=95f pd=0.88u as=0.17p ps=1.68u w=0.5u l=0.13u
X3194 adc8b_0.cmp_0.outn adc8b_0.cmp_0.outp a_76796_95659# sg13cmos5l_Corner_1.vss sg13_lv_nmos ad=0.95p pd=5.38u as=1.7p ps=10.68u w=5u l=0.13u
X3195 adc8b_0.side_cap8b_1.buf_8_1.z adc8b_0.sar12b_0.nl_sw[3] sg13cmos5l_Corner_1.vss sg13cmos5l_Corner_1.vss sg13_lv_nmos ad=95f pd=0.88u as=95f ps=0.88u w=0.5u l=0.13u
X3196 a_100383_96930# adc8b_0.sar12b_0.sg13cmos5l_dfrbp_1_8.D sg13cmos5l_Corner_1.vss sg13cmos5l_Corner_1.vss sg13_lv_nmos ad=0.2516p pd=2.16u as=0.15055p ps=1.17u w=0.74u l=0.13u
X3197 a_87956_92750# adc8b_0.sar12b_0.sg13cmos5l_buf_1_25.A sg13cmos5l_Corner_1.vss sg13cmos5l_Corner_1.vss sg13_lv_nmos ad=0.187p pd=1.78u as=0.14875p ps=1.16u w=0.55u l=0.13u
X3198 adc8b_0.sar12b_0.sg13cmos5l_dlhr_1_0.D a_89084_93548# vdd vdd sg13_lv_pmos ad=0.3808p pd=2.92u as=0.2128p ps=1.5u w=1.12u l=0.13u
X3199 sg13cmos5l_Corner_1.vss a_83639_178370# sg13cmos5l_IOPadAnalog_9.pad sg13cmos5l_Corner_1.vss sg13_hv_nmos ad=1.408p pd=5.04u as=2.596p ps=5.58u w=4.4u l=0.6u
X3200 sg13cmos5l_Corner_1.vss adc8b_0.side_cap8b_0.in_l_sw[0] adc8b_0.side_cap8b_0.buf_32_0.z sg13cmos5l_Corner_1.vss sg13_lv_nmos ad=95f pd=0.88u as=95f ps=0.88u w=0.5u l=0.13u
X3201 a_83170_95024# adc8b_0.sar12b_0.sg13cmos5l_dlygate4sd2_1_0.X vdd vdd sg13_lv_pmos ad=0.1428p pd=1.52u as=0.1523p ps=1.38u w=0.42u l=0.13u
X3202 a_93612_95485# a_93324_95064# a_93550_95485# sg13cmos5l_Corner_1.vss sg13_lv_nmos ad=0.1428p pd=1.52u as=37.8f ps=0.6u w=0.42u l=0.13u
X3203 adc8b_0.sar12b_0.sg13cmos5l_buf_1_44.A a_87441_94298# sg13cmos5l_Corner_1.vss sg13cmos5l_Corner_1.vss sg13_lv_nmos ad=0.2516p pd=2.16u as=0.1406p ps=1.12u w=0.74u l=0.13u
X3204 sg13cmos5l_Corner_1.iovdd a_99639_164698# sg13cmos5l_IOPadAnalog_15.pad sg13cmos5l_Corner_1.iovdd sg13_hv_pmos ad=2.1312p pd=7.3u as=3.9294p ps=7.84u w=6.66u l=0.6u
X3205 vdd adc8b_0.sar12b_0.sg13cmos5l_dfrbp_1_8.RESET_B a_93614_100346# vdd sg13_lv_pmos ad=0.36237p pd=2.605u as=79.8f ps=0.8u w=0.42u l=0.13u
X3206 a_91224_96132# a_90673_95864# vdd vdd sg13_lv_pmos ad=0.105p pd=1.21u as=1.28962p ps=8.195u w=1u l=0.13u
X3207 vdd adc8b_0.sar12b_0.sg13cmos5l_buf_1_41.X a_84592_93548# vdd sg13_lv_pmos ad=0.2114p pd=1.54u as=0.2856p ps=2.36u w=0.84u l=0.13u
X3208 vdd sg13cmos5l_IOPadVdd$1_0.sg13cmos5l_RCClampInverter$1_0.in sg13cmos5l_IOPadVdd$1_0.sg13cmos5l_Clamp_N43N43D4R$1_0.gate vdd sg13_hv_pmos ad=1.33p pd=7.38u as=1.33p ps=7.38u w=7u l=0.5u
X3209 vddr adc8b_0.side_cap8b_0.in_l_sw[1] adc8b_0.side_cap8b_0.buf_16_2.z vddr sg13_lv_pmos ad=0.19p pd=1.38u as=0.19p ps=1.38u w=1u l=0.13u
X3210 a_92180_97286# adc8b_0.sar12b_0.sg13cmos5l_dlhr_1_5.Q sg13cmos5l_Corner_1.vss sg13cmos5l_Corner_1.vss sg13_lv_nmos ad=0.187p pd=1.78u as=0.14875p ps=1.16u w=0.55u l=0.13u
X3211 data[0] a_70044_30676# sg13cmos5l_Corner_1.vss sg13cmos5l_Corner_1.vss sg13_hv_nmos ad=2.596p pd=5.58u as=1.408p ps=5.04u w=4.4u l=0.6u
X3212 sg13cmos5l_IOPadAnalog_0.pad a_164624_86044# sg13cmos5l_Corner_1.iovdd sg13cmos5l_Corner_1.iovdd sg13_hv_pmos ad=3.9294p pd=7.84u as=2.1312p ps=7.3u w=6.66u l=0.6u
X3213 sg13cmos5l_IOPadAnalog_11.pad a_164624_118044# sg13cmos5l_Corner_1.iovdd sg13cmos5l_Corner_1.iovdd sg13_hv_pmos ad=3.9294p pd=7.84u as=2.1312p ps=7.3u w=6.66u l=0.6u
X3214 vddr adc8b_0.sar12b_0.nl_sw[3] adc8b_0.side_cap8b_1.buf_8_1.z vddr sg13_lv_pmos ad=0.19p pd=1.38u as=0.34p ps=2.68u w=1u l=0.13u
X3215 adc8b_0.side_cap8b_1.buf_16_2.z adc8b_0.sar12b_0.nl_sw[1] sg13cmos5l_Corner_1.vss sg13cmos5l_Corner_1.vss sg13_lv_nmos ad=95f pd=0.88u as=95f ps=0.88u w=0.5u l=0.13u
X3216 adc8b_0.sar12b_0.sg13cmos5l_buf_1_18.X a_100144_93548# vdd vdd sg13_lv_pmos ad=0.42p pd=2.99u as=0.2114p ps=1.54u w=1.12u l=0.13u
X3217 a_97742_97322# adc8b_0.sar12b_0.sg13cmos5l_buf_1_57.X vdd vdd sg13_lv_pmos ad=79.8f pd=0.8u as=0.1428p ps=1.52u w=0.42u l=0.13u
X3218 vddr adc8b_0.sar12b_0.nh_sw[5] adc8b_0.side_cap8b_1.buf_8_5.z vddr sg13_lv_pmos ad=0.19p pd=1.38u as=0.19p ps=1.38u w=1u l=0.13u
X3219 a_88863_92802# adc8b_0.sar12b_0.sg13cmos5l_dlhr_1_0.GATE vdd vdd sg13_lv_pmos ad=0.3234p pd=2.45u as=1.777p ps=11.395u w=0.84u l=0.13u
X3220 vdd sg13cmos5l_IOPadVdd$1_0.sg13cmos5l_RCClampInverter$1_0.in sg13cmos5l_IOPadVdd$1_0.sg13cmos5l_Clamp_N43N43D4R$1_0.gate vdd sg13_hv_pmos ad=1.33p pd=7.38u as=1.33p ps=7.38u w=7u l=0.5u
X3221 sg13cmos5l_Corner_1.vss a_94929_98441# a_95454_98514# sg13cmos5l_Corner_1.vss sg13_lv_nmos ad=0.1491p pd=1.18u as=0.187p ps=1.78u w=0.55u l=0.13u
X3222 sg13cmos5l_Corner_1.vss vdd sg13cmos5l_Corner_1.vss sg13cmos5l_Corner_1.vss sg13_lv_nmos ad=0.1428p pd=1.52u as=0 ps=0 w=0.42u l=1u
X3223 a_164624_70044# sg13cmos5l_Corner_1.iovdd sg13cmos5l_Corner_1.iovdd rppd l=12.9u w=0.5u
X3224 vddr adc8b_0.sar12b_0.nh_sw[0] adc8b_0.side_cap8b_1.buf_32_1.z vddr sg13_lv_pmos ad=0.19p pd=1.38u as=0.19p ps=1.38u w=1u l=0.13u
X3225 vdd adc8b_0.sar12b_0.sg13cmos5l_buf_1_5.A a_96208_92824# vdd sg13_lv_pmos ad=0.2114p pd=1.54u as=0.2856p ps=2.36u w=0.84u l=0.13u
X3226 adc8b_0.sar12b_0.sg13cmos5l_nor2b_1_1.Y a_96022_93604# sg13cmos5l_Corner_1.vss sg13cmos5l_Corner_1.vss sg13_lv_nmos ad=0.1406p pd=1.12u as=0.17255p ps=1.25u w=0.74u l=0.13u
X3227 sg13cmos5l_Corner_1.vss a_88247_93909# a_89084_93548# sg13cmos5l_Corner_1.vss sg13_lv_nmos ad=0.1406p pd=1.12u as=0.2516p ps=2.16u w=0.74u l=0.13u
X3228 a_98903_95887# a_98061_95789# a_98809_95887# sg13cmos5l_Corner_1.vss sg13_lv_nmos ad=0.12665p pd=1.145u as=0.1428p ps=1.52u w=0.42u l=0.13u
X3229 adc8b_0.sar12b_0.sg13cmos5l_dlhr_1_11.GATE a_92636_99596# vdd vdd sg13_lv_pmos ad=0.3808p pd=2.92u as=0.2128p ps=1.5u w=1.12u l=0.13u
X3230 frame a_134044_42476# sg13cmos5l_Corner_1.iovdd sg13cmos5l_Corner_1.iovdd sg13_hv_pmos ad=3.9294p pd=7.84u as=3.1302p ps=14.26u w=6.66u l=0.6u
X3231 sg13cmos5l_Corner_1.vss sg13cmos5l_IOPadVdd$1_0.sg13cmos5l_Clamp_N43N43D4R$1_0.gate vdd sg13cmos5l_Corner_1.vss sg13_hv_nmos ad=1.408p pd=5.04u as=2.596p ps=5.58u w=4.4u l=0.6u
X3232 sg13cmos5l_Corner_1.vss a_175886_118222# dantenna l=27.78u w=1.26u
X3233 a_71988_99614# adc8b_0.diff_bsw_0.single_bsw_0.sg13cmos5l_inv_1$1_0.A sg13cmos5l_Corner_1.vss sg13cmos5l_Corner_1.vss sg13_lv_nmos ad=95f pd=0.88u as=0.17p ps=1.68u w=0.5u l=0.13u
X3234 a_87730_99564# a_88173_99607# a_88113_99643# vdd sg13_lv_pmos ad=79.8f pd=0.8u as=63f ps=0.72u w=0.42u l=0.13u
X3235 vddr adc8b_0.sar12b_0.nl_sw[1] adc8b_0.side_cap8b_1.buf_16_2.z vddr sg13_lv_pmos ad=0.19p pd=1.38u as=0.19p ps=1.38u w=1u l=0.13u
X3236 adc8b_0.side_cap8b_0.buf_8_3.z adc8b_0.side_cap8b_0.in_h_sw[3] sg13cmos5l_Corner_1.vss sg13cmos5l_Corner_1.vss sg13_lv_nmos ad=0.17p pd=1.68u as=95f ps=0.88u w=0.5u l=0.13u
X3237 sg13cmos5l_Corner_1.vss a_85342_99010# adc8b_0.sar12b_0.sg13cmos5l_dlhr_1_9.Q_N sg13cmos5l_Corner_1.vss sg13_lv_nmos ad=0.1491p pd=1.18u as=0.2516p ps=2.16u w=0.74u l=0.13u
X3238 a_90551_98911# a_89709_98813# a_89292_99152# vdd sg13_lv_pmos ad=0.2048p pd=1.63u as=0.34p ps=2.68u w=1u l=0.13u
X3239 adc8b_0.side_cap8b_1.buf_16_3.z adc8b_0.sar12b_0.nh_sw[1] sg13cmos5l_Corner_1.vss sg13cmos5l_Corner_1.vss sg13_lv_nmos ad=95f pd=0.88u as=95f ps=0.88u w=0.5u l=0.13u
X3240 adc8b_0.sar12b_0.sg13cmos5l_dfrbp_1_10.Q_N a_85367_94375# sg13cmos5l_Corner_1.vss sg13cmos5l_Corner_1.vss sg13_lv_nmos ad=0.2849p pd=2.25u as=0.2516p ps=2.16u w=0.74u l=0.13u
X3241 sg13cmos5l_Corner_1.vss adc8b_0.sar12b_0.nl_sw[0] adc8b_0.side_cap8b_1.buf_32_0.z sg13cmos5l_Corner_1.vss sg13_lv_nmos ad=95f pd=0.88u as=95f ps=0.88u w=0.5u l=0.13u
X3242 a_83928_96132# a_83377_95864# vdd vdd sg13_lv_pmos ad=0.105p pd=1.21u as=1.28962p ps=8.195u w=1u l=0.13u
X3243 adc8b_0.side_cap8b_1.buf_8_3.z adc8b_0.sar12b_0.nh_sw[3] vddr vddr sg13_lv_pmos ad=0.34p pd=2.68u as=0.19p ps=1.38u w=1u l=0.13u
X3244 a_99182_94298# a_99987_94420# a_99442_94521# vdd sg13_lv_pmos ad=0.1428p pd=1.52u as=79.8f ps=0.8u w=0.42u l=0.13u
X3245 sg13cmos5l_Corner_1.vss a_91799_99957# a_92636_99596# sg13cmos5l_Corner_1.vss sg13_lv_nmos ad=0.1406p pd=1.12u as=0.2516p ps=2.16u w=0.74u l=0.13u
X3246 sg13cmos5l_Corner_1.vss a_32962_118222# dantenna l=27.78u w=1.26u
X3247 adc8b_0.cmp_0.rdy a_80806_96705# vdd vdd sg13_lv_pmos ad=0.4256p pd=3u as=0.2254p ps=1.53u w=1.12u l=0.13u
X3248 vin a_42476_86044# sg13cmos5l_Corner_1.iovdd sg13cmos5l_Corner_1.iovdd sg13_hv_pmos ad=3.9294p pd=7.84u as=2.1312p ps=7.3u w=6.66u l=0.6u
X3249 vddr adc8b_0.side_cap8b_0.in_h_sw[0] adc8b_0.side_cap8b_0.buf_32_1.z vddr sg13_lv_pmos ad=0.19p pd=1.38u as=0.19p ps=1.38u w=1u l=0.13u
X3250 a_83822_94298# adc8b_0.sar12b_0.sg13cmos5l_dfrbp_1_6.D vdd vdd sg13_lv_pmos ad=79.8f pd=0.8u as=0.1428p ps=1.52u w=0.42u l=0.13u
X3251 sg13cmos5l_IOPadAnalog_10.pad a_67639_178370# sg13cmos5l_Corner_1.vss sg13cmos5l_Corner_1.vss sg13_hv_nmos ad=2.596p pd=5.58u as=1.408p ps=5.04u w=4.4u l=0.6u
X3252 sg13cmos5l_Corner_1.vss adc8b_0.sar12b_0.sg13cmos5l_dfrbp_1_6.RESET_B a_89100_98834# sg13cmos5l_Corner_1.vss sg13_lv_nmos ad=0.1626p pd=1.415u as=60.89999f ps=0.71u w=0.42u l=0.13u
X3253 adc8b_0.sar12b_0.sg13cmos5l_buf_1_4.A a_97360_97360# vdd vdd sg13_lv_pmos ad=0.42p pd=2.99u as=0.2114p ps=1.54u w=1.12u l=0.13u
X3254 a_94126_96548# adc8b_0.sar12b_0.sg13cmos5l_dfrbp_1_21.Q vdd vdd sg13_lv_pmos ad=0.1596p pd=1.22u as=0.2226p ps=1.535u w=0.84u l=0.13u
X3255 a_94802_96572# adc8b_0.sar12b_0.sg13cmos5l_nor2_1_0.A adc8b_0.sar12b_0.sg13cmos5l_or2_1_1.B vdd sg13_lv_pmos ad=0.1176p pd=1.33u as=0.3808p ps=2.92u w=1.12u l=0.13u
X3256 sg13cmos5l_Corner_1.vss adc8b_0.sar12b_0.nh_sw[0] adc8b_0.side_cap8b_1.buf_32_1.z sg13cmos5l_Corner_1.vss sg13_lv_nmos ad=95f pd=0.88u as=95f ps=0.88u w=0.5u l=0.13u
X3257 sg13cmos5l_Corner_1.vss adc8b_0.sar12b_0.sg13cmos5l_buf_1_7.A a_95824_92824# sg13cmos5l_Corner_1.vss sg13_lv_nmos ad=0.14875p pd=1.16u as=0.187p ps=1.78u w=0.55u l=0.13u
X3258 vdd adc8b_0.sar12b_0.sg13cmos5l_dfrbp_1_6.RESET_B a_86702_93986# vdd sg13_lv_pmos ad=0.36237p pd=2.605u as=79.8f ps=0.8u w=0.42u l=0.13u
X3259 a_82676_92750# adc8b_0.sar12b_0.sg13cmos5l_buf_1_32.A sg13cmos5l_Corner_1.vss sg13cmos5l_Corner_1.vss sg13_lv_nmos ad=0.187p pd=1.78u as=0.14875p ps=1.16u w=0.55u l=0.13u
X3260 a_97677_93559# adc8b_0.sar12b_0.sg13cmos5l_dfrbp_1_0.CLK sg13cmos5l_Corner_1.vss sg13cmos5l_Corner_1.vss sg13_lv_nmos ad=0.2516p pd=2.16u as=2.43055p ps=15.415u w=0.74u l=0.13u
X3261 a_99481_99998# a_98929_99954# sg13cmos5l_Corner_1.vss sg13cmos5l_Corner_1.vss sg13_lv_nmos ad=71.99999f pd=0.865u as=2.92392p ps=18.89u w=0.64u l=0.13u
X3262 a_95228_99156# a_94946_98844# a_95161_98826# sg13cmos5l_Corner_1.vss sg13_lv_nmos ad=0.141p pd=1.17u as=71.99999f ps=0.865u w=0.64u l=0.13u
X3263 vdd a_87441_94298# a_87966_94280# vdd sg13_lv_pmos ad=0.1974p pd=1.5u as=0.2856p ps=2.36u w=0.84u l=0.13u
X3264 sg13cmos5l_Corner_1.vss a_99639_178370# sg13cmos5l_IOPadAnalog_15.pad sg13cmos5l_Corner_1.vss sg13_hv_nmos ad=1.408p pd=5.04u as=2.596p ps=5.58u w=4.4u l=0.6u
X3265 sg13cmos5l_Corner_1.iovdd a_67639_164698# sg13cmos5l_IOPadAnalog_10.pad sg13cmos5l_Corner_1.iovdd sg13_hv_pmos ad=2.1312p pd=7.3u as=3.9294p ps=7.84u w=6.66u l=0.6u
X3266 adc8b_0.side_cap8b_0.buf_16_3.z adc8b_0.side_cap8b_0.in_h_sw[1] sg13cmos5l_Corner_1.vss sg13cmos5l_Corner_1.vss sg13_lv_nmos ad=95f pd=0.88u as=95f ps=0.88u w=0.5u l=0.13u
X3267 vdd a_82774_95327# adc8b_0.sar12b_0.sg13cmos5l_dlygate4sd3_1_0.X vdd sg13_lv_pmos ad=0.2254p pd=1.53u as=0.4256p ps=3u w=1.12u l=0.13u
X3268 sg13cmos5l_Corner_1.vss a_115639_178370# sg13cmos5l_IOPadAnalog_13.pad sg13cmos5l_Corner_1.vss sg13_hv_nmos ad=1.408p pd=5.04u as=2.596p ps=5.58u w=4.4u l=0.6u
X3269 sg13cmos5l_Corner_1.vss sg13cmos5l_IOPadVdd$1_0.sg13cmos5l_Clamp_N43N43D4R$1_0.gate vdd sg13cmos5l_Corner_1.vss sg13_hv_nmos ad=1.408p pd=5.04u as=2.596p ps=5.58u w=4.4u l=0.6u
X3270 vdd sg13cmos5l_IOPadVdd$1_0.sg13cmos5l_Clamp_N43N43D4R$1_0.gate sg13cmos5l_Corner_1.vss sg13cmos5l_Corner_1.vss sg13_hv_nmos ad=2.596p pd=5.58u as=1.408p ps=5.04u w=4.4u l=0.6u
X3271 vddr adc8b_0.side_cap8b_0.in_h_sw[2] adc8b_0.side_cap8b_0.buf_16_0.z vddr sg13_lv_pmos ad=0.19p pd=1.38u as=0.19p ps=1.38u w=1u l=0.13u
X3272 sg13cmos5l_Corner_1.vss vdd sg13cmos5l_Corner_1.vss sg13cmos5l_Corner_1.vss sg13_lv_nmos ad=79.8f pd=0.8u as=0 ps=0 w=0.42u l=1u
X3273 adc8b_0.side_cap8b_1.buf_8_2.z adc8b_0.sar12b_0.nh_sw[4] vddr vddr sg13_lv_pmos ad=0.19p pd=1.38u as=0.19p ps=1.38u w=1u l=0.13u
X3274 adc8b_0.sar12b_0.nl_sw[1] a_83632_92824# vdd vdd sg13_lv_pmos ad=0.42p pd=2.99u as=0.2114p ps=1.54u w=1.12u l=0.13u
X3275 vddr adc8b_0.side_cap8b_0.in_l_sw[0] adc8b_0.side_cap8b_0.buf_32_0.z vddr sg13_lv_pmos ad=0.19p pd=1.38u as=0.19p ps=1.38u w=1u l=0.13u
X3276 vdd adc8b_0.sar12b_0.sg13cmos5l_inv_1_6.A a_101776_99596# vdd sg13_lv_pmos ad=0.2114p pd=1.54u as=0.2856p ps=2.36u w=0.84u l=0.13u
X3277 adc8b_0.sar12b_0.nl_sw[2] a_84016_92824# sg13cmos5l_Corner_1.vss sg13cmos5l_Corner_1.vss sg13_lv_nmos ad=0.2886p pd=2.26u as=0.14875p ps=1.16u w=0.74u l=0.13u
X3278 sg13cmos5l_Corner_1.iovdd a_42476_102044# vip sg13cmos5l_Corner_1.iovdd sg13_hv_pmos ad=2.1312p pd=7.3u as=3.9294p ps=7.84u w=6.66u l=0.6u
X3279 sg13cmos5l_Corner_1.vss adc8b_0.side_cap8b_0.in_l_sw[7] adc8b_0.side_cap8b_0.buf_4_0.z sg13cmos5l_Corner_1.vss sg13_lv_nmos ad=95f pd=0.88u as=95f ps=0.88u w=0.5u l=0.13u
X3280 sg13cmos5l_Corner_1.vss adc8b_0.sar12b_0.sg13cmos5l_buf_1_116.A a_97360_97360# sg13cmos5l_Corner_1.vss sg13_lv_nmos ad=0.14875p pd=1.16u as=0.187p ps=1.78u w=0.55u l=0.13u
X3281 adc8b_0.sar12b_0.sg13cmos5l_nor2b_1_0.Y a_94582_95852# sg13cmos5l_Corner_1.vss sg13cmos5l_Corner_1.vss sg13_lv_nmos ad=0.1406p pd=1.12u as=0.17255p ps=1.25u w=0.74u l=0.13u
X3282 data[0] a_70044_42476# sg13cmos5l_Corner_1.iovdd sg13cmos5l_Corner_1.iovdd sg13_hv_pmos ad=3.9294p pd=7.84u as=3.1302p ps=14.26u w=6.66u l=0.6u
X3283 sg13cmos5l_Corner_1.vss adc8b_0.sar12b_0.sg13cmos5l_buf_1_60.X a_84016_100384# sg13cmos5l_Corner_1.vss sg13_lv_nmos ad=0.14875p pd=1.16u as=0.187p ps=1.78u w=0.55u l=0.13u
X3284 vdd a_99261_95107# a_98340_95421# vdd sg13_lv_pmos ad=0.36237p pd=2.605u as=0.34p ps=2.68u w=1u l=0.13u
X3285 a_93140_94262# adc8b_0.sar12b_0.sg13cmos5l_buf_1_9.A sg13cmos5l_Corner_1.vss sg13cmos5l_Corner_1.vss sg13_lv_nmos ad=0.187p pd=1.78u as=0.14875p ps=1.16u w=0.55u l=0.13u
X3286 vdd a_90356_93512# adc8b_0.sar12b_0.nl_sw[4] vdd sg13_lv_pmos ad=0.2114p pd=1.54u as=0.42p ps=2.99u w=1.12u l=0.13u
X3287 sg13cmos5l_Corner_1.iovdd a_42476_86044# vin sg13cmos5l_Corner_1.iovdd sg13_hv_pmos ad=2.1312p pd=7.3u as=3.9294p ps=7.84u w=6.66u l=0.6u
X3288 sg13cmos5l_Corner_1.iovdd a_164624_118044# sg13cmos5l_IOPadAnalog_11.pad sg13cmos5l_Corner_1.iovdd sg13_hv_pmos ad=2.1312p pd=7.3u as=3.9294p ps=7.84u w=6.66u l=0.6u
X3289 a_82388_98798# adc8b_0.sar12b_0.sg13cmos5l_buf_1_63.X sg13cmos5l_Corner_1.vss sg13cmos5l_Corner_1.vss sg13_lv_nmos ad=0.187p pd=1.78u as=0.14875p ps=1.16u w=0.55u l=0.13u
X3290 vdd adc8b_0.sar12b_0.sg13cmos5l_buf_1_98.A a_95536_99596# vdd sg13_lv_pmos ad=0.2114p pd=1.54u as=0.2856p ps=2.36u w=0.84u l=0.13u
X3291 data[2] a_102044_30676# sg13cmos5l_Corner_1.vss sg13cmos5l_Corner_1.vss sg13_hv_nmos ad=2.596p pd=5.58u as=1.408p ps=5.04u w=4.4u l=0.6u
X3292 a_82964_99560# adc8b_0.sar12b_0.sg13cmos5l_buf_1_63.A sg13cmos5l_Corner_1.vss sg13cmos5l_Corner_1.vss sg13_lv_nmos ad=0.187p pd=1.78u as=0.14875p ps=1.16u w=0.55u l=0.13u
X3293 a_93741_95071# adc8b_0.sar12b_0.sg13cmos5l_dfrbp_1_0.CLK vdd vdd sg13_lv_pmos ad=0.4088p pd=2.97u as=1.38655p ps=8.8u w=1.12u l=0.13u
X3294 vdd adc8b_0.sar12b_0.sg13cmos5l_dfrbp_1_10.Q_N a_85009_93906# vdd sg13_lv_pmos ad=1.86162p pd=11.935u as=0.2856p ps=2.36u w=0.84u l=0.13u
X3295 sg13cmos5l_Corner_1.vss adc8b_0.sar12b_0.sg13cmos5l_buf_1_44.X adc8b_0.sar12b_0.sg13cmos5l_buf_1_38.A sg13cmos5l_Corner_1.vss sg13_lv_nmos ad=0.2516p pd=2.16u as=0.2516p ps=2.16u w=0.74u l=0.13u
X3296 a_88671_94314# adc8b_0.sar12b_0.sg13cmos5l_dlhr_1_0.GATE sg13cmos5l_Corner_1.vss sg13cmos5l_Corner_1.vss sg13_lv_nmos ad=0.2516p pd=2.16u as=0.15055p ps=1.17u w=0.74u l=0.13u
X3297 a_85561_93950# a_85009_93906# sg13cmos5l_Corner_1.vss sg13cmos5l_Corner_1.vss sg13_lv_nmos ad=71.99999f pd=0.865u as=2.59257p ps=16.445u w=0.64u l=0.13u
X3298 sg13cmos5l_Corner_1.vss sg13cmos5l_IOPadVdd$1_0.sg13cmos5l_Clamp_N43N43D4R$1_0.gate vdd sg13cmos5l_Corner_1.vss sg13_hv_nmos ad=1.408p pd=5.04u as=2.596p ps=5.58u w=4.4u l=0.6u
X3299 sg13cmos5l_Corner_1.vss sg13cmos5l_IOPadVdd$1_0.sg13cmos5l_RCClampInverter$1_0.in sg13cmos5l_Corner_1.vss sg13cmos5l_Corner_1.vss sg13_hv_nmos ad=1.71p pd=9.38u as=0 ps=0 w=9u l=9.5u
X3300 vddr adc8b_0.sar12b_0.nh_sw[1] adc8b_0.side_cap8b_1.buf_16_3.z vddr sg13_lv_pmos ad=0.19p pd=1.38u as=0.19p ps=1.38u w=1u l=0.13u
X3301 sg13cmos5l_Corner_1.iovdd a_164624_86044# sg13cmos5l_IOPadAnalog_0.pad sg13cmos5l_Corner_1.iovdd sg13_hv_pmos ad=2.1312p pd=7.3u as=3.9294p ps=7.84u w=6.66u l=0.6u
X3302 sg13cmos5l_Corner_1.iovdd a_42476_102044# vip sg13cmos5l_Corner_1.iovdd sg13_hv_pmos ad=2.1312p pd=7.3u as=3.9294p ps=7.84u w=6.66u l=0.6u
X3303 a_85175_99957# a_84333_99607# a_83916_99600# vdd sg13_lv_pmos ad=0.2048p pd=1.63u as=0.34p ps=2.68u w=1u l=0.13u
X3304 adc8b_0.sar12b_0.sg13cmos5l_dfrbp_1_11.Q a_90236_96108# sg13cmos5l_Corner_1.vss sg13cmos5l_Corner_1.vss sg13_lv_nmos ad=0.2516p pd=2.16u as=0.1406p ps=1.12u w=0.74u l=0.13u
X3305 adc8b_0.sar12b_0.sg13cmos5l_dlhr_1_3.Q_N a_86334_93978# vdd vdd sg13_lv_pmos ad=0.3808p pd=2.92u as=0.1974p ps=1.5u w=1.12u l=0.13u
X3306 vdd adc8b_0.sar12b_0.sg13cmos5l_nand2_1_1.B a_92232_93587# vdd sg13_lv_pmos ad=0.2891p pd=1.695u as=0.1596p ps=1.22u w=0.84u l=0.13u
X3307 sg13cmos5l_Corner_1.vss a_30676_70044# vddr sg13cmos5l_Corner_1.vss sg13_hv_nmos ad=1.408p pd=5.04u as=2.596p ps=5.58u w=4.4u l=0.6u
X3308 a_93132_95498# adc8b_0.sar12b_0.sg13cmos5l_dfrbp_1_2.D a_93038_95498# sg13cmos5l_Corner_1.vss sg13_lv_nmos ad=60.89999f pd=0.71u as=0.1428p ps=1.52u w=0.42u l=0.13u
X3309 sg13cmos5l_Corner_1.vss a_86044_30676# data[1] sg13cmos5l_Corner_1.vss sg13_hv_nmos ad=1.408p pd=5.04u as=2.596p ps=5.58u w=4.4u l=0.6u
X3310 a_178296_86044# sg13cmos5l_Corner_1.vss sg13cmos5l_Corner_1.vss rppd l=3.54u w=0.5u
X3311 vin a_30676_86044# sg13cmos5l_Corner_1.vss sg13cmos5l_Corner_1.vss sg13_hv_nmos ad=2.596p pd=5.58u as=1.408p ps=5.04u w=4.4u l=0.6u
X3312 vdd a_100995_95814# adc8b_0.sar12b_0.sg13cmos5l_buf_8_0.X vdd sg13_lv_pmos ad=0.2128p pd=1.5u as=0.2128p ps=1.5u w=1.12u l=0.13u
X3313 sg13cmos5l_Corner_1.vss sg13cmos5l_IOPadVdd$1_0.sg13cmos5l_RCClampInverter$1_0.in sg13cmos5l_Corner_1.vss sg13cmos5l_Corner_1.vss sg13_hv_nmos ad=1.71p pd=9.38u as=0 ps=0 w=9u l=9.5u
X3314 a_82774_95327# a_82889_95326# vdd vdd sg13_lv_pmos ad=0.34p pd=2.68u as=0.2254p ps=1.53u w=1u l=0.5u
X3315 a_100068_98870# a_99519_98850# a_99932_99156# sg13cmos5l_Corner_1.vss sg13_lv_nmos ad=47.25f pd=0.645u as=0.141p ps=1.17u w=0.42u l=0.13u
X3316 vdd a_85844_96536# adc8b_0.sar12b_0.sg13cmos5l_inv_1_17.A vdd sg13_lv_pmos ad=0.2114p pd=1.54u as=0.42p ps=2.99u w=1.12u l=0.13u
X3317 a_95364_98870# a_94815_98850# a_95228_99156# sg13cmos5l_Corner_1.vss sg13_lv_nmos ad=47.25f pd=0.645u as=0.141p ps=1.17u w=0.42u l=0.13u
X3318 sg13cmos5l_Corner_1.vss adc8b_0.sar12b_0.nl_sw[1] adc8b_0.side_cap8b_1.buf_16_2.z sg13cmos5l_Corner_1.vss sg13_lv_nmos ad=95f pd=0.88u as=0.17p ps=1.68u w=0.5u l=0.13u
X3319 vdd sg13cmos5l_IOPadVdd$1_0.sg13cmos5l_RCClampInverter$1_0.in sg13cmos5l_IOPadVdd$1_0.sg13cmos5l_Clamp_N43N43D4R$1_0.gate vdd sg13_hv_pmos ad=1.33p pd=7.38u as=1.33p ps=7.38u w=7u l=0.5u
X3320 adc8b_0.sar12b_0.sg13cmos5l_dfrbp_1_18.Q_N a_89015_99957# vdd vdd sg13_lv_pmos ad=0.4312p pd=3.01u as=0.2639p ps=1.81u w=1.12u l=0.13u
X3321 adc8b_0.side_cap8b_1.buf_32_1.z adc8b_0.sar12b_0.nh_sw[0] vddr vddr sg13_lv_pmos ad=0.19p pd=1.38u as=0.19p ps=1.38u w=1u l=0.13u
X3322 sg13cmos5l_Corner_1.iovdd a_42476_70044# vddr sg13cmos5l_Corner_1.iovdd sg13_hv_pmos ad=3.1302p pd=14.26u as=3.9294p ps=7.84u w=6.66u l=0.6u
X3323 adc8b_0.sar12b_0.sg13cmos5l_buf_1_87.A a_100144_100384# sg13cmos5l_Corner_1.vss sg13cmos5l_Corner_1.vss sg13_lv_nmos ad=0.2886p pd=2.26u as=0.14875p ps=1.16u w=0.74u l=0.13u
X3324 a_98061_95789# adc8b_0.sar12b_0.sg13cmos5l_inv_1_2.A vdd vdd sg13_lv_pmos ad=0.4088p pd=2.97u as=1.28962p ps=8.195u w=1.12u l=0.13u
X3325 sg13cmos5l_Corner_1.iovdd a_164624_102044# sg13cmos5l_IOPadAnalog_16.pad sg13cmos5l_Corner_1.iovdd sg13_hv_pmos ad=2.1312p pd=7.3u as=3.9294p ps=7.84u w=6.66u l=0.6u
X3326 sg13cmos5l_Corner_1.vss a_67639_178370# sg13cmos5l_IOPadAnalog_10.pad sg13cmos5l_Corner_1.vss sg13_hv_nmos ad=1.408p pd=5.04u as=2.596p ps=5.58u w=4.4u l=0.6u
X3327 sg13cmos5l_Corner_1.vss vdd sg13cmos5l_Corner_1.vss sg13cmos5l_Corner_1.vss sg13_lv_nmos ad=0.1428p pd=1.52u as=0 ps=0 w=0.42u l=1u
X3328 vip a_42476_102044# sg13cmos5l_Corner_1.iovdd sg13cmos5l_Corner_1.iovdd sg13_hv_pmos ad=3.9294p pd=7.84u as=2.1312p ps=7.3u w=6.66u l=0.6u
X3329 a_93681_95107# a_93324_95064# vdd vdd sg13_lv_pmos ad=63f pd=0.72u as=0.1563p ps=1.22u w=0.42u l=0.13u
X3330 a_85343_97713# adc8b_0.sar12b_0.sg13cmos5l_dfrbp_1_8.RESET_B vdd vdd sg13_lv_pmos ad=79.8f pd=0.8u as=0.36237p ps=2.605u w=0.42u l=0.13u
X3331 a_101180_97644# a_100767_97338# a_101112_97644# vdd sg13_lv_pmos ad=0.191p pd=1.44u as=0.105p ps=1.21u w=1u l=0.13u
X3332 sg13cmos5l_Corner_1.vss a_178296_102044# sg13cmos5l_IOPadAnalog_16.pad sg13cmos5l_Corner_1.vss sg13_hv_nmos ad=1.408p pd=5.04u as=2.596p ps=5.58u w=4.4u l=0.6u
X3333 sg13cmos5l_Corner_1.vss adc8b_0.side_cap8b_0.in_h_sw[0] adc8b_0.side_cap8b_0.buf_32_1.z sg13cmos5l_Corner_1.vss sg13_lv_nmos ad=95f pd=0.88u as=95f ps=0.88u w=0.5u l=0.13u
X3334 vdd adc8b_0.sar12b_0.sg13cmos5l_buf_1_4.A a_98320_92824# vdd sg13_lv_pmos ad=0.2114p pd=1.54u as=0.2856p ps=2.36u w=0.84u l=0.13u
X3335 sg13cmos5l_Corner_1.vss a_30676_86044# vin sg13cmos5l_Corner_1.vss sg13_hv_nmos ad=2.068p pd=9.74u as=2.596p ps=5.58u w=4.4u l=0.6u
X3336 sg13cmos5l_Corner_1.vss adc8b_0.sar12b_0.sg13cmos5l_dfrbp_1_8.RESET_B a_87314_97010# sg13cmos5l_Corner_1.vss sg13_lv_nmos ad=79.8f pd=0.8u as=37.8f ps=0.6u w=0.42u l=0.13u
X3337 data[2] a_102044_42476# sg13cmos5l_Corner_1.iovdd sg13cmos5l_Corner_1.iovdd sg13_hv_pmos ad=3.9294p pd=7.84u as=2.1312p ps=7.3u w=6.66u l=0.6u
X3338 vdd adc8b_0.sar12b_0.sg13cmos5l_inv_1_1.A a_98032_100384# vdd sg13_lv_pmos ad=0.2114p pd=1.54u as=0.2856p ps=2.36u w=0.84u l=0.13u
X3339 adc8b_0.side_cap8b_1.buf_32_0.z adc8b_0.sar12b_0.nl_sw[0] sg13cmos5l_Corner_1.vss sg13cmos5l_Corner_1.vss sg13_lv_nmos ad=95f pd=0.88u as=95f ps=0.88u w=0.5u l=0.13u
X3340 vin a_42476_86044# sg13cmos5l_Corner_1.iovdd sg13cmos5l_Corner_1.iovdd sg13_hv_pmos ad=3.9294p pd=7.84u as=2.1312p ps=7.3u w=6.66u l=0.6u
X3341 sg13cmos5l_Corner_1.iovdd a_42476_70044# vddr sg13cmos5l_Corner_1.iovdd sg13_hv_pmos ad=2.1312p pd=7.3u as=3.9294p ps=7.84u w=6.66u l=0.6u
X3342 vdd adc8b_0.sar12b_0.sg13cmos5l_dlhr_1_0.D a_88657_92840# vdd sg13_lv_pmos ad=1.86162p pd=11.935u as=0.2856p ps=2.36u w=0.84u l=0.13u
X3343 a_99276_94298# adc8b_0.sar12b_0.sg13cmos5l_a22oi_1_1.Y a_99182_94298# sg13cmos5l_Corner_1.vss sg13_lv_nmos ad=60.89999f pd=0.71u as=0.1428p ps=1.52u w=0.42u l=0.13u
X3344 vdd sg13cmos5l_IOPadVdd$1_0.sg13cmos5l_Clamp_N43N43D4R$1_0.gate sg13cmos5l_Corner_1.vss sg13cmos5l_Corner_1.vss sg13_hv_nmos ad=2.596p pd=5.58u as=1.408p ps=5.04u w=4.4u l=0.6u
X3345 adc8b_0.sar12b_0.sg13cmos5l_buf_1_9.A a_91600_92824# sg13cmos5l_Corner_1.vss sg13cmos5l_Corner_1.vss sg13_lv_nmos ad=0.2886p pd=2.26u as=0.14875p ps=1.16u w=0.74u l=0.13u
X3346 adc8b_0.side_cap8b_0.buf_2_2.z adc8b_0.side_cap8b_0.in_l_sw[9] vddr vddr sg13_lv_pmos ad=0.34p pd=2.68u as=0.19p ps=1.38u w=1u l=0.13u
X3347 sg13cmos5l_Corner_1.vss adc8b_0.side_cap8b_0.in_h_sw[7] adc8b_0.side_cap8b_0.buf_4_2.z sg13cmos5l_Corner_1.vss sg13_lv_nmos ad=95f pd=0.88u as=95f ps=0.88u w=0.5u l=0.13u
X3348 vdd a_100995_95814# adc8b_0.sar12b_0.sg13cmos5l_buf_8_0.X vdd sg13_lv_pmos ad=0.2128p pd=1.5u as=0.2128p ps=1.5u w=1.12u l=0.13u
X3349 vdd adc8b_0.sar12b_0.sg13cmos5l_buf_1_24.X a_87472_92824# vdd sg13_lv_pmos ad=0.2114p pd=1.54u as=0.2856p ps=2.36u w=0.84u l=0.13u
X3350 sg13cmos5l_Corner_1.vss a_100984_94518# a_100633_94375# sg13cmos5l_Corner_1.vss sg13_lv_nmos ad=79.8f pd=0.8u as=0.1428p ps=1.52u w=0.42u l=0.13u
X3351 adc8b_0.side_cap8b_0.buf_32_1.z adc8b_0.side_cap8b_0.in_h_sw[0] vddr vddr sg13_lv_pmos ad=0.19p pd=1.38u as=0.19p ps=1.38u w=1u l=0.13u
X3352 a_94680_98084# a_94129_98442# vdd vdd sg13_lv_pmos ad=0.105p pd=1.21u as=1.07253p ps=6.75u w=1u l=0.13u
X3353 a_99095_98445# a_98253_98095# a_99001_98445# sg13cmos5l_Corner_1.vss sg13_lv_nmos ad=0.12665p pd=1.145u as=0.1428p ps=1.52u w=0.42u l=0.13u
X3354 sg13cmos5l_IOPadAnalog_9.pad a_83639_164698# sg13cmos5l_Corner_1.iovdd sg13cmos5l_Corner_1.iovdd sg13_hv_pmos ad=3.9294p pd=7.84u as=2.1312p ps=7.3u w=6.66u l=0.6u
X3355 a_99352_98326# adc8b_0.sar12b_0.sg13cmos5l_dfrbp_1_8.RESET_B vdd vdd sg13_lv_pmos ad=79.8f pd=0.8u as=1.04815p ps=6.595u w=0.42u l=0.13u
X3356 vdd a_98903_95887# a_99740_96108# vdd sg13_lv_pmos ad=0.2128p pd=1.5u as=0.3864p ps=2.93u w=1.12u l=0.13u
X3357 a_90225_98441# a_90044_98084# vdd vdd sg13_lv_pmos ad=0.2128p pd=1.5u as=0.2387p ps=1.84u w=1.12u l=0.13u
X3358 a_97618_96033# a_98061_95789# a_98001_96201# vdd sg13_lv_pmos ad=79.8f pd=0.8u as=63f ps=0.72u w=0.42u l=0.13u
X3359 vdd a_97589_95024# adc8b_0.sar12b_0.sg13cmos5l_dfrbp_1_6.Q_N vdd sg13_lv_pmos ad=0.2639p pd=1.81u as=0.4312p ps=3.01u w=1.12u l=0.13u
X3360 cks a_42476_118044# sg13cmos5l_Corner_1.iovdd sg13cmos5l_Corner_1.iovdd sg13_hv_pmos ad=3.9294p pd=7.84u as=2.1312p ps=7.3u w=6.66u l=0.6u
X3361 a_86050_99272# a_85444_99124# vdd vdd sg13_lv_pmos ad=0.1008p pd=0.9u as=0.2387p ps=1.84u w=0.42u l=0.13u
X3362 vdd sg13cmos5l_Corner_1.vss vdd vdd sg13_lv_pmos ad=0.19p pd=1.38u as=0 ps=0 w=1u l=1u
X3363 sg13cmos5l_Corner_1.vss adc8b_0.sar12b_0.nh_sw[5] adc8b_0.side_cap8b_1.buf_8_5.z sg13cmos5l_Corner_1.vss sg13_lv_nmos ad=95f pd=0.88u as=95f ps=0.88u w=0.5u l=0.13u
X3364 vddr adc8b_0.sar12b_0.nl_sw[0] adc8b_0.side_cap8b_1.buf_32_0.z vddr sg13_lv_pmos ad=0.19p pd=1.38u as=0.19p ps=1.38u w=1u l=0.13u
X3365 vdd adc8b_0.sar12b_0.sg13cmos5l_dfrbp_1_6.RESET_B a_82450_98052# vdd sg13_lv_pmos ad=0.1563p pd=1.22u as=0.147p ps=1.54u w=0.42u l=0.13u
X3366 vdd sg13cmos5l_Corner_1.vss vdd vdd sg13_lv_pmos ad=0.19p pd=1.38u as=0 ps=0 w=1u l=1u
X3367 a_100984_94518# a_100727_94375# a_101146_94298# sg13cmos5l_Corner_1.vss sg13_lv_nmos ad=0.1428p pd=1.52u as=37.8f ps=0.6u w=0.42u l=0.13u
X3368 vdd adc8b_0.sar12b_0.sg13cmos5l_buf_1_86.A a_102160_98084# vdd sg13_lv_pmos ad=0.2114p pd=1.54u as=0.2856p ps=2.36u w=0.84u l=0.13u
X3369 vdd adc8b_0.sar12b_0.sg13cmos5l_dfrbp_1_6.RESET_B a_90801_97322# vdd sg13_lv_pmos ad=0.2128p pd=1.5u as=0.2128p ps=1.5u w=1.12u l=0.13u
X3370 vdd adc8b_0.sar12b_0.sg13cmos5l_or2_1_1.B a_92188_96572# vdd sg13_lv_pmos ad=0.3808p pd=2.92u as=0.2128p ps=1.5u w=1.12u l=0.13u
X3371 sg13cmos5l_Corner_1.iovdd a_131639_164698# sg13cmos5l_IOPadAnalog_12.pad sg13cmos5l_Corner_1.iovdd sg13_hv_pmos ad=2.1312p pd=7.3u as=3.9294p ps=7.84u w=6.66u l=0.6u
X3372 sg13cmos5l_Corner_1.iovdd a_42476_86044# vin sg13cmos5l_Corner_1.iovdd sg13_hv_pmos ad=2.1312p pd=7.3u as=3.9294p ps=7.84u w=6.66u l=0.6u
X3373 sg13cmos5l_Corner_1.iovdd a_86044_42476# data[1] sg13cmos5l_Corner_1.iovdd sg13_hv_pmos ad=2.1312p pd=7.3u as=3.9294p ps=7.84u w=6.66u l=0.6u
X3374 adc8b_0.sar12b_0.sg13cmos5l_buf_1_31.X a_82192_92824# vdd vdd sg13_lv_pmos ad=0.42p pd=2.99u as=0.2114p ps=1.54u w=1.12u l=0.13u
X3375 vdd a_86718_96859# adc8b_0.sar12b_0.sg13cmos5l_dlhr_1_5.GATE vdd sg13_lv_pmos ad=0.2128p pd=1.5u as=0.3808p ps=2.92u w=1.12u l=0.13u
X3376 sg13cmos5l_Corner_1.vss adc8b_0.sar12b_0.sg13cmos5l_dlygate4sd2_1_0.A a_82670_94302# sg13cmos5l_Corner_1.vss sg13_lv_nmos ad=0.1323p pd=1.05u as=0.1428p ps=1.52u w=0.42u l=0.13u
X3377 sg13cmos5l_Corner_1.vss a_84500_92750# adc8b_0.sar12b_0.sg13cmos5l_buf_1_35.A sg13cmos5l_Corner_1.vss sg13_lv_nmos ad=0.14875p pd=1.16u as=0.2886p ps=2.26u w=0.74u l=0.13u
X3378 sg13cmos5l_Corner_1.vss sg13cmos5l_IOPadVdd$1_0.sg13cmos5l_Clamp_N43N43D4R$1_0.gate vdd sg13cmos5l_Corner_1.vss sg13_hv_nmos ad=1.408p pd=5.04u as=2.596p ps=5.58u w=4.4u l=0.6u
X3379 a_90360_96572# a_89809_96930# vdd vdd sg13_lv_pmos ad=0.105p pd=1.21u as=1.28962p ps=8.195u w=1u l=0.13u
X3380 sg13cmos5l_IOPadAnalog_0.pad a_164624_86044# sg13cmos5l_Corner_1.iovdd sg13cmos5l_Corner_1.iovdd sg13_hv_pmos ad=3.9294p pd=7.84u as=2.1312p ps=7.3u w=6.66u l=0.6u
X3381 vddr adc8b_0.sar12b_0.nl_sw[7] adc8b_0.side_cap8b_1.buf_4_0.z vddr sg13_lv_pmos ad=0.19p pd=1.38u as=0.19p ps=1.38u w=1u l=0.13u
X3382 adc8b_0.side_cap8b_1.buf_16_1.z adc8b_0.sar12b_0.nl_sw[2] sg13cmos5l_Corner_1.vss sg13cmos5l_Corner_1.vss sg13_lv_nmos ad=95f pd=0.88u as=95f ps=0.88u w=0.5u l=0.13u
X3383 a_88148_98798# adc8b_0.sar12b_0.sg13cmos5l_buf_1_78.X sg13cmos5l_Corner_1.vss sg13cmos5l_Corner_1.vss sg13_lv_nmos ad=0.187p pd=1.78u as=0.14875p ps=1.16u w=0.55u l=0.13u
X3384 sg13cmos5l_Corner_1.iovdd a_118044_42476# cko sg13cmos5l_Corner_1.iovdd sg13_hv_pmos ad=2.1312p pd=7.3u as=3.9294p ps=7.84u w=6.66u l=0.6u
X3385 adc8b_0.side_cap8b_0.buf_16_2.z adc8b_0.side_cap8b_0.in_l_sw[1] sg13cmos5l_Corner_1.vss sg13cmos5l_Corner_1.vss sg13_lv_nmos ad=95f pd=0.88u as=95f ps=0.88u w=0.5u l=0.13u
X3386 data[2] a_102044_42476# sg13cmos5l_Corner_1.iovdd sg13cmos5l_Corner_1.iovdd sg13_hv_pmos ad=3.9294p pd=7.84u as=2.1312p ps=7.3u w=6.66u l=0.6u
X3387 adc8b_0.sar12b_0.sg13cmos5l_buf_8_0.A a_100248_96188# sg13cmos5l_Corner_1.vss sg13cmos5l_Corner_1.vss sg13_lv_nmos ad=0.2516p pd=2.16u as=0.1469p ps=1.155u w=0.74u l=0.13u
X3388 sg13cmos5l_Corner_1.vss a_89080_95302# a_88729_95421# sg13cmos5l_Corner_1.vss sg13_lv_nmos ad=79.8f pd=0.8u as=0.1428p ps=1.52u w=0.42u l=0.13u
X3389 adc8b_0.sar12b_0.sg13cmos5l_dfrbp_1_14.Q_N a_86615_95887# sg13cmos5l_Corner_1.vss sg13cmos5l_Corner_1.vss sg13_lv_nmos ad=0.2849p pd=2.25u as=0.2516p ps=2.16u w=0.74u l=0.13u
X3390 vdd adc8b_0.sar12b_0.sg13cmos5l_buf_8_0.A a_100995_95814# vdd sg13_lv_pmos ad=0.2128p pd=1.5u as=0.3808p ps=2.92u w=1.12u l=0.13u
X3391 sg13cmos5l_Corner_1.vss adc8b_0.side_cap8b_0.in_l_sw[4] adc8b_0.side_cap8b_0.buf_8_0.z sg13cmos5l_Corner_1.vss sg13_lv_nmos ad=95f pd=0.88u as=95f ps=0.88u w=0.5u l=0.13u
X3392 sg13cmos5l_Corner_1.vss a_100113_98834# a_100638_98816# sg13cmos5l_Corner_1.vss sg13_lv_nmos ad=0.1491p pd=1.18u as=0.187p ps=1.78u w=0.55u l=0.13u
X3393 sg13cmos5l_Corner_1.vss a_85844_96536# adc8b_0.sar12b_0.sg13cmos5l_inv_1_17.A sg13cmos5l_Corner_1.vss sg13_lv_nmos ad=0.14875p pd=1.16u as=0.2886p ps=2.26u w=0.74u l=0.13u
X3394 adc8b_0.side_cap8b_1.buf_8_1.z adc8b_0.sar12b_0.nl_sw[3] sg13cmos5l_Corner_1.vss sg13cmos5l_Corner_1.vss sg13_lv_nmos ad=95f pd=0.88u as=95f ps=0.88u w=0.5u l=0.13u
X3395 vip a_42476_102044# sg13cmos5l_Corner_1.iovdd sg13cmos5l_Corner_1.iovdd sg13_hv_pmos ad=3.9294p pd=7.84u as=2.1312p ps=7.3u w=6.66u l=0.6u
X3396 vddr adc8b_0.side_cap8b_0.in_l_sw[2] adc8b_0.side_cap8b_0.buf_16_1.z vddr sg13_lv_pmos ad=0.19p pd=1.38u as=0.19p ps=1.38u w=1u l=0.13u
X3397 sg13cmos5l_Corner_1.vss adc8b_0.sar12b_0.sg13cmos5l_nand2_1_1.B a_91862_93940# sg13cmos5l_Corner_1.vss sg13_lv_nmos ad=0.2516p pd=2.16u as=96.2f ps=1u w=0.74u l=0.13u
X3398 a_100727_94375# a_99885_94277# a_100633_94375# sg13cmos5l_Corner_1.vss sg13_lv_nmos ad=0.12665p pd=1.145u as=0.1428p ps=1.52u w=0.42u l=0.13u
X3399 sg13cmos5l_Corner_1.vss adc8b_0.side_cap8b_0.in_l_sw[2] adc8b_0.side_cap8b_0.buf_16_1.z sg13cmos5l_Corner_1.vss sg13_lv_nmos ad=95f pd=0.88u as=95f ps=0.88u w=0.5u l=0.13u
X3400 frame a_134044_42476# sg13cmos5l_Corner_1.iovdd sg13cmos5l_Corner_1.iovdd sg13_hv_pmos ad=3.9294p pd=7.84u as=2.1312p ps=7.3u w=6.66u l=0.6u
X3401 sg13cmos5l_Corner_1.vss a_86044_30676# data[1] sg13cmos5l_Corner_1.vss sg13_hv_nmos ad=1.408p pd=5.04u as=2.596p ps=5.58u w=4.4u l=0.6u
X3402 sg13cmos5l_Corner_1.vss adc8b_0.sar12b_0.sg13cmos5l_dfrbp_1_6.RESET_B a_86428_98472# sg13cmos5l_Corner_1.vss sg13_lv_nmos ad=0.1406p pd=1.12u as=77.7f ps=0.95u w=0.74u l=0.13u
X3403 sg13cmos5l_Corner_1.vss vdd sg13cmos5l_Corner_1.vss sg13cmos5l_Corner_1.vss sg13_lv_nmos ad=79.8f pd=0.8u as=0 ps=0 w=0.42u l=1u
X3404 sg13cmos5l_Corner_1.vss a_175886_102222# dantenna l=27.78u w=1.26u
X3405 sg13cmos5l_Corner_1.iovdd a_164624_86044# sg13cmos5l_IOPadAnalog_0.pad sg13cmos5l_Corner_1.iovdd sg13_hv_pmos ad=2.1312p pd=7.3u as=3.9294p ps=7.84u w=6.66u l=0.6u
X3406 vdd a_89631_98442# a_89762_98448# vdd sg13_lv_pmos ad=1.07253p pd=6.75u as=0.2856p ps=2.36u w=0.84u l=0.13u
X3407 a_92188_96572# adc8b_0.sar12b_0.sg13cmos5l_dfrbp_1_16.Q a_92086_96572# vdd sg13_lv_pmos ad=0.2128p pd=1.5u as=0.2128p ps=1.5u w=1.12u l=0.13u
X3408 vdd a_91473_95810# a_91406_96248# vdd sg13_lv_pmos ad=0.2387p pd=1.84u as=0.1008p ps=0.9u w=0.42u l=0.13u
X3409 sg13cmos5l_Corner_1.vss a_85432_95302# a_85081_95421# sg13cmos5l_Corner_1.vss sg13_lv_nmos ad=79.8f pd=0.8u as=0.1428p ps=1.52u w=0.42u l=0.13u
X3410 vdd adc8b_0.sar12b_0.sg13cmos5l_dfrbp_1_6.RESET_B a_87442_97545# vdd sg13_lv_pmos ad=0.1563p pd=1.22u as=0.147p ps=1.54u w=0.42u l=0.13u
X3411 sg13cmos5l_IOPadAnalog_15.pad a_99639_164698# sg13cmos5l_Corner_1.iovdd sg13cmos5l_Corner_1.iovdd sg13_hv_pmos ad=3.9294p pd=7.84u as=2.1312p ps=7.3u w=6.66u l=0.6u
X3412 a_85437_97480# adc8b_0.sar12b_0.sg13cmos5l_dfrbp_1_8.RESET_B vdd vdd sg13_lv_pmos ad=0.147p pd=1.54u as=0.1563p ps=1.22u w=0.42u l=0.13u
X3413 sg13cmos5l_Corner_1.vss sg13cmos5l_IOPadVdd$1_0.sg13cmos5l_Clamp_N43N43D4R$1_0.gate vdd sg13cmos5l_Corner_1.vss sg13_hv_nmos ad=1.408p pd=5.04u as=2.596p ps=5.58u w=4.4u l=0.6u
X3414 a_90879_95826# adc8b_0.sar12b_0.sg13cmos5l_dfrbp_1_11.Q vdd vdd sg13_lv_pmos ad=0.3234p pd=2.45u as=1.2517p ps=7.955u w=0.84u l=0.13u
X3415 vdd adc8b_0.sar12b_0.sg13cmos5l_buf_1_44.X adc8b_0.sar12b_0.sg13cmos5l_buf_1_38.A vdd sg13_lv_pmos ad=0.3808p pd=2.92u as=0.3808p ps=2.92u w=1.12u l=0.13u
X3416 sg13cmos5l_IOPadAnalog_0.pad a_164624_86044# sg13cmos5l_Corner_1.iovdd sg13cmos5l_Corner_1.iovdd sg13_hv_pmos ad=3.9294p pd=7.84u as=2.1312p ps=7.3u w=6.66u l=0.6u
X3417 adc8b_0.side_cap8b_1.buf_4_1.z adc8b_0.sar12b_0.nh_sw[6] sg13cmos5l_Corner_1.vss sg13cmos5l_Corner_1.vss sg13_lv_nmos ad=95f pd=0.88u as=95f ps=0.88u w=0.5u l=0.13u
X3418 vddr adc8b_0.sar12b_0.nh_sw[0] adc8b_0.side_cap8b_1.buf_32_1.z vddr sg13_lv_pmos ad=0.19p pd=1.38u as=0.19p ps=1.38u w=1u l=0.13u
X3419 sg13cmos5l_IOPadAnalog_13.pad a_115639_164698# sg13cmos5l_Corner_1.iovdd sg13cmos5l_Corner_1.iovdd sg13_hv_pmos ad=3.9294p pd=7.84u as=2.1312p ps=7.3u w=6.66u l=0.6u
X3420 sg13cmos5l_IOPadAnalog_11.pad a_164624_118044# sg13cmos5l_Corner_1.iovdd sg13cmos5l_Corner_1.iovdd sg13_hv_pmos ad=3.9294p pd=7.84u as=2.1312p ps=7.3u w=6.66u l=0.6u
X3421 adc8b_0.side_cap8b_1.buf_16_1.z adc8b_0.sar12b_0.nl_sw[2] vddr vddr sg13_lv_pmos ad=0.34p pd=2.68u as=0.19p ps=1.38u w=1u l=0.13u
X3422 a_90932_92750# adc8b_0.sar12b_0.sg13cmos5l_buf_1_26.A sg13cmos5l_Corner_1.vss sg13cmos5l_Corner_1.vss sg13_lv_nmos ad=0.187p pd=1.78u as=0.14875p ps=1.16u w=0.55u l=0.13u
X3423 sg13cmos5l_Corner_1.vss adc8b_0.sar12b_0.sg13cmos5l_dlhr_1_2.D a_88465_94352# sg13cmos5l_Corner_1.vss sg13_lv_nmos ad=0.15055p pd=1.17u as=0.187p ps=1.78u w=0.55u l=0.13u
X3424 sg13cmos5l_Corner_1.iovdd a_83639_164698# sg13cmos5l_IOPadAnalog_9.pad sg13cmos5l_Corner_1.iovdd sg13_hv_pmos ad=2.1312p pd=7.3u as=3.9294p ps=7.84u w=6.66u l=0.6u
X3425 sg13cmos5l_Corner_1.vss a_32962_102222# dantenna l=27.78u w=1.26u
X3426 adc8b_0.sar12b_0.sg13cmos5l_dfrbp_1_11.Q_N a_89399_95887# vdd vdd sg13_lv_pmos ad=0.4312p pd=3.01u as=0.2639p ps=1.81u w=1.12u l=0.13u
X3427 vddr a_42476_70044# sg13cmos5l_Corner_1.iovdd sg13cmos5l_Corner_1.iovdd sg13_hv_pmos ad=3.9294p pd=7.84u as=2.1312p ps=7.3u w=6.66u l=0.6u
X3428 a_90957_99607# adc8b_0.sar12b_0.sg13cmos5l_inv_1_2.A vdd vdd sg13_lv_pmos ad=0.4088p pd=2.97u as=1.12242p ps=7u w=1.12u l=0.13u
X3429 sg13cmos5l_Corner_1.vss adc8b_0.sar12b_0.sg13cmos5l_dfrbp_1_6.RESET_B a_101212_96960# sg13cmos5l_Corner_1.vss sg13_lv_nmos ad=0.1406p pd=1.12u as=77.7f ps=0.95u w=0.74u l=0.13u
X3430 vdd a_99135_99954# a_99266_99960# vdd sg13_lv_pmos ad=1.15047p pd=7.175u as=0.2856p ps=2.36u w=0.84u l=0.13u
X3431 vdd a_93335_98911# a_94172_99132# vdd sg13_lv_pmos ad=0.2128p pd=1.5u as=0.3864p ps=2.93u w=1.12u l=0.13u
X3432 a_118044_42476# sg13cmos5l_Corner_1.iovdd sg13cmos5l_Corner_1.iovdd rppd l=12.9u w=0.5u
X3433 adc8b_0.side_cap8b_1.buf_16_3.z adc8b_0.sar12b_0.nh_sw[1] sg13cmos5l_Corner_1.vss sg13cmos5l_Corner_1.vss sg13_lv_nmos ad=95f pd=0.88u as=95f ps=0.88u w=0.5u l=0.13u
X3434 a_91862_93940# adc8b_0.sar12b_0.sg13cmos5l_inv_1_11.Y adc8b_0.sar12b_0.sg13cmos5l_dfrbp_1_1.D sg13cmos5l_Corner_1.vss sg13_lv_nmos ad=96.2f pd=1u as=0.2664p ps=1.46u w=0.74u l=0.13u
X3435 vddr adc8b_0.side_cap8b_0.in_l_sw[3] adc8b_0.side_cap8b_0.buf_8_1.z vddr sg13_lv_pmos ad=0.19p pd=1.38u as=0.19p ps=1.38u w=1u l=0.13u
X3436 a_93998_97322# a_94803_97444# a_94258_97545# vdd sg13_lv_pmos ad=0.1428p pd=1.52u as=79.8f ps=0.8u w=0.42u l=0.13u
X3437 adc8b_0.cmp_0.sg13cmos5l_inv_1$1_0.Y adc8b_0.cmp_0.outp vdd vdd sg13_lv_pmos ad=0.3808p pd=2.92u as=0.3808p ps=2.92u w=1.12u l=0.13u
X3438 vdd adc8b_0.sar12b_0.sg13cmos5l_buf_8_0.X a_102160_98872# vdd sg13_lv_pmos ad=0.2114p pd=1.54u as=0.2856p ps=2.36u w=0.84u l=0.13u
X3439 adc8b_0.sar12b_0.sg13cmos5l_buf_1_3.X a_102064_92824# sg13cmos5l_Corner_1.vss sg13cmos5l_Corner_1.vss sg13_lv_nmos ad=0.2886p pd=2.26u as=0.14875p ps=1.16u w=0.74u l=0.13u
X3440 sg13cmos5l_Corner_1.vss a_134222_176786# dantenna l=1.26u w=27.78u
X3441 sg13cmos5l_Corner_1.iovdd a_42476_118044# cks sg13cmos5l_Corner_1.iovdd sg13_hv_pmos ad=2.1312p pd=7.3u as=3.9294p ps=7.84u w=6.66u l=0.6u
X3442 a_97197_98813# adc8b_0.sar12b_0.sg13cmos5l_dfrbp_1_22.D sg13cmos5l_Corner_1.vss sg13cmos5l_Corner_1.vss sg13_lv_nmos ad=0.2516p pd=2.16u as=1.49685p ps=9.6u w=0.74u l=0.13u
X3443 sg13cmos5l_Corner_1.vss a_97589_95024# adc8b_0.sar12b_0.sg13cmos5l_dfrbp_1_6.Q_N sg13cmos5l_Corner_1.vss sg13_lv_nmos ad=0.2516p pd=2.16u as=0.2849p ps=2.25u w=0.74u l=0.13u
X3444 cko a_118044_30676# sg13cmos5l_Corner_1.vss sg13cmos5l_Corner_1.vss sg13_hv_nmos ad=2.596p pd=5.58u as=1.408p ps=5.04u w=4.4u l=0.6u
X3445 a_82764_96997# a_82476_96576# a_82702_96997# sg13cmos5l_Corner_1.vss sg13_lv_nmos ad=0.1428p pd=1.52u as=37.8f ps=0.6u w=0.42u l=0.13u
X3446 sg13cmos5l_Corner_1.iovdd a_86044_42476# data[1] sg13cmos5l_Corner_1.iovdd sg13_hv_pmos ad=2.1312p pd=7.3u as=3.9294p ps=7.84u w=6.66u l=0.6u
X3447 sg13cmos5l_Corner_1.iovdd a_164624_70044# sg13cmos5l_IOPadAnalog_1.pad sg13cmos5l_Corner_1.iovdd sg13_hv_pmos ad=3.1302p pd=14.26u as=3.9294p ps=7.84u w=6.66u l=0.6u
X3448 sg13cmos5l_Corner_1.iovdd a_164624_118044# sg13cmos5l_IOPadAnalog_11.pad sg13cmos5l_Corner_1.iovdd sg13_hv_pmos ad=2.1312p pd=7.3u as=3.9294p ps=7.84u w=6.66u l=0.6u
X3449 a_87276_93973# a_87507_93559# a_86962_93516# sg13cmos5l_Corner_1.vss sg13_lv_nmos ad=0.2373p pd=1.97u as=79.8f ps=0.8u w=0.42u l=0.13u
X3450 vdd a_95800_97542# a_95745_97637# vdd sg13_lv_pmos ad=1.07253p pd=6.75u as=93.45f ps=0.865u w=0.42u l=0.13u
X3451 data[1] sg13cmos5l_Corner_1.iovdd dpantenna l=1.26u w=27.78u
X3452 a_93612_92799# a_93843_92908# a_93298_93009# sg13cmos5l_Corner_1.vss sg13_lv_nmos ad=0.2373p pd=1.97u as=79.8f ps=0.8u w=0.42u l=0.13u
X3453 adc8b_0.side_cap8b_0.buf_16_0.z adc8b_0.side_cap8b_0.in_h_sw[2] sg13cmos5l_Corner_1.vss sg13cmos5l_Corner_1.vss sg13_lv_nmos ad=95f pd=0.88u as=95f ps=0.88u w=0.5u l=0.13u
X3454 sg13cmos5l_Corner_1.vss adc8b_0.sar12b_0.sg13cmos5l_buf_1_86.A a_102160_98084# sg13cmos5l_Corner_1.vss sg13_lv_nmos ad=0.14875p pd=1.16u as=0.187p ps=1.78u w=0.55u l=0.13u
X3455 data[0] a_70044_42476# sg13cmos5l_Corner_1.iovdd sg13cmos5l_Corner_1.iovdd sg13_hv_pmos ad=3.9294p pd=7.84u as=2.1312p ps=7.3u w=6.66u l=0.6u
X3456 sg13cmos5l_IOPadAnalog_16.pad a_178296_102044# sg13cmos5l_Corner_1.vss sg13cmos5l_Corner_1.vss sg13_hv_nmos ad=2.596p pd=5.58u as=1.408p ps=5.04u w=4.4u l=0.6u
X3457 adc8b_0.sar12b_0.sg13cmos5l_buf_1_1.A a_95824_92824# sg13cmos5l_Corner_1.vss sg13cmos5l_Corner_1.vss sg13_lv_nmos ad=0.2886p pd=2.26u as=0.14875p ps=1.16u w=0.74u l=0.13u
X3458 vdd sg13cmos5l_IOPadVdd$1_0.sg13cmos5l_Clamp_N43N43D4R$1_0.gate sg13cmos5l_Corner_1.vss sg13cmos5l_Corner_1.vss sg13_hv_nmos ad=2.596p pd=5.58u as=1.408p ps=5.04u w=4.4u l=0.6u
X3459 vdd a_92241_100346# a_92174_100784# vdd sg13_lv_pmos ad=0.2387p pd=1.84u as=0.1008p ps=0.9u w=0.42u l=0.13u
X3460 sg13cmos5l_Corner_1.vss a_86718_96859# adc8b_0.sar12b_0.sg13cmos5l_dlhr_1_5.GATE sg13cmos5l_Corner_1.vss sg13_lv_nmos ad=0.1406p pd=1.12u as=0.2516p ps=2.16u w=0.74u l=0.13u
X3461 vdd a_98519_93909# a_98776_93790# vdd sg13_lv_pmos ad=0.2639p pd=1.81u as=79.8f ps=0.8u w=0.42u l=0.13u
X3462 a_97644_96128# a_98163_95932# a_98903_95887# sg13cmos5l_Corner_1.vss sg13_lv_nmos ad=0.3473p pd=2.71u as=0.12665p ps=1.145u w=0.74u l=0.13u
X3463 a_99363_95107# a_98471_95031# a_99261_95107# vdd sg13_lv_pmos ad=63f pd=0.72u as=79.8f ps=0.8u w=0.42u l=0.13u
X3464 a_95466_96572# adc8b_0.sar12b_0.sg13cmos5l_dfrbp_1_23.Q a_95254_96572# vdd sg13_lv_pmos ad=0.2128p pd=1.5u as=0.2128p ps=1.5u w=1.12u l=0.13u
X3465 vdd adc8b_0.sar12b_0.sg13cmos5l_buf_1_64.A a_85744_100384# vdd sg13_lv_pmos ad=0.2114p pd=1.54u as=0.2856p ps=2.36u w=0.84u l=0.13u
X3466 vdd a_86615_95887# a_87452_96108# vdd sg13_lv_pmos ad=0.2128p pd=1.5u as=0.3864p ps=2.93u w=1.12u l=0.13u
X3467 cks a_30676_118044# sg13cmos5l_Corner_1.vss sg13cmos5l_Corner_1.vss sg13_hv_nmos ad=2.596p pd=5.58u as=1.408p ps=5.04u w=4.4u l=0.6u
X3468 adc8b_0.side_cap8b_0.buf_32_0.z adc8b_0.side_cap8b_0.in_l_sw[0] sg13cmos5l_Corner_1.vss sg13cmos5l_Corner_1.vss sg13_lv_nmos ad=95f pd=0.88u as=95f ps=0.88u w=0.5u l=0.13u
X3469 a_85367_94375# a_84525_94277# a_85273_94375# sg13cmos5l_Corner_1.vss sg13_lv_nmos ad=0.12665p pd=1.145u as=0.1428p ps=1.52u w=0.42u l=0.13u
X3470 adc8b_0.side_cap8b_1.buf_8_2.z adc8b_0.sar12b_0.nh_sw[4] vddr vddr sg13_lv_pmos ad=0.19p pd=1.38u as=0.19p ps=1.38u w=1u l=0.13u
X3471 sg13cmos5l_Corner_1.vss adc8b_0.sar12b_0.sg13cmos5l_dfrbp_1_6.RESET_B a_97836_97322# sg13cmos5l_Corner_1.vss sg13_lv_nmos ad=0.1626p pd=1.415u as=60.89999f ps=0.71u w=0.42u l=0.13u
X3472 sg13cmos5l_IOPadAnalog_10.pad a_67639_164698# sg13cmos5l_Corner_1.iovdd sg13cmos5l_Corner_1.iovdd sg13_hv_pmos ad=3.9294p pd=7.84u as=2.1312p ps=7.3u w=6.66u l=0.6u
X3473 sg13cmos5l_Corner_1.iovdd a_164624_70044# sg13cmos5l_IOPadAnalog_1.pad sg13cmos5l_Corner_1.iovdd sg13_hv_pmos ad=2.1312p pd=7.3u as=3.9294p ps=7.84u w=6.66u l=0.6u
X3474 sg13cmos5l_IOPadAnalog_9.pad a_83639_164698# sg13cmos5l_Corner_1.iovdd sg13cmos5l_Corner_1.iovdd sg13_hv_pmos ad=3.9294p pd=7.84u as=2.1312p ps=7.3u w=6.66u l=0.6u
X3475 a_88820_100310# adc8b_0.sar12b_0.sg13cmos5l_inv_1_14.A sg13cmos5l_Corner_1.vss sg13cmos5l_Corner_1.vss sg13_lv_nmos ad=0.187p pd=1.78u as=0.14875p ps=1.16u w=0.55u l=0.13u
X3476 vdd adc8b_0.sar12b_0.sg13cmos5l_dfrbp_1_6.RESET_B a_94929_98441# vdd sg13_lv_pmos ad=0.2128p pd=1.5u as=0.2128p ps=1.5u w=1.12u l=0.13u
X3477 adc8b_0.sar12b_0.sg13cmos5l_dlhr_1_6.D a_89564_97620# sg13cmos5l_Corner_1.vss sg13cmos5l_Corner_1.vss sg13_lv_nmos ad=0.2516p pd=2.16u as=0.1406p ps=1.12u w=0.74u l=0.13u
X3478 vdd sg13cmos5l_IOPadVdd$1_0.sg13cmos5l_Clamp_N43N43D4R$1_0.gate sg13cmos5l_Corner_1.vss sg13cmos5l_Corner_1.vss sg13_hv_nmos ad=2.596p pd=5.58u as=1.408p ps=5.04u w=4.4u l=0.6u
X3479 a_83348_93512# adc8b_0.sar12b_0.sg13cmos5l_buf_1_40.X vdd vdd sg13_lv_pmos ad=0.2856p pd=2.36u as=0.2114p ps=1.54u w=0.84u l=0.13u
X3480 adc8b_0.side_cap8b_0.buf_8_0.z adc8b_0.side_cap8b_0.in_l_sw[4] vddr vddr sg13_lv_pmos ad=0.19p pd=1.38u as=0.19p ps=1.38u w=1u l=0.13u
X3481 sg13cmos5l_Corner_1.vss a_83252_97286# adc8b_0.sar12b_0.sg13cmos5l_buf_1_40.A sg13cmos5l_Corner_1.vss sg13_lv_nmos ad=0.14875p pd=1.16u as=0.2886p ps=2.26u w=0.74u l=0.13u
X3482 sg13cmos5l_Corner_1.vss adc8b_0.sar12b_0.nl_sw[2] adc8b_0.side_cap8b_1.buf_16_1.z sg13cmos5l_Corner_1.vss sg13_lv_nmos ad=95f pd=0.88u as=0.17p ps=1.68u w=0.5u l=0.13u
X3483 sg13cmos5l_Corner_1.iovdd a_99639_164698# sg13cmos5l_IOPadAnalog_15.pad sg13cmos5l_Corner_1.iovdd sg13_hv_pmos ad=2.1312p pd=7.3u as=3.9294p ps=7.84u w=6.66u l=0.6u
X3484 sg13cmos5l_Corner_1.vss sg13cmos5l_IOPadVdd$1_0.sg13cmos5l_Clamp_N43N43D4R$1_0.gate vdd sg13cmos5l_Corner_1.vss sg13_hv_nmos ad=1.408p pd=5.04u as=2.596p ps=5.58u w=4.4u l=0.6u
X3485 vddr a_30676_70044# sg13cmos5l_Corner_1.vss sg13cmos5l_Corner_1.vss sg13_hv_nmos ad=2.596p pd=5.58u as=1.408p ps=5.04u w=4.4u l=0.6u
X3486 sg13cmos5l_Corner_1.vss vdd sg13cmos5l_Corner_1.vss sg13cmos5l_Corner_1.vss sg13_lv_nmos ad=0.1428p pd=1.52u as=0 ps=0 w=0.42u l=1u
X3487 vdd adc8b_0.sar12b_0.sg13cmos5l_dfrbp_1_0.RESET_B a_97234_93516# vdd sg13_lv_pmos ad=0.1563p pd=1.22u as=0.147p ps=1.54u w=0.42u l=0.13u
X3488 adc8b_0.sar12b_0.sg13cmos5l_dlhr_1_16.Q a_100977_96929# vdd vdd sg13_lv_pmos ad=0.3808p pd=2.92u as=0.2128p ps=1.5u w=1.12u l=0.13u
X3489 sg13cmos5l_Corner_1.iovdd a_164624_102044# sg13cmos5l_IOPadAnalog_16.pad sg13cmos5l_Corner_1.iovdd sg13_hv_pmos ad=3.1302p pd=14.26u as=3.9294p ps=7.84u w=6.66u l=0.6u
X3490 sg13cmos5l_Corner_1.iovdd a_115639_164698# sg13cmos5l_IOPadAnalog_13.pad sg13cmos5l_Corner_1.iovdd sg13_hv_pmos ad=2.1312p pd=7.3u as=3.9294p ps=7.84u w=6.66u l=0.6u
X3491 a_93550_95485# adc8b_0.sar12b_0.sg13cmos5l_dfrbp_1_0.RESET_B sg13cmos5l_Corner_1.vss sg13cmos5l_Corner_1.vss sg13_lv_nmos ad=37.8f pd=0.6u as=0.1701p ps=1.65u w=0.42u l=0.13u
X3492 sg13cmos5l_Corner_1.vss adc8b_0.sar12b_0.nh_sw[0] adc8b_0.side_cap8b_1.buf_32_1.z sg13cmos5l_Corner_1.vss sg13_lv_nmos ad=95f pd=0.88u as=95f ps=0.88u w=0.5u l=0.13u
X3493 vin a_42476_86044# sg13cmos5l_Corner_1.iovdd sg13cmos5l_Corner_1.iovdd sg13_hv_pmos ad=3.9294p pd=7.84u as=2.1312p ps=7.3u w=6.66u l=0.6u
X3494 sg13cmos5l_Corner_1.vss adc8b_0.side_cap8b_0.in_h_sw[0] adc8b_0.side_cap8b_0.buf_32_1.z sg13cmos5l_Corner_1.vss sg13_lv_nmos ad=95f pd=0.88u as=95f ps=0.88u w=0.5u l=0.13u
X3495 a_84495_97540# a_84647_97592# vdd vdd sg13_lv_pmos ad=0.3864p pd=2.93u as=1.07253p ps=6.75u w=1.12u l=0.13u
X3496 sg13cmos5l_Corner_1.vss a_90609_96929# a_91134_97002# sg13cmos5l_Corner_1.vss sg13_lv_nmos ad=0.1491p pd=1.18u as=0.187p ps=1.78u w=0.55u l=0.13u
X3497 vddr adc8b_0.side_cap8b_0.in_h_sw[8] adc8b_0.side_cap8b_0.buf_2_0.z vddr sg13_lv_pmos ad=0.19p pd=1.38u as=0.34p ps=2.68u w=1u l=0.13u
X3498 sg13cmos5l_Corner_1.iovdd a_86044_42476# data[1] sg13cmos5l_Corner_1.iovdd sg13_hv_pmos ad=2.1312p pd=7.3u as=3.9294p ps=7.84u w=6.66u l=0.6u
X3499 sg13cmos5l_IOPadVdd$1_0.sg13cmos5l_Clamp_N43N43D4R$1_0.gate sg13cmos5l_IOPadVdd$1_0.sg13cmos5l_RCClampInverter$1_0.in vdd vdd sg13_hv_pmos ad=1.33p pd=7.38u as=2.38p ps=14.68u w=7u l=0.5u
X3500 a_99468_94616# a_99442_94521# vdd vdd sg13_lv_pmos ad=0.34p pd=2.68u as=0.36237p ps=2.605u w=1u l=0.13u
X3501 a_85460_100310# adc8b_0.sar12b_0.sg13cmos5l_inv_1_17.A vdd vdd sg13_lv_pmos ad=0.2856p pd=2.36u as=0.2114p ps=1.54u w=0.84u l=0.13u
X3502 a_95254_96572# adc8b_0.sar12b_0.sg13cmos5l_nor2b_1_0.Y vdd vdd sg13_lv_pmos ad=0.2128p pd=1.5u as=0.3808p ps=2.92u w=1.12u l=0.13u
X3503 sg13cmos5l_IOPadAnalog_15.pad a_99639_164698# sg13cmos5l_Corner_1.iovdd sg13cmos5l_Corner_1.iovdd sg13_hv_pmos ad=3.9294p pd=7.84u as=3.1302p ps=14.26u w=6.66u l=0.6u
X3504 a_100728_96572# a_100177_96930# vdd vdd sg13_lv_pmos ad=0.105p pd=1.21u as=1.28962p ps=8.195u w=1u l=0.13u
X3505 vip a_30676_102044# sg13cmos5l_Corner_1.vss sg13cmos5l_Corner_1.vss sg13_hv_nmos ad=2.596p pd=5.58u as=1.408p ps=5.04u w=4.4u l=0.6u
X3506 a_97742_97322# a_98547_97444# a_98002_97545# vdd sg13_lv_pmos ad=0.1428p pd=1.52u as=79.8f ps=0.8u w=0.42u l=0.13u
X3507 data[2] a_102160_95060# vdd vdd sg13_lv_pmos ad=0.42p pd=2.99u as=0.2114p ps=1.54u w=1.12u l=0.13u
X3508 adc8b_0.sar12b_0.sg13cmos5l_nor2_1_1.A a_99356_93548# vdd vdd sg13_lv_pmos ad=0.3808p pd=2.92u as=0.2128p ps=1.5u w=1.12u l=0.13u
X3509 sg13cmos5l_Corner_1.vss a_30676_118044# sg13cmos5l_Corner_1.vss rppd l=3.54u w=0.5u
X3510 a_91028_93512# adc8b_0.sar12b_0.sg13cmos5l_buf_1_30.X vdd vdd sg13_lv_pmos ad=0.2856p pd=2.36u as=0.2114p ps=1.54u w=0.84u l=0.13u
X3511 vddr a_42476_70044# sg13cmos5l_Corner_1.iovdd sg13cmos5l_Corner_1.iovdd sg13_hv_pmos ad=3.9294p pd=7.84u as=2.1312p ps=7.3u w=6.66u l=0.6u
X3512 sg13cmos5l_Corner_1.vss adc8b_0.sar12b_0.sg13cmos5l_dfrbp_1_23.Q_N a_96145_96930# sg13cmos5l_Corner_1.vss sg13_lv_nmos ad=0.15055p pd=1.17u as=0.187p ps=1.78u w=0.55u l=0.13u
X3513 adc8b_0.side_cap8b_1.buf_8_3.z adc8b_0.sar12b_0.nh_sw[3] sg13cmos5l_Corner_1.vss sg13cmos5l_Corner_1.vss sg13_lv_nmos ad=95f pd=0.88u as=95f ps=0.88u w=0.5u l=0.13u
X3514 vddr adc8b_0.sar12b_0.nl_sw[2] adc8b_0.side_cap8b_1.buf_16_1.z vddr sg13_lv_pmos ad=0.19p pd=1.38u as=0.19p ps=1.38u w=1u l=0.13u
X3515 vdd adc8b_0.sar12b_0.sg13cmos5l_inv_1_27.Y a_96400_100384# vdd sg13_lv_pmos ad=0.2114p pd=1.54u as=0.2856p ps=2.36u w=0.84u l=0.13u
X3516 vdd a_99544_97542# a_99489_97637# vdd sg13_lv_pmos ad=1.07253p pd=6.75u as=93.45f ps=0.865u w=0.42u l=0.13u
X3517 a_82292_95774# adc8b_0.sar12b_0.sg13cmos5l_buf_1_43.A sg13cmos5l_Corner_1.vss sg13cmos5l_Corner_1.vss sg13_lv_nmos ad=0.187p pd=1.78u as=0.14875p ps=1.16u w=0.55u l=0.13u
X3518 sg13cmos5l_Corner_1.vss adc8b_0.sar12b_0.sg13cmos5l_nor2_1_1.A adc8b_0.sar12b_0.sg13cmos5l_nor2b_1_1.Y sg13cmos5l_Corner_1.vss sg13_lv_nmos ad=0.2516p pd=2.16u as=0.1406p ps=1.12u w=0.74u l=0.13u
X3519 a_84412_95796# a_83996_96132# a_84177_95810# sg13cmos5l_Corner_1.vss sg13_lv_nmos ad=77.7f pd=0.95u as=0.2516p ps=2.16u w=0.74u l=0.13u
X3520 a_88766_96997# a_87588_96933# a_88370_96852# sg13cmos5l_Corner_1.vss sg13_lv_nmos ad=37.8f pd=0.6u as=0.1428p ps=1.52u w=0.42u l=0.13u
X3521 adc8b_0.side_cap8b_0.buf_8_5.z adc8b_0.side_cap8b_0.in_h_sw[5] sg13cmos5l_Corner_1.vss sg13cmos5l_Corner_1.vss sg13_lv_nmos ad=95f pd=0.88u as=95f ps=0.88u w=0.5u l=0.13u
X3522 sg13cmos5l_Corner_1.vss a_178296_70044# sg13cmos5l_IOPadAnalog_1.pad sg13cmos5l_Corner_1.vss sg13_hv_nmos ad=1.408p pd=5.04u as=2.596p ps=5.58u w=4.4u l=0.6u
X3523 sg13cmos5l_IOPadAnalog_0.pad a_178296_86044# sg13cmos5l_Corner_1.vss sg13cmos5l_Corner_1.vss sg13_hv_nmos ad=2.596p pd=5.58u as=1.408p ps=5.04u w=4.4u l=0.6u
X3524 sg13cmos5l_Corner_1.vss a_98519_93909# a_99356_93548# sg13cmos5l_Corner_1.vss sg13_lv_nmos ad=0.1406p pd=1.12u as=0.2516p ps=2.16u w=0.74u l=0.13u
X3525 sg13cmos5l_IOPadAnalog_12.pad a_131639_178370# sg13cmos5l_Corner_1.vss sg13cmos5l_Corner_1.vss sg13_hv_nmos ad=2.596p pd=5.58u as=1.408p ps=5.04u w=4.4u l=0.6u
X3526 a_92942_93986# adc8b_0.sar12b_0.sg13cmos5l_dfrbp_1_4.D vdd vdd sg13_lv_pmos ad=79.8f pd=0.8u as=0.1428p ps=1.52u w=0.42u l=0.13u
X3527 a_83992_96814# adc8b_0.sar12b_0.sg13cmos5l_dfrbp_1_6.RESET_B vdd vdd sg13_lv_pmos ad=79.8f pd=0.8u as=1.28962p ps=8.195u w=0.42u l=0.13u
X3528 vddr adc8b_0.sar12b_0.nh_sw[3] adc8b_0.side_cap8b_1.buf_8_3.z vddr sg13_lv_pmos ad=0.19p pd=1.38u as=0.34p ps=2.68u w=1u l=0.13u
X3529 vdd a_87956_92750# adc8b_0.sar12b_0.sg13cmos5l_buf_1_25.X vdd sg13_lv_pmos ad=0.2114p pd=1.54u as=0.42p ps=2.99u w=1.12u l=0.13u
X3530 a_98708_94262# adc8b_0.sar12b_0.sg13cmos5l_buf_1_4.X vdd vdd sg13_lv_pmos ad=0.2856p pd=2.36u as=0.2114p ps=1.54u w=0.84u l=0.13u
X3531 adc8b_0.side_cap8b_0.buf_16_3.z adc8b_0.side_cap8b_0.in_h_sw[1] vddr vddr sg13_lv_pmos ad=0.19p pd=1.38u as=0.19p ps=1.38u w=1u l=0.13u
X3532 vdd adc8b_0.sar12b_0.sg13cmos5l_inv_1_1.A adc8b_0.sar12b_0.sg13cmos5l_buf_1_2.A vdd sg13_lv_pmos ad=0.3808p pd=2.92u as=0.3808p ps=2.92u w=1.12u l=0.13u
X3533 sg13cmos5l_Corner_1.vss a_30676_86044# vin sg13cmos5l_Corner_1.vss sg13_hv_nmos ad=1.408p pd=5.04u as=2.596p ps=5.58u w=4.4u l=0.6u
X3534 adc8b_0.side_cap8b_0.buf_8_5.z adc8b_0.side_cap8b_0.in_h_sw[5] vddr vddr sg13_lv_pmos ad=0.34p pd=2.68u as=0.19p ps=1.38u w=1u l=0.13u
X3535 sg13cmos5l_Corner_1.vss a_94840_93006# a_94489_92863# sg13cmos5l_Corner_1.vss sg13_lv_nmos ad=79.8f pd=0.8u as=0.1428p ps=1.52u w=0.42u l=0.13u
X3536 sg13cmos5l_Corner_1.iovdd a_67639_164698# sg13cmos5l_IOPadAnalog_10.pad sg13cmos5l_Corner_1.iovdd sg13_hv_pmos ad=2.1312p pd=7.3u as=3.9294p ps=7.84u w=6.66u l=0.6u
X3537 a_93645_93559# adc8b_0.sar12b_0.sg13cmos5l_dfrbp_1_0.CLK vdd vdd sg13_lv_pmos ad=0.4088p pd=2.97u as=1.777p ps=11.395u w=1.12u l=0.13u
X3538 a_86988_93552# a_87507_93559# a_88247_93909# sg13cmos5l_Corner_1.vss sg13_lv_nmos ad=0.3473p pd=2.71u as=0.12665p ps=1.145u w=0.74u l=0.13u
X3539 sg13cmos5l_Corner_1.iovdd a_83639_164698# sg13cmos5l_IOPadAnalog_9.pad sg13cmos5l_Corner_1.iovdd sg13_hv_pmos ad=2.1312p pd=7.3u as=3.9294p ps=7.84u w=6.66u l=0.6u
X3540 sg13cmos5l_IOPadAnalog_10.padres sg13cmos5l_Corner_1.iovdd dpantenna l=0.64u w=4.98u
X3541 sg13cmos5l_Corner_1.vss adc8b_0.side_cap8b_0.in_h_sw[10] adc8b_0.side_cap8b_0.buf_1_1.z sg13cmos5l_Corner_1.vss sg13_lv_nmos ad=0.17p pd=1.68u as=0.17p ps=1.68u w=0.5u l=0.13u
X3542 vdd a_84333_99607# a_84435_99607# vdd sg13_lv_pmos ad=1.15047p pd=7.175u as=0.3864p ps=2.93u w=1.12u l=0.13u
X3543 a_97068_98847# a_97299_98956# a_96754_99057# sg13cmos5l_Corner_1.vss sg13_lv_nmos ad=0.2373p pd=1.97u as=79.8f ps=0.8u w=0.42u l=0.13u
X3544 a_85713_96201# a_85356_96128# vdd vdd sg13_lv_pmos ad=63f pd=0.72u as=0.1563p ps=1.22u w=0.42u l=0.13u
X3545 sg13cmos5l_Corner_1.iovdd a_86044_42476# data[1] sg13cmos5l_Corner_1.iovdd sg13_hv_pmos ad=2.1312p pd=7.3u as=3.9294p ps=7.84u w=6.66u l=0.6u
X3546 sg13cmos5l_Corner_1.vss vdd sg13cmos5l_Corner_1.vss sg13cmos5l_Corner_1.vss sg13_lv_nmos ad=79.8f pd=0.8u as=0 ps=0 w=0.42u l=1u
X3547 a_94884_98486# a_94335_98442# a_94748_98084# sg13cmos5l_Corner_1.vss sg13_lv_nmos ad=47.25f pd=0.645u as=0.141p ps=1.17u w=0.42u l=0.13u
X3548 vdd adc8b_0.sar12b_0.sg13cmos5l_dfrbp_1_23.Q_N a_96145_96930# vdd sg13_lv_pmos ad=1.28962p pd=8.195u as=0.2856p ps=2.36u w=0.84u l=0.13u
X3549 vdd a_86872_96030# a_86817_96125# vdd sg13_lv_pmos ad=1.28962p pd=8.195u as=93.45f ps=0.865u w=0.42u l=0.13u
X3550 adc8b_0.sar12b_0.sg13cmos5l_nor2b_1_0.Y adc8b_0.sar12b_0.sg13cmos5l_inv_1_0.A a_94804_96108# vdd sg13_lv_pmos ad=0.3808p pd=2.92u as=0.1176p ps=1.33u w=1.12u l=0.13u
X3551 adc8b_0.sar12b_0.sg13cmos5l_buf_1_34.X a_86608_92824# sg13cmos5l_Corner_1.vss sg13cmos5l_Corner_1.vss sg13_lv_nmos ad=0.2886p pd=2.26u as=0.14875p ps=1.16u w=0.74u l=0.13u
X3552 adc8b_0.side_cap8b_0.buf_4_1.z adc8b_0.side_cap8b_0.in_h_sw[6] sg13cmos5l_Corner_1.vss sg13cmos5l_Corner_1.vss sg13_lv_nmos ad=95f pd=0.88u as=95f ps=0.88u w=0.5u l=0.13u
X3553 sg13cmos5l_Corner_1.vss a_32962_86222# dantenna l=27.78u w=1.26u
X3554 adc8b_0.sar12b_0.sg13cmos5l_buf_1_104.X a_101392_99596# sg13cmos5l_Corner_1.vss sg13cmos5l_Corner_1.vss sg13_lv_nmos ad=0.2886p pd=2.26u as=0.14875p ps=1.16u w=0.74u l=0.13u
X3555 a_93900_100664# a_93874_100569# vdd vdd sg13_lv_pmos ad=0.34p pd=2.68u as=0.36237p ps=2.605u w=1u l=0.13u
X3556 sg13cmos5l_Corner_1.vss adc8b_0.sar12b_0.nh_sw[5] adc8b_0.side_cap8b_1.buf_8_5.z sg13cmos5l_Corner_1.vss sg13_lv_nmos ad=95f pd=0.88u as=95f ps=0.88u w=0.5u l=0.13u
X3557 a_89972_93512# adc8b_0.sar12b_0.sg13cmos5l_dlhr_1_2.Q sg13cmos5l_Corner_1.vss sg13cmos5l_Corner_1.vss sg13_lv_nmos ad=0.187p pd=1.78u as=0.14875p ps=1.16u w=0.55u l=0.13u
X3558 vdd sg13cmos5l_IOPadVdd$1_0.sg13cmos5l_Clamp_N43N43D4R$1_0.gate sg13cmos5l_Corner_1.vss sg13cmos5l_Corner_1.vss sg13_hv_nmos ad=2.596p pd=5.58u as=1.408p ps=5.04u w=4.4u l=0.6u
X3559 adc8b_0.side_cap8b_0.in_h_sw[0] a_82384_100384# sg13cmos5l_Corner_1.vss sg13cmos5l_Corner_1.vss sg13_lv_nmos ad=0.2886p pd=2.26u as=0.14875p ps=1.16u w=0.74u l=0.13u
X3560 adc8b_0.diff_bsw_0.single_bsw_1.sg13cmos5l_inv_1$1_0.A cks sg13cmos5l_Corner_1.vss sg13cmos5l_Corner_1.vss sg13_lv_nmos ad=0.2516p pd=2.16u as=0.2516p ps=2.16u w=0.74u l=0.13u
X3561 sg13cmos5l_IOPadAnalog_1.pad a_164624_70044# sg13cmos5l_Corner_1.iovdd sg13cmos5l_Corner_1.iovdd sg13_hv_pmos ad=3.9294p pd=7.84u as=2.1312p ps=7.3u w=6.66u l=0.6u
X3562 sg13cmos5l_Corner_1.iovdd a_118044_42476# cko sg13cmos5l_Corner_1.iovdd sg13_hv_pmos ad=2.1312p pd=7.3u as=3.9294p ps=7.84u w=6.66u l=0.6u
X3563 a_96780_99152# a_97299_98956# a_98039_98911# sg13cmos5l_Corner_1.vss sg13_lv_nmos ad=0.3473p pd=2.71u as=0.12665p ps=1.145u w=0.74u l=0.13u
X3564 data[2] a_102044_42476# sg13cmos5l_Corner_1.iovdd sg13cmos5l_Corner_1.iovdd sg13_hv_pmos ad=3.9294p pd=7.84u as=2.1312p ps=7.3u w=6.66u l=0.6u
X3565 sg13cmos5l_Corner_1.vss a_178296_86044# sg13cmos5l_IOPadAnalog_0.pad sg13cmos5l_Corner_1.vss sg13_hv_nmos ad=1.408p pd=5.04u as=2.596p ps=5.58u w=4.4u l=0.6u
X3566 sg13cmos5l_IOPadAnalog_10.pad a_67639_164698# sg13cmos5l_Corner_1.iovdd sg13cmos5l_Corner_1.iovdd sg13_hv_pmos ad=3.9294p pd=7.84u as=3.1302p ps=14.26u w=6.66u l=0.6u
X3567 a_92218_100034# adc8b_0.sar12b_0.sg13cmos5l_dfrbp_1_8.RESET_B sg13cmos5l_Corner_1.vss sg13cmos5l_Corner_1.vss sg13_lv_nmos ad=37.8f pd=0.6u as=79.8f ps=0.8u w=0.42u l=0.13u
X3568 sg13cmos5l_Corner_1.vss a_101780_93512# adc8b_0.sar12b_0.nl_sw[10] sg13cmos5l_Corner_1.vss sg13_lv_nmos ad=0.14875p pd=1.16u as=0.2886p ps=2.26u w=0.74u l=0.13u
X3569 a_36456_133435# a_40542_133765# sg13cmos5l_Corner_1.vss rppd l=20u w=1u
X3570 sg13cmos5l_Corner_1.vss adc8b_0.sar12b_0.sg13cmos5l_or2_1_0.A a_100248_96188# sg13cmos5l_Corner_1.vss sg13_lv_nmos ad=0.1469p pd=1.155u as=0.1045p ps=0.93u w=0.55u l=0.13u
X3571 sg13cmos5l_IOPadVdd$1_0.sg13cmos5l_Clamp_N43N43D4R$1_0.gate sg13cmos5l_IOPadVdd$1_0.sg13cmos5l_RCClampInverter$1_0.in vdd vdd sg13_hv_pmos ad=1.33p pd=7.38u as=1.33p ps=7.38u w=7u l=0.5u
X3572 a_90756_97358# a_90207_97338# a_90620_97644# sg13cmos5l_Corner_1.vss sg13_lv_nmos ad=47.25f pd=0.645u as=0.141p ps=1.17u w=0.42u l=0.13u
X3573 a_82833_96619# a_82476_96576# vdd vdd sg13_lv_pmos ad=63f pd=0.72u as=0.1563p ps=1.22u w=0.42u l=0.13u
X3574 adc8b_0.side_cap8b_0.buf_32_0.z adc8b_0.side_cap8b_0.in_l_sw[0] vddr vddr sg13_lv_pmos ad=0.19p pd=1.38u as=0.19p ps=1.38u w=1u l=0.13u
X3575 a_90564_96974# a_90015_96930# a_90428_96572# sg13cmos5l_Corner_1.vss sg13_lv_nmos ad=47.25f pd=0.645u as=0.141p ps=1.17u w=0.42u l=0.13u
X3576 a_99537_93177# a_99180_93104# vdd vdd sg13_lv_pmos ad=63f pd=0.72u as=0.1563p ps=1.22u w=0.42u l=0.13u
X3577 sg13cmos5l_Corner_1.iovdd a_42476_86044# vin sg13cmos5l_Corner_1.iovdd sg13_hv_pmos ad=2.1312p pd=7.3u as=3.9294p ps=7.84u w=6.66u l=0.6u
X3578 vdd sg13cmos5l_Corner_1.vss vdd vdd sg13_lv_pmos ad=0.19p pd=1.38u as=0 ps=0 w=1u l=1u
X3579 adc8b_0.sar12b_0.sg13cmos5l_dlhr_1_0.Q a_89457_92786# sg13cmos5l_Corner_1.vss sg13cmos5l_Corner_1.vss sg13_lv_nmos ad=0.2516p pd=2.16u as=0.1406p ps=1.12u w=0.74u l=0.13u
X3580 sg13cmos5l_Corner_1.vss a_88820_100310# adc8b_0.sar12b_0.sg13cmos5l_buf_1_76.X sg13cmos5l_Corner_1.vss sg13_lv_nmos ad=0.14875p pd=1.16u as=0.2886p ps=2.26u w=0.74u l=0.13u
X3581 a_83724_100034# adc8b_0.sar12b_0.sg13cmos5l_dfrbp_1_17.D a_83630_100034# sg13cmos5l_Corner_1.vss sg13_lv_nmos ad=60.89999f pd=0.71u as=0.1428p ps=1.52u w=0.42u l=0.13u
X3582 sg13cmos5l_Corner_1.vss adc8b_0.sar12b_0.sg13cmos5l_inv_1_0.A adc8b_0.sar12b_0.sg13cmos5l_nor2b_1_0.Y sg13cmos5l_Corner_1.vss sg13_lv_nmos ad=0.2516p pd=2.16u as=0.1406p ps=1.12u w=0.74u l=0.13u
X3583 sg13cmos5l_Corner_1.vss a_97677_93559# a_97779_93559# sg13cmos5l_Corner_1.vss sg13_lv_nmos ad=2.59257p pd=16.445u as=0.2516p ps=2.16u w=0.74u l=0.13u
X3584 sg13cmos5l_Corner_1.iovdd a_99639_164698# sg13cmos5l_IOPadAnalog_15.pad sg13cmos5l_Corner_1.iovdd sg13_hv_pmos ad=2.1312p pd=7.3u as=3.9294p ps=7.84u w=6.66u l=0.6u
X3585 sg13cmos5l_Corner_1.vss adc8b_0.sar12b_0.sg13cmos5l_inv_1_28.Y a_93232_100384# sg13cmos5l_Corner_1.vss sg13_lv_nmos ad=0.14875p pd=1.16u as=0.187p ps=1.78u w=0.55u l=0.13u
X3586 a_93592_99054# adc8b_0.sar12b_0.sg13cmos5l_dfrbp_1_6.RESET_B vdd vdd sg13_lv_pmos ad=79.8f pd=0.8u as=1.12242p ps=7u w=0.42u l=0.13u
X3587 vdd adc8b_0.sar12b_0.sg13cmos5l_nor2_1_1.A adc8b_0.sar12b_0.sg13cmos5l_nand2_1_1.B vdd sg13_lv_pmos ad=0.2198p pd=1.53u as=0.2128p ps=1.5u w=1.12u l=0.13u
X3588 a_96370_99564# a_96813_99607# a_96753_99643# vdd sg13_lv_pmos ad=79.8f pd=0.8u as=63f ps=0.72u w=0.42u l=0.13u
X3589 a_99406_92799# adc8b_0.sar12b_0.sg13cmos5l_dfrbp_1_0.RESET_B sg13cmos5l_Corner_1.vss sg13cmos5l_Corner_1.vss sg13_lv_nmos ad=37.8f pd=0.6u as=0.1701p ps=1.65u w=0.42u l=0.13u
X3590 a_96754_99057# a_97197_98813# a_97137_99225# vdd sg13_lv_pmos ad=79.8f pd=0.8u as=63f ps=0.72u w=0.42u l=0.13u
X3591 sg13cmos5l_IOPadAnalog_9.pad a_83639_178370# sg13cmos5l_Corner_1.vss sg13cmos5l_Corner_1.vss sg13_hv_nmos ad=2.596p pd=5.58u as=1.408p ps=5.04u w=4.4u l=0.6u
X3592 a_88173_99607# adc8b_0.sar12b_0.sg13cmos5l_inv_1_8.A sg13cmos5l_Corner_1.vss sg13cmos5l_Corner_1.vss sg13_lv_nmos ad=0.2516p pd=2.16u as=2.71505p ps=17.54u w=0.74u l=0.13u
X3593 adc8b_0.sar12b_0.sg13cmos5l_dfrbp_1_3.Q_N a_100727_94375# vdd vdd sg13_lv_pmos ad=0.4312p pd=3.01u as=0.2639p ps=1.81u w=1.12u l=0.13u
X3594 vdd a_85367_94375# a_85624_94518# vdd sg13_lv_pmos ad=0.2639p pd=1.81u as=79.8f ps=0.8u w=0.42u l=0.13u
X3595 sg13cmos5l_Corner_1.vss a_115639_178370# sg13cmos5l_Corner_1.vss rppd l=3.54u w=0.5u
X3596 data[2] a_102160_95060# sg13cmos5l_Corner_1.vss sg13cmos5l_Corner_1.vss sg13_lv_nmos ad=0.2886p pd=2.26u as=0.14875p ps=1.16u w=0.74u l=0.13u
X3597 sg13cmos5l_IOPadAnalog_1.pad a_164624_70044# sg13cmos5l_Corner_1.iovdd sg13cmos5l_Corner_1.iovdd sg13_hv_pmos ad=3.9294p pd=7.84u as=2.1312p ps=7.3u w=6.66u l=0.6u
X3598 a_97125_92976# adc8b_0.sar12b_0.sg13cmos5l_dfrbp_1_0.Q sg13cmos5l_Corner_1.vss sg13cmos5l_Corner_1.vss sg13_lv_nmos ad=0.187p pd=1.78u as=0.14505p ps=1.15u w=0.55u l=0.13u
X3599 adc8b_0.side_cap8b_0.buf_32_1.z adc8b_0.side_cap8b_0.in_h_sw[0] sg13cmos5l_Corner_1.vss sg13cmos5l_Corner_1.vss sg13_lv_nmos ad=95f pd=0.88u as=95f ps=0.88u w=0.5u l=0.13u
X3600 sg13cmos5l_Corner_1.vss a_95252_99560# adc8b_0.sar12b_0.sg13cmos5l_buf_1_5.A sg13cmos5l_Corner_1.vss sg13_lv_nmos ad=0.14875p pd=1.16u as=0.2886p ps=2.26u w=0.74u l=0.13u
X3601 sg13cmos5l_IOPadAnalog_16.pad a_164624_102044# sg13cmos5l_Corner_1.iovdd sg13cmos5l_Corner_1.iovdd sg13_hv_pmos ad=3.9294p pd=7.84u as=2.1312p ps=7.3u w=6.66u l=0.6u
X3602 sg13cmos5l_Corner_1.vss adc8b_0.sar12b_0.sg13cmos5l_nor2_1_0.A a_94582_95852# sg13cmos5l_Corner_1.vss sg13_lv_nmos ad=0.17255p pd=1.25u as=0.187p ps=1.78u w=0.55u l=0.13u
X3603 sg13cmos5l_Corner_1.vss a_98036_92750# adc8b_0.sar12b_0.nl_sw[7] sg13cmos5l_Corner_1.vss sg13_lv_nmos ad=0.14875p pd=1.16u as=0.2886p ps=2.26u w=0.74u l=0.13u
X3604 sg13cmos5l_Corner_1.vss a_131639_178370# sg13cmos5l_IOPadAnalog_12.pad sg13cmos5l_Corner_1.vss sg13_hv_nmos ad=1.408p pd=5.04u as=2.596p ps=5.58u w=4.4u l=0.6u
X3605 a_86079_98870# a_85444_99124# sg13cmos5l_Corner_1.vss sg13cmos5l_Corner_1.vss sg13_lv_nmos ad=47.25f pd=0.645u as=0.1428p ps=1.52u w=0.42u l=0.13u
X3606 vdd a_100977_96929# a_101502_97002# vdd sg13_lv_pmos ad=0.1974p pd=1.5u as=0.2856p ps=2.36u w=0.84u l=0.13u
X3607 vdd a_100696_93006# a_100641_93101# vdd sg13_lv_pmos ad=1.86162p pd=11.935u as=93.45f ps=0.865u w=0.42u l=0.13u
X3608 vddr adc8b_0.side_cap8b_0.in_h_sw[0] adc8b_0.side_cap8b_0.buf_32_1.z vddr sg13_lv_pmos ad=0.19p pd=1.38u as=0.19p ps=1.38u w=1u l=0.13u
X3609 a_89588_93512# adc8b_0.sar12b_0.sg13cmos5l_dlhr_1_0.Q sg13cmos5l_Corner_1.vss sg13cmos5l_Corner_1.vss sg13_lv_nmos ad=0.187p pd=1.78u as=0.14875p ps=1.16u w=0.55u l=0.13u
X3610 sg13cmos5l_Corner_1.iovdd a_67639_164698# sg13cmos5l_Corner_1.iovdd rppd l=12.9u w=0.5u
X3611 adc8b_0.side_cap8b_0.buf_8_1.z adc8b_0.side_cap8b_0.in_l_sw[3] sg13cmos5l_Corner_1.vss sg13cmos5l_Corner_1.vss sg13_lv_nmos ad=95f pd=0.88u as=95f ps=0.88u w=0.5u l=0.13u
X3612 a_89631_98442# adc8b_0.sar12b_0.sg13cmos5l_dlhr_1_5.GATE vdd vdd sg13_lv_pmos ad=0.3234p pd=2.45u as=1.04815p ps=6.595u w=0.84u l=0.13u
X3613 sg13cmos5l_Corner_1.vss adc8b_0.sar12b_0.sg13cmos5l_dfrbp_1_0.RESET_B a_94860_94298# sg13cmos5l_Corner_1.vss sg13_lv_nmos ad=0.1626p pd=1.415u as=60.89999f ps=0.71u w=0.42u l=0.13u
X3614 sg13cmos5l_Corner_1.vss a_100439_92863# a_101276_93084# sg13cmos5l_Corner_1.vss sg13_lv_nmos ad=0.1406p pd=1.12u as=0.2516p ps=2.16u w=0.74u l=0.13u
X3615 a_98039_98911# a_97197_98813# a_97945_98911# sg13cmos5l_Corner_1.vss sg13_lv_nmos ad=0.12665p pd=1.145u as=0.1428p ps=1.52u w=0.42u l=0.13u
X3616 a_96813_99607# adc8b_0.sar12b_0.sg13cmos5l_inv_1_2.A vdd vdd sg13_lv_pmos ad=0.4088p pd=2.97u as=1.12242p ps=7u w=1.12u l=0.13u
X3617 a_82450_96540# a_82893_96583# a_82833_96619# vdd sg13_lv_pmos ad=79.8f pd=0.8u as=63f ps=0.72u w=0.42u l=0.13u
X3618 sg13cmos5l_Corner_1.iovdd a_42476_102044# vip sg13cmos5l_Corner_1.iovdd sg13_hv_pmos ad=2.1312p pd=7.3u as=3.9294p ps=7.84u w=6.66u l=0.6u
X3619 a_85940_92750# adc8b_0.sar12b_0.sg13cmos5l_buf_1_38.A sg13cmos5l_Corner_1.vss sg13cmos5l_Corner_1.vss sg13_lv_nmos ad=0.187p pd=1.78u as=0.14875p ps=1.16u w=0.55u l=0.13u
X3620 vdd a_101396_93512# adc8b_0.sar12b_0.nh_sw[9] vdd sg13_lv_pmos ad=0.2114p pd=1.54u as=0.42p ps=2.99u w=1.12u l=0.13u
X3621 sg13cmos5l_IOPadAnalog_12.pad a_131639_178370# sg13cmos5l_Corner_1.vss sg13cmos5l_Corner_1.vss sg13_hv_nmos ad=2.596p pd=5.58u as=1.408p ps=5.04u w=4.4u l=0.6u
X3622 sg13cmos5l_IOPadAnalog_15.pad sg13cmos5l_IOPadAnalog_15.padres sg13cmos5l_Corner_1.vss rppd l=2u w=1u
X3623 sg13cmos5l_Corner_1.vss sg13cmos5l_IOPadVdd$1_0.sg13cmos5l_Clamp_N43N43D4R$1_0.gate vdd sg13cmos5l_Corner_1.vss sg13_hv_nmos ad=1.408p pd=5.04u as=2.596p ps=5.58u w=4.4u l=0.6u
X3624 sg13cmos5l_Corner_1.vss cks a_100995_100350# sg13cmos5l_Corner_1.vss sg13_lv_nmos ad=0.1406p pd=1.12u as=0.1406p ps=1.12u w=0.74u l=0.13u
X3625 a_96582_95036# adc8b_0.sar12b_0.sg13cmos5l_a22oi_1_1.B1 adc8b_0.sar12b_0.sg13cmos5l_a22oi_1_1.Y vdd sg13_lv_pmos ad=0.2716p pd=1.605u as=0.2128p ps=1.5u w=1.12u l=0.13u
X3626 data[1] a_86044_42476# sg13cmos5l_Corner_1.iovdd sg13cmos5l_Corner_1.iovdd sg13_hv_pmos ad=3.9294p pd=7.84u as=3.1302p ps=14.26u w=6.66u l=0.6u
X3627 sg13cmos5l_Corner_1.iovdd a_115639_164698# sg13cmos5l_IOPadAnalog_13.pad sg13cmos5l_Corner_1.iovdd sg13_hv_pmos ad=2.1312p pd=7.3u as=3.9294p ps=7.84u w=6.66u l=0.6u
X3628 adc8b_0.sar12b_0.sg13cmos5l_buf_1_8.X a_92656_92824# sg13cmos5l_Corner_1.vss sg13cmos5l_Corner_1.vss sg13_lv_nmos ad=0.2886p pd=2.26u as=0.14875p ps=1.16u w=0.74u l=0.13u
X3629 adc8b_0.sar12b_0.sg13cmos5l_dfrbp_1_6.RESET_B cks sg13cmos5l_Corner_1.vss sg13cmos5l_Corner_1.vss sg13_lv_nmos ad=0.1443p pd=1.13u as=0.1406p ps=1.12u w=0.74u l=0.13u
X3630 adc8b_0.sar12b_0.sg13cmos5l_inv_1_1.A a_96976_97360# vdd vdd sg13_lv_pmos ad=0.42p pd=2.99u as=0.2114p ps=1.54u w=1.12u l=0.13u
X3631 sg13cmos5l_Corner_1.vss a_134044_30676# frame sg13cmos5l_Corner_1.vss sg13_hv_nmos ad=1.408p pd=5.04u as=2.596p ps=5.58u w=4.4u l=0.6u
X3632 sg13cmos5l_Corner_1.iovdd a_67639_164698# sg13cmos5l_IOPadAnalog_10.pad sg13cmos5l_Corner_1.iovdd sg13_hv_pmos ad=2.1312p pd=7.3u as=3.9294p ps=7.84u w=6.66u l=0.6u
X3633 adc8b_0.sar12b_0.sg13cmos5l_dlhr_1_21.Q_N a_92766_100328# sg13cmos5l_Corner_1.vss sg13cmos5l_Corner_1.vss sg13_lv_nmos ad=0.2516p pd=2.16u as=0.1491p ps=1.18u w=0.74u l=0.13u
X3634 a_99468_92799# a_99699_92908# a_99154_93009# sg13cmos5l_Corner_1.vss sg13_lv_nmos ad=0.2373p pd=1.97u as=79.8f ps=0.8u w=0.42u l=0.13u
X3635 vdd adc8b_0.sar12b_0.sg13cmos5l_buf_1_24.A adc8b_0.sar12b_0.sg13cmos5l_buf_1_78.A vdd sg13_lv_pmos ad=0.3808p pd=2.92u as=0.3808p ps=2.92u w=1.12u l=0.13u
X3636 a_94583_95421# a_93741_95071# a_93324_95064# vdd sg13_lv_pmos ad=0.2048p pd=1.63u as=0.34p ps=2.68u w=1u l=0.13u
X3637 vdd sg13cmos5l_IOPadVdd$1_0.sg13cmos5l_Clamp_N43N43D4R$1_0.gate sg13cmos5l_Corner_1.vss sg13cmos5l_Corner_1.vss sg13_hv_nmos ad=2.596p pd=5.58u as=1.408p ps=5.04u w=4.4u l=0.6u
X3638 sg13cmos5l_Corner_1.vss a_152182_92462# dantenna l=0.64u w=3.1u
X3639 a_101396_93512# adc8b_0.sar12b_0.sg13cmos5l_buf_1_19.X vdd vdd sg13_lv_pmos ad=0.2856p pd=2.36u as=0.2114p ps=1.54u w=0.84u l=0.13u
X3640 a_100727_94375# a_99885_94277# a_99468_94616# vdd sg13_lv_pmos ad=0.2048p pd=1.63u as=0.34p ps=2.68u w=1u l=0.13u
X3641 adc8b_0.side_cap8b_0.buf_16_0.z adc8b_0.side_cap8b_0.in_h_sw[2] sg13cmos5l_Corner_1.vss sg13cmos5l_Corner_1.vss sg13_lv_nmos ad=95f pd=0.88u as=95f ps=0.88u w=0.5u l=0.13u
X3642 a_85076_96536# adc8b_0.sar12b_0.sg13cmos5l_dlhr_1_1.Q vdd vdd sg13_lv_pmos ad=0.2856p pd=2.36u as=0.2114p ps=1.54u w=0.84u l=0.13u
X3643 vddr adc8b_0.side_cap8b_0.in_h_sw[4] adc8b_0.side_cap8b_0.buf_8_2.z vddr sg13_lv_pmos ad=0.19p pd=1.38u as=0.34p ps=2.68u w=1u l=0.13u
X3644 vdd adc8b_0.sar12b_0.sg13cmos5l_buf_1_104.A a_101392_99596# vdd sg13_lv_pmos ad=0.2114p pd=1.54u as=0.2856p ps=2.36u w=0.84u l=0.13u
X3645 sg13cmos5l_Corner_1.vss a_89972_93512# adc8b_0.sar12b_0.sg13cmos5l_buf_1_24.A sg13cmos5l_Corner_1.vss sg13_lv_nmos ad=0.14875p pd=1.16u as=0.2886p ps=2.26u w=0.74u l=0.13u
X3646 a_101146_94298# adc8b_0.sar12b_0.sg13cmos5l_dfrbp_1_0.RESET_B sg13cmos5l_Corner_1.vss sg13cmos5l_Corner_1.vss sg13_lv_nmos ad=37.8f pd=0.6u as=79.8f ps=0.8u w=0.42u l=0.13u
X3647 sg13cmos5l_Corner_1.vss a_83639_178370# sg13cmos5l_Corner_1.vss rppd l=3.54u w=0.5u
X3648 a_36456_136735# a_40542_137065# sg13cmos5l_Corner_1.vss rppd l=20u w=1u
X3649 adc8b_0.side_cap8b_0.buf_8_4.z adc8b_0.side_cap8b_0.in_l_sw[5] sg13cmos5l_Corner_1.vss sg13cmos5l_Corner_1.vss sg13_lv_nmos ad=95f pd=0.88u as=95f ps=0.88u w=0.5u l=0.13u
X3650 sg13cmos5l_Corner_1.vss adc8b_0.sar12b_0.sg13cmos5l_buf_1_89.A a_96976_97360# sg13cmos5l_Corner_1.vss sg13_lv_nmos ad=0.14875p pd=1.16u as=0.187p ps=1.78u w=0.55u l=0.13u
X3651 vdd a_99095_98445# a_99352_98326# vdd sg13_lv_pmos ad=0.2639p pd=1.81u as=79.8f ps=0.8u w=0.42u l=0.13u
X3652 adc8b_0.side_cap8b_1.buf_8_4.z adc8b_0.sar12b_0.nl_sw[5] vddr vddr sg13_lv_pmos ad=0.34p pd=2.68u as=0.19p ps=1.38u w=1u l=0.13u
X3653 adc8b_0.sar12b_0.sg13cmos5l_buf_8_1.A a_99740_96108# vdd vdd sg13_lv_pmos ad=0.3808p pd=2.92u as=0.2128p ps=1.5u w=1.12u l=0.13u
X3654 adc8b_0.side_cap8b_1.buf_32_0.z adc8b_0.sar12b_0.nl_sw[0] vddr vddr sg13_lv_pmos ad=0.19p pd=1.38u as=0.19p ps=1.38u w=1u l=0.13u
X3655 adc8b_0.side_cap8b_0.buf_32_0.z adc8b_0.side_cap8b_0.in_l_sw[0] sg13cmos5l_Corner_1.vss sg13cmos5l_Corner_1.vss sg13_lv_nmos ad=95f pd=0.88u as=95f ps=0.88u w=0.5u l=0.13u
X3656 adc8b_0.sar12b_0.sg13cmos5l_a22oi_1_1.B1 adc8b_0.sar12b_0.sg13cmos5l_nand2_1_1.B sg13cmos5l_Corner_1.vss sg13cmos5l_Corner_1.vss sg13_lv_nmos ad=0.1406p pd=1.12u as=0.2516p ps=2.16u w=0.74u l=0.13u
X3657 vdd sg13cmos5l_IOPadVdd$1_0.sg13cmos5l_Clamp_N43N43D4R$1_0.gate sg13cmos5l_Corner_1.vss sg13cmos5l_Corner_1.vss sg13_hv_nmos ad=2.596p pd=5.58u as=1.408p ps=5.04u w=4.4u l=0.6u
X3658 a_101108_99560# adc8b_0.sar12b_0.sg13cmos5l_buf_1_107.X vdd vdd sg13_lv_pmos ad=0.2856p pd=2.36u as=0.2114p ps=1.54u w=0.84u l=0.13u
X3659 adc8b_0.sar12b_0.sg13cmos5l_o21ai_1_0.B1 adc8b_0.sar12b_0.sg13cmos5l_nand2_1_1.A a_96226_95430# sg13cmos5l_Corner_1.vss sg13_lv_nmos ad=0.2516p pd=2.16u as=0.1406p ps=1.12u w=0.74u l=0.13u
X3660 sg13cmos5l_Corner_1.vss a_84525_94277# a_84627_94420# sg13cmos5l_Corner_1.vss sg13_lv_nmos ad=2.59257p pd=16.445u as=0.2516p ps=2.16u w=0.74u l=0.13u
X3661 sg13cmos5l_Corner_1.iovdd a_102044_42476# data[2] sg13cmos5l_Corner_1.iovdd sg13_hv_pmos ad=2.1312p pd=7.3u as=3.9294p ps=7.84u w=6.66u l=0.6u
X3662 vin sg13cmos5l_Corner_1.iovdd dpantenna l=27.78u w=1.26u
X3663 sg13cmos5l_Corner_1.vss sg13cmos5l_IOPadVdd$1_0.sg13cmos5l_Clamp_N43N43D4R$1_0.gate vdd sg13cmos5l_Corner_1.vss sg13_hv_nmos ad=1.408p pd=5.04u as=2.596p ps=5.58u w=4.4u l=0.6u
X3664 sg13cmos5l_IOPadAnalog_15.pad a_99639_164698# sg13cmos5l_Corner_1.iovdd sg13cmos5l_Corner_1.iovdd sg13_hv_pmos ad=3.9294p pd=7.84u as=2.1312p ps=7.3u w=6.66u l=0.6u
X3665 adc8b_0.side_cap8b_0.buf_8_0.z adc8b_0.side_cap8b_0.in_l_sw[4] vddr vddr sg13_lv_pmos ad=0.34p pd=2.68u as=0.19p ps=1.38u w=1u l=0.13u
X3666 a_99964_99984# a_99548_99596# a_99729_99953# sg13cmos5l_Corner_1.vss sg13_lv_nmos ad=77.7f pd=0.95u as=0.2516p ps=2.16u w=0.74u l=0.13u
X3667 vdd sg13cmos5l_IOPadVdd$1_0.sg13cmos5l_Clamp_N43N43D4R$1_0.gate sg13cmos5l_Corner_1.vss sg13cmos5l_Corner_1.vss sg13_hv_nmos ad=2.596p pd=5.58u as=1.408p ps=5.04u w=4.4u l=0.6u
X3668 sg13cmos5l_Corner_1.vss a_83992_98326# a_83641_98445# sg13cmos5l_Corner_1.vss sg13_lv_nmos ad=79.8f pd=0.8u as=0.1428p ps=1.52u w=0.42u l=0.13u
X3669 vdd adc8b_0.sar12b_0.sg13cmos5l_inv_1_0.A adc8b_0.sar12b_0.sg13cmos5l_inv_1_0.Y vdd sg13_lv_pmos ad=0.3808p pd=2.92u as=0.3808p ps=2.92u w=1.12u l=0.13u
X3670 sg13cmos5l_IOPadAnalog_10.pad sg13cmos5l_IOPadAnalog_10.padres sg13cmos5l_Corner_1.vss rppd l=2u w=1u
X3671 cks a_42476_118044# sg13cmos5l_Corner_1.iovdd sg13cmos5l_Corner_1.iovdd sg13_hv_pmos ad=3.9294p pd=7.84u as=2.1312p ps=7.3u w=6.66u l=0.6u
X3672 sg13cmos5l_Corner_1.iovdd a_134044_42476# frame sg13cmos5l_Corner_1.iovdd sg13_hv_pmos ad=2.1312p pd=7.3u as=3.9294p ps=7.84u w=6.66u l=0.6u
X3673 sg13cmos5l_IOPadAnalog_0.pad a_178296_86044# sg13cmos5l_Corner_1.vss sg13cmos5l_Corner_1.vss sg13_hv_nmos ad=2.596p pd=5.58u as=1.408p ps=5.04u w=4.4u l=0.6u
X3674 sg13cmos5l_Corner_1.vss adc8b_0.side_cap8b_0.in_l_sw[1] adc8b_0.side_cap8b_0.buf_16_2.z sg13cmos5l_Corner_1.vss sg13_lv_nmos ad=95f pd=0.88u as=0.17p ps=1.68u w=0.5u l=0.13u
X3675 sg13cmos5l_Corner_1.vss adc8b_0.sar12b_0.nh_sw[0] adc8b_0.side_cap8b_1.buf_32_1.z sg13cmos5l_Corner_1.vss sg13_lv_nmos ad=95f pd=0.88u as=95f ps=0.88u w=0.5u l=0.13u
X3676 sg13cmos5l_Corner_1.iovdd a_83639_164698# sg13cmos5l_IOPadAnalog_9.pad sg13cmos5l_Corner_1.iovdd sg13_hv_pmos ad=2.1312p pd=7.3u as=3.9294p ps=7.84u w=6.66u l=0.6u
X3677 vdd adc8b_0.sar12b_0.sg13cmos5l_dfrbp_1_6.RESET_B a_91473_95810# vdd sg13_lv_pmos ad=0.2128p pd=1.5u as=0.2128p ps=1.5u w=1.12u l=0.13u
X3678 sg13cmos5l_Corner_1.vss a_70044_30676# data[0] sg13cmos5l_Corner_1.vss sg13_hv_nmos ad=1.408p pd=5.04u as=2.596p ps=5.58u w=4.4u l=0.6u
X3679 sg13cmos5l_Corner_1.vss adc8b_0.sar12b_0.nl_sw[4] adc8b_0.side_cap8b_1.buf_8_0.z sg13cmos5l_Corner_1.vss sg13_lv_nmos ad=95f pd=0.88u as=95f ps=0.88u w=0.5u l=0.13u
X3680 sg13cmos5l_Corner_1.vss a_102222_33862# dantenna l=1.26u w=27.78u
X3681 adc8b_0.side_cap8b_0.buf_16_1.z adc8b_0.side_cap8b_0.in_l_sw[2] vddr vddr sg13_lv_pmos ad=0.19p pd=1.38u as=0.19p ps=1.38u w=1u l=0.13u
X3682 adc8b_0.sar12b_0.sg13cmos5l_buf_1_10.A a_93616_99596# sg13cmos5l_Corner_1.vss sg13cmos5l_Corner_1.vss sg13_lv_nmos ad=0.2886p pd=2.26u as=0.14875p ps=1.16u w=0.74u l=0.13u
X3683 a_83992_98326# a_83735_98445# a_84154_98522# sg13cmos5l_Corner_1.vss sg13_lv_nmos ad=0.1428p pd=1.52u as=37.8f ps=0.6u w=0.42u l=0.13u
X3684 sg13cmos5l_Corner_1.vss sg13cmos5l_IOPadVdd$1_0.sg13cmos5l_Clamp_N43N43D4R$1_0.gate vdd sg13cmos5l_Corner_1.vss sg13_hv_nmos ad=1.408p pd=5.04u as=2.596p ps=5.58u w=4.4u l=0.6u
X3685 vdd a_98039_98911# a_98296_99054# vdd sg13_lv_pmos ad=0.2639p pd=1.81u as=79.8f ps=0.8u w=0.42u l=0.13u
X3686 a_83765_97286# a_84495_97540# a_84516_97286# sg13cmos5l_Corner_1.vss sg13_lv_nmos ad=0.12665p pd=1.145u as=0.3473p ps=2.71u w=0.74u l=0.13u
X3687 vdd adc8b_0.sar12b_0.sg13cmos5l_dfrbp_1_6.RESET_B a_93998_97322# vdd sg13_lv_pmos ad=0.36237p pd=2.605u as=79.8f ps=0.8u w=0.42u l=0.13u
X3688 a_100932_96974# a_100383_96930# a_100796_96572# sg13cmos5l_Corner_1.vss sg13_lv_nmos ad=47.25f pd=0.645u as=0.141p ps=1.17u w=0.42u l=0.13u
X3689 sg13cmos5l_Corner_1.vss a_100977_96929# a_100932_96974# sg13cmos5l_Corner_1.vss sg13_lv_nmos ad=0.1428p pd=1.52u as=47.25f ps=0.645u w=0.42u l=0.13u
X3690 a_97068_98847# a_96780_99152# a_97006_98847# sg13cmos5l_Corner_1.vss sg13_lv_nmos ad=0.1428p pd=1.52u as=37.8f ps=0.6u w=0.42u l=0.13u
X3691 sg13cmos5l_Corner_1.vss a_100131_95430# adc8b_0.sar12b_0.sg13cmos5l_or2_1_0.A sg13cmos5l_Corner_1.vss sg13_lv_nmos ad=0.1406p pd=1.12u as=0.1406p ps=1.12u w=0.74u l=0.13u
X3692 sg13cmos5l_Corner_1.vss adc8b_0.sar12b_0.nh_sw[0] adc8b_0.side_cap8b_1.buf_32_1.z sg13cmos5l_Corner_1.vss sg13_lv_nmos ad=95f pd=0.88u as=95f ps=0.88u w=0.5u l=0.13u
X3693 sg13cmos5l_Corner_1.vss cks a_100995_100350# sg13cmos5l_Corner_1.vss sg13_lv_nmos ad=0.1406p pd=1.12u as=0.2553p ps=2.17u w=0.74u l=0.13u
X3694 sg13cmos5l_IOPadAnalog_1.pad a_178296_70044# sg13cmos5l_Corner_1.vss sg13cmos5l_Corner_1.vss sg13_hv_nmos ad=2.596p pd=5.58u as=1.408p ps=5.04u w=4.4u l=0.6u
X3695 vdd a_89588_93512# adc8b_0.sar12b_0.sg13cmos5l_inv_1_14.A vdd sg13_lv_pmos ad=0.2114p pd=1.54u as=0.42p ps=2.99u w=1.12u l=0.13u
X3696 a_89292_99152# a_89266_99057# sg13cmos5l_Corner_1.vss sg13cmos5l_Corner_1.vss sg13_lv_nmos ad=0.2516p pd=2.16u as=0.1626p ps=1.415u w=0.74u l=0.13u
X3697 sg13cmos5l_Corner_1.vss a_96657_98441# a_97182_98514# sg13cmos5l_Corner_1.vss sg13_lv_nmos ad=0.1491p pd=1.18u as=0.187p ps=1.78u w=0.55u l=0.13u
X3698 a_92381_93918# adc8b_0.sar12b_0.sg13cmos5l_nand2_1_1.B sg13cmos5l_Corner_1.vss sg13cmos5l_Corner_1.vss sg13_lv_nmos ad=0.1406p pd=1.12u as=0.1898p ps=1.36u w=0.74u l=0.13u
X3699 a_83916_99600# a_83890_99564# vdd vdd sg13_lv_pmos ad=0.34p pd=2.68u as=0.36237p ps=2.605u w=1u l=0.13u
X3700 sg13cmos5l_Corner_1.vss adc8b_0.sar12b_0.sg13cmos5l_a22oi_1_0.Y adc8b_0.sar12b_0.sg13cmos5l_dfrbp_1_2.D sg13cmos5l_Corner_1.vss sg13_lv_nmos ad=0.2516p pd=2.16u as=0.2516p ps=2.16u w=0.74u l=0.13u
X3701 adc8b_0.side_cap8b_1.buf_32_1.z adc8b_0.sar12b_0.nh_sw[0] sg13cmos5l_Corner_1.vss sg13cmos5l_Corner_1.vss sg13_lv_nmos ad=95f pd=0.88u as=95f ps=0.88u w=0.5u l=0.13u
X3702 sg13cmos5l_Corner_1.vss a_30676_70044# vddr sg13cmos5l_Corner_1.vss sg13_hv_nmos ad=1.408p pd=5.04u as=2.596p ps=5.58u w=4.4u l=0.6u
X3703 a_92433_99225# a_92076_99152# vdd vdd sg13_lv_pmos ad=63f pd=0.72u as=0.1563p ps=1.22u w=0.42u l=0.13u
X3704 sg13cmos5l_Corner_1.vss adc8b_0.sar12b_0.sg13cmos5l_or2_1_0.A adc8b_0.sar12b_0.sg13cmos5l_nand2_1_2.B sg13cmos5l_Corner_1.vss sg13_lv_nmos ad=0.2516p pd=2.16u as=0.1406p ps=1.12u w=0.74u l=0.13u
X3705 a_85367_94375# a_84525_94277# a_84108_94616# vdd sg13_lv_pmos ad=0.2048p pd=1.63u as=0.34p ps=2.68u w=1u l=0.13u
X3706 vdd a_88247_93909# a_88504_93790# vdd sg13_lv_pmos ad=0.2639p pd=1.81u as=79.8f ps=0.8u w=0.42u l=0.13u
X3707 vip a_42476_102044# sg13cmos5l_Corner_1.iovdd sg13cmos5l_Corner_1.iovdd sg13_hv_pmos ad=3.9294p pd=7.84u as=2.1312p ps=7.3u w=6.66u l=0.6u
X3708 a_97836_98088# a_97810_98052# sg13cmos5l_Corner_1.vss sg13cmos5l_Corner_1.vss sg13_lv_nmos ad=0.2516p pd=2.16u as=0.1626p ps=1.415u w=0.74u l=0.13u
X3709 vdd a_91796_97286# adc8b_0.sar12b_0.sg13cmos5l_inv_1_18.A vdd sg13_lv_pmos ad=0.2114p pd=1.54u as=0.42p ps=2.99u w=1.12u l=0.13u
X3710 adc8b_0.sar12b_0.sg13cmos5l_buf_1_28.X a_91216_92824# sg13cmos5l_Corner_1.vss sg13cmos5l_Corner_1.vss sg13_lv_nmos ad=0.2886p pd=2.26u as=0.14875p ps=1.16u w=0.74u l=0.13u
X3711 adc8b_0.side_cap8b_0.buf_8_5.z adc8b_0.side_cap8b_0.in_h_sw[5] sg13cmos5l_Corner_1.vss sg13cmos5l_Corner_1.vss sg13_lv_nmos ad=95f pd=0.88u as=95f ps=0.88u w=0.5u l=0.13u
X3712 adc8b_0.sar12b_0.sg13cmos5l_inv_1_2.A a_90256_100384# sg13cmos5l_Corner_1.vss sg13cmos5l_Corner_1.vss sg13_lv_nmos ad=0.2886p pd=2.26u as=0.14875p ps=1.16u w=0.74u l=0.13u
X3713 sg13cmos5l_IOPadAnalog_11.pad a_164624_118044# sg13cmos5l_Corner_1.iovdd sg13cmos5l_Corner_1.iovdd sg13_hv_pmos ad=3.9294p pd=7.84u as=2.1312p ps=7.3u w=6.66u l=0.6u
X3714 a_92364_98847# a_92595_98956# a_92050_99057# sg13cmos5l_Corner_1.vss sg13_lv_nmos ad=0.2373p pd=1.97u as=79.8f ps=0.8u w=0.42u l=0.13u
X3715 a_92302_98847# adc8b_0.sar12b_0.sg13cmos5l_dfrbp_1_6.RESET_B sg13cmos5l_Corner_1.vss sg13cmos5l_Corner_1.vss sg13_lv_nmos ad=37.8f pd=0.6u as=0.1701p ps=1.65u w=0.42u l=0.13u
X3716 sg13cmos5l_Corner_1.vss a_32962_70222# dantenna l=27.78u w=1.26u
X3717 a_85175_99957# a_84333_99607# a_85081_99957# sg13cmos5l_Corner_1.vss sg13_lv_nmos ad=0.12665p pd=1.145u as=0.1428p ps=1.52u w=0.42u l=0.13u
X3718 a_85076_96536# adc8b_0.sar12b_0.sg13cmos5l_dlhr_1_1.Q sg13cmos5l_Corner_1.vss sg13cmos5l_Corner_1.vss sg13_lv_nmos ad=0.187p pd=1.78u as=0.14875p ps=1.16u w=0.55u l=0.13u
X3719 a_96830_95452# adc8b_0.sar12b_0.sg13cmos5l_a22oi_1_1.B2 adc8b_0.sar12b_0.sg13cmos5l_a22oi_1_1.Y sg13cmos5l_Corner_1.vss sg13_lv_nmos ad=0.13875p pd=1.115u as=0.2664p ps=1.46u w=0.74u l=0.13u
X3720 sg13cmos5l_Corner_1.vss adc8b_0.sar12b_0.sg13cmos5l_dfrbp_1_6.RESET_B a_98066_95498# sg13cmos5l_Corner_1.vss sg13_lv_nmos ad=79.8f pd=0.8u as=37.8f ps=0.6u w=0.42u l=0.13u
X3721 sg13cmos5l_IOPadAnalog_10.pad a_67639_164698# sg13cmos5l_Corner_1.iovdd sg13cmos5l_Corner_1.iovdd sg13_hv_pmos ad=3.9294p pd=7.84u as=2.1312p ps=7.3u w=6.66u l=0.6u
X3722 adc8b_0.side_cap8b_0.buf_32_0.z adc8b_0.side_cap8b_0.in_l_sw[0] vddr vddr sg13_lv_pmos ad=0.19p pd=1.38u as=0.19p ps=1.38u w=1u l=0.13u
X3723 vddr adc8b_0.side_cap8b_0.in_h_sw[2] adc8b_0.side_cap8b_0.buf_16_0.z vddr sg13_lv_pmos ad=0.19p pd=1.38u as=0.19p ps=1.38u w=1u l=0.13u
X3724 adc8b_0.sar12b_0.sg13cmos5l_dfrbp_1_22.D a_98492_99596# sg13cmos5l_Corner_1.vss sg13cmos5l_Corner_1.vss sg13_lv_nmos ad=0.2516p pd=2.16u as=0.1406p ps=1.12u w=0.74u l=0.13u
X3725 sg13cmos5l_Corner_1.iovdd a_70044_42476# data[0] sg13cmos5l_Corner_1.iovdd sg13_hv_pmos ad=2.1312p pd=7.3u as=3.9294p ps=7.84u w=6.66u l=0.6u
X3726 sg13cmos5l_Corner_1.iovdd a_134044_42476# frame sg13cmos5l_Corner_1.iovdd sg13_hv_pmos ad=2.1312p pd=7.3u as=3.9294p ps=7.84u w=6.66u l=0.6u
X3727 a_96668_93512# adc8b_0.sar12b_0.sg13cmos5l_nor2_1_1.A vdd vdd sg13_lv_pmos ad=0.2856p pd=2.36u as=0.2618p ps=1.63u w=0.84u l=0.13u
X3728 a_82388_93512# adc8b_0.sar12b_0.sg13cmos5l_buf_1_32.X vdd vdd sg13_lv_pmos ad=0.2856p pd=2.36u as=0.2114p ps=1.54u w=0.84u l=0.13u
X3729 adc8b_0.side_cap8b_0.buf_16_3.z adc8b_0.side_cap8b_0.in_h_sw[1] vddr vddr sg13_lv_pmos ad=0.19p pd=1.38u as=0.19p ps=1.38u w=1u l=0.13u
X3730 a_85432_99838# adc8b_0.sar12b_0.sg13cmos5l_dfrbp_1_8.RESET_B vdd vdd sg13_lv_pmos ad=79.8f pd=0.8u as=1.12242p ps=7u w=0.42u l=0.13u
X3731 sg13cmos5l_IOPadAnalog_11.pad a_178296_118044# sg13cmos5l_Corner_1.vss sg13cmos5l_Corner_1.vss sg13_hv_nmos ad=2.596p pd=5.58u as=1.408p ps=5.04u w=4.4u l=0.6u
X3732 vddr adc8b_0.sar12b_0.nh_sw[6] adc8b_0.side_cap8b_1.buf_4_1.z vddr sg13_lv_pmos ad=0.19p pd=1.38u as=0.34p ps=2.68u w=1u l=0.13u
X3733 sg13cmos5l_IOPadAnalog_0.pad a_164624_86044# sg13cmos5l_Corner_1.iovdd sg13cmos5l_Corner_1.iovdd sg13_hv_pmos ad=3.9294p pd=7.84u as=2.1312p ps=7.3u w=6.66u l=0.6u
X3734 a_92950_96108# adc8b_0.sar12b_0.sg13cmos5l_a221oi_1_0.A2 vdd vdd sg13_lv_pmos ad=0.2128p pd=1.5u as=0.3808p ps=2.92u w=1.12u l=0.13u
X3735 a_93228_93552# a_93202_93516# vdd vdd sg13_lv_pmos ad=0.34p pd=2.68u as=0.36237p ps=2.605u w=1u l=0.13u
X3736 cks a_30676_118044# sg13cmos5l_Corner_1.vss sg13cmos5l_Corner_1.vss sg13_hv_nmos ad=2.596p pd=5.58u as=1.408p ps=5.04u w=4.4u l=0.6u
X3737 sg13cmos5l_Corner_1.vss a_30676_102044# vip sg13cmos5l_Corner_1.vss sg13_hv_nmos ad=1.408p pd=5.04u as=2.596p ps=5.58u w=4.4u l=0.6u
X3738 vip a_42476_102044# sg13cmos5l_Corner_1.iovdd sg13cmos5l_Corner_1.iovdd sg13_hv_pmos ad=3.9294p pd=7.84u as=2.1312p ps=7.3u w=6.66u l=0.6u
X3739 vdd adc8b_0.sar12b_0.sg13cmos5l_dfrbp_1_10.Q a_92099_95060# vdd sg13_lv_pmos ad=0.2128p pd=1.5u as=0.2128p ps=1.5u w=1.12u l=0.13u
X3740 sg13cmos5l_Corner_1.vss adc8b_0.sar12b_0.sg13cmos5l_buf_1_10.A a_94288_94336# sg13cmos5l_Corner_1.vss sg13_lv_nmos ad=0.14875p pd=1.16u as=0.187p ps=1.78u w=0.55u l=0.13u
X3741 sg13cmos5l_IOPadAnalog_0.pad sg13cmos5l_Corner_1.iovdd dpantenna l=27.78u w=1.26u
X3742 a_93454_93973# adc8b_0.sar12b_0.sg13cmos5l_dfrbp_1_0.RESET_B sg13cmos5l_Corner_1.vss sg13cmos5l_Corner_1.vss sg13_lv_nmos ad=37.8f pd=0.6u as=0.1701p ps=1.65u w=0.42u l=0.13u
X3743 sg13cmos5l_Corner_1.iovdd a_99639_164698# sg13cmos5l_IOPadAnalog_15.pad sg13cmos5l_Corner_1.iovdd sg13_hv_pmos ad=2.1312p pd=7.3u as=3.9294p ps=7.84u w=6.66u l=0.6u
X3744 adc8b_0.side_cap8b_0.buf_4_1.z adc8b_0.side_cap8b_0.in_h_sw[6] sg13cmos5l_Corner_1.vss sg13cmos5l_Corner_1.vss sg13_lv_nmos ad=0.17p pd=1.68u as=95f ps=0.88u w=0.5u l=0.13u
X3745 sg13cmos5l_Corner_1.vss vdd sg13cmos5l_Corner_1.vss sg13cmos5l_Corner_1.vss sg13_lv_nmos ad=0.1428p pd=1.52u as=0 ps=0 w=0.42u l=1u
X3746 adc8b_0.sar12b_0.sg13cmos5l_buf_1_26.A adc8b_0.sar12b_0.sg13cmos5l_buf_1_45.X sg13cmos5l_Corner_1.vss sg13cmos5l_Corner_1.vss sg13_lv_nmos ad=0.2516p pd=2.16u as=0.2516p ps=2.16u w=0.74u l=0.13u
X3747 sg13cmos5l_Corner_1.iovdd a_115639_164698# sg13cmos5l_IOPadAnalog_13.pad sg13cmos5l_Corner_1.iovdd sg13_hv_pmos ad=2.1312p pd=7.3u as=3.9294p ps=7.84u w=6.66u l=0.6u
X3748 a_95469_94277# adc8b_0.sar12b_0.sg13cmos5l_dfrbp_1_0.CLK sg13cmos5l_Corner_1.vss sg13cmos5l_Corner_1.vss sg13_lv_nmos ad=0.2516p pd=2.16u as=2.43055p ps=15.415u w=0.74u l=0.13u
X3749 adc8b_0.side_cap8b_1.buf_2_0.z adc8b_0.sar12b_0.nh_sw[8] sg13cmos5l_Corner_1.vss sg13cmos5l_Corner_1.vss sg13_lv_nmos ad=0.17p pd=1.68u as=95f ps=0.88u w=0.5u l=0.13u
X3750 sg13cmos5l_Corner_1.iovdd a_42476_70044# vddr sg13cmos5l_Corner_1.iovdd sg13_hv_pmos ad=2.1312p pd=7.3u as=3.9294p ps=7.84u w=6.66u l=0.6u
X3751 adc8b_0.side_cap8b_0.buf_32_0.z adc8b_0.side_cap8b_0.in_l_sw[0] sg13cmos5l_Corner_1.vss sg13cmos5l_Corner_1.vss sg13_lv_nmos ad=95f pd=0.88u as=95f ps=0.88u w=0.5u l=0.13u
X3752 a_101316_97358# a_100767_97338# a_101180_97644# sg13cmos5l_Corner_1.vss sg13_lv_nmos ad=47.25f pd=0.645u as=0.141p ps=1.17u w=0.42u l=0.13u
X3753 data[1] a_86044_42476# sg13cmos5l_Corner_1.iovdd sg13cmos5l_Corner_1.iovdd sg13_hv_pmos ad=3.9294p pd=7.84u as=2.1312p ps=7.3u w=6.66u l=0.6u
X3754 adc8b_0.sar12b_0.sg13cmos5l_buf_1_5.X a_96208_92824# vdd vdd sg13_lv_pmos ad=0.42p pd=2.99u as=0.2114p ps=1.54u w=1.12u l=0.13u
X3755 vdd sg13cmos5l_IOPadVdd$1_0.sg13cmos5l_Clamp_N43N43D4R$1_0.gate sg13cmos5l_Corner_1.vss sg13cmos5l_Corner_1.vss sg13_hv_nmos ad=2.596p pd=5.58u as=1.408p ps=5.04u w=4.4u l=0.6u
X3756 vdd a_90932_92750# adc8b_0.sar12b_0.sg13cmos5l_buf_1_26.X vdd sg13_lv_pmos ad=0.2114p pd=1.54u as=0.42p ps=2.99u w=1.12u l=0.13u
X3757 vdd a_87092_92750# adc8b_0.sar12b_0.sg13cmos5l_buf_1_39.A vdd sg13_lv_pmos ad=0.2114p pd=1.54u as=0.42p ps=2.99u w=1.12u l=0.13u
X3758 a_91647_100362# adc8b_0.sar12b_0.sg13cmos5l_dfrbp_1_18.Q sg13cmos5l_Corner_1.vss sg13cmos5l_Corner_1.vss sg13_lv_nmos ad=0.2516p pd=2.16u as=0.15055p ps=1.17u w=0.74u l=0.13u
X3759 vddr adc8b_0.sar12b_0.nl_sw[0] adc8b_0.side_cap8b_1.buf_32_0.z vddr sg13_lv_pmos ad=0.19p pd=1.38u as=0.19p ps=1.38u w=1u l=0.13u
X3760 sg13cmos5l_Corner_1.vss a_97652_94262# adc8b_0.sar12b_0.nh_sw[7] sg13cmos5l_Corner_1.vss sg13_lv_nmos ad=0.14875p pd=1.16u as=0.2886p ps=2.26u w=0.74u l=0.13u
X3761 adc8b_0.sar12b_0.sg13cmos5l_buf_1_79.X a_91024_100384# sg13cmos5l_Corner_1.vss sg13cmos5l_Corner_1.vss sg13_lv_nmos ad=0.2886p pd=2.26u as=0.14875p ps=1.16u w=0.74u l=0.13u
X3762 sg13cmos5l_Corner_1.vss a_97197_98813# a_97299_98956# sg13cmos5l_Corner_1.vss sg13_lv_nmos ad=1.49685p pd=9.6u as=0.2516p ps=2.16u w=0.74u l=0.13u
X3763 a_85644_95823# a_85875_95932# a_85330_96033# sg13cmos5l_Corner_1.vss sg13_lv_nmos ad=0.2373p pd=1.97u as=79.8f ps=0.8u w=0.42u l=0.13u
X3764 vdd a_84516_97286# a_85539_97713# vdd sg13_lv_pmos ad=0.1563p pd=1.22u as=63f ps=0.72u w=0.42u l=0.13u
X3765 sg13cmos5l_Corner_1.vss a_178296_86044# sg13cmos5l_IOPadAnalog_0.pad sg13cmos5l_Corner_1.vss sg13_hv_nmos ad=1.408p pd=5.04u as=2.596p ps=5.58u w=4.4u l=0.6u
X3766 sg13cmos5l_IOPadAnalog_16.pad a_164624_102044# sg13cmos5l_Corner_1.iovdd sg13cmos5l_Corner_1.iovdd sg13_hv_pmos ad=3.9294p pd=7.84u as=2.1312p ps=7.3u w=6.66u l=0.6u
X3767 a_96622_100021# adc8b_0.sar12b_0.sg13cmos5l_dfrbp_1_8.RESET_B sg13cmos5l_Corner_1.vss sg13cmos5l_Corner_1.vss sg13_lv_nmos ad=37.8f pd=0.6u as=0.1701p ps=1.65u w=0.42u l=0.13u
X3768 a_92050_99057# a_92493_98813# a_92433_99225# vdd sg13_lv_pmos ad=79.8f pd=0.8u as=63f ps=0.72u w=0.42u l=0.13u
X3769 a_99322_95810# adc8b_0.sar12b_0.sg13cmos5l_dfrbp_1_8.RESET_B sg13cmos5l_Corner_1.vss sg13cmos5l_Corner_1.vss sg13_lv_nmos ad=37.8f pd=0.6u as=79.8f ps=0.8u w=0.42u l=0.13u
X3770 a_90609_96929# a_90428_96572# vdd vdd sg13_lv_pmos ad=0.2128p pd=1.5u as=0.2387p ps=1.84u w=1.12u l=0.13u
X3771 sg13cmos5l_Corner_1.vss a_30676_118044# cks sg13cmos5l_Corner_1.vss sg13_hv_nmos ad=2.068p pd=9.74u as=2.596p ps=5.58u w=4.4u l=0.6u
X3772 adc8b_0.side_cap8b_0.buf_16_2.z adc8b_0.side_cap8b_0.in_l_sw[1] vddr vddr sg13_lv_pmos ad=0.19p pd=1.38u as=0.19p ps=1.38u w=1u l=0.13u
X3773 sg13cmos5l_IOPadAnalog_16.pad a_178296_102044# sg13cmos5l_Corner_1.vss sg13cmos5l_Corner_1.vss sg13_hv_nmos ad=2.596p pd=5.58u as=1.408p ps=5.04u w=4.4u l=0.6u
X3774 a_87885_97301# adc8b_0.sar12b_0.sg13cmos5l_dlhr_1_5.GATE vdd vdd sg13_lv_pmos ad=0.4088p pd=2.97u as=1.04815p ps=6.595u w=1.12u l=0.13u
X3775 sg13cmos5l_IOPadAnalog_15.pad sg13cmos5l_Corner_1.iovdd dpantenna l=1.26u w=27.78u
X3776 sg13cmos5l_Corner_1.vss adc8b_0.sar12b_0.nl_sw[1] adc8b_0.side_cap8b_1.buf_16_2.z sg13cmos5l_Corner_1.vss sg13_lv_nmos ad=95f pd=0.88u as=95f ps=0.88u w=0.5u l=0.13u
X3777 adc8b_0.sar12b_0.sg13cmos5l_nand2_1_0.A adc8b_0.sar12b_0.sg13cmos5l_dfrbp_1_0.Q sg13cmos5l_Corner_1.vss sg13cmos5l_Corner_1.vss sg13_lv_nmos ad=0.1406p pd=1.12u as=0.2516p ps=2.16u w=0.74u l=0.13u
X3778 sg13cmos5l_IOPadVdd$1_0.sg13cmos5l_Clamp_N43N43D4R$1_0.gate sg13cmos5l_IOPadVdd$1_0.sg13cmos5l_RCClampInverter$1_0.in vdd vdd sg13_hv_pmos ad=1.33p pd=7.38u as=1.33p ps=7.38u w=7u l=0.5u
X3779 sg13cmos5l_Corner_1.vss a_30676_70044# sg13cmos5l_Corner_1.vss rppd l=3.54u w=0.5u
X3780 sg13cmos5l_Corner_1.vss adc8b_0.side_cap8b_0.in_h_sw[3] adc8b_0.side_cap8b_0.buf_8_3.z sg13cmos5l_Corner_1.vss sg13_lv_nmos ad=95f pd=0.88u as=0.17p ps=1.68u w=0.5u l=0.13u
X3781 a_97197_98813# adc8b_0.sar12b_0.sg13cmos5l_dfrbp_1_22.D vdd vdd sg13_lv_pmos ad=0.4088p pd=2.97u as=1.12242p ps=7u w=1.12u l=0.13u
X3782 sg13cmos5l_Corner_1.iovdd a_70044_42476# data[0] sg13cmos5l_Corner_1.iovdd sg13_hv_pmos ad=2.1312p pd=7.3u as=3.9294p ps=7.84u w=6.66u l=0.6u
X3783 vddr adc8b_0.side_cap8b_0.in_h_sw[9] adc8b_0.side_cap8b_0.buf_2_3.z vddr sg13_lv_pmos ad=0.19p pd=1.38u as=0.34p ps=2.68u w=1u l=0.13u
X3784 vdd adc8b_0.sar12b_0.sg13cmos5l_dlhr_1_6.D a_90001_97376# vdd sg13_lv_pmos ad=1.07253p pd=6.75u as=0.2856p ps=2.36u w=0.84u l=0.13u
X3785 a_95052_94616# a_95026_94521# sg13cmos5l_Corner_1.vss sg13cmos5l_Corner_1.vss sg13_lv_nmos ad=0.2516p pd=2.16u as=0.1626p ps=1.415u w=0.74u l=0.13u
X3786 adc8b_0.side_cap8b_0.buf_32_1.z adc8b_0.side_cap8b_0.in_h_sw[0] sg13cmos5l_Corner_1.vss sg13cmos5l_Corner_1.vss sg13_lv_nmos ad=95f pd=0.88u as=95f ps=0.88u w=0.5u l=0.13u
X3787 vdd a_91799_99957# a_92056_99838# vdd sg13_lv_pmos ad=0.2639p pd=1.81u as=79.8f ps=0.8u w=0.42u l=0.13u
X3788 a_87278_95498# adc8b_0.sar12b_0.sg13cmos5l_dfrbp_1_6.D vdd vdd sg13_lv_pmos ad=79.8f pd=0.8u as=0.1428p ps=1.52u w=0.42u l=0.13u
X3789 vdd adc8b_0.sar12b_0.sg13cmos5l_buf_1_97.A a_93616_99596# vdd sg13_lv_pmos ad=0.2114p pd=1.54u as=0.2856p ps=2.36u w=0.84u l=0.13u
X3790 a_95164_98472# a_94748_98084# a_94929_98441# sg13cmos5l_Corner_1.vss sg13_lv_nmos ad=77.7f pd=0.95u as=0.2516p ps=2.16u w=0.74u l=0.13u
X3791 sg13cmos5l_Corner_1.vss a_102044_30676# data[2] sg13cmos5l_Corner_1.vss sg13_hv_nmos ad=1.408p pd=5.04u as=2.596p ps=5.58u w=4.4u l=0.6u
X3792 adc8b_0.side_cap8b_1.buf_16_2.z adc8b_0.sar12b_0.nl_sw[1] vddr vddr sg13_lv_pmos ad=0.19p pd=1.38u as=0.19p ps=1.38u w=1u l=0.13u
X3793 sg13cmos5l_Corner_1.vss adc8b_0.sar12b_0.nl_sw[0] adc8b_0.side_cap8b_1.buf_32_0.z sg13cmos5l_Corner_1.vss sg13_lv_nmos ad=95f pd=0.88u as=95f ps=0.88u w=0.5u l=0.13u
X3794 sg13cmos5l_Corner_1.vss a_175886_86222# dantenna l=27.78u w=1.26u
X3795 data[1] a_86044_42476# sg13cmos5l_Corner_1.iovdd sg13cmos5l_Corner_1.iovdd sg13_hv_pmos ad=3.9294p pd=7.84u as=2.1312p ps=7.3u w=6.66u l=0.6u
X3796 sg13cmos5l_Corner_1.iovdd a_67639_164698# sg13cmos5l_IOPadAnalog_10.pad sg13cmos5l_Corner_1.iovdd sg13_hv_pmos ad=2.1312p pd=7.3u as=3.9294p ps=7.84u w=6.66u l=0.6u
X3797 vdd adc8b_0.sar12b_0.sg13cmos5l_dlhr_1_2.D a_88465_94352# vdd sg13_lv_pmos ad=1.43437p pd=9.105u as=0.2856p ps=2.36u w=0.84u l=0.13u
X3798 adc8b_0.side_cap8b_0.buf_8_1.z adc8b_0.side_cap8b_0.in_l_sw[3] sg13cmos5l_Corner_1.vss sg13cmos5l_Corner_1.vss sg13_lv_nmos ad=0.17p pd=1.68u as=95f ps=0.88u w=0.5u l=0.13u
X3799 vdd adc8b_0.sar12b_0.sg13cmos5l_dlhr_1_6.D a_95254_96572# vdd sg13_lv_pmos ad=0.3808p pd=2.92u as=0.2128p ps=1.5u w=1.12u l=0.13u
X3800 vdd adc8b_0.sar12b_0.sg13cmos5l_buf_1_111.A a_100144_100384# vdd sg13_lv_pmos ad=0.2114p pd=1.54u as=0.2856p ps=2.36u w=0.84u l=0.13u
X3801 a_92388_98486# a_91839_98442# a_92252_98084# sg13cmos5l_Corner_1.vss sg13_lv_nmos ad=47.25f pd=0.645u as=0.141p ps=1.17u w=0.42u l=0.13u
X3802 a_83630_95498# adc8b_0.sar12b_0.sg13cmos5l_dlhr_1_1.GATE vdd vdd sg13_lv_pmos ad=79.8f pd=0.8u as=0.1428p ps=1.52u w=0.42u l=0.13u
X3803 sg13cmos5l_Corner_1.iovdd a_164624_118044# sg13cmos5l_IOPadAnalog_11.pad sg13cmos5l_Corner_1.iovdd sg13_hv_pmos ad=2.1312p pd=7.3u as=3.9294p ps=7.84u w=6.66u l=0.6u
X3804 sg13cmos5l_Corner_1.vss sg13cmos5l_IOPadVdd$1_0.sg13cmos5l_Clamp_N43N43D4R$1_0.gate vdd sg13cmos5l_Corner_1.vss sg13_hv_nmos ad=1.408p pd=5.04u as=2.596p ps=5.58u w=4.4u l=0.6u
X3805 adc8b_0.side_cap8b_0.buf_2_2.z adc8b_0.side_cap8b_0.in_l_sw[9] sg13cmos5l_Corner_1.vss sg13cmos5l_Corner_1.vss sg13_lv_nmos ad=0.17p pd=1.68u as=95f ps=0.88u w=0.5u l=0.13u
X3806 a_97550_98522# a_98355_98095# a_97810_98052# vdd sg13_lv_pmos ad=0.1428p pd=1.52u as=79.8f ps=0.8u w=0.42u l=0.13u
X3807 cko a_118044_42476# sg13cmos5l_Corner_1.iovdd sg13cmos5l_Corner_1.iovdd sg13_hv_pmos ad=3.9294p pd=7.84u as=2.1312p ps=7.3u w=6.66u l=0.6u
X3808 sg13cmos5l_Corner_1.vss a_100995_100350# adc8b_0.sar12b_0.sg13cmos5l_buf_8_2.X sg13cmos5l_Corner_1.vss sg13_lv_nmos ad=0.2516p pd=2.16u as=0.1406p ps=1.12u w=0.74u l=0.13u
X3809 a_95092_95856# adc8b_0.sar12b_0.sg13cmos5l_inv_1_0.A vdd vdd sg13_lv_pmos ad=0.1596p pd=1.22u as=0.1596p ps=1.22u w=0.84u l=0.13u
X3810 vdd a_98039_98911# a_98876_99132# vdd sg13_lv_pmos ad=0.2128p pd=1.5u as=0.3864p ps=2.93u w=1.12u l=0.13u
X3811 a_91591_93524# adc8b_0.sar12b_0.sg13cmos5l_inv_1_11.Y vdd vdd sg13_lv_pmos ad=0.2716p pd=1.605u as=0.3808p ps=2.92u w=1.12u l=0.13u
X3812 sg13cmos5l_IOPadVdd$1_0.sg13cmos5l_Clamp_N43N43D4R$1_0.gate sg13cmos5l_IOPadVdd$1_0.sg13cmos5l_RCClampInverter$1_0.in vdd vdd sg13_hv_pmos ad=1.33p pd=7.38u as=1.33p ps=7.38u w=7u l=0.5u
X3813 sg13cmos5l_Corner_1.vss vdd sg13cmos5l_Corner_1.vss sg13cmos5l_Corner_1.vss sg13_lv_nmos ad=0.1428p pd=1.52u as=0 ps=0 w=0.42u l=1u
X3814 sg13cmos5l_Corner_1.vss a_94317_100325# a_94419_100468# sg13cmos5l_Corner_1.vss sg13_lv_nmos ad=2.92392p pd=18.89u as=0.2516p ps=2.16u w=0.74u l=0.13u
X3815 a_98039_98911# a_97197_98813# a_96780_99152# vdd sg13_lv_pmos ad=0.2048p pd=1.63u as=0.34p ps=2.68u w=1u l=0.13u
X3816 a_99544_97542# adc8b_0.sar12b_0.sg13cmos5l_dfrbp_1_6.RESET_B vdd vdd sg13_lv_pmos ad=79.8f pd=0.8u as=1.04815p ps=6.595u w=0.42u l=0.13u
X3817 vdd a_83735_96933# a_84572_96572# vdd sg13_lv_pmos ad=0.2128p pd=1.5u as=0.3864p ps=2.93u w=1.12u l=0.13u
X3818 adc8b_0.sar12b_0.sg13cmos5l_o21ai_1_0.B1 adc8b_0.sar12b_0.sg13cmos5l_nand2_1_1.B vdd vdd sg13_lv_pmos ad=0.2128p pd=1.5u as=0.3808p ps=2.92u w=1.12u l=0.13u
X3819 vddr adc8b_0.side_cap8b_0.in_l_sw[0] adc8b_0.side_cap8b_0.buf_32_0.z vddr sg13_lv_pmos ad=0.19p pd=1.38u as=0.19p ps=1.38u w=1u l=0.13u
X3820 a_86900_100310# adc8b_0.sar12b_0.sg13cmos5l_buf_1_44.X vdd vdd sg13_lv_pmos ad=0.2856p pd=2.36u as=0.2114p ps=1.54u w=0.84u l=0.13u
X3821 a_87278_95498# a_88083_95071# a_87538_95028# vdd sg13_lv_pmos ad=0.1428p pd=1.52u as=79.8f ps=0.8u w=0.42u l=0.13u
X3822 a_93298_95028# a_93741_95071# a_93038_95498# sg13cmos5l_Corner_1.vss sg13_lv_nmos ad=79.8f pd=0.8u as=0.1296p ps=1.52u w=0.42u l=0.13u
X3823 a_70044_42476# sg13cmos5l_Corner_1.iovdd sg13cmos5l_Corner_1.iovdd rppd l=12.9u w=0.5u
X3824 sg13cmos5l_IOPadAnalog_10.pad sg13cmos5l_Corner_1.iovdd dpantenna l=1.26u w=27.78u
X3825 adc8b_0.side_cap8b_0.buf_8_2.z adc8b_0.side_cap8b_0.in_h_sw[4] sg13cmos5l_Corner_1.vss sg13cmos5l_Corner_1.vss sg13_lv_nmos ad=0.17p pd=1.68u as=95f ps=0.88u w=0.5u l=0.13u
X3826 adc8b_0.sar12b_0.sg13cmos5l_nand2_1_0.B adc8b_0.sar12b_0.sg13cmos5l_a221oi_1_0.C1 vdd vdd sg13_lv_pmos ad=0.2128p pd=1.5u as=0.2198p ps=1.53u w=1.12u l=0.13u
X3827 adc8b_0.sar12b_0.sg13cmos5l_dlhr_1_21.Q_N a_92766_100328# vdd vdd sg13_lv_pmos ad=0.3808p pd=2.92u as=0.1974p ps=1.5u w=1.12u l=0.13u
X3828 sg13cmos5l_Corner_1.vss adc8b_0.cmp_0.sg13cmos5l_dlygate4sd3_1$1_0.A a_80424_96641# sg13cmos5l_Corner_1.vss sg13_lv_nmos ad=79.8f pd=0.8u as=0.1428p ps=1.52u w=0.42u l=0.13u
X3829 vdd a_83735_96933# a_83992_96814# vdd sg13_lv_pmos ad=0.2639p pd=1.81u as=79.8f ps=0.8u w=0.42u l=0.13u
X3830 a_88140_96128# a_88114_96033# vdd vdd sg13_lv_pmos ad=0.34p pd=2.68u as=0.36237p ps=2.605u w=1u l=0.13u
X3831 sg13cmos5l_Corner_1.vss a_96945_96929# a_97470_97002# sg13cmos5l_Corner_1.vss sg13_lv_nmos ad=0.1491p pd=1.18u as=0.187p ps=1.78u w=0.55u l=0.13u
X3832 vdd adc8b_0.sar12b_0.sg13cmos5l_a22oi_1_0.Y adc8b_0.sar12b_0.sg13cmos5l_dfrbp_1_2.D vdd sg13_lv_pmos ad=0.3808p pd=2.92u as=0.3808p ps=2.92u w=1.12u l=0.13u
X3833 sg13cmos5l_Corner_1.iovdd a_102044_42476# data[2] sg13cmos5l_Corner_1.iovdd sg13_hv_pmos ad=2.1312p pd=7.3u as=3.9294p ps=7.84u w=6.66u l=0.6u
X3834 sg13cmos5l_Corner_1.iovdd a_102044_42476# data[2] sg13cmos5l_Corner_1.iovdd sg13_hv_pmos ad=3.1302p pd=14.26u as=3.9294p ps=7.84u w=6.66u l=0.6u
X3835 vdd adc8b_0.cmp_0.clk a_73970_98361# vdd sg13_lv_pmos ad=95f pd=0.88u as=0.17p ps=1.68u w=0.5u l=0.13u
X3836 adc8b_0.sar12b_0.sg13cmos5l_dfrbp_1_16.Q_N a_83735_98445# vdd vdd sg13_lv_pmos ad=0.4312p pd=3.01u as=0.2639p ps=1.81u w=1.12u l=0.13u
X3837 a_96408_98084# a_95857_98442# vdd vdd sg13_lv_pmos ad=0.105p pd=1.21u as=1.07253p ps=6.75u w=1u l=0.13u
X3838 sg13cmos5l_Corner_1.vss vdd sg13cmos5l_Corner_1.vss sg13cmos5l_Corner_1.vss sg13_lv_nmos ad=0.1428p pd=1.52u as=0 ps=0 w=0.42u l=1u
X3839 vdd adc8b_0.sar12b_0.sg13cmos5l_dfrbp_1_6.RESET_B a_96945_96929# vdd sg13_lv_pmos ad=0.2128p pd=1.5u as=0.2128p ps=1.5u w=1.12u l=0.13u
X3840 vddr sg13cmos5l_Corner_1.iovdd dpantenna l=27.78u w=1.26u
X3841 adc8b_0.side_cap8b_0.buf_8_4.z adc8b_0.side_cap8b_0.in_l_sw[5] sg13cmos5l_Corner_1.vss sg13cmos5l_Corner_1.vss sg13_lv_nmos ad=95f pd=0.88u as=95f ps=0.88u w=0.5u l=0.13u
X3842 a_90970_98834# adc8b_0.sar12b_0.sg13cmos5l_dfrbp_1_6.RESET_B sg13cmos5l_Corner_1.vss sg13cmos5l_Corner_1.vss sg13_lv_nmos ad=37.8f pd=0.6u as=79.8f ps=0.8u w=0.42u l=0.13u
X3843 adc8b_0.sar12b_0.sg13cmos5l_dfrbp_1_12.Q_N a_88823_95421# vdd vdd sg13_lv_pmos ad=0.4312p pd=3.01u as=0.2639p ps=1.81u w=1.12u l=0.13u
X3844 a_84396_94311# a_84108_94616# a_84334_94311# sg13cmos5l_Corner_1.vss sg13_lv_nmos ad=0.1428p pd=1.52u as=37.8f ps=0.6u w=0.42u l=0.13u
X3845 sg13cmos5l_Corner_1.vss adc8b_0.sar12b_0.sg13cmos5l_inv_1_3.A adc8b_0.sar12b_0.sg13cmos5l_buf_1_7.A sg13cmos5l_Corner_1.vss sg13_lv_nmos ad=0.2516p pd=2.16u as=0.2516p ps=2.16u w=0.74u l=0.13u
X3846 sg13cmos5l_Corner_1.vss adc8b_0.sar12b_0.nl_sw[6] adc8b_0.side_cap8b_1.buf_4_3.z sg13cmos5l_Corner_1.vss sg13_lv_nmos ad=95f pd=0.88u as=95f ps=0.88u w=0.5u l=0.13u
X3847 vdd sg13cmos5l_IOPadVdd$1_0.sg13cmos5l_Clamp_N43N43D4R$1_0.gate sg13cmos5l_Corner_1.vss sg13cmos5l_Corner_1.vss sg13_hv_nmos ad=2.596p pd=5.58u as=1.408p ps=5.04u w=4.4u l=0.6u
X3848 a_95745_97637# a_94803_97444# a_95543_97399# vdd sg13_lv_pmos ad=93.45f pd=0.865u as=0.2048p ps=1.63u w=0.42u l=0.13u
X3849 adc8b_0.side_cap8b_1.buf_16_3.z adc8b_0.sar12b_0.nh_sw[1] vddr vddr sg13_lv_pmos ad=0.19p pd=1.38u as=0.19p ps=1.38u w=1u l=0.13u
X3850 a_99548_99596# a_99135_99954# a_99480_99596# vdd sg13_lv_pmos ad=0.191p pd=1.44u as=0.105p ps=1.21u w=1u l=0.13u
X3851 a_96351_96930# adc8b_0.sar12b_0.sg13cmos5l_dfrbp_1_23.CLK sg13cmos5l_Corner_1.vss sg13cmos5l_Corner_1.vss sg13_lv_nmos ad=0.2516p pd=2.16u as=0.15055p ps=1.17u w=0.74u l=0.13u
X3852 sg13cmos5l_Corner_1.iovdd a_164624_118044# sg13cmos5l_IOPadAnalog_11.pad sg13cmos5l_Corner_1.iovdd sg13_hv_pmos ad=2.1312p pd=7.3u as=3.9294p ps=7.84u w=6.66u l=0.6u
X3853 sg13cmos5l_Corner_1.vss adc8b_0.side_cap8b_0.in_l_sw[2] adc8b_0.side_cap8b_0.buf_16_1.z sg13cmos5l_Corner_1.vss sg13_lv_nmos ad=95f pd=0.88u as=95f ps=0.88u w=0.5u l=0.13u
X3854 a_94257_100737# a_93900_100664# vdd vdd sg13_lv_pmos ad=63f pd=0.72u as=0.1563p ps=1.22u w=0.42u l=0.13u
X3855 a_87854_95810# a_88659_95932# a_88114_96033# vdd sg13_lv_pmos ad=0.1428p pd=1.52u as=79.8f ps=0.8u w=0.42u l=0.13u
X3856 a_94840_95302# adc8b_0.sar12b_0.sg13cmos5l_dfrbp_1_0.RESET_B vdd vdd sg13_lv_pmos ad=79.8f pd=0.8u as=1.38655p ps=8.8u w=0.42u l=0.13u
X3857 adc8b_0.sar12b_0.sg13cmos5l_buf_1_4.X a_98320_92824# vdd vdd sg13_lv_pmos ad=0.42p pd=2.99u as=0.2114p ps=1.54u w=1.12u l=0.13u
X3858 vdd sg13cmos5l_IOPadVdd$1_0.sg13cmos5l_Clamp_N43N43D4R$1_0.gate sg13cmos5l_Corner_1.vss sg13cmos5l_Corner_1.vss sg13_hv_nmos ad=2.596p pd=5.58u as=1.408p ps=5.04u w=4.4u l=0.6u
X3859 vdd a_85809_93905# a_85742_93548# vdd sg13_lv_pmos ad=0.2387p pd=1.84u as=0.1008p ps=0.9u w=0.42u l=0.13u
X3860 sg13cmos5l_Corner_1.vss adc8b_0.sar12b_0.sg13cmos5l_dfrbp_1_6.RESET_B a_90844_96960# sg13cmos5l_Corner_1.vss sg13_lv_nmos ad=0.1406p pd=1.12u as=77.7f ps=0.95u w=0.74u l=0.13u
X3861 sg13cmos5l_Corner_1.vss adc8b_0.sar12b_0.nh_sw[2] adc8b_0.side_cap8b_1.buf_16_0.z sg13cmos5l_Corner_1.vss sg13_lv_nmos ad=95f pd=0.88u as=95f ps=0.88u w=0.5u l=0.13u
X3862 adc8b_0.side_cap8b_0.in_h_sw[3] a_87184_100384# sg13cmos5l_Corner_1.vss sg13cmos5l_Corner_1.vss sg13_lv_nmos ad=0.2886p pd=2.26u as=0.14875p ps=1.16u w=0.74u l=0.13u
X3863 a_82418_95060# adc8b_0.sar12b_0.sg13cmos5l_nor2_1_2.A vdd vdd sg13_lv_pmos ad=0.1176p pd=1.33u as=0.4032p ps=2.96u w=1.12u l=0.13u
X3864 vdd a_85844_98784# a_85444_99124# vdd sg13_lv_pmos ad=0.2387p pd=1.84u as=0.2128p ps=1.5u w=1.12u l=0.13u
X3865 sg13cmos5l_Corner_1.vss a_86420_97286# adc8b_0.sar12b_0.sg13cmos5l_inv_1_19.A sg13cmos5l_Corner_1.vss sg13_lv_nmos ad=0.14875p pd=1.16u as=0.2886p ps=2.26u w=0.74u l=0.13u
X3866 adc8b_0.sar12b_0.sg13cmos5l_buf_1_26.A adc8b_0.sar12b_0.sg13cmos5l_buf_1_45.X vdd vdd sg13_lv_pmos ad=0.3808p pd=2.92u as=0.3808p ps=2.92u w=1.12u l=0.13u
X3867 adc8b_0.side_cap8b_1.buf_32_1.z adc8b_0.sar12b_0.nh_sw[0] vddr vddr sg13_lv_pmos ad=0.19p pd=1.38u as=0.19p ps=1.38u w=1u l=0.13u
X3868 a_84980_92750# adc8b_0.sar12b_0.sg13cmos5l_buf_1_41.A sg13cmos5l_Corner_1.vss sg13cmos5l_Corner_1.vss sg13_lv_nmos ad=0.187p pd=1.78u as=0.14875p ps=1.16u w=0.55u l=0.13u
X3869 adc8b_0.sar12b_0.nh_sw[3] a_87472_92824# vdd vdd sg13_lv_pmos ad=0.42p pd=2.99u as=0.2114p ps=1.54u w=1.12u l=0.13u
X3870 a_89292_99152# a_89266_99057# vdd vdd sg13_lv_pmos ad=0.34p pd=2.68u as=0.36237p ps=2.605u w=1u l=0.13u
X3871 vdd a_93335_98911# a_93592_99054# vdd sg13_lv_pmos ad=0.2639p pd=1.81u as=79.8f ps=0.8u w=0.42u l=0.13u
X3872 vddr adc8b_0.sar12b_0.nh_sw[0] adc8b_0.side_cap8b_1.buf_32_1.z vddr sg13_lv_pmos ad=0.19p pd=1.38u as=0.19p ps=1.38u w=1u l=0.13u
X3873 sg13cmos5l_Corner_1.vss adc8b_0.sar12b_0.nl_sw[4] adc8b_0.side_cap8b_1.buf_8_0.z sg13cmos5l_Corner_1.vss sg13_lv_nmos ad=95f pd=0.88u as=95f ps=0.88u w=0.5u l=0.13u
X3874 sg13cmos5l_IOPadVdd$1_0.sg13cmos5l_Clamp_N43N43D4R$1_0.gate sg13cmos5l_IOPadVdd$1_0.sg13cmos5l_RCClampInverter$1_0.in vdd vdd sg13_hv_pmos ad=1.33p pd=7.38u as=1.33p ps=7.38u w=7u l=0.5u
X3875 sg13cmos5l_Corner_1.vss adc8b_0.sar12b_0.sg13cmos5l_dfrbp_1_8.RESET_B a_96204_100034# sg13cmos5l_Corner_1.vss sg13_lv_nmos ad=0.1626p pd=1.415u as=60.89999f ps=0.71u w=0.42u l=0.13u
X3876 a_97870_95823# adc8b_0.sar12b_0.sg13cmos5l_dfrbp_1_8.RESET_B sg13cmos5l_Corner_1.vss sg13cmos5l_Corner_1.vss sg13_lv_nmos ad=37.8f pd=0.6u as=0.1701p ps=1.65u w=0.42u l=0.13u
X3877 frame a_134044_30676# sg13cmos5l_Corner_1.vss sg13cmos5l_Corner_1.vss sg13_hv_nmos ad=2.596p pd=5.58u as=2.068p ps=9.74u w=4.4u l=0.6u
X3878 sg13cmos5l_Corner_1.vss adc8b_0.side_cap8b_0.in_h_sw[0] adc8b_0.side_cap8b_0.buf_32_1.z sg13cmos5l_Corner_1.vss sg13_lv_nmos ad=95f pd=0.88u as=95f ps=0.88u w=0.5u l=0.13u
X3879 sg13cmos5l_Corner_1.vss a_99639_178370# sg13cmos5l_IOPadAnalog_15.pad sg13cmos5l_Corner_1.vss sg13_hv_nmos ad=1.408p pd=5.04u as=2.596p ps=5.58u w=4.4u l=0.6u
X3880 sg13cmos5l_Corner_1.vss adc8b_0.sar12b_0.sg13cmos5l_inv_1_1.A a_98032_100384# sg13cmos5l_Corner_1.vss sg13_lv_nmos ad=0.14875p pd=1.16u as=0.187p ps=1.78u w=0.55u l=0.13u
X3881 sg13cmos5l_Corner_1.vss adc8b_0.sar12b_0.sg13cmos5l_dlhr_1_9.D a_92355_95852# sg13cmos5l_Corner_1.vss sg13_lv_nmos ad=0.14505p pd=1.15u as=0.187p ps=1.78u w=0.55u l=0.13u
X3882 adc8b_0.side_cap8b_1.buf_16_3.z adc8b_0.sar12b_0.nh_sw[1] sg13cmos5l_Corner_1.vss sg13cmos5l_Corner_1.vss sg13_lv_nmos ad=0.17p pd=1.68u as=95f ps=0.88u w=0.5u l=0.13u
X3883 vddr adc8b_0.sar12b_0.nl_sw[1] adc8b_0.side_cap8b_1.buf_16_2.z vddr sg13_lv_pmos ad=0.19p pd=1.38u as=0.19p ps=1.38u w=1u l=0.13u
X3884 sg13cmos5l_Corner_1.vss a_33862_86222# dantenna l=27.78u w=1.26u
X3885 adc8b_0.side_cap8b_0.buf_32_1.z adc8b_0.side_cap8b_0.in_h_sw[0] sg13cmos5l_Corner_1.vss sg13cmos5l_Corner_1.vss sg13_lv_nmos ad=95f pd=0.88u as=95f ps=0.88u w=0.5u l=0.13u
X3886 a_92840_96507# adc8b_0.sar12b_0.sg13cmos5l_nor2_1_0.A a_93138_96920# sg13cmos5l_Corner_1.vss sg13_lv_nmos ad=0.2176p pd=1.96u as=0.1216p ps=1.02u w=0.64u l=0.13u
X3887 a_84396_94311# a_84627_94420# a_84082_94521# sg13cmos5l_Corner_1.vss sg13_lv_nmos ad=0.2373p pd=1.97u as=79.8f ps=0.8u w=0.42u l=0.13u
X3888 vdd cks adc8b_0.sar12b_0.sg13cmos5l_dfrbp_1_6.RESET_B vdd sg13_lv_pmos ad=0.3808p pd=2.92u as=0.2184p ps=1.51u w=1.12u l=0.13u
X3889 sg13cmos5l_Corner_1.vss vdd sg13cmos5l_Corner_1.vss sg13cmos5l_Corner_1.vss sg13_lv_nmos ad=79.8f pd=0.8u as=0 ps=0 w=0.42u l=1u
X3890 adc8b_0.side_cap8b_0.buf_32_1.z adc8b_0.side_cap8b_0.in_h_sw[0] vddr vddr sg13_lv_pmos ad=0.19p pd=1.38u as=0.19p ps=1.38u w=1u l=0.13u
X3891 sg13cmos5l_Corner_1.vss a_88173_99607# a_88275_99607# sg13cmos5l_Corner_1.vss sg13_lv_nmos ad=2.92392p pd=18.89u as=0.2516p ps=2.16u w=0.74u l=0.13u
X3892 adc8b_0.sar12b_0.sg13cmos5l_nor2_1_0.A a_95324_93548# vdd vdd sg13_lv_pmos ad=0.3808p pd=2.92u as=0.2128p ps=1.5u w=1.12u l=0.13u
X3893 sg13cmos5l_Corner_1.iovdd a_134044_42476# frame sg13cmos5l_Corner_1.iovdd sg13_hv_pmos ad=2.1312p pd=7.3u as=3.9294p ps=7.84u w=6.66u l=0.6u
X3894 adc8b_0.sar12b_0.sg13cmos5l_buf_1_78.X a_87952_100384# sg13cmos5l_Corner_1.vss sg13cmos5l_Corner_1.vss sg13_lv_nmos ad=0.2886p pd=2.26u as=0.14875p ps=1.16u w=0.74u l=0.13u
X3895 sg13cmos5l_Corner_1.vss a_83735_96933# a_84572_96572# sg13cmos5l_Corner_1.vss sg13_lv_nmos ad=0.1406p pd=1.12u as=0.2516p ps=2.16u w=0.74u l=0.13u
X3896 adc8b_0.sar12b_0.sg13cmos5l_dfrbp_1_20.Q_N a_90551_98911# vdd vdd sg13_lv_pmos ad=0.4312p pd=3.01u as=0.2639p ps=1.81u w=1.12u l=0.13u
X3897 vdd a_94317_100325# a_94419_100468# vdd sg13_lv_pmos ad=4.11675p pd=27.17u as=0.3864p ps=2.93u w=1.12u l=0.13u
X3898 sg13cmos5l_IOPadAnalog_1.pad a_164624_70044# sg13cmos5l_Corner_1.iovdd sg13cmos5l_Corner_1.iovdd sg13_hv_pmos ad=3.9294p pd=7.84u as=2.1312p ps=7.3u w=6.66u l=0.6u
X3899 adc8b_0.side_cap8b_0.buf_8_4.z adc8b_0.side_cap8b_0.in_l_sw[5] vddr vddr sg13_lv_pmos ad=0.19p pd=1.38u as=0.19p ps=1.38u w=1u l=0.13u
X3900 a_70946_99114# vdd a_70852_97472# sg13cmos5l_Corner_1.vss sg13_lv_nmos ad=0.57p pd=3.38u as=1.02p ps=6.68u w=3u l=0.13u
X3901 vip a_30676_102044# sg13cmos5l_Corner_1.vss sg13cmos5l_Corner_1.vss sg13_hv_nmos ad=2.596p pd=5.58u as=1.408p ps=5.04u w=4.4u l=0.6u
X3902 sg13cmos5l_IOPadAnalog_1.pad sg13cmos5l_Corner_1.iovdd dpantenna l=27.78u w=1.26u
X3903 a_86428_98472# a_86012_98084# a_86193_98441# sg13cmos5l_Corner_1.vss sg13_lv_nmos ad=77.7f pd=0.95u as=0.2516p ps=2.16u w=0.74u l=0.13u
X3904 vdd a_88727_97399# a_88984_97542# vdd sg13_lv_pmos ad=0.2639p pd=1.81u as=79.8f ps=0.8u w=0.42u l=0.13u
X3905 data[2] a_102044_42476# sg13cmos5l_Corner_1.iovdd sg13cmos5l_Corner_1.iovdd sg13_hv_pmos ad=3.9294p pd=7.84u as=2.1312p ps=7.3u w=6.66u l=0.6u
X3906 vdd adc8b_0.sar12b_0.sg13cmos5l_dfrbp_1_0.RESET_B a_99154_93009# vdd sg13_lv_pmos ad=0.1563p pd=1.22u as=0.147p ps=1.54u w=0.42u l=0.13u
X3907 vdd a_94583_92863# a_95420_93084# vdd sg13_lv_pmos ad=0.2128p pd=1.5u as=0.3864p ps=2.93u w=1.12u l=0.13u
X3908 sg13cmos5l_Corner_1.vss adc8b_0.sar12b_0.sg13cmos5l_buf_1_30.A a_90448_92824# sg13cmos5l_Corner_1.vss sg13_lv_nmos ad=0.14875p pd=1.16u as=0.187p ps=1.78u w=0.55u l=0.13u
X3909 sg13cmos5l_Corner_1.vss a_94487_93909# a_95324_93548# sg13cmos5l_Corner_1.vss sg13_lv_nmos ad=0.1406p pd=1.12u as=0.2516p ps=2.16u w=0.74u l=0.13u
X3910 adc8b_0.side_cap8b_0.buf_32_0.z adc8b_0.side_cap8b_0.in_l_sw[0] vddr vddr sg13_lv_pmos ad=0.34p pd=2.68u as=0.19p ps=1.38u w=1u l=0.13u
X3911 a_82764_96997# a_82995_96583# a_82450_96540# sg13cmos5l_Corner_1.vss sg13_lv_nmos ad=0.2373p pd=1.97u as=79.8f ps=0.8u w=0.42u l=0.13u
X3912 data[1] a_86044_42476# sg13cmos5l_Corner_1.iovdd sg13cmos5l_Corner_1.iovdd sg13_hv_pmos ad=3.9294p pd=7.84u as=2.1312p ps=7.3u w=6.66u l=0.6u
X3913 a_86327_98790# adc8b_0.sar12b_0.sg13cmos5l_dlhr_1_9.D vdd vdd sg13_lv_pmos ad=0.2856p pd=2.36u as=1.15047p ps=7.175u w=0.84u l=0.13u
X3914 adc8b_0.sar12b_0.sg13cmos5l_dfrbp_1_16.Q_N a_83735_98445# sg13cmos5l_Corner_1.vss sg13cmos5l_Corner_1.vss sg13_lv_nmos ad=0.2849p pd=2.25u as=0.2516p ps=2.16u w=0.74u l=0.13u
X3915 a_74586_95659# adc8b_0.diff_bsw_0.vcp a_76796_95659# sg13cmos5l_Corner_1.vss sg13_lv_nmos ad=0.95p pd=5.38u as=1.7p ps=10.68u w=5u l=0.13u
X3916 adc8b_0.sar12b_0.sg13cmos5l_buf_8_0.X a_100995_95814# sg13cmos5l_Corner_1.vss sg13cmos5l_Corner_1.vss sg13_lv_nmos ad=0.1406p pd=1.12u as=0.1406p ps=1.12u w=0.74u l=0.13u
X3917 sg13cmos5l_Corner_1.iovdd a_42476_118044# sg13cmos5l_Corner_1.iovdd rppd l=12.9u w=0.5u
X3918 sg13cmos5l_Corner_1.vss adc8b_0.sar12b_0.sg13cmos5l_dfrbp_1_6.RESET_B a_89500_94284# sg13cmos5l_Corner_1.vss sg13_lv_nmos ad=0.1406p pd=1.12u as=77.7f ps=0.95u w=0.74u l=0.13u
X3919 vdd a_96813_99607# a_96915_99607# vdd sg13_lv_pmos ad=1.15047p pd=7.175u as=0.3864p ps=2.93u w=1.12u l=0.13u
X3920 adc8b_0.sar12b_0.sg13cmos5l_dfrbp_1_12.Q_N a_88823_95421# sg13cmos5l_Corner_1.vss sg13cmos5l_Corner_1.vss sg13_lv_nmos ad=0.2849p pd=2.25u as=0.2516p ps=2.16u w=0.74u l=0.13u
X3921 frame a_134044_42476# sg13cmos5l_Corner_1.iovdd sg13cmos5l_Corner_1.iovdd sg13_hv_pmos ad=3.9294p pd=7.84u as=2.1312p ps=7.3u w=6.66u l=0.6u
X3922 a_83614_99010# a_83716_99124# vdd vdd sg13_lv_pmos ad=0.2856p pd=2.36u as=0.1974p ps=1.5u w=0.84u l=0.13u
X3923 a_93140_94262# adc8b_0.sar12b_0.sg13cmos5l_buf_1_9.A vdd vdd sg13_lv_pmos ad=0.2856p pd=2.36u as=0.2114p ps=1.54u w=0.84u l=0.13u
X3924 sg13cmos5l_Corner_1.vss adc8b_0.sar12b_0.nh_sw[9] adc8b_0.side_cap8b_1.buf_2_3.z sg13cmos5l_Corner_1.vss sg13_lv_nmos ad=95f pd=0.88u as=0.17p ps=1.68u w=0.5u l=0.13u
X3925 data[0] a_70044_30676# sg13cmos5l_Corner_1.vss sg13cmos5l_Corner_1.vss sg13_hv_nmos ad=2.596p pd=5.58u as=2.068p ps=9.74u w=4.4u l=0.6u
X3926 a_89390_93224# a_88994_92796# a_89276_93108# vdd sg13_lv_pmos ad=0.1008p pd=0.9u as=0.191p ps=1.44u w=0.42u l=0.13u
X3927 a_87192_94620# a_86641_94352# vdd vdd sg13_lv_pmos ad=0.105p pd=1.21u as=1.43437p ps=9.105u w=1u l=0.13u
X3928 sg13cmos5l_Corner_1.vss a_178296_70044# sg13cmos5l_IOPadAnalog_1.pad sg13cmos5l_Corner_1.vss sg13_hv_nmos ad=1.408p pd=5.04u as=2.596p ps=5.58u w=4.4u l=0.6u
X3929 sg13cmos5l_Corner_1.vss adc8b_0.sar12b_0.nl_sw[2] adc8b_0.side_cap8b_1.buf_16_1.z sg13cmos5l_Corner_1.vss sg13_lv_nmos ad=95f pd=0.88u as=95f ps=0.88u w=0.5u l=0.13u
X3930 adc8b_0.side_cap8b_0.in_h_sw[1] a_83632_100384# sg13cmos5l_Corner_1.vss sg13cmos5l_Corner_1.vss sg13_lv_nmos ad=0.2886p pd=2.26u as=0.14875p ps=1.16u w=0.74u l=0.13u
X3931 a_72090_94286# vdd a_71988_94286# sg13cmos5l_Corner_1.vss sg13_lv_nmos ad=0.17p pd=1.68u as=95f ps=0.88u w=0.5u l=0.13u
X3932 a_90254_100034# a_91059_99607# a_90514_99564# vdd sg13_lv_pmos ad=0.1428p pd=1.52u as=79.8f ps=0.8u w=0.42u l=0.13u
X3933 a_94681_98486# a_94129_98442# sg13cmos5l_Corner_1.vss sg13cmos5l_Corner_1.vss sg13_lv_nmos ad=71.99999f pd=0.865u as=1.49685p ps=9.6u w=0.64u l=0.13u
X3934 a_97589_95024# a_98319_95147# a_98230_95183# vdd sg13_lv_pmos ad=0.2048p pd=1.63u as=93.45f ps=0.865u w=0.42u l=0.13u
X3935 vddr adc8b_0.sar12b_0.nl_sw[5] adc8b_0.side_cap8b_1.buf_8_4.z vddr sg13_lv_pmos ad=0.19p pd=1.38u as=0.34p ps=2.68u w=1u l=0.13u
X3936 sg13cmos5l_Corner_1.vss a_67639_178370# sg13cmos5l_IOPadAnalog_10.pad sg13cmos5l_Corner_1.vss sg13_hv_nmos ad=1.408p pd=5.04u as=2.596p ps=5.58u w=4.4u l=0.6u
X3937 cks a_42476_118044# sg13cmos5l_Corner_1.iovdd sg13cmos5l_Corner_1.iovdd sg13_hv_pmos ad=3.9294p pd=7.84u as=2.1312p ps=7.3u w=6.66u l=0.6u
X3938 sg13cmos5l_Corner_1.iovdd a_42476_102044# vip sg13cmos5l_Corner_1.iovdd sg13_hv_pmos ad=2.1312p pd=7.3u as=3.9294p ps=7.84u w=6.66u l=0.6u
X3939 vdd a_85940_92750# adc8b_0.sar12b_0.sg13cmos5l_buf_1_33.A vdd sg13_lv_pmos ad=0.2114p pd=1.54u as=0.42p ps=2.99u w=1.12u l=0.13u
X3940 vdd a_82964_99560# adc8b_0.sar12b_0.sg13cmos5l_buf_1_63.X vdd sg13_lv_pmos ad=0.2114p pd=1.54u as=0.42p ps=2.99u w=1.12u l=0.13u
X3941 sg13cmos5l_Corner_1.vss a_83646_97497# adc8b_0.sar12b_0.sg13cmos5l_dlhr_1_1.GATE sg13cmos5l_Corner_1.vss sg13_lv_nmos ad=0.1406p pd=1.12u as=0.2516p ps=2.16u w=0.74u l=0.13u
X3942 sg13cmos5l_Corner_1.vss adc8b_0.sar12b_0.nl_sw[3] adc8b_0.side_cap8b_1.buf_8_1.z sg13cmos5l_Corner_1.vss sg13_lv_nmos ad=95f pd=0.88u as=95f ps=0.88u w=0.5u l=0.13u
X3943 vddr adc8b_0.sar12b_0.nh_sw[1] adc8b_0.side_cap8b_1.buf_16_3.z vddr sg13_lv_pmos ad=0.19p pd=1.38u as=0.19p ps=1.38u w=1u l=0.13u
X3944 sg13cmos5l_Corner_1.iovdd a_70044_42476# data[0] sg13cmos5l_Corner_1.iovdd sg13_hv_pmos ad=2.1312p pd=7.3u as=3.9294p ps=7.84u w=6.66u l=0.6u
X3945 adc8b_0.sar12b_0.sg13cmos5l_dfrbp_1_8.D a_99932_98084# vdd vdd sg13_lv_pmos ad=0.3808p pd=2.92u as=0.2128p ps=1.5u w=1.12u l=0.13u
X3946 vddr adc8b_0.sar12b_0.nl_sw[2] adc8b_0.side_cap8b_1.buf_16_1.z vddr sg13_lv_pmos ad=0.19p pd=1.38u as=0.19p ps=1.38u w=1u l=0.13u
X3947 vdd sg13cmos5l_IOPadVdd$1_0.sg13cmos5l_Clamp_N43N43D4R$1_0.gate sg13cmos5l_Corner_1.vss sg13cmos5l_Corner_1.vss sg13_hv_nmos ad=2.596p pd=5.58u as=1.408p ps=5.04u w=4.4u l=0.6u
X3948 adc8b_0.side_cap8b_0.buf_16_2.z adc8b_0.side_cap8b_0.in_l_sw[1] vddr vddr sg13_lv_pmos ad=0.19p pd=1.38u as=0.19p ps=1.38u w=1u l=0.13u
X3949 vin a_30676_86044# sg13cmos5l_Corner_1.vss sg13cmos5l_Corner_1.vss sg13_hv_nmos ad=2.596p pd=5.58u as=2.068p ps=9.74u w=4.4u l=0.6u
X3950 adc8b_0.side_cap8b_1.buf_16_0.z adc8b_0.sar12b_0.nh_sw[2] sg13cmos5l_Corner_1.vss sg13cmos5l_Corner_1.vss sg13_lv_nmos ad=95f pd=0.88u as=95f ps=0.88u w=0.5u l=0.13u
X3951 vdd sg13cmos5l_Corner_1.vss vdd vdd sg13_lv_pmos ad=0.34p pd=2.68u as=0 ps=0 w=1u l=1u
X3952 a_90361_96974# a_89809_96930# sg13cmos5l_Corner_1.vss sg13cmos5l_Corner_1.vss sg13_lv_nmos ad=71.99999f pd=0.865u as=1.97045p ps=12.335u w=0.64u l=0.13u
X3953 sg13cmos5l_Corner_1.vss a_175886_70222# dantenna l=27.78u w=1.26u
X3954 adc8b_0.side_cap8b_1.buf_8_1.z adc8b_0.sar12b_0.nl_sw[3] vddr vddr sg13_lv_pmos ad=0.19p pd=1.38u as=0.19p ps=1.38u w=1u l=0.13u
X3955 sg13cmos5l_Corner_1.vss adc8b_0.sar12b_0.nl_sw[1] adc8b_0.side_cap8b_1.buf_16_2.z sg13cmos5l_Corner_1.vss sg13_lv_nmos ad=95f pd=0.88u as=95f ps=0.88u w=0.5u l=0.13u
X3956 vdd a_85076_100310# adc8b_0.sar12b_0.sg13cmos5l_inv_1_8.A vdd sg13_lv_pmos ad=0.2114p pd=1.54u as=0.42p ps=2.99u w=1.12u l=0.13u
X3957 a_90460_98472# a_90044_98084# a_90225_98441# sg13cmos5l_Corner_1.vss sg13_lv_nmos ad=77.7f pd=0.95u as=0.2516p ps=2.16u w=0.74u l=0.13u
X3958 sg13cmos5l_Corner_1.vss adc8b_0.sar12b_0.sg13cmos5l_nand2_1_2.B a_82978_95814# sg13cmos5l_Corner_1.vss sg13_lv_nmos ad=0.2516p pd=2.16u as=0.1406p ps=1.12u w=0.74u l=0.13u
X3959 adc8b_0.side_cap8b_1.buf_8_5.z adc8b_0.sar12b_0.nh_sw[5] vddr vddr sg13_lv_pmos ad=0.34p pd=2.68u as=0.19p ps=1.38u w=1u l=0.13u
X3960 adc8b_0.side_cap8b_0.buf_16_3.z adc8b_0.side_cap8b_0.in_h_sw[1] sg13cmos5l_Corner_1.vss sg13cmos5l_Corner_1.vss sg13_lv_nmos ad=95f pd=0.88u as=95f ps=0.88u w=0.5u l=0.13u
X3961 adc8b_0.diff_bsw_0.single_bsw_1.sg13cmos5l_inv_1$1_0.A cks vdd vdd sg13_lv_pmos ad=0.3808p pd=2.92u as=0.3808p ps=2.92u w=1.12u l=0.13u
X3962 vdd adc8b_0.sar12b_0.sg13cmos5l_inv_1_3.A adc8b_0.sar12b_0.sg13cmos5l_buf_1_7.A vdd sg13_lv_pmos ad=0.3808p pd=2.92u as=0.3808p ps=2.92u w=1.12u l=0.13u
X3963 sg13cmos5l_Corner_1.vss a_88340_92750# adc8b_0.sar12b_0.sg13cmos5l_buf_1_24.X sg13cmos5l_Corner_1.vss sg13_lv_nmos ad=0.14875p pd=1.16u as=0.2886p ps=2.26u w=0.74u l=0.13u
X3964 sg13cmos5l_Corner_1.iovdd a_42476_118044# cks sg13cmos5l_Corner_1.iovdd sg13_hv_pmos ad=3.1302p pd=14.26u as=3.9294p ps=7.84u w=6.66u l=0.6u
X3965 sg13cmos5l_Corner_1.iovdd a_42476_70044# vddr sg13cmos5l_Corner_1.iovdd sg13_hv_pmos ad=2.1312p pd=7.3u as=3.9294p ps=7.84u w=6.66u l=0.6u
X3966 vdd a_101972_96536# adc8b_0.sar12b_0.sg13cmos5l_inv_1_6.A vdd sg13_lv_pmos ad=0.2114p pd=1.54u as=0.42p ps=2.99u w=1.12u l=0.13u
X3967 vin a_42476_86044# sg13cmos5l_Corner_1.iovdd sg13cmos5l_Corner_1.iovdd sg13_hv_pmos ad=3.9294p pd=7.84u as=2.1312p ps=7.3u w=6.66u l=0.6u
X3968 data[0] a_70044_42476# sg13cmos5l_Corner_1.iovdd sg13cmos5l_Corner_1.iovdd sg13_hv_pmos ad=3.9294p pd=7.84u as=2.1312p ps=7.3u w=6.66u l=0.6u
X3969 frame a_134044_42476# sg13cmos5l_Corner_1.iovdd sg13cmos5l_Corner_1.iovdd sg13_hv_pmos ad=3.9294p pd=7.84u as=2.1312p ps=7.3u w=6.66u l=0.6u
X3970 sg13cmos5l_Corner_1.iovdd a_164624_102044# sg13cmos5l_IOPadAnalog_16.pad sg13cmos5l_Corner_1.iovdd sg13_hv_pmos ad=2.1312p pd=7.3u as=3.9294p ps=7.84u w=6.66u l=0.6u
X3971 sg13cmos5l_Corner_1.iovdd a_42476_86044# vin sg13cmos5l_Corner_1.iovdd sg13_hv_pmos ad=2.1312p pd=7.3u as=3.9294p ps=7.84u w=6.66u l=0.6u
X3972 vddr adc8b_0.side_cap8b_0.in_l_sw[2] adc8b_0.side_cap8b_0.buf_16_1.z vddr sg13_lv_pmos ad=0.19p pd=1.38u as=0.34p ps=2.68u w=1u l=0.13u
X3973 vdd a_100995_100350# adc8b_0.sar12b_0.sg13cmos5l_buf_8_2.X vdd sg13_lv_pmos ad=0.2128p pd=1.5u as=0.2128p ps=1.5u w=1.12u l=0.13u
X3974 adc8b_0.side_cap8b_1.buf_16_2.z adc8b_0.sar12b_0.nl_sw[1] vddr vddr sg13_lv_pmos ad=0.19p pd=1.38u as=0.19p ps=1.38u w=1u l=0.13u
X3975 vddr adc8b_0.sar12b_0.nl_sw[0] adc8b_0.side_cap8b_1.buf_32_0.z vddr sg13_lv_pmos ad=0.19p pd=1.38u as=0.19p ps=1.38u w=1u l=0.13u
X3976 a_83890_95028# a_84333_95071# a_84273_95107# vdd sg13_lv_pmos ad=79.8f pd=0.8u as=63f ps=0.72u w=0.42u l=0.13u
X3977 vdd a_90356_95024# adc8b_0.sar12b_0.sg13cmos5l_buf_1_30.A vdd sg13_lv_pmos ad=0.2114p pd=1.54u as=0.42p ps=2.99u w=1.12u l=0.13u
X3978 sg13cmos5l_Corner_1.vss a_85624_94518# a_85273_94375# sg13cmos5l_Corner_1.vss sg13_lv_nmos ad=79.8f pd=0.8u as=0.1428p ps=1.52u w=0.42u l=0.13u
X3979 a_96311_94375# a_95469_94277# a_96217_94375# sg13cmos5l_Corner_1.vss sg13_lv_nmos ad=0.12665p pd=1.145u as=0.1428p ps=1.52u w=0.42u l=0.13u
X3980 adc8b_0.side_cap8b_1.buf_16_0.z adc8b_0.sar12b_0.nh_sw[2] vddr vddr sg13_lv_pmos ad=0.19p pd=1.38u as=0.19p ps=1.38u w=1u l=0.13u
X3981 sg13cmos5l_Corner_1.vss adc8b_0.sar12b_0.nh_sw[1] adc8b_0.side_cap8b_1.buf_16_3.z sg13cmos5l_Corner_1.vss sg13_lv_nmos ad=95f pd=0.88u as=95f ps=0.88u w=0.5u l=0.13u
X3982 a_36456_137395# a_40542_137725# sg13cmos5l_Corner_1.vss rppd l=20u w=1u
X3983 adc8b_0.sar12b_0.sg13cmos5l_dlhr_1_15.Q a_100113_98834# vdd vdd sg13_lv_pmos ad=0.3808p pd=2.92u as=0.2128p ps=1.5u w=1.12u l=0.13u
X3984 sg13cmos5l_Corner_1.iovdd a_115639_164698# sg13cmos5l_IOPadAnalog_13.pad sg13cmos5l_Corner_1.iovdd sg13_hv_pmos ad=2.1312p pd=7.3u as=3.9294p ps=7.84u w=6.66u l=0.6u
X3985 sg13cmos5l_Corner_1.vss adc8b_0.side_cap8b_0.in_h_sw[2] adc8b_0.side_cap8b_0.buf_16_0.z sg13cmos5l_Corner_1.vss sg13_lv_nmos ad=95f pd=0.88u as=95f ps=0.88u w=0.5u l=0.13u
X3986 sg13cmos5l_Corner_1.vss sg13cmos5l_IOPadVdd$1_0.sg13cmos5l_Clamp_N43N43D4R$1_0.gate vdd sg13cmos5l_Corner_1.vss sg13_hv_nmos ad=1.408p pd=5.04u as=2.596p ps=5.58u w=4.4u l=0.6u
X3987 sg13cmos5l_Corner_1.vss a_30676_86044# vin sg13cmos5l_Corner_1.vss sg13_hv_nmos ad=1.408p pd=5.04u as=2.596p ps=5.58u w=4.4u l=0.6u
X3988 sg13cmos5l_Corner_1.vss a_95543_97399# a_96380_97620# sg13cmos5l_Corner_1.vss sg13_lv_nmos ad=0.1406p pd=1.12u as=0.2516p ps=2.16u w=0.74u l=0.13u
X3989 a_89434_100034# adc8b_0.sar12b_0.sg13cmos5l_dfrbp_1_8.RESET_B sg13cmos5l_Corner_1.vss sg13cmos5l_Corner_1.vss sg13_lv_nmos ad=37.8f pd=0.6u as=79.8f ps=0.8u w=0.42u l=0.13u
X3990 a_85599_98442# adc8b_0.sar12b_0.sg13cmos5l_dfrbp_1_15.D vdd vdd sg13_lv_pmos ad=0.3234p pd=2.45u as=1.04815p ps=6.595u w=0.84u l=0.13u
X3991 a_92433_98441# a_92252_98084# vdd vdd sg13_lv_pmos ad=0.2128p pd=1.5u as=0.2387p ps=1.84u w=1.12u l=0.13u
X3992 sg13cmos5l_Corner_1.vss a_178296_102044# sg13cmos5l_IOPadAnalog_16.pad sg13cmos5l_Corner_1.vss sg13_hv_nmos ad=1.408p pd=5.04u as=2.596p ps=5.58u w=4.4u l=0.6u
X3993 adc8b_0.side_cap8b_1.buf_8_0.z adc8b_0.sar12b_0.nl_sw[4] vddr vddr sg13_lv_pmos ad=0.19p pd=1.38u as=0.19p ps=1.38u w=1u l=0.13u
X3994 sg13cmos5l_IOPadAnalog_11.pad a_178296_118044# sg13cmos5l_Corner_1.vss sg13cmos5l_Corner_1.vss sg13_hv_nmos ad=2.596p pd=5.58u as=1.408p ps=5.04u w=4.4u l=0.6u
X3995 a_100641_93101# a_99699_92908# a_100439_92863# vdd sg13_lv_pmos ad=93.45f pd=0.865u as=0.2048p ps=1.63u w=0.42u l=0.13u
X3996 a_99885_94277# adc8b_0.sar12b_0.sg13cmos5l_dfrbp_1_0.CLK vdd vdd sg13_lv_pmos ad=0.4088p pd=2.97u as=1.38655p ps=8.8u w=1.12u l=0.13u
X3997 sg13cmos5l_IOPadAnalog_12.pad a_131639_164698# sg13cmos5l_Corner_1.iovdd sg13cmos5l_Corner_1.iovdd sg13_hv_pmos ad=3.9294p pd=7.84u as=2.1312p ps=7.3u w=6.66u l=0.6u
X3998 sg13cmos5l_Corner_1.iovdd a_42476_86044# vin sg13cmos5l_Corner_1.iovdd sg13_hv_pmos ad=2.1312p pd=7.3u as=3.9294p ps=7.84u w=6.66u l=0.6u
X3999 sg13cmos5l_Corner_1.vss adc8b_0.side_cap8b_0.in_l_sw[0] adc8b_0.side_cap8b_0.buf_32_0.z sg13cmos5l_Corner_1.vss sg13_lv_nmos ad=95f pd=0.88u as=95f ps=0.88u w=0.5u l=0.13u
X4000 sg13cmos5l_Corner_1.vss vdd sg13cmos5l_Corner_1.vss sg13cmos5l_Corner_1.vss sg13_lv_nmos ad=0.1428p pd=1.52u as=0 ps=0 w=0.42u l=1u
X4001 sg13cmos5l_Corner_1.vss adc8b_0.sar12b_0.sg13cmos5l_buf_1_64.A a_85744_100384# sg13cmos5l_Corner_1.vss sg13_lv_nmos ad=0.14875p pd=1.16u as=0.187p ps=1.78u w=0.55u l=0.13u
X4002 a_98900_100310# adc8b_0.sar12b_0.sg13cmos5l_buf_1_94.X vdd vdd sg13_lv_pmos ad=0.2856p pd=2.36u as=0.2114p ps=1.54u w=0.84u l=0.13u
X4003 a_101012_93512# adc8b_0.sar12b_0.sg13cmos5l_buf_1_18.X vdd vdd sg13_lv_pmos ad=0.2856p pd=2.36u as=0.2114p ps=1.54u w=0.84u l=0.13u
X4004 sg13cmos5l_Corner_1.vss sg13cmos5l_IOPadVdd$1_0.sg13cmos5l_Clamp_N43N43D4R$1_0.gate vdd sg13cmos5l_Corner_1.vss sg13_hv_nmos ad=1.408p pd=5.04u as=2.596p ps=5.58u w=4.4u l=0.6u
X4005 vddr adc8b_0.side_cap8b_0.in_h_sw[7] adc8b_0.side_cap8b_0.buf_4_2.z vddr sg13_lv_pmos ad=0.19p pd=1.38u as=0.34p ps=2.68u w=1u l=0.13u
X4006 cks a_42476_118044# sg13cmos5l_Corner_1.iovdd sg13cmos5l_Corner_1.iovdd sg13_hv_pmos ad=3.9294p pd=7.84u as=2.1312p ps=7.3u w=6.66u l=0.6u
X4007 vddr adc8b_0.side_cap8b_0.in_l_sw[0] adc8b_0.side_cap8b_0.buf_32_0.z vddr sg13_lv_pmos ad=0.19p pd=1.38u as=0.19p ps=1.38u w=1u l=0.13u
X4008 adc8b_0.side_cap8b_0.buf_16_0.z adc8b_0.side_cap8b_0.in_h_sw[2] vddr vddr sg13_lv_pmos ad=0.19p pd=1.38u as=0.19p ps=1.38u w=1u l=0.13u
X4009 adc8b_0.sar12b_0.sg13cmos5l_a221oi_1_0.B2 adc8b_0.sar12b_0.sg13cmos5l_nor2b_1_0.Y sg13cmos5l_Corner_1.vss sg13cmos5l_Corner_1.vss sg13_lv_nmos ad=0.1406p pd=1.12u as=0.2516p ps=2.16u w=0.74u l=0.13u
X4010 sg13cmos5l_Corner_1.vss adc8b_0.sar12b_0.sg13cmos5l_buf_8_0.X a_102160_98872# sg13cmos5l_Corner_1.vss sg13_lv_nmos ad=0.14875p pd=1.16u as=0.187p ps=1.78u w=0.55u l=0.13u
X4011 sg13cmos5l_Corner_1.vss a_86044_30676# data[1] sg13cmos5l_Corner_1.vss sg13_hv_nmos ad=1.408p pd=5.04u as=2.596p ps=5.58u w=4.4u l=0.6u
X4012 sg13cmos5l_Corner_1.vss sg13cmos5l_IOPadVdd$1_0.sg13cmos5l_Clamp_N43N43D4R$1_0.gate vdd sg13cmos5l_Corner_1.vss sg13_hv_nmos ad=1.408p pd=5.04u as=2.596p ps=5.58u w=4.4u l=0.6u
X4013 vdd a_85175_99957# a_85432_99838# vdd sg13_lv_pmos ad=0.2639p pd=1.81u as=79.8f ps=0.8u w=0.42u l=0.13u
X4014 sg13cmos5l_Corner_1.iovdd a_86044_42476# data[1] sg13cmos5l_Corner_1.iovdd sg13_hv_pmos ad=2.1312p pd=7.3u as=3.9294p ps=7.84u w=6.66u l=0.6u
X4015 sg13cmos5l_Corner_1.vss a_178296_118044# sg13cmos5l_IOPadAnalog_11.pad sg13cmos5l_Corner_1.vss sg13_hv_nmos ad=2.068p pd=9.74u as=2.596p ps=5.58u w=4.4u l=0.6u
X4016 sg13cmos5l_IOPadAnalog_5.padres sg13cmos5l_Corner_1.iovdd dpantenna l=4.98u w=0.64u
X4017 sg13cmos5l_Corner_1.vss a_30676_70044# vddr sg13cmos5l_Corner_1.vss sg13_hv_nmos ad=1.408p pd=5.04u as=2.596p ps=5.58u w=4.4u l=0.6u
X4018 data[0] a_70044_42476# sg13cmos5l_Corner_1.iovdd sg13cmos5l_Corner_1.iovdd sg13_hv_pmos ad=3.9294p pd=7.84u as=2.1312p ps=7.3u w=6.66u l=0.6u
X4019 a_96612_98486# a_96063_98442# a_96476_98084# sg13cmos5l_Corner_1.vss sg13_lv_nmos ad=47.25f pd=0.645u as=0.141p ps=1.17u w=0.42u l=0.13u
X4020 sg13cmos5l_Corner_1.vss a_118222_33862# dantenna l=1.26u w=27.78u
X4021 vdd a_88727_97399# a_89564_97620# vdd sg13_lv_pmos ad=0.2128p pd=1.5u as=0.3864p ps=2.93u w=1.12u l=0.13u
X4022 a_93741_92765# adc8b_0.sar12b_0.sg13cmos5l_dfrbp_1_0.CLK sg13cmos5l_Corner_1.vss sg13cmos5l_Corner_1.vss sg13_lv_nmos ad=0.2516p pd=2.16u as=5.84582p ps=38.34u w=0.74u l=0.13u
X4023 adc8b_0.sar12b_0.sg13cmos5l_inv_1_20.Y adc8b_0.sar12b_0.sg13cmos5l_buf_1_41.A sg13cmos5l_Corner_1.vss sg13cmos5l_Corner_1.vss sg13_lv_nmos ad=0.2516p pd=2.16u as=0.2516p ps=2.16u w=0.74u l=0.13u
X4024 sg13cmos5l_IOPadAnalog_15.pad a_99639_164698# sg13cmos5l_Corner_1.iovdd sg13cmos5l_Corner_1.iovdd sg13_hv_pmos ad=3.9294p pd=7.84u as=2.1312p ps=7.3u w=6.66u l=0.6u
X4025 vdd adc8b_0.sar12b_0.sg13cmos5l_buf_1_68.X a_82384_100384# vdd sg13_lv_pmos ad=0.2114p pd=1.54u as=0.2856p ps=2.36u w=0.84u l=0.13u
X4026 adc8b_0.sar12b_0.sg13cmos5l_dfrbp_1_8.D a_99932_98084# sg13cmos5l_Corner_1.vss sg13cmos5l_Corner_1.vss sg13_lv_nmos ad=0.2516p pd=2.16u as=0.1406p ps=1.12u w=0.74u l=0.13u
X4027 sg13cmos5l_Corner_1.vss a_118044_30676# cko sg13cmos5l_Corner_1.vss sg13_hv_nmos ad=1.408p pd=5.04u as=2.596p ps=5.58u w=4.4u l=0.6u
X4028 data[2] a_102044_30676# sg13cmos5l_Corner_1.vss sg13cmos5l_Corner_1.vss sg13_hv_nmos ad=2.596p pd=5.58u as=1.408p ps=5.04u w=4.4u l=0.6u
X4029 adc8b_0.sar12b_0.sg13cmos5l_dfrbp_1_6.RESET_B cks vdd vdd sg13_lv_pmos ad=0.2128p pd=1.5u as=0.2128p ps=1.5u w=1.12u l=0.13u
X4030 adc8b_0.sar12b_0.sg13cmos5l_dfrbp_1_27.Q_N a_91799_99957# sg13cmos5l_Corner_1.vss sg13cmos5l_Corner_1.vss sg13_lv_nmos ad=0.2849p pd=2.25u as=0.2516p ps=2.16u w=0.74u l=0.13u
X4031 sg13cmos5l_Corner_1.vss vdd sg13cmos5l_Corner_1.vss sg13cmos5l_Corner_1.vss sg13_lv_nmos ad=0.1428p pd=1.52u as=0 ps=0 w=0.42u l=1u
X4032 adc8b_0.side_cap8b_1.buf_16_3.z adc8b_0.sar12b_0.nh_sw[1] vddr vddr sg13_lv_pmos ad=0.19p pd=1.38u as=0.19p ps=1.38u w=1u l=0.13u
X4033 adc8b_0.side_cap8b_1.buf_32_0.z adc8b_0.sar12b_0.nl_sw[0] sg13cmos5l_Corner_1.vss sg13cmos5l_Corner_1.vss sg13_lv_nmos ad=95f pd=0.88u as=95f ps=0.88u w=0.5u l=0.13u
X4034 sg13cmos5l_Corner_1.iovdd a_83639_164698# sg13cmos5l_IOPadAnalog_9.pad sg13cmos5l_Corner_1.iovdd sg13_hv_pmos ad=2.1312p pd=7.3u as=3.9294p ps=7.84u w=6.66u l=0.6u
X4035 vdd adc8b_0.sar12b_0.sg13cmos5l_dlhr_1_1.GATE a_86117_98796# vdd sg13_lv_pmos ad=1.15047p pd=7.175u as=0.3234p ps=2.45u w=0.84u l=0.13u
X4036 adc8b_0.sar12b_0.sg13cmos5l_dfrbp_1_9.Q a_86012_95060# vdd vdd sg13_lv_pmos ad=0.3808p pd=2.92u as=0.2128p ps=1.5u w=1.12u l=0.13u
X4037 vdd sg13cmos5l_IOPadVdd$1_0.sg13cmos5l_Clamp_N43N43D4R$1_0.gate sg13cmos5l_Corner_1.vss sg13cmos5l_Corner_1.vss sg13_hv_nmos ad=2.596p pd=5.58u as=1.408p ps=5.04u w=4.4u l=0.6u
X4038 sg13cmos5l_IOPadVdd$1_0.sg13cmos5l_Clamp_N43N43D4R$1_0.gate sg13cmos5l_IOPadVdd$1_0.sg13cmos5l_RCClampInverter$1_0.in sg13cmos5l_Corner_1.vss sg13cmos5l_Corner_1.vss sg13_hv_nmos ad=1.71p pd=9.38u as=1.71p ps=9.38u w=9u l=0.5u
X4039 a_85460_100310# adc8b_0.sar12b_0.sg13cmos5l_inv_1_17.A sg13cmos5l_Corner_1.vss sg13cmos5l_Corner_1.vss sg13_lv_nmos ad=0.187p pd=1.78u as=0.14875p ps=1.16u w=0.55u l=0.13u
X4040 sg13cmos5l_Corner_1.vss a_88504_93790# a_88153_93909# sg13cmos5l_Corner_1.vss sg13_lv_nmos ad=79.8f pd=0.8u as=0.1428p ps=1.52u w=0.42u l=0.13u
X4041 vip a_42476_102044# sg13cmos5l_Corner_1.iovdd sg13cmos5l_Corner_1.iovdd sg13_hv_pmos ad=3.9294p pd=7.84u as=2.1312p ps=7.3u w=6.66u l=0.6u
X4042 a_87441_94298# a_87260_94620# vdd vdd sg13_lv_pmos ad=0.2128p pd=1.5u as=0.2387p ps=1.84u w=1.12u l=0.13u
X4043 sg13cmos5l_IOPadAnalog_9.pad a_83639_164698# sg13cmos5l_Corner_1.iovdd sg13cmos5l_Corner_1.iovdd sg13_hv_pmos ad=3.9294p pd=7.84u as=2.1312p ps=7.3u w=6.66u l=0.6u
X4044 cks sg13cmos5l_IOPadAnalog_8.padres sg13cmos5l_Corner_1.vss rppd l=2u w=1u
X4045 adc8b_0.side_cap8b_0.buf_32_1.z adc8b_0.side_cap8b_0.in_h_sw[0] vddr vddr sg13_lv_pmos ad=0.19p pd=1.38u as=0.19p ps=1.38u w=1u l=0.13u
X4046 sg13cmos5l_Corner_1.vss a_101972_96536# adc8b_0.sar12b_0.sg13cmos5l_inv_1_6.A sg13cmos5l_Corner_1.vss sg13_lv_nmos ad=0.14875p pd=1.16u as=0.2886p ps=2.26u w=0.74u l=0.13u
X4047 sg13cmos5l_IOPadAnalog_12.pad a_131639_178370# sg13cmos5l_Corner_1.vss sg13cmos5l_Corner_1.vss sg13_hv_nmos ad=2.596p pd=5.58u as=1.408p ps=5.04u w=4.4u l=0.6u
X4048 a_91799_99957# a_90957_99607# a_90540_99600# vdd sg13_lv_pmos ad=0.2048p pd=1.63u as=0.34p ps=2.68u w=1u l=0.13u
X4049 a_99135_99954# adc8b_0.sar12b_0.sg13cmos5l_dfrbp_1_22.D sg13cmos5l_Corner_1.vss sg13cmos5l_Corner_1.vss sg13_lv_nmos ad=0.2516p pd=2.16u as=0.15055p ps=1.17u w=0.74u l=0.13u
X4050 vdd adc8b_0.sar12b_0.sg13cmos5l_dfrbp_1_6.RESET_B a_90609_96929# vdd sg13_lv_pmos ad=0.2128p pd=1.5u as=0.2128p ps=1.5u w=1.12u l=0.13u
X4051 adc8b_0.sar12b_0.sg13cmos5l_and3_1_0.X a_95092_95856# sg13cmos5l_Corner_1.vss sg13cmos5l_Corner_1.vss sg13_lv_nmos ad=0.2516p pd=2.16u as=0.1371p ps=1.12u w=0.74u l=0.13u
X4052 sg13cmos5l_IOPadVdd$1_0.sg13cmos5l_Clamp_N43N43D4R$1_0.gate sg13cmos5l_IOPadVdd$1_0.sg13cmos5l_RCClampInverter$1_0.in sg13cmos5l_Corner_1.vss sg13cmos5l_Corner_1.vss sg13_hv_nmos ad=1.71p pd=9.38u as=1.71p ps=9.38u w=9u l=0.5u
X4053 vdd a_100995_100350# adc8b_0.sar12b_0.sg13cmos5l_buf_8_2.X vdd sg13_lv_pmos ad=0.2128p pd=1.5u as=0.2128p ps=1.5u w=1.12u l=0.13u
X4054 adc8b_0.sar12b_0.sg13cmos5l_dlhr_1_4.Q_N a_87966_94280# sg13cmos5l_Corner_1.vss sg13cmos5l_Corner_1.vss sg13_lv_nmos ad=0.2516p pd=2.16u as=0.1491p ps=1.18u w=0.74u l=0.13u
X4055 adc8b_0.side_cap8b_1.buf_16_2.z adc8b_0.sar12b_0.nl_sw[1] sg13cmos5l_Corner_1.vss sg13cmos5l_Corner_1.vss sg13_lv_nmos ad=95f pd=0.88u as=95f ps=0.88u w=0.5u l=0.13u
X4056 sg13cmos5l_Corner_1.vss a_33862_70222# dantenna l=27.78u w=1.26u
X4057 sg13cmos5l_Corner_1.vss adc8b_0.sar12b_0.sg13cmos5l_inv_1_27.Y a_96400_100384# sg13cmos5l_Corner_1.vss sg13_lv_nmos ad=0.14875p pd=1.16u as=0.187p ps=1.78u w=0.55u l=0.13u
X4058 vdd adc8b_0.sar12b_0.sg13cmos5l_buf_1_5.A adc8b_0.sar12b_0.sg13cmos5l_inv_1_27.Y vdd sg13_lv_pmos ad=0.3808p pd=2.92u as=0.3808p ps=2.92u w=1.12u l=0.13u
X4059 a_83583_95826# adc8b_0.sar12b_0.sg13cmos5l_dlhr_1_1.GATE sg13cmos5l_Corner_1.vss sg13cmos5l_Corner_1.vss sg13_lv_nmos ad=0.2516p pd=2.16u as=0.15055p ps=1.17u w=0.74u l=0.13u
X4060 adc8b_0.sar12b_0.sg13cmos5l_dfrbp_1_6.D a_83440_94336# sg13cmos5l_Corner_1.vss sg13cmos5l_Corner_1.vss sg13_lv_nmos ad=0.2886p pd=2.26u as=0.14875p ps=1.16u w=0.74u l=0.13u
X4061 a_83614_99010# a_83716_99124# sg13cmos5l_Corner_1.vss sg13cmos5l_Corner_1.vss sg13_lv_nmos ad=0.187p pd=1.78u as=0.1491p ps=1.18u w=0.55u l=0.13u
X4062 a_86012_98084# a_85730_98448# a_85945_98486# sg13cmos5l_Corner_1.vss sg13_lv_nmos ad=0.141p pd=1.17u as=71.99999f ps=0.865u w=0.64u l=0.13u
X4063 sg13cmos5l_Corner_1.vss a_90356_95024# adc8b_0.sar12b_0.sg13cmos5l_buf_1_30.A sg13cmos5l_Corner_1.vss sg13_lv_nmos ad=0.14875p pd=1.16u as=0.2886p ps=2.26u w=0.74u l=0.13u
X4064 sg13cmos5l_Corner_1.vss a_88671_94314# a_88802_94308# sg13cmos5l_Corner_1.vss sg13_lv_nmos ad=2.59257p pd=16.445u as=0.2775p ps=2.23u w=0.74u l=0.13u
X4065 sg13cmos5l_Corner_1.vss adc8b_0.side_cap8b_0.in_h_sw[1] adc8b_0.side_cap8b_0.buf_16_3.z sg13cmos5l_Corner_1.vss sg13_lv_nmos ad=95f pd=0.88u as=95f ps=0.88u w=0.5u l=0.13u
X4066 sg13cmos5l_Corner_1.iovdd a_86044_42476# data[1] sg13cmos5l_Corner_1.iovdd sg13_hv_pmos ad=2.1312p pd=7.3u as=3.9294p ps=7.84u w=6.66u l=0.6u
X4067 sg13cmos5l_Corner_1.iovdd a_131639_164698# sg13cmos5l_IOPadAnalog_12.pad sg13cmos5l_Corner_1.iovdd sg13_hv_pmos ad=2.1312p pd=7.3u as=3.9294p ps=7.84u w=6.66u l=0.6u
X4068 a_84525_94277# adc8b_0.sar12b_0.sg13cmos5l_dfrbp_1_9.Q vdd vdd sg13_lv_pmos ad=0.4088p pd=2.97u as=1.38655p ps=8.8u w=1.12u l=0.13u
X4069 a_96692_92750# adc8b_0.sar12b_0.sg13cmos5l_buf_1_6.A sg13cmos5l_Corner_1.vss sg13cmos5l_Corner_1.vss sg13_lv_nmos ad=0.187p pd=1.78u as=0.14875p ps=1.16u w=0.55u l=0.13u
X4070 a_93324_93104# a_93298_93009# sg13cmos5l_Corner_1.vss sg13cmos5l_Corner_1.vss sg13_lv_nmos ad=0.2516p pd=2.16u as=0.1626p ps=1.415u w=0.74u l=0.13u
X4071 vddr adc8b_0.side_cap8b_0.in_h_sw[1] adc8b_0.side_cap8b_0.buf_16_3.z vddr sg13_lv_pmos ad=0.19p pd=1.38u as=0.19p ps=1.38u w=1u l=0.13u
X4072 vddr adc8b_0.side_cap8b_0.in_h_sw[5] adc8b_0.side_cap8b_0.buf_8_5.z vddr sg13_lv_pmos ad=0.19p pd=1.38u as=0.34p ps=2.68u w=1u l=0.13u
X4073 sg13cmos5l_IOPadAnalog_0.pad sg13cmos5l_Corner_1.iovdd dpantenna l=27.78u w=1.26u
X4074 a_97260_93552# a_97234_93516# sg13cmos5l_Corner_1.vss sg13cmos5l_Corner_1.vss sg13_lv_nmos ad=0.2516p pd=2.16u as=0.1626p ps=1.415u w=0.74u l=0.13u
X4075 vdd a_87885_97301# a_87987_97444# vdd sg13_lv_pmos ad=1.07253p pd=6.75u as=0.3864p ps=2.93u w=1.12u l=0.13u
X4076 sg13cmos5l_Corner_1.vss adc8b_0.sar12b_0.sg13cmos5l_dfrbp_1_6.RESET_B a_97180_96960# sg13cmos5l_Corner_1.vss sg13_lv_nmos ad=0.1406p pd=1.12u as=77.7f ps=0.95u w=0.74u l=0.13u
X4077 vddr adc8b_0.sar12b_0.nl_sw[1] adc8b_0.side_cap8b_1.buf_16_2.z vddr sg13_lv_pmos ad=0.19p pd=1.38u as=0.19p ps=1.38u w=1u l=0.13u
X4078 a_87345_93595# a_86988_93552# vdd vdd sg13_lv_pmos ad=63f pd=0.72u as=0.1563p ps=1.22u w=0.42u l=0.13u
X4079 adc8b_0.side_cap8b_0.buf_32_1.z adc8b_0.side_cap8b_0.in_h_sw[0] sg13cmos5l_Corner_1.vss sg13cmos5l_Corner_1.vss sg13_lv_nmos ad=95f pd=0.88u as=95f ps=0.88u w=0.5u l=0.13u
X4080 sg13cmos5l_Corner_1.vss a_89015_99957# a_89852_99596# sg13cmos5l_Corner_1.vss sg13_lv_nmos ad=0.1406p pd=1.12u as=0.2516p ps=2.16u w=0.74u l=0.13u
X4081 vdd a_94583_92863# a_94840_93006# vdd sg13_lv_pmos ad=0.2639p pd=1.81u as=79.8f ps=0.8u w=0.42u l=0.13u
X4082 adc8b_0.sar12b_0.sg13cmos5l_inv_1_26.Y adc8b_0.sar12b_0.sg13cmos5l_buf_1_19.A sg13cmos5l_Corner_1.vss sg13cmos5l_Corner_1.vss sg13_lv_nmos ad=0.2516p pd=2.16u as=0.2516p ps=2.16u w=0.74u l=0.13u
X4083 sg13cmos5l_Corner_1.iovdd a_118044_42476# cko sg13cmos5l_Corner_1.iovdd sg13_hv_pmos ad=2.1312p pd=7.3u as=3.9294p ps=7.84u w=6.66u l=0.6u
X4084 sg13cmos5l_Corner_1.vss adc8b_0.sar12b_0.nl_sw[5] adc8b_0.side_cap8b_1.buf_8_4.z sg13cmos5l_Corner_1.vss sg13_lv_nmos ad=95f pd=0.88u as=95f ps=0.88u w=0.5u l=0.13u
X4085 vdd adc8b_0.cmp_0.clk a_76796_95659# vdd sg13_lv_pmos ad=95f pd=0.88u as=0.17p ps=1.68u w=0.5u l=0.13u
X4086 data[2] a_102044_42476# sg13cmos5l_Corner_1.iovdd sg13cmos5l_Corner_1.iovdd sg13_hv_pmos ad=3.9294p pd=7.84u as=2.1312p ps=7.3u w=6.66u l=0.6u
X4087 sg13cmos5l_IOPadAnalog_11.pad sg13cmos5l_Corner_1.iovdd dpantenna l=27.78u w=1.26u
X4088 a_100796_96572# a_100514_96936# a_100729_96974# sg13cmos5l_Corner_1.vss sg13_lv_nmos ad=0.141p pd=1.17u as=71.99999f ps=0.865u w=0.64u l=0.13u
X4089 sg13cmos5l_IOPadAnalog_12.pad a_131639_164698# sg13cmos5l_Corner_1.iovdd sg13cmos5l_Corner_1.iovdd sg13_hv_pmos ad=3.9294p pd=7.84u as=2.1312p ps=7.3u w=6.66u l=0.6u
X4090 vdd a_97197_98813# a_97299_98956# vdd sg13_lv_pmos ad=1.15047p pd=7.175u as=0.3864p ps=2.93u w=1.12u l=0.13u
X4091 a_90734_97760# a_90338_97332# a_90620_97644# vdd sg13_lv_pmos ad=0.1008p pd=0.9u as=0.191p ps=1.44u w=0.42u l=0.13u
X4092 a_88415_96619# adc8b_0.sar12b_0.sg13cmos5l_dfrbp_1_8.RESET_B vdd vdd sg13_lv_pmos ad=79.8f pd=0.8u as=0.36237p ps=2.605u w=0.42u l=0.13u
X4093 a_100729_96974# a_100177_96930# sg13cmos5l_Corner_1.vss sg13cmos5l_Corner_1.vss sg13_lv_nmos ad=71.99999f pd=0.865u as=1.97045p ps=12.335u w=0.64u l=0.13u
X4094 sg13cmos5l_IOPadAnalog_10.pad a_67639_164698# sg13cmos5l_Corner_1.iovdd sg13cmos5l_Corner_1.iovdd sg13_hv_pmos ad=3.9294p pd=7.84u as=2.1312p ps=7.3u w=6.66u l=0.6u
X4095 a_91993_100338# a_91441_100400# sg13cmos5l_Corner_1.vss sg13cmos5l_Corner_1.vss sg13_lv_nmos ad=71.99999f pd=0.865u as=2.92392p ps=18.89u w=0.64u l=0.13u
X4096 a_96396_99600# a_96370_99564# vdd vdd sg13_lv_pmos ad=0.34p pd=2.68u as=0.36237p ps=2.605u w=1u l=0.13u
X4097 a_87956_92750# adc8b_0.sar12b_0.sg13cmos5l_buf_1_25.A vdd vdd sg13_lv_pmos ad=0.2856p pd=2.36u as=0.2114p ps=1.54u w=0.84u l=0.13u
X4098 sg13cmos5l_Corner_1.vss sg13cmos5l_IOPadVdd$1_0.sg13cmos5l_Clamp_N43N43D4R$1_0.gate vdd sg13cmos5l_Corner_1.vss sg13_hv_nmos ad=1.408p pd=5.04u as=2.596p ps=5.58u w=4.4u l=0.6u
X4099 adc8b_0.side_cap8b_0.buf_8_4.z adc8b_0.side_cap8b_0.in_l_sw[5] vddr vddr sg13_lv_pmos ad=0.34p pd=2.68u as=0.19p ps=1.38u w=1u l=0.13u
X4100 sg13cmos5l_Corner_1.iovdd a_164624_70044# sg13cmos5l_IOPadAnalog_1.pad sg13cmos5l_Corner_1.iovdd sg13_hv_pmos ad=2.1312p pd=7.3u as=3.9294p ps=7.84u w=6.66u l=0.6u
X4101 sg13cmos5l_IOPadAnalog_0.pad a_164624_86044# sg13cmos5l_Corner_1.iovdd sg13cmos5l_Corner_1.iovdd sg13_hv_pmos ad=3.9294p pd=7.84u as=2.1312p ps=7.3u w=6.66u l=0.6u
X4102 sg13cmos5l_Corner_1.iovdd a_99639_164698# sg13cmos5l_IOPadAnalog_15.pad sg13cmos5l_Corner_1.iovdd sg13_hv_pmos ad=2.1312p pd=7.3u as=3.9294p ps=7.84u w=6.66u l=0.6u
X4103 a_82893_98095# adc8b_0.sar12b_0.sg13cmos5l_dfrbp_1_15.D sg13cmos5l_Corner_1.vss sg13cmos5l_Corner_1.vss sg13_lv_nmos ad=0.2516p pd=2.16u as=1.49685p ps=9.6u w=0.74u l=0.13u
X4104 data[2] sg13cmos5l_Corner_1.iovdd dpantenna l=1.26u w=27.78u
X4105 sg13cmos5l_Corner_1.iovdd a_115639_164698# sg13cmos5l_IOPadAnalog_13.pad sg13cmos5l_Corner_1.iovdd sg13_hv_pmos ad=2.1312p pd=7.3u as=3.9294p ps=7.84u w=6.66u l=0.6u
X4106 vdd adc8b_0.sar12b_0.sg13cmos5l_dlhr_1_12.D a_98929_99954# vdd sg13_lv_pmos ad=1.15047p pd=7.175u as=0.2856p ps=2.36u w=0.84u l=0.13u
X4107 vdd a_94335_98442# a_94466_98448# vdd sg13_lv_pmos ad=1.07253p pd=6.75u as=0.2856p ps=2.36u w=0.84u l=0.13u
X4108 vdd adc8b_0.sar12b_0.sg13cmos5l_dfrbp_1_6.RESET_B a_101361_97322# vdd sg13_lv_pmos ad=0.2128p pd=1.5u as=0.2128p ps=1.5u w=1.12u l=0.13u
X4109 a_87981_95071# adc8b_0.sar12b_0.sg13cmos5l_dfrbp_1_11.Q sg13cmos5l_Corner_1.vss sg13cmos5l_Corner_1.vss sg13_lv_nmos ad=0.2516p pd=2.16u as=2.41737p ps=15.64u w=0.74u l=0.13u
X4110 a_94868_99560# adc8b_0.sar12b_0.sg13cmos5l_buf_1_90.X sg13cmos5l_Corner_1.vss sg13cmos5l_Corner_1.vss sg13_lv_nmos ad=0.187p pd=1.78u as=0.14875p ps=1.16u w=0.55u l=0.13u
X4111 a_97912_99838# adc8b_0.sar12b_0.sg13cmos5l_dfrbp_1_8.RESET_B vdd vdd sg13_lv_pmos ad=79.8f pd=0.8u as=1.12242p ps=7u w=0.42u l=0.13u
X4112 sg13cmos5l_Corner_1.vss adc8b_0.sar12b_0.sg13cmos5l_buf_1_39.A a_85456_92824# sg13cmos5l_Corner_1.vss sg13_lv_nmos ad=0.14875p pd=1.16u as=0.187p ps=1.78u w=0.55u l=0.13u
X4113 sg13cmos5l_IOPadAnalog_9.pad a_83639_178370# sg13cmos5l_Corner_1.vss sg13cmos5l_Corner_1.vss sg13_hv_nmos ad=2.596p pd=5.58u as=1.408p ps=5.04u w=4.4u l=0.6u
X4114 adc8b_0.side_cap8b_0.buf_32_0.z adc8b_0.side_cap8b_0.in_l_sw[0] vddr vddr sg13_lv_pmos ad=0.19p pd=1.38u as=0.19p ps=1.38u w=1u l=0.13u
X4115 vip a_42476_102044# sg13cmos5l_Corner_1.iovdd sg13cmos5l_Corner_1.iovdd sg13_hv_pmos ad=3.9294p pd=7.84u as=2.1312p ps=7.3u w=6.66u l=0.6u
X4116 sg13cmos5l_Corner_1.iovdd a_86044_42476# data[1] sg13cmos5l_Corner_1.iovdd sg13_hv_pmos ad=2.1312p pd=7.3u as=3.9294p ps=7.84u w=6.66u l=0.6u
X4117 vin a_42476_86044# sg13cmos5l_Corner_1.iovdd sg13cmos5l_Corner_1.iovdd sg13_hv_pmos ad=3.9294p pd=7.84u as=2.1312p ps=7.3u w=6.66u l=0.6u
X4118 sg13cmos5l_Corner_1.vss a_131639_178370# sg13cmos5l_IOPadAnalog_12.pad sg13cmos5l_Corner_1.vss sg13_hv_nmos ad=1.408p pd=5.04u as=2.596p ps=5.58u w=4.4u l=0.6u
X4119 adc8b_0.sar12b_0.sg13cmos5l_dfrbp_1_9.Q a_86012_95060# sg13cmos5l_Corner_1.vss sg13cmos5l_Corner_1.vss sg13_lv_nmos ad=0.2516p pd=2.16u as=0.1406p ps=1.12u w=0.74u l=0.13u
X4120 sg13cmos5l_IOPadAnalog_11.pad a_164624_118044# sg13cmos5l_Corner_1.iovdd sg13cmos5l_Corner_1.iovdd sg13_hv_pmos ad=3.9294p pd=7.84u as=2.1312p ps=7.3u w=6.66u l=0.6u
X4121 sg13cmos5l_Corner_1.vss adc8b_0.sar12b_0.nl_sw[2] adc8b_0.side_cap8b_1.buf_16_1.z sg13cmos5l_Corner_1.vss sg13_lv_nmos ad=95f pd=0.88u as=95f ps=0.88u w=0.5u l=0.13u
X4122 sg13cmos5l_Corner_1.vss a_176786_86222# dantenna l=27.78u w=1.26u
X4123 sg13cmos5l_Corner_1.iovdd a_164624_86044# sg13cmos5l_IOPadAnalog_0.pad sg13cmos5l_Corner_1.iovdd sg13_hv_pmos ad=2.1312p pd=7.3u as=3.9294p ps=7.84u w=6.66u l=0.6u
X4124 vdd sg13cmos5l_IOPadVdd$1_0.sg13cmos5l_Clamp_N43N43D4R$1_0.gate sg13cmos5l_Corner_1.vss sg13cmos5l_Corner_1.vss sg13_hv_nmos ad=2.596p pd=5.58u as=1.408p ps=5.04u w=4.4u l=0.6u
X4125 vdd a_90015_96930# a_90146_96936# vdd sg13_lv_pmos ad=1.28962p pd=8.195u as=0.2856p ps=2.36u w=0.84u l=0.13u
X4126 a_73970_98361# adc8b_0.cmp_0.clk vdd vdd sg13_lv_pmos ad=0.17p pd=1.68u as=95f ps=0.88u w=0.5u l=0.13u
X4127 sg13cmos5l_Corner_1.vss a_83765_97286# adc8b_0.sar12b_0.sg13cmos5l_dfrbp_1_15.Q_N sg13cmos5l_Corner_1.vss sg13_lv_nmos ad=0.2516p pd=2.16u as=0.2849p ps=2.25u w=0.74u l=0.13u
X4128 sg13cmos5l_Corner_1.iovdd a_118044_42476# cko sg13cmos5l_Corner_1.iovdd sg13_hv_pmos ad=2.1312p pd=7.3u as=3.9294p ps=7.84u w=6.66u l=0.6u
X4129 vdd sg13cmos5l_IOPadVdd$1_0.sg13cmos5l_Clamp_N43N43D4R$1_0.gate sg13cmos5l_Corner_1.vss sg13cmos5l_Corner_1.vss sg13_hv_nmos ad=2.596p pd=5.58u as=1.408p ps=5.04u w=4.4u l=0.6u
X4130 vddr a_30676_70044# sg13cmos5l_Corner_1.vss sg13cmos5l_Corner_1.vss sg13_hv_nmos ad=2.596p pd=5.58u as=2.068p ps=9.74u w=4.4u l=0.6u
X4131 adc8b_0.sar12b_0.sg13cmos5l_dlhr_1_0.GATE a_87452_96108# sg13cmos5l_Corner_1.vss sg13cmos5l_Corner_1.vss sg13_lv_nmos ad=0.2516p pd=2.16u as=0.1406p ps=1.12u w=0.74u l=0.13u
X4132 data[2] a_102044_42476# sg13cmos5l_Corner_1.iovdd sg13cmos5l_Corner_1.iovdd sg13_hv_pmos ad=3.9294p pd=7.84u as=2.1312p ps=7.3u w=6.66u l=0.6u
X4133 sg13cmos5l_Corner_1.iovdd a_164624_70044# sg13cmos5l_IOPadAnalog_1.pad sg13cmos5l_Corner_1.iovdd sg13_hv_pmos ad=2.1312p pd=7.3u as=3.9294p ps=7.84u w=6.66u l=0.6u
X4134 sg13cmos5l_IOPadAnalog_0.pad a_164624_86044# sg13cmos5l_Corner_1.iovdd sg13cmos5l_Corner_1.iovdd sg13_hv_pmos ad=3.9294p pd=7.84u as=2.1312p ps=7.3u w=6.66u l=0.6u
X4135 sg13cmos5l_Corner_1.iovdd a_164624_102044# sg13cmos5l_IOPadAnalog_16.pad sg13cmos5l_Corner_1.iovdd sg13_hv_pmos ad=2.1312p pd=7.3u as=3.9294p ps=7.84u w=6.66u l=0.6u
X4136 a_93516_93973# a_93747_93559# a_93202_93516# sg13cmos5l_Corner_1.vss sg13_lv_nmos ad=0.2373p pd=1.97u as=79.8f ps=0.8u w=0.42u l=0.13u
X4137 a_99442_94521# a_99885_94277# a_99182_94298# sg13cmos5l_Corner_1.vss sg13_lv_nmos ad=79.8f pd=0.8u as=0.1296p ps=1.52u w=0.42u l=0.13u
X4138 sg13cmos5l_Corner_1.vss a_30676_102044# vip sg13cmos5l_Corner_1.vss sg13_hv_nmos ad=1.408p pd=5.04u as=2.596p ps=5.58u w=4.4u l=0.6u
X4139 a_98296_99054# a_98039_98911# a_98458_98834# sg13cmos5l_Corner_1.vss sg13_lv_nmos ad=0.1428p pd=1.52u as=37.8f ps=0.6u w=0.42u l=0.13u
X4140 sg13cmos5l_IOPadAnalog_11.pad a_164624_118044# sg13cmos5l_Corner_1.iovdd sg13cmos5l_Corner_1.iovdd sg13_hv_pmos ad=3.9294p pd=7.84u as=2.1312p ps=7.3u w=6.66u l=0.6u
X4141 vddr adc8b_0.sar12b_0.nh_sw[1] adc8b_0.side_cap8b_1.buf_16_3.z vddr sg13_lv_pmos ad=0.19p pd=1.38u as=0.19p ps=1.38u w=1u l=0.13u
X4142 vdd adc8b_0.sar12b_0.sg13cmos5l_dlhr_1_10.Q a_101296_98084# vdd sg13_lv_pmos ad=0.2114p pd=1.54u as=0.2856p ps=2.36u w=0.84u l=0.13u
X4143 a_36456_134095# a_40542_134425# sg13cmos5l_Corner_1.vss rppd l=20u w=1u
X4144 adc8b_0.side_cap8b_0.buf_16_1.z adc8b_0.side_cap8b_0.in_l_sw[2] sg13cmos5l_Corner_1.vss sg13cmos5l_Corner_1.vss sg13_lv_nmos ad=95f pd=0.88u as=95f ps=0.88u w=0.5u l=0.13u
X4145 sg13cmos5l_Corner_1.vss a_85460_100310# adc8b_0.sar12b_0.sg13cmos5l_buf_1_62.X sg13cmos5l_Corner_1.vss sg13_lv_nmos ad=0.14875p pd=1.16u as=0.2886p ps=2.26u w=0.74u l=0.13u
X4146 sg13cmos5l_IOPadAnalog_13.pad a_115639_178370# sg13cmos5l_Corner_1.vss sg13cmos5l_Corner_1.vss sg13_hv_nmos ad=2.596p pd=5.58u as=1.408p ps=5.04u w=4.4u l=0.6u
X4147 sg13cmos5l_IOPadAnalog_12.pad a_131639_178370# sg13cmos5l_Corner_1.vss sg13cmos5l_Corner_1.vss sg13_hv_nmos ad=2.596p pd=5.58u as=2.068p ps=9.74u w=4.4u l=0.6u
X4148 vddr a_30676_70044# sg13cmos5l_Corner_1.vss sg13cmos5l_Corner_1.vss sg13_hv_nmos ad=2.596p pd=5.58u as=1.408p ps=5.04u w=4.4u l=0.6u
X4149 frame a_134044_42476# sg13cmos5l_Corner_1.iovdd sg13cmos5l_Corner_1.iovdd sg13_hv_pmos ad=3.9294p pd=7.84u as=2.1312p ps=7.3u w=6.66u l=0.6u
X4150 sg13cmos5l_Corner_1.vss a_86044_30676# data[1] sg13cmos5l_Corner_1.vss sg13_hv_nmos ad=1.408p pd=5.04u as=2.596p ps=5.58u w=4.4u l=0.6u
X4151 vddr a_42476_70044# sg13cmos5l_Corner_1.iovdd sg13cmos5l_Corner_1.iovdd sg13_hv_pmos ad=3.9294p pd=7.84u as=2.1312p ps=7.3u w=6.66u l=0.6u
X4152 sg13cmos5l_Corner_1.iovdd a_42476_70044# vddr sg13cmos5l_Corner_1.iovdd sg13_hv_pmos ad=2.1312p pd=7.3u as=3.9294p ps=7.84u w=6.66u l=0.6u
X4153 vddr adc8b_0.side_cap8b_0.in_h_sw[0] adc8b_0.side_cap8b_0.buf_32_1.z vddr sg13_lv_pmos ad=0.19p pd=1.38u as=0.19p ps=1.38u w=1u l=0.13u
X4154 adc8b_0.side_cap8b_0.in_l_sw[1] a_82768_100384# sg13cmos5l_Corner_1.vss sg13cmos5l_Corner_1.vss sg13_lv_nmos ad=0.2886p pd=2.26u as=0.14875p ps=1.16u w=0.74u l=0.13u
X4155 a_97470_95347# a_97589_95024# vdd vdd sg13_lv_pmos ad=0.3864p pd=2.93u as=0.2128p ps=1.5u w=1.12u l=0.13u
X4156 adc8b_0.side_cap8b_1.buf_16_0.z adc8b_0.sar12b_0.nh_sw[2] sg13cmos5l_Corner_1.vss sg13cmos5l_Corner_1.vss sg13_lv_nmos ad=95f pd=0.88u as=95f ps=0.88u w=0.5u l=0.13u
X4157 vdd adc8b_0.sar12b_0.sg13cmos5l_buf_1_7.A a_95824_92824# vdd sg13_lv_pmos ad=0.2114p pd=1.54u as=0.2856p ps=2.36u w=0.84u l=0.13u
X4158 vddr adc8b_0.side_cap8b_0.in_h_sw[3] adc8b_0.side_cap8b_0.buf_8_3.z vddr sg13_lv_pmos ad=0.19p pd=1.38u as=0.19p ps=1.38u w=1u l=0.13u
X4159 a_92770_94302# adc8b_0.sar12b_0.sg13cmos5l_nand2_1_0.B sg13cmos5l_Corner_1.vss sg13cmos5l_Corner_1.vss sg13_lv_nmos ad=0.1406p pd=1.12u as=0.2516p ps=2.16u w=0.74u l=0.13u
X4160 sg13cmos5l_Corner_1.vss adc8b_0.sar12b_0.nh_sw[0] adc8b_0.side_cap8b_1.buf_32_1.z sg13cmos5l_Corner_1.vss sg13_lv_nmos ad=95f pd=0.88u as=95f ps=0.88u w=0.5u l=0.13u
X4161 a_82676_92750# adc8b_0.sar12b_0.sg13cmos5l_buf_1_32.A vdd vdd sg13_lv_pmos ad=0.2856p pd=2.36u as=0.2114p ps=1.54u w=0.84u l=0.13u
X4162 a_93539_96572# adc8b_0.sar12b_0.sg13cmos5l_or2_1_1.B vdd vdd sg13_lv_pmos ad=0.3808p pd=2.92u as=0.2128p ps=1.5u w=1.12u l=0.13u
X4163 sg13cmos5l_Corner_1.iovdd a_67639_164698# sg13cmos5l_IOPadAnalog_10.pad sg13cmos5l_Corner_1.iovdd sg13_hv_pmos ad=2.1312p pd=7.3u as=3.9294p ps=7.84u w=6.66u l=0.6u
X4164 adc8b_0.side_cap8b_0.buf_16_3.z adc8b_0.side_cap8b_0.in_h_sw[1] sg13cmos5l_Corner_1.vss sg13cmos5l_Corner_1.vss sg13_lv_nmos ad=0.17p pd=1.68u as=95f ps=0.88u w=0.5u l=0.13u
X4165 adc8b_0.side_cap8b_1.buf_4_3.z adc8b_0.sar12b_0.nl_sw[6] vddr vddr sg13_lv_pmos ad=0.19p pd=1.38u as=0.19p ps=1.38u w=1u l=0.13u
X4166 a_89656_96030# adc8b_0.sar12b_0.sg13cmos5l_dfrbp_1_8.RESET_B vdd vdd sg13_lv_pmos ad=79.8f pd=0.8u as=1.2517p ps=7.955u w=0.42u l=0.13u
X4167 a_95416_100566# adc8b_0.sar12b_0.sg13cmos5l_dfrbp_1_8.RESET_B vdd vdd sg13_lv_pmos ad=79.8f pd=0.8u as=4.11675p ps=27.17u w=0.42u l=0.13u
X4168 sg13cmos5l_Corner_1.vss adc8b_0.sar12b_0.sg13cmos5l_dfrbp_1_6.RESET_B a_99518_95485# sg13cmos5l_Corner_1.vss sg13_lv_nmos ad=0.1701p pd=1.65u as=37.8f ps=0.6u w=0.42u l=0.13u
X4169 sg13cmos5l_Corner_1.vss a_178296_86044# sg13cmos5l_IOPadAnalog_0.pad sg13cmos5l_Corner_1.vss sg13_hv_nmos ad=1.408p pd=5.04u as=2.596p ps=5.58u w=4.4u l=0.6u
X4170 sg13cmos5l_Corner_1.iovdd a_164624_86044# sg13cmos5l_IOPadAnalog_0.pad sg13cmos5l_Corner_1.iovdd sg13_hv_pmos ad=3.1302p pd=14.26u as=3.9294p ps=7.84u w=6.66u l=0.6u
X4171 a_97836_97322# adc8b_0.sar12b_0.sg13cmos5l_buf_1_57.X a_97742_97322# sg13cmos5l_Corner_1.vss sg13_lv_nmos ad=60.89999f pd=0.71u as=0.1428p ps=1.52u w=0.42u l=0.13u
X4172 sg13cmos5l_Corner_1.iovdd a_164624_118044# sg13cmos5l_IOPadAnalog_11.pad sg13cmos5l_Corner_1.iovdd sg13_hv_pmos ad=2.1312p pd=7.3u as=3.9294p ps=7.84u w=6.66u l=0.6u
X4173 vdd a_92241_100346# a_92766_100328# vdd sg13_lv_pmos ad=0.1974p pd=1.5u as=0.2856p ps=2.36u w=0.84u l=0.13u
X4174 adc8b_0.sar12b_0.sg13cmos5l_dfrbp_1_11.Q a_90236_96108# vdd vdd sg13_lv_pmos ad=0.3808p pd=2.92u as=0.2128p ps=1.5u w=1.12u l=0.13u
X4175 vddr adc8b_0.sar12b_0.nl_sw[0] adc8b_0.side_cap8b_1.buf_32_0.z vddr sg13_lv_pmos ad=0.19p pd=1.38u as=0.19p ps=1.38u w=1u l=0.13u
X4176 sg13cmos5l_IOPadAnalog_16.pad a_178296_102044# sg13cmos5l_Corner_1.vss sg13cmos5l_Corner_1.vss sg13_hv_nmos ad=2.596p pd=5.58u as=1.408p ps=5.04u w=4.4u l=0.6u
X4177 sg13cmos5l_Corner_1.vss adc8b_0.sar12b_0.sg13cmos5l_inv_1_2.A adc8b_0.sar12b_0.sg13cmos5l_dfrbp_1_0.CLK sg13cmos5l_Corner_1.vss sg13_lv_nmos ad=0.2516p pd=2.16u as=0.2516p ps=2.16u w=0.74u l=0.13u
X4178 adc8b_0.sar12b_0.sg13cmos5l_dlygate4sd2_1_0.X a_83058_94366# sg13cmos5l_Corner_1.vss sg13cmos5l_Corner_1.vss sg13_lv_nmos ad=0.2516p pd=2.16u as=0.1405p ps=1.15u w=0.74u l=0.13u
X4179 sg13cmos5l_Corner_1.vss adc8b_0.sar12b_0.nl_sw[8] adc8b_0.side_cap8b_1.buf_2_1.z sg13cmos5l_Corner_1.vss sg13_lv_nmos ad=95f pd=0.88u as=0.17p ps=1.68u w=0.5u l=0.13u
X4180 adc8b_0.side_cap8b_1.buf_16_0.z adc8b_0.sar12b_0.nh_sw[2] vddr vddr sg13_lv_pmos ad=0.19p pd=1.38u as=0.19p ps=1.38u w=1u l=0.13u
X4181 sg13cmos5l_Corner_1.iovdd a_118044_42476# cko sg13cmos5l_Corner_1.iovdd sg13_hv_pmos ad=2.1312p pd=7.3u as=3.9294p ps=7.84u w=6.66u l=0.6u
X4182 a_83630_100034# a_84435_99607# a_83890_99564# vdd sg13_lv_pmos ad=0.1428p pd=1.52u as=79.8f ps=0.8u w=0.42u l=0.13u
X4183 vddr a_42476_70044# sg13cmos5l_Corner_1.iovdd sg13cmos5l_Corner_1.iovdd sg13_hv_pmos ad=3.9294p pd=7.84u as=2.1312p ps=7.3u w=6.66u l=0.6u
X4184 adc8b_0.sar12b_0.sg13cmos5l_inv_1_7.A a_93232_99596# vdd vdd sg13_lv_pmos ad=0.42p pd=2.99u as=0.2114p ps=1.54u w=1.12u l=0.13u
X4185 vdd adc8b_0.sar12b_0.sg13cmos5l_dfrbp_1_6.D a_99167_95107# vdd sg13_lv_pmos ad=0.1428p pd=1.52u as=79.8f ps=0.8u w=0.42u l=0.13u
X4186 a_97268_100310# adc8b_0.sar12b_0.sg13cmos5l_buf_1_95.X vdd vdd sg13_lv_pmos ad=0.2856p pd=2.36u as=0.2114p ps=1.54u w=0.84u l=0.13u
X4187 adc8b_0.side_cap8b_1.buf_8_0.z adc8b_0.sar12b_0.nl_sw[4] vddr vddr sg13_lv_pmos ad=0.19p pd=1.38u as=0.19p ps=1.38u w=1u l=0.13u
X4188 sg13cmos5l_Corner_1.vss adc8b_0.sar12b_0.sg13cmos5l_dlhr_1_1.D a_83377_95864# sg13cmos5l_Corner_1.vss sg13_lv_nmos ad=0.15055p pd=1.17u as=0.187p ps=1.78u w=0.55u l=0.13u
X4189 adc8b_0.sar12b_0.sg13cmos5l_o21ai_1_0.A2 adc8b_0.sar12b_0.sg13cmos5l_nand2_1_0.B vdd vdd sg13_lv_pmos ad=0.2128p pd=1.5u as=0.3808p ps=2.92u w=1.12u l=0.13u
X4190 vddr adc8b_0.sar12b_0.nl_sw[0] adc8b_0.side_cap8b_1.buf_32_0.z vddr sg13_lv_pmos ad=0.19p pd=1.38u as=0.19p ps=1.38u w=1u l=0.13u
X4191 vdd a_93741_92765# a_93843_92908# vdd sg13_lv_pmos ad=1.86162p pd=11.935u as=0.3864p ps=2.93u w=1.12u l=0.13u
X4192 vdd sg13cmos5l_Corner_1.vss vdd vdd sg13_lv_pmos ad=0.34p pd=2.68u as=0 ps=0 w=1u l=1u
X4193 vdd a_84980_92750# adc8b_0.sar12b_0.sg13cmos5l_buf_1_41.X vdd sg13_lv_pmos ad=0.2114p pd=1.54u as=0.42p ps=2.99u w=1.12u l=0.13u
X4194 adc8b_0.side_cap8b_0.buf_8_0.z adc8b_0.side_cap8b_0.in_l_sw[4] sg13cmos5l_Corner_1.vss sg13cmos5l_Corner_1.vss sg13_lv_nmos ad=95f pd=0.88u as=95f ps=0.88u w=0.5u l=0.13u
X4195 sg13cmos5l_Corner_1.iovdd a_86044_42476# data[1] sg13cmos5l_Corner_1.iovdd sg13_hv_pmos ad=3.1302p pd=14.26u as=3.9294p ps=7.84u w=6.66u l=0.6u
X4196 adc8b_0.side_cap8b_1.buf_32_1.z adc8b_0.sar12b_0.nh_sw[0] vddr vddr sg13_lv_pmos ad=0.19p pd=1.38u as=0.19p ps=1.38u w=1u l=0.13u
X4197 sg13cmos5l_Corner_1.vss sg13cmos5l_IOPadVdd$1_0.sg13cmos5l_Clamp_N43N43D4R$1_0.gate vdd sg13cmos5l_Corner_1.vss sg13_hv_nmos ad=1.408p pd=5.04u as=2.596p ps=5.58u w=4.4u l=0.6u
X4198 vdd adc8b_0.sar12b_0.sg13cmos5l_buf_1_65.X a_90256_100384# vdd sg13_lv_pmos ad=0.2114p pd=1.54u as=0.2856p ps=2.36u w=0.84u l=0.13u
X4199 data[0] a_70044_42476# sg13cmos5l_Corner_1.iovdd sg13cmos5l_Corner_1.iovdd sg13_hv_pmos ad=3.9294p pd=7.84u as=2.1312p ps=7.3u w=6.66u l=0.6u
X4200 adc8b_0.side_cap8b_0.buf_8_2.z adc8b_0.side_cap8b_0.in_h_sw[4] vddr vddr sg13_lv_pmos ad=0.19p pd=1.38u as=0.19p ps=1.38u w=1u l=0.13u
X4201 adc8b_0.side_cap8b_1.buf_32_0.z adc8b_0.sar12b_0.nl_sw[0] vddr vddr sg13_lv_pmos ad=0.19p pd=1.38u as=0.19p ps=1.38u w=1u l=0.13u
X4202 sg13cmos5l_IOPadAnalog_9.pad a_83639_178370# sg13cmos5l_Corner_1.vss sg13cmos5l_Corner_1.vss sg13_hv_nmos ad=2.596p pd=5.58u as=1.408p ps=5.04u w=4.4u l=0.6u
X4203 sg13cmos5l_Corner_1.iovdd a_42476_86044# vin sg13cmos5l_Corner_1.iovdd sg13_hv_pmos ad=2.1312p pd=7.3u as=3.9294p ps=7.84u w=6.66u l=0.6u
X4204 sg13cmos5l_Corner_1.vss adc8b_0.sar12b_0.sg13cmos5l_buf_1_33.A a_84016_92824# sg13cmos5l_Corner_1.vss sg13_lv_nmos ad=0.14875p pd=1.16u as=0.187p ps=1.78u w=0.55u l=0.13u
X4205 adc8b_0.sar12b_0.sg13cmos5l_buf_8_2.X a_100995_100350# sg13cmos5l_Corner_1.vss sg13cmos5l_Corner_1.vss sg13_lv_nmos ad=0.1406p pd=1.12u as=0.1406p ps=1.12u w=0.74u l=0.13u
X4206 vdd a_94868_99560# adc8b_0.side_cap8b_0.in_l_sw[6] vdd sg13_lv_pmos ad=0.2114p pd=1.54u as=0.42p ps=2.99u w=1.12u l=0.13u
X4207 adc8b_0.sar12b_0.sg13cmos5l_dfrbp_1_1.Q a_95420_93084# vdd vdd sg13_lv_pmos ad=0.3808p pd=2.92u as=0.2128p ps=1.5u w=1.12u l=0.13u
X4208 sg13cmos5l_Corner_1.vss sg13cmos5l_IOPadVdd$1_0.sg13cmos5l_Clamp_N43N43D4R$1_0.gate vdd sg13cmos5l_Corner_1.vss sg13_hv_nmos ad=1.408p pd=5.04u as=2.596p ps=5.58u w=4.4u l=0.6u
X4209 vin a_42476_86044# sg13cmos5l_Corner_1.iovdd sg13cmos5l_Corner_1.iovdd sg13_hv_pmos ad=3.9294p pd=7.84u as=2.1312p ps=7.3u w=6.66u l=0.6u
X4210 adc8b_0.sar12b_0.sg13cmos5l_dlygate4sd2_1_0.X a_83058_94366# vdd vdd sg13_lv_pmos ad=0.3808p pd=2.92u as=0.2245p ps=1.53u w=1.12u l=0.13u
X4211 a_95052_94616# a_95571_94420# a_96311_94375# sg13cmos5l_Corner_1.vss sg13_lv_nmos ad=0.3473p pd=2.71u as=0.12665p ps=1.145u w=0.74u l=0.13u
X4212 vdd sg13cmos5l_IOPadVdd$1_0.sg13cmos5l_Clamp_N43N43D4R$1_0.gate sg13cmos5l_Corner_1.vss sg13cmos5l_Corner_1.vss sg13_hv_nmos ad=2.596p pd=5.58u as=1.408p ps=5.04u w=4.4u l=0.6u
X4213 adc8b_0.sar12b_0.sg13cmos5l_dfrbp_1_20.Q a_91388_99132# vdd vdd sg13_lv_pmos ad=0.3808p pd=2.92u as=0.2128p ps=1.5u w=1.12u l=0.13u
X4214 vdd adc8b_0.sar12b_0.sg13cmos5l_dfrbp_1_8.RESET_B a_97618_96033# vdd sg13_lv_pmos ad=0.1563p pd=1.22u as=0.147p ps=1.54u w=0.42u l=0.13u
X4215 a_96668_93512# adc8b_0.sar12b_0.sg13cmos5l_nor2_1_1.A sg13cmos5l_Corner_1.vss sg13cmos5l_Corner_1.vss sg13_lv_nmos ad=0.187p pd=1.78u as=0.17255p ps=1.25u w=0.55u l=0.13u
X4216 sg13cmos5l_Corner_1.vss a_115639_178370# sg13cmos5l_IOPadAnalog_13.pad sg13cmos5l_Corner_1.vss sg13_hv_nmos ad=1.408p pd=5.04u as=2.596p ps=5.58u w=4.4u l=0.6u
X4217 a_72090_98590# vdd a_71988_99614# sg13cmos5l_Corner_1.vss sg13_lv_nmos ad=0.17p pd=1.68u as=95f ps=0.88u w=0.5u l=0.13u
X4218 a_95160_99156# a_94609_98888# vdd vdd sg13_lv_pmos ad=0.105p pd=1.21u as=1.15047p ps=7.175u w=1u l=0.13u
X4219 a_86012_98084# a_85599_98442# a_85944_98084# vdd sg13_lv_pmos ad=0.191p pd=1.44u as=0.105p ps=1.21u w=1u l=0.13u
X4220 a_76796_95659# adc8b_0.diff_bsw_0.vcp a_74586_95659# sg13cmos5l_Corner_1.vss sg13_lv_nmos ad=1.7p pd=10.68u as=0.95p ps=5.38u w=5u l=0.13u
X4221 sg13cmos5l_Corner_1.vss a_100995_95814# adc8b_0.sar12b_0.sg13cmos5l_buf_8_0.X sg13cmos5l_Corner_1.vss sg13_lv_nmos ad=0.1406p pd=1.12u as=0.1406p ps=1.12u w=0.74u l=0.13u
X4222 a_93324_93104# a_93843_92908# a_94583_92863# sg13cmos5l_Corner_1.vss sg13_lv_nmos ad=0.3473p pd=2.71u as=0.12665p ps=1.145u w=0.74u l=0.13u
X4223 sg13cmos5l_Corner_1.vss a_131639_178370# sg13cmos5l_IOPadAnalog_12.pad sg13cmos5l_Corner_1.vss sg13_hv_nmos ad=1.408p pd=5.04u as=2.596p ps=5.58u w=4.4u l=0.6u
X4224 vdd adc8b_0.sar12b_0.sg13cmos5l_dfrbp_1_6.RESET_B a_99729_99953# vdd sg13_lv_pmos ad=0.2128p pd=1.5u as=0.2128p ps=1.5u w=1.12u l=0.13u
X4225 a_88114_96033# a_88557_95789# a_87854_95810# sg13cmos5l_Corner_1.vss sg13_lv_nmos ad=79.8f pd=0.8u as=0.1296p ps=1.52u w=0.42u l=0.13u
X4226 adc8b_0.side_cap8b_1.buf_32_1.z adc8b_0.sar12b_0.nh_sw[0] vddr vddr sg13_lv_pmos ad=0.19p pd=1.38u as=0.19p ps=1.38u w=1u l=0.13u
X4227 a_96657_98441# a_96476_98084# vdd vdd sg13_lv_pmos ad=0.2128p pd=1.5u as=0.2387p ps=1.84u w=1.12u l=0.13u
X4228 sg13cmos5l_Corner_1.vss adc8b_0.sar12b_0.sg13cmos5l_dlhr_1_10.Q a_101296_98084# sg13cmos5l_Corner_1.vss sg13_lv_nmos ad=0.14875p pd=1.16u as=0.187p ps=1.78u w=0.55u l=0.13u
X4229 a_100767_97338# adc8b_0.sar12b_0.sg13cmos5l_dfrbp_1_8.D sg13cmos5l_Corner_1.vss sg13cmos5l_Corner_1.vss sg13_lv_nmos ad=0.2516p pd=2.16u as=0.15055p ps=1.17u w=0.74u l=0.13u
X4230 adc8b_0.side_cap8b_1.buf_16_1.z adc8b_0.sar12b_0.nl_sw[2] sg13cmos5l_Corner_1.vss sg13cmos5l_Corner_1.vss sg13_lv_nmos ad=95f pd=0.88u as=95f ps=0.88u w=0.5u l=0.13u
X4231 adc8b_0.sar12b_0.sg13cmos5l_dfrbp_1_6.RESET_B cks sg13cmos5l_Corner_1.vss sg13cmos5l_Corner_1.vss sg13_lv_nmos ad=0.1406p pd=1.12u as=0.1406p ps=1.12u w=0.74u l=0.13u
X4232 adc8b_0.side_cap8b_1.buf_32_1.z adc8b_0.sar12b_0.nh_sw[0] sg13cmos5l_Corner_1.vss sg13cmos5l_Corner_1.vss sg13_lv_nmos ad=0.17p pd=1.68u as=95f ps=0.88u w=0.5u l=0.13u
X4233 adc8b_0.side_cap8b_1.buf_32_0.z adc8b_0.sar12b_0.nl_sw[0] sg13cmos5l_Corner_1.vss sg13cmos5l_Corner_1.vss sg13_lv_nmos ad=95f pd=0.88u as=95f ps=0.88u w=0.5u l=0.13u
X4234 a_93228_93552# a_93747_93559# a_94487_93909# sg13cmos5l_Corner_1.vss sg13_lv_nmos ad=0.3473p pd=2.71u as=0.12665p ps=1.145u w=0.74u l=0.13u
X4235 sg13cmos5l_Corner_1.vss a_83716_99124# adc8b_0.sar12b_0.sg13cmos5l_buf_1_58.A sg13cmos5l_Corner_1.vss sg13_lv_nmos ad=0.1406p pd=1.12u as=0.2516p ps=2.16u w=0.74u l=0.13u
X4236 a_97470_95347# a_97589_95024# sg13cmos5l_Corner_1.vss sg13cmos5l_Corner_1.vss sg13_lv_nmos ad=0.2516p pd=2.16u as=0.1406p ps=1.12u w=0.74u l=0.13u
X4237 sg13cmos5l_Corner_1.vss sg13cmos5l_IOPadAnalog_13.padres dantenna l=3.1u w=0.64u
X4238 adc8b_0.side_cap8b_0.buf_4_3.z adc8b_0.side_cap8b_0.in_l_sw[6] vddr vddr sg13_lv_pmos ad=0.19p pd=1.38u as=0.19p ps=1.38u w=1u l=0.13u
X4239 sg13cmos5l_Corner_1.vss adc8b_0.side_cap8b_0.in_h_sw[9] adc8b_0.side_cap8b_0.buf_2_3.z sg13cmos5l_Corner_1.vss sg13_lv_nmos ad=95f pd=0.88u as=0.17p ps=1.68u w=0.5u l=0.13u
X4240 a_89972_100310# adc8b_0.sar12b_0.sg13cmos5l_buf_1_45.X vdd vdd sg13_lv_pmos ad=0.2856p pd=2.36u as=0.2114p ps=1.54u w=0.84u l=0.13u
X4241 sg13cmos5l_Corner_1.vss a_99287_97399# a_100124_97620# sg13cmos5l_Corner_1.vss sg13_lv_nmos ad=0.1406p pd=1.12u as=0.2516p ps=2.16u w=0.74u l=0.13u
X4242 a_96568_94518# adc8b_0.sar12b_0.sg13cmos5l_dfrbp_1_0.RESET_B vdd vdd sg13_lv_pmos ad=79.8f pd=0.8u as=1.38655p ps=8.8u w=0.42u l=0.13u
X4243 a_97655_99957# a_96813_99607# a_96396_99600# vdd sg13_lv_pmos ad=0.2048p pd=1.63u as=0.34p ps=2.68u w=1u l=0.13u
X4244 a_86092_99156# a_86117_98796# vdd vdd sg13_lv_pmos ad=0.2856p pd=2.36u as=1.15047p ps=7.175u w=0.84u l=0.13u
X4245 a_99519_98850# adc8b_0.sar12b_0.sg13cmos5l_dfrbp_1_22.D vdd vdd sg13_lv_pmos ad=0.3234p pd=2.45u as=1.12242p ps=7u w=0.84u l=0.13u
X4246 adc8b_0.side_cap8b_0.buf_32_1.z adc8b_0.side_cap8b_0.in_h_sw[0] vddr vddr sg13_lv_pmos ad=0.34p pd=2.68u as=0.19p ps=1.38u w=1u l=0.13u
X4247 cko a_102160_98872# vdd vdd sg13_lv_pmos ad=0.42p pd=2.99u as=0.2114p ps=1.54u w=1.12u l=0.13u
X4248 vdd a_96945_96929# a_97470_97002# vdd sg13_lv_pmos ad=0.1974p pd=1.5u as=0.2856p ps=2.36u w=0.84u l=0.13u
X4249 sg13cmos5l_Corner_1.vss adc8b_0.sar12b_0.nh_sw[4] adc8b_0.side_cap8b_1.buf_8_2.z sg13cmos5l_Corner_1.vss sg13_lv_nmos ad=95f pd=0.88u as=95f ps=0.88u w=0.5u l=0.13u
X4250 sg13cmos5l_IOPadAnalog_1.pad sg13cmos5l_Corner_1.iovdd dpantenna l=27.78u w=1.26u
X4251 sg13cmos5l_IOPadAnalog_0.pad a_164624_86044# sg13cmos5l_Corner_1.iovdd sg13cmos5l_Corner_1.iovdd sg13_hv_pmos ad=3.9294p pd=7.84u as=2.1312p ps=7.3u w=6.66u l=0.6u
X4252 sg13cmos5l_Corner_1.iovdd a_134044_42476# frame sg13cmos5l_Corner_1.iovdd sg13_hv_pmos ad=2.1312p pd=7.3u as=3.9294p ps=7.84u w=6.66u l=0.6u
X4253 adc8b_0.side_cap8b_1.buf_32_1.z adc8b_0.sar12b_0.nh_sw[0] sg13cmos5l_Corner_1.vss sg13cmos5l_Corner_1.vss sg13_lv_nmos ad=95f pd=0.88u as=95f ps=0.88u w=0.5u l=0.13u
X4254 sg13cmos5l_Corner_1.vss vdd sg13cmos5l_Corner_1.vss sg13cmos5l_Corner_1.vss sg13_lv_nmos ad=79.8f pd=0.8u as=0 ps=0 w=0.42u l=1u
X4255 sg13cmos5l_Corner_1.vss a_100995_95814# adc8b_0.sar12b_0.sg13cmos5l_buf_8_0.X sg13cmos5l_Corner_1.vss sg13_lv_nmos ad=0.1406p pd=1.12u as=0.1406p ps=1.12u w=0.74u l=0.13u
X4256 vddr adc8b_0.sar12b_0.nh_sw[5] adc8b_0.side_cap8b_1.buf_8_5.z vddr sg13_lv_pmos ad=0.19p pd=1.38u as=0.34p ps=2.68u w=1u l=0.13u
X4257 sg13cmos5l_Corner_1.vss a_30676_86044# vin sg13cmos5l_Corner_1.vss sg13_hv_nmos ad=1.408p pd=5.04u as=2.596p ps=5.58u w=4.4u l=0.6u
X4258 sg13cmos5l_Corner_1.vss adc8b_0.side_cap8b_0.in_h_sw[1] adc8b_0.side_cap8b_0.buf_16_3.z sg13cmos5l_Corner_1.vss sg13_lv_nmos ad=95f pd=0.88u as=95f ps=0.88u w=0.5u l=0.13u
X4259 sg13cmos5l_Corner_1.vss vdd sg13cmos5l_Corner_1.vss sg13cmos5l_Corner_1.vss sg13_lv_nmos ad=0.1428p pd=1.52u as=0 ps=0 w=0.42u l=1u
X4260 adc8b_0.sar12b_0.sg13cmos5l_dfrbp_1_14.Q_N a_86615_95887# vdd vdd sg13_lv_pmos ad=0.4312p pd=3.01u as=0.2639p ps=1.81u w=1.12u l=0.13u
X4261 sg13cmos5l_IOPadAnalog_16.pad sg13cmos5l_Corner_1.iovdd dpantenna l=27.78u w=1.26u
X4262 vddr adc8b_0.sar12b_0.nh_sw[8] adc8b_0.side_cap8b_1.buf_2_0.z vddr sg13_lv_pmos ad=0.19p pd=1.38u as=0.34p ps=2.68u w=1u l=0.13u
X4263 sg13cmos5l_IOPadAnalog_15.pad a_99639_178370# sg13cmos5l_Corner_1.vss sg13cmos5l_Corner_1.vss sg13_hv_nmos ad=2.596p pd=5.58u as=1.408p ps=5.04u w=4.4u l=0.6u
X4264 sg13cmos5l_IOPadAnalog_13.pad a_115639_178370# sg13cmos5l_Corner_1.vss sg13cmos5l_Corner_1.vss sg13_hv_nmos ad=2.596p pd=5.58u as=1.408p ps=5.04u w=4.4u l=0.6u
X4265 a_82833_98131# a_82476_98088# vdd vdd sg13_lv_pmos ad=63f pd=0.72u as=0.1563p ps=1.22u w=0.42u l=0.13u
X4266 vdd a_87588_96933# a_88611_96619# vdd sg13_lv_pmos ad=0.1563p pd=1.22u as=63f ps=0.72u w=0.42u l=0.13u
X4267 a_87948_95810# adc8b_0.sar12b_0.sg13cmos5l_dlhr_1_0.GATE a_87854_95810# sg13cmos5l_Corner_1.vss sg13_lv_nmos ad=60.89999f pd=0.71u as=0.1428p ps=1.52u w=0.42u l=0.13u
X4268 sg13cmos5l_Corner_1.iovdd a_42476_86044# sg13cmos5l_Corner_1.iovdd rppd l=12.9u w=0.5u
X4269 a_101294_97760# a_100898_97332# a_101180_97644# vdd sg13_lv_pmos ad=0.1008p pd=0.9u as=0.191p ps=1.44u w=0.42u l=0.13u
X4270 data[1] a_86044_30676# sg13cmos5l_Corner_1.vss sg13cmos5l_Corner_1.vss sg13_hv_nmos ad=2.596p pd=5.58u as=2.068p ps=9.74u w=4.4u l=0.6u
X4271 a_94583_92863# a_93741_92765# a_94489_92863# sg13cmos5l_Corner_1.vss sg13_lv_nmos ad=0.12665p pd=1.145u as=0.1428p ps=1.52u w=0.42u l=0.13u
X4272 sg13cmos5l_Corner_1.vss a_83639_178370# sg13cmos5l_IOPadAnalog_9.pad sg13cmos5l_Corner_1.vss sg13_hv_nmos ad=1.408p pd=5.04u as=2.596p ps=5.58u w=4.4u l=0.6u
X4273 sg13cmos5l_Corner_1.iovdd a_118044_42476# cko sg13cmos5l_Corner_1.iovdd sg13_hv_pmos ad=2.1312p pd=7.3u as=3.9294p ps=7.84u w=6.66u l=0.6u
X4274 sg13cmos5l_Corner_1.vss adc8b_0.sar12b_0.nl_sw[5] adc8b_0.side_cap8b_1.buf_8_4.z sg13cmos5l_Corner_1.vss sg13_lv_nmos ad=95f pd=0.88u as=95f ps=0.88u w=0.5u l=0.13u
X4275 vddr adc8b_0.sar12b_0.nh_sw[2] adc8b_0.side_cap8b_1.buf_16_0.z vddr sg13_lv_pmos ad=0.19p pd=1.38u as=0.34p ps=2.68u w=1u l=0.13u
X4276 vddr adc8b_0.side_cap8b_0.in_l_sw[3] adc8b_0.side_cap8b_0.buf_8_1.z vddr sg13_lv_pmos ad=0.19p pd=1.38u as=0.34p ps=2.68u w=1u l=0.13u
X4277 a_85786_94298# adc8b_0.sar12b_0.sg13cmos5l_dfrbp_1_6.RESET_B sg13cmos5l_Corner_1.vss sg13cmos5l_Corner_1.vss sg13_lv_nmos ad=37.8f pd=0.6u as=79.8f ps=0.8u w=0.42u l=0.13u
X4278 sg13cmos5l_IOPadAnalog_1.pad a_164624_70044# sg13cmos5l_Corner_1.iovdd sg13cmos5l_Corner_1.iovdd sg13_hv_pmos ad=3.9294p pd=7.84u as=2.1312p ps=7.3u w=6.66u l=0.6u
X4279 sg13cmos5l_Corner_1.vss adc8b_0.sar12b_0.sg13cmos5l_buf_1_29.A a_91600_92824# sg13cmos5l_Corner_1.vss sg13_lv_nmos ad=0.14875p pd=1.16u as=0.187p ps=1.78u w=0.55u l=0.13u
X4280 adc8b_0.sar12b_0.sg13cmos5l_dfrbp_1_17.Q_N a_85175_99957# sg13cmos5l_Corner_1.vss sg13cmos5l_Corner_1.vss sg13_lv_nmos ad=0.2849p pd=2.25u as=0.2516p ps=2.16u w=0.74u l=0.13u
X4281 sg13cmos5l_Corner_1.vss vdd sg13cmos5l_Corner_1.vss sg13cmos5l_Corner_1.vss sg13_lv_nmos ad=0.1428p pd=1.52u as=0 ps=0 w=0.42u l=1u
X4282 sg13cmos5l_Corner_1.iovdd a_42476_102044# vip sg13cmos5l_Corner_1.iovdd sg13_hv_pmos ad=2.1312p pd=7.3u as=3.9294p ps=7.84u w=6.66u l=0.6u
X4283 cks a_42476_118044# sg13cmos5l_Corner_1.iovdd sg13cmos5l_Corner_1.iovdd sg13_hv_pmos ad=3.9294p pd=7.84u as=2.1312p ps=7.3u w=6.66u l=0.6u
X4284 vip a_70852_97472# a_70096_99454# sg13cmos5l_Corner_1.vss sg13_lv_nmos ad=1.02p pd=6.68u as=1.02p ps=6.68u w=3u l=0.13u
X4285 adc8b_0.side_cap8b_1.buf_4_1.z adc8b_0.sar12b_0.nh_sw[6] vddr vddr sg13_lv_pmos ad=0.34p pd=2.68u as=0.19p ps=1.38u w=1u l=0.13u
X4286 adc8b_0.sar12b_0.sg13cmos5l_dfrbp_1_23.Q a_96380_97620# sg13cmos5l_Corner_1.vss sg13cmos5l_Corner_1.vss sg13_lv_nmos ad=0.2516p pd=2.16u as=0.1406p ps=1.12u w=0.74u l=0.13u
X4287 a_84204_95485# a_84435_95071# a_83890_95028# sg13cmos5l_Corner_1.vss sg13_lv_nmos ad=0.2373p pd=1.97u as=79.8f ps=0.8u w=0.42u l=0.13u
X4288 sg13cmos5l_IOPadAnalog_11.pad a_164624_118044# sg13cmos5l_Corner_1.iovdd sg13cmos5l_Corner_1.iovdd sg13_hv_pmos ad=3.9294p pd=7.84u as=2.1312p ps=7.3u w=6.66u l=0.6u
X4289 vdd a_88823_95421# a_89660_95060# vdd sg13_lv_pmos ad=0.2128p pd=1.5u as=0.3864p ps=2.93u w=1.12u l=0.13u
X4290 sg13cmos5l_Corner_1.iovdd a_86044_42476# data[1] sg13cmos5l_Corner_1.iovdd sg13_hv_pmos ad=2.1312p pd=7.3u as=3.9294p ps=7.84u w=6.66u l=0.6u
X4291 sg13cmos5l_Corner_1.iovdd a_42476_86044# vin sg13cmos5l_Corner_1.iovdd sg13_hv_pmos ad=2.1312p pd=7.3u as=3.9294p ps=7.84u w=6.66u l=0.6u
X4292 sg13cmos5l_Corner_1.vss sg13cmos5l_IOPadAnalog_9.padres dantenna l=3.1u w=0.64u
X4293 adc8b_0.side_cap8b_0.buf_32_0.z adc8b_0.side_cap8b_0.in_l_sw[0] sg13cmos5l_Corner_1.vss sg13cmos5l_Corner_1.vss sg13_lv_nmos ad=95f pd=0.88u as=95f ps=0.88u w=0.5u l=0.13u
X4294 sg13cmos5l_Corner_1.vss adc8b_0.sar12b_0.sg13cmos5l_buf_8_0.A a_100995_95814# sg13cmos5l_Corner_1.vss sg13_lv_nmos ad=0.1406p pd=1.12u as=0.2553p ps=2.17u w=0.74u l=0.13u
X4295 vdd sg13cmos5l_IOPadVdd$1_0.sg13cmos5l_RCClampInverter$1_0.in sg13cmos5l_IOPadVdd$1_0.sg13cmos5l_Clamp_N43N43D4R$1_0.gate vdd sg13_hv_pmos ad=1.33p pd=7.38u as=1.33p ps=7.38u w=7u l=0.5u
X4296 sg13cmos5l_Corner_1.vss adc8b_0.side_cap8b_0.in_l_sw[0] adc8b_0.side_cap8b_0.buf_32_0.z sg13cmos5l_Corner_1.vss sg13_lv_nmos ad=95f pd=0.88u as=95f ps=0.88u w=0.5u l=0.13u
X4297 a_88497_96201# a_88140_96128# vdd vdd sg13_lv_pmos ad=63f pd=0.72u as=0.1563p ps=1.22u w=0.42u l=0.13u
X4298 vdd adc8b_0.sar12b_0.sg13cmos5l_inv_1_2.A adc8b_0.sar12b_0.sg13cmos5l_dfrbp_1_0.CLK vdd sg13_lv_pmos ad=0.3808p pd=2.92u as=0.3808p ps=2.92u w=1.12u l=0.13u
X4299 sg13cmos5l_Corner_1.vss a_100131_95430# adc8b_0.sar12b_0.sg13cmos5l_or2_1_0.A sg13cmos5l_Corner_1.vss sg13_lv_nmos ad=0.1406p pd=1.12u as=0.1406p ps=1.12u w=0.74u l=0.13u
X4300 sg13cmos5l_Corner_1.vss a_93592_99054# a_93241_98911# sg13cmos5l_Corner_1.vss sg13_lv_nmos ad=79.8f pd=0.8u as=0.1428p ps=1.52u w=0.42u l=0.13u
X4301 sg13cmos5l_Corner_1.vss adc8b_0.sar12b_0.sg13cmos5l_dlhr_1_15.D a_99313_98888# sg13cmos5l_Corner_1.vss sg13_lv_nmos ad=0.15055p pd=1.17u as=0.187p ps=1.78u w=0.55u l=0.13u
X4302 vdd a_88823_95421# a_89080_95302# vdd sg13_lv_pmos ad=0.2639p pd=1.81u as=79.8f ps=0.8u w=0.42u l=0.13u
X4303 sg13cmos5l_Corner_1.vss a_176786_70222# dantenna l=27.78u w=1.26u
X4304 vddr adc8b_0.side_cap8b_0.in_l_sw[1] adc8b_0.side_cap8b_0.buf_16_2.z vddr sg13_lv_pmos ad=0.19p pd=1.38u as=0.19p ps=1.38u w=1u l=0.13u
X4305 a_92493_98813# adc8b_0.sar12b_0.sg13cmos5l_dlhr_1_11.GATE sg13cmos5l_Corner_1.vss sg13cmos5l_Corner_1.vss sg13_lv_nmos ad=0.2516p pd=2.16u as=1.49685p ps=9.6u w=0.74u l=0.13u
X4306 a_94335_98442# adc8b_0.sar12b_0.sg13cmos5l_dlhr_1_11.GATE vdd vdd sg13_lv_pmos ad=0.3234p pd=2.45u as=1.07253p ps=6.75u w=0.84u l=0.13u
X4307 sg13cmos5l_Corner_1.iovdd a_70044_42476# data[0] sg13cmos5l_Corner_1.iovdd sg13_hv_pmos ad=2.1312p pd=7.3u as=3.9294p ps=7.84u w=6.66u l=0.6u
X4308 vddr adc8b_0.side_cap8b_0.in_h_sw[2] adc8b_0.side_cap8b_0.buf_16_0.z vddr sg13_lv_pmos ad=0.19p pd=1.38u as=0.34p ps=2.68u w=1u l=0.13u
X4309 sg13cmos5l_Corner_1.vss vdd sg13cmos5l_Corner_1.vss sg13cmos5l_Corner_1.vss sg13_lv_nmos ad=0.1428p pd=1.52u as=0 ps=0 w=0.42u l=1u
X4310 a_89017_94290# a_88465_94352# sg13cmos5l_Corner_1.vss sg13cmos5l_Corner_1.vss sg13_lv_nmos ad=71.99999f pd=0.865u as=2.59257p ps=16.445u w=0.64u l=0.13u
X4311 sg13cmos5l_Corner_1.iovdd a_42476_118044# cks sg13cmos5l_Corner_1.iovdd sg13_hv_pmos ad=3.1302p pd=14.26u as=3.9294p ps=7.84u w=6.66u l=0.6u
X4312 adc8b_0.side_cap8b_1.buf_8_2.z adc8b_0.sar12b_0.nh_sw[4] vddr vddr sg13_lv_pmos ad=0.19p pd=1.38u as=0.19p ps=1.38u w=1u l=0.13u
X4313 sg13cmos5l_Corner_1.vss adc8b_0.sar12b_0.nl_sw[0] adc8b_0.side_cap8b_1.buf_32_0.z sg13cmos5l_Corner_1.vss sg13_lv_nmos ad=95f pd=0.88u as=95f ps=0.88u w=0.5u l=0.13u
X4314 vddr adc8b_0.side_cap8b_0.in_l_sw[0] adc8b_0.side_cap8b_0.buf_32_0.z vddr sg13_lv_pmos ad=0.19p pd=1.38u as=0.19p ps=1.38u w=1u l=0.13u
X4315 a_98319_95147# a_98471_95031# vdd vdd sg13_lv_pmos ad=0.3864p pd=2.93u as=1.43437p ps=9.105u w=1.12u l=0.13u
X4316 sg13cmos5l_IOPadAnalog_1.pad a_164624_70044# sg13cmos5l_Corner_1.iovdd sg13cmos5l_Corner_1.iovdd sg13_hv_pmos ad=3.9294p pd=7.84u as=2.1312p ps=7.3u w=6.66u l=0.6u
X4317 vddr adc8b_0.sar12b_0.nh_sw[0] adc8b_0.side_cap8b_1.buf_32_1.z vddr sg13_lv_pmos ad=0.19p pd=1.38u as=0.19p ps=1.38u w=1u l=0.13u
X4318 a_90932_92750# adc8b_0.sar12b_0.sg13cmos5l_buf_1_26.A vdd vdd sg13_lv_pmos ad=0.2856p pd=2.36u as=0.2114p ps=1.54u w=0.84u l=0.13u
X4319 vdd a_99885_94277# a_99987_94420# vdd sg13_lv_pmos ad=1.43437p pd=9.105u as=0.3864p ps=2.93u w=1.12u l=0.13u
X4320 sg13cmos5l_Corner_1.vss adc8b_0.sar12b_0.sg13cmos5l_dfrbp_1_20.Q_N a_91441_100400# sg13cmos5l_Corner_1.vss sg13_lv_nmos ad=0.15055p pd=1.17u as=0.187p ps=1.78u w=0.55u l=0.13u
X4321 a_82450_98052# a_82893_98095# a_82833_98131# vdd sg13_lv_pmos ad=79.8f pd=0.8u as=63f ps=0.72u w=0.42u l=0.13u
X4322 sg13cmos5l_Corner_1.vss a_102044_30676# data[2] sg13cmos5l_Corner_1.vss sg13_hv_nmos ad=1.408p pd=5.04u as=2.596p ps=5.58u w=4.4u l=0.6u
X4323 sg13cmos5l_IOPadAnalog_16.pad a_164624_102044# sg13cmos5l_Corner_1.iovdd sg13cmos5l_Corner_1.iovdd sg13_hv_pmos ad=3.9294p pd=7.84u as=2.1312p ps=7.3u w=6.66u l=0.6u
X4324 vdd sg13cmos5l_IOPadVdd$1_0.sg13cmos5l_Clamp_N43N43D4R$1_0.gate sg13cmos5l_Corner_1.vss sg13cmos5l_Corner_1.vss sg13_hv_nmos ad=2.596p pd=5.58u as=1.408p ps=5.04u w=4.4u l=0.6u
X4325 a_93592_99054# a_93335_98911# a_93754_98834# sg13cmos5l_Corner_1.vss sg13_lv_nmos ad=0.1428p pd=1.52u as=37.8f ps=0.6u w=0.42u l=0.13u
X4326 sg13cmos5l_Corner_1.vss adc8b_0.sar12b_0.nh_sw[3] adc8b_0.side_cap8b_1.buf_8_3.z sg13cmos5l_Corner_1.vss sg13_lv_nmos ad=95f pd=0.88u as=95f ps=0.88u w=0.5u l=0.13u
X4327 data[1] a_86044_42476# sg13cmos5l_Corner_1.iovdd sg13cmos5l_Corner_1.iovdd sg13_hv_pmos ad=3.9294p pd=7.84u as=2.1312p ps=7.3u w=6.66u l=0.6u
X4328 a_92475_93548# adc8b_0.sar12b_0.sg13cmos5l_nor2_1_0.A vdd vdd sg13_lv_pmos ad=0.1428p pd=1.375u as=0.2891p ps=1.695u w=1.12u l=0.13u
X4329 sg13cmos5l_IOPadAnalog_10.pad a_67639_178370# sg13cmos5l_Corner_1.vss sg13cmos5l_Corner_1.vss sg13_hv_nmos ad=2.596p pd=5.58u as=1.408p ps=5.04u w=4.4u l=0.6u
X4330 vdd sg13cmos5l_IOPadVdd$1_0.sg13cmos5l_Clamp_N43N43D4R$1_0.gate sg13cmos5l_Corner_1.vss sg13cmos5l_Corner_1.vss sg13_hv_nmos ad=2.596p pd=5.58u as=1.408p ps=5.04u w=4.4u l=0.6u
X4331 adc8b_0.side_cap8b_0.buf_8_0.z adc8b_0.side_cap8b_0.in_l_sw[4] vddr vddr sg13_lv_pmos ad=0.19p pd=1.38u as=0.19p ps=1.38u w=1u l=0.13u
X4332 vdd adc8b_0.sar12b_0.sg13cmos5l_dfrbp_1_8.RESET_B a_85330_96033# vdd sg13_lv_pmos ad=0.1563p pd=1.22u as=0.147p ps=1.54u w=0.42u l=0.13u
X4333 adc8b_0.sar12b_0.sg13cmos5l_dfrbp_1_5.Q_N a_98519_93909# sg13cmos5l_Corner_1.vss sg13cmos5l_Corner_1.vss sg13_lv_nmos ad=0.2849p pd=2.25u as=0.2516p ps=2.16u w=0.74u l=0.13u
X4334 sg13cmos5l_IOPadAnalog_9.pad a_83639_178370# sg13cmos5l_Corner_1.vss sg13cmos5l_Corner_1.vss sg13_hv_nmos ad=2.596p pd=5.58u as=1.408p ps=5.04u w=4.4u l=0.6u
X4335 sg13cmos5l_Corner_1.vss adc8b_0.sar12b_0.sg13cmos5l_dfrbp_1_0.RESET_B a_99276_94298# sg13cmos5l_Corner_1.vss sg13_lv_nmos ad=0.1626p pd=1.415u as=60.89999f ps=0.71u w=0.42u l=0.13u
X4336 vdd sg13cmos5l_IOPadVdd$1_0.sg13cmos5l_Clamp_N43N43D4R$1_0.gate sg13cmos5l_Corner_1.vss sg13cmos5l_Corner_1.vss sg13_hv_nmos ad=2.596p pd=5.58u as=1.408p ps=5.04u w=4.4u l=0.6u
X4337 adc8b_0.side_cap8b_0.buf_8_3.z adc8b_0.side_cap8b_0.in_h_sw[3] sg13cmos5l_Corner_1.vss sg13cmos5l_Corner_1.vss sg13_lv_nmos ad=95f pd=0.88u as=95f ps=0.88u w=0.5u l=0.13u
X4338 a_90015_96930# adc8b_0.sar12b_0.sg13cmos5l_dfrbp_1_11.Q vdd vdd sg13_lv_pmos ad=0.3234p pd=2.45u as=1.2517p ps=7.955u w=0.84u l=0.13u
X4339 sg13cmos5l_Corner_1.iovdd a_164624_86044# sg13cmos5l_IOPadAnalog_0.pad sg13cmos5l_Corner_1.iovdd sg13_hv_pmos ad=2.1312p pd=7.3u as=3.9294p ps=7.84u w=6.66u l=0.6u
X4340 sg13cmos5l_Corner_1.vss adc8b_0.sar12b_0.nl_sw[0] adc8b_0.side_cap8b_1.buf_32_0.z sg13cmos5l_Corner_1.vss sg13_lv_nmos ad=95f pd=0.88u as=95f ps=0.88u w=0.5u l=0.13u
X4341 a_86988_93552# a_86962_93516# sg13cmos5l_Corner_1.vss sg13cmos5l_Corner_1.vss sg13_lv_nmos ad=0.2516p pd=2.16u as=0.1626p ps=1.415u w=0.74u l=0.13u
X4342 adc8b_0.sar12b_0.sg13cmos5l_inv_1_5.A a_101564_94596# vdd vdd sg13_lv_pmos ad=0.3808p pd=2.92u as=0.2128p ps=1.5u w=1.12u l=0.13u
X4343 sg13cmos5l_Corner_1.vss a_115639_178370# sg13cmos5l_IOPadAnalog_13.pad sg13cmos5l_Corner_1.vss sg13_hv_nmos ad=1.408p pd=5.04u as=2.596p ps=5.58u w=4.4u l=0.6u
X4344 adc8b_0.side_cap8b_1.buf_8_3.z adc8b_0.sar12b_0.nh_sw[3] vddr vddr sg13_lv_pmos ad=0.19p pd=1.38u as=0.19p ps=1.38u w=1u l=0.13u
X4345 a_92840_96507# adc8b_0.sar12b_0.sg13cmos5l_nor2_1_0.A vdd vdd sg13_lv_pmos ad=0.2856p pd=2.36u as=0.1596p ps=1.22u w=0.84u l=0.13u
X4346 vdd sg13cmos5l_IOPadVdd$1_0.sg13cmos5l_RCClampInverter$1_0.in sg13cmos5l_IOPadVdd$1_0.sg13cmos5l_Clamp_N43N43D4R$1_0.gate vdd sg13_hv_pmos ad=1.33p pd=7.38u as=1.33p ps=7.38u w=7u l=0.5u
X4347 sg13cmos5l_Corner_1.vss adc8b_0.side_cap8b_0.in_h_sw[0] adc8b_0.side_cap8b_0.buf_32_1.z sg13cmos5l_Corner_1.vss sg13_lv_nmos ad=95f pd=0.88u as=95f ps=0.88u w=0.5u l=0.13u
X4348 vdd cks adc8b_0.sar12b_0.sg13cmos5l_dfrbp_1_6.RESET_B vdd sg13_lv_pmos ad=0.2128p pd=1.5u as=0.2128p ps=1.5u w=1.12u l=0.13u
X4349 sg13cmos5l_Corner_1.vss a_178296_70044# sg13cmos5l_IOPadAnalog_1.pad sg13cmos5l_Corner_1.vss sg13_hv_nmos ad=1.408p pd=5.04u as=2.596p ps=5.58u w=4.4u l=0.6u
X4350 adc8b_0.side_cap8b_0.buf_2_1.z adc8b_0.side_cap8b_0.in_l_sw[8] sg13cmos5l_Corner_1.vss sg13cmos5l_Corner_1.vss sg13_lv_nmos ad=0.17p pd=1.68u as=95f ps=0.88u w=0.5u l=0.13u
X4351 a_102260_99560# adc8b_0.sar12b_0.sg13cmos5l_buf_1_104.X sg13cmos5l_Corner_1.vss sg13cmos5l_Corner_1.vss sg13_lv_nmos ad=0.187p pd=1.78u as=0.14875p ps=1.16u w=0.55u l=0.13u
X4352 a_88666_93986# adc8b_0.sar12b_0.sg13cmos5l_dfrbp_1_6.RESET_B sg13cmos5l_Corner_1.vss sg13cmos5l_Corner_1.vss sg13_lv_nmos ad=37.8f pd=0.6u as=79.8f ps=0.8u w=0.42u l=0.13u
X4353 sg13cmos5l_Corner_1.vss a_96945_96929# a_96900_96974# sg13cmos5l_Corner_1.vss sg13_lv_nmos ad=0.1428p pd=1.52u as=47.25f ps=0.645u w=0.42u l=0.13u
X4354 vdd sg13cmos5l_Corner_1.vss vdd vdd sg13_lv_pmos ad=0.34p pd=2.68u as=0 ps=0 w=1u l=1u
X4355 vddr adc8b_0.side_cap8b_0.in_h_sw[0] adc8b_0.side_cap8b_0.buf_32_1.z vddr sg13_lv_pmos ad=0.19p pd=1.38u as=0.19p ps=1.38u w=1u l=0.13u
X4356 vdd adc8b_0.sar12b_0.sg13cmos5l_buf_1_76.X a_87184_100384# vdd sg13_lv_pmos ad=0.2114p pd=1.54u as=0.2856p ps=2.36u w=0.84u l=0.13u
X4357 sg13cmos5l_Corner_1.vss adc8b_0.sar12b_0.sg13cmos5l_buf_1_111.A a_100144_100384# sg13cmos5l_Corner_1.vss sg13_lv_nmos ad=0.14875p pd=1.16u as=0.187p ps=1.78u w=0.55u l=0.13u
X4358 sg13cmos5l_Corner_1.iovdd a_42476_102044# vip sg13cmos5l_Corner_1.iovdd sg13_hv_pmos ad=2.1312p pd=7.3u as=3.9294p ps=7.84u w=6.66u l=0.6u
X4359 sg13cmos5l_Corner_1.vss a_176786_118222# dantenna l=27.78u w=1.26u
X4360 sg13cmos5l_Corner_1.vss adc8b_0.sar12b_0.nh_sw[0] adc8b_0.side_cap8b_1.buf_32_1.z sg13cmos5l_Corner_1.vss sg13_lv_nmos ad=95f pd=0.88u as=95f ps=0.88u w=0.5u l=0.13u
X4361 adc8b_0.side_cap8b_0.in_l_sw[2] a_84016_100384# vdd vdd sg13_lv_pmos ad=0.42p pd=2.99u as=0.2114p ps=1.54u w=1.12u l=0.13u
X4362 a_88727_97399# a_87885_97301# a_88633_97399# sg13cmos5l_Corner_1.vss sg13_lv_nmos ad=0.12665p pd=1.145u as=0.1428p ps=1.52u w=0.42u l=0.13u
X4363 adc8b_0.side_cap8b_1.buf_4_3.z adc8b_0.sar12b_0.nl_sw[6] vddr vddr sg13_lv_pmos ad=0.34p pd=2.68u as=0.19p ps=1.38u w=1u l=0.13u
X4364 sg13cmos5l_Corner_1.iovdd a_99639_164698# sg13cmos5l_IOPadAnalog_15.pad sg13cmos5l_Corner_1.iovdd sg13_hv_pmos ad=2.1312p pd=7.3u as=3.9294p ps=7.84u w=6.66u l=0.6u
X4365 cks sg13cmos5l_Corner_1.iovdd dpantenna l=27.78u w=1.26u
X4366 a_93612_92799# a_93324_93104# a_93550_92799# sg13cmos5l_Corner_1.vss sg13_lv_nmos ad=0.1428p pd=1.52u as=37.8f ps=0.6u w=0.42u l=0.13u
X4367 a_92099_93084# adc8b_0.sar12b_0.sg13cmos5l_nor2b_1_0.Y vdd vdd sg13_lv_pmos ad=0.3808p pd=2.92u as=0.2128p ps=1.5u w=1.12u l=0.13u
X4368 sg13cmos5l_Corner_1.vss adc8b_0.side_cap8b_0.in_h_sw[4] adc8b_0.side_cap8b_0.buf_8_2.z sg13cmos5l_Corner_1.vss sg13_lv_nmos ad=95f pd=0.88u as=0.17p ps=1.68u w=0.5u l=0.13u
X4369 a_87442_97545# a_87885_97301# a_87825_97713# vdd sg13_lv_pmos ad=79.8f pd=0.8u as=63f ps=0.72u w=0.42u l=0.13u
X4370 sg13cmos5l_Corner_1.vss adc8b_0.sar12b_0.sg13cmos5l_a221oi_1_0.B2 a_93256_95836# sg13cmos5l_Corner_1.vss sg13_lv_nmos ad=0.1406p pd=1.12u as=0.1406p ps=1.12u w=0.74u l=0.13u
X4371 vdd adc8b_0.sar12b_0.sg13cmos5l_inv_1_8.A a_84647_97592# vdd sg13_lv_pmos ad=1.07253p pd=6.75u as=0.4088p ps=2.97u w=1.12u l=0.13u
X4372 data[0] a_102160_93548# sg13cmos5l_Corner_1.vss sg13cmos5l_Corner_1.vss sg13_lv_nmos ad=0.2886p pd=2.26u as=0.14875p ps=1.16u w=0.74u l=0.13u
X4373 a_98776_93790# a_98519_93909# a_98938_93986# sg13cmos5l_Corner_1.vss sg13_lv_nmos ad=0.1428p pd=1.52u as=37.8f ps=0.6u w=0.42u l=0.13u
X4374 sg13cmos5l_IOPadAnalog_12.pad a_131639_164698# sg13cmos5l_Corner_1.iovdd sg13cmos5l_Corner_1.iovdd sg13_hv_pmos ad=3.9294p pd=7.84u as=2.1312p ps=7.3u w=6.66u l=0.6u
X4375 a_86900_100310# adc8b_0.sar12b_0.sg13cmos5l_buf_1_44.X sg13cmos5l_Corner_1.vss sg13cmos5l_Corner_1.vss sg13_lv_nmos ad=0.187p pd=1.78u as=0.14875p ps=1.16u w=0.55u l=0.13u
X4376 vin sg13cmos5l_IOPadAnalog_4.padres sg13cmos5l_Corner_1.vss rppd l=2u w=1u
X4377 vdd adc8b_0.sar12b_0.sg13cmos5l_buf_8_2.X a_101776_98872# vdd sg13_lv_pmos ad=0.2114p pd=1.54u as=0.2856p ps=2.36u w=0.84u l=0.13u
X4378 sg13cmos5l_IOPadAnalog_1.pad a_178296_70044# sg13cmos5l_Corner_1.vss sg13cmos5l_Corner_1.vss sg13_hv_nmos ad=2.596p pd=5.58u as=1.408p ps=5.04u w=4.4u l=0.6u
X4379 data[1] a_86044_42476# sg13cmos5l_Corner_1.iovdd sg13cmos5l_Corner_1.iovdd sg13_hv_pmos ad=3.9294p pd=7.84u as=2.1312p ps=7.3u w=6.66u l=0.6u
X4380 sg13cmos5l_Corner_1.iovdd a_164624_86044# sg13cmos5l_IOPadAnalog_0.pad sg13cmos5l_Corner_1.iovdd sg13_hv_pmos ad=2.1312p pd=7.3u as=3.9294p ps=7.84u w=6.66u l=0.6u
X4381 sg13cmos5l_Corner_1.vss adc8b_0.sar12b_0.sg13cmos5l_buf_1_3.A a_102064_92824# sg13cmos5l_Corner_1.vss sg13_lv_nmos ad=0.14875p pd=1.16u as=0.187p ps=1.78u w=0.55u l=0.13u
X4382 sg13cmos5l_Corner_1.vss a_33862_118222# dantenna l=27.78u w=1.26u
X4383 a_90844_96960# a_90428_96572# a_90609_96929# sg13cmos5l_Corner_1.vss sg13_lv_nmos ad=77.7f pd=0.95u as=0.2516p ps=2.16u w=0.74u l=0.13u
X4384 sg13cmos5l_Corner_1.vss a_88823_95421# a_89660_95060# sg13cmos5l_Corner_1.vss sg13_lv_nmos ad=0.1406p pd=1.12u as=0.2516p ps=2.16u w=0.74u l=0.13u
X4385 adc8b_0.side_cap8b_1.buf_4_2.z adc8b_0.sar12b_0.nh_sw[7] sg13cmos5l_Corner_1.vss sg13cmos5l_Corner_1.vss sg13_lv_nmos ad=95f pd=0.88u as=95f ps=0.88u w=0.5u l=0.13u
X4386 vdd sg13cmos5l_IOPadVdd$1_0.sg13cmos5l_RCClampInverter$1_0.in sg13cmos5l_IOPadVdd$1_0.sg13cmos5l_Clamp_N43N43D4R$1_0.gate vdd sg13_hv_pmos ad=1.33p pd=7.38u as=1.33p ps=7.38u w=7u l=0.5u
X4387 sg13cmos5l_Corner_1.vss a_134044_30676# frame sg13cmos5l_Corner_1.vss sg13_hv_nmos ad=1.408p pd=5.04u as=2.596p ps=5.58u w=4.4u l=0.6u
X4388 sg13cmos5l_Corner_1.iovdd a_42476_70044# vddr sg13cmos5l_Corner_1.iovdd sg13_hv_pmos ad=2.1312p pd=7.3u as=3.9294p ps=7.84u w=6.66u l=0.6u
X4389 sg13cmos5l_Corner_1.vss adc8b_0.side_cap8b_0.in_l_sw[1] adc8b_0.side_cap8b_0.buf_16_2.z sg13cmos5l_Corner_1.vss sg13_lv_nmos ad=95f pd=0.88u as=95f ps=0.88u w=0.5u l=0.13u
X4390 vdd cks adc8b_0.sar12b_0.sg13cmos5l_dfrbp_1_6.RESET_B vdd sg13_lv_pmos ad=0.2128p pd=1.5u as=0.2128p ps=1.5u w=1.12u l=0.13u
X4391 a_85356_96128# a_85330_96033# sg13cmos5l_Corner_1.vss sg13cmos5l_Corner_1.vss sg13_lv_nmos ad=0.2516p pd=2.16u as=0.1626p ps=1.415u w=0.74u l=0.13u
X4392 a_83916_95064# a_84435_95071# a_85175_95421# sg13cmos5l_Corner_1.vss sg13_lv_nmos ad=0.3473p pd=2.71u as=0.12665p ps=1.145u w=0.74u l=0.13u
X4393 vdd adc8b_0.sar12b_0.sg13cmos5l_buf_1_10.A a_94288_94336# vdd sg13_lv_pmos ad=0.2114p pd=1.54u as=0.2856p ps=2.36u w=0.84u l=0.13u
X4394 vddr adc8b_0.side_cap8b_0.in_l_sw[7] adc8b_0.side_cap8b_0.buf_4_0.z vddr sg13_lv_pmos ad=0.19p pd=1.38u as=0.19p ps=1.38u w=1u l=0.13u
X4395 vdd adc8b_0.sar12b_0.sg13cmos5l_buf_1_78.A a_87952_100384# vdd sg13_lv_pmos ad=0.2114p pd=1.54u as=0.2856p ps=2.36u w=0.84u l=0.13u
X4396 a_91292_96132# a_90879_95826# a_91224_96132# vdd sg13_lv_pmos ad=0.191p pd=1.44u as=0.105p ps=1.21u w=1u l=0.13u
X4397 a_97358_95810# adc8b_0.sar12b_0.sg13cmos5l_dfrbp_1_8.D vdd vdd sg13_lv_pmos ad=79.8f pd=0.8u as=0.1428p ps=1.52u w=0.42u l=0.13u
X4398 cko a_118044_42476# sg13cmos5l_Corner_1.iovdd sg13cmos5l_Corner_1.iovdd sg13_hv_pmos ad=3.9294p pd=7.84u as=2.1312p ps=7.3u w=6.66u l=0.6u
X4399 sg13cmos5l_Corner_1.vss adc8b_0.sar12b_0.sg13cmos5l_buf_1_19.A a_100528_93548# sg13cmos5l_Corner_1.vss sg13_lv_nmos ad=0.14875p pd=1.16u as=0.187p ps=1.78u w=0.55u l=0.13u
X4400 sg13cmos5l_Corner_1.vss sg13cmos5l_IOPadVdd$1_0.sg13cmos5l_Clamp_N43N43D4R$1_0.gate vdd sg13cmos5l_Corner_1.vss sg13_hv_nmos ad=1.408p pd=5.04u as=2.596p ps=5.58u w=4.4u l=0.6u
X4401 vdd adc8b_0.sar12b_0.sg13cmos5l_dfrbp_1_11.Q a_88415_96619# vdd sg13_lv_pmos ad=0.1428p pd=1.52u as=79.8f ps=0.8u w=0.42u l=0.13u
X4402 sg13cmos5l_IOPadAnalog_13.pad sg13cmos5l_Corner_1.iovdd dpantenna l=1.26u w=27.78u
X4403 adc8b_0.side_cap8b_0.buf_8_0.z adc8b_0.side_cap8b_0.in_l_sw[4] sg13cmos5l_Corner_1.vss sg13cmos5l_Corner_1.vss sg13_lv_nmos ad=0.17p pd=1.68u as=95f ps=0.88u w=0.5u l=0.13u
X4404 adc8b_0.side_cap8b_1.buf_32_1.z adc8b_0.sar12b_0.nh_sw[0] vddr vddr sg13_lv_pmos ad=0.19p pd=1.38u as=0.19p ps=1.38u w=1u l=0.13u
X4405 cks a_30676_118044# sg13cmos5l_Corner_1.vss sg13cmos5l_Corner_1.vss sg13_hv_nmos ad=2.596p pd=5.58u as=2.068p ps=9.74u w=4.4u l=0.6u
X4406 a_99597_92765# adc8b_0.sar12b_0.sg13cmos5l_dfrbp_1_0.CLK sg13cmos5l_Corner_1.vss sg13cmos5l_Corner_1.vss sg13_lv_nmos ad=0.2516p pd=2.16u as=5.84582p ps=38.34u w=0.74u l=0.13u
X4407 sg13cmos5l_Corner_1.vss a_83639_178370# sg13cmos5l_IOPadAnalog_9.pad sg13cmos5l_Corner_1.vss sg13_hv_nmos ad=1.408p pd=5.04u as=2.596p ps=5.58u w=4.4u l=0.6u
X4408 adc8b_0.side_cap8b_0.buf_8_2.z adc8b_0.side_cap8b_0.in_h_sw[4] vddr vddr sg13_lv_pmos ad=0.19p pd=1.38u as=0.19p ps=1.38u w=1u l=0.13u
X4409 sg13cmos5l_Corner_1.vss a_152182_108462# dantenna l=0.64u w=3.1u
X4410 sg13cmos5l_Corner_1.vss adc8b_0.side_cap8b_0.in_l_sw[10] adc8b_0.side_cap8b_0.buf_1_0.z sg13cmos5l_Corner_1.vss sg13_lv_nmos ad=0.17p pd=1.68u as=0.17p ps=1.68u w=0.5u l=0.13u
X4411 adc8b_0.sar12b_0.sg13cmos5l_dlhr_1_15.Q_N a_100638_98816# vdd vdd sg13_lv_pmos ad=0.3808p pd=2.92u as=0.1974p ps=1.5u w=1.12u l=0.13u
X4412 sg13cmos5l_Corner_1.vss sg13cmos5l_IOPadVdd$1_0.sg13cmos5l_Clamp_N43N43D4R$1_0.gate vdd sg13cmos5l_Corner_1.vss sg13_hv_nmos ad=1.408p pd=5.04u as=2.596p ps=5.58u w=4.4u l=0.6u
X4413 adc8b_0.sar12b_0.sg13cmos5l_buf_1_107.X a_99664_100384# sg13cmos5l_Corner_1.vss sg13cmos5l_Corner_1.vss sg13_lv_nmos ad=0.2886p pd=2.26u as=0.14875p ps=1.16u w=0.74u l=0.13u
X4414 sg13cmos5l_IOPadAnalog_0.pad a_178296_86044# sg13cmos5l_Corner_1.vss sg13cmos5l_Corner_1.vss sg13_hv_nmos ad=2.596p pd=5.58u as=1.408p ps=5.04u w=4.4u l=0.6u
X4415 data[1] a_86044_30676# sg13cmos5l_Corner_1.vss sg13cmos5l_Corner_1.vss sg13_hv_nmos ad=2.596p pd=5.58u as=1.408p ps=5.04u w=4.4u l=0.6u
X4416 adc8b_0.sar12b_0.sg13cmos5l_dfrbp_1_24.Q_N a_95159_100423# sg13cmos5l_Corner_1.vss sg13cmos5l_Corner_1.vss sg13_lv_nmos ad=0.2849p pd=2.25u as=0.2516p ps=2.16u w=0.74u l=0.13u
X4417 adc8b_0.sar12b_0.sg13cmos5l_dfrbp_1_10.Q a_86204_94596# vdd vdd sg13_lv_pmos ad=0.3808p pd=2.92u as=0.2128p ps=1.5u w=1.12u l=0.13u
X4418 sg13cmos5l_Corner_1.vss a_178296_102044# sg13cmos5l_IOPadAnalog_16.pad sg13cmos5l_Corner_1.vss sg13_hv_nmos ad=1.408p pd=5.04u as=2.596p ps=5.58u w=4.4u l=0.6u
X4419 sg13cmos5l_Corner_1.vss a_101780_92750# adc8b_0.sar12b_0.sg13cmos5l_buf_1_0.X sg13cmos5l_Corner_1.vss sg13_lv_nmos ad=0.14875p pd=1.16u as=0.2886p ps=2.26u w=0.74u l=0.13u
X4420 adc8b_0.sar12b_0.sg13cmos5l_dfrbp_1_0.Q_N a_100439_92863# sg13cmos5l_Corner_1.vss sg13cmos5l_Corner_1.vss sg13_lv_nmos ad=0.2849p pd=2.25u as=0.2516p ps=2.16u w=0.74u l=0.13u
X4421 sg13cmos5l_Corner_1.vss adc8b_0.sar12b_0.sg13cmos5l_nor2b_1_0.Y a_92201_92812# sg13cmos5l_Corner_1.vss sg13_lv_nmos ad=0.2516p pd=2.16u as=0.1406p ps=1.12u w=0.74u l=0.13u
X4422 vdd a_94487_93909# a_94744_93790# vdd sg13_lv_pmos ad=0.2639p pd=1.81u as=79.8f ps=0.8u w=0.42u l=0.13u
X4423 sg13cmos5l_Corner_1.vss a_92180_97286# adc8b_0.sar12b_0.sg13cmos5l_buf_1_29.A sg13cmos5l_Corner_1.vss sg13_lv_nmos ad=0.14875p pd=1.16u as=0.2886p ps=2.26u w=0.74u l=0.13u
X4424 a_88044_100021# a_87756_99600# a_87982_100021# sg13cmos5l_Corner_1.vss sg13_lv_nmos ad=0.1428p pd=1.52u as=37.8f ps=0.6u w=0.42u l=0.13u
X4425 vdd a_97655_99957# a_97912_99838# vdd sg13_lv_pmos ad=0.2639p pd=1.81u as=79.8f ps=0.8u w=0.42u l=0.13u
X4426 adc8b_0.sar12b_0.sg13cmos5l_buf_1_19.X a_100528_93548# sg13cmos5l_Corner_1.vss sg13cmos5l_Corner_1.vss sg13_lv_nmos ad=0.2886p pd=2.26u as=0.14875p ps=1.16u w=0.74u l=0.13u
X4427 adc8b_0.sar12b_0.sg13cmos5l_nor2b_1_1.Y adc8b_0.sar12b_0.sg13cmos5l_nor2_1_1.A a_96244_93548# vdd sg13_lv_pmos ad=0.3808p pd=2.92u as=0.1176p ps=1.33u w=1.12u l=0.13u
X4428 adc8b_0.side_cap8b_1.buf_32_1.z adc8b_0.sar12b_0.nh_sw[0] vddr vddr sg13_lv_pmos ad=0.19p pd=1.38u as=0.19p ps=1.38u w=1u l=0.13u
X4429 a_36456_137395# a_40542_137065# sg13cmos5l_Corner_1.vss rppd l=20u w=1u
X4430 a_85342_99010# a_85444_99124# vdd vdd sg13_lv_pmos ad=0.2856p pd=2.36u as=0.1974p ps=1.5u w=0.84u l=0.13u
X4431 a_82292_95774# adc8b_0.sar12b_0.sg13cmos5l_buf_1_43.A vdd vdd sg13_lv_pmos ad=0.2856p pd=2.36u as=0.2114p ps=1.54u w=0.84u l=0.13u
X4432 adc8b_0.sar12b_0.sg13cmos5l_or2_1_0.A a_100131_95430# vdd vdd sg13_lv_pmos ad=0.2128p pd=1.5u as=0.2128p ps=1.5u w=1.12u l=0.13u
X4433 sg13cmos5l_Corner_1.iovdd a_102044_42476# data[2] sg13cmos5l_Corner_1.iovdd sg13_hv_pmos ad=3.1302p pd=14.26u as=3.9294p ps=7.84u w=6.66u l=0.6u
X4434 sg13cmos5l_IOPadAnalog_16.pad a_164624_102044# sg13cmos5l_Corner_1.iovdd sg13cmos5l_Corner_1.iovdd sg13_hv_pmos ad=3.9294p pd=7.84u as=2.1312p ps=7.3u w=6.66u l=0.6u
X4435 vin a_42476_86044# sg13cmos5l_Corner_1.iovdd sg13cmos5l_Corner_1.iovdd sg13_hv_pmos ad=3.9294p pd=7.84u as=2.1312p ps=7.3u w=6.66u l=0.6u
X4436 sg13cmos5l_Corner_1.iovdd a_102044_42476# data[2] sg13cmos5l_Corner_1.iovdd sg13_hv_pmos ad=2.1312p pd=7.3u as=3.9294p ps=7.84u w=6.66u l=0.6u
X4437 sg13cmos5l_Corner_1.iovdd a_67639_164698# sg13cmos5l_IOPadAnalog_10.pad sg13cmos5l_Corner_1.iovdd sg13_hv_pmos ad=2.1312p pd=7.3u as=3.9294p ps=7.84u w=6.66u l=0.6u
X4438 sg13cmos5l_Corner_1.vss adc8b_0.sar12b_0.sg13cmos5l_inv_1_7.A a_94000_99596# sg13cmos5l_Corner_1.vss sg13_lv_nmos ad=0.14875p pd=1.16u as=0.187p ps=1.78u w=0.55u l=0.13u
X4439 sg13cmos5l_Corner_1.vss a_82893_98095# a_82995_98095# sg13cmos5l_Corner_1.vss sg13_lv_nmos ad=1.49685p pd=9.6u as=0.2516p ps=2.16u w=0.74u l=0.13u
X4440 sg13cmos5l_Corner_1.vss a_30676_118044# cks sg13cmos5l_Corner_1.vss sg13_hv_nmos ad=1.408p pd=5.04u as=2.596p ps=5.58u w=4.4u l=0.6u
X4441 vdd adc8b_0.sar12b_0.sg13cmos5l_buf_1_62.X a_83632_100384# vdd sg13_lv_pmos ad=0.2114p pd=1.54u as=0.2856p ps=2.36u w=0.84u l=0.13u
X4442 a_98458_98834# adc8b_0.sar12b_0.sg13cmos5l_dfrbp_1_6.RESET_B sg13cmos5l_Corner_1.vss sg13cmos5l_Corner_1.vss sg13_lv_nmos ad=37.8f pd=0.6u as=79.8f ps=0.8u w=0.42u l=0.13u
X4443 vdd adc8b_0.sar12b_0.sg13cmos5l_dfrbp_1_8.RESET_B a_84148_97322# vdd sg13_lv_pmos ad=1.04815p pd=6.595u as=79.8f ps=0.8u w=0.42u l=0.13u
X4444 sg13cmos5l_Corner_1.vss a_87981_95071# a_88083_95071# sg13cmos5l_Corner_1.vss sg13_lv_nmos ad=2.41737p pd=15.64u as=0.2516p ps=2.16u w=0.74u l=0.13u
X4445 a_87260_94620# a_86978_94308# a_87193_94290# sg13cmos5l_Corner_1.vss sg13_lv_nmos ad=0.141p pd=1.17u as=71.99999f ps=0.865u w=0.64u l=0.13u
X4446 sg13cmos5l_IOPadAnalog_9.pad a_83639_164698# sg13cmos5l_Corner_1.iovdd sg13cmos5l_Corner_1.iovdd sg13_hv_pmos ad=3.9294p pd=7.84u as=2.1312p ps=7.3u w=6.66u l=0.6u
X4447 a_94815_98850# adc8b_0.sar12b_0.sg13cmos5l_dlhr_1_11.GATE vdd vdd sg13_lv_pmos ad=0.3234p pd=2.45u as=1.12242p ps=7u w=0.84u l=0.13u
X4448 a_96409_98486# a_95857_98442# sg13cmos5l_Corner_1.vss sg13cmos5l_Corner_1.vss sg13_lv_nmos ad=71.99999f pd=0.865u as=1.49685p ps=9.6u w=0.64u l=0.13u
X4449 sg13cmos5l_Corner_1.iovdd a_134044_42476# frame sg13cmos5l_Corner_1.iovdd sg13_hv_pmos ad=2.1312p pd=7.3u as=3.9294p ps=7.84u w=6.66u l=0.6u
X4450 sg13cmos5l_Corner_1.vss adc8b_0.sar12b_0.nh_sw[1] adc8b_0.side_cap8b_1.buf_16_3.z sg13cmos5l_Corner_1.vss sg13_lv_nmos ad=95f pd=0.88u as=95f ps=0.88u w=0.5u l=0.13u
X4451 sg13cmos5l_Corner_1.vss sg13cmos5l_IOPadVdd$1_0.sg13cmos5l_Clamp_N43N43D4R$1_0.gate vdd sg13cmos5l_Corner_1.vss sg13_hv_nmos ad=1.408p pd=5.04u as=2.596p ps=5.58u w=4.4u l=0.6u
X4452 adc8b_0.side_cap8b_0.buf_4_3.z adc8b_0.side_cap8b_0.in_l_sw[6] vddr vddr sg13_lv_pmos ad=0.34p pd=2.68u as=0.19p ps=1.38u w=1u l=0.13u
X4453 adc8b_0.sar12b_0.sg13cmos5l_dlhr_1_2.Q a_89265_94298# vdd vdd sg13_lv_pmos ad=0.3808p pd=2.92u as=0.2128p ps=1.5u w=1.12u l=0.13u
X4454 sg13cmos5l_Corner_1.vss a_70044_30676# data[0] sg13cmos5l_Corner_1.vss sg13_hv_nmos ad=1.408p pd=5.04u as=2.596p ps=5.58u w=4.4u l=0.6u
X4455 adc8b_0.side_cap8b_1.buf_32_0.z adc8b_0.sar12b_0.nl_sw[0] sg13cmos5l_Corner_1.vss sg13cmos5l_Corner_1.vss sg13_lv_nmos ad=95f pd=0.88u as=95f ps=0.88u w=0.5u l=0.13u
X4456 vdd a_94844_96536# a_94802_96572# vdd sg13_lv_pmos ad=0.2618p pd=1.63u as=0.1176p ps=1.33u w=1.12u l=0.13u
X4457 a_97234_93516# a_97677_93559# a_97617_93595# vdd sg13_lv_pmos ad=79.8f pd=0.8u as=63f ps=0.72u w=0.42u l=0.13u
X4458 sg13cmos5l_Corner_1.vss a_30676_70044# vddr sg13cmos5l_Corner_1.vss sg13_hv_nmos ad=1.408p pd=5.04u as=2.596p ps=5.58u w=4.4u l=0.6u
X4459 sg13cmos5l_Corner_1.vss adc8b_0.sar12b_0.sg13cmos5l_and3_1_0.C a_95288_95856# sg13cmos5l_Corner_1.vss sg13_lv_nmos ad=0.1371p pd=1.12u as=0.1216p ps=1.02u w=0.64u l=0.13u
X4460 vdd adc8b_0.sar12b_0.sg13cmos5l_dfrbp_1_0.RESET_B a_95026_94521# vdd sg13_lv_pmos ad=0.1563p pd=1.22u as=0.147p ps=1.54u w=0.42u l=0.13u
X4461 adc8b_0.sar12b_0.nh_sw[10] a_102160_94336# sg13cmos5l_Corner_1.vss sg13cmos5l_Corner_1.vss sg13_lv_nmos ad=0.2886p pd=2.26u as=0.14875p ps=1.16u w=0.74u l=0.13u
X4462 sg13cmos5l_Corner_1.iovdd a_131639_164698# sg13cmos5l_IOPadAnalog_12.pad sg13cmos5l_Corner_1.iovdd sg13_hv_pmos ad=2.1312p pd=7.3u as=3.9294p ps=7.84u w=6.66u l=0.6u
X4463 adc8b_0.side_cap8b_0.buf_32_1.z adc8b_0.side_cap8b_0.in_h_sw[0] sg13cmos5l_Corner_1.vss sg13cmos5l_Corner_1.vss sg13_lv_nmos ad=95f pd=0.88u as=95f ps=0.88u w=0.5u l=0.13u
X4464 sg13cmos5l_Corner_1.vss adc8b_0.side_cap8b_0.in_l_sw[2] adc8b_0.side_cap8b_0.buf_16_1.z sg13cmos5l_Corner_1.vss sg13_lv_nmos ad=95f pd=0.88u as=0.17p ps=1.68u w=0.5u l=0.13u
X4465 vdd a_102260_99560# adc8b_0.side_cap8b_0.in_l_sw[10] vdd sg13_lv_pmos ad=0.2114p pd=1.54u as=0.42p ps=2.99u w=1.12u l=0.13u
X4466 sg13cmos5l_Corner_1.vss a_84333_95071# a_84435_95071# sg13cmos5l_Corner_1.vss sg13_lv_nmos ad=2.41737p pd=15.64u as=0.2516p ps=2.16u w=0.74u l=0.13u
X4467 data[1] a_101776_95060# vdd vdd sg13_lv_pmos ad=0.42p pd=2.99u as=0.2114p ps=1.54u w=1.12u l=0.13u
X4468 vdd sg13cmos5l_IOPadVdd$1_0.sg13cmos5l_RCClampInverter$1_0.in sg13cmos5l_IOPadVdd$1_0.sg13cmos5l_Clamp_N43N43D4R$1_0.gate vdd sg13_hv_pmos ad=1.33p pd=7.38u as=1.33p ps=7.38u w=7u l=0.5u
X4469 a_92476_100332# a_92060_100668# a_92241_100346# sg13cmos5l_Corner_1.vss sg13_lv_nmos ad=77.7f pd=0.95u as=0.2516p ps=2.16u w=0.74u l=0.13u
X4470 sg13cmos5l_IOPadAnalog_11.pad a_164624_118044# sg13cmos5l_Corner_1.iovdd sg13cmos5l_Corner_1.iovdd sg13_hv_pmos ad=3.9294p pd=7.84u as=2.1312p ps=7.3u w=6.66u l=0.6u
X4471 sg13cmos5l_IOPadAnalog_9.pad sg13cmos5l_Corner_1.iovdd dpantenna l=1.26u w=27.78u
X4472 adc8b_0.side_cap8b_0.buf_32_1.z adc8b_0.side_cap8b_0.in_h_sw[0] vddr vddr sg13_lv_pmos ad=0.19p pd=1.38u as=0.19p ps=1.38u w=1u l=0.13u
X4473 sg13cmos5l_Corner_1.vss adc8b_0.side_cap8b_0.in_h_sw[2] adc8b_0.side_cap8b_0.buf_16_0.z sg13cmos5l_Corner_1.vss sg13_lv_nmos ad=95f pd=0.88u as=95f ps=0.88u w=0.5u l=0.13u
X4474 vdd a_86900_100310# adc8b_0.sar12b_0.sg13cmos5l_buf_1_64.A vdd sg13_lv_pmos ad=0.2114p pd=1.54u as=0.42p ps=2.99u w=1.12u l=0.13u
X4475 data[1] a_86044_42476# sg13cmos5l_Corner_1.iovdd sg13cmos5l_Corner_1.iovdd sg13_hv_pmos ad=3.9294p pd=7.84u as=2.1312p ps=7.3u w=6.66u l=0.6u
X4476 cko sg13cmos5l_Corner_1.iovdd dpantenna l=1.26u w=27.78u
X4477 adc8b_0.side_cap8b_1.buf_32_1.z adc8b_0.sar12b_0.nh_sw[0] sg13cmos5l_Corner_1.vss sg13cmos5l_Corner_1.vss sg13_lv_nmos ad=95f pd=0.88u as=95f ps=0.88u w=0.5u l=0.13u
X4478 vdd sg13cmos5l_IOPadVdd$1_0.sg13cmos5l_Clamp_N43N43D4R$1_0.gate sg13cmos5l_Corner_1.vss sg13cmos5l_Corner_1.vss sg13_hv_nmos ad=2.596p pd=5.58u as=1.408p ps=5.04u w=4.4u l=0.6u
X4479 a_94284_97640# a_94258_97545# vdd vdd sg13_lv_pmos ad=0.34p pd=2.68u as=0.36237p ps=2.605u w=1u l=0.13u
X4480 adc8b_0.side_cap8b_0.buf_8_1.z adc8b_0.side_cap8b_0.in_l_sw[3] sg13cmos5l_Corner_1.vss sg13cmos5l_Corner_1.vss sg13_lv_nmos ad=95f pd=0.88u as=95f ps=0.88u w=0.5u l=0.13u
X4481 vddr adc8b_0.side_cap8b_0.in_h_sw[7] adc8b_0.side_cap8b_0.buf_4_2.z vddr sg13_lv_pmos ad=0.19p pd=1.38u as=0.19p ps=1.38u w=1u l=0.13u
X4482 adc8b_0.sar12b_0.sg13cmos5l_or2_1_0.A a_100131_95430# vdd vdd sg13_lv_pmos ad=0.2128p pd=1.5u as=0.2128p ps=1.5u w=1.12u l=0.13u
X4483 sg13cmos5l_IOPadAnalog_12.pad a_131639_164698# sg13cmos5l_Corner_1.iovdd sg13cmos5l_Corner_1.iovdd sg13_hv_pmos ad=3.9294p pd=7.84u as=2.1312p ps=7.3u w=6.66u l=0.6u
X4484 a_102044_30676# sg13cmos5l_Corner_1.vss sg13cmos5l_Corner_1.vss rppd l=3.54u w=0.5u
X4485 sg13cmos5l_Corner_1.vss a_30676_102044# vip sg13cmos5l_Corner_1.vss sg13_hv_nmos ad=1.408p pd=5.04u as=2.596p ps=5.58u w=4.4u l=0.6u
X4486 vip a_42476_102044# sg13cmos5l_Corner_1.iovdd sg13cmos5l_Corner_1.iovdd sg13_hv_pmos ad=3.9294p pd=7.84u as=2.1312p ps=7.3u w=6.66u l=0.6u
X4487 sg13cmos5l_Corner_1.vss adc8b_0.cmp_0.clk a_74586_95659# sg13cmos5l_Corner_1.vss sg13_lv_nmos ad=95f pd=0.88u as=95f ps=0.88u w=0.5u l=0.13u
X4488 sg13cmos5l_IOPadAnalog_3.padres sg13cmos5l_Corner_1.iovdd dpantenna l=0.64u w=4.98u
X4489 sg13cmos5l_Corner_1.vss adc8b_0.side_cap8b_0.in_l_sw[0] adc8b_0.side_cap8b_0.buf_32_0.z sg13cmos5l_Corner_1.vss sg13_lv_nmos ad=95f pd=0.88u as=95f ps=0.88u w=0.5u l=0.13u
X4490 adc8b_0.side_cap8b_0.in_l_sw[4] a_87568_100384# sg13cmos5l_Corner_1.vss sg13cmos5l_Corner_1.vss sg13_lv_nmos ad=0.2886p pd=2.26u as=0.14875p ps=1.16u w=0.74u l=0.13u
X4491 a_88247_93909# a_87405_93559# a_88153_93909# sg13cmos5l_Corner_1.vss sg13_lv_nmos ad=0.12665p pd=1.145u as=0.1428p ps=1.52u w=0.42u l=0.13u
X4492 a_98061_95789# adc8b_0.sar12b_0.sg13cmos5l_inv_1_2.A sg13cmos5l_Corner_1.vss sg13cmos5l_Corner_1.vss sg13_lv_nmos ad=0.2516p pd=2.16u as=2.41737p ps=15.64u w=0.74u l=0.13u
X4493 vdd adc8b_0.sar12b_0.sg13cmos5l_dfrbp_1_1.Q a_102160_93548# vdd sg13_lv_pmos ad=0.2114p pd=1.54u as=0.2856p ps=2.36u w=0.84u l=0.13u
X4494 vdd a_89272_99838# a_89217_99719# vdd sg13_lv_pmos ad=1.15047p pd=7.175u as=93.45f ps=0.865u w=0.42u l=0.13u
X4495 sg13cmos5l_Corner_1.iovdd a_42476_70044# vddr sg13cmos5l_Corner_1.iovdd sg13_hv_pmos ad=2.1312p pd=7.3u as=3.9294p ps=7.84u w=6.66u l=0.6u
X4496 vddr adc8b_0.side_cap8b_0.in_l_sw[3] adc8b_0.side_cap8b_0.buf_8_1.z vddr sg13_lv_pmos ad=0.19p pd=1.38u as=0.19p ps=1.38u w=1u l=0.13u
X4497 a_70096_99454# adc8b_0.diff_bsw_0.single_bsw_0.sg13cmos5l_inv_1$1_0.A sg13cmos5l_Corner_1.vss sg13cmos5l_Corner_1.vss sg13_lv_nmos ad=0.442p pd=3.28u as=0.442p ps=3.28u w=1.3u l=0.4u
X4498 adc8b_0.cmp_0.outn adc8b_0.cmp_0.clk vdd vdd sg13_lv_pmos ad=0.17p pd=1.68u as=95f ps=0.88u w=0.5u l=0.13u
X4499 vdd a_96351_96930# a_96482_96936# vdd sg13_lv_pmos ad=1.28962p pd=8.195u as=0.2856p ps=2.36u w=0.84u l=0.13u
X4500 sg13cmos5l_Corner_1.iovdd a_70044_42476# data[0] sg13cmos5l_Corner_1.iovdd sg13_hv_pmos ad=2.1312p pd=7.3u as=3.9294p ps=7.84u w=6.66u l=0.6u
X4501 sg13cmos5l_Corner_1.iovdd a_134044_42476# frame sg13cmos5l_Corner_1.iovdd sg13_hv_pmos ad=2.1312p pd=7.3u as=3.9294p ps=7.84u w=6.66u l=0.6u
X4502 sg13cmos5l_Corner_1.vss adc8b_0.sar12b_0.sg13cmos5l_buf_1_34.A a_86608_92824# sg13cmos5l_Corner_1.vss sg13_lv_nmos ad=0.14875p pd=1.16u as=0.187p ps=1.78u w=0.55u l=0.13u
X4503 a_90348_100034# adc8b_0.sar12b_0.sg13cmos5l_dfrbp_1_18.Q a_90254_100034# sg13cmos5l_Corner_1.vss sg13_lv_nmos ad=60.89999f pd=0.71u as=0.1428p ps=1.52u w=0.42u l=0.13u
X4504 sg13cmos5l_Corner_1.vss a_82388_98798# adc8b_0.side_cap8b_0.in_l_sw[0] sg13cmos5l_Corner_1.vss sg13_lv_nmos ad=0.14875p pd=1.16u as=0.2886p ps=2.26u w=0.74u l=0.13u
X4505 adc8b_0.side_cap8b_0.buf_16_2.z adc8b_0.side_cap8b_0.in_l_sw[1] sg13cmos5l_Corner_1.vss sg13cmos5l_Corner_1.vss sg13_lv_nmos ad=95f pd=0.88u as=95f ps=0.88u w=0.5u l=0.13u
X4506 sg13cmos5l_Corner_1.vss a_178296_86044# sg13cmos5l_IOPadAnalog_0.pad sg13cmos5l_Corner_1.vss sg13_hv_nmos ad=1.408p pd=5.04u as=2.596p ps=5.58u w=4.4u l=0.6u
X4507 a_94484_99560# adc8b_0.sar12b_0.sg13cmos5l_buf_1_79.X sg13cmos5l_Corner_1.vss sg13cmos5l_Corner_1.vss sg13_lv_nmos ad=0.187p pd=1.78u as=0.14875p ps=1.16u w=0.55u l=0.13u
X4508 a_84558_99156# a_84389_98796# a_84116_98784# vdd sg13_lv_pmos ad=0.105p pd=1.21u as=0.191p ps=1.44u w=1u l=0.13u
X4509 a_95416_100566# a_95159_100423# a_95578_100346# sg13cmos5l_Corner_1.vss sg13_lv_nmos ad=0.1428p pd=1.52u as=37.8f ps=0.6u w=0.42u l=0.13u
X4510 sg13cmos5l_Corner_1.vss adc8b_0.sar12b_0.sg13cmos5l_nor2_1_1.A a_97207_92790# sg13cmos5l_Corner_1.vss sg13_lv_nmos ad=0.14505p pd=1.15u as=0.1406p ps=1.12u w=0.74u l=0.13u
X4511 w_71686_95000# a_68824_96348# vdd sg13cmos5l_Corner_1.vss sg13_lv_nmos ad=0.442p pd=3.28u as=0.442p ps=3.28u w=1.3u l=0.13u
X4512 a_91708_95796# a_91292_96132# a_91473_95810# sg13cmos5l_Corner_1.vss sg13_lv_nmos ad=77.7f pd=0.95u as=0.2516p ps=2.16u w=0.74u l=0.13u
X4513 sg13cmos5l_Corner_1.vss a_94840_95302# a_94489_95421# sg13cmos5l_Corner_1.vss sg13_lv_nmos ad=79.8f pd=0.8u as=0.1428p ps=1.52u w=0.42u l=0.13u
X4514 sg13cmos5l_Corner_1.vss adc8b_0.side_cap8b_0.in_l_sw[0] adc8b_0.side_cap8b_0.buf_32_0.z sg13cmos5l_Corner_1.vss sg13_lv_nmos ad=95f pd=0.88u as=95f ps=0.88u w=0.5u l=0.13u
X4515 vdd adc8b_0.sar12b_0.sg13cmos5l_or2_1_0.A a_100342_96188# vdd sg13_lv_pmos ad=0.2226p pd=1.535u as=0.1596p ps=1.22u w=0.84u l=0.13u
X4516 sg13cmos5l_Corner_1.vss a_89265_94298# a_89220_94334# sg13cmos5l_Corner_1.vss sg13_lv_nmos ad=0.1428p pd=1.52u as=47.25f ps=0.645u w=0.42u l=0.13u
X4517 adc8b_0.sar12b_0.sg13cmos5l_buf_1_2.X a_97552_92824# sg13cmos5l_Corner_1.vss sg13cmos5l_Corner_1.vss sg13_lv_nmos ad=0.2886p pd=2.26u as=0.14875p ps=1.16u w=0.74u l=0.13u
X4518 adc8b_0.side_cap8b_0.in_h_sw[4] a_88336_100384# sg13cmos5l_Corner_1.vss sg13cmos5l_Corner_1.vss sg13_lv_nmos ad=0.2886p pd=2.26u as=0.14875p ps=1.16u w=0.74u l=0.13u
X4519 data[1] a_86044_42476# sg13cmos5l_Corner_1.iovdd sg13cmos5l_Corner_1.iovdd sg13_hv_pmos ad=3.9294p pd=7.84u as=2.1312p ps=7.3u w=6.66u l=0.6u
X4520 adc8b_0.sar12b_0.sg13cmos5l_nand2_1_1.A a_97148_94596# sg13cmos5l_Corner_1.vss sg13cmos5l_Corner_1.vss sg13_lv_nmos ad=0.2516p pd=2.16u as=0.1406p ps=1.12u w=0.74u l=0.13u
X4521 adc8b_0.cmp_0.sg13cmos5l_inv_1$1_0.Y adc8b_0.cmp_0.outp sg13cmos5l_Corner_1.vss sg13cmos5l_Corner_1.vss sg13_lv_nmos ad=0.2516p pd=2.16u as=0.2516p ps=2.16u w=0.74u l=0.13u
X4522 sg13cmos5l_Corner_1.vss sg13cmos5l_IOPadVdd$1_0.sg13cmos5l_Clamp_N43N43D4R$1_0.gate vdd sg13cmos5l_Corner_1.vss sg13_hv_nmos ad=1.408p pd=5.04u as=2.596p ps=5.58u w=4.4u l=0.6u
X4523 vdd sg13cmos5l_IOPadVdd$1_0.sg13cmos5l_Clamp_N43N43D4R$1_0.gate sg13cmos5l_Corner_1.vss sg13cmos5l_Corner_1.vss sg13_hv_nmos ad=2.596p pd=5.58u as=1.408p ps=5.04u w=4.4u l=0.6u
X4524 sg13cmos5l_Corner_1.vss sg13cmos5l_IOPadVdd$1_0.sg13cmos5l_RCClampInverter$1_0.in sg13cmos5l_IOPadVdd$1_0.sg13cmos5l_Clamp_N43N43D4R$1_0.gate sg13cmos5l_Corner_1.vss sg13_hv_nmos ad=1.71p pd=9.38u as=1.71p ps=9.38u w=9u l=0.5u
X4525 sg13cmos5l_Corner_1.vss a_82292_95774# adc8b_0.cmp_0.clk sg13cmos5l_Corner_1.vss sg13_lv_nmos ad=0.14875p pd=1.16u as=0.2886p ps=2.26u w=0.74u l=0.13u
X4526 frame a_134044_42476# sg13cmos5l_Corner_1.iovdd sg13cmos5l_Corner_1.iovdd sg13_hv_pmos ad=3.9294p pd=7.84u as=2.1312p ps=7.3u w=6.66u l=0.6u
X4527 sg13cmos5l_Corner_1.iovdd a_164624_70044# sg13cmos5l_IOPadAnalog_1.pad sg13cmos5l_Corner_1.iovdd sg13_hv_pmos ad=2.1312p pd=7.3u as=3.9294p ps=7.84u w=6.66u l=0.6u
X4528 vdd sg13cmos5l_IOPadVdd$1_0.sg13cmos5l_Clamp_N43N43D4R$1_0.gate sg13cmos5l_Corner_1.vss sg13cmos5l_Corner_1.vss sg13_hv_nmos ad=2.596p pd=5.58u as=1.408p ps=5.04u w=4.4u l=0.6u
X4529 vddr adc8b_0.sar12b_0.nh_sw[0] adc8b_0.side_cap8b_1.buf_32_1.z vddr sg13_lv_pmos ad=0.19p pd=1.38u as=0.34p ps=2.68u w=1u l=0.13u
X4530 a_85940_92750# adc8b_0.sar12b_0.sg13cmos5l_buf_1_38.A vdd vdd sg13_lv_pmos ad=0.2856p pd=2.36u as=0.2114p ps=1.54u w=0.84u l=0.13u
X4531 sg13cmos5l_Corner_1.vss adc8b_0.sar12b_0.sg13cmos5l_buf_1_8.X a_93424_94336# sg13cmos5l_Corner_1.vss sg13_lv_nmos ad=0.14875p pd=1.16u as=0.187p ps=1.78u w=0.55u l=0.13u
X4532 adc8b_0.side_cap8b_1.buf_16_1.z adc8b_0.sar12b_0.nl_sw[2] vddr vddr sg13_lv_pmos ad=0.19p pd=1.38u as=0.19p ps=1.38u w=1u l=0.13u
X4533 sg13cmos5l_Corner_1.vss adc8b_0.sar12b_0.nh_sw[3] adc8b_0.side_cap8b_1.buf_8_3.z sg13cmos5l_Corner_1.vss sg13_lv_nmos ad=95f pd=0.88u as=95f ps=0.88u w=0.5u l=0.13u
X4534 vdd sg13cmos5l_IOPadVdd$1_0.sg13cmos5l_Clamp_N43N43D4R$1_0.gate sg13cmos5l_Corner_1.vss sg13cmos5l_Corner_1.vss sg13_hv_nmos ad=2.596p pd=5.58u as=1.408p ps=5.04u w=4.4u l=0.6u
X4535 a_97810_98052# a_98253_98095# a_97550_98522# sg13cmos5l_Corner_1.vss sg13_lv_nmos ad=79.8f pd=0.8u as=0.1296p ps=1.52u w=0.42u l=0.13u
X4536 adc8b_0.side_cap8b_0.buf_8_0.z adc8b_0.side_cap8b_0.in_l_sw[4] vddr vddr sg13_lv_pmos ad=0.19p pd=1.38u as=0.19p ps=1.38u w=1u l=0.13u
X4537 sg13cmos5l_Corner_1.vss sg13cmos5l_IOPadVdd$1_0.sg13cmos5l_RCClampInverter$1_0.in sg13cmos5l_IOPadVdd$1_0.sg13cmos5l_Clamp_N43N43D4R$1_0.gate sg13cmos5l_Corner_1.vss sg13_hv_nmos ad=1.71p pd=9.38u as=1.71p ps=9.38u w=9u l=0.5u
X4538 adc8b_0.side_cap8b_0.buf_8_3.z adc8b_0.side_cap8b_0.in_h_sw[3] sg13cmos5l_Corner_1.vss sg13cmos5l_Corner_1.vss sg13_lv_nmos ad=95f pd=0.88u as=95f ps=0.88u w=0.5u l=0.13u
X4539 data[1] a_101776_95060# sg13cmos5l_Corner_1.vss sg13cmos5l_Corner_1.vss sg13_lv_nmos ad=0.2886p pd=2.26u as=0.14875p ps=1.16u w=0.74u l=0.13u
X4540 cko a_118044_42476# sg13cmos5l_Corner_1.iovdd sg13cmos5l_Corner_1.iovdd sg13_hv_pmos ad=3.9294p pd=7.84u as=2.1312p ps=7.3u w=6.66u l=0.6u
X4541 a_92386_94302# adc8b_0.sar12b_0.sg13cmos5l_nand2_1_0.A sg13cmos5l_Corner_1.vss sg13cmos5l_Corner_1.vss sg13_lv_nmos ad=0.1406p pd=1.12u as=0.2516p ps=2.16u w=0.74u l=0.13u
X4542 sg13cmos5l_Corner_1.iovdd a_70044_42476# data[0] sg13cmos5l_Corner_1.iovdd sg13_hv_pmos ad=2.1312p pd=7.3u as=3.9294p ps=7.84u w=6.66u l=0.6u
X4543 sg13cmos5l_Corner_1.vss a_176786_102222# dantenna l=27.78u w=1.26u
X4544 adc8b_0.side_cap8b_1.buf_8_3.z adc8b_0.sar12b_0.nh_sw[3] vddr vddr sg13_lv_pmos ad=0.19p pd=1.38u as=0.19p ps=1.38u w=1u l=0.13u
X4545 a_94748_98084# a_94335_98442# a_94680_98084# vdd sg13_lv_pmos ad=0.191p pd=1.44u as=0.105p ps=1.21u w=1u l=0.13u
X4546 a_86872_96030# adc8b_0.sar12b_0.sg13cmos5l_dfrbp_1_8.RESET_B vdd vdd sg13_lv_pmos ad=79.8f pd=0.8u as=1.2517p ps=7.955u w=0.42u l=0.13u
X4547 sg13cmos5l_IOPadAnalog_12.pad a_131639_164698# sg13cmos5l_Corner_1.iovdd sg13cmos5l_Corner_1.iovdd sg13_hv_pmos ad=3.9294p pd=7.84u as=2.1312p ps=7.3u w=6.66u l=0.6u
X4548 sg13cmos5l_Corner_1.vss adc8b_0.side_cap8b_0.in_h_sw[0] adc8b_0.side_cap8b_0.buf_32_1.z sg13cmos5l_Corner_1.vss sg13_lv_nmos ad=95f pd=0.88u as=95f ps=0.88u w=0.5u l=0.13u
X4549 vddr adc8b_0.side_cap8b_0.in_h_sw[1] adc8b_0.side_cap8b_0.buf_16_3.z vddr sg13_lv_pmos ad=0.19p pd=1.38u as=0.19p ps=1.38u w=1u l=0.13u
X4550 a_94284_97640# a_94258_97545# sg13cmos5l_Corner_1.vss sg13cmos5l_Corner_1.vss sg13_lv_nmos ad=0.2516p pd=2.16u as=0.1626p ps=1.415u w=0.74u l=0.13u
X4551 vip sg13cmos5l_Corner_1.iovdd dpantenna l=27.78u w=1.26u
X4552 sg13cmos5l_Corner_1.vss vdd sg13cmos5l_Corner_1.vss sg13cmos5l_Corner_1.vss sg13_lv_nmos ad=0.1428p pd=1.52u as=0 ps=0 w=0.42u l=1u
X4553 a_98253_98095# adc8b_0.sar12b_0.sg13cmos5l_inv_1_2.A vdd vdd sg13_lv_pmos ad=0.4088p pd=2.97u as=1.07253p ps=6.75u w=1.12u l=0.13u
X4554 sg13cmos5l_Corner_1.vss a_82774_95327# adc8b_0.sar12b_0.sg13cmos5l_dlygate4sd3_1_0.X sg13cmos5l_Corner_1.vss sg13_lv_nmos ad=0.1426p pd=1.16u as=0.2516p ps=2.16u w=0.74u l=0.13u
X4555 data[1] a_86044_42476# sg13cmos5l_Corner_1.iovdd sg13cmos5l_Corner_1.iovdd sg13_hv_pmos ad=3.9294p pd=7.84u as=2.1312p ps=7.3u w=6.66u l=0.6u
X4556 sg13cmos5l_Corner_1.iovdd a_164624_70044# sg13cmos5l_IOPadAnalog_1.pad sg13cmos5l_Corner_1.iovdd sg13_hv_pmos ad=2.1312p pd=7.3u as=3.9294p ps=7.84u w=6.66u l=0.6u
X4557 sg13cmos5l_Corner_1.vss a_33862_102222# dantenna l=27.78u w=1.26u
X4558 sg13cmos5l_Corner_1.iovdd a_164624_102044# sg13cmos5l_IOPadAnalog_16.pad sg13cmos5l_Corner_1.iovdd sg13_hv_pmos ad=2.1312p pd=7.3u as=3.9294p ps=7.84u w=6.66u l=0.6u
X4559 sg13cmos5l_Corner_1.vss adc8b_0.sar12b_0.nh_sw[0] adc8b_0.side_cap8b_1.buf_32_1.z sg13cmos5l_Corner_1.vss sg13_lv_nmos ad=95f pd=0.88u as=95f ps=0.88u w=0.5u l=0.13u
X4560 a_85342_99010# a_85444_99124# sg13cmos5l_Corner_1.vss sg13cmos5l_Corner_1.vss sg13_lv_nmos ad=0.187p pd=1.78u as=0.1491p ps=1.18u w=0.55u l=0.13u
X4561 a_89649_99225# a_89292_99152# vdd vdd sg13_lv_pmos ad=63f pd=0.72u as=0.1563p ps=1.22u w=0.42u l=0.13u
X4562 vdd adc8b_0.cmp_0.sg13cmos5l_inv_1$1_0.Y a_79646_97015# vdd sg13_lv_pmos ad=0.2226p pd=1.535u as=0.1596p ps=1.22u w=0.84u l=0.13u
X4563 sg13cmos5l_Corner_1.vss a_99729_99953# a_99684_99998# sg13cmos5l_Corner_1.vss sg13_lv_nmos ad=0.1428p pd=1.52u as=47.25f ps=0.645u w=0.42u l=0.13u
X4564 a_85437_97480# a_84495_97540# a_85298_97480# sg13cmos5l_Corner_1.vss sg13_lv_nmos ad=79.8f pd=0.8u as=0.2373p ps=1.97u w=0.42u l=0.13u
X4565 a_90428_96572# a_90015_96930# a_90360_96572# vdd sg13_lv_pmos ad=0.191p pd=1.44u as=0.105p ps=1.21u w=1u l=0.13u
X4566 adc8b_0.side_cap8b_1.buf_2_2.z adc8b_0.sar12b_0.nl_sw[9] sg13cmos5l_Corner_1.vss sg13cmos5l_Corner_1.vss sg13_lv_nmos ad=0.17p pd=1.68u as=95f ps=0.88u w=0.5u l=0.13u
X4567 vdd sg13cmos5l_Corner_1.vss vdd vdd sg13_lv_pmos ad=0.19p pd=1.38u as=0 ps=0 w=1u l=1u
X4568 sg13cmos5l_Corner_1.iovdd a_102044_42476# data[2] sg13cmos5l_Corner_1.iovdd sg13_hv_pmos ad=2.1312p pd=7.3u as=3.9294p ps=7.84u w=6.66u l=0.6u
X4569 sg13cmos5l_Corner_1.vss adc8b_0.sar12b_0.sg13cmos5l_buf_1_8.A a_92656_92824# sg13cmos5l_Corner_1.vss sg13_lv_nmos ad=0.14875p pd=1.16u as=0.187p ps=1.78u w=0.55u l=0.13u
X4570 a_98900_100310# adc8b_0.sar12b_0.sg13cmos5l_buf_1_94.X sg13cmos5l_Corner_1.vss sg13cmos5l_Corner_1.vss sg13_lv_nmos ad=0.187p pd=1.78u as=0.14875p ps=1.16u w=0.55u l=0.13u
X4571 a_90553_97314# a_90001_97376# sg13cmos5l_Corner_1.vss sg13cmos5l_Corner_1.vss sg13_lv_nmos ad=71.99999f pd=0.865u as=1.97045p ps=12.335u w=0.64u l=0.13u
X4572 a_90620_97644# a_90338_97332# a_90553_97314# sg13cmos5l_Corner_1.vss sg13_lv_nmos ad=0.141p pd=1.17u as=71.99999f ps=0.865u w=0.64u l=0.13u
X4573 data[0] a_70044_42476# sg13cmos5l_Corner_1.iovdd sg13cmos5l_Corner_1.iovdd sg13_hv_pmos ad=3.9294p pd=7.84u as=2.1312p ps=7.3u w=6.66u l=0.6u
X4574 a_89518_98847# adc8b_0.sar12b_0.sg13cmos5l_dfrbp_1_6.RESET_B sg13cmos5l_Corner_1.vss sg13cmos5l_Corner_1.vss sg13_lv_nmos ad=37.8f pd=0.6u as=0.1701p ps=1.65u w=0.42u l=0.13u
X4575 a_82190_97010# adc8b_0.sar12b_0.sg13cmos5l_dfrbp_1_6.D vdd vdd sg13_lv_pmos ad=79.8f pd=0.8u as=0.1428p ps=1.52u w=0.42u l=0.13u
X4576 vdd adc8b_0.sar12b_0.sg13cmos5l_nand2_1_1.B a_91591_93524# vdd sg13_lv_pmos ad=0.3808p pd=2.92u as=0.2744p ps=1.61u w=1.12u l=0.13u
X4577 a_98340_95421# a_98471_95031# a_97589_95024# vdd sg13_lv_pmos ad=0.34p pd=2.68u as=0.2048p ps=1.63u w=1u l=0.13u
X4578 sg13cmos5l_Corner_1.vss sg13cmos5l_IOPadVdd$1_0.sg13cmos5l_Clamp_N43N43D4R$1_0.gate vdd sg13cmos5l_Corner_1.vss sg13_hv_nmos ad=1.408p pd=5.04u as=2.596p ps=5.58u w=4.4u l=0.6u
X4579 sg13cmos5l_Corner_1.vss adc8b_0.side_cap8b_0.in_l_sw[7] adc8b_0.side_cap8b_0.buf_4_0.z sg13cmos5l_Corner_1.vss sg13_lv_nmos ad=95f pd=0.88u as=0.17p ps=1.68u w=0.5u l=0.13u
X4580 adc8b_0.sar12b_0.sg13cmos5l_a22oi_1_0.B1 adc8b_0.sar12b_0.sg13cmos5l_nand2_1_0.A vdd vdd sg13_lv_pmos ad=0.2128p pd=1.5u as=0.3808p ps=2.92u w=1.12u l=0.13u
X4581 vip a_30676_102044# sg13cmos5l_Corner_1.vss sg13cmos5l_Corner_1.vss sg13_hv_nmos ad=2.596p pd=5.58u as=2.068p ps=9.74u w=4.4u l=0.6u
X4582 a_87374_94736# a_86978_94308# a_87260_94620# vdd sg13_lv_pmos ad=0.1008p pd=0.9u as=0.191p ps=1.44u w=0.42u l=0.13u
X4583 adc8b_0.side_cap8b_1.buf_1_1.z adc8b_0.sar12b_0.nh_sw[10] vddr vddr sg13_lv_pmos ad=0.34p pd=2.68u as=0.34p ps=2.68u w=1u l=0.13u
X4584 data[2] a_102044_30676# sg13cmos5l_Corner_1.vss sg13cmos5l_Corner_1.vss sg13_hv_nmos ad=2.596p pd=5.58u as=1.408p ps=5.04u w=4.4u l=0.6u
X4585 adc8b_0.side_cap8b_0.buf_32_0.z adc8b_0.side_cap8b_0.in_l_sw[0] vddr vddr sg13_lv_pmos ad=0.19p pd=1.38u as=0.19p ps=1.38u w=1u l=0.13u
X4586 a_98516_100310# adc8b_0.sar12b_0.sg13cmos5l_buf_1_93.X vdd vdd sg13_lv_pmos ad=0.2856p pd=2.36u as=0.2114p ps=1.54u w=0.84u l=0.13u
X4587 a_87756_97335# a_87987_97444# a_87442_97545# sg13cmos5l_Corner_1.vss sg13_lv_nmos ad=0.2373p pd=1.97u as=79.8f ps=0.8u w=0.42u l=0.13u
X4588 a_87694_97335# adc8b_0.sar12b_0.sg13cmos5l_dfrbp_1_6.RESET_B sg13cmos5l_Corner_1.vss sg13cmos5l_Corner_1.vss sg13_lv_nmos ad=37.8f pd=0.6u as=0.1701p ps=1.65u w=0.42u l=0.13u
X4589 a_36456_134095# a_40542_133765# sg13cmos5l_Corner_1.vss rppd l=20u w=1u
X4590 sg13cmos5l_Corner_1.vss a_88148_98798# adc8b_0.side_cap8b_0.in_l_sw[3] sg13cmos5l_Corner_1.vss sg13_lv_nmos ad=0.14875p pd=1.16u as=0.2886p ps=2.26u w=0.74u l=0.13u
X4591 sg13cmos5l_Corner_1.iovdd a_164624_118044# sg13cmos5l_IOPadAnalog_11.pad sg13cmos5l_Corner_1.iovdd sg13_hv_pmos ad=2.1312p pd=7.3u as=3.9294p ps=7.84u w=6.66u l=0.6u
X4592 vip a_30676_102044# sg13cmos5l_Corner_1.vss sg13cmos5l_Corner_1.vss sg13_hv_nmos ad=2.596p pd=5.58u as=1.408p ps=5.04u w=4.4u l=0.6u
X4593 sg13cmos5l_Corner_1.vss adc8b_0.sar12b_0.sg13cmos5l_dfrbp_1_8.RESET_B a_97644_98522# sg13cmos5l_Corner_1.vss sg13_lv_nmos ad=0.1626p pd=1.415u as=60.89999f ps=0.71u w=0.42u l=0.13u
X4594 a_94701_97301# adc8b_0.sar12b_0.sg13cmos5l_dfrbp_1_23.CLK vdd vdd sg13_lv_pmos ad=0.4088p pd=2.97u as=1.04815p ps=6.595u w=1.12u l=0.13u
X4595 vdd a_94484_99560# adc8b_0.side_cap8b_0.in_h_sw[5] vdd sg13_lv_pmos ad=0.2114p pd=1.54u as=0.42p ps=2.99u w=1.12u l=0.13u
X4596 a_86615_95887# a_85773_95789# a_86521_95887# sg13cmos5l_Corner_1.vss sg13_lv_nmos ad=0.12665p pd=1.145u as=0.1428p ps=1.52u w=0.42u l=0.13u
X4597 sg13cmos5l_Corner_1.vss a_85809_93905# a_85764_93950# sg13cmos5l_Corner_1.vss sg13_lv_nmos ad=0.1428p pd=1.52u as=47.25f ps=0.645u w=0.42u l=0.13u
X4598 sg13cmos5l_Corner_1.vss adc8b_0.sar12b_0.sg13cmos5l_buf_1_68.X a_82384_100384# sg13cmos5l_Corner_1.vss sg13_lv_nmos ad=0.14875p pd=1.16u as=0.187p ps=1.78u w=0.55u l=0.13u
X4599 adc8b_0.diff_bsw_0.single_bsw_1.sg13cmos5l_inv_1$1_2.Y adc8b_0.diff_bsw_0.single_bsw_1.sg13cmos5l_inv_1$1_2.A vdd vdd sg13_lv_pmos ad=0.3808p pd=2.92u as=0.3808p ps=2.92u w=1.12u l=0.13u
X4600 sg13cmos5l_IOPadAnalog_9.pad a_83639_164698# sg13cmos5l_Corner_1.iovdd sg13cmos5l_Corner_1.iovdd sg13_hv_pmos ad=3.9294p pd=7.84u as=2.1312p ps=7.3u w=6.66u l=0.6u
X4601 adc8b_0.sar12b_0.sg13cmos5l_dfrbp_1_16.Q a_84572_98084# vdd vdd sg13_lv_pmos ad=0.3808p pd=2.92u as=0.2128p ps=1.5u w=1.12u l=0.13u
X4602 vdd a_89588_100310# adc8b_0.sar12b_0.sg13cmos5l_buf_1_73.X vdd sg13_lv_pmos ad=0.2114p pd=1.54u as=0.42p ps=2.99u w=1.12u l=0.13u
X4603 adc8b_0.sar12b_0.sg13cmos5l_a221oi_1_0.A2 a_89660_95060# vdd vdd sg13_lv_pmos ad=0.3808p pd=2.92u as=0.2128p ps=1.5u w=1.12u l=0.13u
X4604 vddr a_42476_70044# sg13cmos5l_Corner_1.iovdd sg13cmos5l_Corner_1.iovdd sg13_hv_pmos ad=3.9294p pd=7.84u as=2.1312p ps=7.3u w=6.66u l=0.6u
X4605 vdd a_96063_98442# a_96194_98448# vdd sg13_lv_pmos ad=1.07253p pd=6.75u as=0.2856p ps=2.36u w=0.84u l=0.13u
X4606 sg13cmos5l_Corner_1.vss a_88984_97542# a_88633_97399# sg13cmos5l_Corner_1.vss sg13_lv_nmos ad=79.8f pd=0.8u as=0.1428p ps=1.52u w=0.42u l=0.13u
X4607 vdd sg13cmos5l_IOPadVdd$1_0.sg13cmos5l_RCClampInverter$1_0.in sg13cmos5l_IOPadVdd$1_0.sg13cmos5l_Clamp_N43N43D4R$1_0.gate vdd sg13_hv_pmos ad=1.33p pd=7.38u as=1.33p ps=7.38u w=7u l=0.5u
X4608 adc8b_0.sar12b_0.sg13cmos5l_or2_1_0.A a_100131_95430# sg13cmos5l_Corner_1.vss sg13cmos5l_Corner_1.vss sg13_lv_nmos ad=0.1406p pd=1.12u as=0.1406p ps=1.12u w=0.74u l=0.13u
X4609 sg13cmos5l_Corner_1.iovdd a_131639_164698# sg13cmos5l_IOPadAnalog_12.pad sg13cmos5l_Corner_1.iovdd sg13_hv_pmos ad=2.1312p pd=7.3u as=3.9294p ps=7.84u w=6.66u l=0.6u
X4610 cks a_42476_118044# sg13cmos5l_Corner_1.iovdd sg13cmos5l_Corner_1.iovdd sg13_hv_pmos ad=3.9294p pd=7.84u as=3.1302p ps=14.26u w=6.66u l=0.6u
X4611 vdd a_86228_100310# adc8b_0.sar12b_0.sg13cmos5l_buf_1_60.X vdd sg13_lv_pmos ad=0.2114p pd=1.54u as=0.42p ps=2.99u w=1.12u l=0.13u
X4612 a_99864_99156# a_99313_98888# vdd vdd sg13_lv_pmos ad=0.105p pd=1.21u as=1.15047p ps=7.175u w=1u l=0.13u
X4613 a_88727_97399# a_87885_97301# a_87468_97640# vdd sg13_lv_pmos ad=0.2048p pd=1.63u as=0.34p ps=2.68u w=1u l=0.13u
X4614 sg13cmos5l_Corner_1.vss adc8b_0.sar12b_0.sg13cmos5l_buf_1_10.A adc8b_0.sar12b_0.sg13cmos5l_inv_1_28.Y sg13cmos5l_Corner_1.vss sg13_lv_nmos ad=0.2516p pd=2.16u as=0.2516p ps=2.16u w=0.74u l=0.13u
X4615 sg13cmos5l_IOPadAnalog_0.pad a_178296_86044# sg13cmos5l_Corner_1.vss sg13cmos5l_Corner_1.vss sg13_hv_nmos ad=2.596p pd=5.58u as=1.408p ps=5.04u w=4.4u l=0.6u
X4616 a_92668_98472# a_92252_98084# a_92433_98441# sg13cmos5l_Corner_1.vss sg13_lv_nmos ad=77.7f pd=0.95u as=0.2516p ps=2.16u w=0.74u l=0.13u
X4617 adc8b_0.sar12b_0.sg13cmos5l_dlhr_1_12.D a_98039_98911# vdd vdd sg13_lv_pmos ad=0.4312p pd=3.01u as=0.2639p ps=1.81u w=1.12u l=0.13u
X4618 a_88984_97542# a_88727_97399# a_89146_97322# sg13cmos5l_Corner_1.vss sg13_lv_nmos ad=0.1428p pd=1.52u as=37.8f ps=0.6u w=0.42u l=0.13u
X4619 vdd a_86900_95024# adc8b_0.sar12b_0.sg13cmos5l_buf_1_44.X vdd sg13_lv_pmos ad=0.2114p pd=1.54u as=0.42p ps=2.99u w=1.12u l=0.13u
X4620 adc8b_0.side_cap8b_1.buf_16_0.z adc8b_0.sar12b_0.nh_sw[2] sg13cmos5l_Corner_1.vss sg13cmos5l_Corner_1.vss sg13_lv_nmos ad=0.17p pd=1.68u as=95f ps=0.88u w=0.5u l=0.13u
X4621 vddr adc8b_0.sar12b_0.nl_sw[2] adc8b_0.side_cap8b_1.buf_16_1.z vddr sg13_lv_pmos ad=0.19p pd=1.38u as=0.19p ps=1.38u w=1u l=0.13u
X4622 sg13cmos5l_Corner_1.iovdd a_42476_86044# vin sg13cmos5l_Corner_1.iovdd sg13_hv_pmos ad=2.1312p pd=7.3u as=3.9294p ps=7.84u w=6.66u l=0.6u
X4623 sg13cmos5l_Corner_1.vss a_95469_94277# a_95571_94420# sg13cmos5l_Corner_1.vss sg13_lv_nmos ad=2.59257p pd=16.445u as=0.2516p ps=2.16u w=0.74u l=0.13u
X4624 adc8b_0.sar12b_0.sg13cmos5l_dlhr_1_1.D a_83735_96933# vdd vdd sg13_lv_pmos ad=0.4312p pd=3.01u as=0.2639p ps=1.81u w=1.12u l=0.13u
X4625 adc8b_0.sar12b_0.sg13cmos5l_dlhr_1_3.Q_N a_86334_93978# sg13cmos5l_Corner_1.vss sg13cmos5l_Corner_1.vss sg13_lv_nmos ad=0.2516p pd=2.16u as=0.1491p ps=1.18u w=0.74u l=0.13u
X4626 sg13cmos5l_Corner_1.vss sg13cmos5l_IOPadVdd$1_0.sg13cmos5l_Clamp_N43N43D4R$1_0.gate vdd sg13cmos5l_Corner_1.vss sg13_hv_nmos ad=1.408p pd=5.04u as=2.596p ps=5.58u w=4.4u l=0.6u
X4627 sg13cmos5l_Corner_1.iovdd a_134044_42476# frame sg13cmos5l_Corner_1.iovdd sg13_hv_pmos ad=2.1312p pd=7.3u as=3.9294p ps=7.84u w=6.66u l=0.6u
X4628 a_98721_93671# a_97779_93559# a_98519_93909# vdd sg13_lv_pmos ad=93.45f pd=0.865u as=0.2048p ps=1.63u w=0.42u l=0.13u
X4629 sg13cmos5l_IOPadAnalog_12.pad a_131639_164698# sg13cmos5l_Corner_1.iovdd sg13cmos5l_Corner_1.iovdd sg13_hv_pmos ad=3.9294p pd=7.84u as=3.1302p ps=14.26u w=6.66u l=0.6u
X4630 sg13cmos5l_IOPadAnalog_13.pad a_115639_164698# sg13cmos5l_Corner_1.iovdd sg13cmos5l_Corner_1.iovdd sg13_hv_pmos ad=3.9294p pd=7.84u as=2.1312p ps=7.3u w=6.66u l=0.6u
X4631 sg13cmos5l_Corner_1.vss a_85432_99838# a_85081_99957# sg13cmos5l_Corner_1.vss sg13_lv_nmos ad=79.8f pd=0.8u as=0.1428p ps=1.52u w=0.42u l=0.13u
X4632 vdd sg13cmos5l_Corner_1.vss vdd vdd sg13_lv_pmos ad=0.34p pd=2.68u as=0 ps=0 w=1u l=1u
X4633 adc8b_0.side_cap8b_1.buf_32_0.z adc8b_0.sar12b_0.nl_sw[0] sg13cmos5l_Corner_1.vss sg13cmos5l_Corner_1.vss sg13_lv_nmos ad=95f pd=0.88u as=95f ps=0.88u w=0.5u l=0.13u
X4634 vdd a_88557_95789# a_88659_95932# vdd sg13_lv_pmos ad=1.28962p pd=8.195u as=0.3864p ps=2.93u w=1.12u l=0.13u
X4635 sg13cmos5l_Corner_1.iovdd a_42476_118044# cks sg13cmos5l_Corner_1.iovdd sg13_hv_pmos ad=2.1312p pd=7.3u as=3.9294p ps=7.84u w=6.66u l=0.6u
X4636 adc8b_0.side_cap8b_0.buf_32_1.z adc8b_0.side_cap8b_0.in_h_sw[0] sg13cmos5l_Corner_1.vss sg13cmos5l_Corner_1.vss sg13_lv_nmos ad=95f pd=0.88u as=95f ps=0.88u w=0.5u l=0.13u
X4637 frame a_134044_30676# sg13cmos5l_Corner_1.vss sg13cmos5l_Corner_1.vss sg13_hv_nmos ad=2.596p pd=5.58u as=1.408p ps=5.04u w=4.4u l=0.6u
X4638 adc8b_0.side_cap8b_0.buf_8_5.z adc8b_0.side_cap8b_0.in_h_sw[5] vddr vddr sg13_lv_pmos ad=0.19p pd=1.38u as=0.19p ps=1.38u w=1u l=0.13u
X4639 vdd a_98900_100310# adc8b_0.side_cap8b_0.in_h_sw[7] vdd sg13_lv_pmos ad=0.2114p pd=1.54u as=0.42p ps=2.99u w=1.12u l=0.13u
X4640 vdd adc8b_0.sar12b_0.sg13cmos5l_buf_1_61.X a_82768_100384# vdd sg13_lv_pmos ad=0.2114p pd=1.54u as=0.2856p ps=2.36u w=0.84u l=0.13u
X4641 vdd sg13cmos5l_IOPadVdd$1_0.sg13cmos5l_Clamp_N43N43D4R$1_0.gate sg13cmos5l_Corner_1.vss sg13cmos5l_Corner_1.vss sg13_hv_nmos ad=2.596p pd=5.58u as=1.408p ps=5.04u w=4.4u l=0.6u
X4642 a_95278_94311# adc8b_0.sar12b_0.sg13cmos5l_dfrbp_1_0.RESET_B sg13cmos5l_Corner_1.vss sg13cmos5l_Corner_1.vss sg13_lv_nmos ad=37.8f pd=0.6u as=0.1701p ps=1.65u w=0.42u l=0.13u
X4643 a_94844_96536# adc8b_0.sar12b_0.sg13cmos5l_inv_1_0.A vdd vdd sg13_lv_pmos ad=0.2856p pd=2.36u as=0.2618p ps=1.63u w=0.84u l=0.13u
X4644 a_100131_95430# adc8b_0.sar12b_0.sg13cmos5l_buf_8_1.A sg13cmos5l_Corner_1.vss sg13cmos5l_Corner_1.vss sg13_lv_nmos ad=0.1406p pd=1.12u as=0.1406p ps=1.12u w=0.74u l=0.13u
X4645 a_93550_92799# adc8b_0.sar12b_0.sg13cmos5l_dfrbp_1_0.RESET_B sg13cmos5l_Corner_1.vss sg13cmos5l_Corner_1.vss sg13_lv_nmos ad=37.8f pd=0.6u as=0.1701p ps=1.65u w=0.42u l=0.13u
X4646 vdd sg13cmos5l_IOPadVdd$1_0.sg13cmos5l_Clamp_N43N43D4R$1_0.gate sg13cmos5l_Corner_1.vss sg13cmos5l_Corner_1.vss sg13_hv_nmos ad=2.596p pd=5.58u as=1.408p ps=5.04u w=4.4u l=0.6u
X4647 vddr adc8b_0.side_cap8b_0.in_h_sw[0] adc8b_0.side_cap8b_0.buf_32_1.z vddr sg13_lv_pmos ad=0.19p pd=1.38u as=0.19p ps=1.38u w=1u l=0.13u
X4648 sg13cmos5l_Corner_1.vss adc8b_0.side_cap8b_0.in_l_sw[5] adc8b_0.side_cap8b_0.buf_8_4.z sg13cmos5l_Corner_1.vss sg13_lv_nmos ad=95f pd=0.88u as=95f ps=0.88u w=0.5u l=0.13u
X4649 a_92493_98813# adc8b_0.sar12b_0.sg13cmos5l_dlhr_1_11.GATE vdd vdd sg13_lv_pmos ad=0.4088p pd=2.97u as=1.12242p ps=7u w=1.12u l=0.13u
X4650 sg13cmos5l_IOPadAnalog_11.pad a_164624_118044# sg13cmos5l_Corner_1.iovdd sg13cmos5l_Corner_1.iovdd sg13_hv_pmos ad=3.9294p pd=7.84u as=2.1312p ps=7.3u w=6.66u l=0.6u
X4651 adc8b_0.side_cap8b_0.buf_8_1.z adc8b_0.side_cap8b_0.in_l_sw[3] sg13cmos5l_Corner_1.vss sg13cmos5l_Corner_1.vss sg13_lv_nmos ad=95f pd=0.88u as=95f ps=0.88u w=0.5u l=0.13u
X4652 vdd a_85175_99957# a_86012_99596# vdd sg13_lv_pmos ad=0.2128p pd=1.5u as=0.3864p ps=2.93u w=1.12u l=0.13u
X4653 vdd sg13cmos5l_Corner_1.vss vdd vdd sg13_lv_pmos ad=0.34p pd=2.68u as=0 ps=0 w=1u l=1u
X4654 sg13cmos5l_Corner_1.vss adc8b_0.sar12b_0.nh_sw[5] adc8b_0.side_cap8b_1.buf_8_5.z sg13cmos5l_Corner_1.vss sg13_lv_nmos ad=95f pd=0.88u as=95f ps=0.88u w=0.5u l=0.13u
X4655 a_98938_93986# adc8b_0.sar12b_0.sg13cmos5l_dfrbp_1_0.RESET_B sg13cmos5l_Corner_1.vss sg13cmos5l_Corner_1.vss sg13_lv_nmos ad=37.8f pd=0.6u as=79.8f ps=0.8u w=0.42u l=0.13u
X4656 adc8b_0.sar12b_0.sg13cmos5l_buf_1_90.X a_93232_100384# vdd vdd sg13_lv_pmos ad=0.42p pd=2.99u as=0.2114p ps=1.54u w=1.12u l=0.13u
X4657 sg13cmos5l_Corner_1.vss a_90225_98441# a_90750_98514# sg13cmos5l_Corner_1.vss sg13_lv_nmos ad=0.1491p pd=1.18u as=0.187p ps=1.78u w=0.55u l=0.13u
X4658 sg13cmos5l_Corner_1.iovdd a_86044_42476# data[1] sg13cmos5l_Corner_1.iovdd sg13_hv_pmos ad=2.1312p pd=7.3u as=3.9294p ps=7.84u w=6.66u l=0.6u
X4659 vddr adc8b_0.sar12b_0.nl_sw[0] adc8b_0.side_cap8b_1.buf_32_0.z vddr sg13_lv_pmos ad=0.19p pd=1.38u as=0.19p ps=1.38u w=1u l=0.13u
X4660 sg13cmos5l_Corner_1.vss adc8b_0.sar12b_0.sg13cmos5l_buf_1_28.A a_91216_92824# sg13cmos5l_Corner_1.vss sg13_lv_nmos ad=0.14875p pd=1.16u as=0.187p ps=1.78u w=0.55u l=0.13u
X4661 vdd a_85215_93906# a_85346_93912# vdd sg13_lv_pmos ad=1.86162p pd=11.935u as=0.2856p ps=2.36u w=0.84u l=0.13u
X4662 a_89080_95302# a_88823_95421# a_89242_95498# sg13cmos5l_Corner_1.vss sg13_lv_nmos ad=0.1428p pd=1.52u as=37.8f ps=0.6u w=0.42u l=0.13u
X4663 adc8b_0.sar12b_0.sg13cmos5l_a22oi_1_0.Y adc8b_0.sar12b_0.sg13cmos5l_inv_1_0.A a_92551_95452# sg13cmos5l_Corner_1.vss sg13_lv_nmos ad=0.2664p pd=1.46u as=0.13875p ps=1.115u w=0.74u l=0.13u
X4664 sg13cmos5l_IOPadAnalog_11.pad a_178296_118044# sg13cmos5l_Corner_1.vss sg13cmos5l_Corner_1.vss sg13_hv_nmos ad=2.596p pd=5.58u as=2.068p ps=9.74u w=4.4u l=0.6u
X4665 sg13cmos5l_Corner_1.vss a_85437_97480# a_84516_97286# sg13cmos5l_Corner_1.vss sg13_lv_nmos ad=0.1626p pd=1.415u as=0.2516p ps=2.16u w=0.74u l=0.13u
X4666 sg13cmos5l_Corner_1.vss a_178296_70044# sg13cmos5l_IOPadAnalog_1.pad sg13cmos5l_Corner_1.vss sg13_hv_nmos ad=1.408p pd=5.04u as=2.596p ps=5.58u w=4.4u l=0.6u
X4667 sg13cmos5l_Corner_1.vss a_140462_57198# dantenna l=3.1u w=0.64u
X4668 adc8b_0.sar12b_0.sg13cmos5l_dfrbp_1_25.Q_N a_97655_99957# sg13cmos5l_Corner_1.vss sg13cmos5l_Corner_1.vss sg13_lv_nmos ad=0.2849p pd=2.25u as=0.2516p ps=2.16u w=0.74u l=0.13u
X4669 sg13cmos5l_Corner_1.iovdd a_118044_42476# cko sg13cmos5l_Corner_1.iovdd sg13_hv_pmos ad=2.1312p pd=7.3u as=3.9294p ps=7.84u w=6.66u l=0.6u
X4670 sg13cmos5l_Corner_1.iovdd a_42476_102044# vip sg13cmos5l_Corner_1.iovdd sg13_hv_pmos ad=2.1312p pd=7.3u as=3.9294p ps=7.84u w=6.66u l=0.6u
X4671 data[2] a_102044_42476# sg13cmos5l_Corner_1.iovdd sg13cmos5l_Corner_1.iovdd sg13_hv_pmos ad=3.9294p pd=7.84u as=2.1312p ps=7.3u w=6.66u l=0.6u
X4672 a_89457_92786# a_89276_93108# vdd vdd sg13_lv_pmos ad=0.2128p pd=1.5u as=0.2387p ps=1.84u w=1.12u l=0.13u
X4673 a_97655_99957# a_96813_99607# a_97561_99957# sg13cmos5l_Corner_1.vss sg13_lv_nmos ad=0.12665p pd=1.145u as=0.1428p ps=1.52u w=0.42u l=0.13u
X4674 adc8b_0.sar12b_0.sg13cmos5l_dfrbp_1_16.Q a_84572_98084# sg13cmos5l_Corner_1.vss sg13cmos5l_Corner_1.vss sg13_lv_nmos ad=0.2516p pd=2.16u as=0.1406p ps=1.12u w=0.74u l=0.13u
X4675 vdd adc8b_0.cmp_0.sg13cmos5l_dlygate4sd3_1$1_0.A a_80424_96641# vdd sg13_lv_pmos ad=0.1523p pd=1.38u as=0.1428p ps=1.52u w=0.42u l=0.13u
X4676 adc8b_0.sar12b_0.sg13cmos5l_dlhr_1_1.Q_N a_84702_95792# vdd vdd sg13_lv_pmos ad=0.3808p pd=2.92u as=0.1974p ps=1.5u w=1.12u l=0.13u
X4677 sg13cmos5l_Corner_1.iovdd a_70044_42476# data[0] sg13cmos5l_Corner_1.iovdd sg13_hv_pmos ad=2.1312p pd=7.3u as=3.9294p ps=7.84u w=6.66u l=0.6u
X4678 vddr adc8b_0.sar12b_0.nl_sw[7] adc8b_0.side_cap8b_1.buf_4_0.z vddr sg13_lv_pmos ad=0.19p pd=1.38u as=0.34p ps=2.68u w=1u l=0.13u
X4679 a_96351_96930# adc8b_0.sar12b_0.sg13cmos5l_dfrbp_1_23.CLK vdd vdd sg13_lv_pmos ad=0.3234p pd=2.45u as=1.28962p ps=8.195u w=0.84u l=0.13u
X4680 adc8b_0.sar12b_0.sg13cmos5l_a221oi_1_0.A2 a_89660_95060# sg13cmos5l_Corner_1.vss sg13cmos5l_Corner_1.vss sg13_lv_nmos ad=0.2516p pd=2.16u as=0.1406p ps=1.12u w=0.74u l=0.13u
X4681 adc8b_0.side_cap8b_0.buf_16_2.z adc8b_0.side_cap8b_0.in_l_sw[1] sg13cmos5l_Corner_1.vss sg13cmos5l_Corner_1.vss sg13_lv_nmos ad=95f pd=0.88u as=95f ps=0.88u w=0.5u l=0.13u
X4682 vdd sg13cmos5l_Corner_1.vss vdd vdd sg13_lv_pmos ad=0.34p pd=2.68u as=0 ps=0 w=1u l=1u
X4683 sg13cmos5l_Corner_1.iovdd a_164624_118044# sg13cmos5l_IOPadAnalog_11.pad sg13cmos5l_Corner_1.iovdd sg13_hv_pmos ad=2.1312p pd=7.3u as=3.9294p ps=7.84u w=6.66u l=0.6u
X4684 adc8b_0.sar12b_0.sg13cmos5l_o21ai_1_0.A1 adc8b_0.sar12b_0.sg13cmos5l_a221oi_1_0.C1 a_93162_96108# vdd sg13_lv_pmos ad=0.3808p pd=2.92u as=0.2128p ps=1.5u w=1.12u l=0.13u
X4685 sg13cmos5l_IOPadAnalog_13.pad a_115639_178370# sg13cmos5l_Corner_1.vss sg13cmos5l_Corner_1.vss sg13_hv_nmos ad=2.596p pd=5.58u as=1.408p ps=5.04u w=4.4u l=0.6u
X4686 sg13cmos5l_IOPadAnalog_9.pad a_83639_164698# sg13cmos5l_Corner_1.iovdd sg13cmos5l_Corner_1.iovdd sg13_hv_pmos ad=3.9294p pd=7.84u as=2.1312p ps=7.3u w=6.66u l=0.6u
X4687 a_85773_95789# adc8b_0.sar12b_0.sg13cmos5l_inv_1_8.A vdd vdd sg13_lv_pmos ad=0.4088p pd=2.97u as=1.2517p ps=7.955u w=1.12u l=0.13u
X4688 frame a_134044_42476# sg13cmos5l_Corner_1.iovdd sg13cmos5l_Corner_1.iovdd sg13_hv_pmos ad=3.9294p pd=7.84u as=2.1312p ps=7.3u w=6.66u l=0.6u
X4689 sg13cmos5l_Corner_1.vss a_86044_30676# data[1] sg13cmos5l_Corner_1.vss sg13_hv_nmos ad=1.408p pd=5.04u as=2.596p ps=5.58u w=4.4u l=0.6u
X4690 sg13cmos5l_IOPadAnalog_12.pad a_131639_178370# sg13cmos5l_Corner_1.vss sg13cmos5l_Corner_1.vss sg13_hv_nmos ad=2.596p pd=5.58u as=1.408p ps=5.04u w=4.4u l=0.6u
X4691 data[0] a_70044_30676# sg13cmos5l_Corner_1.vss sg13cmos5l_Corner_1.vss sg13_hv_nmos ad=2.596p pd=5.58u as=1.408p ps=5.04u w=4.4u l=0.6u
X4692 sg13cmos5l_Corner_1.vss a_178296_118044# sg13cmos5l_IOPadAnalog_11.pad sg13cmos5l_Corner_1.vss sg13_hv_nmos ad=1.408p pd=5.04u as=2.596p ps=5.58u w=4.4u l=0.6u
X4693 adc8b_0.side_cap8b_1.buf_8_0.z adc8b_0.sar12b_0.nl_sw[4] sg13cmos5l_Corner_1.vss sg13cmos5l_Corner_1.vss sg13_lv_nmos ad=0.17p pd=1.68u as=95f ps=0.88u w=0.5u l=0.13u
X4694 a_93298_93009# a_93741_92765# a_93681_93177# vdd sg13_lv_pmos ad=79.8f pd=0.8u as=63f ps=0.72u w=0.42u l=0.13u
X4695 vddr adc8b_0.side_cap8b_0.in_l_sw[2] adc8b_0.side_cap8b_0.buf_16_1.z vddr sg13_lv_pmos ad=0.19p pd=1.38u as=0.19p ps=1.38u w=1u l=0.13u
X4696 sg13cmos5l_Corner_1.vss adc8b_0.cmp_0.rdy a_82192_99596# sg13cmos5l_Corner_1.vss sg13_lv_nmos ad=0.14875p pd=1.16u as=0.187p ps=1.78u w=0.55u l=0.13u
X4697 vdd sg13cmos5l_Corner_1.vss vdd vdd sg13_lv_pmos ad=0.34p pd=2.68u as=0 ps=0 w=1u l=1u
X4698 a_87756_99600# a_87730_99564# sg13cmos5l_Corner_1.vss sg13cmos5l_Corner_1.vss sg13_lv_nmos ad=0.2516p pd=2.16u as=0.1626p ps=1.415u w=0.74u l=0.13u
X4699 a_90808_99054# a_90551_98911# a_90970_98834# sg13cmos5l_Corner_1.vss sg13_lv_nmos ad=0.1428p pd=1.52u as=37.8f ps=0.6u w=0.42u l=0.13u
X4700 adc8b_0.sar12b_0.sg13cmos5l_buf_1_40.X a_82960_92824# sg13cmos5l_Corner_1.vss sg13cmos5l_Corner_1.vss sg13_lv_nmos ad=0.2886p pd=2.26u as=0.14875p ps=1.16u w=0.74u l=0.13u
X4701 sg13cmos5l_Corner_1.iovdd a_115639_164698# sg13cmos5l_IOPadAnalog_13.pad sg13cmos5l_Corner_1.iovdd sg13_hv_pmos ad=2.1312p pd=7.3u as=3.9294p ps=7.84u w=6.66u l=0.6u
X4702 sg13cmos5l_Corner_1.iovdd a_42476_102044# vip sg13cmos5l_Corner_1.iovdd sg13_hv_pmos ad=2.1312p pd=7.3u as=3.9294p ps=7.84u w=6.66u l=0.6u
X4703 adc8b_0.side_cap8b_1.buf_8_4.z adc8b_0.sar12b_0.nl_sw[5] vddr vddr sg13_lv_pmos ad=0.19p pd=1.38u as=0.19p ps=1.38u w=1u l=0.13u
X4704 sg13cmos5l_Corner_1.iovdd a_131639_164698# sg13cmos5l_IOPadAnalog_12.pad sg13cmos5l_Corner_1.iovdd sg13_hv_pmos ad=2.1312p pd=7.3u as=3.9294p ps=7.84u w=6.66u l=0.6u
X4705 sg13cmos5l_Corner_1.vss adc8b_0.sar12b_0.sg13cmos5l_dfrbp_1_8.RESET_B a_87948_95810# sg13cmos5l_Corner_1.vss sg13_lv_nmos ad=0.1626p pd=1.415u as=60.89999f ps=0.71u w=0.42u l=0.13u
X4706 sg13cmos5l_Corner_1.vss a_108462_57198# dantenna l=3.1u w=0.64u
X4707 adc8b_0.diff_bsw_0.single_bsw_1.sg13cmos5l_inv_1$1_0.Y adc8b_0.diff_bsw_0.single_bsw_1.sg13cmos5l_inv_1$1_0.A sg13cmos5l_Corner_1.vss sg13cmos5l_Corner_1.vss sg13_lv_nmos ad=0.2516p pd=2.16u as=0.2516p ps=2.16u w=0.74u l=0.13u
X4708 sg13cmos5l_Corner_1.vss adc8b_0.sar12b_0.sg13cmos5l_dfrbp_1_6.RESET_B a_84412_95796# sg13cmos5l_Corner_1.vss sg13_lv_nmos ad=0.1406p pd=1.12u as=77.7f ps=0.95u w=0.74u l=0.13u
X4709 sg13cmos5l_Corner_1.vss a_86900_95024# adc8b_0.sar12b_0.sg13cmos5l_buf_1_44.X sg13cmos5l_Corner_1.vss sg13_lv_nmos ad=0.14875p pd=1.16u as=0.2886p ps=2.26u w=0.74u l=0.13u
X4710 sg13cmos5l_Corner_1.vss a_83992_96814# a_83641_96933# sg13cmos5l_Corner_1.vss sg13_lv_nmos ad=79.8f pd=0.8u as=0.1428p ps=1.52u w=0.42u l=0.13u
X4711 adc8b_0.sar12b_0.sg13cmos5l_dlhr_1_1.D a_83735_96933# sg13cmos5l_Corner_1.vss sg13cmos5l_Corner_1.vss sg13_lv_nmos ad=0.2849p pd=2.25u as=0.2516p ps=2.16u w=0.74u l=0.13u
X4712 adc8b_0.side_cap8b_1.buf_2_3.z adc8b_0.sar12b_0.nh_sw[9] vddr vddr sg13_lv_pmos ad=0.34p pd=2.68u as=0.19p ps=1.38u w=1u l=0.13u
X4713 vdd sg13cmos5l_IOPadVdd$1_0.sg13cmos5l_Clamp_N43N43D4R$1_0.gate sg13cmos5l_Corner_1.vss sg13cmos5l_Corner_1.vss sg13_hv_nmos ad=2.596p pd=5.58u as=1.408p ps=5.04u w=4.4u l=0.6u
X4714 vdd a_83583_95826# a_83714_95820# vdd sg13_lv_pmos ad=1.28962p pd=8.195u as=0.2856p ps=2.36u w=0.84u l=0.13u
X4715 adc8b_0.sar12b_0.sg13cmos5l_dlhr_1_2.D a_88247_93909# vdd vdd sg13_lv_pmos ad=0.4312p pd=3.01u as=0.2639p ps=1.81u w=1.12u l=0.13u
X4716 a_83937_98207# a_82995_98095# a_83735_98445# vdd sg13_lv_pmos ad=93.45f pd=0.865u as=0.2048p ps=1.63u w=0.42u l=0.13u
X4717 adc8b_0.side_cap8b_1.buf_16_1.z adc8b_0.sar12b_0.nl_sw[2] vddr vddr sg13_lv_pmos ad=0.19p pd=1.38u as=0.19p ps=1.38u w=1u l=0.13u
X4718 sg13cmos5l_Corner_1.vss a_99597_92765# a_99699_92908# sg13cmos5l_Corner_1.vss sg13_lv_nmos ad=7.01497p pd=46.005u as=0.2516p ps=2.16u w=0.74u l=0.13u
X4719 a_83252_100310# adc8b_0.sar12b_0.sg13cmos5l_inv_1_19.A vdd vdd sg13_lv_pmos ad=0.2856p pd=2.36u as=0.2114p ps=1.54u w=0.84u l=0.13u
X4720 adc8b_0.sar12b_0.sg13cmos5l_dlhr_1_15.Q_N a_100638_98816# sg13cmos5l_Corner_1.vss sg13cmos5l_Corner_1.vss sg13_lv_nmos ad=0.2516p pd=2.16u as=0.1491p ps=1.18u w=0.74u l=0.13u
X4721 adc8b_0.sar12b_0.sg13cmos5l_buf_1_59.A a_86193_98441# vdd vdd sg13_lv_pmos ad=0.3808p pd=2.92u as=0.2128p ps=1.5u w=1.12u l=0.13u
X4722 vdd a_89265_94298# a_89198_94736# vdd sg13_lv_pmos ad=0.2387p pd=1.84u as=0.1008p ps=0.9u w=0.42u l=0.13u
X4723 sg13cmos5l_Corner_1.vss adc8b_0.sar12b_0.nh_sw[2] adc8b_0.side_cap8b_1.buf_16_0.z sg13cmos5l_Corner_1.vss sg13_lv_nmos ad=95f pd=0.88u as=95f ps=0.88u w=0.5u l=0.13u
X4724 sg13cmos5l_Corner_1.iovdd a_164624_102044# sg13cmos5l_IOPadAnalog_16.pad sg13cmos5l_Corner_1.iovdd sg13_hv_pmos ad=3.1302p pd=14.26u as=3.9294p ps=7.84u w=6.66u l=0.6u
X4725 vddr adc8b_0.side_cap8b_0.in_l_sw[8] adc8b_0.side_cap8b_0.buf_2_1.z vddr sg13_lv_pmos ad=0.19p pd=1.38u as=0.34p ps=2.68u w=1u l=0.13u
X4726 a_83992_96814# a_83735_96933# a_84154_97010# sg13cmos5l_Corner_1.vss sg13_lv_nmos ad=0.1428p pd=1.52u as=37.8f ps=0.6u w=0.42u l=0.13u
X4727 a_84406_97637# a_84148_97322# vdd vdd sg13_lv_pmos ad=93.45f pd=0.865u as=1.07253p ps=6.75u w=0.42u l=0.13u
X4728 vdd adc8b_0.sar12b_0.sg13cmos5l_inv_1_0.Y a_92950_96108# vdd sg13_lv_pmos ad=0.3808p pd=2.92u as=0.2128p ps=1.5u w=1.12u l=0.13u
X4729 a_83170_95024# adc8b_0.sar12b_0.sg13cmos5l_dlygate4sd2_1_0.X sg13cmos5l_Corner_1.vss sg13cmos5l_Corner_1.vss sg13_lv_nmos ad=0.1428p pd=1.52u as=79.8f ps=0.8u w=0.42u l=0.13u
X4730 sg13cmos5l_Corner_1.vss a_85444_99124# adc8b_0.sar12b_0.sg13cmos5l_dlhr_1_9.Q sg13cmos5l_Corner_1.vss sg13_lv_nmos ad=0.1406p pd=1.12u as=0.2516p ps=2.16u w=0.74u l=0.13u
X4731 sg13cmos5l_Corner_1.vss a_178296_102044# sg13cmos5l_IOPadAnalog_16.pad sg13cmos5l_Corner_1.vss sg13_hv_nmos ad=1.408p pd=5.04u as=2.596p ps=5.58u w=4.4u l=0.6u
X4732 a_88509_96619# a_87567_96659# a_88370_96852# sg13cmos5l_Corner_1.vss sg13_lv_nmos ad=79.8f pd=0.8u as=0.2373p ps=1.97u w=0.42u l=0.13u
X4733 vdd adc8b_0.sar12b_0.sg13cmos5l_dfrbp_1_6.RESET_B a_92241_100346# vdd sg13_lv_pmos ad=0.2128p pd=1.5u as=0.2128p ps=1.5u w=1.12u l=0.13u
X4734 sg13cmos5l_Corner_1.iovdd a_99639_164698# sg13cmos5l_IOPadAnalog_15.pad sg13cmos5l_Corner_1.iovdd sg13_hv_pmos ad=2.1312p pd=7.3u as=3.9294p ps=7.84u w=6.66u l=0.6u
X4735 a_85944_98084# a_85393_98442# vdd vdd sg13_lv_pmos ad=0.105p pd=1.21u as=1.07253p ps=6.75u w=1u l=0.13u
X4736 sg13cmos5l_Corner_1.vss a_92433_98441# a_92958_98514# sg13cmos5l_Corner_1.vss sg13_lv_nmos ad=0.1491p pd=1.18u as=0.187p ps=1.78u w=0.55u l=0.13u
X4737 adc8b_0.side_cap8b_1.buf_32_0.z adc8b_0.sar12b_0.nl_sw[0] vddr vddr sg13_lv_pmos ad=0.34p pd=2.68u as=0.19p ps=1.38u w=1u l=0.13u
X4738 vdd a_88509_96619# a_87588_96933# vdd sg13_lv_pmos ad=0.36237p pd=2.605u as=0.34p ps=2.68u w=1u l=0.13u
X4739 data[0] a_70044_42476# sg13cmos5l_Corner_1.iovdd sg13cmos5l_Corner_1.iovdd sg13_hv_pmos ad=3.9294p pd=7.84u as=2.1312p ps=7.3u w=6.66u l=0.6u
X4740 frame a_134044_42476# sg13cmos5l_Corner_1.iovdd sg13cmos5l_Corner_1.iovdd sg13_hv_pmos ad=3.9294p pd=7.84u as=2.1312p ps=7.3u w=6.66u l=0.6u
X4741 vin a_42476_86044# sg13cmos5l_Corner_1.iovdd sg13cmos5l_Corner_1.iovdd sg13_hv_pmos ad=3.9294p pd=7.84u as=2.1312p ps=7.3u w=6.66u l=0.6u
X4742 a_87756_97335# a_87468_97640# a_87694_97335# sg13cmos5l_Corner_1.vss sg13_lv_nmos ad=0.1428p pd=1.52u as=37.8f ps=0.6u w=0.42u l=0.13u
X4743 vddr adc8b_0.sar12b_0.nh_sw[2] adc8b_0.side_cap8b_1.buf_16_0.z vddr sg13_lv_pmos ad=0.19p pd=1.38u as=0.19p ps=1.38u w=1u l=0.13u
X4744 a_97836_98088# a_97810_98052# vdd vdd sg13_lv_pmos ad=0.34p pd=2.68u as=0.36237p ps=2.605u w=1u l=0.13u
X4745 a_85742_93548# a_85346_93912# a_85628_93548# vdd sg13_lv_pmos ad=0.1008p pd=0.9u as=0.191p ps=1.44u w=0.42u l=0.13u
X4746 sg13cmos5l_IOPadAnalog_9.pad a_83639_178370# sg13cmos5l_Corner_1.vss sg13cmos5l_Corner_1.vss sg13_hv_nmos ad=2.596p pd=5.58u as=1.408p ps=5.04u w=4.4u l=0.6u
X4747 adc8b_0.side_cap8b_0.buf_16_0.z adc8b_0.side_cap8b_0.in_h_sw[2] sg13cmos5l_Corner_1.vss sg13cmos5l_Corner_1.vss sg13_lv_nmos ad=95f pd=0.88u as=95f ps=0.88u w=0.5u l=0.13u
X4748 a_97268_100310# adc8b_0.sar12b_0.sg13cmos5l_buf_1_95.X sg13cmos5l_Corner_1.vss sg13cmos5l_Corner_1.vss sg13_lv_nmos ad=0.187p pd=1.78u as=0.14875p ps=1.16u w=0.55u l=0.13u
X4749 a_94335_98442# adc8b_0.sar12b_0.sg13cmos5l_dlhr_1_11.GATE sg13cmos5l_Corner_1.vss sg13cmos5l_Corner_1.vss sg13_lv_nmos ad=0.2516p pd=2.16u as=0.15055p ps=1.17u w=0.74u l=0.13u
X4750 a_92557_95814# adc8b_0.sar12b_0.sg13cmos5l_a221oi_1_0.C1 sg13cmos5l_Corner_1.vss sg13cmos5l_Corner_1.vss sg13_lv_nmos ad=0.1406p pd=1.12u as=0.14505p ps=1.15u w=0.74u l=0.13u
X4751 sg13cmos5l_IOPadAnalog_15.pad a_99639_164698# sg13cmos5l_Corner_1.iovdd sg13cmos5l_Corner_1.iovdd sg13_hv_pmos ad=3.9294p pd=7.84u as=2.1312p ps=7.3u w=6.66u l=0.6u
X4752 a_101113_97314# a_100561_97376# sg13cmos5l_Corner_1.vss sg13cmos5l_Corner_1.vss sg13_lv_nmos ad=71.99999f pd=0.865u as=1.97045p ps=12.335u w=0.64u l=0.13u
X4753 sg13cmos5l_Corner_1.iovdd a_164624_86044# sg13cmos5l_IOPadAnalog_0.pad sg13cmos5l_Corner_1.iovdd sg13_hv_pmos ad=2.1312p pd=7.3u as=3.9294p ps=7.84u w=6.66u l=0.6u
X4754 sg13cmos5l_Corner_1.vss a_94744_93790# a_94393_93909# sg13cmos5l_Corner_1.vss sg13_lv_nmos ad=79.8f pd=0.8u as=0.1428p ps=1.52u w=0.42u l=0.13u
X4755 sg13cmos5l_IOPadAnalog_13.pad a_115639_164698# sg13cmos5l_Corner_1.iovdd sg13cmos5l_Corner_1.iovdd sg13_hv_pmos ad=3.9294p pd=7.84u as=2.1312p ps=7.3u w=6.66u l=0.6u
X4756 a_96764_96572# a_96482_96936# a_96697_96974# sg13cmos5l_Corner_1.vss sg13_lv_nmos ad=0.141p pd=1.17u as=71.99999f ps=0.865u w=0.64u l=0.13u
X4757 vdd adc8b_0.cmp_0.outn adc8b_0.cmp_0.outp vdd sg13_lv_pmos ad=0.2375p pd=1.63u as=0.425p ps=3.18u w=1.25u l=0.13u
X4758 vddr adc8b_0.sar12b_0.nl_sw[4] adc8b_0.side_cap8b_1.buf_8_0.z vddr sg13_lv_pmos ad=0.19p pd=1.38u as=0.19p ps=1.38u w=1u l=0.13u
X4759 sg13cmos5l_Corner_1.vss a_115639_178370# sg13cmos5l_IOPadAnalog_13.pad sg13cmos5l_Corner_1.vss sg13_hv_nmos ad=1.408p pd=5.04u as=2.596p ps=5.58u w=4.4u l=0.6u
X4760 sg13cmos5l_Corner_1.iovdd a_83639_164698# sg13cmos5l_IOPadAnalog_9.pad sg13cmos5l_Corner_1.iovdd sg13_hv_pmos ad=2.1312p pd=7.3u as=3.9294p ps=7.84u w=6.66u l=0.6u
X4761 sg13cmos5l_Corner_1.vss adc8b_0.sar12b_0.sg13cmos5l_buf_1_65.X a_90256_100384# sg13cmos5l_Corner_1.vss sg13_lv_nmos ad=0.14875p pd=1.16u as=0.187p ps=1.78u w=0.55u l=0.13u
X4762 a_76796_95659# adc8b_0.cmp_0.outp adc8b_0.cmp_0.outn sg13cmos5l_Corner_1.vss sg13_lv_nmos ad=1.7p pd=10.68u as=0.95p ps=5.38u w=5u l=0.13u
X4763 sg13cmos5l_IOPadAnalog_16.padres sg13cmos5l_IOPadAnalog_16.pad sg13cmos5l_Corner_1.vss rppd l=2u w=1u
X4764 sg13cmos5l_Corner_1.vss a_131639_178370# sg13cmos5l_IOPadAnalog_12.pad sg13cmos5l_Corner_1.vss sg13_hv_nmos ad=1.408p pd=5.04u as=2.596p ps=5.58u w=4.4u l=0.6u
X4765 adc8b_0.side_cap8b_1.buf_32_0.z adc8b_0.sar12b_0.nl_sw[0] vddr vddr sg13_lv_pmos ad=0.19p pd=1.38u as=0.19p ps=1.38u w=1u l=0.13u
X4766 adc8b_0.side_cap8b_0.buf_32_0.z adc8b_0.side_cap8b_0.in_l_sw[0] sg13cmos5l_Corner_1.vss sg13cmos5l_Corner_1.vss sg13_lv_nmos ad=95f pd=0.88u as=95f ps=0.88u w=0.5u l=0.13u
X4767 adc8b_0.side_cap8b_0.buf_8_4.z adc8b_0.side_cap8b_0.in_l_sw[5] vddr vddr sg13_lv_pmos ad=0.19p pd=1.38u as=0.19p ps=1.38u w=1u l=0.13u
X4768 a_83630_100034# adc8b_0.sar12b_0.sg13cmos5l_dfrbp_1_17.D vdd vdd sg13_lv_pmos ad=79.8f pd=0.8u as=0.1428p ps=1.52u w=0.42u l=0.13u
X4769 a_98074_100034# adc8b_0.sar12b_0.sg13cmos5l_dfrbp_1_8.RESET_B sg13cmos5l_Corner_1.vss sg13cmos5l_Corner_1.vss sg13_lv_nmos ad=37.8f pd=0.6u as=79.8f ps=0.8u w=0.42u l=0.13u
X4770 a_68892_96252# a_68824_96348# vdd sg13cmos5l_Corner_1.vss sg13_lv_nmos ad=0.442p pd=3.28u as=0.442p ps=3.28u w=1.3u l=0.13u
X4771 sg13cmos5l_Corner_1.iovdd a_118044_42476# cko sg13cmos5l_Corner_1.iovdd sg13_hv_pmos ad=2.1312p pd=7.3u as=3.9294p ps=7.84u w=6.66u l=0.6u
X4772 adc8b_0.sar12b_0.sg13cmos5l_dlhr_1_0.Q_N a_89982_92768# vdd vdd sg13_lv_pmos ad=0.3808p pd=2.92u as=0.1974p ps=1.5u w=1.12u l=0.13u
X4773 vddr adc8b_0.side_cap8b_0.in_l_sw[1] adc8b_0.side_cap8b_0.buf_16_2.z vddr sg13_lv_pmos ad=0.19p pd=1.38u as=0.19p ps=1.38u w=1u l=0.13u
X4774 vdd adc8b_0.sar12b_0.sg13cmos5l_dfrbp_1_6.RESET_B a_97742_97322# vdd sg13_lv_pmos ad=0.36237p pd=2.605u as=79.8f ps=0.8u w=0.42u l=0.13u
X4775 a_84980_92750# adc8b_0.sar12b_0.sg13cmos5l_buf_1_41.A vdd vdd sg13_lv_pmos ad=0.2856p pd=2.36u as=0.2114p ps=1.54u w=0.84u l=0.13u
X4776 a_87405_93559# adc8b_0.sar12b_0.sg13cmos5l_dlhr_1_0.GATE sg13cmos5l_Corner_1.vss sg13cmos5l_Corner_1.vss sg13_lv_nmos ad=0.2516p pd=2.16u as=2.59257p ps=16.445u w=0.74u l=0.13u
X4777 sg13cmos5l_Corner_1.vss sg13cmos5l_IOPadVdd$1_0.sg13cmos5l_Clamp_N43N43D4R$1_0.gate vdd sg13cmos5l_Corner_1.vss sg13_hv_nmos ad=1.408p pd=5.04u as=2.596p ps=5.58u w=4.4u l=0.6u
X4778 adc8b_0.side_cap8b_0.buf_32_0.z adc8b_0.side_cap8b_0.in_l_sw[0] vddr vddr sg13_lv_pmos ad=0.19p pd=1.38u as=0.19p ps=1.38u w=1u l=0.13u
X4779 sg13cmos5l_Corner_1.vss a_89972_100310# adc8b_0.sar12b_0.sg13cmos5l_buf_1_74.X sg13cmos5l_Corner_1.vss sg13_lv_nmos ad=0.14875p pd=1.16u as=0.2886p ps=2.26u w=0.74u l=0.13u
X4780 a_84599_98790# adc8b_0.sar12b_0.sg13cmos5l_dfrbp_1_16.Q_N sg13cmos5l_Corner_1.vss sg13cmos5l_Corner_1.vss sg13_lv_nmos ad=0.187p pd=1.78u as=0.15055p ps=1.17u w=0.55u l=0.13u
X4781 adc8b_0.sar12b_0.sg13cmos5l_dlhr_1_0.D a_89084_93548# sg13cmos5l_Corner_1.vss sg13cmos5l_Corner_1.vss sg13_lv_nmos ad=0.2516p pd=2.16u as=0.1406p ps=1.12u w=0.74u l=0.13u
X4782 sg13cmos5l_Corner_1.vss a_86044_30676# data[1] sg13cmos5l_Corner_1.vss sg13_hv_nmos ad=1.408p pd=5.04u as=2.596p ps=5.58u w=4.4u l=0.6u
X4783 a_93585_93595# a_93228_93552# vdd vdd sg13_lv_pmos ad=63f pd=0.72u as=0.1563p ps=1.22u w=0.42u l=0.13u
X4784 vdd adc8b_0.sar12b_0.sg13cmos5l_inv_1_18.A adc8b_0.sar12b_0.sg13cmos5l_buf_1_28.A vdd sg13_lv_pmos ad=0.3808p pd=2.92u as=0.3808p ps=2.92u w=1.12u l=0.13u
X4785 sg13cmos5l_Corner_1.vss adc8b_0.sar12b_0.sg13cmos5l_buf_1_41.X a_84592_93548# sg13cmos5l_Corner_1.vss sg13_lv_nmos ad=0.14875p pd=1.16u as=0.187p ps=1.78u w=0.55u l=0.13u
X4786 vip a_42476_102044# sg13cmos5l_Corner_1.iovdd sg13cmos5l_Corner_1.iovdd sg13_hv_pmos ad=3.9294p pd=7.84u as=3.1302p ps=14.26u w=6.66u l=0.6u
X4787 sg13cmos5l_Corner_1.vss adc8b_0.side_cap8b_0.in_h_sw[8] adc8b_0.side_cap8b_0.buf_2_0.z sg13cmos5l_Corner_1.vss sg13_lv_nmos ad=95f pd=0.88u as=0.17p ps=1.68u w=0.5u l=0.13u
X4788 sg13cmos5l_Corner_1.iovdd a_86044_42476# data[1] sg13cmos5l_Corner_1.iovdd sg13_hv_pmos ad=3.1302p pd=14.26u as=3.9294p ps=7.84u w=6.66u l=0.6u
X4789 a_87470_100034# a_88275_99607# a_87730_99564# vdd sg13_lv_pmos ad=0.1428p pd=1.52u as=79.8f ps=0.8u w=0.42u l=0.13u
X4790 sg13cmos5l_IOPadAnalog_1.pad a_178296_70044# sg13cmos5l_Corner_1.vss sg13cmos5l_Corner_1.vss sg13_hv_nmos ad=2.596p pd=5.58u as=1.408p ps=5.04u w=4.4u l=0.6u
X4791 sg13cmos5l_Corner_1.iovdd a_164624_118044# sg13cmos5l_IOPadAnalog_11.pad sg13cmos5l_Corner_1.iovdd sg13_hv_pmos ad=2.1312p pd=7.3u as=3.9294p ps=7.84u w=6.66u l=0.6u
X4792 sg13cmos5l_Corner_1.vss a_96692_92750# adc8b_0.sar12b_0.nh_sw[6] sg13cmos5l_Corner_1.vss sg13_lv_nmos ad=0.14875p pd=1.16u as=0.2886p ps=2.26u w=0.74u l=0.13u
X4793 data[0] a_70044_42476# sg13cmos5l_Corner_1.iovdd sg13cmos5l_Corner_1.iovdd sg13_hv_pmos ad=3.9294p pd=7.84u as=2.1312p ps=7.3u w=6.66u l=0.6u
X4794 adc8b_0.sar12b_0.sg13cmos5l_buf_1_18.X a_100144_93548# sg13cmos5l_Corner_1.vss sg13cmos5l_Corner_1.vss sg13_lv_nmos ad=0.2886p pd=2.26u as=0.14875p ps=1.16u w=0.74u l=0.13u
X4795 adc8b_0.side_cap8b_0.buf_16_1.z adc8b_0.side_cap8b_0.in_l_sw[2] vddr vddr sg13_lv_pmos ad=0.19p pd=1.38u as=0.19p ps=1.38u w=1u l=0.13u
X4796 sg13cmos5l_Corner_1.iovdd a_67639_164698# sg13cmos5l_IOPadAnalog_10.pad sg13cmos5l_Corner_1.iovdd sg13_hv_pmos ad=2.1312p pd=7.3u as=3.9294p ps=7.84u w=6.66u l=0.6u
X4797 a_89972_100310# adc8b_0.sar12b_0.sg13cmos5l_buf_1_45.X sg13cmos5l_Corner_1.vss sg13cmos5l_Corner_1.vss sg13_lv_nmos ad=0.187p pd=1.78u as=0.14875p ps=1.16u w=0.55u l=0.13u
X4798 vip a_42476_102044# sg13cmos5l_Corner_1.iovdd sg13cmos5l_Corner_1.iovdd sg13_hv_pmos ad=3.9294p pd=7.84u as=2.1312p ps=7.3u w=6.66u l=0.6u
X4799 sg13cmos5l_Corner_1.iovdd a_42476_70044# vddr sg13cmos5l_Corner_1.iovdd sg13_hv_pmos ad=2.1312p pd=7.3u as=3.9294p ps=7.84u w=6.66u l=0.6u
X4800 adc8b_0.sar12b_0.sg13cmos5l_dlhr_1_11.D a_93335_98911# vdd vdd sg13_lv_pmos ad=0.4312p pd=3.01u as=0.2639p ps=1.81u w=1.12u l=0.13u
X4801 sg13cmos5l_Corner_1.vss a_118044_30676# cko sg13cmos5l_Corner_1.vss sg13_hv_nmos ad=1.408p pd=5.04u as=2.596p ps=5.58u w=4.4u l=0.6u
X4802 adc8b_0.sar12b_0.sg13cmos5l_dlhr_1_11.GATE a_92636_99596# sg13cmos5l_Corner_1.vss sg13cmos5l_Corner_1.vss sg13_lv_nmos ad=0.2516p pd=2.16u as=0.1406p ps=1.12u w=0.74u l=0.13u
X4803 data[2] a_102044_30676# sg13cmos5l_Corner_1.vss sg13cmos5l_Corner_1.vss sg13_hv_nmos ad=2.596p pd=5.58u as=1.408p ps=5.04u w=4.4u l=0.6u
X4804 vddr adc8b_0.sar12b_0.nh_sw[7] adc8b_0.side_cap8b_1.buf_4_2.z vddr sg13_lv_pmos ad=0.19p pd=1.38u as=0.19p ps=1.38u w=1u l=0.13u
X4805 sg13cmos5l_Corner_1.vss adc8b_0.sar12b_0.nl_sw[0] adc8b_0.side_cap8b_1.buf_32_0.z sg13cmos5l_Corner_1.vss sg13_lv_nmos ad=95f pd=0.88u as=95f ps=0.88u w=0.5u l=0.13u
X4806 vdd sg13cmos5l_IOPadVdd$1_0.sg13cmos5l_Clamp_N43N43D4R$1_0.gate sg13cmos5l_Corner_1.vss sg13cmos5l_Corner_1.vss sg13_hv_nmos ad=2.596p pd=5.58u as=1.408p ps=5.04u w=4.4u l=0.6u
X4807 a_96063_98442# adc8b_0.sar12b_0.sg13cmos5l_dfrbp_1_23.CLK vdd vdd sg13_lv_pmos ad=0.3234p pd=2.45u as=1.04815p ps=6.595u w=0.84u l=0.13u
X4808 vdd adc8b_0.sar12b_0.sg13cmos5l_buf_8_1.A a_100131_95430# vdd sg13_lv_pmos ad=0.2128p pd=1.5u as=0.3808p ps=2.92u w=1.12u l=0.13u
X4809 sg13cmos5l_IOPadAnalog_15.pad a_99639_178370# sg13cmos5l_Corner_1.vss sg13cmos5l_Corner_1.vss sg13_hv_nmos ad=2.596p pd=5.58u as=1.408p ps=5.04u w=4.4u l=0.6u
X4810 sg13cmos5l_IOPadAnalog_10.pad a_67639_164698# sg13cmos5l_Corner_1.iovdd sg13cmos5l_Corner_1.iovdd sg13_hv_pmos ad=3.9294p pd=7.84u as=2.1312p ps=7.3u w=6.66u l=0.6u
X4811 adc8b_0.sar12b_0.sg13cmos5l_dlhr_1_15.D a_98876_99132# vdd vdd sg13_lv_pmos ad=0.3808p pd=2.92u as=0.2128p ps=1.5u w=1.12u l=0.13u
X4812 sg13cmos5l_IOPadAnalog_0.pad a_164624_86044# sg13cmos5l_Corner_1.iovdd sg13cmos5l_Corner_1.iovdd sg13_hv_pmos ad=3.9294p pd=7.84u as=3.1302p ps=14.26u w=6.66u l=0.6u
X4813 sg13cmos5l_IOPadAnalog_13.pad a_115639_178370# sg13cmos5l_Corner_1.vss sg13cmos5l_Corner_1.vss sg13_hv_nmos ad=2.596p pd=5.58u as=1.408p ps=5.04u w=4.4u l=0.6u
X4814 sg13cmos5l_IOPadAnalog_9.pad a_83639_164698# sg13cmos5l_Corner_1.iovdd sg13cmos5l_Corner_1.iovdd sg13_hv_pmos ad=3.9294p pd=7.84u as=2.1312p ps=7.3u w=6.66u l=0.6u
X4815 vdd adc8b_0.sar12b_0.sg13cmos5l_inv_1_18.A a_91024_100384# vdd sg13_lv_pmos ad=0.2114p pd=1.54u as=0.2856p ps=2.36u w=0.84u l=0.13u
X4816 vdd a_95409_98834# a_95934_98816# vdd sg13_lv_pmos ad=0.1974p pd=1.5u as=0.2856p ps=2.36u w=0.84u l=0.13u
X4817 a_85694_97335# a_84516_97286# a_85298_97480# sg13cmos5l_Corner_1.vss sg13_lv_nmos ad=37.8f pd=0.6u as=0.1428p ps=1.52u w=0.42u l=0.13u
X4818 vdd adc8b_0.sar12b_0.sg13cmos5l_dfrbp_1_6.RESET_B a_83822_94298# vdd sg13_lv_pmos ad=0.36237p pd=2.605u as=79.8f ps=0.8u w=0.42u l=0.13u
X4819 a_118044_30676# sg13cmos5l_Corner_1.vss sg13cmos5l_Corner_1.vss rppd l=3.54u w=0.5u
X4820 vdd a_95159_100423# a_95996_100644# vdd sg13_lv_pmos ad=0.2128p pd=1.5u as=0.3864p ps=2.93u w=1.12u l=0.13u
X4821 a_93984_96888# adc8b_0.sar12b_0.sg13cmos5l_or2_1_1.B a_94126_96548# vdd sg13_lv_pmos ad=0.2856p pd=2.36u as=0.1596p ps=1.22u w=0.84u l=0.13u
X4822 sg13cmos5l_IOPadAnalog_2.padres sg13cmos5l_Corner_1.iovdd dpantenna l=0.64u w=4.98u
X4823 sg13cmos5l_Corner_1.vss a_83639_178370# sg13cmos5l_IOPadAnalog_9.pad sg13cmos5l_Corner_1.vss sg13_hv_nmos ad=1.408p pd=5.04u as=2.596p ps=5.58u w=4.4u l=0.6u
X4824 sg13cmos5l_Corner_1.vss sg13cmos5l_IOPadVdd$1_0.sg13cmos5l_Clamp_N43N43D4R$1_0.gate vdd sg13cmos5l_Corner_1.vss sg13_hv_nmos ad=1.408p pd=5.04u as=2.596p ps=5.58u w=4.4u l=0.6u
X4825 vddr adc8b_0.sar12b_0.nl_sw[2] adc8b_0.side_cap8b_1.buf_16_1.z vddr sg13_lv_pmos ad=0.19p pd=1.38u as=0.19p ps=1.38u w=1u l=0.13u
X4826 data[2] a_102044_42476# sg13cmos5l_Corner_1.iovdd sg13cmos5l_Corner_1.iovdd sg13_hv_pmos ad=3.9294p pd=7.84u as=3.1302p ps=14.26u w=6.66u l=0.6u
X4827 sg13cmos5l_Corner_1.vss adc8b_0.sar12b_0.nl_sw[7] adc8b_0.side_cap8b_1.buf_4_0.z sg13cmos5l_Corner_1.vss sg13_lv_nmos ad=95f pd=0.88u as=95f ps=0.88u w=0.5u l=0.13u
X4828 sg13cmos5l_Corner_1.iovdd a_115639_164698# sg13cmos5l_IOPadAnalog_13.pad sg13cmos5l_Corner_1.iovdd sg13_hv_pmos ad=2.1312p pd=7.3u as=3.9294p ps=7.84u w=6.66u l=0.6u
X4829 vdd adc8b_0.sar12b_0.sg13cmos5l_buf_1_30.A a_90448_92824# vdd sg13_lv_pmos ad=0.2114p pd=1.54u as=0.2856p ps=2.36u w=0.84u l=0.13u
X4830 adc8b_0.side_cap8b_0.buf_8_5.z adc8b_0.side_cap8b_0.in_h_sw[5] sg13cmos5l_Corner_1.vss sg13cmos5l_Corner_1.vss sg13_lv_nmos ad=95f pd=0.88u as=95f ps=0.88u w=0.5u l=0.13u
X4831 a_85356_96128# a_85875_95932# a_86615_95887# sg13cmos5l_Corner_1.vss sg13_lv_nmos ad=0.3473p pd=2.71u as=0.12665p ps=1.145u w=0.74u l=0.13u
X4832 a_93874_100569# a_94317_100325# a_93614_100346# sg13cmos5l_Corner_1.vss sg13_lv_nmos ad=79.8f pd=0.8u as=0.1296p ps=1.52u w=0.42u l=0.13u
X4833 sg13cmos5l_Corner_1.vss adc8b_0.sar12b_0.sg13cmos5l_a221oi_1_1.C1 adc8b_0.sar12b_0.sg13cmos5l_a22oi_1_2.B2 sg13cmos5l_Corner_1.vss sg13_lv_nmos ad=0.1406p pd=1.12u as=0.2516p ps=2.16u w=0.74u l=0.13u
X4834 adc8b_0.side_cap8b_0.buf_16_3.z adc8b_0.side_cap8b_0.in_h_sw[1] sg13cmos5l_Corner_1.vss sg13cmos5l_Corner_1.vss sg13_lv_nmos ad=95f pd=0.88u as=95f ps=0.88u w=0.5u l=0.13u
X4835 a_93614_100346# a_94419_100468# a_93874_100569# vdd sg13_lv_pmos ad=0.1428p pd=1.52u as=79.8f ps=0.8u w=0.42u l=0.13u
X4836 vddr a_42476_70044# sg13cmos5l_Corner_1.iovdd sg13cmos5l_Corner_1.iovdd sg13_hv_pmos ad=3.9294p pd=7.84u as=2.1312p ps=7.3u w=6.66u l=0.6u
X4837 adc8b_0.sar12b_0.sg13cmos5l_buf_1_111.A a_101008_98872# sg13cmos5l_Corner_1.vss sg13cmos5l_Corner_1.vss sg13_lv_nmos ad=0.2886p pd=2.26u as=0.14875p ps=1.16u w=0.74u l=0.13u
X4838 sg13cmos5l_IOPadAnalog_16.pad a_164624_102044# sg13cmos5l_Corner_1.iovdd sg13cmos5l_Corner_1.iovdd sg13_hv_pmos ad=3.9294p pd=7.84u as=2.1312p ps=7.3u w=6.66u l=0.6u
X4839 a_98230_95498# a_98471_95031# a_97589_95024# sg13cmos5l_Corner_1.vss sg13_lv_nmos ad=0.1428p pd=1.52u as=0.12665p ps=1.145u w=0.42u l=0.13u
X4840 sg13cmos5l_Corner_1.iovdd a_86044_42476# data[1] sg13cmos5l_Corner_1.iovdd sg13_hv_pmos ad=2.1312p pd=7.3u as=3.9294p ps=7.84u w=6.66u l=0.6u
X4841 sg13cmos5l_Corner_1.iovdd a_164624_86044# sg13cmos5l_IOPadAnalog_0.pad sg13cmos5l_Corner_1.iovdd sg13_hv_pmos ad=2.1312p pd=7.3u as=3.9294p ps=7.84u w=6.66u l=0.6u
X4842 vdd sg13cmos5l_IOPadVdd$1_0.sg13cmos5l_Clamp_N43N43D4R$1_0.gate sg13cmos5l_Corner_1.vss sg13cmos5l_Corner_1.vss sg13_hv_nmos ad=2.596p pd=5.58u as=1.408p ps=5.04u w=4.4u l=0.6u
X4843 adc8b_0.side_cap8b_0.buf_16_3.z adc8b_0.side_cap8b_0.in_h_sw[1] vddr vddr sg13_lv_pmos ad=0.19p pd=1.38u as=0.19p ps=1.38u w=1u l=0.13u
X4844 adc8b_0.side_cap8b_0.buf_8_5.z adc8b_0.side_cap8b_0.in_h_sw[5] vddr vddr sg13_lv_pmos ad=0.19p pd=1.38u as=0.19p ps=1.38u w=1u l=0.13u
X4845 sg13cmos5l_Corner_1.vss a_30676_118044# cks sg13cmos5l_Corner_1.vss sg13_hv_nmos ad=1.408p pd=5.04u as=2.596p ps=5.58u w=4.4u l=0.6u
X4846 vdd a_86615_95887# a_86872_96030# vdd sg13_lv_pmos ad=0.2639p pd=1.81u as=79.8f ps=0.8u w=0.42u l=0.13u
X4847 vdd a_94583_95421# a_95420_95060# vdd sg13_lv_pmos ad=0.2128p pd=1.5u as=0.3864p ps=2.93u w=1.12u l=0.13u
X4848 sg13cmos5l_IOPadAnalog_16.pad a_178296_102044# sg13cmos5l_Corner_1.vss sg13cmos5l_Corner_1.vss sg13_hv_nmos ad=2.596p pd=5.58u as=2.068p ps=9.74u w=4.4u l=0.6u
X4849 vdd sg13cmos5l_IOPadVdd$1_0.sg13cmos5l_Clamp_N43N43D4R$1_0.gate sg13cmos5l_Corner_1.vss sg13cmos5l_Corner_1.vss sg13_hv_nmos ad=2.596p pd=5.58u as=1.408p ps=5.04u w=4.4u l=0.6u
X4850 adc8b_0.sar12b_0.sg13cmos5l_dlhr_1_5.D a_88727_97399# vdd vdd sg13_lv_pmos ad=0.4312p pd=3.01u as=0.2639p ps=1.81u w=1.12u l=0.13u
X4851 sg13cmos5l_Corner_1.vss a_118222_175886# dantenna l=1.26u w=27.78u
X4852 vin a_30676_86044# sg13cmos5l_Corner_1.vss sg13cmos5l_Corner_1.vss sg13_hv_nmos ad=2.596p pd=5.58u as=1.408p ps=5.04u w=4.4u l=0.6u
X4853 sg13cmos5l_Corner_1.vss a_97268_100310# adc8b_0.side_cap8b_0.in_h_sw[6] sg13cmos5l_Corner_1.vss sg13_lv_nmos ad=0.14875p pd=1.16u as=0.2886p ps=2.26u w=0.74u l=0.13u
X4854 a_96892_98472# a_96476_98084# a_96657_98441# sg13cmos5l_Corner_1.vss sg13_lv_nmos ad=77.7f pd=0.95u as=0.2516p ps=2.16u w=0.74u l=0.13u
X4855 adc8b_0.sar12b_0.sg13cmos5l_dfrbp_1_4.Q_N a_94487_93909# vdd vdd sg13_lv_pmos ad=0.4312p pd=3.01u as=0.2639p ps=1.81u w=1.12u l=0.13u
X4856 sg13cmos5l_Corner_1.vss adc8b_0.sar12b_0.sg13cmos5l_inv_1_6.A a_101776_99596# sg13cmos5l_Corner_1.vss sg13_lv_nmos ad=0.14875p pd=1.16u as=0.187p ps=1.78u w=0.55u l=0.13u
X4857 a_96494_98834# adc8b_0.sar12b_0.sg13cmos5l_buf_1_57.X vdd vdd sg13_lv_pmos ad=79.8f pd=0.8u as=0.1428p ps=1.52u w=0.42u l=0.13u
X4858 a_86090_97322# adc8b_0.sar12b_0.sg13cmos5l_dfrbp_1_8.RESET_B sg13cmos5l_Corner_1.vss sg13cmos5l_Corner_1.vss sg13_lv_nmos ad=60.89999f pd=0.71u as=0.1626p ps=1.415u w=0.42u l=0.13u
X4859 sg13cmos5l_Corner_1.vss adc8b_0.sar12b_0.sg13cmos5l_inv_1_6.A adc8b_0.sar12b_0.sg13cmos5l_buf_1_0.A sg13cmos5l_Corner_1.vss sg13_lv_nmos ad=0.2516p pd=2.16u as=0.2516p ps=2.16u w=0.74u l=0.13u
X4860 vdd a_94583_95421# a_94840_95302# vdd sg13_lv_pmos ad=0.2639p pd=1.81u as=79.8f ps=0.8u w=0.42u l=0.13u
X4861 adc8b_0.sar12b_0.sg13cmos5l_dlhr_1_2.Q_N a_89790_94280# vdd vdd sg13_lv_pmos ad=0.3808p pd=2.92u as=0.1974p ps=1.5u w=1.12u l=0.13u
X4862 sg13cmos5l_IOPadAnalog_16.pad a_178296_102044# sg13cmos5l_Corner_1.vss sg13cmos5l_Corner_1.vss sg13_hv_nmos ad=2.596p pd=5.58u as=1.408p ps=5.04u w=4.4u l=0.6u
X4863 a_97644_98522# adc8b_0.sar12b_0.sg13cmos5l_dfrbp_1_22.D a_97550_98522# sg13cmos5l_Corner_1.vss sg13_lv_nmos ad=60.89999f pd=0.71u as=0.1428p ps=1.52u w=0.42u l=0.13u
X4864 sg13cmos5l_Corner_1.vss a_90356_93512# adc8b_0.sar12b_0.nl_sw[4] sg13cmos5l_Corner_1.vss sg13_lv_nmos ad=0.14875p pd=1.16u as=0.2886p ps=2.26u w=0.74u l=0.13u
X4865 vddr adc8b_0.sar12b_0.nl_sw[0] adc8b_0.side_cap8b_1.buf_32_0.z vddr sg13_lv_pmos ad=0.19p pd=1.38u as=0.19p ps=1.38u w=1u l=0.13u
X4866 vin a_42476_86044# sg13cmos5l_Corner_1.iovdd sg13cmos5l_Corner_1.iovdd sg13_hv_pmos ad=3.9294p pd=7.84u as=2.1312p ps=7.3u w=6.66u l=0.6u
X4867 sg13cmos5l_Corner_1.vss a_90225_98441# a_90180_98486# sg13cmos5l_Corner_1.vss sg13_lv_nmos ad=0.1428p pd=1.52u as=47.25f ps=0.645u w=0.42u l=0.13u
X4868 sg13cmos5l_Corner_1.vss adc8b_0.sar12b_0.sg13cmos5l_buf_1_25.X a_86224_92824# sg13cmos5l_Corner_1.vss sg13_lv_nmos ad=0.14875p pd=1.16u as=0.187p ps=1.78u w=0.55u l=0.13u
X4869 sg13cmos5l_Corner_1.vss adc8b_0.side_cap8b_0.in_l_sw[0] adc8b_0.side_cap8b_0.buf_32_0.z sg13cmos5l_Corner_1.vss sg13_lv_nmos ad=95f pd=0.88u as=95f ps=0.88u w=0.5u l=0.13u
X4870 sg13cmos5l_Corner_1.vss adc8b_0.sar12b_0.sg13cmos5l_buf_1_98.A a_95536_99596# sg13cmos5l_Corner_1.vss sg13_lv_nmos ad=0.14875p pd=1.16u as=0.187p ps=1.78u w=0.55u l=0.13u
X4871 adc8b_0.sar12b_0.sg13cmos5l_buf_8_0.X a_100995_95814# vdd vdd sg13_lv_pmos ad=0.2128p pd=1.5u as=0.2128p ps=1.5u w=1.12u l=0.13u
X4872 sg13cmos5l_IOPadAnalog_10.pad a_67639_178370# sg13cmos5l_Corner_1.vss sg13cmos5l_Corner_1.vss sg13_hv_nmos ad=2.596p pd=5.58u as=1.408p ps=5.04u w=4.4u l=0.6u
X4873 adc8b_0.side_cap8b_0.buf_32_0.z adc8b_0.side_cap8b_0.in_l_sw[0] vddr vddr sg13_lv_pmos ad=0.19p pd=1.38u as=0.19p ps=1.38u w=1u l=0.13u
X4874 sg13cmos5l_IOPadAnalog_6.padres sg13cmos5l_Corner_1.iovdd dpantenna l=0.64u w=4.98u
X4875 sg13cmos5l_Corner_1.iovdd a_118044_42476# cko sg13cmos5l_Corner_1.iovdd sg13_hv_pmos ad=2.1312p pd=7.3u as=3.9294p ps=7.84u w=6.66u l=0.6u
X4876 a_85215_93906# adc8b_0.sar12b_0.sg13cmos5l_dfrbp_1_9.Q vdd vdd sg13_lv_pmos ad=0.3234p pd=2.45u as=1.86162p ps=11.935u w=0.84u l=0.13u
X4877 sg13cmos5l_IOPadAnalog_9.pad a_83639_178370# sg13cmos5l_Corner_1.vss sg13cmos5l_Corner_1.vss sg13_hv_nmos ad=2.596p pd=5.58u as=1.408p ps=5.04u w=4.4u l=0.6u
X4878 vdd sg13cmos5l_IOPadVdd$1_0.sg13cmos5l_Clamp_N43N43D4R$1_0.gate sg13cmos5l_Corner_1.vss sg13cmos5l_Corner_1.vss sg13_hv_nmos ad=2.596p pd=5.58u as=1.408p ps=5.04u w=4.4u l=0.6u
X4879 vdd a_83614_99010# adc8b_0.sar12b_0.sg13cmos5l_dlhr_1_8.Q_N vdd sg13_lv_pmos ad=0.1974p pd=1.5u as=0.3808p ps=2.92u w=1.12u l=0.13u
X4880 vdd adc8b_0.sar12b_0.sg13cmos5l_dfrbp_1_6.RESET_B a_82190_97010# vdd sg13_lv_pmos ad=0.36237p pd=2.605u as=79.8f ps=0.8u w=0.42u l=0.13u
X4881 a_82926_94302# a_82670_94302# vdd vdd sg13_lv_pmos ad=0.34p pd=2.68u as=0.2481p ps=1.56u w=1u l=0.25u
X4882 a_92184_98084# a_91633_98442# vdd vdd sg13_lv_pmos ad=0.105p pd=1.21u as=1.07253p ps=6.75u w=1u l=0.13u
X4883 sg13cmos5l_Corner_1.iovdd a_164624_70044# sg13cmos5l_IOPadAnalog_1.pad sg13cmos5l_Corner_1.iovdd sg13_hv_pmos ad=2.1312p pd=7.3u as=3.9294p ps=7.84u w=6.66u l=0.6u
X4884 vdd sg13cmos5l_Corner_1.vss vdd vdd sg13_lv_pmos ad=0.34p pd=2.68u as=0 ps=0 w=1u l=1u
X4885 sg13cmos5l_Corner_1.vss a_115639_178370# sg13cmos5l_IOPadAnalog_13.pad sg13cmos5l_Corner_1.vss sg13_hv_nmos ad=1.408p pd=5.04u as=2.596p ps=5.58u w=4.4u l=0.6u
X4886 sg13cmos5l_Corner_1.iovdd a_83639_164698# sg13cmos5l_IOPadAnalog_9.pad sg13cmos5l_Corner_1.iovdd sg13_hv_pmos ad=2.1312p pd=7.3u as=3.9294p ps=7.84u w=6.66u l=0.6u
X4887 sg13cmos5l_IOPadVdd$1_0.sg13cmos5l_Clamp_N43N43D4R$1_0.gate sg13cmos5l_IOPadVdd$1_0.sg13cmos5l_RCClampInverter$1_0.in vdd vdd sg13_hv_pmos ad=1.33p pd=7.38u as=1.33p ps=7.38u w=7u l=0.5u
X4888 sg13cmos5l_Corner_1.vss a_30676_102044# vip sg13cmos5l_Corner_1.vss sg13_hv_nmos ad=1.408p pd=5.04u as=2.596p ps=5.58u w=4.4u l=0.6u
X4889 a_95560_96920# adc8b_0.sar12b_0.sg13cmos5l_or2_1_1.B adc8b_0.sar12b_0.sg13cmos5l_a22oi_1_1.B2 sg13cmos5l_Corner_1.vss sg13_lv_nmos ad=0.1406p pd=1.12u as=0.2516p ps=2.16u w=0.74u l=0.13u
X4890 a_99154_93009# a_99597_92765# a_99537_93177# vdd sg13_lv_pmos ad=79.8f pd=0.8u as=63f ps=0.72u w=0.42u l=0.13u
X4891 sg13cmos5l_Corner_1.vss a_99639_178370# sg13cmos5l_IOPadAnalog_15.pad sg13cmos5l_Corner_1.vss sg13_hv_nmos ad=2.068p pd=9.74u as=2.596p ps=5.58u w=4.4u l=0.6u
X4892 frame a_134044_42476# sg13cmos5l_Corner_1.iovdd sg13cmos5l_Corner_1.iovdd sg13_hv_pmos ad=3.9294p pd=7.84u as=2.1312p ps=7.3u w=6.66u l=0.6u
X4893 adc8b_0.side_cap8b_1.buf_32_1.z adc8b_0.sar12b_0.nh_sw[0] vddr vddr sg13_lv_pmos ad=0.19p pd=1.38u as=0.19p ps=1.38u w=1u l=0.13u
X4894 sg13cmos5l_Corner_1.iovdd a_86044_42476# data[1] sg13cmos5l_Corner_1.iovdd sg13_hv_pmos ad=2.1312p pd=7.3u as=3.9294p ps=7.84u w=6.66u l=0.6u
X4895 vddr a_30676_70044# sg13cmos5l_Corner_1.vss sg13cmos5l_Corner_1.vss sg13_hv_nmos ad=2.596p pd=5.58u as=1.408p ps=5.04u w=4.4u l=0.6u
X4896 vdd adc8b_0.sar12b_0.sg13cmos5l_dfrbp_1_15.D a_85343_97713# vdd sg13_lv_pmos ad=0.1428p pd=1.52u as=79.8f ps=0.8u w=0.42u l=0.13u
X4897 a_84082_94521# a_84525_94277# a_84465_94689# vdd sg13_lv_pmos ad=79.8f pd=0.8u as=63f ps=0.72u w=0.42u l=0.13u
X4898 a_99468_94616# a_99987_94420# a_100727_94375# sg13cmos5l_Corner_1.vss sg13_lv_nmos ad=0.3473p pd=2.71u as=0.12665p ps=1.145u w=0.74u l=0.13u
X4899 vdd adc8b_0.sar12b_0.sg13cmos5l_buf_1_18.A a_100144_93548# vdd sg13_lv_pmos ad=0.2114p pd=1.54u as=0.2856p ps=2.36u w=0.84u l=0.13u
X4900 adc8b_0.sar12b_0.sg13cmos5l_dfrbp_1_18.Q_N a_89015_99957# sg13cmos5l_Corner_1.vss sg13cmos5l_Corner_1.vss sg13_lv_nmos ad=0.2849p pd=2.25u as=0.2516p ps=2.16u w=0.74u l=0.13u
X4901 a_87478_97010# a_87220_97010# sg13cmos5l_Corner_1.vss sg13cmos5l_Corner_1.vss sg13_lv_nmos ad=0.1428p pd=1.52u as=79.8f ps=0.8u w=0.42u l=0.13u
X4902 vdd adc8b_0.sar12b_0.sg13cmos5l_inv_1_26.Y a_99664_100384# vdd sg13_lv_pmos ad=0.2114p pd=1.54u as=0.2856p ps=2.36u w=0.84u l=0.13u
X4903 a_82893_96583# adc8b_0.sar12b_0.sg13cmos5l_dlhr_1_1.GATE sg13cmos5l_Corner_1.vss sg13cmos5l_Corner_1.vss sg13_lv_nmos ad=0.2516p pd=2.16u as=1.97045p ps=12.335u w=0.74u l=0.13u
X4904 adc8b_0.side_cap8b_1.buf_16_2.z adc8b_0.sar12b_0.nl_sw[1] vddr vddr sg13_lv_pmos ad=0.19p pd=1.38u as=0.19p ps=1.38u w=1u l=0.13u
X4905 sg13cmos5l_Corner_1.vss adc8b_0.side_cap8b_0.in_h_sw[0] adc8b_0.side_cap8b_0.buf_32_1.z sg13cmos5l_Corner_1.vss sg13_lv_nmos ad=95f pd=0.88u as=95f ps=0.88u w=0.5u l=0.13u
X4906 a_89015_99957# a_88173_99607# a_88921_99957# sg13cmos5l_Corner_1.vss sg13_lv_nmos ad=0.12665p pd=1.145u as=0.1428p ps=1.52u w=0.42u l=0.13u
X4907 a_84495_97540# a_84647_97592# sg13cmos5l_Corner_1.vss sg13cmos5l_Corner_1.vss sg13_lv_nmos ad=0.2516p pd=2.16u as=1.97045p ps=12.335u w=0.74u l=0.13u
X4908 sg13cmos5l_IOPadAnalog_15.pad a_99639_178370# sg13cmos5l_Corner_1.vss sg13cmos5l_Corner_1.vss sg13_hv_nmos ad=2.596p pd=5.58u as=1.408p ps=5.04u w=4.4u l=0.6u
X4909 adc8b_0.side_cap8b_1.buf_2_1.z adc8b_0.sar12b_0.nl_sw[8] vddr vddr sg13_lv_pmos ad=0.34p pd=2.68u as=0.19p ps=1.38u w=1u l=0.13u
X4910 a_83890_99564# a_84333_99607# a_83630_100034# sg13cmos5l_Corner_1.vss sg13_lv_nmos ad=79.8f pd=0.8u as=0.1296p ps=1.52u w=0.42u l=0.13u
.ends
