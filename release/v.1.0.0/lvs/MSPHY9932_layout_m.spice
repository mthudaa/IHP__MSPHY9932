* NGSPICE file created from MSPHY9932_flat.ext - technology: ihp-sg13cmos5l

.subckt MSPHY9932_flat vdd cks vip vin vddr data[0] data[1] data[2] cko frame
X0 sg13cmos5l_Corner_1.vss a_86222_175886# dantenna l=1.26u w=27.78u
M1 sg13cmos5l_Corner_1.vss adc8b_0.diff_bsw_0.single_bsw_0.sg13cmos5l_inv_1$1_0.A a_70946_99114# sg13cmos5l_Corner_1.vss sg13_lv_nmos ad=1.02p pd=6.68u as=0.57p ps=3.38u w=3u l=0.13u
M2 a_89146_97322# adc8b_0.sar12b_0.sg13cmos5l_dfrbp_1_6.RESET_B sg13cmos5l_Corner_1.vss sg13cmos5l_Corner_1.vss sg13_lv_nmos ad=37.8f pd=0.6u as=79.8f ps=0.8u w=0.42u l=0.13u
M3 vdd a_94701_97301# a_94803_97444# vdd sg13_lv_pmos ad=1.07253p pd=6.75u as=0.3864p ps=2.93u w=1.12u l=0.13u
M4 a_96764_96572# a_96351_96930# a_96696_96572# vdd sg13_lv_pmos ad=0.191p pd=1.44u as=0.105p ps=1.21u w=1u l=0.13u
M5 sg13cmos5l_Corner_1.vss a_89656_96030# a_89305_95887# sg13cmos5l_Corner_1.vss sg13_lv_nmos ad=79.8f pd=0.8u as=0.1428p ps=1.52u w=0.42u l=0.13u
M6 a_97125_92976# adc8b_0.sar12b_0.sg13cmos5l_dfrbp_1_0.Q vdd vdd sg13_lv_pmos ad=0.2856p pd=2.36u as=0.2198p ps=1.53u w=0.84u l=0.13u
M7 vdd a_90740_100310# adc8b_0.sar12b_0.sg13cmos5l_buf_1_77.X vdd sg13_lv_pmos ad=0.2114p pd=1.54u as=0.42p ps=2.99u w=1.12u l=0.13u
M8 sg13cmos5l_Corner_1.vss adc8b_0.sar12b_0.sg13cmos5l_buf_1_76.X a_87184_100384# sg13cmos5l_Corner_1.vss sg13_lv_nmos ad=0.14875p pd=1.16u as=0.187p ps=1.78u w=0.55u l=0.13u
M9 vdd adc8b_0.sar12b_0.sg13cmos5l_dfrbp_1_6.RESET_B a_89266_99057# vdd sg13_lv_pmos ad=0.1563p pd=1.22u as=0.147p ps=1.54u w=0.42u l=0.13u
M10 adc8b_0.sar12b_0.sg13cmos5l_buf_8_0.X a_100995_95814# vdd vdd sg13_lv_pmos ad=0.2128p pd=1.5u as=0.2128p ps=1.5u w=1.12u l=0.13u
M11 vdd sg13cmos5l_Corner_1.vss vdd vdd sg13_lv_pmos ad=0.34p pd=2.68u as=1.12529n ps=7.72949m w=1u l=1u
M12 sg13cmos5l_Corner_1.vss sg13cmos5l_IOPadVdd$1_0.sg13cmos5l_Clamp_N43N43D4R$1_0.gate vdd sg13cmos5l_Corner_1.vss sg13_hv_nmos ad=1.408p pd=5.04u as=2.596p ps=5.58u w=4.4u l=0.6u
M13 sg13cmos5l_IOPadAnalog_12.pad a_131639_164698# sg13cmos5l_Corner_1.iovdd sg13cmos5l_Corner_1.iovdd sg13_hv_pmos ad=3.9294p pd=7.84u as=2.1312p ps=7.3u w=6.66u l=0.6u
M14 data[1] a_86044_42476# sg13cmos5l_Corner_1.iovdd sg13cmos5l_Corner_1.iovdd sg13_hv_pmos ad=3.9294p pd=7.84u as=2.1312p ps=7.3u w=6.66u l=0.6u
M15 sg13cmos5l_Corner_1.iovdd a_118044_42476# cko sg13cmos5l_Corner_1.iovdd sg13_hv_pmos ad=2.1312p pd=7.3u as=3.9294p ps=7.84u w=6.66u l=0.6u
M16 adc8b_0.side_cap8b_0.buf_32_1.z adc8b_0.side_cap8b_0.in_h_sw[0] vddr vddr sg13_lv_pmos ad=0.19p pd=1.38u as=0.19p ps=1.38u w=1u l=0.13u
M17 vdd adc8b_0.sar12b_0.sg13cmos5l_dfrbp_1_6.RESET_B a_90225_98441# vdd sg13_lv_pmos ad=0.2128p pd=1.5u as=0.2128p ps=1.5u w=1.12u l=0.13u
M18 a_97358_95810# a_98163_95932# a_97618_96033# vdd sg13_lv_pmos ad=0.1428p pd=1.52u as=79.8f ps=0.8u w=0.42u l=0.13u
M19 sg13cmos5l_IOPadVdd$1_0.sg13cmos5l_Clamp_N43N43D4R$1_0.gate sg13cmos5l_IOPadVdd$1_0.sg13cmos5l_RCClampInverter$1_0.in vdd vdd sg13_hv_pmos ad=1.33p pd=7.38u as=1.33p ps=7.38u w=7u l=0.5u
M20 adc8b_0.side_cap8b_0.buf_8_3.z adc8b_0.side_cap8b_0.in_h_sw[3] vddr vddr sg13_lv_pmos ad=0.34p pd=2.68u as=0.19p ps=1.38u w=1u l=0.13u
M21 vddr a_42476_70044# sg13cmos5l_Corner_1.iovdd sg13cmos5l_Corner_1.iovdd sg13_hv_pmos ad=3.9294p pd=7.84u as=2.1312p ps=7.3u w=6.66u l=0.6u
M22 adc8b_0.sar12b_0.sg13cmos5l_buf_1_6.A a_94288_94336# vdd vdd sg13_lv_pmos ad=0.42p pd=2.99u as=0.2114p ps=1.54u w=1.12u l=0.13u
M23 a_90207_97338# adc8b_0.sar12b_0.sg13cmos5l_dlhr_1_5.GATE vdd vdd sg13_lv_pmos ad=0.3234p pd=2.45u as=1.04815p ps=6.595u w=0.84u l=0.13u
M24 sg13cmos5l_Corner_1.vss a_134044_30676# frame sg13cmos5l_Corner_1.vss sg13_hv_nmos ad=1.408p pd=5.04u as=2.596p ps=5.58u w=4.4u l=0.6u
X25 a_36456_134755# a_40542_134425# sg13cmos5l_Corner_1.vss rppd l=20u w=1u
M26 adc8b_0.sar12b_0.sg13cmos5l_buf_1_56.A a_90801_97322# vdd vdd sg13_lv_pmos ad=0.3808p pd=2.92u as=0.2128p ps=1.5u w=1.12u l=0.13u
M27 sg13cmos5l_Corner_1.vss adc8b_0.sar12b_0.sg13cmos5l_dfrbp_1_6.RESET_B a_101596_97308# sg13cmos5l_Corner_1.vss sg13_lv_nmos ad=0.1406p pd=1.12u as=77.7f ps=0.95u w=0.74u l=0.13u
M28 sg13cmos5l_Corner_1.vss sg13cmos5l_IOPadVdd$1_0.sg13cmos5l_Clamp_N43N43D4R$1_0.gate vdd sg13cmos5l_Corner_1.vss sg13_hv_nmos ad=1.408p pd=5.04u as=2.596p ps=5.58u w=4.4u l=0.6u
M29 a_84333_99607# adc8b_0.sar12b_0.sg13cmos5l_inv_1_8.A vdd vdd sg13_lv_pmos ad=0.4088p pd=2.97u as=1.12242p ps=7u w=1.12u l=0.13u
M30 vdd a_99160_96030# a_99105_96125# vdd sg13_lv_pmos ad=1.28962p pd=8.195u as=93.45f ps=0.865u w=0.42u l=0.13u
M31 sg13cmos5l_Corner_1.vss a_94583_95421# a_95420_95060# sg13cmos5l_Corner_1.vss sg13_lv_nmos ad=0.1406p pd=1.12u as=0.2516p ps=2.16u w=0.74u l=0.13u
M32 sg13cmos5l_Corner_1.iovdd a_164624_70044# sg13cmos5l_IOPadAnalog_1.pad sg13cmos5l_Corner_1.iovdd sg13_hv_pmos ad=2.1312p pd=7.3u as=3.9294p ps=7.84u w=6.66u l=0.6u
M33 sg13cmos5l_Corner_1.vss a_30676_86044# vin sg13cmos5l_Corner_1.vss sg13_hv_nmos ad=1.408p pd=5.04u as=2.596p ps=5.58u w=4.4u l=0.6u
M34 a_86718_96859# a_86837_96536# vdd vdd sg13_lv_pmos ad=0.3864p pd=2.93u as=0.2128p ps=1.5u w=1.12u l=0.13u
M35 a_88671_94314# adc8b_0.sar12b_0.sg13cmos5l_dlhr_1_0.GATE vdd vdd sg13_lv_pmos ad=0.3234p pd=2.45u as=1.43437p ps=9.105u w=0.84u l=0.13u
M36 data[0] a_70044_42476# sg13cmos5l_Corner_1.iovdd sg13cmos5l_Corner_1.iovdd sg13_hv_pmos ad=3.9294p pd=7.84u as=2.1312p ps=7.3u w=6.66u l=0.6u
M37 sg13cmos5l_IOPadAnalog_0.pad a_178296_86044# sg13cmos5l_Corner_1.vss sg13cmos5l_Corner_1.vss sg13_hv_nmos ad=2.596p pd=5.58u as=1.408p ps=5.04u w=4.4u l=0.6u
M38 a_96244_93548# a_96022_93604# vdd vdd sg13_lv_pmos ad=0.1176p pd=1.33u as=0.2618p ps=1.63u w=1.12u l=0.13u
M39 adc8b_0.side_cap8b_0.buf_8_2.z adc8b_0.side_cap8b_0.in_h_sw[4] sg13cmos5l_Corner_1.vss sg13cmos5l_Corner_1.vss sg13_lv_nmos ad=95f pd=0.88u as=95f ps=0.88u w=0.5u l=0.13u
M40 sg13cmos5l_Corner_1.vss a_83639_178370# sg13cmos5l_IOPadAnalog_9.pad sg13cmos5l_Corner_1.vss sg13_hv_nmos ad=1.408p pd=5.04u as=2.596p ps=5.58u w=4.4u l=0.6u
M41 a_82476_98088# a_82995_98095# a_83735_98445# sg13cmos5l_Corner_1.vss sg13_lv_nmos ad=0.3473p pd=2.71u as=0.12665p ps=1.145u w=0.74u l=0.13u
M42 a_87564_95064# a_87538_95028# sg13cmos5l_Corner_1.vss sg13cmos5l_Corner_1.vss sg13_lv_nmos ad=0.2516p pd=2.16u as=0.1626p ps=1.415u w=0.74u l=0.13u
M43 vddr adc8b_0.sar12b_0.nh_sw[2] adc8b_0.side_cap8b_1.buf_16_0.z vddr sg13_lv_pmos ad=0.19p pd=1.38u as=0.19p ps=1.38u w=1u l=0.13u
M44 vdd a_98036_94262# adc8b_0.sar12b_0.nl_sw[8] vdd sg13_lv_pmos ad=0.2114p pd=1.54u as=0.42p ps=2.99u w=1.12u l=0.13u
M45 sg13cmos5l_Corner_1.vss a_67639_178370# sg13cmos5l_IOPadAnalog_10.pad sg13cmos5l_Corner_1.vss sg13_hv_nmos ad=2.068p pd=9.74u as=2.596p ps=5.58u w=4.4u l=0.6u
M46 a_87564_95064# a_88083_95071# a_88823_95421# sg13cmos5l_Corner_1.vss sg13_lv_nmos ad=0.3473p pd=2.71u as=0.12665p ps=1.145u w=0.74u l=0.13u
M47 vdd sg13cmos5l_Corner_1.vss vdd vdd sg13_lv_pmos ad=0.34p pd=2.68u as=0 ps=0 w=1u l=1u
M48 sg13cmos5l_Corner_1.vss adc8b_0.sar12b_0.sg13cmos5l_dfrbp_1_8.RESET_B a_88766_96997# sg13cmos5l_Corner_1.vss sg13_lv_nmos ad=0.1701p pd=1.65u as=37.8f ps=0.6u w=0.42u l=0.13u
M49 vdd a_88671_94314# a_88802_94308# vdd sg13_lv_pmos ad=1.43437p pd=9.105u as=0.2856p ps=2.36u w=0.84u l=0.13u
M50 sg13cmos5l_Corner_1.iovdd a_42476_86044# vin sg13cmos5l_Corner_1.iovdd sg13_hv_pmos ad=2.1312p pd=7.3u as=3.9294p ps=7.84u w=6.66u l=0.6u
M51 sg13cmos5l_Corner_1.vss adc8b_0.sar12b_0.sg13cmos5l_buf_1_78.A a_87952_100384# sg13cmos5l_Corner_1.vss sg13_lv_nmos ad=0.14875p pd=1.16u as=0.187p ps=1.78u w=0.55u l=0.13u
M52 vdd adc8b_0.sar12b_0.sg13cmos5l_dlygate4sd2_1_0.A a_82670_94302# vdd sg13_lv_pmos ad=0.2481p pd=1.56u as=0.1428p ps=1.52u w=0.42u l=0.13u
M53 a_98894_92786# adc8b_0.sar12b_0.sg13cmos5l_dfrbp_1_0.D vdd vdd sg13_lv_pmos ad=79.8f pd=0.8u as=0.1428p ps=1.52u w=0.42u l=0.13u
M54 sg13cmos5l_Corner_1.vss a_96568_94518# a_96217_94375# sg13cmos5l_Corner_1.vss sg13_lv_nmos ad=79.8f pd=0.8u as=0.1428p ps=1.52u w=0.42u l=0.13u
M55 a_99825_94689# a_99468_94616# vdd vdd sg13_lv_pmos ad=63f pd=0.72u as=0.1563p ps=1.22u w=0.42u l=0.13u
M56 a_100995_95814# adc8b_0.sar12b_0.sg13cmos5l_buf_8_0.A vdd vdd sg13_lv_pmos ad=0.2128p pd=1.5u as=0.2128p ps=1.5u w=1.12u l=0.13u
M57 a_89242_95498# adc8b_0.sar12b_0.sg13cmos5l_dfrbp_1_6.RESET_B sg13cmos5l_Corner_1.vss sg13cmos5l_Corner_1.vss sg13_lv_nmos ad=37.8f pd=0.6u as=79.8f ps=0.8u w=0.42u l=0.13u
M58 sg13cmos5l_IOPadVdd$1_0.sg13cmos5l_Clamp_N43N43D4R$1_0.gate sg13cmos5l_IOPadVdd$1_0.sg13cmos5l_RCClampInverter$1_0.in vdd vdd sg13_hv_pmos ad=1.33p pd=7.38u as=1.33p ps=7.38u w=7u l=0.5u
M59 cks a_42476_118044# sg13cmos5l_Corner_1.iovdd sg13cmos5l_Corner_1.iovdd sg13_hv_pmos ad=3.9294p pd=7.84u as=3.1302p ps=14.26u w=6.66u l=0.6u
M60 a_83916_95064# a_83890_95028# sg13cmos5l_Corner_1.vss sg13cmos5l_Corner_1.vss sg13_lv_nmos ad=0.2516p pd=2.16u as=0.1626p ps=1.415u w=0.74u l=0.13u
M61 adc8b_0.side_cap8b_1.buf_32_0.z adc8b_0.sar12b_0.nl_sw[0] vddr vddr sg13_lv_pmos ad=0.19p pd=1.38u as=0.19p ps=1.38u w=1u l=0.13u
M62 sg13cmos5l_IOPadAnalog_1.pad a_164624_70044# sg13cmos5l_Corner_1.iovdd sg13cmos5l_Corner_1.iovdd sg13_hv_pmos ad=3.9294p pd=7.84u as=2.1312p ps=7.3u w=6.66u l=0.6u
M63 adc8b_0.side_cap8b_1.buf_16_3.z adc8b_0.sar12b_0.nh_sw[1] vddr vddr sg13_lv_pmos ad=0.19p pd=1.38u as=0.19p ps=1.38u w=1u l=0.13u
M64 sg13cmos5l_IOPadAnalog_10.pad a_67639_178370# sg13cmos5l_Corner_1.vss sg13cmos5l_Corner_1.vss sg13_hv_nmos ad=2.596p pd=5.58u as=1.408p ps=5.04u w=4.4u l=0.6u
M65 vdd adc8b_0.sar12b_0.sg13cmos5l_buf_1_73.X a_87568_100384# vdd sg13_lv_pmos ad=0.2114p pd=1.54u as=0.2856p ps=2.36u w=0.84u l=0.13u
M66 a_90897_99643# a_90540_99600# vdd vdd sg13_lv_pmos ad=63f pd=0.72u as=0.1563p ps=1.22u w=0.42u l=0.13u
M67 sg13cmos5l_Corner_1.vss vdd sg13cmos5l_Corner_1.vss sg13cmos5l_Corner_1.vss sg13_lv_nmos ad=0.1428p pd=1.52u as=25.72481n ps=0.04234 w=0.42u l=1u
M68 adc8b_0.side_cap8b_0.buf_8_4.z adc8b_0.side_cap8b_0.in_l_sw[5] vddr vddr sg13_lv_pmos ad=0.19p pd=1.38u as=0.19p ps=1.38u w=1u l=0.13u
M69 a_99548_99596# a_99266_99960# a_99481_99998# sg13cmos5l_Corner_1.vss sg13_lv_nmos ad=0.141p pd=1.17u as=71.99999f ps=0.865u w=0.64u l=0.13u
M70 vdd a_84525_94277# a_84627_94420# vdd sg13_lv_pmos ad=1.43437p pd=9.105u as=0.3864p ps=2.93u w=1.12u l=0.13u
M71 a_84108_94616# a_84627_94420# a_85367_94375# sg13cmos5l_Corner_1.vss sg13_lv_nmos ad=0.3473p pd=2.71u as=0.12665p ps=1.145u w=0.74u l=0.13u
M72 adc8b_0.sar12b_0.sg13cmos5l_buf_1_59.A a_86193_98441# sg13cmos5l_Corner_1.vss sg13cmos5l_Corner_1.vss sg13_lv_nmos ad=0.2516p pd=2.16u as=0.1406p ps=1.12u w=0.74u l=0.13u
M73 sg13cmos5l_IOPadAnalog_9.pad a_83639_164698# sg13cmos5l_Corner_1.iovdd sg13cmos5l_Corner_1.iovdd sg13_hv_pmos ad=3.9294p pd=7.84u as=2.1312p ps=7.3u w=6.66u l=0.6u
M74 a_90254_100034# adc8b_0.sar12b_0.sg13cmos5l_dfrbp_1_18.Q vdd vdd sg13_lv_pmos ad=79.8f pd=0.8u as=0.1428p ps=1.52u w=0.42u l=0.13u
M75 adc8b_0.sar12b_0.sg13cmos5l_dlhr_1_7.Q_N a_86718_98514# sg13cmos5l_Corner_1.vss sg13cmos5l_Corner_1.vss sg13_lv_nmos ad=0.2516p pd=2.16u as=0.1491p ps=1.18u w=0.74u l=0.13u
M76 a_85594_95498# adc8b_0.sar12b_0.sg13cmos5l_dfrbp_1_8.RESET_B sg13cmos5l_Corner_1.vss sg13cmos5l_Corner_1.vss sg13_lv_nmos ad=37.8f pd=0.6u as=79.8f ps=0.8u w=0.42u l=0.13u
M77 sg13cmos5l_Corner_1.iovdd a_164624_102044# sg13cmos5l_IOPadAnalog_16.pad sg13cmos5l_Corner_1.iovdd sg13_hv_pmos ad=2.1312p pd=7.3u as=3.9294p ps=7.84u w=6.66u l=0.6u
M78 sg13cmos5l_Corner_1.vss a_99639_178370# sg13cmos5l_IOPadAnalog_15.pad sg13cmos5l_Corner_1.vss sg13_hv_nmos ad=1.408p pd=5.04u as=2.596p ps=5.58u w=4.4u l=0.6u
M79 sg13cmos5l_Corner_1.vss adc8b_0.sar12b_0.sg13cmos5l_buf_8_2.X a_101776_98872# sg13cmos5l_Corner_1.vss sg13_lv_nmos ad=0.14875p pd=1.16u as=0.187p ps=1.78u w=0.55u l=0.13u
M80 sg13cmos5l_Corner_1.vss adc8b_0.sar12b_0.sg13cmos5l_dfrbp_1_8.RESET_B a_85694_97335# sg13cmos5l_Corner_1.vss sg13_lv_nmos ad=0.1701p pd=1.65u as=37.8f ps=0.6u w=0.42u l=0.13u
M81 a_92086_96572# adc8b_0.sar12b_0.sg13cmos5l_a221oi_1_0.C1 a_92188_96572# vdd sg13_lv_pmos ad=0.3808p pd=2.92u as=0.2128p ps=1.5u w=1.12u l=0.13u
M82 sg13cmos5l_Corner_1.vss vdd sg13cmos5l_Corner_1.vss sg13cmos5l_Corner_1.vss sg13_lv_nmos ad=0.1428p pd=1.52u as=0 ps=0 w=0.42u l=1u
M83 sg13cmos5l_Corner_1.vss a_115639_178370# sg13cmos5l_IOPadAnalog_13.pad sg13cmos5l_Corner_1.vss sg13_hv_nmos ad=1.408p pd=5.04u as=2.596p ps=5.58u w=4.4u l=0.6u
M84 adc8b_0.side_cap8b_0.buf_4_3.z adc8b_0.side_cap8b_0.in_l_sw[6] sg13cmos5l_Corner_1.vss sg13cmos5l_Corner_1.vss sg13_lv_nmos ad=95f pd=0.88u as=95f ps=0.88u w=0.5u l=0.13u
M85 adc8b_0.sar12b_0.sg13cmos5l_buf_1_101.X a_98032_100384# vdd vdd sg13_lv_pmos ad=0.42p pd=2.99u as=0.2114p ps=1.54u w=1.12u l=0.13u
M86 a_98028_97640# a_98002_97545# vdd vdd sg13_lv_pmos ad=0.34p pd=2.68u as=0.36237p ps=2.605u w=1u l=0.13u
M87 sg13cmos5l_Corner_1.vss a_93741_95071# a_93843_95071# sg13cmos5l_Corner_1.vss sg13_lv_nmos ad=2.41737p pd=15.64u as=0.2516p ps=2.16u w=0.74u l=0.13u
M88 sg13cmos5l_Corner_1.vss a_70044_30676# data[0] sg13cmos5l_Corner_1.vss sg13_hv_nmos ad=1.408p pd=5.04u as=2.596p ps=5.58u w=4.4u l=0.6u
M89 sg13cmos5l_Corner_1.vss adc8b_0.sar12b_0.sg13cmos5l_dfrbp_1_6.RESET_B a_95164_98472# sg13cmos5l_Corner_1.vss sg13_lv_nmos ad=0.1406p pd=1.12u as=77.7f ps=0.95u w=0.74u l=0.13u
M90 vdd a_88863_92802# a_88994_92796# vdd sg13_lv_pmos ad=1.86162p pd=11.935u as=0.2856p ps=2.36u w=0.84u l=0.13u
M91 sg13cmos5l_Corner_1.iovdd a_131639_164698# sg13cmos5l_IOPadAnalog_12.pad sg13cmos5l_Corner_1.iovdd sg13_hv_pmos ad=2.1312p pd=7.3u as=3.9294p ps=7.84u w=6.66u l=0.6u
M92 sg13cmos5l_Corner_1.iovdd a_42476_118044# cks sg13cmos5l_Corner_1.iovdd sg13_hv_pmos ad=2.1312p pd=7.3u as=3.9294p ps=7.84u w=6.66u l=0.6u
M93 sg13cmos5l_Corner_1.vss adc8b_0.sar12b_0.sg13cmos5l_buf_1_62.X a_83632_100384# sg13cmos5l_Corner_1.vss sg13_lv_nmos ad=0.14875p pd=1.16u as=0.187p ps=1.78u w=0.55u l=0.13u
M94 vddr adc8b_0.sar12b_0.nh_sw[0] adc8b_0.side_cap8b_1.buf_32_1.z vddr sg13_lv_pmos ad=0.19p pd=1.38u as=0.19p ps=1.38u w=1u l=0.13u
M95 a_86286_99156# a_86117_98796# a_85844_98784# vdd sg13_lv_pmos ad=0.105p pd=1.21u as=0.191p ps=1.44u w=1u l=0.13u
M96 a_92950_95836# adc8b_0.sar12b_0.sg13cmos5l_a221oi_1_0.A2 sg13cmos5l_Corner_1.vss sg13cmos5l_Corner_1.vss sg13_lv_nmos ad=0.1406p pd=1.12u as=0.2516p ps=2.16u w=0.74u l=0.13u
M97 sg13cmos5l_IOPadAnalog_1.pad a_164624_70044# sg13cmos5l_Corner_1.iovdd sg13cmos5l_Corner_1.iovdd sg13_hv_pmos ad=3.9294p pd=7.84u as=3.1302p ps=14.26u w=6.66u l=0.6u
M98 a_96692_92750# adc8b_0.sar12b_0.sg13cmos5l_buf_1_6.A vdd vdd sg13_lv_pmos ad=0.2856p pd=2.36u as=0.2114p ps=1.54u w=0.84u l=0.13u
M99 adc8b_0.sar12b_0.sg13cmos5l_dlhr_1_16.Q a_100977_96929# sg13cmos5l_Corner_1.vss sg13cmos5l_Corner_1.vss sg13_lv_nmos ad=0.2516p pd=2.16u as=0.1406p ps=1.12u w=0.74u l=0.13u
M100 sg13cmos5l_Corner_1.vss adc8b_0.sar12b_0.nl_sw[4] adc8b_0.side_cap8b_1.buf_8_0.z sg13cmos5l_Corner_1.vss sg13_lv_nmos ad=95f pd=0.88u as=0.17p ps=1.68u w=0.5u l=0.13u
M101 adc8b_0.side_cap8b_0.buf_16_1.z adc8b_0.side_cap8b_0.in_l_sw[2] vddr vddr sg13_lv_pmos ad=0.19p pd=1.38u as=0.19p ps=1.38u w=1u l=0.13u
M102 adc8b_0.sar12b_0.sg13cmos5l_inv_1_29.A a_94172_99132# vdd vdd sg13_lv_pmos ad=0.3808p pd=2.92u as=0.2128p ps=1.5u w=1.12u l=0.13u
M103 sg13cmos5l_IOPadAnalog_0.pad a_164624_86044# sg13cmos5l_Corner_1.iovdd sg13cmos5l_Corner_1.iovdd sg13_hv_pmos ad=3.9294p pd=7.84u as=2.1312p ps=7.3u w=6.66u l=0.6u
X104 sg13cmos5l_Corner_1.vss sg13cmos5l_IOPadAnalog_15.padres dantenna l=3.1u w=0.64u
M105 adc8b_0.sar12b_0.sg13cmos5l_dlhr_1_16.Q_N a_101502_97002# sg13cmos5l_Corner_1.vss sg13cmos5l_Corner_1.vss sg13_lv_nmos ad=0.2516p pd=2.16u as=0.1491p ps=1.18u w=0.74u l=0.13u
M106 a_97972_95498# a_97589_95024# vdd vdd sg13_lv_pmos ad=79.8f pd=0.8u as=0.2639p ps=1.81u w=0.42u l=0.13u
M107 vdd adc8b_0.sar12b_0.sg13cmos5l_dfrbp_1_0.RESET_B a_93298_93009# vdd sg13_lv_pmos ad=0.1563p pd=1.22u as=0.147p ps=1.54u w=0.42u l=0.13u
M108 a_85628_93548# a_85346_93912# a_85561_93950# sg13cmos5l_Corner_1.vss sg13_lv_nmos ad=0.141p pd=1.17u as=71.99999f ps=0.865u w=0.64u l=0.13u
M109 vdd sg13cmos5l_IOPadVdd$1_0.sg13cmos5l_Clamp_N43N43D4R$1_0.gate sg13cmos5l_Corner_1.vss sg13cmos5l_Corner_1.vss sg13_hv_nmos ad=2.596p pd=5.58u as=1.408p ps=5.04u w=4.4u l=0.6u
M110 adc8b_0.side_cap8b_1.buf_16_3.z adc8b_0.sar12b_0.nh_sw[1] sg13cmos5l_Corner_1.vss sg13cmos5l_Corner_1.vss sg13_lv_nmos ad=95f pd=0.88u as=95f ps=0.88u w=0.5u l=0.13u
M111 vdd adc8b_0.sar12b_0.sg13cmos5l_buf_1_74.X a_88336_100384# vdd sg13_lv_pmos ad=0.2114p pd=1.54u as=0.2856p ps=2.36u w=0.84u l=0.13u
M112 sg13cmos5l_IOPadAnalog_1.pad a_164624_70044# sg13cmos5l_Corner_1.iovdd sg13cmos5l_Corner_1.iovdd sg13_hv_pmos ad=3.9294p pd=7.84u as=2.1312p ps=7.3u w=6.66u l=0.6u
M113 sg13cmos5l_IOPadAnalog_16.pad a_164624_102044# sg13cmos5l_Corner_1.iovdd sg13cmos5l_Corner_1.iovdd sg13_hv_pmos ad=3.9294p pd=7.84u as=2.1312p ps=7.3u w=6.66u l=0.6u
M114 a_92076_99152# a_92595_98956# a_93335_98911# sg13cmos5l_Corner_1.vss sg13_lv_nmos ad=0.3473p pd=2.71u as=0.12665p ps=1.145u w=0.74u l=0.13u
M115 a_99468_92799# a_99180_93104# a_99406_92799# sg13cmos5l_Corner_1.vss sg13_lv_nmos ad=0.1428p pd=1.52u as=37.8f ps=0.6u w=0.42u l=0.13u
M116 sg13cmos5l_IOPadAnalog_12.pad a_131639_164698# sg13cmos5l_Corner_1.iovdd sg13cmos5l_Corner_1.iovdd sg13_hv_pmos ad=3.9294p pd=7.84u as=3.1302p ps=14.26u w=6.66u l=0.6u
M117 sg13cmos5l_IOPadAnalog_13.pad a_115639_164698# sg13cmos5l_Corner_1.iovdd sg13cmos5l_Corner_1.iovdd sg13_hv_pmos ad=3.9294p pd=7.84u as=2.1312p ps=7.3u w=6.66u l=0.6u
M118 a_100995_100350# cks vdd vdd sg13_lv_pmos ad=0.2128p pd=1.5u as=0.2128p ps=1.5u w=1.12u l=0.13u
M119 vdd a_83992_98326# a_83937_98207# vdd sg13_lv_pmos ad=1.07253p pd=6.75u as=93.45f ps=0.865u w=0.42u l=0.13u
M120 a_95800_97542# adc8b_0.sar12b_0.sg13cmos5l_dfrbp_1_6.RESET_B vdd vdd sg13_lv_pmos ad=79.8f pd=0.8u as=1.04815p ps=6.595u w=0.42u l=0.13u
M121 vdd a_85773_95789# a_85875_95932# vdd sg13_lv_pmos ad=1.28962p pd=8.195u as=0.3864p ps=2.93u w=1.12u l=0.13u
M122 vdd adc8b_0.cmp_0.clk adc8b_0.cmp_0.outp vdd sg13_lv_pmos ad=95f pd=0.88u as=0.17p ps=1.68u w=0.5u l=0.13u
M123 vdd a_90808_99054# a_90753_99149# vdd sg13_lv_pmos ad=1.15047p pd=7.175u as=93.45f ps=0.865u w=0.42u l=0.13u
M124 sg13cmos5l_Corner_1.vss a_100113_98834# a_100068_98870# sg13cmos5l_Corner_1.vss sg13_lv_nmos ad=0.1428p pd=1.52u as=47.25f ps=0.645u w=0.42u l=0.13u
M125 a_84108_94616# a_84082_94521# vdd vdd sg13_lv_pmos ad=0.34p pd=2.68u as=0.36237p ps=2.605u w=1u l=0.13u
M126 vddr adc8b_0.side_cap8b_0.in_l_sw[9] adc8b_0.side_cap8b_0.buf_2_2.z vddr sg13_lv_pmos ad=0.19p pd=1.38u as=0.34p ps=2.68u w=1u l=0.13u
M127 adc8b_0.side_cap8b_0.buf_4_2.z adc8b_0.side_cap8b_0.in_h_sw[7] sg13cmos5l_Corner_1.vss sg13cmos5l_Corner_1.vss sg13_lv_nmos ad=95f pd=0.88u as=95f ps=0.88u w=0.5u l=0.13u
M128 sg13cmos5l_Corner_1.vss adc8b_0.sar12b_0.sg13cmos5l_buf_1_31.X a_83440_94336# sg13cmos5l_Corner_1.vss sg13_lv_nmos ad=0.14875p pd=1.16u as=0.187p ps=1.78u w=0.55u l=0.13u
M129 adc8b_0.side_cap8b_1.buf_8_2.z adc8b_0.sar12b_0.nh_sw[4] sg13cmos5l_Corner_1.vss sg13cmos5l_Corner_1.vss sg13_lv_nmos ad=0.17p pd=1.68u as=95f ps=0.88u w=0.5u l=0.13u
X130 a_36456_138055# a_40542_137725# sg13cmos5l_Corner_1.vss rppd l=20u w=1u
M131 sg13cmos5l_Corner_1.vss a_95409_98834# a_95364_98870# sg13cmos5l_Corner_1.vss sg13_lv_nmos ad=0.1428p pd=1.52u as=47.25f ps=0.645u w=0.42u l=0.13u
M132 a_86718_96859# a_86837_96536# sg13cmos5l_Corner_1.vss sg13cmos5l_Corner_1.vss sg13_lv_nmos ad=0.2516p pd=2.16u as=0.1406p ps=1.12u w=0.74u l=0.13u
M133 adc8b_0.side_cap8b_1.buf_32_1.z adc8b_0.sar12b_0.nh_sw[0] sg13cmos5l_Corner_1.vss sg13cmos5l_Corner_1.vss sg13_lv_nmos ad=95f pd=0.88u as=95f ps=0.88u w=0.5u l=0.13u
M134 adc8b_0.sar12b_0.sg13cmos5l_a22oi_1_1.B2 adc8b_0.sar12b_0.sg13cmos5l_and3_1_0.X a_95466_96572# vdd sg13_lv_pmos ad=0.3808p pd=2.92u as=0.2128p ps=1.5u w=1.12u l=0.13u
M135 sg13cmos5l_Corner_1.vss adc8b_0.sar12b_0.nh_sw[0] adc8b_0.side_cap8b_1.buf_32_1.z sg13cmos5l_Corner_1.vss sg13_lv_nmos ad=95f pd=0.88u as=95f ps=0.88u w=0.5u l=0.13u
M136 sg13cmos5l_Corner_1.iovdd a_42476_102044# vip sg13cmos5l_Corner_1.iovdd sg13_hv_pmos ad=2.1312p pd=7.3u as=3.9294p ps=7.84u w=6.66u l=0.6u
M137 sg13cmos5l_Corner_1.iovdd a_134044_42476# frame sg13cmos5l_Corner_1.iovdd sg13_hv_pmos ad=2.1312p pd=7.3u as=3.9294p ps=7.84u w=6.66u l=0.6u
M138 adc8b_0.side_cap8b_0.buf_16_3.z adc8b_0.side_cap8b_0.in_h_sw[1] sg13cmos5l_Corner_1.vss sg13cmos5l_Corner_1.vss sg13_lv_nmos ad=95f pd=0.88u as=95f ps=0.88u w=0.5u l=0.13u
M139 adc8b_0.sar12b_0.sg13cmos5l_dlhr_1_0.GATE a_87452_96108# vdd vdd sg13_lv_pmos ad=0.3808p pd=2.92u as=0.2128p ps=1.5u w=1.12u l=0.13u
M140 vdd adc8b_0.sar12b_0.sg13cmos5l_buf_1_39.A a_85456_92824# vdd sg13_lv_pmos ad=0.2114p pd=1.54u as=0.2856p ps=2.36u w=0.84u l=0.13u
M141 sg13cmos5l_IOPadVdd$1_0.sg13cmos5l_Clamp_N43N43D4R$1_0.gate sg13cmos5l_IOPadVdd$1_0.sg13cmos5l_RCClampInverter$1_0.in vdd vdd sg13_hv_pmos ad=1.33p pd=7.38u as=1.33p ps=7.38u w=7u l=0.5u
M142 vdd adc8b_0.sar12b_0.sg13cmos5l_buf_1_34.X adc8b_0.sar12b_0.sg13cmos5l_buf_1_60.A vdd sg13_lv_pmos ad=0.3808p pd=2.92u as=0.3808p ps=2.92u w=1.12u l=0.13u
M143 sg13cmos5l_Corner_1.vss a_67639_178370# sg13cmos5l_IOPadAnalog_10.pad sg13cmos5l_Corner_1.vss sg13_hv_nmos ad=1.408p pd=5.04u as=2.596p ps=5.58u w=4.4u l=0.6u
M144 vddr adc8b_0.side_cap8b_0.in_h_sw[2] adc8b_0.side_cap8b_0.buf_16_0.z vddr sg13_lv_pmos ad=0.19p pd=1.38u as=0.19p ps=1.38u w=1u l=0.13u
M145 a_96476_98084# a_96063_98442# a_96408_98084# vdd sg13_lv_pmos ad=0.191p pd=1.44u as=0.105p ps=1.21u w=1u l=0.13u
M146 sg13cmos5l_IOPadAnalog_11.pad a_164624_118044# sg13cmos5l_Corner_1.iovdd sg13cmos5l_Corner_1.iovdd sg13_hv_pmos ad=3.9294p pd=7.84u as=2.1312p ps=7.3u w=6.66u l=0.6u
M147 vdd sg13cmos5l_IOPadVdd$1_0.sg13cmos5l_Clamp_N43N43D4R$1_0.gate sg13cmos5l_Corner_1.vss sg13cmos5l_Corner_1.vss sg13_hv_nmos ad=2.596p pd=5.58u as=1.408p ps=5.04u w=4.4u l=0.6u
M148 adc8b_0.sar12b_0.sg13cmos5l_dlhr_1_11.Q a_94929_98441# vdd vdd sg13_lv_pmos ad=0.3808p pd=2.92u as=0.2128p ps=1.5u w=1.12u l=0.13u
M149 a_95469_94277# adc8b_0.sar12b_0.sg13cmos5l_dfrbp_1_0.CLK vdd vdd sg13_lv_pmos ad=0.4088p pd=2.97u as=1.38655p ps=8.8u w=1.12u l=0.13u
M150 adc8b_0.side_cap8b_1.buf_16_0.z adc8b_0.sar12b_0.nh_sw[2] vddr vddr sg13_lv_pmos ad=0.19p pd=1.38u as=0.19p ps=1.38u w=1u l=0.13u
M151 sg13cmos5l_Corner_1.iovdd a_118044_42476# cko sg13cmos5l_Corner_1.iovdd sg13_hv_pmos ad=2.1312p pd=7.3u as=3.9294p ps=7.84u w=6.66u l=0.6u
M152 data[1] a_86044_30676# sg13cmos5l_Corner_1.vss sg13cmos5l_Corner_1.vss sg13_hv_nmos ad=2.596p pd=5.58u as=1.408p ps=5.04u w=4.4u l=0.6u
M153 sg13cmos5l_Corner_1.vss adc8b_0.sar12b_0.sg13cmos5l_inv_1_19.A adc8b_0.sar12b_0.sg13cmos5l_buf_1_32.A sg13cmos5l_Corner_1.vss sg13_lv_nmos ad=0.2516p pd=2.16u as=0.2516p ps=2.16u w=0.74u l=0.13u
M154 sg13cmos5l_Corner_1.vss adc8b_0.side_cap8b_0.in_h_sw[2] adc8b_0.side_cap8b_0.buf_16_0.z sg13cmos5l_Corner_1.vss sg13_lv_nmos ad=95f pd=0.88u as=0.17p ps=1.68u w=0.5u l=0.13u
M155 data[1] a_86044_42476# sg13cmos5l_Corner_1.iovdd sg13cmos5l_Corner_1.iovdd sg13_hv_pmos ad=3.9294p pd=7.84u as=2.1312p ps=7.3u w=6.66u l=0.6u
M156 a_90879_95826# adc8b_0.sar12b_0.sg13cmos5l_dfrbp_1_11.Q sg13cmos5l_Corner_1.vss sg13cmos5l_Corner_1.vss sg13_lv_nmos ad=0.2516p pd=2.16u as=0.15055p ps=1.17u w=0.74u l=0.13u
M157 sg13cmos5l_Corner_1.iovdd a_42476_118044# cks sg13cmos5l_Corner_1.iovdd sg13_hv_pmos ad=2.1312p pd=7.3u as=3.9294p ps=7.84u w=6.66u l=0.6u
M158 a_100628_100310# adc8b_0.sar12b_0.sg13cmos5l_buf_1_101.X vdd vdd sg13_lv_pmos ad=0.2856p pd=2.36u as=0.2114p ps=1.54u w=0.84u l=0.13u
M159 a_94906_93986# adc8b_0.sar12b_0.sg13cmos5l_dfrbp_1_0.RESET_B sg13cmos5l_Corner_1.vss sg13cmos5l_Corner_1.vss sg13_lv_nmos ad=37.8f pd=0.6u as=79.8f ps=0.8u w=0.42u l=0.13u
M160 a_93335_98911# a_92493_98813# a_93241_98911# sg13cmos5l_Corner_1.vss sg13_lv_nmos ad=0.12665p pd=1.145u as=0.1428p ps=1.52u w=0.42u l=0.13u
M161 a_82702_98509# adc8b_0.sar12b_0.sg13cmos5l_dfrbp_1_6.RESET_B sg13cmos5l_Corner_1.vss sg13cmos5l_Corner_1.vss sg13_lv_nmos ad=37.8f pd=0.6u as=0.1701p ps=1.65u w=0.42u l=0.13u
M162 cko a_118044_30676# sg13cmos5l_Corner_1.vss sg13cmos5l_Corner_1.vss sg13_hv_nmos ad=2.596p pd=5.58u as=1.408p ps=5.04u w=4.4u l=0.6u
M163 adc8b_0.sar12b_0.sg13cmos5l_nand2_1_2.B adc8b_0.sar12b_0.sg13cmos5l_or2_1_0.A a_82418_95060# vdd sg13_lv_pmos ad=0.3808p pd=2.92u as=0.1176p ps=1.33u w=1.12u l=0.13u
M164 vddr adc8b_0.sar12b_0.nl_sw[0] adc8b_0.side_cap8b_1.buf_32_0.z vddr sg13_lv_pmos ad=0.19p pd=1.38u as=0.19p ps=1.38u w=1u l=0.13u
M165 a_83348_93512# adc8b_0.sar12b_0.sg13cmos5l_buf_1_40.X sg13cmos5l_Corner_1.vss sg13cmos5l_Corner_1.vss sg13_lv_nmos ad=0.187p pd=1.78u as=0.14875p ps=1.16u w=0.55u l=0.13u
M166 vdd sg13cmos5l_IOPadVdd$1_0.sg13cmos5l_Clamp_N43N43D4R$1_0.gate sg13cmos5l_Corner_1.vss sg13cmos5l_Corner_1.vss sg13_hv_nmos ad=2.596p pd=5.58u as=1.408p ps=5.04u w=4.4u l=0.6u
M167 adc8b_0.side_cap8b_0.buf_8_0.z adc8b_0.side_cap8b_0.in_l_sw[4] sg13cmos5l_Corner_1.vss sg13cmos5l_Corner_1.vss sg13_lv_nmos ad=95f pd=0.88u as=95f ps=0.88u w=0.5u l=0.13u
M168 a_98028_97640# a_98002_97545# sg13cmos5l_Corner_1.vss sg13cmos5l_Corner_1.vss sg13_lv_nmos ad=0.2516p pd=2.16u as=0.1626p ps=1.415u w=0.74u l=0.13u
M169 adc8b_0.sar12b_0.sg13cmos5l_buf_1_45.A a_90609_96929# vdd vdd sg13_lv_pmos ad=0.3808p pd=2.92u as=0.2128p ps=1.5u w=1.12u l=0.13u
M170 sg13cmos5l_Corner_1.vss adc8b_0.sar12b_0.nl_sw[3] adc8b_0.side_cap8b_1.buf_8_1.z sg13cmos5l_Corner_1.vss sg13_lv_nmos ad=95f pd=0.88u as=95f ps=0.88u w=0.5u l=0.13u
M171 sg13cmos5l_IOPadAnalog_9.pad a_83639_164698# sg13cmos5l_Corner_1.iovdd sg13cmos5l_Corner_1.iovdd sg13_hv_pmos ad=3.9294p pd=7.84u as=2.1312p ps=7.3u w=6.66u l=0.6u
M172 sg13cmos5l_Corner_1.vss adc8b_0.side_cap8b_0.in_l_sw[0] adc8b_0.side_cap8b_0.buf_32_0.z sg13cmos5l_Corner_1.vss sg13_lv_nmos ad=95f pd=0.88u as=95f ps=0.88u w=0.5u l=0.13u
M173 sg13cmos5l_IOPadVdd$1_0.sg13cmos5l_Clamp_N43N43D4R$1_0.gate sg13cmos5l_IOPadVdd$1_0.sg13cmos5l_RCClampInverter$1_0.in vdd vdd sg13_hv_pmos ad=1.33p pd=7.38u as=1.33p ps=7.38u w=7u l=0.5u
M174 vin a_42476_86044# sg13cmos5l_Corner_1.iovdd sg13cmos5l_Corner_1.iovdd sg13_hv_pmos ad=3.9294p pd=7.84u as=2.1312p ps=7.3u w=6.66u l=0.6u
M175 sg13cmos5l_Corner_1.iovdd a_115639_164698# sg13cmos5l_IOPadAnalog_13.pad sg13cmos5l_Corner_1.iovdd sg13_hv_pmos ad=2.1312p pd=7.3u as=3.9294p ps=7.84u w=6.66u l=0.6u
M176 adc8b_0.side_cap8b_0.buf_16_2.z adc8b_0.side_cap8b_0.in_l_sw[1] vddr vddr sg13_lv_pmos ad=0.19p pd=1.38u as=0.19p ps=1.38u w=1u l=0.13u
X177 sg13cmos5l_Corner_1.vss a_92462_57198# dantenna l=3.1u w=0.64u
M178 sg13cmos5l_Corner_1.iovdd a_164624_86044# sg13cmos5l_IOPadAnalog_0.pad sg13cmos5l_Corner_1.iovdd sg13_hv_pmos ad=2.1312p pd=7.3u as=3.9294p ps=7.84u w=6.66u l=0.6u
M179 adc8b_0.sar12b_0.sg13cmos5l_dfrbp_1_0.D adc8b_0.sar12b_0.sg13cmos5l_nor2_1_1.A sg13cmos5l_Corner_1.vss sg13cmos5l_Corner_1.vss sg13_lv_nmos ad=0.1406p pd=1.12u as=0.2516p ps=2.16u w=0.74u l=0.13u
M180 sg13cmos5l_Corner_1.iovdd a_70044_42476# data[0] sg13cmos5l_Corner_1.iovdd sg13_hv_pmos ad=2.1312p pd=7.3u as=3.9294p ps=7.84u w=6.66u l=0.6u
M181 sg13cmos5l_Corner_1.iovdd a_131639_164698# sg13cmos5l_IOPadAnalog_12.pad sg13cmos5l_Corner_1.iovdd sg13_hv_pmos ad=2.1312p pd=7.3u as=3.9294p ps=7.84u w=6.66u l=0.6u
M182 adc8b_0.side_cap8b_1.buf_8_1.z adc8b_0.sar12b_0.nl_sw[3] vddr vddr sg13_lv_pmos ad=0.19p pd=1.38u as=0.19p ps=1.38u w=1u l=0.13u
M183 sg13cmos5l_Corner_1.vss adc8b_0.sar12b_0.nl_sw[1] adc8b_0.side_cap8b_1.buf_16_2.z sg13cmos5l_Corner_1.vss sg13_lv_nmos ad=95f pd=0.88u as=95f ps=0.88u w=0.5u l=0.13u
M184 vdd a_96311_94375# a_97148_94596# vdd sg13_lv_pmos ad=0.2128p pd=1.5u as=0.3864p ps=2.93u w=1.12u l=0.13u
M185 a_87182_97322# adc8b_0.sar12b_0.sg13cmos5l_dfrbp_1_6.D vdd vdd sg13_lv_pmos ad=79.8f pd=0.8u as=0.1428p ps=1.52u w=0.42u l=0.13u
M186 a_93298_95028# a_93741_95071# a_93681_95107# vdd sg13_lv_pmos ad=79.8f pd=0.8u as=63f ps=0.72u w=0.42u l=0.13u
M187 adc8b_0.side_cap8b_1.buf_8_5.z adc8b_0.sar12b_0.nh_sw[5] vddr vddr sg13_lv_pmos ad=0.19p pd=1.38u as=0.19p ps=1.38u w=1u l=0.13u
M188 a_99468_94616# a_99442_94521# sg13cmos5l_Corner_1.vss sg13cmos5l_Corner_1.vss sg13_lv_nmos ad=0.2516p pd=2.16u as=0.1626p ps=1.415u w=0.74u l=0.13u
M189 vdd sg13cmos5l_IOPadVdd$1_0.sg13cmos5l_Clamp_N43N43D4R$1_0.gate sg13cmos5l_Corner_1.vss sg13cmos5l_Corner_1.vss sg13_hv_nmos ad=2.596p pd=5.58u as=1.408p ps=5.04u w=4.4u l=0.6u
M190 a_76796_95659# adc8b_0.cmp_0.clk vdd vdd sg13_lv_pmos ad=0.17p pd=1.68u as=95f ps=0.88u w=0.5u l=0.13u
M191 sg13cmos5l_Corner_1.vss a_102044_30676# data[2] sg13cmos5l_Corner_1.vss sg13_hv_nmos ad=2.068p pd=9.74u as=2.596p ps=5.58u w=4.4u l=0.6u
M192 sg13cmos5l_Corner_1.vss a_102044_30676# data[2] sg13cmos5l_Corner_1.vss sg13_hv_nmos ad=1.408p pd=5.04u as=2.596p ps=5.58u w=4.4u l=0.6u
M193 data[1] a_86044_42476# sg13cmos5l_Corner_1.iovdd sg13cmos5l_Corner_1.iovdd sg13_hv_pmos ad=3.9294p pd=7.84u as=2.1312p ps=7.3u w=6.66u l=0.6u
M194 adc8b_0.sar12b_0.sg13cmos5l_dlhr_1_0.Q_N a_89982_92768# sg13cmos5l_Corner_1.vss sg13cmos5l_Corner_1.vss sg13_lv_nmos ad=0.2516p pd=2.16u as=0.1491p ps=1.18u w=0.74u l=0.13u
M195 adc8b_0.sar12b_0.sg13cmos5l_nor2_1_1.A a_99356_93548# sg13cmos5l_Corner_1.vss sg13cmos5l_Corner_1.vss sg13_lv_nmos ad=0.2516p pd=2.16u as=0.1406p ps=1.12u w=0.74u l=0.13u
M196 sg13cmos5l_Corner_1.iovdd a_42476_102044# vip sg13cmos5l_Corner_1.iovdd sg13_hv_pmos ad=2.1312p pd=7.3u as=3.9294p ps=7.84u w=6.66u l=0.6u
M197 adc8b_0.sar12b_0.sg13cmos5l_dlhr_1_20.Q_N a_91998_95792# vdd vdd sg13_lv_pmos ad=0.3808p pd=2.92u as=0.1974p ps=1.5u w=1.12u l=0.13u
M198 adc8b_0.side_cap8b_1.buf_16_2.z adc8b_0.sar12b_0.nl_sw[1] vddr vddr sg13_lv_pmos ad=0.19p pd=1.38u as=0.19p ps=1.38u w=1u l=0.13u
M199 vdd adc8b_0.sar12b_0.sg13cmos5l_dfrbp_1_0.RESET_B a_92942_93986# vdd sg13_lv_pmos ad=0.36237p pd=2.605u as=79.8f ps=0.8u w=0.42u l=0.13u
M200 a_91028_93512# adc8b_0.sar12b_0.sg13cmos5l_buf_1_30.X sg13cmos5l_Corner_1.vss sg13cmos5l_Corner_1.vss sg13_lv_nmos ad=0.187p pd=1.78u as=0.14875p ps=1.16u w=0.55u l=0.13u
M201 sg13cmos5l_Corner_1.vss a_87405_93559# a_87507_93559# sg13cmos5l_Corner_1.vss sg13_lv_nmos ad=2.59257p pd=16.445u as=0.2516p ps=2.16u w=0.74u l=0.13u
M202 vdd a_83170_95024# a_82889_95326# vdd sg13_lv_pmos ad=0.1523p pd=1.38u as=0.34p ps=2.68u w=1u l=0.5u
M203 sg13cmos5l_Corner_1.iovdd a_164624_118044# sg13cmos5l_IOPadAnalog_11.pad sg13cmos5l_Corner_1.iovdd sg13_hv_pmos ad=2.1312p pd=7.3u as=3.9294p ps=7.84u w=6.66u l=0.6u
M204 adc8b_0.side_cap8b_1.buf_8_4.z adc8b_0.sar12b_0.nl_sw[5] sg13cmos5l_Corner_1.vss sg13cmos5l_Corner_1.vss sg13_lv_nmos ad=0.17p pd=1.68u as=95f ps=0.88u w=0.5u l=0.13u
M205 sg13cmos5l_Corner_1.vss adc8b_0.sar12b_0.nh_sw[1] adc8b_0.side_cap8b_1.buf_16_3.z sg13cmos5l_Corner_1.vss sg13_lv_nmos ad=95f pd=0.88u as=95f ps=0.88u w=0.5u l=0.13u
M206 sg13cmos5l_Corner_1.vss sg13cmos5l_IOPadVdd$1_0.sg13cmos5l_Clamp_N43N43D4R$1_0.gate vdd sg13cmos5l_Corner_1.vss sg13_hv_nmos ad=1.408p pd=5.04u as=2.596p ps=5.58u w=4.4u l=0.6u
M207 adc8b_0.side_cap8b_1.buf_32_0.z adc8b_0.sar12b_0.nl_sw[0] sg13cmos5l_Corner_1.vss sg13cmos5l_Corner_1.vss sg13_lv_nmos ad=95f pd=0.88u as=95f ps=0.88u w=0.5u l=0.13u
M208 a_95002_92786# adc8b_0.sar12b_0.sg13cmos5l_dfrbp_1_0.RESET_B sg13cmos5l_Corner_1.vss sg13cmos5l_Corner_1.vss sg13_lv_nmos ad=37.8f pd=0.6u as=79.8f ps=0.8u w=0.42u l=0.13u
M209 sg13cmos5l_Corner_1.vss sg13cmos5l_IOPadVdd$1_0.sg13cmos5l_Clamp_N43N43D4R$1_0.gate vdd sg13cmos5l_Corner_1.vss sg13_hv_nmos ad=1.408p pd=5.04u as=2.596p ps=5.58u w=4.4u l=0.6u
M210 sg13cmos5l_IOPadVdd$1_0.sg13cmos5l_Clamp_N43N43D4R$1_0.gate sg13cmos5l_IOPadVdd$1_0.sg13cmos5l_RCClampInverter$1_0.in vdd vdd sg13_hv_pmos ad=1.33p pd=7.38u as=1.33p ps=7.38u w=7u l=0.5u
M211 adc8b_0.side_cap8b_0.in_h_sw[2] a_85744_100384# vdd vdd sg13_lv_pmos ad=0.42p pd=2.99u as=0.2114p ps=1.54u w=1.12u l=0.13u
M212 sg13cmos5l_Corner_1.vss vdd sg13cmos5l_Corner_1.vss sg13cmos5l_Corner_1.vss sg13_lv_nmos ad=0.1428p pd=1.52u as=0 ps=0 w=0.42u l=1u
M213 sg13cmos5l_Corner_1.vss a_178296_118044# sg13cmos5l_IOPadAnalog_11.pad sg13cmos5l_Corner_1.vss sg13_hv_nmos ad=1.408p pd=5.04u as=2.596p ps=5.58u w=4.4u l=0.6u
X214 sg13cmos5l_Corner_1.iovdd a_99639_164698# sg13cmos5l_Corner_1.iovdd rppd l=12.9u w=0.5u
M215 sg13cmos5l_Corner_1.vss a_30676_70044# vddr sg13cmos5l_Corner_1.vss sg13_hv_nmos ad=1.408p pd=5.04u as=2.596p ps=5.58u w=4.4u l=0.6u
M216 a_84500_100310# adc8b_0.sar12b_0.sg13cmos5l_inv_1_20.Y vdd vdd sg13_lv_pmos ad=0.2856p pd=2.36u as=0.2114p ps=1.54u w=0.84u l=0.13u
M217 sg13cmos5l_Corner_1.vss a_84177_95810# a_84702_95792# sg13cmos5l_Corner_1.vss sg13_lv_nmos ad=0.1491p pd=1.18u as=0.187p ps=1.78u w=0.55u l=0.13u
M218 a_100628_98048# adc8b_0.sar12b_0.sg13cmos5l_buf_1_87.A vdd vdd sg13_lv_pmos ad=0.2856p pd=2.36u as=0.2114p ps=1.54u w=0.84u l=0.13u
M219 sg13cmos5l_IOPadAnalog_1.pad a_178296_70044# sg13cmos5l_Corner_1.vss sg13cmos5l_Corner_1.vss sg13_hv_nmos ad=2.596p pd=5.58u as=1.408p ps=5.04u w=4.4u l=0.6u
M220 sg13cmos5l_Corner_1.iovdd a_164624_86044# sg13cmos5l_IOPadAnalog_0.pad sg13cmos5l_Corner_1.iovdd sg13_hv_pmos ad=2.1312p pd=7.3u as=3.9294p ps=7.84u w=6.66u l=0.6u
M221 sg13cmos5l_Corner_1.iovdd a_164624_118044# sg13cmos5l_IOPadAnalog_11.pad sg13cmos5l_Corner_1.iovdd sg13_hv_pmos ad=2.1312p pd=7.3u as=3.9294p ps=7.84u w=6.66u l=0.6u
M222 adc8b_0.side_cap8b_0.buf_32_1.z adc8b_0.side_cap8b_0.in_h_sw[0] vddr vddr sg13_lv_pmos ad=0.19p pd=1.38u as=0.19p ps=1.38u w=1u l=0.13u
M223 adc8b_0.side_cap8b_0.in_l_sw[5] a_89104_100384# sg13cmos5l_Corner_1.vss sg13cmos5l_Corner_1.vss sg13_lv_nmos ad=0.2886p pd=2.26u as=0.14875p ps=1.16u w=0.74u l=0.13u
M224 sg13cmos5l_Corner_1.vss a_90957_99607# a_91059_99607# sg13cmos5l_Corner_1.vss sg13_lv_nmos ad=2.92392p pd=18.89u as=0.2516p ps=2.16u w=0.74u l=0.13u
M225 sg13cmos5l_IOPadAnalog_15.pad a_99639_164698# sg13cmos5l_Corner_1.iovdd sg13cmos5l_Corner_1.iovdd sg13_hv_pmos ad=3.9294p pd=7.84u as=2.1312p ps=7.3u w=6.66u l=0.6u
X226 sg13cmos5l_IOPadAnalog_12.pad sg13cmos5l_IOPadAnalog_12.padres sg13cmos5l_Corner_1.vss rppd l=2u w=1u
M227 cko a_118044_42476# sg13cmos5l_Corner_1.iovdd sg13cmos5l_Corner_1.iovdd sg13_hv_pmos ad=3.9294p pd=7.84u as=2.1312p ps=7.3u w=6.66u l=0.6u
M228 vdd adc8b_0.sar12b_0.sg13cmos5l_buf_1_33.A a_84016_92824# vdd sg13_lv_pmos ad=0.2114p pd=1.54u as=0.2856p ps=2.36u w=0.84u l=0.13u
M229 sg13cmos5l_Corner_1.iovdd a_42476_70044# vddr sg13cmos5l_Corner_1.iovdd sg13_hv_pmos ad=2.1312p pd=7.3u as=3.9294p ps=7.84u w=6.66u l=0.6u
M230 vdd a_96945_96929# a_96878_96572# vdd sg13_lv_pmos ad=0.2387p pd=1.84u as=0.1008p ps=0.9u w=0.42u l=0.13u
M231 sg13cmos5l_IOPadAnalog_13.pad a_115639_164698# sg13cmos5l_Corner_1.iovdd sg13cmos5l_Corner_1.iovdd sg13_hv_pmos ad=3.9294p pd=7.84u as=2.1312p ps=7.3u w=6.66u l=0.6u
M232 a_85432_95302# a_85175_95421# a_85594_95498# sg13cmos5l_Corner_1.vss sg13_lv_nmos ad=0.1428p pd=1.52u as=37.8f ps=0.6u w=0.42u l=0.13u
M233 a_87260_94620# a_86847_94314# a_87192_94620# vdd sg13_lv_pmos ad=0.191p pd=1.44u as=0.105p ps=1.21u w=1u l=0.13u
M234 vdd sg13cmos5l_IOPadVdd$1_0.sg13cmos5l_Clamp_N43N43D4R$1_0.gate sg13cmos5l_Corner_1.vss sg13cmos5l_Corner_1.vss sg13_hv_nmos ad=2.596p pd=5.58u as=1.408p ps=5.04u w=4.4u l=0.6u
M235 a_99135_99954# adc8b_0.sar12b_0.sg13cmos5l_dfrbp_1_22.D vdd vdd sg13_lv_pmos ad=0.3234p pd=2.45u as=1.12242p ps=7u w=0.84u l=0.13u
M236 adc8b_0.diff_bsw_0.single_bsw_1.sg13cmos5l_inv_1$1_0.Y adc8b_0.diff_bsw_0.single_bsw_1.sg13cmos5l_inv_1$1_0.A vdd vdd sg13_lv_pmos ad=0.3808p pd=2.92u as=0.3808p ps=2.92u w=1.12u l=0.13u
M237 sg13cmos5l_Corner_1.iovdd a_83639_164698# sg13cmos5l_IOPadAnalog_9.pad sg13cmos5l_Corner_1.iovdd sg13_hv_pmos ad=2.1312p pd=7.3u as=3.9294p ps=7.84u w=6.66u l=0.6u
M238 vddr adc8b_0.side_cap8b_0.in_l_sw[0] adc8b_0.side_cap8b_0.buf_32_0.z vddr sg13_lv_pmos ad=0.19p pd=1.38u as=0.19p ps=1.38u w=1u l=0.13u
M239 adc8b_0.side_cap8b_0.buf_16_0.z adc8b_0.side_cap8b_0.in_h_sw[2] vddr vddr sg13_lv_pmos ad=0.19p pd=1.38u as=0.19p ps=1.38u w=1u l=0.13u
M240 adc8b_0.side_cap8b_0.buf_8_2.z adc8b_0.side_cap8b_0.in_h_sw[4] sg13cmos5l_Corner_1.vss sg13cmos5l_Corner_1.vss sg13_lv_nmos ad=95f pd=0.88u as=95f ps=0.88u w=0.5u l=0.13u
M241 vip a_42476_102044# sg13cmos5l_Corner_1.iovdd sg13cmos5l_Corner_1.iovdd sg13_hv_pmos ad=3.9294p pd=7.84u as=3.1302p ps=14.26u w=6.66u l=0.6u
M242 vddr adc8b_0.side_cap8b_0.in_h_sw[1] adc8b_0.side_cap8b_0.buf_16_3.z vddr sg13_lv_pmos ad=0.19p pd=1.38u as=0.34p ps=2.68u w=1u l=0.13u
M243 vddr adc8b_0.sar12b_0.nh_sw[4] adc8b_0.side_cap8b_1.buf_8_2.z vddr sg13_lv_pmos ad=0.19p pd=1.38u as=0.19p ps=1.38u w=1u l=0.13u
M244 a_98516_100310# adc8b_0.sar12b_0.sg13cmos5l_buf_1_93.X sg13cmos5l_Corner_1.vss sg13cmos5l_Corner_1.vss sg13_lv_nmos ad=0.187p pd=1.78u as=0.14875p ps=1.16u w=0.55u l=0.13u
M245 a_96110_100034# a_96915_99607# a_96370_99564# vdd sg13_lv_pmos ad=0.1428p pd=1.52u as=79.8f ps=0.8u w=0.42u l=0.13u
M246 data[1] a_86044_42476# sg13cmos5l_Corner_1.iovdd sg13cmos5l_Corner_1.iovdd sg13_hv_pmos ad=3.9294p pd=7.84u as=2.1312p ps=7.3u w=6.66u l=0.6u
M247 vip a_42476_102044# sg13cmos5l_Corner_1.iovdd sg13cmos5l_Corner_1.iovdd sg13_hv_pmos ad=3.9294p pd=7.84u as=2.1312p ps=7.3u w=6.66u l=0.6u
M248 vdd a_90207_97338# a_90338_97332# vdd sg13_lv_pmos ad=1.07253p pd=6.75u as=0.2856p ps=2.36u w=0.84u l=0.13u
X249 sg13cmos5l_IOPadAnalog_15.pad sg13cmos5l_Corner_1.iovdd dpantenna l=1.26u w=27.78u
M250 a_92364_98847# a_92076_99152# a_92302_98847# sg13cmos5l_Corner_1.vss sg13_lv_nmos ad=0.1428p pd=1.52u as=37.8f ps=0.6u w=0.42u l=0.13u
M251 a_96494_98834# a_97299_98956# a_96754_99057# vdd sg13_lv_pmos ad=0.1428p pd=1.52u as=79.8f ps=0.8u w=0.42u l=0.13u
M252 a_94641_97713# a_94284_97640# vdd vdd sg13_lv_pmos ad=63f pd=0.72u as=0.1563p ps=1.22u w=0.42u l=0.13u
M253 adc8b_0.sar12b_0.sg13cmos5l_inv_1_0.A a_95420_95060# vdd vdd sg13_lv_pmos ad=0.3808p pd=2.92u as=0.2128p ps=1.5u w=1.12u l=0.13u
M254 sg13cmos5l_Corner_1.vss a_178296_102044# sg13cmos5l_IOPadAnalog_16.pad sg13cmos5l_Corner_1.vss sg13_hv_nmos ad=1.408p pd=5.04u as=2.596p ps=5.58u w=4.4u l=0.6u
M255 sg13cmos5l_Corner_1.vss a_134044_30676# frame sg13cmos5l_Corner_1.vss sg13_hv_nmos ad=1.408p pd=5.04u as=2.596p ps=5.58u w=4.4u l=0.6u
M256 vddr adc8b_0.sar12b_0.nl_sw[9] adc8b_0.side_cap8b_1.buf_2_2.z vddr sg13_lv_pmos ad=0.19p pd=1.38u as=0.34p ps=2.68u w=1u l=0.13u
M257 vdd a_94929_98441# a_95454_98514# vdd sg13_lv_pmos ad=0.1974p pd=1.5u as=0.2856p ps=2.36u w=0.84u l=0.13u
M258 sg13cmos5l_Corner_1.iovdd a_102044_42476# data[2] sg13cmos5l_Corner_1.iovdd sg13_hv_pmos ad=2.1312p pd=7.3u as=3.9294p ps=7.84u w=6.66u l=0.6u
M259 sg13cmos5l_Corner_1.vss adc8b_0.sar12b_0.nl_sw[6] adc8b_0.side_cap8b_1.buf_4_3.z sg13cmos5l_Corner_1.vss sg13_lv_nmos ad=95f pd=0.88u as=0.17p ps=1.68u w=0.5u l=0.13u
M260 vin a_42476_86044# sg13cmos5l_Corner_1.iovdd sg13cmos5l_Corner_1.iovdd sg13_hv_pmos ad=3.9294p pd=7.84u as=2.1312p ps=7.3u w=6.66u l=0.6u
M261 sg13cmos5l_Corner_1.iovdd a_42476_70044# vddr sg13cmos5l_Corner_1.iovdd sg13_hv_pmos ad=2.1312p pd=7.3u as=3.9294p ps=7.84u w=6.66u l=0.6u
M262 sg13cmos5l_Corner_1.vss a_100995_100350# adc8b_0.sar12b_0.sg13cmos5l_buf_8_2.X sg13cmos5l_Corner_1.vss sg13_lv_nmos ad=0.1406p pd=1.12u as=0.1406p ps=1.12u w=0.74u l=0.13u
M263 a_96110_100034# adc8b_0.sar12b_0.sg13cmos5l_dfrbp_1_23.CLK vdd vdd sg13_lv_pmos ad=79.8f pd=0.8u as=0.1428p ps=1.52u w=0.42u l=0.13u
M264 adc8b_0.side_cap8b_1.buf_16_3.z adc8b_0.sar12b_0.nh_sw[1] vddr vddr sg13_lv_pmos ad=0.19p pd=1.38u as=0.19p ps=1.38u w=1u l=0.13u
M265 vdd a_83348_93512# adc8b_0.sar12b_0.nh_sw[0] vdd sg13_lv_pmos ad=0.2114p pd=1.54u as=0.42p ps=2.99u w=1.12u l=0.13u
M266 vdd sg13cmos5l_IOPadVdd$1_0.sg13cmos5l_Clamp_N43N43D4R$1_0.gate sg13cmos5l_Corner_1.vss sg13cmos5l_Corner_1.vss sg13_hv_nmos ad=2.596p pd=5.58u as=1.408p ps=5.04u w=4.4u l=0.6u
M267 adc8b_0.sar12b_0.sg13cmos5l_buf_1_93.X a_96400_100384# vdd vdd sg13_lv_pmos ad=0.42p pd=2.99u as=0.2114p ps=1.54u w=1.12u l=0.13u
M268 sg13cmos5l_Corner_1.vss adc8b_0.sar12b_0.sg13cmos5l_buf_1_40.A adc8b_0.sar12b_0.sg13cmos5l_buf_1_63.A sg13cmos5l_Corner_1.vss sg13_lv_nmos ad=0.2516p pd=2.16u as=0.2516p ps=2.16u w=0.74u l=0.13u
M269 sg13cmos5l_Corner_1.vss adc8b_0.side_cap8b_0.in_l_sw[2] adc8b_0.side_cap8b_0.buf_16_1.z sg13cmos5l_Corner_1.vss sg13_lv_nmos ad=95f pd=0.88u as=95f ps=0.88u w=0.5u l=0.13u
M270 adc8b_0.sar12b_0.sg13cmos5l_dfrbp_1_23.CLK a_95996_100644# sg13cmos5l_Corner_1.vss sg13cmos5l_Corner_1.vss sg13_lv_nmos ad=0.2516p pd=2.16u as=0.1406p ps=1.12u w=0.74u l=0.13u
M271 sg13cmos5l_Corner_1.vss adc8b_0.sar12b_0.sg13cmos5l_dfrbp_1_6.RESET_B a_90460_98472# sg13cmos5l_Corner_1.vss sg13_lv_nmos ad=0.1406p pd=1.12u as=77.7f ps=0.95u w=0.74u l=0.13u
M272 adc8b_0.sar12b_0.sg13cmos5l_dlhr_1_16.Q_N a_101502_97002# vdd vdd sg13_lv_pmos ad=0.3808p pd=2.92u as=0.1974p ps=1.5u w=1.12u l=0.13u
M273 a_88140_96128# a_88114_96033# sg13cmos5l_Corner_1.vss sg13cmos5l_Corner_1.vss sg13_lv_nmos ad=0.2516p pd=2.16u as=0.1626p ps=1.415u w=0.74u l=0.13u
X274 sg13cmos5l_Corner_1.vss a_134222_32962# dantenna l=1.26u w=27.78u
M275 a_100696_93006# adc8b_0.sar12b_0.sg13cmos5l_dfrbp_1_0.RESET_B vdd vdd sg13_lv_pmos ad=79.8f pd=0.8u as=1.777p ps=11.395u w=0.42u l=0.13u
M276 a_87478_97010# a_87719_96543# a_86837_96536# sg13cmos5l_Corner_1.vss sg13_lv_nmos ad=0.1428p pd=1.52u as=0.12665p ps=1.145u w=0.42u l=0.13u
M277 adc8b_0.sar12b_0.sg13cmos5l_dfrbp_1_1.Q_N a_94583_92863# vdd vdd sg13_lv_pmos ad=0.4312p pd=3.01u as=0.2639p ps=1.81u w=1.12u l=0.13u
M278 adc8b_0.side_cap8b_0.buf_4_3.z adc8b_0.side_cap8b_0.in_l_sw[6] sg13cmos5l_Corner_1.vss sg13cmos5l_Corner_1.vss sg13_lv_nmos ad=0.17p pd=1.68u as=95f ps=0.88u w=0.5u l=0.13u
M279 cko a_118044_42476# sg13cmos5l_Corner_1.iovdd sg13cmos5l_Corner_1.iovdd sg13_hv_pmos ad=3.9294p pd=7.84u as=3.1302p ps=14.26u w=6.66u l=0.6u
M280 sg13cmos5l_IOPadAnalog_13.pad a_115639_164698# sg13cmos5l_Corner_1.iovdd sg13cmos5l_Corner_1.iovdd sg13_hv_pmos ad=3.9294p pd=7.84u as=2.1312p ps=7.3u w=6.66u l=0.6u
M281 data[1] a_86044_30676# sg13cmos5l_Corner_1.vss sg13cmos5l_Corner_1.vss sg13_hv_nmos ad=2.596p pd=5.58u as=1.408p ps=5.04u w=4.4u l=0.6u
M282 sg13cmos5l_Corner_1.vss adc8b_0.sar12b_0.nh_sw[2] adc8b_0.side_cap8b_1.buf_16_0.z sg13cmos5l_Corner_1.vss sg13_lv_nmos ad=95f pd=0.88u as=95f ps=0.88u w=0.5u l=0.13u
M283 adc8b_0.sar12b_0.sg13cmos5l_dfrbp_1_0.Q a_101276_93084# sg13cmos5l_Corner_1.vss sg13cmos5l_Corner_1.vss sg13_lv_nmos ad=0.2516p pd=2.16u as=0.1406p ps=1.12u w=0.74u l=0.13u
M284 sg13cmos5l_IOPadAnalog_12.pad a_131639_164698# sg13cmos5l_Corner_1.iovdd sg13cmos5l_Corner_1.iovdd sg13_hv_pmos ad=3.9294p pd=7.84u as=2.1312p ps=7.3u w=6.66u l=0.6u
M285 a_90540_99600# a_90514_99564# vdd vdd sg13_lv_pmos ad=0.34p pd=2.68u as=0.36237p ps=2.605u w=1u l=0.13u
M286 sg13cmos5l_Corner_1.vss a_97912_99838# a_97561_99957# sg13cmos5l_Corner_1.vss sg13_lv_nmos ad=79.8f pd=0.8u as=0.1428p ps=1.52u w=0.42u l=0.13u
M287 a_94487_93909# a_93645_93559# a_94393_93909# sg13cmos5l_Corner_1.vss sg13_lv_nmos ad=0.12665p pd=1.145u as=0.1428p ps=1.52u w=0.42u l=0.13u
M288 a_87885_97301# adc8b_0.sar12b_0.sg13cmos5l_dlhr_1_5.GATE sg13cmos5l_Corner_1.vss sg13cmos5l_Corner_1.vss sg13_lv_nmos ad=0.2516p pd=2.16u as=1.97045p ps=12.335u w=0.74u l=0.13u
M289 a_82190_97010# a_82995_96583# a_82450_96540# vdd sg13_lv_pmos ad=0.1428p pd=1.52u as=79.8f ps=0.8u w=0.42u l=0.13u
M290 vdd a_90609_96929# a_91134_97002# vdd sg13_lv_pmos ad=0.1974p pd=1.5u as=0.2856p ps=2.36u w=0.84u l=0.13u
M291 adc8b_0.side_cap8b_1.buf_16_2.z adc8b_0.sar12b_0.nl_sw[1] sg13cmos5l_Corner_1.vss sg13cmos5l_Corner_1.vss sg13_lv_nmos ad=95f pd=0.88u as=95f ps=0.88u w=0.5u l=0.13u
M292 vdd adc8b_0.sar12b_0.sg13cmos5l_buf_1_8.X a_93424_94336# vdd sg13_lv_pmos ad=0.2114p pd=1.54u as=0.2856p ps=2.36u w=0.84u l=0.13u
M293 frame a_134044_30676# sg13cmos5l_Corner_1.vss sg13cmos5l_Corner_1.vss sg13_hv_nmos ad=2.596p pd=5.58u as=1.408p ps=5.04u w=4.4u l=0.6u
M294 vddr adc8b_0.sar12b_0.nh_sw[0] adc8b_0.side_cap8b_1.buf_32_1.z vddr sg13_lv_pmos ad=0.19p pd=1.38u as=0.19p ps=1.38u w=1u l=0.13u
M295 sg13cmos5l_IOPadAnalog_10.pad a_67639_164698# sg13cmos5l_Corner_1.iovdd sg13cmos5l_Corner_1.iovdd sg13_hv_pmos ad=3.9294p pd=7.84u as=2.1312p ps=7.3u w=6.66u l=0.6u
M296 sg13cmos5l_Corner_1.vss adc8b_0.sar12b_0.sg13cmos5l_dfrbp_1_12.Q_N a_90673_95864# sg13cmos5l_Corner_1.vss sg13_lv_nmos ad=0.15055p pd=1.17u as=0.187p ps=1.78u w=0.55u l=0.13u
M297 sg13cmos5l_IOPadAnalog_9.pad a_83639_164698# sg13cmos5l_Corner_1.iovdd sg13cmos5l_Corner_1.iovdd sg13_hv_pmos ad=3.9294p pd=7.84u as=2.1312p ps=7.3u w=6.66u l=0.6u
M298 sg13cmos5l_Corner_1.vss sg13cmos5l_IOPadVdd$1_0.sg13cmos5l_Clamp_N43N43D4R$1_0.gate vdd sg13cmos5l_Corner_1.vss sg13_hv_nmos ad=1.408p pd=5.04u as=2.596p ps=5.58u w=4.4u l=0.6u
M299 vdd sg13cmos5l_IOPadVdd$1_0.sg13cmos5l_Clamp_N43N43D4R$1_0.gate sg13cmos5l_Corner_1.vss sg13cmos5l_Corner_1.vss sg13_hv_nmos ad=2.596p pd=5.58u as=1.408p ps=5.04u w=4.4u l=0.6u
M300 sg13cmos5l_Corner_1.iovdd a_42476_86044# vin sg13cmos5l_Corner_1.iovdd sg13_hv_pmos ad=3.1302p pd=14.26u as=3.9294p ps=7.84u w=6.66u l=0.6u
M301 a_99160_96030# a_98903_95887# a_99322_95810# sg13cmos5l_Corner_1.vss sg13_lv_nmos ad=0.1428p pd=1.52u as=37.8f ps=0.6u w=0.42u l=0.13u
M302 a_99284_100310# adc8b_0.sar12b_0.sg13cmos5l_buf_1_103.A vdd vdd sg13_lv_pmos ad=0.2856p pd=2.36u as=0.2114p ps=1.54u w=0.84u l=0.13u
M303 vdd adc8b_0.sar12b_0.sg13cmos5l_inv_1_5.A a_102160_95060# vdd sg13_lv_pmos ad=0.2114p pd=1.54u as=0.2856p ps=2.36u w=0.84u l=0.13u
X304 sg13cmos5l_IOPadAnalog_3.padres cko sg13cmos5l_Corner_1.vss rppd l=2u w=1u
M305 adc8b_0.sar12b_0.sg13cmos5l_dfrbp_1_7.Q_N a_96311_94375# vdd vdd sg13_lv_pmos ad=0.4312p pd=3.01u as=0.2639p ps=1.81u w=1.12u l=0.13u
M306 a_88509_96619# adc8b_0.sar12b_0.sg13cmos5l_dfrbp_1_8.RESET_B vdd vdd sg13_lv_pmos ad=0.147p pd=1.54u as=0.1563p ps=1.22u w=0.42u l=0.13u
X307 sg13cmos5l_IOPadAnalog_16.padres sg13cmos5l_Corner_1.iovdd dpantenna l=4.98u w=0.64u
M308 adc8b_0.side_cap8b_1.buf_16_3.z adc8b_0.sar12b_0.nh_sw[1] sg13cmos5l_Corner_1.vss sg13cmos5l_Corner_1.vss sg13_lv_nmos ad=95f pd=0.88u as=95f ps=0.88u w=0.5u l=0.13u
M309 vddr adc8b_0.sar12b_0.nl_sw[1] adc8b_0.side_cap8b_1.buf_16_2.z vddr sg13_lv_pmos ad=0.19p pd=1.38u as=0.34p ps=2.68u w=1u l=0.13u
M310 vdd adc8b_0.sar12b_0.sg13cmos5l_buf_1_29.A a_91600_92824# vdd sg13_lv_pmos ad=0.2114p pd=1.54u as=0.2856p ps=2.36u w=0.84u l=0.13u
M311 vdd a_91028_93512# adc8b_0.sar12b_0.nh_sw[4] vdd sg13_lv_pmos ad=0.2114p pd=1.54u as=0.42p ps=2.99u w=1.12u l=0.13u
M312 sg13cmos5l_Corner_1.iovdd a_115639_164698# sg13cmos5l_IOPadAnalog_13.pad sg13cmos5l_Corner_1.iovdd sg13_hv_pmos ad=2.1312p pd=7.3u as=3.9294p ps=7.84u w=6.66u l=0.6u
M313 adc8b_0.side_cap8b_0.buf_32_1.z adc8b_0.side_cap8b_0.in_h_sw[0] sg13cmos5l_Corner_1.vss sg13cmos5l_Corner_1.vss sg13_lv_nmos ad=95f pd=0.88u as=95f ps=0.88u w=0.5u l=0.13u
M314 a_100628_98048# adc8b_0.sar12b_0.sg13cmos5l_buf_1_87.A sg13cmos5l_Corner_1.vss sg13cmos5l_Corner_1.vss sg13_lv_nmos ad=0.187p pd=1.78u as=0.14875p ps=1.16u w=0.55u l=0.13u
M315 vdd sg13cmos5l_Corner_1.vss vdd vdd sg13_lv_pmos ad=0.19p pd=1.38u as=0 ps=0 w=1u l=1u
M316 sg13cmos5l_IOPadAnalog_0.pad a_164624_86044# sg13cmos5l_Corner_1.iovdd sg13cmos5l_Corner_1.iovdd sg13_hv_pmos ad=3.9294p pd=7.84u as=2.1312p ps=7.3u w=6.66u l=0.6u
M317 sg13cmos5l_Corner_1.vss adc8b_0.sar12b_0.nl_sw[0] adc8b_0.side_cap8b_1.buf_32_0.z sg13cmos5l_Corner_1.vss sg13_lv_nmos ad=95f pd=0.88u as=95f ps=0.88u w=0.5u l=0.13u
M318 sg13cmos5l_Corner_1.vss a_101396_93512# adc8b_0.sar12b_0.nh_sw[9] sg13cmos5l_Corner_1.vss sg13_lv_nmos ad=0.14875p pd=1.16u as=0.2886p ps=2.26u w=0.74u l=0.13u
M319 sg13cmos5l_Corner_1.vss a_92493_98813# a_92595_98956# sg13cmos5l_Corner_1.vss sg13_lv_nmos ad=1.49685p pd=9.6u as=0.2516p ps=2.16u w=0.74u l=0.13u
M320 frame a_101776_98872# vdd vdd sg13_lv_pmos ad=0.42p pd=2.99u as=0.2114p ps=1.54u w=1.12u l=0.13u
M321 sg13cmos5l_Corner_1.vss a_70044_30676# data[0] sg13cmos5l_Corner_1.vss sg13_hv_nmos ad=1.408p pd=5.04u as=2.596p ps=5.58u w=4.4u l=0.6u
X322 sg13cmos5l_IOPadAnalog_10.pad sg13cmos5l_Corner_1.iovdd dpantenna l=1.26u w=27.78u
M323 adc8b_0.side_cap8b_0.buf_32_1.z adc8b_0.side_cap8b_0.in_h_sw[0] vddr vddr sg13_lv_pmos ad=0.19p pd=1.38u as=0.19p ps=1.38u w=1u l=0.13u
M324 sg13cmos5l_Corner_1.vss adc8b_0.sar12b_0.sg13cmos5l_buf_1_61.X a_82768_100384# sg13cmos5l_Corner_1.vss sg13_lv_nmos ad=0.14875p pd=1.16u as=0.187p ps=1.78u w=0.55u l=0.13u
M325 adc8b_0.sar12b_0.sg13cmos5l_buf_1_57.X a_91216_98084# vdd vdd sg13_lv_pmos ad=0.42p pd=2.99u as=0.2114p ps=1.54u w=1.12u l=0.13u
M326 adc8b_0.side_cap8b_0.buf_4_2.z adc8b_0.side_cap8b_0.in_h_sw[7] sg13cmos5l_Corner_1.vss sg13cmos5l_Corner_1.vss sg13_lv_nmos ad=0.17p pd=1.68u as=95f ps=0.88u w=0.5u l=0.13u
M327 vdd a_98340_95421# a_99363_95107# vdd sg13_lv_pmos ad=0.1563p pd=1.22u as=63f ps=0.72u w=0.42u l=0.13u
M328 a_97677_93559# adc8b_0.sar12b_0.sg13cmos5l_dfrbp_1_0.CLK vdd vdd sg13_lv_pmos ad=0.4088p pd=2.97u as=1.777p ps=11.395u w=1.12u l=0.13u
X329 sg13cmos5l_Corner_1.vss a_70222_32962# dantenna l=1.26u w=27.78u
M330 adc8b_0.side_cap8b_1.buf_1_0.z adc8b_0.sar12b_0.nl_sw[10] vddr vddr sg13_lv_pmos ad=0.34p pd=2.68u as=0.34p ps=2.68u w=1u l=0.13u
M331 sg13cmos5l_Corner_1.vss a_82893_96583# a_82995_96583# sg13cmos5l_Corner_1.vss sg13_lv_nmos ad=1.97045p pd=12.335u as=0.2516p ps=2.16u w=0.74u l=0.13u
M332 sg13cmos5l_Corner_1.iovdd a_134044_42476# frame sg13cmos5l_Corner_1.iovdd sg13_hv_pmos ad=2.1312p pd=7.3u as=3.9294p ps=7.84u w=6.66u l=0.6u
X333 a_70044_30676# sg13cmos5l_Corner_1.vss sg13cmos5l_Corner_1.vss rppd l=3.54u w=0.5u
M334 a_98385_97713# a_98028_97640# vdd vdd sg13_lv_pmos ad=63f pd=0.72u as=0.1563p ps=1.22u w=0.42u l=0.13u
M335 a_92174_100784# a_91778_100356# a_92060_100668# vdd sg13_lv_pmos ad=0.1008p pd=0.9u as=0.191p ps=1.44u w=0.42u l=0.13u
M336 vdd adc8b_0.diff_bsw_0.single_bsw_1.sg13cmos5l_inv_1$1_2.A a_70852_94286# vdd sg13_lv_pmos ad=0.17p pd=1.68u as=0.17p ps=1.68u w=0.5u l=0.13u
M337 a_101396_93512# adc8b_0.sar12b_0.sg13cmos5l_buf_1_19.X sg13cmos5l_Corner_1.vss sg13cmos5l_Corner_1.vss sg13_lv_nmos ad=0.187p pd=1.78u as=0.14875p ps=1.16u w=0.55u l=0.13u
M338 a_95578_100346# adc8b_0.sar12b_0.sg13cmos5l_dfrbp_1_8.RESET_B sg13cmos5l_Corner_1.vss sg13cmos5l_Corner_1.vss sg13_lv_nmos ad=37.8f pd=0.6u as=79.8f ps=0.8u w=0.42u l=0.13u
M339 a_92201_95408# adc8b_0.sar12b_0.sg13cmos5l_dfrbp_1_10.Q adc8b_0.sar12b_0.sg13cmos5l_a22oi_1_1.B1 sg13cmos5l_Corner_1.vss sg13_lv_nmos ad=0.1406p pd=1.12u as=0.1406p ps=1.12u w=0.74u l=0.13u
M340 a_97068_93986# adc8b_0.sar12b_0.sg13cmos5l_nor2b_1_1.Y a_96974_93986# sg13cmos5l_Corner_1.vss sg13_lv_nmos ad=60.89999f pd=0.71u as=0.1428p ps=1.52u w=0.42u l=0.13u
M341 sg13cmos5l_IOPadAnalog_9.pad a_83639_164698# sg13cmos5l_Corner_1.iovdd sg13cmos5l_Corner_1.iovdd sg13_hv_pmos ad=3.9294p pd=7.84u as=2.1312p ps=7.3u w=6.66u l=0.6u
M342 a_82476_98088# a_82450_98052# sg13cmos5l_Corner_1.vss sg13cmos5l_Corner_1.vss sg13_lv_nmos ad=0.2516p pd=2.16u as=0.1626p ps=1.415u w=0.74u l=0.13u
M343 a_90514_99564# a_90957_99607# a_90254_100034# sg13cmos5l_Corner_1.vss sg13_lv_nmos ad=79.8f pd=0.8u as=0.1296p ps=1.52u w=0.42u l=0.13u
M344 sg13cmos5l_Corner_1.vss adc8b_0.sar12b_0.sg13cmos5l_buf_1_104.A a_101392_99596# sg13cmos5l_Corner_1.vss sg13_lv_nmos ad=0.14875p pd=1.16u as=0.187p ps=1.78u w=0.55u l=0.13u
M345 adc8b_0.sar12b_0.sg13cmos5l_dlhr_1_10.Q a_101361_97322# sg13cmos5l_Corner_1.vss sg13cmos5l_Corner_1.vss sg13_lv_nmos ad=0.2516p pd=2.16u as=0.1406p ps=1.12u w=0.74u l=0.13u
M346 adc8b_0.sar12b_0.sg13cmos5l_inv_1_0.A a_95420_95060# sg13cmos5l_Corner_1.vss sg13cmos5l_Corner_1.vss sg13_lv_nmos ad=0.2516p pd=2.16u as=0.1406p ps=1.12u w=0.74u l=0.13u
M347 data[0] a_70044_30676# sg13cmos5l_Corner_1.vss sg13cmos5l_Corner_1.vss sg13_hv_nmos ad=2.596p pd=5.58u as=1.408p ps=5.04u w=4.4u l=0.6u
M348 sg13cmos5l_Corner_1.vss a_93645_93559# a_93747_93559# sg13cmos5l_Corner_1.vss sg13_lv_nmos ad=2.59257p pd=16.445u as=0.2516p ps=2.16u w=0.74u l=0.13u
X349 data[2] sg13cmos5l_Corner_1.iovdd dpantenna l=1.26u w=27.78u
M350 sg13cmos5l_Corner_1.vss a_98516_100310# adc8b_0.side_cap8b_0.in_l_sw[7] sg13cmos5l_Corner_1.vss sg13_lv_nmos ad=0.14875p pd=1.16u as=0.2886p ps=2.26u w=0.74u l=0.13u
M351 a_84154_98522# adc8b_0.sar12b_0.sg13cmos5l_dfrbp_1_6.RESET_B sg13cmos5l_Corner_1.vss sg13cmos5l_Corner_1.vss sg13_lv_nmos ad=37.8f pd=0.6u as=79.8f ps=0.8u w=0.42u l=0.13u
M352 vdd adc8b_0.sar12b_0.sg13cmos5l_o21ai_1_0.B1 adc8b_0.sar12b_0.sg13cmos5l_o21ai_1_0.Y vdd sg13_lv_pmos ad=0.3808p pd=2.92u as=0.2128p ps=1.5u w=1.12u l=0.15u
M353 sg13cmos5l_Corner_1.iovdd a_115639_164698# sg13cmos5l_IOPadAnalog_13.pad sg13cmos5l_Corner_1.iovdd sg13_hv_pmos ad=2.1312p pd=7.3u as=3.9294p ps=7.84u w=6.66u l=0.6u
M354 sg13cmos5l_Corner_1.vss a_100995_100350# adc8b_0.sar12b_0.sg13cmos5l_buf_8_2.X sg13cmos5l_Corner_1.vss sg13_lv_nmos ad=0.1406p pd=1.12u as=0.1406p ps=1.12u w=0.74u l=0.13u
M355 a_84074_98820# adc8b_0.sar12b_0.sg13cmos5l_dfrbp_1_6.RESET_B sg13cmos5l_Corner_1.vss sg13cmos5l_Corner_1.vss sg13_lv_nmos ad=77.7f pd=0.95u as=0.1406p ps=1.12u w=0.74u l=0.13u
M356 sg13cmos5l_Corner_1.vss adc8b_0.sar12b_0.sg13cmos5l_dfrbp_1_20.Q a_91633_98442# sg13cmos5l_Corner_1.vss sg13_lv_nmos ad=0.15055p pd=1.17u as=0.187p ps=1.78u w=0.55u l=0.13u
M357 sg13cmos5l_Corner_1.iovdd a_131639_164698# sg13cmos5l_IOPadAnalog_12.pad sg13cmos5l_Corner_1.iovdd sg13_hv_pmos ad=2.1312p pd=7.3u as=3.9294p ps=7.84u w=6.66u l=0.6u
M358 a_96063_98442# adc8b_0.sar12b_0.sg13cmos5l_dfrbp_1_23.CLK sg13cmos5l_Corner_1.vss sg13cmos5l_Corner_1.vss sg13_lv_nmos ad=0.2516p pd=2.16u as=0.15055p ps=1.17u w=0.74u l=0.13u
M359 sg13cmos5l_Corner_1.vss adc8b_0.sar12b_0.nl_sw[2] adc8b_0.side_cap8b_1.buf_16_1.z sg13cmos5l_Corner_1.vss sg13_lv_nmos ad=95f pd=0.88u as=95f ps=0.88u w=0.5u l=0.13u
M360 vddr a_42476_70044# sg13cmos5l_Corner_1.iovdd sg13cmos5l_Corner_1.iovdd sg13_hv_pmos ad=3.9294p pd=7.84u as=2.1312p ps=7.3u w=6.66u l=0.6u
M361 adc8b_0.sar12b_0.sg13cmos5l_buf_1_46.A a_91473_95810# vdd vdd sg13_lv_pmos ad=0.3808p pd=2.92u as=0.2128p ps=1.5u w=1.12u l=0.13u
M362 a_101108_99560# adc8b_0.sar12b_0.sg13cmos5l_buf_1_107.X sg13cmos5l_Corner_1.vss sg13cmos5l_Corner_1.vss sg13_lv_nmos ad=0.187p pd=1.78u as=0.14875p ps=1.16u w=0.55u l=0.13u
M363 adc8b_0.sar12b_0.sg13cmos5l_dfrbp_1_23.Q_N a_95543_97399# sg13cmos5l_Corner_1.vss sg13cmos5l_Corner_1.vss sg13_lv_nmos ad=0.2849p pd=2.25u as=0.2516p ps=2.16u w=0.74u l=0.13u
M364 vdd sg13cmos5l_IOPadVdd$1_0.sg13cmos5l_Clamp_N43N43D4R$1_0.gate sg13cmos5l_Corner_1.vss sg13cmos5l_Corner_1.vss sg13_hv_nmos ad=2.596p pd=5.58u as=1.408p ps=5.04u w=4.4u l=0.6u
M365 sg13cmos5l_Corner_1.vss adc8b_0.side_cap8b_0.in_l_sw[1] adc8b_0.side_cap8b_0.buf_16_2.z sg13cmos5l_Corner_1.vss sg13_lv_nmos ad=95f pd=0.88u as=95f ps=0.88u w=0.5u l=0.13u
M366 sg13cmos5l_Corner_1.vss a_94929_98441# a_94884_98486# sg13cmos5l_Corner_1.vss sg13_lv_nmos ad=0.1428p pd=1.52u as=47.25f ps=0.645u w=0.42u l=0.13u
M367 sg13cmos5l_Corner_1.iovdd a_164624_70044# sg13cmos5l_IOPadAnalog_1.pad sg13cmos5l_Corner_1.iovdd sg13_hv_pmos ad=2.1312p pd=7.3u as=3.9294p ps=7.84u w=6.66u l=0.6u
M368 sg13cmos5l_Corner_1.iovdd a_83639_164698# sg13cmos5l_IOPadAnalog_9.pad sg13cmos5l_Corner_1.iovdd sg13_hv_pmos ad=2.1312p pd=7.3u as=3.9294p ps=7.84u w=6.66u l=0.6u
M369 sg13cmos5l_Corner_1.vss vdd sg13cmos5l_Corner_1.vss sg13cmos5l_Corner_1.vss sg13_lv_nmos ad=0.1428p pd=1.52u as=0 ps=0 w=0.42u l=1u
M370 a_88247_93909# a_87405_93559# a_86988_93552# vdd sg13_lv_pmos ad=0.2048p pd=1.63u as=0.34p ps=2.68u w=1u l=0.13u
M371 vddr adc8b_0.sar12b_0.nh_sw[1] adc8b_0.side_cap8b_1.buf_16_3.z vddr sg13_lv_pmos ad=0.19p pd=1.38u as=0.34p ps=2.68u w=1u l=0.13u
M372 sg13cmos5l_Corner_1.vss adc8b_0.sar12b_0.sg13cmos5l_inv_1_17.A adc8b_0.sar12b_0.sg13cmos5l_buf_1_37.A sg13cmos5l_Corner_1.vss sg13_lv_nmos ad=0.2516p pd=2.16u as=0.2516p ps=2.16u w=0.74u l=0.13u
M373 adc8b_0.side_cap8b_0.buf_8_0.z adc8b_0.side_cap8b_0.in_l_sw[4] sg13cmos5l_Corner_1.vss sg13cmos5l_Corner_1.vss sg13_lv_nmos ad=95f pd=0.88u as=95f ps=0.88u w=0.5u l=0.13u
M374 a_85582_95823# adc8b_0.sar12b_0.sg13cmos5l_dfrbp_1_8.RESET_B sg13cmos5l_Corner_1.vss sg13cmos5l_Corner_1.vss sg13_lv_nmos ad=37.8f pd=0.6u as=0.1701p ps=1.65u w=0.42u l=0.13u
M375 sg13cmos5l_Corner_1.vss adc8b_0.sar12b_0.nl_sw[3] adc8b_0.side_cap8b_1.buf_8_1.z sg13cmos5l_Corner_1.vss sg13_lv_nmos ad=95f pd=0.88u as=95f ps=0.88u w=0.5u l=0.13u
M376 adc8b_0.side_cap8b_0.buf_16_1.z adc8b_0.side_cap8b_0.in_l_sw[2] sg13cmos5l_Corner_1.vss sg13cmos5l_Corner_1.vss sg13_lv_nmos ad=95f pd=0.88u as=95f ps=0.88u w=0.5u l=0.13u
M377 a_99287_97399# a_98445_97301# a_99193_97399# sg13cmos5l_Corner_1.vss sg13_lv_nmos ad=0.12665p pd=1.145u as=0.1428p ps=1.52u w=0.42u l=0.13u
M378 a_93335_98911# a_92493_98813# a_92076_99152# vdd sg13_lv_pmos ad=0.2048p pd=1.63u as=0.34p ps=2.68u w=1u l=0.13u
M379 a_90044_98084# a_89762_98448# a_89977_98486# sg13cmos5l_Corner_1.vss sg13_lv_nmos ad=0.141p pd=1.17u as=71.99999f ps=0.865u w=0.64u l=0.13u
M380 adc8b_0.sar12b_0.sg13cmos5l_or2_1_0.A a_100131_95430# sg13cmos5l_Corner_1.vss sg13cmos5l_Corner_1.vss sg13_lv_nmos ad=0.1406p pd=1.12u as=0.1406p ps=1.12u w=0.74u l=0.13u
M381 sg13cmos5l_Corner_1.iovdd a_70044_42476# data[0] sg13cmos5l_Corner_1.iovdd sg13_hv_pmos ad=2.1312p pd=7.3u as=3.9294p ps=7.84u w=6.66u l=0.6u
M382 vdd adc8b_0.sar12b_0.sg13cmos5l_dfrbp_1_20.Q a_91633_98442# vdd sg13_lv_pmos ad=1.07253p pd=6.75u as=0.2856p ps=2.36u w=0.84u l=0.13u
M383 sg13cmos5l_Corner_1.vss a_90801_97322# a_90756_97358# sg13cmos5l_Corner_1.vss sg13_lv_nmos ad=0.1428p pd=1.52u as=47.25f ps=0.645u w=0.42u l=0.13u
M384 vdd sg13cmos5l_IOPadVdd$1_0.sg13cmos5l_Clamp_N43N43D4R$1_0.gate sg13cmos5l_Corner_1.vss sg13cmos5l_Corner_1.vss sg13_hv_nmos ad=2.596p pd=5.58u as=1.408p ps=5.04u w=4.4u l=0.6u
M385 sg13cmos5l_Corner_1.vss adc8b_0.sar12b_0.sg13cmos5l_inv_1_5.A a_102160_95060# sg13cmos5l_Corner_1.vss sg13_lv_nmos ad=0.14875p pd=1.16u as=0.187p ps=1.78u w=0.55u l=0.13u
M386 adc8b_0.side_cap8b_1.buf_8_1.z adc8b_0.sar12b_0.nl_sw[3] vddr vddr sg13_lv_pmos ad=0.19p pd=1.38u as=0.19p ps=1.38u w=1u l=0.13u
X387 sg13cmos5l_IOPadAnalog_12.pad sg13cmos5l_Corner_1.iovdd dpantenna l=1.26u w=27.78u
M388 sg13cmos5l_Corner_1.vss a_90609_96929# a_90564_96974# sg13cmos5l_Corner_1.vss sg13_lv_nmos ad=0.1428p pd=1.52u as=47.25f ps=0.645u w=0.42u l=0.13u
M389 adc8b_0.side_cap8b_1.buf_8_5.z adc8b_0.sar12b_0.nh_sw[5] vddr vddr sg13_lv_pmos ad=0.19p pd=1.38u as=0.19p ps=1.38u w=1u l=0.13u
M390 adc8b_0.sar12b_0.sg13cmos5l_dfrbp_1_4.D a_92232_93587# a_92381_93918# sg13cmos5l_Corner_1.vss sg13_lv_nmos ad=0.2516p pd=2.16u as=0.1406p ps=1.12u w=0.74u l=0.13u
M391 a_83252_100310# adc8b_0.sar12b_0.sg13cmos5l_inv_1_19.A sg13cmos5l_Corner_1.vss sg13cmos5l_Corner_1.vss sg13_lv_nmos ad=0.187p pd=1.78u as=0.14875p ps=1.16u w=0.55u l=0.13u
M392 frame a_134044_42476# sg13cmos5l_Corner_1.iovdd sg13cmos5l_Corner_1.iovdd sg13_hv_pmos ad=3.9294p pd=7.84u as=2.1312p ps=7.3u w=6.66u l=0.6u
X393 sg13cmos5l_IOPadAnalog_1.padres sg13cmos5l_Corner_1.iovdd dpantenna l=4.98u w=0.64u
M394 vdd a_86193_98441# a_86718_98514# vdd sg13_lv_pmos ad=0.1974p pd=1.5u as=0.2856p ps=2.36u w=0.84u l=0.13u
M395 sg13cmos5l_Corner_1.vss adc8b_0.sar12b_0.nh_sw[6] adc8b_0.side_cap8b_1.buf_4_1.z sg13cmos5l_Corner_1.vss sg13_lv_nmos ad=95f pd=0.88u as=95f ps=0.88u w=0.5u l=0.13u
M396 adc8b_0.side_cap8b_1.buf_32_1.z adc8b_0.sar12b_0.nh_sw[0] vddr vddr sg13_lv_pmos ad=0.19p pd=1.38u as=0.19p ps=1.38u w=1u l=0.13u
M397 data[1] a_86044_42476# sg13cmos5l_Corner_1.iovdd sg13cmos5l_Corner_1.iovdd sg13_hv_pmos ad=3.9294p pd=7.84u as=2.1312p ps=7.3u w=6.66u l=0.6u
M398 cks a_30676_118044# sg13cmos5l_Corner_1.vss sg13cmos5l_Corner_1.vss sg13_hv_nmos ad=2.596p pd=5.58u as=1.408p ps=5.04u w=4.4u l=0.6u
M399 vdd a_83716_99124# adc8b_0.sar12b_0.sg13cmos5l_buf_1_58.A vdd sg13_lv_pmos ad=0.2128p pd=1.5u as=0.3808p ps=2.92u w=1.12u l=0.13u
M400 adc8b_0.sar12b_0.sg13cmos5l_dlhr_1_11.Q_N a_95454_98514# sg13cmos5l_Corner_1.vss sg13cmos5l_Corner_1.vss sg13_lv_nmos ad=0.2516p pd=2.16u as=0.1491p ps=1.18u w=0.74u l=0.13u
M401 sg13cmos5l_Corner_1.vss a_84177_95810# a_84132_95846# sg13cmos5l_Corner_1.vss sg13_lv_nmos ad=0.1428p pd=1.52u as=47.25f ps=0.645u w=0.42u l=0.13u
M402 a_97618_96033# a_98061_95789# a_97358_95810# sg13cmos5l_Corner_1.vss sg13_lv_nmos ad=79.8f pd=0.8u as=0.1296p ps=1.52u w=0.42u l=0.13u
M403 adc8b_0.sar12b_0.nl_sw[6] a_93424_94336# sg13cmos5l_Corner_1.vss sg13cmos5l_Corner_1.vss sg13_lv_nmos ad=0.2886p pd=2.26u as=0.14875p ps=1.16u w=0.74u l=0.13u
M404 vdd adc8b_0.sar12b_0.sg13cmos5l_buf_1_3.A a_102064_92824# vdd sg13_lv_pmos ad=0.2114p pd=1.54u as=0.2856p ps=2.36u w=0.84u l=0.13u
M405 sg13cmos5l_Corner_1.vss a_89588_93512# adc8b_0.sar12b_0.sg13cmos5l_inv_1_14.A sg13cmos5l_Corner_1.vss sg13_lv_nmos ad=0.14875p pd=1.16u as=0.2886p ps=2.26u w=0.74u l=0.13u
M406 sg13cmos5l_IOPadAnalog_15.pad a_99639_164698# sg13cmos5l_Corner_1.iovdd sg13cmos5l_Corner_1.iovdd sg13_hv_pmos ad=3.9294p pd=7.84u as=2.1312p ps=7.3u w=6.66u l=0.6u
M407 sg13cmos5l_Corner_1.vss sg13cmos5l_IOPadVdd$1_0.sg13cmos5l_Clamp_N43N43D4R$1_0.gate vdd sg13cmos5l_Corner_1.vss sg13_hv_nmos ad=1.408p pd=5.04u as=2.596p ps=5.58u w=4.4u l=0.6u
M408 adc8b_0.sar12b_0.sg13cmos5l_buf_1_57.X a_91216_98084# sg13cmos5l_Corner_1.vss sg13cmos5l_Corner_1.vss sg13_lv_nmos ad=0.2886p pd=2.26u as=0.14875p ps=1.16u w=0.74u l=0.13u
M409 a_84132_95846# a_83583_95826# a_83996_96132# sg13cmos5l_Corner_1.vss sg13_lv_nmos ad=47.25f pd=0.645u as=0.141p ps=1.17u w=0.42u l=0.13u
M410 sg13cmos5l_Corner_1.iovdd a_164624_70044# sg13cmos5l_IOPadAnalog_1.pad sg13cmos5l_Corner_1.iovdd sg13_hv_pmos ad=2.1312p pd=7.3u as=3.9294p ps=7.84u w=6.66u l=0.6u
M411 sg13cmos5l_Corner_1.iovdd a_164624_102044# sg13cmos5l_IOPadAnalog_16.pad sg13cmos5l_Corner_1.iovdd sg13_hv_pmos ad=2.1312p pd=7.3u as=3.9294p ps=7.84u w=6.66u l=0.6u
M412 sg13cmos5l_IOPadAnalog_13.pad a_115639_164698# sg13cmos5l_Corner_1.iovdd sg13cmos5l_Corner_1.iovdd sg13_hv_pmos ad=3.9294p pd=7.84u as=2.1312p ps=7.3u w=6.66u l=0.6u
M413 a_98230_95498# a_97972_95498# sg13cmos5l_Corner_1.vss sg13cmos5l_Corner_1.vss sg13_lv_nmos ad=0.1428p pd=1.52u as=79.8f ps=0.8u w=0.42u l=0.13u
M414 sg13cmos5l_Corner_1.vss adc8b_0.sar12b_0.nh_sw[1] adc8b_0.side_cap8b_1.buf_16_3.z sg13cmos5l_Corner_1.vss sg13_lv_nmos ad=95f pd=0.88u as=95f ps=0.88u w=0.5u l=0.13u
M415 sg13cmos5l_Corner_1.vss sg13cmos5l_IOPadVdd$1_0.sg13cmos5l_Clamp_N43N43D4R$1_0.gate vdd sg13cmos5l_Corner_1.vss sg13_hv_nmos ad=1.408p pd=5.04u as=2.596p ps=5.58u w=4.4u l=0.6u
M416 vdd a_80694_96641# a_80806_96705# vdd sg13_lv_pmos ad=0.2254p pd=1.53u as=0.34p ps=2.68u w=1u l=0.5u
M417 a_86872_96030# a_86615_95887# a_87034_95810# sg13cmos5l_Corner_1.vss sg13_lv_nmos ad=0.1428p pd=1.52u as=37.8f ps=0.6u w=0.42u l=0.13u
M418 sg13cmos5l_Corner_1.iovdd a_83639_164698# sg13cmos5l_IOPadAnalog_9.pad sg13cmos5l_Corner_1.iovdd sg13_hv_pmos ad=2.1312p pd=7.3u as=3.9294p ps=7.84u w=6.66u l=0.6u
M419 adc8b_0.side_cap8b_0.buf_8_1.z adc8b_0.side_cap8b_0.in_l_sw[3] vddr vddr sg13_lv_pmos ad=0.19p pd=1.38u as=0.19p ps=1.38u w=1u l=0.13u
M420 a_85330_96033# a_85773_95789# a_85713_96201# vdd sg13_lv_pmos ad=79.8f pd=0.8u as=63f ps=0.72u w=0.42u l=0.13u
M421 cko a_118044_42476# sg13cmos5l_Corner_1.iovdd sg13cmos5l_Corner_1.iovdd sg13_hv_pmos ad=3.9294p pd=7.84u as=2.1312p ps=7.3u w=6.66u l=0.6u
M422 sg13cmos5l_Corner_1.vss adc8b_0.sar12b_0.sg13cmos5l_dlygate4sd3_1_0.X adc8b_0.sar12b_0.sg13cmos5l_buf_1_43.A sg13cmos5l_Corner_1.vss sg13_lv_nmos ad=0.2516p pd=2.16u as=0.2516p ps=2.16u w=0.74u l=0.13u
M423 sg13cmos5l_Corner_1.vss a_98708_94262# adc8b_0.sar12b_0.nh_sw[8] sg13cmos5l_Corner_1.vss sg13_lv_nmos ad=0.14875p pd=1.16u as=0.2886p ps=2.26u w=0.74u l=0.13u
M424 a_92099_95060# adc8b_0.sar12b_0.sg13cmos5l_a221oi_1_0.C1 vdd vdd sg13_lv_pmos ad=0.3808p pd=2.92u as=0.2128p ps=1.5u w=1.12u l=0.13u
M425 a_85844_98784# a_86117_98796# a_86079_98870# sg13cmos5l_Corner_1.vss sg13_lv_nmos ad=0.141p pd=1.17u as=47.25f ps=0.645u w=0.42u l=0.13u
M426 a_97932_95823# a_97644_96128# a_97870_95823# sg13cmos5l_Corner_1.vss sg13_lv_nmos ad=0.1428p pd=1.52u as=37.8f ps=0.6u w=0.42u l=0.13u
M427 adc8b_0.sar12b_0.sg13cmos5l_dlhr_1_17.Q_N a_91134_97002# sg13cmos5l_Corner_1.vss sg13cmos5l_Corner_1.vss sg13_lv_nmos ad=0.2516p pd=2.16u as=0.1491p ps=1.18u w=0.74u l=0.13u
M428 sg13cmos5l_Corner_1.vss adc8b_0.sar12b_0.nh_sw[4] adc8b_0.side_cap8b_1.buf_8_2.z sg13cmos5l_Corner_1.vss sg13_lv_nmos ad=95f pd=0.88u as=0.17p ps=1.68u w=0.5u l=0.13u
M429 sg13cmos5l_Corner_1.vss a_90551_98911# a_91388_99132# sg13cmos5l_Corner_1.vss sg13_lv_nmos ad=0.1406p pd=1.12u as=0.2516p ps=2.16u w=0.74u l=0.13u
M430 a_82388_93512# adc8b_0.sar12b_0.sg13cmos5l_buf_1_32.X sg13cmos5l_Corner_1.vss sg13cmos5l_Corner_1.vss sg13_lv_nmos ad=0.187p pd=1.78u as=0.14875p ps=1.16u w=0.55u l=0.13u
M431 vdd sg13cmos5l_IOPadVdd$1_0.sg13cmos5l_Clamp_N43N43D4R$1_0.gate sg13cmos5l_Corner_1.vss sg13cmos5l_Corner_1.vss sg13_hv_nmos ad=2.596p pd=5.58u as=1.408p ps=5.04u w=4.4u l=0.6u
M432 adc8b_0.side_cap8b_0.buf_32_0.z adc8b_0.side_cap8b_0.in_l_sw[0] sg13cmos5l_Corner_1.vss sg13cmos5l_Corner_1.vss sg13_lv_nmos ad=95f pd=0.88u as=95f ps=0.88u w=0.5u l=0.13u
M433 sg13cmos5l_Corner_1.vss vdd sg13cmos5l_Corner_1.vss sg13cmos5l_Corner_1.vss sg13_lv_nmos ad=0.1428p pd=1.52u as=0 ps=0 w=0.42u l=1u
M434 vip a_30676_102044# sg13cmos5l_Corner_1.vss sg13cmos5l_Corner_1.vss sg13_hv_nmos ad=2.596p pd=5.58u as=1.408p ps=5.04u w=4.4u l=0.6u
M435 vdd a_85076_96536# adc8b_0.sar12b_0.sg13cmos5l_buf_1_41.A vdd sg13_lv_pmos ad=0.2114p pd=1.54u as=0.42p ps=2.99u w=1.12u l=0.13u
M436 a_87220_97010# a_86837_96536# vdd vdd sg13_lv_pmos ad=79.8f pd=0.8u as=0.2639p ps=1.81u w=0.42u l=0.13u
M437 sg13cmos5l_Corner_1.vss a_86044_30676# data[1] sg13cmos5l_Corner_1.vss sg13_hv_nmos ad=1.408p pd=5.04u as=2.596p ps=5.58u w=4.4u l=0.6u
M438 adc8b_0.side_cap8b_0.buf_16_0.z adc8b_0.side_cap8b_0.in_h_sw[2] vddr vddr sg13_lv_pmos ad=0.19p pd=1.38u as=0.19p ps=1.38u w=1u l=0.13u
M439 a_91790_98834# a_92595_98956# a_92050_99057# vdd sg13_lv_pmos ad=0.1428p pd=1.52u as=79.8f ps=0.8u w=0.42u l=0.13u
M440 data[0] a_70044_42476# sg13cmos5l_Corner_1.iovdd sg13cmos5l_Corner_1.iovdd sg13_hv_pmos ad=3.9294p pd=7.84u as=2.1312p ps=7.3u w=6.66u l=0.6u
M441 sg13cmos5l_Corner_1.iovdd a_102044_42476# data[2] sg13cmos5l_Corner_1.iovdd sg13_hv_pmos ad=2.1312p pd=7.3u as=3.9294p ps=7.84u w=6.66u l=0.6u
M442 a_101780_93512# adc8b_0.sar12b_0.sg13cmos5l_buf_1_0.X vdd vdd sg13_lv_pmos ad=0.2856p pd=2.36u as=0.2114p ps=1.54u w=0.84u l=0.13u
M443 a_93900_100664# a_93874_100569# sg13cmos5l_Corner_1.vss sg13cmos5l_Corner_1.vss sg13_lv_nmos ad=0.2516p pd=2.16u as=0.1626p ps=1.415u w=0.74u l=0.13u
M444 sg13cmos5l_Corner_1.vss a_101361_97322# a_101886_97304# sg13cmos5l_Corner_1.vss sg13_lv_nmos ad=0.1491p pd=1.18u as=0.187p ps=1.78u w=0.55u l=0.13u
M445 vdd a_92840_96507# adc8b_0.sar12b_0.sg13cmos5l_a221oi_1_1.C1 vdd sg13_lv_pmos ad=0.36195p pd=1.84u as=0.3808p ps=2.92u w=1.12u l=0.13u
M446 vddr adc8b_0.sar12b_0.nh_sw[4] adc8b_0.side_cap8b_1.buf_8_2.z vddr sg13_lv_pmos ad=0.19p pd=1.38u as=0.19p ps=1.38u w=1u l=0.13u
M447 vddr a_42476_70044# sg13cmos5l_Corner_1.iovdd sg13cmos5l_Corner_1.iovdd sg13_hv_pmos ad=3.9294p pd=7.84u as=2.1312p ps=7.3u w=6.66u l=0.6u
M448 vdd a_99729_99953# a_99662_99596# vdd sg13_lv_pmos ad=0.2387p pd=1.84u as=0.1008p ps=0.9u w=0.42u l=0.13u
M449 vdd a_90225_98441# a_90750_98514# vdd sg13_lv_pmos ad=0.1974p pd=1.5u as=0.2856p ps=2.36u w=0.84u l=0.13u
M450 a_85945_98486# a_85393_98442# sg13cmos5l_Corner_1.vss sg13cmos5l_Corner_1.vss sg13_lv_nmos ad=71.99999f pd=0.865u as=1.49685p ps=9.6u w=0.64u l=0.13u
M451 a_99105_96125# a_98163_95932# a_98903_95887# vdd sg13_lv_pmos ad=93.45f pd=0.865u as=0.2048p ps=1.63u w=0.42u l=0.13u
M452 sg13cmos5l_Corner_1.vss a_118044_30676# cko sg13cmos5l_Corner_1.vss sg13_hv_nmos ad=1.408p pd=5.04u as=2.596p ps=5.58u w=4.4u l=0.6u
M453 sg13cmos5l_Corner_1.vss a_96668_93512# adc8b_0.sar12b_0.sg13cmos5l_nand2_1_0.A sg13cmos5l_Corner_1.vss sg13_lv_nmos ad=0.17255p pd=1.25u as=0.1406p ps=1.12u w=0.74u l=0.13u
M454 vddr adc8b_0.side_cap8b_0.in_l_sw[4] adc8b_0.side_cap8b_0.buf_8_0.z vddr sg13_lv_pmos ad=0.19p pd=1.38u as=0.19p ps=1.38u w=1u l=0.13u
M455 adc8b_0.sar12b_0.sg13cmos5l_buf_1_94.X a_96784_100384# sg13cmos5l_Corner_1.vss sg13cmos5l_Corner_1.vss sg13_lv_nmos ad=0.2886p pd=2.26u as=0.14875p ps=1.16u w=0.74u l=0.13u
M456 data[2] a_102044_30676# sg13cmos5l_Corner_1.vss sg13cmos5l_Corner_1.vss sg13_hv_nmos ad=2.596p pd=5.58u as=1.408p ps=5.04u w=4.4u l=0.6u
M457 adc8b_0.sar12b_0.sg13cmos5l_dlhr_1_6.Q_N a_91326_97304# vdd vdd sg13_lv_pmos ad=0.3808p pd=2.92u as=0.1974p ps=1.5u w=1.12u l=0.13u
M458 adc8b_0.side_cap8b_1.buf_16_1.z adc8b_0.sar12b_0.nl_sw[2] sg13cmos5l_Corner_1.vss sg13cmos5l_Corner_1.vss sg13_lv_nmos ad=95f pd=0.88u as=95f ps=0.88u w=0.5u l=0.13u
M459 sg13cmos5l_IOPadAnalog_10.pad a_67639_164698# sg13cmos5l_Corner_1.iovdd sg13cmos5l_Corner_1.iovdd sg13_hv_pmos ad=3.9294p pd=7.84u as=2.1312p ps=7.3u w=6.66u l=0.6u
M460 adc8b_0.sar12b_0.sg13cmos5l_dfrbp_1_6.RESET_B cks vdd vdd sg13_lv_pmos ad=0.2184p pd=1.51u as=0.2128p ps=1.5u w=1.12u l=0.13u
M461 vdd a_101108_99560# adc8b_0.side_cap8b_0.in_l_sw[9] vdd sg13_lv_pmos ad=0.2114p pd=1.54u as=0.42p ps=2.99u w=1.12u l=0.13u
M462 sg13cmos5l_Corner_1.vss a_178296_70044# sg13cmos5l_IOPadAnalog_1.pad sg13cmos5l_Corner_1.vss sg13_hv_nmos ad=1.408p pd=5.04u as=2.596p ps=5.58u w=4.4u l=0.6u
M463 a_100910_96572# a_100514_96936# a_100796_96572# vdd sg13_lv_pmos ad=0.1008p pd=0.9u as=0.191p ps=1.44u w=0.42u l=0.13u
M464 sg13cmos5l_IOPadAnalog_0.pad a_178296_86044# sg13cmos5l_Corner_1.vss sg13cmos5l_Corner_1.vss sg13_hv_nmos ad=2.596p pd=5.58u as=1.408p ps=5.04u w=4.4u l=0.6u
M465 sg13cmos5l_IOPadAnalog_15.pad a_99639_178370# sg13cmos5l_Corner_1.vss sg13cmos5l_Corner_1.vss sg13_hv_nmos ad=2.596p pd=5.58u as=1.408p ps=5.04u w=4.4u l=0.6u
M466 sg13cmos5l_IOPadAnalog_9.pad a_83639_164698# sg13cmos5l_Corner_1.iovdd sg13cmos5l_Corner_1.iovdd sg13_hv_pmos ad=3.9294p pd=7.84u as=2.1312p ps=7.3u w=6.66u l=0.6u
M467 vdd adc8b_0.sar12b_0.sg13cmos5l_dfrbp_1_6.RESET_B a_87278_95498# vdd sg13_lv_pmos ad=0.36237p pd=2.605u as=79.8f ps=0.8u w=0.42u l=0.13u
M468 adc8b_0.side_cap8b_1.buf_32_1.z adc8b_0.sar12b_0.nh_sw[0] sg13cmos5l_Corner_1.vss sg13cmos5l_Corner_1.vss sg13_lv_nmos ad=95f pd=0.88u as=95f ps=0.88u w=0.5u l=0.13u
X469 a_36456_138715# a_40542_138385# sg13cmos5l_Corner_1.vss rppd l=20u w=1u
M470 adc8b_0.sar12b_0.sg13cmos5l_buf_1_30.X a_90448_92824# vdd vdd sg13_lv_pmos ad=0.42p pd=2.99u as=0.2114p ps=1.54u w=1.12u l=0.13u
M471 adc8b_0.side_cap8b_0.buf_32_1.z adc8b_0.side_cap8b_0.in_h_sw[0] sg13cmos5l_Corner_1.vss sg13cmos5l_Corner_1.vss sg13_lv_nmos ad=95f pd=0.88u as=95f ps=0.88u w=0.5u l=0.13u
M472 sg13cmos5l_Corner_1.vss a_83639_178370# sg13cmos5l_IOPadAnalog_9.pad sg13cmos5l_Corner_1.vss sg13_hv_nmos ad=1.408p pd=5.04u as=2.596p ps=5.58u w=4.4u l=0.6u
M473 sg13cmos5l_Corner_1.iovdd a_99639_164698# sg13cmos5l_IOPadAnalog_15.pad sg13cmos5l_Corner_1.iovdd sg13_hv_pmos ad=3.1302p pd=14.26u as=3.9294p ps=7.84u w=6.66u l=0.6u
M474 sg13cmos5l_Corner_1.iovdd a_115639_164698# sg13cmos5l_IOPadAnalog_13.pad sg13cmos5l_Corner_1.iovdd sg13_hv_pmos ad=2.1312p pd=7.3u as=3.9294p ps=7.84u w=6.66u l=0.6u
M475 adc8b_0.side_cap8b_0.buf_2_0.z adc8b_0.side_cap8b_0.in_h_sw[8] vddr vddr sg13_lv_pmos ad=0.34p pd=2.68u as=0.19p ps=1.38u w=1u l=0.13u
M476 vdd a_85342_99010# adc8b_0.sar12b_0.sg13cmos5l_dlhr_1_9.Q_N vdd sg13_lv_pmos ad=0.1974p pd=1.5u as=0.3808p ps=2.92u w=1.12u l=0.13u
M477 a_95252_99560# adc8b_0.sar12b_0.sg13cmos5l_dlhr_1_11.Q vdd vdd sg13_lv_pmos ad=0.2856p pd=2.36u as=0.2114p ps=1.54u w=0.84u l=0.13u
M478 a_89399_95887# a_88557_95789# a_89305_95887# sg13cmos5l_Corner_1.vss sg13_lv_nmos ad=0.12665p pd=1.145u as=0.1428p ps=1.52u w=0.42u l=0.13u
M479 adc8b_0.sar12b_0.sg13cmos5l_dfrbp_1_10.Q_N a_85367_94375# vdd vdd sg13_lv_pmos ad=0.4312p pd=3.01u as=0.2639p ps=1.81u w=1.12u l=0.13u
M480 sg13cmos5l_Corner_1.vss adc8b_0.sar12b_0.sg13cmos5l_inv_1_18.A a_91024_100384# sg13cmos5l_Corner_1.vss sg13_lv_nmos ad=0.14875p pd=1.16u as=0.187p ps=1.78u w=0.55u l=0.13u
M481 a_84406_97322# a_84647_97592# a_83765_97286# sg13cmos5l_Corner_1.vss sg13_lv_nmos ad=0.1428p pd=1.52u as=0.12665p ps=1.145u w=0.42u l=0.13u
M482 a_89209_92778# a_88657_92840# sg13cmos5l_Corner_1.vss sg13cmos5l_Corner_1.vss sg13_lv_nmos ad=71.99999f pd=0.865u as=7.01497p ps=46.005u w=0.64u l=0.13u
M483 sg13cmos5l_Corner_1.vss a_30676_118044# cks sg13cmos5l_Corner_1.vss sg13_hv_nmos ad=1.408p pd=5.04u as=2.596p ps=5.58u w=4.4u l=0.6u
M484 vddr adc8b_0.side_cap8b_0.in_l_sw[1] adc8b_0.side_cap8b_0.buf_16_2.z vddr sg13_lv_pmos ad=0.19p pd=1.38u as=0.34p ps=2.68u w=1u l=0.13u
M485 adc8b_0.diff_bsw_0.single_bsw_0.sg13cmos5l_inv_1$1_0.A cks sg13cmos5l_Corner_1.vss sg13cmos5l_Corner_1.vss sg13_lv_nmos ad=0.2516p pd=2.16u as=0.2516p ps=2.16u w=0.74u l=0.13u
M486 vdd sg13cmos5l_IOPadVdd$1_0.sg13cmos5l_Clamp_N43N43D4R$1_0.gate sg13cmos5l_Corner_1.vss sg13cmos5l_Corner_1.vss sg13_hv_nmos ad=2.596p pd=5.58u as=1.408p ps=5.04u w=4.4u l=0.6u
M487 sg13cmos5l_Corner_1.vss adc8b_0.sar12b_0.sg13cmos5l_buf_1_97.A a_93616_99596# sg13cmos5l_Corner_1.vss sg13_lv_nmos ad=0.14875p pd=1.16u as=0.187p ps=1.78u w=0.55u l=0.13u
M488 sg13cmos5l_IOPadAnalog_1.pad a_164624_70044# sg13cmos5l_Corner_1.iovdd sg13cmos5l_Corner_1.iovdd sg13_hv_pmos ad=3.9294p pd=7.84u as=2.1312p ps=7.3u w=6.66u l=0.6u
M489 adc8b_0.side_cap8b_1.buf_16_2.z adc8b_0.sar12b_0.nl_sw[1] sg13cmos5l_Corner_1.vss sg13cmos5l_Corner_1.vss sg13_lv_nmos ad=95f pd=0.88u as=95f ps=0.88u w=0.5u l=0.13u
M490 adc8b_0.side_cap8b_1.buf_32_1.z adc8b_0.sar12b_0.nh_sw[0] sg13cmos5l_Corner_1.vss sg13cmos5l_Corner_1.vss sg13_lv_nmos ad=95f pd=0.88u as=95f ps=0.88u w=0.5u l=0.13u
M491 vin a_30676_86044# sg13cmos5l_Corner_1.vss sg13cmos5l_Corner_1.vss sg13_hv_nmos ad=2.596p pd=5.58u as=1.408p ps=5.04u w=4.4u l=0.6u
M492 sg13cmos5l_Corner_1.vss a_83252_100310# adc8b_0.sar12b_0.sg13cmos5l_buf_1_68.X sg13cmos5l_Corner_1.vss sg13_lv_nmos ad=0.14875p pd=1.16u as=0.2886p ps=2.26u w=0.74u l=0.13u
M493 vdd a_100113_98834# a_100638_98816# vdd sg13_lv_pmos ad=0.1974p pd=1.5u as=0.2856p ps=2.36u w=0.84u l=0.13u
M494 sg13cmos5l_Corner_1.vss a_178296_86044# sg13cmos5l_IOPadAnalog_0.pad sg13cmos5l_Corner_1.vss sg13_hv_nmos ad=2.068p pd=9.74u as=2.596p ps=5.58u w=4.4u l=0.6u
M495 sg13cmos5l_Corner_1.vss adc8b_0.side_cap8b_0.in_h_sw[1] adc8b_0.side_cap8b_0.buf_16_3.z sg13cmos5l_Corner_1.vss sg13_lv_nmos ad=95f pd=0.88u as=95f ps=0.88u w=0.5u l=0.13u
M496 adc8b_0.sar12b_0.sg13cmos5l_buf_1_103.A a_97552_100384# sg13cmos5l_Corner_1.vss sg13cmos5l_Corner_1.vss sg13_lv_nmos ad=0.2886p pd=2.26u as=0.14875p ps=1.16u w=0.74u l=0.13u
M497 sg13cmos5l_Corner_1.vss adc8b_0.sar12b_0.sg13cmos5l_buf_1_29.A adc8b_0.sar12b_0.sg13cmos5l_buf_1_77.A sg13cmos5l_Corner_1.vss sg13_lv_nmos ad=0.2516p pd=2.16u as=0.2516p ps=2.16u w=0.74u l=0.13u
M498 vdd adc8b_0.sar12b_0.sg13cmos5l_and3_1_0.C a_95092_95856# vdd sg13_lv_pmos ad=0.36195p pd=1.84u as=0.1596p ps=1.22u w=0.84u l=0.13u
M499 a_85377_95183# a_84435_95071# a_85175_95421# vdd sg13_lv_pmos ad=93.45f pd=0.865u as=0.2048p ps=1.63u w=0.42u l=0.13u
M500 vdd adc8b_0.sar12b_0.sg13cmos5l_dfrbp_1_0.RESET_B a_93298_95028# vdd sg13_lv_pmos ad=0.1563p pd=1.22u as=0.147p ps=1.54u w=0.42u l=0.13u
M501 sg13cmos5l_IOPadAnalog_15.pad a_99639_164698# sg13cmos5l_Corner_1.iovdd sg13cmos5l_Corner_1.iovdd sg13_hv_pmos ad=3.9294p pd=7.84u as=2.1312p ps=7.3u w=6.66u l=0.6u
M502 vdd a_99287_97399# a_99544_97542# vdd sg13_lv_pmos ad=0.2639p pd=1.81u as=79.8f ps=0.8u w=0.42u l=0.13u
M503 vdd adc8b_0.sar12b_0.sg13cmos5l_nand2_1_1.A adc8b_0.sar12b_0.sg13cmos5l_o21ai_1_0.B1 vdd sg13_lv_pmos ad=0.3808p pd=2.92u as=0.2128p ps=1.5u w=1.12u l=0.13u
M504 adc8b_0.sar12b_0.sg13cmos5l_dlhr_1_9.D a_84572_96572# vdd vdd sg13_lv_pmos ad=0.3808p pd=2.92u as=0.2128p ps=1.5u w=1.12u l=0.13u
X505 cks sg13cmos5l_Corner_1.iovdd dpantenna l=27.78u w=1.26u
M506 sg13cmos5l_Corner_1.iovdd a_164624_102044# sg13cmos5l_IOPadAnalog_16.pad sg13cmos5l_Corner_1.iovdd sg13_hv_pmos ad=2.1312p pd=7.3u as=3.9294p ps=7.84u w=6.66u l=0.6u
M507 vin a_42476_86044# sg13cmos5l_Corner_1.iovdd sg13cmos5l_Corner_1.iovdd sg13_hv_pmos ad=3.9294p pd=7.84u as=2.1312p ps=7.3u w=6.66u l=0.6u
M508 sg13cmos5l_Corner_1.iovdd a_42476_86044# vin sg13cmos5l_Corner_1.iovdd sg13_hv_pmos ad=2.1312p pd=7.3u as=3.9294p ps=7.84u w=6.66u l=0.6u
M509 sg13cmos5l_Corner_1.vss adc8b_0.side_cap8b_0.in_h_sw[5] adc8b_0.side_cap8b_0.buf_8_5.z sg13cmos5l_Corner_1.vss sg13_lv_nmos ad=95f pd=0.88u as=95f ps=0.88u w=0.5u l=0.13u
M510 a_93612_95485# a_93843_95071# a_93298_95028# sg13cmos5l_Corner_1.vss sg13_lv_nmos ad=0.2373p pd=1.97u as=79.8f ps=0.8u w=0.42u l=0.13u
M511 sg13cmos5l_Corner_1.iovdd a_134044_42476# frame sg13cmos5l_Corner_1.iovdd sg13_hv_pmos ad=2.1312p pd=7.3u as=3.9294p ps=7.84u w=6.66u l=0.6u
M512 sg13cmos5l_IOPadAnalog_11.pad a_164624_118044# sg13cmos5l_Corner_1.iovdd sg13cmos5l_Corner_1.iovdd sg13_hv_pmos ad=3.9294p pd=7.84u as=2.1312p ps=7.3u w=6.66u l=0.6u
M513 sg13cmos5l_Corner_1.vss adc8b_0.sar12b_0.sg13cmos5l_buf_1_3.X a_102160_94336# sg13cmos5l_Corner_1.vss sg13_lv_nmos ad=0.14875p pd=1.16u as=0.187p ps=1.78u w=0.55u l=0.13u
M514 vdd a_92355_95852# adc8b_0.sar12b_0.sg13cmos5l_nand2_1_0.B vdd sg13_lv_pmos ad=0.3808p pd=2.92u as=0.2128p ps=1.5u w=1.12u l=0.13u
M515 a_84334_94311# adc8b_0.sar12b_0.sg13cmos5l_dfrbp_1_6.RESET_B sg13cmos5l_Corner_1.vss sg13cmos5l_Corner_1.vss sg13_lv_nmos ad=37.8f pd=0.6u as=0.1701p ps=1.65u w=0.42u l=0.13u
M516 sg13cmos5l_Corner_1.vss adc8b_0.sar12b_0.nl_sw[5] adc8b_0.side_cap8b_1.buf_8_4.z sg13cmos5l_Corner_1.vss sg13_lv_nmos ad=95f pd=0.88u as=0.17p ps=1.68u w=0.5u l=0.13u
M517 sg13cmos5l_Corner_1.vss a_131639_178370# sg13cmos5l_IOPadAnalog_12.pad sg13cmos5l_Corner_1.vss sg13_hv_nmos ad=1.408p pd=5.04u as=2.596p ps=5.58u w=4.4u l=0.6u
M518 a_80694_96641# a_80424_96641# sg13cmos5l_Corner_1.vss sg13cmos5l_Corner_1.vss sg13_lv_nmos ad=0.1428p pd=1.52u as=79.8f ps=0.8u w=0.42u l=0.5u
M519 vdd adc8b_0.sar12b_0.sg13cmos5l_buf_1_34.A a_86608_92824# vdd sg13_lv_pmos ad=0.2114p pd=1.54u as=0.2856p ps=2.36u w=0.84u l=0.13u
M520 sg13cmos5l_Corner_1.iovdd a_42476_118044# cks sg13cmos5l_Corner_1.iovdd sg13_hv_pmos ad=2.1312p pd=7.3u as=3.9294p ps=7.84u w=6.66u l=0.6u
X521 sg13cmos5l_IOPadAnalog_8.padres sg13cmos5l_Corner_1.iovdd dpantenna l=4.98u w=0.64u
M522 adc8b_0.side_cap8b_1.buf_8_3.z adc8b_0.sar12b_0.nh_sw[3] vddr vddr sg13_lv_pmos ad=0.19p pd=1.38u as=0.19p ps=1.38u w=1u l=0.13u
M523 vdd a_82292_95774# adc8b_0.cmp_0.clk vdd sg13_lv_pmos ad=0.2114p pd=1.54u as=0.42p ps=2.99u w=1.12u l=0.13u
M524 sg13cmos5l_Corner_1.vss adc8b_0.sar12b_0.sg13cmos5l_dfrbp_1_0.RESET_B a_93132_92786# sg13cmos5l_Corner_1.vss sg13_lv_nmos ad=0.1626p pd=1.415u as=60.89999f ps=0.71u w=0.42u l=0.13u
X525 a_36456_140035# a_40542_139705# sg13cmos5l_Corner_1.vss rppd l=20u w=1u
M526 adc8b_0.sar12b_0.sg13cmos5l_buf_1_116.A a_96945_96929# vdd vdd sg13_lv_pmos ad=0.3808p pd=2.92u as=0.2128p ps=1.5u w=1.12u l=0.13u
M527 frame a_134044_30676# sg13cmos5l_Corner_1.vss sg13cmos5l_Corner_1.vss sg13_hv_nmos ad=2.596p pd=5.58u as=1.408p ps=5.04u w=4.4u l=0.6u
M528 sg13cmos5l_Corner_1.vss a_85076_96536# adc8b_0.sar12b_0.sg13cmos5l_buf_1_41.A sg13cmos5l_Corner_1.vss sg13_lv_nmos ad=0.14875p pd=1.16u as=0.2886p ps=2.26u w=0.74u l=0.13u
M529 sg13cmos5l_Corner_1.vss vdd sg13cmos5l_Corner_1.vss sg13cmos5l_Corner_1.vss sg13_lv_nmos ad=0.1428p pd=1.52u as=0 ps=0 w=0.42u l=1u
M530 data[2] a_102044_42476# sg13cmos5l_Corner_1.iovdd sg13cmos5l_Corner_1.iovdd sg13_hv_pmos ad=3.9294p pd=7.84u as=3.1302p ps=14.26u w=6.66u l=0.6u
X531 sg13cmos5l_IOPadAnalog_1.padres sg13cmos5l_IOPadAnalog_1.pad sg13cmos5l_Corner_1.vss rppd l=2u w=1u
M532 sg13cmos5l_IOPadAnalog_10.pad a_67639_178370# sg13cmos5l_Corner_1.vss sg13cmos5l_Corner_1.vss sg13_hv_nmos ad=2.596p pd=5.58u as=1.408p ps=5.04u w=4.4u l=0.6u
M533 vdd a_83231_99901# a_83231_99671# vdd sg13_lv_pmos ad=1.15047p pd=7.175u as=0.2442p ps=2.06u w=0.66u l=0.13u
M534 a_94510_97335# adc8b_0.sar12b_0.sg13cmos5l_dfrbp_1_6.RESET_B sg13cmos5l_Corner_1.vss sg13cmos5l_Corner_1.vss sg13_lv_nmos ad=37.8f pd=0.6u as=0.1701p ps=1.65u w=0.42u l=0.13u
M535 a_97486_93973# adc8b_0.sar12b_0.sg13cmos5l_dfrbp_1_0.RESET_B sg13cmos5l_Corner_1.vss sg13cmos5l_Corner_1.vss sg13_lv_nmos ad=37.8f pd=0.6u as=0.1701p ps=1.65u w=0.42u l=0.13u
M536 vdd a_82388_93512# adc8b_0.sar12b_0.nl_sw[0] vdd sg13_lv_pmos ad=0.2114p pd=1.54u as=0.42p ps=2.99u w=1.12u l=0.13u
M537 vdd a_92433_98441# a_92958_98514# vdd sg13_lv_pmos ad=0.1974p pd=1.5u as=0.2856p ps=2.36u w=0.84u l=0.13u
M538 a_95026_94521# a_95469_94277# a_95409_94689# vdd sg13_lv_pmos ad=79.8f pd=0.8u as=63f ps=0.72u w=0.42u l=0.13u
M539 sg13cmos5l_IOPadAnalog_16.pad a_164624_102044# sg13cmos5l_Corner_1.iovdd sg13cmos5l_Corner_1.iovdd sg13_hv_pmos ad=3.9294p pd=7.84u as=2.1312p ps=7.3u w=6.66u l=0.6u
M540 vdd sg13cmos5l_Corner_1.vss vdd vdd sg13_lv_pmos ad=0.19p pd=1.38u as=0 ps=0 w=1u l=1u
M541 sg13cmos5l_Corner_1.vss a_82926_94302# a_83058_94366# sg13cmos5l_Corner_1.vss sg13_lv_nmos ad=0.1405p pd=1.15u as=0.2163p ps=1.87u w=0.42u l=0.18u
M542 sg13cmos5l_Corner_1.vss adc8b_0.sar12b_0.nh_sw[8] adc8b_0.side_cap8b_1.buf_2_0.z sg13cmos5l_Corner_1.vss sg13_lv_nmos ad=95f pd=0.88u as=0.17p ps=1.68u w=0.5u l=0.13u
M543 a_95228_99156# a_94815_98850# a_95160_99156# vdd sg13_lv_pmos ad=0.191p pd=1.44u as=0.105p ps=1.21u w=1u l=0.13u
M544 a_90044_98084# a_89631_98442# a_89976_98084# vdd sg13_lv_pmos ad=0.191p pd=1.44u as=0.105p ps=1.21u w=1u l=0.13u
M545 adc8b_0.side_cap8b_1.buf_8_5.z adc8b_0.sar12b_0.nh_sw[5] sg13cmos5l_Corner_1.vss sg13cmos5l_Corner_1.vss sg13_lv_nmos ad=0.17p pd=1.68u as=95f ps=0.88u w=0.5u l=0.13u
M546 sg13cmos5l_Corner_1.vss a_99639_178370# sg13cmos5l_IOPadAnalog_15.pad sg13cmos5l_Corner_1.vss sg13_hv_nmos ad=1.408p pd=5.04u as=2.596p ps=5.58u w=4.4u l=0.6u
M547 sg13cmos5l_Corner_1.iovdd a_67639_164698# sg13cmos5l_IOPadAnalog_10.pad sg13cmos5l_Corner_1.iovdd sg13_hv_pmos ad=3.1302p pd=14.26u as=3.9294p ps=7.84u w=6.66u l=0.6u
M548 sg13cmos5l_Corner_1.iovdd a_83639_164698# sg13cmos5l_IOPadAnalog_9.pad sg13cmos5l_Corner_1.iovdd sg13_hv_pmos ad=2.1312p pd=7.3u as=3.9294p ps=7.84u w=6.66u l=0.6u
M549 sg13cmos5l_Corner_1.vss adc8b_0.side_cap8b_0.in_l_sw[0] adc8b_0.side_cap8b_0.buf_32_0.z sg13cmos5l_Corner_1.vss sg13_lv_nmos ad=95f pd=0.88u as=0.17p ps=1.68u w=0.5u l=0.13u
M550 a_90753_99149# a_89811_98956# a_90551_98911# vdd sg13_lv_pmos ad=93.45f pd=0.865u as=0.2048p ps=1.63u w=0.42u l=0.13u
M551 adc8b_0.sar12b_0.sg13cmos5l_a22oi_1_0.Y adc8b_0.sar12b_0.sg13cmos5l_a22oi_1_0.B1 a_92551_95036# vdd sg13_lv_pmos ad=0.2128p pd=1.5u as=0.2716p ps=1.605u w=1.12u l=0.13u
M552 vdd a_100131_95430# adc8b_0.sar12b_0.sg13cmos5l_or2_1_0.A vdd sg13_lv_pmos ad=0.2128p pd=1.5u as=0.2128p ps=1.5u w=1.12u l=0.13u
M553 a_83916_94298# adc8b_0.sar12b_0.sg13cmos5l_dfrbp_1_6.D a_83822_94298# sg13cmos5l_Corner_1.vss sg13_lv_nmos ad=60.89999f pd=0.71u as=0.1428p ps=1.52u w=0.42u l=0.13u
M554 sg13cmos5l_Corner_1.iovdd a_164624_118044# sg13cmos5l_IOPadAnalog_11.pad sg13cmos5l_Corner_1.iovdd sg13_hv_pmos ad=2.1312p pd=7.3u as=3.9294p ps=7.84u w=6.66u l=0.6u
M555 sg13cmos5l_Corner_1.iovdd a_86044_42476# data[1] sg13cmos5l_Corner_1.iovdd sg13_hv_pmos ad=2.1312p pd=7.3u as=3.9294p ps=7.84u w=6.66u l=0.6u
M556 sg13cmos5l_Corner_1.vss sg13cmos5l_IOPadVdd$1_0.sg13cmos5l_Clamp_N43N43D4R$1_0.gate vdd sg13cmos5l_Corner_1.vss sg13_hv_nmos ad=1.408p pd=5.04u as=2.596p ps=5.58u w=4.4u l=0.6u
M557 adc8b_0.side_cap8b_0.buf_32_0.z adc8b_0.side_cap8b_0.in_l_sw[0] vddr vddr sg13_lv_pmos ad=0.19p pd=1.38u as=0.19p ps=1.38u w=1u l=0.13u
M558 a_98903_95887# a_98061_95789# a_97644_96128# vdd sg13_lv_pmos ad=0.2048p pd=1.63u as=0.34p ps=2.68u w=1u l=0.13u
M559 a_98036_94262# adc8b_0.sar12b_0.sg13cmos5l_buf_1_2.X sg13cmos5l_Corner_1.vss sg13cmos5l_Corner_1.vss sg13_lv_nmos ad=0.187p pd=1.78u as=0.14875p ps=1.16u w=0.55u l=0.13u
M560 adc8b_0.sar12b_0.sg13cmos5l_buf_1_45.A a_90609_96929# sg13cmos5l_Corner_1.vss sg13cmos5l_Corner_1.vss sg13_lv_nmos ad=0.2516p pd=2.16u as=0.1406p ps=1.12u w=0.74u l=0.13u
M561 sg13cmos5l_Corner_1.vss adc8b_0.sar12b_0.nl_sw[0] adc8b_0.side_cap8b_1.buf_32_0.z sg13cmos5l_Corner_1.vss sg13_lv_nmos ad=95f pd=0.88u as=95f ps=0.88u w=0.5u l=0.13u
M562 sg13cmos5l_IOPadVdd$1_0.sg13cmos5l_Clamp_N43N43D4R$1_0.gate sg13cmos5l_IOPadVdd$1_0.sg13cmos5l_RCClampInverter$1_0.in vdd vdd sg13_hv_pmos ad=1.33p pd=7.38u as=1.33p ps=7.38u w=7u l=0.5u
M563 vddr adc8b_0.side_cap8b_0.in_l_sw[0] adc8b_0.side_cap8b_0.buf_32_0.z vddr sg13_lv_pmos ad=0.19p pd=1.38u as=0.19p ps=1.38u w=1u l=0.13u
M564 a_88823_95421# a_87981_95071# a_88729_95421# sg13cmos5l_Corner_1.vss sg13_lv_nmos ad=0.12665p pd=1.145u as=0.1428p ps=1.52u w=0.42u l=0.13u
M565 sg13cmos5l_Corner_1.vss adc8b_0.sar12b_0.sg13cmos5l_dfrbp_1_8.RESET_B a_90348_100034# sg13cmos5l_Corner_1.vss sg13_lv_nmos ad=0.1626p pd=1.415u as=60.89999f ps=0.71u w=0.42u l=0.13u
M566 sg13cmos5l_Corner_1.vss a_118044_30676# cko sg13cmos5l_Corner_1.vss sg13_hv_nmos ad=1.408p pd=5.04u as=2.596p ps=5.58u w=4.4u l=0.6u
M567 sg13cmos5l_Corner_1.vss sg13cmos5l_IOPadVdd$1_0.sg13cmos5l_Clamp_N43N43D4R$1_0.gate vdd sg13cmos5l_Corner_1.vss sg13_hv_nmos ad=1.408p pd=5.04u as=2.596p ps=5.58u w=4.4u l=0.6u
M568 sg13cmos5l_Corner_1.iovdd a_42476_102044# vip sg13cmos5l_Corner_1.iovdd sg13_hv_pmos ad=2.1312p pd=7.3u as=3.9294p ps=7.84u w=6.66u l=0.6u
M569 sg13cmos5l_Corner_1.vss a_89631_98442# a_89762_98448# sg13cmos5l_Corner_1.vss sg13_lv_nmos ad=1.49685p pd=9.6u as=0.2775p ps=2.23u w=0.74u l=0.13u
M570 sg13cmos5l_IOPadAnalog_15.pad a_99639_178370# sg13cmos5l_Corner_1.vss sg13cmos5l_Corner_1.vss sg13_hv_nmos ad=2.596p pd=5.58u as=1.408p ps=5.04u w=4.4u l=0.6u
M571 sg13cmos5l_IOPadAnalog_10.pad a_67639_164698# sg13cmos5l_Corner_1.iovdd sg13cmos5l_Corner_1.iovdd sg13_hv_pmos ad=3.9294p pd=7.84u as=2.1312p ps=7.3u w=6.66u l=0.6u
M572 sg13cmos5l_Corner_1.iovdd a_70044_42476# data[0] sg13cmos5l_Corner_1.iovdd sg13_hv_pmos ad=2.1312p pd=7.3u as=3.9294p ps=7.84u w=6.66u l=0.6u
M573 sg13cmos5l_IOPadAnalog_13.pad a_115639_178370# sg13cmos5l_Corner_1.vss sg13cmos5l_Corner_1.vss sg13_hv_nmos ad=2.596p pd=5.58u as=1.408p ps=5.04u w=4.4u l=0.6u
M574 sg13cmos5l_Corner_1.vss adc8b_0.side_cap8b_0.in_l_sw[1] adc8b_0.side_cap8b_0.buf_16_2.z sg13cmos5l_Corner_1.vss sg13_lv_nmos ad=95f pd=0.88u as=95f ps=0.88u w=0.5u l=0.13u
M575 adc8b_0.sar12b_0.sg13cmos5l_buf_1_87.A a_100144_100384# vdd vdd sg13_lv_pmos ad=0.42p pd=2.99u as=0.2114p ps=1.54u w=1.12u l=0.13u
M576 sg13cmos5l_Corner_1.vss adc8b_0.sar12b_0.sg13cmos5l_buf_1_2.A a_97552_92824# sg13cmos5l_Corner_1.vss sg13_lv_nmos ad=0.14875p pd=1.16u as=0.187p ps=1.78u w=0.55u l=0.13u
M577 sg13cmos5l_Corner_1.iovdd a_99639_164698# sg13cmos5l_IOPadAnalog_15.pad sg13cmos5l_Corner_1.iovdd sg13_hv_pmos ad=2.1312p pd=7.3u as=3.9294p ps=7.84u w=6.66u l=0.6u
M578 sg13cmos5l_Corner_1.vss adc8b_0.sar12b_0.sg13cmos5l_inv_1_26.Y a_99664_100384# sg13cmos5l_Corner_1.vss sg13_lv_nmos ad=0.14875p pd=1.16u as=0.187p ps=1.78u w=0.55u l=0.13u
M579 adc8b_0.sar12b_0.sg13cmos5l_dlhr_1_11.Q_N a_95454_98514# vdd vdd sg13_lv_pmos ad=0.3808p pd=2.92u as=0.1974p ps=1.5u w=1.12u l=0.13u
M580 sg13cmos5l_Corner_1.vss a_91988_94262# adc8b_0.sar12b_0.nl_sw[5] sg13cmos5l_Corner_1.vss sg13_lv_nmos ad=0.14875p pd=1.16u as=0.2886p ps=2.26u w=0.74u l=0.13u
M581 sg13cmos5l_Corner_1.vss a_86044_30676# data[1] sg13cmos5l_Corner_1.vss sg13_hv_nmos ad=2.068p pd=9.74u as=2.596p ps=5.58u w=4.4u l=0.6u
M582 sg13cmos5l_Corner_1.iovdd a_115639_164698# sg13cmos5l_IOPadAnalog_13.pad sg13cmos5l_Corner_1.iovdd sg13_hv_pmos ad=2.1312p pd=7.3u as=3.9294p ps=7.84u w=6.66u l=0.6u
M583 sg13cmos5l_Corner_1.vss a_101361_97322# a_101316_97358# sg13cmos5l_Corner_1.vss sg13_lv_nmos ad=0.1428p pd=1.52u as=47.25f ps=0.645u w=0.42u l=0.13u
M584 a_93038_92786# adc8b_0.sar12b_0.sg13cmos5l_dfrbp_1_1.D vdd vdd sg13_lv_pmos ad=79.8f pd=0.8u as=0.1428p ps=1.52u w=0.42u l=0.13u
M585 sg13cmos5l_Corner_1.vss adc8b_0.side_cap8b_0.in_h_sw[0] adc8b_0.side_cap8b_0.buf_32_1.z sg13cmos5l_Corner_1.vss sg13_lv_nmos ad=95f pd=0.88u as=95f ps=0.88u w=0.5u l=0.13u
M586 adc8b_0.side_cap8b_0.buf_16_1.z adc8b_0.side_cap8b_0.in_l_sw[2] sg13cmos5l_Corner_1.vss sg13cmos5l_Corner_1.vss sg13_lv_nmos ad=95f pd=0.88u as=95f ps=0.88u w=0.5u l=0.13u
M587 vdd adc8b_0.sar12b_0.sg13cmos5l_dfrbp_1_8.RESET_B a_96110_100034# vdd sg13_lv_pmos ad=0.36237p pd=2.605u as=79.8f ps=0.8u w=0.42u l=0.13u
M588 a_89084_94620# a_88802_94308# a_89017_94290# sg13cmos5l_Corner_1.vss sg13_lv_nmos ad=0.141p pd=1.17u as=71.99999f ps=0.865u w=0.64u l=0.13u
M589 data[0] a_70044_30676# sg13cmos5l_Corner_1.vss sg13cmos5l_Corner_1.vss sg13_hv_nmos ad=2.596p pd=5.58u as=1.408p ps=5.04u w=4.4u l=0.6u
M590 vdd sg13cmos5l_IOPadVdd$1_0.sg13cmos5l_Clamp_N43N43D4R$1_0.gate sg13cmos5l_Corner_1.vss sg13cmos5l_Corner_1.vss sg13_hv_nmos ad=2.596p pd=5.58u as=1.408p ps=5.04u w=4.4u l=0.6u
M591 a_88557_95789# adc8b_0.sar12b_0.sg13cmos5l_inv_1_8.A vdd vdd sg13_lv_pmos ad=0.4088p pd=2.97u as=1.2517p ps=7.955u w=1.12u l=0.13u
M592 vddr adc8b_0.side_cap8b_0.in_h_sw[0] adc8b_0.side_cap8b_0.buf_32_1.z vddr sg13_lv_pmos ad=0.19p pd=1.38u as=0.19p ps=1.38u w=1u l=0.13u
M593 vddr adc8b_0.side_cap8b_0.in_h_sw[3] adc8b_0.side_cap8b_0.buf_8_3.z vddr sg13_lv_pmos ad=0.19p pd=1.38u as=0.34p ps=2.68u w=1u l=0.13u
M594 a_92185_98486# a_91633_98442# sg13cmos5l_Corner_1.vss sg13cmos5l_Corner_1.vss sg13_lv_nmos ad=71.99999f pd=0.865u as=1.49685p ps=9.6u w=0.64u l=0.13u
M595 sg13cmos5l_Corner_1.vss adc8b_0.sar12b_0.sg13cmos5l_dfrbp_1_23.Q a_95857_98442# sg13cmos5l_Corner_1.vss sg13_lv_nmos ad=0.15055p pd=1.17u as=0.187p ps=1.78u w=0.55u l=0.13u
M596 adc8b_0.sar12b_0.sg13cmos5l_dlhr_1_9.D a_84572_96572# sg13cmos5l_Corner_1.vss sg13cmos5l_Corner_1.vss sg13_lv_nmos ad=0.2516p pd=2.16u as=0.1406p ps=1.12u w=0.74u l=0.13u
M597 sg13cmos5l_Corner_1.vss adc8b_0.sar12b_0.nh_sw[0] adc8b_0.side_cap8b_1.buf_32_1.z sg13cmos5l_Corner_1.vss sg13_lv_nmos ad=95f pd=0.88u as=95f ps=0.88u w=0.5u l=0.13u
M598 frame a_134044_42476# sg13cmos5l_Corner_1.iovdd sg13cmos5l_Corner_1.iovdd sg13_hv_pmos ad=3.9294p pd=7.84u as=2.1312p ps=7.3u w=6.66u l=0.6u
M599 sg13cmos5l_Corner_1.vss adc8b_0.side_cap8b_0.in_l_sw[3] adc8b_0.side_cap8b_0.buf_8_1.z sg13cmos5l_Corner_1.vss sg13_lv_nmos ad=95f pd=0.88u as=95f ps=0.88u w=0.5u l=0.13u
M600 vdd adc8b_0.sar12b_0.sg13cmos5l_buf_1_8.A a_92656_92824# vdd sg13_lv_pmos ad=0.2114p pd=1.54u as=0.2856p ps=2.36u w=0.84u l=0.13u
M601 adc8b_0.sar12b_0.sg13cmos5l_dlhr_1_17.Q_N a_91134_97002# vdd vdd sg13_lv_pmos ad=0.3808p pd=2.92u as=0.1974p ps=1.5u w=1.12u l=0.13u
M602 a_94766_94298# adc8b_0.sar12b_0.sg13cmos5l_o21ai_1_0.Y vdd vdd sg13_lv_pmos ad=79.8f pd=0.8u as=0.1428p ps=1.52u w=0.42u l=0.13u
M603 sg13cmos5l_Corner_1.vss a_67639_178370# sg13cmos5l_IOPadAnalog_10.pad sg13cmos5l_Corner_1.vss sg13_hv_nmos ad=1.408p pd=5.04u as=2.596p ps=5.58u w=4.4u l=0.6u
M604 vdd a_100113_98834# a_100046_99272# vdd sg13_lv_pmos ad=0.2387p pd=1.84u as=0.1008p ps=0.9u w=0.42u l=0.13u
M605 sg13cmos5l_Corner_1.vss adc8b_0.side_cap8b_0.in_l_sw[9] adc8b_0.side_cap8b_0.buf_2_2.z sg13cmos5l_Corner_1.vss sg13_lv_nmos ad=95f pd=0.88u as=0.17p ps=1.68u w=0.5u l=0.13u
M606 sg13cmos5l_Corner_1.vss sg13cmos5l_IOPadVdd$1_0.sg13cmos5l_Clamp_N43N43D4R$1_0.gate vdd sg13cmos5l_Corner_1.vss sg13_hv_nmos ad=1.408p pd=5.04u as=2.596p ps=5.58u w=4.4u l=0.6u
M607 vdd a_95409_98834# a_95342_99272# vdd sg13_lv_pmos ad=0.2387p pd=1.84u as=0.1008p ps=0.9u w=0.42u l=0.13u
M608 a_87676_94284# a_87260_94620# a_87441_94298# sg13cmos5l_Corner_1.vss sg13_lv_nmos ad=77.7f pd=0.95u as=0.2516p ps=2.16u w=0.74u l=0.13u
M609 adc8b_0.sar12b_0.sg13cmos5l_nor2_1_0.A a_95324_93548# sg13cmos5l_Corner_1.vss sg13cmos5l_Corner_1.vss sg13_lv_nmos ad=0.2516p pd=2.16u as=0.1406p ps=1.12u w=0.74u l=0.13u
M610 a_86796_93986# adc8b_0.sar12b_0.sg13cmos5l_dfrbp_1_6.D a_86702_93986# sg13cmos5l_Corner_1.vss sg13_lv_nmos ad=60.89999f pd=0.71u as=0.1428p ps=1.52u w=0.42u l=0.13u
M611 a_93324_95064# a_93843_95071# a_94583_95421# sg13cmos5l_Corner_1.vss sg13_lv_nmos ad=0.3473p pd=2.71u as=0.12665p ps=1.145u w=0.74u l=0.13u
M612 a_89025_95183# a_88083_95071# a_88823_95421# vdd sg13_lv_pmos ad=93.45f pd=0.865u as=0.2048p ps=1.63u w=0.42u l=0.13u
M613 sg13cmos5l_Corner_1.vss a_85215_93906# a_85346_93912# sg13cmos5l_Corner_1.vss sg13_lv_nmos ad=2.59257p pd=16.445u as=0.2775p ps=2.23u w=0.74u l=0.13u
M614 vdd sg13cmos5l_IOPadVdd$1_0.sg13cmos5l_RCClampInverter$1_0.in sg13cmos5l_IOPadVdd$1_0.sg13cmos5l_Clamp_N43N43D4R$1_0.gate vdd sg13_hv_pmos ad=1.33p pd=7.38u as=1.33p ps=7.38u w=7u l=0.5u
X615 sg13cmos5l_Corner_1.iovdd a_42476_70044# sg13cmos5l_Corner_1.iovdd rppd l=12.9u w=0.5u
M616 adc8b_0.side_cap8b_0.buf_8_1.z adc8b_0.side_cap8b_0.in_l_sw[3] vddr vddr sg13_lv_pmos ad=0.34p pd=2.68u as=0.19p ps=1.38u w=1u l=0.13u
M617 sg13cmos5l_Corner_1.vss a_99352_98326# a_99001_98445# sg13cmos5l_Corner_1.vss sg13_lv_nmos ad=79.8f pd=0.8u as=0.1428p ps=1.52u w=0.42u l=0.13u
M618 adc8b_0.sar12b_0.sg13cmos5l_dlhr_1_2.Q a_89265_94298# sg13cmos5l_Corner_1.vss sg13cmos5l_Corner_1.vss sg13_lv_nmos ad=0.2516p pd=2.16u as=0.1406p ps=1.12u w=0.74u l=0.13u
M619 sg13cmos5l_Corner_1.vss a_87885_97301# a_87987_97444# sg13cmos5l_Corner_1.vss sg13_lv_nmos ad=1.97045p pd=12.335u as=0.2516p ps=2.16u w=0.74u l=0.13u
M620 cks a_42476_118044# sg13cmos5l_Corner_1.iovdd sg13cmos5l_Corner_1.iovdd sg13_hv_pmos ad=3.9294p pd=7.84u as=2.1312p ps=7.3u w=6.66u l=0.6u
M621 vdd adc8b_0.sar12b_0.sg13cmos5l_dfrbp_1_6.RESET_B a_94258_97545# vdd sg13_lv_pmos ad=0.1563p pd=1.22u as=0.147p ps=1.54u w=0.42u l=0.13u
M622 sg13cmos5l_IOPadAnalog_10.pad a_67639_178370# sg13cmos5l_Corner_1.vss sg13cmos5l_Corner_1.vss sg13_hv_nmos ad=2.596p pd=5.58u as=1.408p ps=5.04u w=4.4u l=0.6u
M623 a_87564_100034# adc8b_0.sar12b_0.sg13cmos5l_dlhr_1_5.GATE a_87470_100034# sg13cmos5l_Corner_1.vss sg13_lv_nmos ad=60.89999f pd=0.71u as=0.1428p ps=1.52u w=0.42u l=0.13u
M624 vdd adc8b_0.sar12b_0.sg13cmos5l_dfrbp_1_23.Q a_95857_98442# vdd sg13_lv_pmos ad=1.07253p pd=6.75u as=0.2856p ps=2.36u w=0.84u l=0.13u
M625 sg13cmos5l_Corner_1.iovdd a_118044_42476# cko sg13cmos5l_Corner_1.iovdd sg13_hv_pmos ad=2.1312p pd=7.3u as=3.9294p ps=7.84u w=6.66u l=0.6u
M626 vdd adc8b_0.sar12b_0.sg13cmos5l_buf_1_29.A adc8b_0.sar12b_0.sg13cmos5l_buf_1_77.A vdd sg13_lv_pmos ad=0.3808p pd=2.92u as=0.3808p ps=2.92u w=1.12u l=0.13u
M627 vdd a_85599_98442# a_85730_98448# vdd sg13_lv_pmos ad=1.07253p pd=6.75u as=0.2856p ps=2.36u w=0.84u l=0.13u
M628 sg13cmos5l_Corner_1.vss a_99639_178370# sg13cmos5l_IOPadAnalog_15.pad sg13cmos5l_Corner_1.vss sg13_hv_nmos ad=1.408p pd=5.04u as=2.596p ps=5.58u w=4.4u l=0.6u
M629 sg13cmos5l_Corner_1.iovdd a_67639_164698# sg13cmos5l_IOPadAnalog_10.pad sg13cmos5l_Corner_1.iovdd sg13_hv_pmos ad=2.1312p pd=7.3u as=3.9294p ps=7.84u w=6.66u l=0.6u
M630 vdd sg13cmos5l_IOPadVdd$1_0.sg13cmos5l_Clamp_N43N43D4R$1_0.gate sg13cmos5l_Corner_1.vss sg13cmos5l_Corner_1.vss sg13_hv_nmos ad=2.596p pd=5.58u as=1.408p ps=5.04u w=4.4u l=0.6u
M631 a_87730_99564# a_88173_99607# a_87470_100034# sg13cmos5l_Corner_1.vss sg13_lv_nmos ad=79.8f pd=0.8u as=0.1296p ps=1.52u w=0.42u l=0.13u
M632 sg13cmos5l_Corner_1.vss a_92433_98441# a_92388_98486# sg13cmos5l_Corner_1.vss sg13_lv_nmos ad=0.1428p pd=1.52u as=47.25f ps=0.645u w=0.42u l=0.13u
M633 sg13cmos5l_Corner_1.vss a_115639_178370# sg13cmos5l_IOPadAnalog_13.pad sg13cmos5l_Corner_1.vss sg13_hv_nmos ad=1.408p pd=5.04u as=2.596p ps=5.58u w=4.4u l=0.6u
M634 sg13cmos5l_Corner_1.vss sg13cmos5l_IOPadVdd$1_0.sg13cmos5l_Clamp_N43N43D4R$1_0.gate vdd sg13cmos5l_Corner_1.vss sg13_hv_nmos ad=1.408p pd=5.04u as=2.596p ps=5.58u w=4.4u l=0.6u
M635 adc8b_0.side_cap8b_0.buf_8_2.z adc8b_0.side_cap8b_0.in_h_sw[4] vddr vddr sg13_lv_pmos ad=0.19p pd=1.38u as=0.19p ps=1.38u w=1u l=0.13u
M636 adc8b_0.side_cap8b_1.buf_32_0.z adc8b_0.sar12b_0.nl_sw[0] vddr vddr sg13_lv_pmos ad=0.19p pd=1.38u as=0.19p ps=1.38u w=1u l=0.13u
M637 sg13cmos5l_Corner_1.vss adc8b_0.sar12b_0.sg13cmos5l_buf_1_73.X a_87568_100384# sg13cmos5l_Corner_1.vss sg13_lv_nmos ad=0.14875p pd=1.16u as=0.187p ps=1.78u w=0.55u l=0.13u
M638 a_83646_97497# a_83765_97286# sg13cmos5l_Corner_1.vss sg13cmos5l_Corner_1.vss sg13_lv_nmos ad=0.2516p pd=2.16u as=0.1406p ps=1.12u w=0.74u l=0.13u
M639 sg13cmos5l_IOPadAnalog_0.pad a_164624_86044# sg13cmos5l_Corner_1.iovdd sg13cmos5l_Corner_1.iovdd sg13_hv_pmos ad=3.9294p pd=7.84u as=2.1312p ps=7.3u w=6.66u l=0.6u
M640 a_97234_93516# a_97677_93559# a_96974_93986# sg13cmos5l_Corner_1.vss sg13_lv_nmos ad=79.8f pd=0.8u as=0.1296p ps=1.52u w=0.42u l=0.13u
X641 a_36456_135415# a_40542_135085# sg13cmos5l_Corner_1.vss rppd l=20u w=1u
M642 vddr adc8b_0.sar12b_0.nl_sw[0] adc8b_0.side_cap8b_1.buf_32_0.z vddr sg13_lv_pmos ad=0.19p pd=1.38u as=0.19p ps=1.38u w=1u l=0.13u
M643 a_98193_98131# a_97836_98088# vdd vdd sg13_lv_pmos ad=63f pd=0.72u as=0.1563p ps=1.22u w=0.42u l=0.13u
M644 data[0] a_70044_42476# sg13cmos5l_Corner_1.iovdd sg13cmos5l_Corner_1.iovdd sg13_hv_pmos ad=3.9294p pd=7.84u as=2.1312p ps=7.3u w=6.66u l=0.6u
M645 adc8b_0.sar12b_0.sg13cmos5l_dlhr_1_10.Q_N a_101886_97304# vdd vdd sg13_lv_pmos ad=0.3808p pd=2.92u as=0.1974p ps=1.5u w=1.12u l=0.13u
M646 vdd adc8b_0.sar12b_0.sg13cmos5l_inv_1_6.A adc8b_0.sar12b_0.sg13cmos5l_buf_1_0.A vdd sg13_lv_pmos ad=0.3808p pd=2.92u as=0.3808p ps=2.92u w=1.12u l=0.13u
M647 sg13cmos5l_IOPadAnalog_1.pad a_178296_70044# sg13cmos5l_Corner_1.vss sg13cmos5l_Corner_1.vss sg13_hv_nmos ad=2.596p pd=5.58u as=1.408p ps=5.04u w=4.4u l=0.6u
M648 vdd sg13cmos5l_IOPadVdd$1_0.sg13cmos5l_RCClampInverter$1_0.in sg13cmos5l_IOPadVdd$1_0.sg13cmos5l_Clamp_N43N43D4R$1_0.gate vdd sg13_hv_pmos ad=1.33p pd=7.38u as=1.33p ps=7.38u w=7u l=0.5u
M649 adc8b_0.sar12b_0.sg13cmos5l_buf_1_89.A a_96657_98441# vdd vdd sg13_lv_pmos ad=0.3808p pd=2.92u as=0.2128p ps=1.5u w=1.12u l=0.13u
M650 vdd a_97677_93559# a_97779_93559# vdd sg13_lv_pmos ad=1.86162p pd=11.935u as=0.3864p ps=2.93u w=1.12u l=0.13u
M651 a_89016_94620# a_88465_94352# vdd vdd sg13_lv_pmos ad=0.105p pd=1.21u as=1.43437p ps=9.105u w=1u l=0.13u
M652 sg13cmos5l_Corner_1.vss a_118044_30676# cko sg13cmos5l_Corner_1.vss sg13_hv_nmos ad=1.408p pd=5.04u as=2.596p ps=5.58u w=4.4u l=0.6u
M653 vip a_42476_102044# sg13cmos5l_Corner_1.iovdd sg13cmos5l_Corner_1.iovdd sg13_hv_pmos ad=3.9294p pd=7.84u as=2.1312p ps=7.3u w=6.66u l=0.6u
M654 sg13cmos5l_Corner_1.vss a_82964_99560# adc8b_0.sar12b_0.sg13cmos5l_buf_1_63.X sg13cmos5l_Corner_1.vss sg13_lv_nmos ad=0.14875p pd=1.16u as=0.2886p ps=2.26u w=0.74u l=0.13u
X655 sg13cmos5l_IOPadAnalog_2.padres frame sg13cmos5l_Corner_1.vss rppd l=2u w=1u
M656 a_88173_99607# adc8b_0.sar12b_0.sg13cmos5l_inv_1_8.A vdd vdd sg13_lv_pmos ad=0.4088p pd=2.97u as=1.12242p ps=7u w=1.12u l=0.13u
M657 adc8b_0.side_cap8b_1.buf_16_1.z adc8b_0.sar12b_0.nl_sw[2] sg13cmos5l_Corner_1.vss sg13cmos5l_Corner_1.vss sg13_lv_nmos ad=95f pd=0.88u as=95f ps=0.88u w=0.5u l=0.13u
M658 vdd sg13cmos5l_IOPadVdd$1_0.sg13cmos5l_Clamp_N43N43D4R$1_0.gate sg13cmos5l_Corner_1.vss sg13cmos5l_Corner_1.vss sg13_hv_nmos ad=2.596p pd=5.58u as=1.408p ps=5.04u w=4.4u l=0.6u
M659 sg13cmos5l_IOPadAnalog_11.pad a_164624_118044# sg13cmos5l_Corner_1.iovdd sg13cmos5l_Corner_1.iovdd sg13_hv_pmos ad=3.9294p pd=7.84u as=2.1312p ps=7.3u w=6.66u l=0.6u
M660 sg13cmos5l_IOPadAnalog_13.pad a_115639_164698# sg13cmos5l_Corner_1.iovdd sg13cmos5l_Corner_1.iovdd sg13_hv_pmos ad=3.9294p pd=7.84u as=2.1312p ps=7.3u w=6.66u l=0.6u
M661 vdd a_92493_98813# a_92595_98956# vdd sg13_lv_pmos ad=1.15047p pd=7.175u as=0.3864p ps=2.93u w=1.12u l=0.13u
M662 sg13cmos5l_IOPadAnalog_12.pad a_131639_164698# sg13cmos5l_Corner_1.iovdd sg13cmos5l_Corner_1.iovdd sg13_hv_pmos ad=3.9294p pd=7.84u as=2.1312p ps=7.3u w=6.66u l=0.6u
M663 sg13cmos5l_Corner_1.vss a_30676_102044# vip sg13cmos5l_Corner_1.vss sg13_hv_nmos ad=1.408p pd=5.04u as=2.596p ps=5.58u w=4.4u l=0.6u
M664 adc8b_0.side_cap8b_0.buf_16_2.z adc8b_0.side_cap8b_0.in_l_sw[1] sg13cmos5l_Corner_1.vss sg13cmos5l_Corner_1.vss sg13_lv_nmos ad=95f pd=0.88u as=95f ps=0.88u w=0.5u l=0.13u
M665 a_89272_99838# a_89015_99957# a_89434_100034# sg13cmos5l_Corner_1.vss sg13_lv_nmos ad=0.1428p pd=1.52u as=37.8f ps=0.6u w=0.42u l=0.13u
M666 adc8b_0.side_cap8b_1.buf_32_1.z adc8b_0.sar12b_0.nh_sw[0] sg13cmos5l_Corner_1.vss sg13cmos5l_Corner_1.vss sg13_lv_nmos ad=95f pd=0.88u as=95f ps=0.88u w=0.5u l=0.13u
M667 a_87396_94334# a_86847_94314# a_87260_94620# sg13cmos5l_Corner_1.vss sg13_lv_nmos ad=47.25f pd=0.645u as=0.141p ps=1.17u w=0.42u l=0.13u
M668 vdd a_98445_97301# a_98547_97444# vdd sg13_lv_pmos ad=1.07253p pd=6.75u as=0.3864p ps=2.93u w=1.12u l=0.13u
M669 a_83630_95498# a_84435_95071# a_83890_95028# vdd sg13_lv_pmos ad=0.1428p pd=1.52u as=79.8f ps=0.8u w=0.42u l=0.13u
M670 sg13cmos5l_Corner_1.vss a_86044_30676# data[1] sg13cmos5l_Corner_1.vss sg13_hv_nmos ad=1.408p pd=5.04u as=2.596p ps=5.58u w=4.4u l=0.6u
M671 sg13cmos5l_IOPadAnalog_11.pad a_178296_118044# sg13cmos5l_Corner_1.vss sg13cmos5l_Corner_1.vss sg13_hv_nmos ad=2.596p pd=5.58u as=1.408p ps=5.04u w=4.4u l=0.6u
M672 vddr a_30676_70044# sg13cmos5l_Corner_1.vss sg13cmos5l_Corner_1.vss sg13_hv_nmos ad=2.596p pd=5.58u as=1.408p ps=5.04u w=4.4u l=0.6u
M673 adc8b_0.side_cap8b_0.buf_32_1.z adc8b_0.side_cap8b_0.in_h_sw[0] sg13cmos5l_Corner_1.vss sg13cmos5l_Corner_1.vss sg13_lv_nmos ad=0.17p pd=1.68u as=95f ps=0.88u w=0.5u l=0.13u
M674 sg13cmos5l_Corner_1.vss adc8b_0.sar12b_0.sg13cmos5l_buf_1_74.X a_88336_100384# sg13cmos5l_Corner_1.vss sg13_lv_nmos ad=0.14875p pd=1.16u as=0.187p ps=1.78u w=0.55u l=0.13u
M675 a_94258_97545# a_94701_97301# a_93998_97322# sg13cmos5l_Corner_1.vss sg13_lv_nmos ad=79.8f pd=0.8u as=0.1296p ps=1.52u w=0.42u l=0.13u
M676 vddr adc8b_0.side_cap8b_0.in_l_sw[2] adc8b_0.side_cap8b_0.buf_16_1.z vddr sg13_lv_pmos ad=0.19p pd=1.38u as=0.19p ps=1.38u w=1u l=0.13u
M677 adc8b_0.sar12b_0.nh_sw[2] a_85456_92824# vdd vdd sg13_lv_pmos ad=0.42p pd=2.99u as=0.2114p ps=1.54u w=1.12u l=0.13u
X678 sg13cmos5l_Corner_1.vss a_86222_32962# dantenna l=1.26u w=27.78u
M679 a_98519_93909# a_97677_93559# a_97260_93552# vdd sg13_lv_pmos ad=0.2048p pd=1.63u as=0.34p ps=2.68u w=1u l=0.13u
X680 vip sg13cmos5l_Corner_1.iovdd dpantenna l=27.78u w=1.26u
M681 a_96588_98834# adc8b_0.sar12b_0.sg13cmos5l_buf_1_57.X a_96494_98834# sg13cmos5l_Corner_1.vss sg13_lv_nmos ad=60.89999f pd=0.71u as=0.1428p ps=1.52u w=0.42u l=0.13u
M682 vdd adc8b_0.sar12b_0.sg13cmos5l_dfrbp_1_6.RESET_B a_92433_98441# vdd sg13_lv_pmos ad=0.2128p pd=1.5u as=0.2128p ps=1.5u w=1.12u l=0.13u
M683 sg13cmos5l_Corner_1.vss a_100131_95430# adc8b_0.sar12b_0.sg13cmos5l_or2_1_0.A sg13cmos5l_Corner_1.vss sg13_lv_nmos ad=0.2516p pd=2.16u as=0.1406p ps=1.12u w=0.74u l=0.13u
M684 sg13cmos5l_Corner_1.vss a_67639_178370# sg13cmos5l_IOPadAnalog_10.pad sg13cmos5l_Corner_1.vss sg13_hv_nmos ad=1.408p pd=5.04u as=2.596p ps=5.58u w=4.4u l=0.6u
M685 vddr a_42476_70044# sg13cmos5l_Corner_1.iovdd sg13cmos5l_Corner_1.iovdd sg13_hv_pmos ad=3.9294p pd=7.84u as=2.1312p ps=7.3u w=6.66u l=0.6u
M686 sg13cmos5l_Corner_1.iovdd a_42476_70044# vddr sg13cmos5l_Corner_1.iovdd sg13_hv_pmos ad=2.1312p pd=7.3u as=3.9294p ps=7.84u w=6.66u l=0.6u
M687 a_91225_95802# a_90673_95864# sg13cmos5l_Corner_1.vss sg13cmos5l_Corner_1.vss sg13_lv_nmos ad=71.99999f pd=0.865u as=2.41737p ps=15.64u w=0.64u l=0.13u
M688 adc8b_0.sar12b_0.sg13cmos5l_dfrbp_1_9.Q_N a_85175_95421# vdd vdd sg13_lv_pmos ad=0.4312p pd=3.01u as=0.2639p ps=1.81u w=1.12u l=0.13u
M689 sg13cmos5l_IOPadAnalog_16.pad a_164624_102044# sg13cmos5l_Corner_1.iovdd sg13cmos5l_Corner_1.iovdd sg13_hv_pmos ad=3.9294p pd=7.84u as=2.1312p ps=7.3u w=6.66u l=0.6u
M690 adc8b_0.side_cap8b_1.buf_32_1.z adc8b_0.sar12b_0.nh_sw[0] sg13cmos5l_Corner_1.vss sg13cmos5l_Corner_1.vss sg13_lv_nmos ad=95f pd=0.88u as=95f ps=0.88u w=0.5u l=0.13u
M691 vdd sg13cmos5l_IOPadVdd$1_0.sg13cmos5l_Clamp_N43N43D4R$1_0.gate sg13cmos5l_Corner_1.vss sg13cmos5l_Corner_1.vss sg13_hv_nmos ad=2.596p pd=5.58u as=1.408p ps=5.04u w=4.4u l=0.6u
M692 sg13cmos5l_Corner_1.vss vdd sg13cmos5l_Corner_1.vss sg13cmos5l_Corner_1.vss sg13_lv_nmos ad=0.1428p pd=1.52u as=0 ps=0 w=0.42u l=1u
M693 vdd adc8b_0.sar12b_0.sg13cmos5l_buf_1_28.A a_91216_92824# vdd sg13_lv_pmos ad=0.2114p pd=1.54u as=0.2856p ps=2.36u w=0.84u l=0.13u
M694 adc8b_0.sar12b_0.sg13cmos5l_nor2_1_2.A adc8b_0.sar12b_0.sg13cmos5l_inv_1_9.Y sg13cmos5l_Corner_1.vss sg13cmos5l_Corner_1.vss sg13_lv_nmos ad=0.2516p pd=2.16u as=0.2516p ps=2.16u w=0.74u l=0.13u
M695 data[1] a_86044_30676# sg13cmos5l_Corner_1.vss sg13cmos5l_Corner_1.vss sg13_hv_nmos ad=2.596p pd=5.58u as=1.408p ps=5.04u w=4.4u l=0.6u
M696 sg13cmos5l_Corner_1.iovdd a_42476_118044# cks sg13cmos5l_Corner_1.iovdd sg13_hv_pmos ad=2.1312p pd=7.3u as=3.9294p ps=7.84u w=6.66u l=0.6u
M697 a_91839_98442# adc8b_0.sar12b_0.sg13cmos5l_dfrbp_1_18.Q sg13cmos5l_Corner_1.vss sg13cmos5l_Corner_1.vss sg13_lv_nmos ad=0.2516p pd=2.16u as=0.15055p ps=1.17u w=0.74u l=0.13u
M698 sg13cmos5l_Corner_1.iovdd a_118044_42476# cko sg13cmos5l_Corner_1.iovdd sg13_hv_pmos ad=2.1312p pd=7.3u as=3.9294p ps=7.84u w=6.66u l=0.6u
M699 sg13cmos5l_Corner_1.vss a_178296_86044# sg13cmos5l_IOPadAnalog_0.pad sg13cmos5l_Corner_1.vss sg13_hv_nmos ad=1.408p pd=5.04u as=2.596p ps=5.58u w=4.4u l=0.6u
M700 vdd adc8b_0.sar12b_0.sg13cmos5l_dfrbp_1_0.RESET_B a_93202_93516# vdd sg13_lv_pmos ad=0.1563p pd=1.22u as=0.147p ps=1.54u w=0.42u l=0.13u
M701 vdd a_86193_98441# a_86126_98084# vdd sg13_lv_pmos ad=0.2387p pd=1.84u as=0.1008p ps=0.9u w=0.42u l=0.13u
M702 data[2] a_102044_42476# sg13cmos5l_Corner_1.iovdd sg13cmos5l_Corner_1.iovdd sg13_hv_pmos ad=3.9294p pd=7.84u as=2.1312p ps=7.3u w=6.66u l=0.6u
X703 cko sg13cmos5l_Corner_1.iovdd dpantenna l=1.26u w=27.78u
M704 sg13cmos5l_Corner_1.vss adc8b_0.sar12b_0.sg13cmos5l_dfrbp_1_10.Q_N a_85009_93906# sg13cmos5l_Corner_1.vss sg13_lv_nmos ad=0.15055p pd=1.17u as=0.187p ps=1.78u w=0.55u l=0.13u
M705 sg13cmos5l_Corner_1.vss adc8b_0.side_cap8b_0.in_h_sw[5] adc8b_0.side_cap8b_0.buf_8_5.z sg13cmos5l_Corner_1.vss sg13_lv_nmos ad=95f pd=0.88u as=95f ps=0.88u w=0.5u l=0.13u
M706 a_84554_98826# a_84364_99156# a_84116_98784# sg13cmos5l_Corner_1.vss sg13_lv_nmos ad=71.99999f pd=0.865u as=0.141p ps=1.17u w=0.64u l=0.13u
M707 sg13cmos5l_Corner_1.vss a_84599_98790# a_84554_98826# sg13cmos5l_Corner_1.vss sg13_lv_nmos ad=1.49685p pd=9.6u as=71.99999f ps=0.865u w=0.64u l=0.13u
M708 a_83765_97286# a_84495_97540# a_84406_97637# vdd sg13_lv_pmos ad=0.2048p pd=1.63u as=93.45f ps=0.865u w=0.42u l=0.13u
X709 sg13cmos5l_IOPadAnalog_6.padres data[0] sg13cmos5l_Corner_1.vss rppd l=2u w=1u
M710 sg13cmos5l_IOPadAnalog_16.pad a_178296_102044# sg13cmos5l_Corner_1.vss sg13cmos5l_Corner_1.vss sg13_hv_nmos ad=2.596p pd=5.58u as=1.408p ps=5.04u w=4.4u l=0.6u
M711 a_79552_97015# adc8b_0.cmp_0.sg13cmos5l_inv_1$1_1.Y sg13cmos5l_Corner_1.vss sg13cmos5l_Corner_1.vss sg13_lv_nmos ad=0.1045p pd=0.93u as=0.187p ps=1.78u w=0.55u l=0.13u
M712 a_93641_96920# adc8b_0.sar12b_0.sg13cmos5l_inv_1_29.Y adc8b_0.sar12b_0.sg13cmos5l_a221oi_1_0.B2 sg13cmos5l_Corner_1.vss sg13_lv_nmos ad=0.1406p pd=1.12u as=0.1406p ps=1.12u w=0.74u l=0.13u
M713 a_93741_92765# adc8b_0.sar12b_0.sg13cmos5l_dfrbp_1_0.CLK vdd vdd sg13_lv_pmos ad=0.4088p pd=2.97u as=1.777p ps=11.395u w=1.12u l=0.13u
M714 vddr adc8b_0.side_cap8b_0.in_l_sw[0] adc8b_0.side_cap8b_0.buf_32_0.z vddr sg13_lv_pmos ad=0.19p pd=1.38u as=0.19p ps=1.38u w=1u l=0.13u
M715 sg13cmos5l_Corner_1.vss a_89265_94298# a_89790_94280# sg13cmos5l_Corner_1.vss sg13_lv_nmos ad=0.1491p pd=1.18u as=0.187p ps=1.78u w=0.55u l=0.13u
X716 sg13cmos5l_Corner_1.vss a_102222_175886# dantenna l=1.26u w=27.78u
M717 a_83996_96132# a_83714_95820# a_83929_95802# sg13cmos5l_Corner_1.vss sg13_lv_nmos ad=0.141p pd=1.17u as=71.99999f ps=0.865u w=0.64u l=0.13u
M718 a_88140_96128# a_88659_95932# a_89399_95887# sg13cmos5l_Corner_1.vss sg13_lv_nmos ad=0.3473p pd=2.71u as=0.12665p ps=1.145u w=0.74u l=0.13u
M719 adc8b_0.side_cap8b_1.buf_4_1.z adc8b_0.sar12b_0.nh_sw[6] vddr vddr sg13_lv_pmos ad=0.19p pd=1.38u as=0.19p ps=1.38u w=1u l=0.13u
M720 sg13cmos5l_IOPadAnalog_9.pad a_83639_164698# sg13cmos5l_Corner_1.iovdd sg13cmos5l_Corner_1.iovdd sg13_hv_pmos ad=3.9294p pd=7.84u as=2.1312p ps=7.3u w=6.66u l=0.6u
M721 vdd sg13cmos5l_IOPadVdd$1_0.sg13cmos5l_RCClampInverter$1_0.in sg13cmos5l_IOPadVdd$1_0.sg13cmos5l_Clamp_N43N43D4R$1_0.gate vdd sg13_hv_pmos ad=1.33p pd=7.38u as=1.33p ps=7.38u w=7u l=0.5u
M722 a_83929_95802# a_83377_95864# sg13cmos5l_Corner_1.vss sg13cmos5l_Corner_1.vss sg13_lv_nmos ad=71.99999f pd=0.865u as=2.41737p ps=15.64u w=0.64u l=0.13u
M723 a_101012_93512# adc8b_0.sar12b_0.sg13cmos5l_buf_1_18.X sg13cmos5l_Corner_1.vss sg13cmos5l_Corner_1.vss sg13_lv_nmos ad=0.187p pd=1.78u as=0.14875p ps=1.16u w=0.55u l=0.13u
M724 adc8b_0.sar12b_0.sg13cmos5l_buf_1_97.A a_92241_100346# sg13cmos5l_Corner_1.vss sg13cmos5l_Corner_1.vss sg13_lv_nmos ad=0.2516p pd=2.16u as=0.1406p ps=1.12u w=0.74u l=0.13u
M725 vdd a_98296_99054# a_98241_99149# vdd sg13_lv_pmos ad=1.15047p pd=7.175u as=93.45f ps=0.865u w=0.42u l=0.13u
M726 vdd adc8b_0.sar12b_0.sg13cmos5l_buf_1_77.X a_89104_100384# vdd sg13_lv_pmos ad=0.2114p pd=1.54u as=0.2856p ps=2.36u w=0.84u l=0.13u
M727 vdd a_100995_100350# adc8b_0.sar12b_0.sg13cmos5l_buf_8_2.X vdd sg13_lv_pmos ad=0.2128p pd=1.5u as=0.2128p ps=1.5u w=1.12u l=0.13u
M728 adc8b_0.sar12b_0.sg13cmos5l_dlhr_1_6.D a_89564_97620# vdd vdd sg13_lv_pmos ad=0.3808p pd=2.92u as=0.2128p ps=1.5u w=1.12u l=0.13u
M729 vdd a_68892_96252# a_68824_96348# sg13cmos5l_Corner_1.vss sg13_lv_nmos ad=0.442p pd=3.28u as=0.442p ps=3.28u w=1.3u l=0.13u
M730 vdd a_100977_96929# a_100910_96572# vdd sg13_lv_pmos ad=0.2387p pd=1.84u as=0.1008p ps=0.9u w=0.42u l=0.13u
M731 a_89198_94736# a_88802_94308# a_89084_94620# vdd sg13_lv_pmos ad=0.1008p pd=0.9u as=0.191p ps=1.44u w=0.42u l=0.13u
M732 adc8b_0.sar12b_0.sg13cmos5l_o21ai_1_0.Y adc8b_0.sar12b_0.sg13cmos5l_o21ai_1_0.B1 a_93790_94294# sg13cmos5l_Corner_1.vss sg13_lv_nmos ad=0.2516p pd=2.16u as=0.1406p ps=1.12u w=0.74u l=0.15u
M733 a_100628_100310# adc8b_0.sar12b_0.sg13cmos5l_buf_1_101.X sg13cmos5l_Corner_1.vss sg13cmos5l_Corner_1.vss sg13_lv_nmos ad=0.187p pd=1.78u as=0.14875p ps=1.16u w=0.55u l=0.13u
M734 a_89015_99957# a_88173_99607# a_87756_99600# vdd sg13_lv_pmos ad=0.2048p pd=1.63u as=0.34p ps=2.68u w=1u l=0.13u
M735 vdd a_83252_97286# adc8b_0.sar12b_0.sg13cmos5l_buf_1_40.A vdd sg13_lv_pmos ad=0.2114p pd=1.54u as=0.42p ps=2.99u w=1.12u l=0.13u
M736 sg13cmos5l_Corner_1.vss a_100696_93006# a_100345_92863# sg13cmos5l_Corner_1.vss sg13_lv_nmos ad=79.8f pd=0.8u as=0.1428p ps=1.52u w=0.42u l=0.13u
M737 sg13cmos5l_Corner_1.iovdd a_115639_164698# sg13cmos5l_IOPadAnalog_13.pad sg13cmos5l_Corner_1.iovdd sg13_hv_pmos ad=2.1312p pd=7.3u as=3.9294p ps=7.84u w=6.66u l=0.6u
M738 sg13cmos5l_Corner_1.iovdd a_131639_164698# sg13cmos5l_IOPadAnalog_12.pad sg13cmos5l_Corner_1.iovdd sg13_hv_pmos ad=2.1312p pd=7.3u as=3.9294p ps=7.84u w=6.66u l=0.6u
M739 sg13cmos5l_Corner_1.vss sg13cmos5l_IOPadVdd$1_0.sg13cmos5l_Clamp_N43N43D4R$1_0.gate vdd sg13cmos5l_Corner_1.vss sg13_hv_nmos ad=1.408p pd=5.04u as=2.596p ps=5.58u w=4.4u l=0.6u
M740 sg13cmos5l_Corner_1.vss adc8b_0.side_cap8b_0.in_l_sw[0] adc8b_0.side_cap8b_0.buf_32_0.z sg13cmos5l_Corner_1.vss sg13_lv_nmos ad=95f pd=0.88u as=95f ps=0.88u w=0.5u l=0.13u
M741 vdd a_97655_99957# a_98492_99596# vdd sg13_lv_pmos ad=0.2128p pd=1.5u as=0.3864p ps=2.93u w=1.12u l=0.13u
M742 adc8b_0.sar12b_0.sg13cmos5l_buf_1_8.A adc8b_0.sar12b_0.sg13cmos5l_inv_1_7.A sg13cmos5l_Corner_1.vss sg13cmos5l_Corner_1.vss sg13_lv_nmos ad=0.2516p pd=2.16u as=0.2516p ps=2.16u w=0.74u l=0.13u
M743 sg13cmos5l_Corner_1.vss sg13cmos5l_IOPadVdd$1_0.sg13cmos5l_RCClampInverter$1_0.in sg13cmos5l_IOPadVdd$1_0.sg13cmos5l_Clamp_N43N43D4R$1_0.gate sg13cmos5l_Corner_1.vss sg13_hv_nmos ad=1.71p pd=9.38u as=1.71p ps=9.38u w=9u l=0.5u
M744 a_98002_97545# a_98445_97301# a_97742_97322# sg13cmos5l_Corner_1.vss sg13_lv_nmos ad=79.8f pd=0.8u as=0.1296p ps=1.52u w=0.42u l=0.13u
M745 vdd adc8b_0.sar12b_0.sg13cmos5l_dfrbp_1_8.RESET_B a_87220_97010# vdd sg13_lv_pmos ad=1.2517p pd=7.955u as=79.8f ps=0.8u w=0.42u l=0.13u
M746 vdd adc8b_0.sar12b_0.sg13cmos5l_dfrbp_1_6.RESET_B a_87441_94298# vdd sg13_lv_pmos ad=0.2128p pd=1.5u as=0.2128p ps=1.5u w=1.12u l=0.13u
M747 sg13cmos5l_Corner_1.vss adc8b_0.sar12b_0.nl_sw[0] adc8b_0.side_cap8b_1.buf_32_0.z sg13cmos5l_Corner_1.vss sg13_lv_nmos ad=95f pd=0.88u as=95f ps=0.88u w=0.5u l=0.13u
M748 sg13cmos5l_Corner_1.vss sg13cmos5l_IOPadVdd$1_0.sg13cmos5l_Clamp_N43N43D4R$1_0.gate vdd sg13cmos5l_Corner_1.vss sg13_hv_nmos ad=1.408p pd=5.04u as=2.596p ps=5.58u w=4.4u l=0.6u
M749 vddr adc8b_0.side_cap8b_0.in_l_sw[0] adc8b_0.side_cap8b_0.buf_32_0.z vddr sg13_lv_pmos ad=0.19p pd=1.38u as=0.19p ps=1.38u w=1u l=0.13u
M750 a_90540_99600# a_91059_99607# a_91799_99957# sg13cmos5l_Corner_1.vss sg13_lv_nmos ad=0.3473p pd=2.71u as=0.12665p ps=1.145u w=0.74u l=0.13u
M751 adc8b_0.sar12b_0.nl_sw[3] a_86224_92824# sg13cmos5l_Corner_1.vss sg13cmos5l_Corner_1.vss sg13_lv_nmos ad=0.2886p pd=2.26u as=0.14875p ps=1.16u w=0.74u l=0.13u
M752 adc8b_0.sar12b_0.sg13cmos5l_dfrbp_1_8.RESET_B cks sg13cmos5l_Corner_1.vss sg13cmos5l_Corner_1.vss sg13_lv_nmos ad=0.2516p pd=2.16u as=0.2516p ps=2.16u w=0.74u l=0.13u
M753 sg13cmos5l_Corner_1.iovdd a_118044_42476# cko sg13cmos5l_Corner_1.iovdd sg13_hv_pmos ad=2.1312p pd=7.3u as=3.9294p ps=7.84u w=6.66u l=0.6u
M754 sg13cmos5l_Corner_1.vss adc8b_0.sar12b_0.sg13cmos5l_dfrbp_1_21.Q_N a_100561_97376# sg13cmos5l_Corner_1.vss sg13_lv_nmos ad=0.15055p pd=1.17u as=0.187p ps=1.78u w=0.55u l=0.13u
M755 vdd a_90225_98441# a_90158_98084# vdd sg13_lv_pmos ad=0.2387p pd=1.84u as=0.1008p ps=0.9u w=0.42u l=0.13u
M756 sg13cmos5l_Corner_1.vss a_178296_118044# sg13cmos5l_IOPadAnalog_11.pad sg13cmos5l_Corner_1.vss sg13_hv_nmos ad=1.408p pd=5.04u as=2.596p ps=5.58u w=4.4u l=0.6u
M757 sg13cmos5l_Corner_1.vss adc8b_0.sar12b_0.nh_sw[3] adc8b_0.side_cap8b_1.buf_8_3.z sg13cmos5l_Corner_1.vss sg13_lv_nmos ad=95f pd=0.88u as=95f ps=0.88u w=0.5u l=0.13u
M758 adc8b_0.side_cap8b_1.buf_16_1.z adc8b_0.sar12b_0.nl_sw[2] vddr vddr sg13_lv_pmos ad=0.19p pd=1.38u as=0.19p ps=1.38u w=1u l=0.13u
M759 sg13cmos5l_Corner_1.vss sg13cmos5l_IOPadVdd$1_0.sg13cmos5l_RCClampInverter$1_0.in sg13cmos5l_IOPadVdd$1_0.sg13cmos5l_Clamp_N43N43D4R$1_0.gate sg13cmos5l_Corner_1.vss sg13_hv_nmos ad=1.71p pd=9.38u as=1.71p ps=9.38u w=9u l=0.5u
M760 vdd sg13cmos5l_IOPadVdd$1_0.sg13cmos5l_RCClampInverter$1_0.in sg13cmos5l_IOPadVdd$1_0.sg13cmos5l_Clamp_N43N43D4R$1_0.gate vdd sg13_hv_pmos ad=1.33p pd=7.38u as=1.33p ps=7.38u w=7u l=0.5u
M761 vdd a_91839_98442# a_91970_98448# vdd sg13_lv_pmos ad=1.07253p pd=6.75u as=0.2856p ps=2.36u w=0.84u l=0.13u
M762 a_98316_97335# a_98028_97640# a_98254_97335# sg13cmos5l_Corner_1.vss sg13_lv_nmos ad=0.1428p pd=1.52u as=37.8f ps=0.6u w=0.42u l=0.13u
M763 adc8b_0.side_cap8b_0.buf_8_3.z adc8b_0.side_cap8b_0.in_h_sw[3] sg13cmos5l_Corner_1.vss sg13cmos5l_Corner_1.vss sg13_lv_nmos ad=95f pd=0.88u as=95f ps=0.88u w=0.5u l=0.13u
M764 vdd a_96657_98441# a_97182_98514# vdd sg13_lv_pmos ad=0.1974p pd=1.5u as=0.2856p ps=2.36u w=0.84u l=0.13u
M765 frame a_134044_42476# sg13cmos5l_Corner_1.iovdd sg13cmos5l_Corner_1.iovdd sg13_hv_pmos ad=3.9294p pd=7.84u as=2.1312p ps=7.3u w=6.66u l=0.6u
M766 sg13cmos5l_Corner_1.vss adc8b_0.sar12b_0.sg13cmos5l_buf_1_40.A a_82960_92824# sg13cmos5l_Corner_1.vss sg13_lv_nmos ad=0.14875p pd=1.16u as=0.187p ps=1.78u w=0.55u l=0.13u
M767 sg13cmos5l_Corner_1.vss adc8b_0.sar12b_0.nl_sw[0] adc8b_0.side_cap8b_1.buf_32_0.z sg13cmos5l_Corner_1.vss sg13_lv_nmos ad=95f pd=0.88u as=95f ps=0.88u w=0.5u l=0.13u
M768 adc8b_0.side_cap8b_0.buf_2_3.z adc8b_0.side_cap8b_0.in_h_sw[9] vddr vddr sg13_lv_pmos ad=0.34p pd=2.68u as=0.19p ps=1.38u w=1u l=0.13u
M769 a_94748_98084# a_94466_98448# a_94681_98486# sg13cmos5l_Corner_1.vss sg13_lv_nmos ad=0.141p pd=1.17u as=71.99999f ps=0.865u w=0.64u l=0.13u
M770 adc8b_0.sar12b_0.sg13cmos5l_buf_1_116.A a_96945_96929# sg13cmos5l_Corner_1.vss sg13cmos5l_Corner_1.vss sg13_lv_nmos ad=0.2516p pd=2.16u as=0.1406p ps=1.12u w=0.74u l=0.13u
M771 sg13cmos5l_Corner_1.vss adc8b_0.side_cap8b_0.in_h_sw[0] adc8b_0.side_cap8b_0.buf_32_1.z sg13cmos5l_Corner_1.vss sg13_lv_nmos ad=95f pd=0.88u as=95f ps=0.88u w=0.5u l=0.13u
M772 adc8b_0.sar12b_0.sg13cmos5l_dfrbp_1_18.Q a_89852_99596# vdd vdd sg13_lv_pmos ad=0.3808p pd=2.92u as=0.2128p ps=1.5u w=1.12u l=0.13u
M773 adc8b_0.sar12b_0.sg13cmos5l_dlhr_1_19.Q_N a_97470_97002# sg13cmos5l_Corner_1.vss sg13cmos5l_Corner_1.vss sg13_lv_nmos ad=0.2516p pd=2.16u as=0.1491p ps=1.18u w=0.74u l=0.13u
M774 adc8b_0.sar12b_0.sg13cmos5l_dfrbp_1_9.Q_N a_85175_95421# sg13cmos5l_Corner_1.vss sg13cmos5l_Corner_1.vss sg13_lv_nmos ad=0.2849p pd=2.25u as=0.2516p ps=2.16u w=0.74u l=0.13u
M775 adc8b_0.sar12b_0.nl_sw[2] a_84016_92824# vdd vdd sg13_lv_pmos ad=0.42p pd=2.99u as=0.2114p ps=1.54u w=1.12u l=0.13u
X776 sg13cmos5l_Corner_1.vss a_70222_175886# dantenna l=1.26u w=27.78u
M777 vddr adc8b_0.sar12b_0.nl_sw[1] adc8b_0.side_cap8b_1.buf_16_2.z vddr sg13_lv_pmos ad=0.19p pd=1.38u as=0.19p ps=1.38u w=1u l=0.13u
M778 adc8b_0.side_cap8b_1.buf_32_0.z adc8b_0.sar12b_0.nl_sw[0] sg13cmos5l_Corner_1.vss sg13cmos5l_Corner_1.vss sg13_lv_nmos ad=95f pd=0.88u as=95f ps=0.88u w=0.5u l=0.13u
M779 sg13cmos5l_IOPadAnalog_15.pad a_99639_164698# sg13cmos5l_Corner_1.iovdd sg13cmos5l_Corner_1.iovdd sg13_hv_pmos ad=3.9294p pd=7.84u as=2.1312p ps=7.3u w=6.66u l=0.6u
M780 sg13cmos5l_IOPadAnalog_13.pad a_115639_164698# sg13cmos5l_Corner_1.iovdd sg13cmos5l_Corner_1.iovdd sg13_hv_pmos ad=3.9294p pd=7.84u as=2.1312p ps=7.3u w=6.66u l=0.6u
M781 a_84500_100310# adc8b_0.sar12b_0.sg13cmos5l_inv_1_20.Y sg13cmos5l_Corner_1.vss sg13cmos5l_Corner_1.vss sg13_lv_nmos ad=0.187p pd=1.78u as=0.14875p ps=1.16u w=0.55u l=0.13u
M782 adc8b_0.sar12b_0.sg13cmos5l_inv_1_20.Y adc8b_0.sar12b_0.sg13cmos5l_buf_1_41.A vdd vdd sg13_lv_pmos ad=0.3808p pd=2.92u as=0.3808p ps=2.92u w=1.12u l=0.13u
M783 sg13cmos5l_Corner_1.iovdd a_83639_164698# sg13cmos5l_IOPadAnalog_9.pad sg13cmos5l_Corner_1.iovdd sg13_hv_pmos ad=2.1312p pd=7.3u as=3.9294p ps=7.84u w=6.66u l=0.6u
M784 sg13cmos5l_Corner_1.vss adc8b_0.sar12b_0.nh_sw[0] adc8b_0.side_cap8b_1.buf_32_1.z sg13cmos5l_Corner_1.vss sg13_lv_nmos ad=95f pd=0.88u as=0.17p ps=1.68u w=0.5u l=0.13u
M785 sg13cmos5l_Corner_1.vss vdd sg13cmos5l_Corner_1.vss sg13cmos5l_Corner_1.vss sg13_lv_nmos ad=79.8f pd=0.8u as=0 ps=0 w=0.42u l=1u
M786 vdd adc8b_0.sar12b_0.sg13cmos5l_buf_1_31.X a_83440_94336# vdd sg13_lv_pmos ad=0.2114p pd=1.54u as=0.2856p ps=2.36u w=0.84u l=0.13u
M787 adc8b_0.diff_bsw_0.single_bsw_1.sg13cmos5l_inv_1$1_2.Y adc8b_0.diff_bsw_0.single_bsw_1.sg13cmos5l_inv_1$1_2.A sg13cmos5l_Corner_1.vss sg13cmos5l_Corner_1.vss sg13_lv_nmos ad=0.2516p pd=2.16u as=0.2516p ps=2.16u w=0.74u l=0.13u
M788 a_99261_95107# a_98319_95147# a_99122_95340# sg13cmos5l_Corner_1.vss sg13_lv_nmos ad=79.8f pd=0.8u as=0.2373p ps=1.97u w=0.42u l=0.13u
M789 vdd sg13cmos5l_IOPadVdd$1_0.sg13cmos5l_RCClampInverter$1_0.in sg13cmos5l_IOPadVdd$1_0.sg13cmos5l_Clamp_N43N43D4R$1_0.gate vdd sg13_hv_pmos ad=1.33p pd=7.38u as=1.33p ps=7.38u w=7u l=0.5u
M790 a_90428_96572# a_90146_96936# a_90361_96974# sg13cmos5l_Corner_1.vss sg13_lv_nmos ad=0.141p pd=1.17u as=71.99999f ps=0.865u w=0.64u l=0.13u
M791 adc8b_0.sar12b_0.sg13cmos5l_dlhr_1_10.Q a_101361_97322# vdd vdd sg13_lv_pmos ad=0.3808p pd=2.92u as=0.2128p ps=1.5u w=1.12u l=0.13u
M792 data[1] a_86044_42476# sg13cmos5l_Corner_1.iovdd sg13cmos5l_Corner_1.iovdd sg13_hv_pmos ad=3.9294p pd=7.84u as=2.1312p ps=7.3u w=6.66u l=0.6u
M793 sg13cmos5l_Corner_1.vss a_82676_92750# adc8b_0.sar12b_0.sg13cmos5l_buf_1_32.X sg13cmos5l_Corner_1.vss sg13_lv_nmos ad=0.14875p pd=1.16u as=0.2886p ps=2.26u w=0.74u l=0.13u
M794 a_99519_98850# adc8b_0.sar12b_0.sg13cmos5l_dfrbp_1_22.D sg13cmos5l_Corner_1.vss sg13cmos5l_Corner_1.vss sg13_lv_nmos ad=0.2516p pd=2.16u as=0.15055p ps=1.17u w=0.74u l=0.13u
M795 sg13cmos5l_Corner_1.vss adc8b_0.sar12b_0.sg13cmos5l_nor2b_1_0.Y a_92822_95452# sg13cmos5l_Corner_1.vss sg13_lv_nmos ad=0.2516p pd=2.16u as=96.2f ps=1u w=0.74u l=0.13u
M796 sg13cmos5l_Corner_1.vss a_100727_94375# a_101564_94596# sg13cmos5l_Corner_1.vss sg13_lv_nmos ad=0.1406p pd=1.12u as=0.2516p ps=2.16u w=0.74u l=0.13u
M797 adc8b_0.side_cap8b_0.in_h_sw[0] a_82384_100384# vdd vdd sg13_lv_pmos ad=0.42p pd=2.99u as=0.2114p ps=1.54u w=1.12u l=0.13u
M798 vdd a_84599_98790# a_84558_99156# vdd sg13_lv_pmos ad=1.15047p pd=7.175u as=0.105p ps=1.21u w=1u l=0.13u
M799 sg13cmos5l_Corner_1.vss a_134044_30676# frame sg13cmos5l_Corner_1.vss sg13_hv_nmos ad=1.408p pd=5.04u as=2.596p ps=5.58u w=4.4u l=0.6u
M800 sg13cmos5l_Corner_1.vss adc8b_0.sar12b_0.sg13cmos5l_dfrbp_1_6.RESET_B a_91708_95796# sg13cmos5l_Corner_1.vss sg13_lv_nmos ad=0.1406p pd=1.12u as=77.7f ps=0.95u w=0.74u l=0.13u
M801 a_87092_92750# adc8b_0.sar12b_0.sg13cmos5l_buf_1_34.X sg13cmos5l_Corner_1.vss sg13cmos5l_Corner_1.vss sg13_lv_nmos ad=0.187p pd=1.78u as=0.14875p ps=1.16u w=0.55u l=0.13u
M802 sg13cmos5l_IOPadAnalog_1.pad a_164624_70044# sg13cmos5l_Corner_1.iovdd sg13cmos5l_Corner_1.iovdd sg13_hv_pmos ad=3.9294p pd=7.84u as=2.1312p ps=7.3u w=6.66u l=0.6u
M803 sg13cmos5l_IOPadAnalog_0.pad a_164624_86044# sg13cmos5l_Corner_1.iovdd sg13cmos5l_Corner_1.iovdd sg13_hv_pmos ad=3.9294p pd=7.84u as=2.1312p ps=7.3u w=6.66u l=0.6u
M804 vdd a_92056_99838# a_92001_99719# vdd sg13_lv_pmos ad=1.15047p pd=7.175u as=93.45f ps=0.865u w=0.42u l=0.13u
M805 sg13cmos5l_IOPadAnalog_11.pad a_164624_118044# sg13cmos5l_Corner_1.iovdd sg13cmos5l_Corner_1.iovdd sg13_hv_pmos ad=3.9294p pd=7.84u as=2.1312p ps=7.3u w=6.66u l=0.6u
M806 cks a_30676_118044# sg13cmos5l_Corner_1.vss sg13cmos5l_Corner_1.vss sg13_hv_nmos ad=2.596p pd=5.58u as=1.408p ps=5.04u w=4.4u l=0.6u
M807 vddr adc8b_0.side_cap8b_0.in_l_sw[7] adc8b_0.side_cap8b_0.buf_4_0.z vddr sg13_lv_pmos ad=0.19p pd=1.38u as=0.34p ps=2.68u w=1u l=0.13u
M808 sg13cmos5l_Corner_1.vss a_93140_94262# adc8b_0.sar12b_0.nh_sw[5] sg13cmos5l_Corner_1.vss sg13_lv_nmos ad=0.14875p pd=1.16u as=0.2886p ps=2.26u w=0.74u l=0.13u
M809 data[0] a_70044_42476# sg13cmos5l_Corner_1.iovdd sg13cmos5l_Corner_1.iovdd sg13_hv_pmos ad=3.9294p pd=7.84u as=2.1312p ps=7.3u w=6.66u l=0.6u
M810 vdd a_101012_93512# adc8b_0.sar12b_0.nl_sw[9] vdd sg13_lv_pmos ad=0.2114p pd=1.54u as=0.42p ps=2.99u w=1.12u l=0.13u
M811 vdd a_88820_100310# adc8b_0.sar12b_0.sg13cmos5l_buf_1_76.X vdd sg13_lv_pmos ad=0.2114p pd=1.54u as=0.42p ps=2.99u w=1.12u l=0.13u
M812 a_90740_95024# adc8b_0.sar12b_0.sg13cmos5l_buf_1_45.A vdd vdd sg13_lv_pmos ad=0.2856p pd=2.36u as=0.2114p ps=1.54u w=0.84u l=0.13u
M813 vdd sg13cmos5l_IOPadVdd$1_0.sg13cmos5l_RCClampInverter$1_0.in sg13cmos5l_IOPadVdd$1_0.sg13cmos5l_Clamp_N43N43D4R$1_0.gate vdd sg13_hv_pmos ad=1.33p pd=7.38u as=1.33p ps=7.38u w=7u l=0.5u
M814 sg13cmos5l_Corner_1.vss a_100628_100310# adc8b_0.side_cap8b_0.in_h_sw[8] sg13cmos5l_Corner_1.vss sg13_lv_nmos ad=0.14875p pd=1.16u as=0.2886p ps=2.26u w=0.74u l=0.13u
M815 data[1] a_86044_30676# sg13cmos5l_Corner_1.vss sg13cmos5l_Corner_1.vss sg13_hv_nmos ad=2.596p pd=5.58u as=1.408p ps=5.04u w=4.4u l=0.6u
M816 a_85624_94518# a_85367_94375# a_85786_94298# sg13cmos5l_Corner_1.vss sg13_lv_nmos ad=0.1428p pd=1.52u as=37.8f ps=0.6u w=0.42u l=0.13u
M817 adc8b_0.sar12b_0.sg13cmos5l_dfrbp_1_1.D adc8b_0.sar12b_0.sg13cmos5l_a22oi_1_2.B2 a_91591_93940# sg13cmos5l_Corner_1.vss sg13_lv_nmos ad=0.2664p pd=1.46u as=0.13875p ps=1.115u w=0.74u l=0.13u
M818 a_99756_94311# a_99987_94420# a_99442_94521# sg13cmos5l_Corner_1.vss sg13_lv_nmos ad=0.2373p pd=1.97u as=79.8f ps=0.8u w=0.42u l=0.13u
M819 a_94766_94298# a_95571_94420# a_95026_94521# vdd sg13_lv_pmos ad=0.1428p pd=1.52u as=79.8f ps=0.8u w=0.42u l=0.13u
M820 sg13cmos5l_Corner_1.vss adc8b_0.sar12b_0.nh_sw[5] adc8b_0.side_cap8b_1.buf_8_5.z sg13cmos5l_Corner_1.vss sg13_lv_nmos ad=95f pd=0.88u as=0.17p ps=1.68u w=0.5u l=0.13u
M821 adc8b_0.sar12b_0.sg13cmos5l_inv_1_26.Y adc8b_0.sar12b_0.sg13cmos5l_buf_1_19.A vdd vdd sg13_lv_pmos ad=0.3808p pd=2.92u as=0.3808p ps=2.92u w=1.12u l=0.13u
M822 sg13cmos5l_IOPadAnalog_10.pad a_67639_164698# sg13cmos5l_Corner_1.iovdd sg13cmos5l_Corner_1.iovdd sg13_hv_pmos ad=3.9294p pd=7.84u as=2.1312p ps=7.3u w=6.66u l=0.6u
M823 a_92822_95452# adc8b_0.sar12b_0.sg13cmos5l_nand2_1_0.A adc8b_0.sar12b_0.sg13cmos5l_a22oi_1_0.Y sg13cmos5l_Corner_1.vss sg13_lv_nmos ad=96.2f pd=1u as=0.2664p ps=1.46u w=0.74u l=0.13u
M824 vddr adc8b_0.sar12b_0.nh_sw[1] adc8b_0.side_cap8b_1.buf_16_3.z vddr sg13_lv_pmos ad=0.19p pd=1.38u as=0.19p ps=1.38u w=1u l=0.13u
M825 sg13cmos5l_IOPadAnalog_9.pad a_83639_164698# sg13cmos5l_Corner_1.iovdd sg13cmos5l_Corner_1.iovdd sg13_hv_pmos ad=3.9294p pd=7.84u as=2.1312p ps=7.3u w=6.66u l=0.6u
M826 a_92551_95036# adc8b_0.sar12b_0.sg13cmos5l_inv_1_0.A adc8b_0.sar12b_0.sg13cmos5l_a22oi_1_0.Y vdd sg13_lv_pmos ad=0.2744p pd=1.61u as=0.2128p ps=1.5u w=1.12u l=0.13u
M827 a_82476_96576# a_82995_96583# a_83735_96933# sg13cmos5l_Corner_1.vss sg13_lv_nmos ad=0.3473p pd=2.71u as=0.12665p ps=1.145u w=0.74u l=0.13u
M828 adc8b_0.side_cap8b_1.buf_1_1.z adc8b_0.sar12b_0.nh_sw[10] sg13cmos5l_Corner_1.vss sg13cmos5l_Corner_1.vss sg13_lv_nmos ad=0.17p pd=1.68u as=0.17p ps=1.68u w=0.5u l=0.13u
M829 adc8b_0.sar12b_0.sg13cmos5l_buf_1_9.A a_91600_92824# vdd vdd sg13_lv_pmos ad=0.42p pd=2.99u as=0.2114p ps=1.54u w=1.12u l=0.13u
M830 adc8b_0.sar12b_0.sg13cmos5l_o21ai_1_0.A2 adc8b_0.sar12b_0.sg13cmos5l_nand2_1_0.A a_92770_94302# sg13cmos5l_Corner_1.vss sg13_lv_nmos ad=0.2516p pd=2.16u as=0.1406p ps=1.12u w=0.74u l=0.13u
M831 vdd sg13cmos5l_IOPadVdd$1_0.sg13cmos5l_Clamp_N43N43D4R$1_0.gate sg13cmos5l_Corner_1.vss sg13cmos5l_Corner_1.vss sg13_hv_nmos ad=2.596p pd=5.58u as=1.408p ps=5.04u w=4.4u l=0.6u
M832 sg13cmos5l_IOPadAnalog_1.pad a_164624_70044# sg13cmos5l_Corner_1.iovdd sg13cmos5l_Corner_1.iovdd sg13_hv_pmos ad=3.9294p pd=7.84u as=2.1312p ps=7.3u w=6.66u l=0.6u
X833 a_164624_86044# sg13cmos5l_Corner_1.iovdd sg13cmos5l_Corner_1.iovdd rppd l=12.9u w=0.5u
M834 sg13cmos5l_Corner_1.iovdd a_99639_164698# sg13cmos5l_IOPadAnalog_15.pad sg13cmos5l_Corner_1.iovdd sg13_hv_pmos ad=3.1302p pd=14.26u as=3.9294p ps=7.84u w=6.66u l=0.6u
M835 sg13cmos5l_Corner_1.iovdd a_115639_164698# sg13cmos5l_IOPadAnalog_13.pad sg13cmos5l_Corner_1.iovdd sg13_hv_pmos ad=2.1312p pd=7.3u as=3.9294p ps=7.84u w=6.66u l=0.6u
M836 sg13cmos5l_IOPadAnalog_16.pad a_164624_102044# sg13cmos5l_Corner_1.iovdd sg13cmos5l_Corner_1.iovdd sg13_hv_pmos ad=3.9294p pd=7.84u as=2.1312p ps=7.3u w=6.66u l=0.6u
M837 adc8b_0.side_cap8b_1.buf_16_0.z adc8b_0.sar12b_0.nh_sw[2] sg13cmos5l_Corner_1.vss sg13cmos5l_Corner_1.vss sg13_lv_nmos ad=95f pd=0.88u as=95f ps=0.88u w=0.5u l=0.13u
X838 sg13cmos5l_IOPadAnalog_13.padres sg13cmos5l_Corner_1.iovdd dpantenna l=0.64u w=4.98u
M839 sg13cmos5l_Corner_1.vss adc8b_0.sar12b_0.sg13cmos5l_dfrbp_1_6.RESET_B a_99964_99984# sg13cmos5l_Corner_1.vss sg13_lv_nmos ad=0.1406p pd=1.12u as=77.7f ps=0.95u w=0.74u l=0.13u
M840 vddr adc8b_0.side_cap8b_0.in_h_sw[6] adc8b_0.side_cap8b_0.buf_4_1.z vddr sg13_lv_pmos ad=0.19p pd=1.38u as=0.34p ps=2.68u w=1u l=0.13u
M841 vdd sg13cmos5l_Corner_1.vss vdd vdd sg13_lv_pmos ad=0.34p pd=2.68u as=0 ps=0 w=1u l=1u
M842 vdd a_89399_95887# a_89656_96030# vdd sg13_lv_pmos ad=0.2639p pd=1.81u as=79.8f ps=0.8u w=0.42u l=0.13u
M843 sg13cmos5l_Corner_1.vss a_70044_30676# data[0] sg13cmos5l_Corner_1.vss sg13_hv_nmos ad=1.408p pd=5.04u as=2.596p ps=5.58u w=4.4u l=0.6u
M844 vddr adc8b_0.sar12b_0.nh_sw[0] adc8b_0.side_cap8b_1.buf_32_1.z vddr sg13_lv_pmos ad=0.19p pd=1.38u as=0.19p ps=1.38u w=1u l=0.13u
M845 a_99284_100310# adc8b_0.sar12b_0.sg13cmos5l_buf_1_103.A sg13cmos5l_Corner_1.vss sg13cmos5l_Corner_1.vss sg13_lv_nmos ad=0.187p pd=1.78u as=0.14875p ps=1.16u w=0.55u l=0.13u
M846 sg13cmos5l_Corner_1.vss a_96657_98441# a_96612_98486# sg13cmos5l_Corner_1.vss sg13_lv_nmos ad=0.1428p pd=1.52u as=47.25f ps=0.645u w=0.42u l=0.13u
M847 vdd adc8b_0.sar12b_0.sg13cmos5l_dfrbp_1_0.RESET_B a_99442_94521# vdd sg13_lv_pmos ad=0.1563p pd=1.22u as=0.147p ps=1.54u w=0.42u l=0.13u
M848 vdd sg13cmos5l_IOPadVdd$1_0.sg13cmos5l_Clamp_N43N43D4R$1_0.gate sg13cmos5l_Corner_1.vss sg13cmos5l_Corner_1.vss sg13_hv_nmos ad=2.596p pd=5.58u as=1.408p ps=5.04u w=4.4u l=0.6u
M849 a_97912_99838# a_97655_99957# a_98074_100034# sg13cmos5l_Corner_1.vss sg13_lv_nmos ad=0.1428p pd=1.52u as=37.8f ps=0.6u w=0.42u l=0.13u
M850 adc8b_0.side_cap8b_1.buf_8_0.z adc8b_0.sar12b_0.nl_sw[4] sg13cmos5l_Corner_1.vss sg13cmos5l_Corner_1.vss sg13_lv_nmos ad=95f pd=0.88u as=95f ps=0.88u w=0.5u l=0.13u
M851 vddr adc8b_0.side_cap8b_0.in_l_sw[2] adc8b_0.side_cap8b_0.buf_16_1.z vddr sg13_lv_pmos ad=0.19p pd=1.38u as=0.19p ps=1.38u w=1u l=0.13u
M852 adc8b_0.side_cap8b_0.buf_32_1.z adc8b_0.side_cap8b_0.in_h_sw[0] sg13cmos5l_Corner_1.vss sg13cmos5l_Corner_1.vss sg13_lv_nmos ad=95f pd=0.88u as=95f ps=0.88u w=0.5u l=0.13u
M853 sg13cmos5l_IOPadAnalog_15.pad a_99639_164698# sg13cmos5l_Corner_1.iovdd sg13cmos5l_Corner_1.iovdd sg13_hv_pmos ad=3.9294p pd=7.84u as=2.1312p ps=7.3u w=6.66u l=0.6u
M854 vdd a_84500_92750# adc8b_0.sar12b_0.sg13cmos5l_buf_1_35.A vdd sg13_lv_pmos ad=0.2114p pd=1.54u as=0.42p ps=2.99u w=1.12u l=0.13u
M855 sg13cmos5l_Corner_1.iovdd a_42476_102044# vip sg13cmos5l_Corner_1.iovdd sg13_hv_pmos ad=2.1312p pd=7.3u as=3.9294p ps=7.84u w=6.66u l=0.6u
M856 sg13cmos5l_Corner_1.vss a_85367_94375# a_86204_94596# sg13cmos5l_Corner_1.vss sg13_lv_nmos ad=0.1406p pd=1.12u as=0.2516p ps=2.16u w=0.74u l=0.13u
M857 sg13cmos5l_Corner_1.vss a_178296_70044# sg13cmos5l_IOPadAnalog_1.pad sg13cmos5l_Corner_1.vss sg13_hv_nmos ad=1.408p pd=5.04u as=2.596p ps=5.58u w=4.4u l=0.6u
M858 cko a_118044_42476# sg13cmos5l_Corner_1.iovdd sg13cmos5l_Corner_1.iovdd sg13_hv_pmos ad=3.9294p pd=7.84u as=3.1302p ps=14.26u w=6.66u l=0.6u
M859 sg13cmos5l_Corner_1.vss adc8b_0.side_cap8b_0.in_h_sw[2] adc8b_0.side_cap8b_0.buf_16_0.z sg13cmos5l_Corner_1.vss sg13_lv_nmos ad=95f pd=0.88u as=95f ps=0.88u w=0.5u l=0.13u
M860 sg13cmos5l_Corner_1.vss adc8b_0.sar12b_0.sg13cmos5l_inv_1_29.A a_94609_98888# sg13cmos5l_Corner_1.vss sg13_lv_nmos ad=0.15055p pd=1.17u as=0.187p ps=1.78u w=0.55u l=0.13u
M861 adc8b_0.side_cap8b_0.buf_32_1.z adc8b_0.side_cap8b_0.in_h_sw[0] vddr vddr sg13_lv_pmos ad=0.19p pd=1.38u as=0.19p ps=1.38u w=1u l=0.13u
M862 sg13cmos5l_Corner_1.vss a_84500_100310# adc8b_0.sar12b_0.sg13cmos5l_buf_1_61.X sg13cmos5l_Corner_1.vss sg13_lv_nmos ad=0.14875p pd=1.16u as=0.2886p ps=2.26u w=0.74u l=0.13u
M863 a_93614_100346# adc8b_0.sar12b_0.sg13cmos5l_dlhr_1_11.GATE vdd vdd sg13_lv_pmos ad=79.8f pd=0.8u as=0.1428p ps=1.52u w=0.42u l=0.13u
M864 vdd adc8b_0.sar12b_0.sg13cmos5l_nand2_1_0.A adc8b_0.sar12b_0.sg13cmos5l_o21ai_1_0.A2 vdd sg13_lv_pmos ad=0.3808p pd=2.92u as=0.2128p ps=1.5u w=1.12u l=0.13u
M865 sg13cmos5l_Corner_1.vss sg13cmos5l_IOPadVdd$1_0.sg13cmos5l_RCClampInverter$1_0.in sg13cmos5l_IOPadVdd$1_0.sg13cmos5l_Clamp_N43N43D4R$1_0.gate sg13cmos5l_Corner_1.vss sg13_hv_nmos ad=3.06p pd=18.68u as=1.71p ps=9.38u w=9u l=0.5u
M866 vddr adc8b_0.side_cap8b_0.in_h_sw[0] adc8b_0.side_cap8b_0.buf_32_1.z vddr sg13_lv_pmos ad=0.19p pd=1.38u as=0.19p ps=1.38u w=1u l=0.13u
M867 sg13cmos5l_Corner_1.vss adc8b_0.sar12b_0.sg13cmos5l_dlhr_1_5.D a_89425_98442# sg13cmos5l_Corner_1.vss sg13_lv_nmos ad=0.15055p pd=1.17u as=0.187p ps=1.78u w=0.55u l=0.13u
M868 a_85070_95810# adc8b_0.sar12b_0.sg13cmos5l_dfrbp_1_9.Q vdd vdd sg13_lv_pmos ad=79.8f pd=0.8u as=0.1428p ps=1.52u w=0.42u l=0.13u
M869 sg13cmos5l_Corner_1.vss a_90207_97338# a_90338_97332# sg13cmos5l_Corner_1.vss sg13_lv_nmos ad=1.97045p pd=12.335u as=0.2775p ps=2.23u w=0.74u l=0.13u
M870 vdd adc8b_0.sar12b_0.sg13cmos5l_buf_1_25.X a_86224_92824# vdd sg13_lv_pmos ad=0.2114p pd=1.54u as=0.2856p ps=2.36u w=0.84u l=0.13u
M871 sg13cmos5l_Corner_1.vss sg13cmos5l_IOPadVdd$1_0.sg13cmos5l_Clamp_N43N43D4R$1_0.gate vdd sg13cmos5l_Corner_1.vss sg13_hv_nmos ad=1.408p pd=5.04u as=2.596p ps=5.58u w=4.4u l=0.6u
M872 adc8b_0.sar12b_0.sg13cmos5l_inv_1_7.A a_93232_99596# sg13cmos5l_Corner_1.vss sg13cmos5l_Corner_1.vss sg13_lv_nmos ad=0.2886p pd=2.26u as=0.14875p ps=1.16u w=0.74u l=0.13u
M873 sg13cmos5l_IOPadAnalog_12.pad a_131639_178370# sg13cmos5l_Corner_1.vss sg13cmos5l_Corner_1.vss sg13_hv_nmos ad=2.596p pd=5.58u as=1.408p ps=5.04u w=4.4u l=0.6u
M874 sg13cmos5l_Corner_1.vss adc8b_0.side_cap8b_0.in_l_sw[0] adc8b_0.side_cap8b_0.buf_32_0.z sg13cmos5l_Corner_1.vss sg13_lv_nmos ad=95f pd=0.88u as=95f ps=0.88u w=0.5u l=0.13u
M875 vdd a_85444_99124# adc8b_0.sar12b_0.sg13cmos5l_dlhr_1_9.Q vdd sg13_lv_pmos ad=0.2128p pd=1.5u as=0.3808p ps=2.92u w=1.12u l=0.13u
M876 sg13cmos5l_Corner_1.iovdd a_164624_86044# sg13cmos5l_IOPadAnalog_0.pad sg13cmos5l_Corner_1.iovdd sg13_hv_pmos ad=2.1312p pd=7.3u as=3.9294p ps=7.84u w=6.66u l=0.6u
M877 a_88504_93790# a_88247_93909# a_88666_93986# sg13cmos5l_Corner_1.vss sg13_lv_nmos ad=0.1428p pd=1.52u as=37.8f ps=0.6u w=0.42u l=0.13u
M878 vddr adc8b_0.side_cap8b_0.in_l_sw[5] adc8b_0.side_cap8b_0.buf_8_4.z vddr sg13_lv_pmos ad=0.19p pd=1.38u as=0.19p ps=1.38u w=1u l=0.13u
M879 sg13cmos5l_Corner_1.vss sg13cmos5l_IOPadVdd$1_0.sg13cmos5l_RCClampInverter$1_0.in sg13cmos5l_IOPadVdd$1_0.sg13cmos5l_Clamp_N43N43D4R$1_0.gate sg13cmos5l_Corner_1.vss sg13_hv_nmos ad=3.06p pd=18.68u as=1.71p ps=9.38u w=9u l=0.5u
M880 vin a_30676_86044# sg13cmos5l_Corner_1.vss sg13cmos5l_Corner_1.vss sg13_hv_nmos ad=2.596p pd=5.58u as=1.408p ps=5.04u w=4.4u l=0.6u
M881 sg13cmos5l_Corner_1.vss adc8b_0.sar12b_0.sg13cmos5l_inv_1_8.A a_84647_97592# sg13cmos5l_Corner_1.vss sg13_lv_nmos ad=1.88087p pd=11.775u as=0.2516p ps=2.16u w=0.74u l=0.13u
M882 a_74586_95659# adc8b_0.diff_bsw_0.vcn a_73970_98361# sg13cmos5l_Corner_1.vss sg13_lv_nmos ad=0.95p pd=5.38u as=1.7p ps=10.68u w=5u l=0.13u
M883 a_90740_95024# adc8b_0.sar12b_0.sg13cmos5l_buf_1_45.A sg13cmos5l_Corner_1.vss sg13cmos5l_Corner_1.vss sg13_lv_nmos ad=0.187p pd=1.78u as=0.14875p ps=1.16u w=0.55u l=0.13u
M884 cko a_118044_30676# sg13cmos5l_Corner_1.vss sg13cmos5l_Corner_1.vss sg13_hv_nmos ad=2.596p pd=5.58u as=1.408p ps=5.04u w=4.4u l=0.6u
M885 sg13cmos5l_Corner_1.iovdd a_83639_164698# sg13cmos5l_IOPadAnalog_9.pad sg13cmos5l_Corner_1.iovdd sg13_hv_pmos ad=2.1312p pd=7.3u as=3.9294p ps=7.84u w=6.66u l=0.6u
M886 adc8b_0.sar12b_0.sg13cmos5l_buf_8_0.X a_100995_95814# sg13cmos5l_Corner_1.vss sg13cmos5l_Corner_1.vss sg13_lv_nmos ad=0.1406p pd=1.12u as=0.1406p ps=1.12u w=0.74u l=0.13u
M887 sg13cmos5l_Corner_1.iovdd a_67639_164698# sg13cmos5l_IOPadAnalog_10.pad sg13cmos5l_Corner_1.iovdd sg13_hv_pmos ad=3.1302p pd=14.26u as=3.9294p ps=7.84u w=6.66u l=0.6u
X888 a_36456_138055# a_40542_138385# sg13cmos5l_Corner_1.vss rppd l=20u w=1u
M889 adc8b_0.sar12b_0.sg13cmos5l_buf_1_105.A a_99729_99953# vdd vdd sg13_lv_pmos ad=0.3808p pd=2.92u as=0.2128p ps=1.5u w=1.12u l=0.13u
M890 a_88428_95823# a_88659_95932# a_88114_96033# sg13cmos5l_Corner_1.vss sg13_lv_nmos ad=0.2373p pd=1.97u as=79.8f ps=0.8u w=0.42u l=0.13u
X891 sg13cmos5l_IOPadAnalog_9.padres sg13cmos5l_Corner_1.iovdd dpantenna l=0.64u w=4.98u
M892 vdd adc8b_0.sar12b_0.sg13cmos5l_dlhr_1_5.D a_89425_98442# vdd sg13_lv_pmos ad=1.07253p pd=6.75u as=0.2856p ps=2.36u w=0.84u l=0.13u
M893 vdd adc8b_0.sar12b_0.sg13cmos5l_dfrbp_1_6.RESET_B a_96657_98441# vdd sg13_lv_pmos ad=0.2128p pd=1.5u as=0.2128p ps=1.5u w=1.12u l=0.13u
M894 sg13cmos5l_Corner_1.vss a_88557_95789# a_88659_95932# sg13cmos5l_Corner_1.vss sg13_lv_nmos ad=2.41737p pd=15.64u as=0.2516p ps=2.16u w=0.74u l=0.13u
X895 sg13cmos5l_Corner_1.iovdd a_115639_164698# sg13cmos5l_Corner_1.iovdd rppd l=12.9u w=0.5u
M896 sg13cmos5l_Corner_1.iovdd a_42476_70044# vddr sg13cmos5l_Corner_1.iovdd sg13_hv_pmos ad=2.1312p pd=7.3u as=3.9294p ps=7.84u w=6.66u l=0.6u
M897 a_93036_96920# adc8b_0.sar12b_0.sg13cmos5l_dlhr_1_15.D sg13cmos5l_Corner_1.vss sg13cmos5l_Corner_1.vss sg13_lv_nmos ad=0.1216p pd=1.02u as=0.1371p ps=1.12u w=0.64u l=0.13u
M898 vin a_42476_86044# sg13cmos5l_Corner_1.iovdd sg13cmos5l_Corner_1.iovdd sg13_hv_pmos ad=3.9294p pd=7.84u as=2.1312p ps=7.3u w=6.66u l=0.6u
M899 sg13cmos5l_Corner_1.vss cks adc8b_0.sar12b_0.sg13cmos5l_dfrbp_1_6.RESET_B sg13cmos5l_Corner_1.vss sg13_lv_nmos ad=0.1406p pd=1.12u as=0.1406p ps=1.12u w=0.74u l=0.13u
M900 sg13cmos5l_Corner_1.vss a_94868_99560# adc8b_0.side_cap8b_0.in_l_sw[6] sg13cmos5l_Corner_1.vss sg13_lv_nmos ad=0.14875p pd=1.16u as=0.2886p ps=2.26u w=0.74u l=0.13u
M901 sg13cmos5l_Corner_1.iovdd a_164624_102044# sg13cmos5l_IOPadAnalog_16.pad sg13cmos5l_Corner_1.iovdd sg13_hv_pmos ad=2.1312p pd=7.3u as=3.9294p ps=7.84u w=6.66u l=0.6u
M902 sg13cmos5l_Corner_1.vss sg13cmos5l_IOPadVdd$1_0.sg13cmos5l_Clamp_N43N43D4R$1_0.gate vdd sg13cmos5l_Corner_1.vss sg13_hv_nmos ad=1.408p pd=5.04u as=2.596p ps=5.58u w=4.4u l=0.6u
M903 a_99932_99156# a_99519_98850# a_99864_99156# vdd sg13_lv_pmos ad=0.191p pd=1.44u as=0.105p ps=1.21u w=1u l=0.13u
M904 data[1] a_86044_30676# sg13cmos5l_Corner_1.vss sg13cmos5l_Corner_1.vss sg13_hv_nmos ad=2.596p pd=5.58u as=1.408p ps=5.04u w=4.4u l=0.6u
M905 adc8b_0.sar12b_0.sg13cmos5l_dfrbp_1_4.D adc8b_0.sar12b_0.sg13cmos5l_nand2_1_1.B a_92475_93548# vdd sg13_lv_pmos ad=0.2408p pd=1.55u as=0.1428p ps=1.375u w=1.12u l=0.13u
M906 sg13cmos5l_IOPadAnalog_10.pad a_67639_164698# sg13cmos5l_Corner_1.iovdd sg13cmos5l_Corner_1.iovdd sg13_hv_pmos ad=3.9294p pd=7.84u as=2.1312p ps=7.3u w=6.66u l=0.6u
M907 sg13cmos5l_Corner_1.vss adc8b_0.sar12b_0.sg13cmos5l_dfrbp_1_6.RESET_B a_92668_98472# sg13cmos5l_Corner_1.vss sg13_lv_nmos ad=0.1406p pd=1.12u as=77.7f ps=0.95u w=0.74u l=0.13u
M908 adc8b_0.sar12b_0.sg13cmos5l_dfrbp_1_21.Q a_100124_97620# sg13cmos5l_Corner_1.vss sg13cmos5l_Corner_1.vss sg13_lv_nmos ad=0.2516p pd=2.16u as=0.1406p ps=1.12u w=0.74u l=0.13u
M909 sg13cmos5l_Corner_1.vss a_178296_102044# sg13cmos5l_IOPadAnalog_16.pad sg13cmos5l_Corner_1.vss sg13_hv_nmos ad=1.408p pd=5.04u as=2.596p ps=5.58u w=4.4u l=0.6u
M910 sg13cmos5l_Corner_1.vss vdd sg13cmos5l_Corner_1.vss sg13cmos5l_Corner_1.vss sg13_lv_nmos ad=79.8f pd=0.8u as=0 ps=0 w=0.42u l=1u
M911 vdd adc8b_0.sar12b_0.sg13cmos5l_dfrbp_1_8.RESET_B a_83630_95498# vdd sg13_lv_pmos ad=0.36237p pd=2.605u as=79.8f ps=0.8u w=0.42u l=0.13u
M912 vdd a_96311_94375# a_96568_94518# vdd sg13_lv_pmos ad=0.2639p pd=1.81u as=79.8f ps=0.8u w=0.42u l=0.13u
M913 adc8b_0.side_cap8b_1.buf_8_4.z adc8b_0.sar12b_0.nl_sw[5] vddr vddr sg13_lv_pmos ad=0.19p pd=1.38u as=0.19p ps=1.38u w=1u l=0.13u
M914 sg13cmos5l_Corner_1.vss sg13cmos5l_IOPadVdd$1_0.sg13cmos5l_Clamp_N43N43D4R$1_0.gate vdd sg13cmos5l_Corner_1.vss sg13_hv_nmos ad=1.408p pd=5.04u as=2.596p ps=5.58u w=4.4u l=0.6u
M915 sg13cmos5l_Corner_1.vss a_30676_86044# vin sg13cmos5l_Corner_1.vss sg13_hv_nmos ad=1.408p pd=5.04u as=2.596p ps=5.58u w=4.4u l=0.6u
M916 sg13cmos5l_Corner_1.vss a_102044_30676# data[2] sg13cmos5l_Corner_1.vss sg13_hv_nmos ad=1.408p pd=5.04u as=2.596p ps=5.58u w=4.4u l=0.6u
M917 sg13cmos5l_Corner_1.vss adc8b_0.sar12b_0.sg13cmos5l_dfrbp_1_6.RESET_B a_87372_95498# sg13cmos5l_Corner_1.vss sg13_lv_nmos ad=0.1626p pd=1.415u as=60.89999f ps=0.71u w=0.42u l=0.13u
M918 adc8b_0.sar12b_0.sg13cmos5l_buf_1_3.X a_102064_92824# vdd vdd sg13_lv_pmos ad=0.42p pd=2.99u as=0.2114p ps=1.54u w=1.12u l=0.13u
M919 vin a_42476_86044# sg13cmos5l_Corner_1.iovdd sg13cmos5l_Corner_1.iovdd sg13_hv_pmos ad=3.9294p pd=7.84u as=3.1302p ps=14.26u w=6.66u l=0.6u
M920 adc8b_0.sar12b_0.sg13cmos5l_dlhr_1_19.Q_N a_97470_97002# vdd vdd sg13_lv_pmos ad=0.3808p pd=2.92u as=0.1974p ps=1.5u w=1.12u l=0.13u
X921 a_178296_70044# sg13cmos5l_Corner_1.vss sg13cmos5l_Corner_1.vss rppd l=3.54u w=0.5u
M922 sg13cmos5l_Corner_1.iovdd a_99639_164698# sg13cmos5l_IOPadAnalog_15.pad sg13cmos5l_Corner_1.iovdd sg13_hv_pmos ad=2.1312p pd=7.3u as=3.9294p ps=7.84u w=6.66u l=0.6u
M923 sg13cmos5l_Corner_1.iovdd a_115639_164698# sg13cmos5l_IOPadAnalog_13.pad sg13cmos5l_Corner_1.iovdd sg13_hv_pmos ad=2.1312p pd=7.3u as=3.9294p ps=7.84u w=6.66u l=0.6u
M924 sg13cmos5l_Corner_1.vss adc8b_0.sar12b_0.sg13cmos5l_buf_1_30.A adc8b_0.sar12b_0.sg13cmos5l_buf_1_73.A sg13cmos5l_Corner_1.vss sg13_lv_nmos ad=0.2516p pd=2.16u as=0.2516p ps=2.16u w=0.74u l=0.13u
M925 adc8b_0.side_cap8b_1.buf_16_1.z adc8b_0.sar12b_0.nl_sw[2] vddr vddr sg13_lv_pmos ad=0.19p pd=1.38u as=0.19p ps=1.38u w=1u l=0.13u
M926 sg13cmos5l_IOPadAnalog_15.pad a_99639_164698# sg13cmos5l_Corner_1.iovdd sg13cmos5l_Corner_1.iovdd sg13_hv_pmos ad=3.9294p pd=7.84u as=2.1312p ps=7.3u w=6.66u l=0.6u
M927 sg13cmos5l_Corner_1.vss sg13cmos5l_IOPadVdd$1_0.sg13cmos5l_RCClampInverter$1_0.in sg13cmos5l_Corner_1.vss sg13cmos5l_Corner_1.vss sg13_hv_nmos ad=1.71p pd=9.38u as=0 ps=0 w=9u l=9.5u
M928 sg13cmos5l_Corner_1.iovdd a_42476_86044# vin sg13cmos5l_Corner_1.iovdd sg13_hv_pmos ad=3.1302p pd=14.26u as=3.9294p ps=7.84u w=6.66u l=0.6u
M929 vdd adc8b_0.sar12b_0.sg13cmos5l_inv_1_3.A a_96784_100384# vdd sg13_lv_pmos ad=0.2114p pd=1.54u as=0.2856p ps=2.36u w=0.84u l=0.13u
M930 vdd adc8b_0.sar12b_0.sg13cmos5l_buf_1_40.A adc8b_0.sar12b_0.sg13cmos5l_buf_1_63.A vdd sg13_lv_pmos ad=0.3808p pd=2.92u as=0.3808p ps=2.92u w=1.12u l=0.13u
M931 adc8b_0.sar12b_0.sg13cmos5l_buf_8_0.X a_100995_95814# sg13cmos5l_Corner_1.vss sg13cmos5l_Corner_1.vss sg13_lv_nmos ad=0.1406p pd=1.12u as=0.1406p ps=1.12u w=0.74u l=0.13u
M932 sg13cmos5l_Corner_1.iovdd a_164624_118044# sg13cmos5l_IOPadAnalog_11.pad sg13cmos5l_Corner_1.iovdd sg13_hv_pmos ad=2.1312p pd=7.3u as=3.9294p ps=7.84u w=6.66u l=0.6u
M933 adc8b_0.sar12b_0.sg13cmos5l_buf_1_1.A a_95824_92824# vdd vdd sg13_lv_pmos ad=0.42p pd=2.99u as=0.2114p ps=1.54u w=1.12u l=0.13u
M934 a_100929_94613# a_99987_94420# a_100727_94375# vdd sg13_lv_pmos ad=93.45f pd=0.865u as=0.2048p ps=1.63u w=0.42u l=0.13u
M935 sg13cmos5l_Corner_1.vss a_83231_99901# a_83231_99901# sg13cmos5l_Corner_1.vss sg13_lv_nmos ad=2.92392p pd=18.89u as=0.111p ps=1.34u w=0.3u l=0.13u
M936 cko a_118044_42476# sg13cmos5l_Corner_1.iovdd sg13cmos5l_Corner_1.iovdd sg13_hv_pmos ad=3.9294p pd=7.84u as=2.1312p ps=7.3u w=6.66u l=0.6u
M937 sg13cmos5l_Corner_1.vss adc8b_0.sar12b_0.nh_sw[2] adc8b_0.side_cap8b_1.buf_16_0.z sg13cmos5l_Corner_1.vss sg13_lv_nmos ad=95f pd=0.88u as=95f ps=0.88u w=0.5u l=0.13u
M938 adc8b_0.side_cap8b_1.buf_16_2.z adc8b_0.sar12b_0.nl_sw[1] sg13cmos5l_Corner_1.vss sg13cmos5l_Corner_1.vss sg13_lv_nmos ad=0.17p pd=1.68u as=95f ps=0.88u w=0.5u l=0.13u
M939 a_99095_98445# a_98253_98095# a_97836_98088# vdd sg13_lv_pmos ad=0.2048p pd=1.63u as=0.34p ps=2.68u w=1u l=0.13u
M940 adc8b_0.sar12b_0.sg13cmos5l_and3_1_0.X a_95092_95856# vdd vdd sg13_lv_pmos ad=0.3808p pd=2.92u as=0.36195p ps=1.84u w=1.12u l=0.13u
M941 sg13cmos5l_Corner_1.vss adc8b_0.sar12b_0.sg13cmos5l_dfrbp_1_8.RESET_B a_83724_95498# sg13cmos5l_Corner_1.vss sg13_lv_nmos ad=0.1626p pd=1.415u as=60.89999f ps=0.71u w=0.42u l=0.13u
M942 vddr adc8b_0.sar12b_0.nl_sw[3] adc8b_0.side_cap8b_1.buf_8_1.z vddr sg13_lv_pmos ad=0.19p pd=1.38u as=0.19p ps=1.38u w=1u l=0.13u
M943 sg13cmos5l_Corner_1.iovdd a_83639_164698# sg13cmos5l_IOPadAnalog_9.pad sg13cmos5l_Corner_1.iovdd sg13_hv_pmos ad=2.1312p pd=7.3u as=3.9294p ps=7.84u w=6.66u l=0.6u
M944 sg13cmos5l_Corner_1.vss sg13cmos5l_IOPadVdd$1_0.sg13cmos5l_Clamp_N43N43D4R$1_0.gate vdd sg13cmos5l_Corner_1.vss sg13_hv_nmos ad=1.408p pd=5.04u as=2.596p ps=5.58u w=4.4u l=0.6u
M945 a_84333_95071# adc8b_0.sar12b_0.sg13cmos5l_inv_1_8.A sg13cmos5l_Corner_1.vss sg13cmos5l_Corner_1.vss sg13_lv_nmos ad=0.2516p pd=2.16u as=2.27517p ps=14.72u w=0.74u l=0.13u
X946 sg13cmos5l_Corner_1.vss a_131639_178370# sg13cmos5l_Corner_1.vss rppd l=3.54u w=0.5u
M947 cks a_42476_118044# sg13cmos5l_Corner_1.iovdd sg13cmos5l_Corner_1.iovdd sg13_hv_pmos ad=3.9294p pd=7.84u as=2.1312p ps=7.3u w=6.66u l=0.6u
M948 sg13cmos5l_Corner_1.vss adc8b_0.side_cap8b_0.in_h_sw[1] adc8b_0.side_cap8b_0.buf_16_3.z sg13cmos5l_Corner_1.vss sg13_lv_nmos ad=95f pd=0.88u as=95f ps=0.88u w=0.5u l=0.13u
M949 a_86327_98790# adc8b_0.sar12b_0.sg13cmos5l_dlhr_1_9.D sg13cmos5l_Corner_1.vss sg13cmos5l_Corner_1.vss sg13_lv_nmos ad=0.187p pd=1.78u as=0.15055p ps=1.17u w=0.55u l=0.13u
M950 sg13cmos5l_Corner_1.vss a_99284_100310# adc8b_0.side_cap8b_0.in_l_sw[8] sg13cmos5l_Corner_1.vss sg13_lv_nmos ad=0.14875p pd=1.16u as=0.2886p ps=2.26u w=0.74u l=0.13u
M951 a_86962_93516# a_87405_93559# a_87345_93595# vdd sg13_lv_pmos ad=79.8f pd=0.8u as=63f ps=0.72u w=0.42u l=0.13u
M952 sg13cmos5l_Corner_1.vss sg13cmos5l_IOPadVdd$1_0.sg13cmos5l_RCClampInverter$1_0.in sg13cmos5l_Corner_1.vss sg13cmos5l_Corner_1.vss sg13_hv_nmos ad=1.71p pd=9.38u as=0 ps=0 w=9u l=9.5u
M953 vddr adc8b_0.side_cap8b_0.in_h_sw[1] adc8b_0.side_cap8b_0.buf_16_3.z vddr sg13_lv_pmos ad=0.19p pd=1.38u as=0.19p ps=1.38u w=1u l=0.13u
M954 a_85773_95789# adc8b_0.sar12b_0.sg13cmos5l_inv_1_8.A sg13cmos5l_Corner_1.vss sg13cmos5l_Corner_1.vss sg13_lv_nmos ad=0.2516p pd=2.16u as=2.27517p ps=14.72u w=0.74u l=0.13u
M955 sg13cmos5l_Corner_1.vss a_86872_96030# a_86521_95887# sg13cmos5l_Corner_1.vss sg13_lv_nmos ad=79.8f pd=0.8u as=0.1428p ps=1.52u w=0.42u l=0.13u
M956 adc8b_0.side_cap8b_1.buf_32_0.z adc8b_0.sar12b_0.nl_sw[0] vddr vddr sg13_lv_pmos ad=0.19p pd=1.38u as=0.19p ps=1.38u w=1u l=0.13u
M957 sg13cmos5l_Corner_1.vss sg13cmos5l_IOPadVdd$1_0.sg13cmos5l_Clamp_N43N43D4R$1_0.gate vdd sg13cmos5l_Corner_1.vss sg13_hv_nmos ad=1.408p pd=5.04u as=2.596p ps=5.58u w=4.4u l=0.6u
M958 sg13cmos5l_Corner_1.iovdd a_42476_86044# vin sg13cmos5l_Corner_1.iovdd sg13_hv_pmos ad=2.1312p pd=7.3u as=3.9294p ps=7.84u w=6.66u l=0.6u
M959 adc8b_0.side_cap8b_0.buf_16_1.z adc8b_0.side_cap8b_0.in_l_sw[2] vddr vddr sg13_lv_pmos ad=0.19p pd=1.38u as=0.19p ps=1.38u w=1u l=0.13u
M960 adc8b_0.sar12b_0.sg13cmos5l_inv_1_2.A a_90256_100384# vdd vdd sg13_lv_pmos ad=0.42p pd=2.99u as=0.2114p ps=1.54u w=1.12u l=0.13u
M961 vddr adc8b_0.sar12b_0.nl_sw[1] adc8b_0.side_cap8b_1.buf_16_2.z vddr sg13_lv_pmos ad=0.19p pd=1.38u as=0.19p ps=1.38u w=1u l=0.13u
M962 sg13cmos5l_Corner_1.vss a_30676_70044# vddr sg13cmos5l_Corner_1.vss sg13_hv_nmos ad=2.068p pd=9.74u as=2.596p ps=5.58u w=4.4u l=0.6u
M963 a_85343_97713# adc8b_0.sar12b_0.sg13cmos5l_dfrbp_1_15.D a_86090_97322# sg13cmos5l_Corner_1.vss sg13_lv_nmos ad=0.1428p pd=1.52u as=60.89999f ps=0.71u w=0.42u l=0.13u
M964 a_89692_92772# a_89276_93108# a_89457_92786# sg13cmos5l_Corner_1.vss sg13_lv_nmos ad=77.7f pd=0.95u as=0.2516p ps=2.16u w=0.74u l=0.13u
M965 vdd a_88173_99607# a_88275_99607# vdd sg13_lv_pmos ad=1.15047p pd=7.175u as=0.3864p ps=2.93u w=1.12u l=0.13u
M966 sg13cmos5l_Corner_1.vss a_100383_96930# a_100514_96936# sg13cmos5l_Corner_1.vss sg13_lv_nmos ad=1.97045p pd=12.335u as=0.2775p ps=2.23u w=0.74u l=0.13u
X967 sg13cmos5l_Corner_1.iovdd a_83639_164698# sg13cmos5l_Corner_1.iovdd rppd l=12.9u w=0.5u
M968 adc8b_0.side_cap8b_0.buf_16_0.z adc8b_0.side_cap8b_0.in_h_sw[2] sg13cmos5l_Corner_1.vss sg13cmos5l_Corner_1.vss sg13_lv_nmos ad=95f pd=0.88u as=95f ps=0.88u w=0.5u l=0.13u
M969 a_96370_99564# a_96813_99607# a_96110_100034# sg13cmos5l_Corner_1.vss sg13_lv_nmos ad=79.8f pd=0.8u as=0.1296p ps=1.52u w=0.42u l=0.13u
M970 a_87468_97640# a_87987_97444# a_88727_97399# sg13cmos5l_Corner_1.vss sg13_lv_nmos ad=0.3473p pd=2.71u as=0.12665p ps=1.145u w=0.74u l=0.13u
M971 vdd adc8b_0.sar12b_0.sg13cmos5l_buf_1_110.A a_97552_100384# vdd sg13_lv_pmos ad=0.2114p pd=1.54u as=0.2856p ps=2.36u w=0.84u l=0.13u
M972 vdd a_100995_95814# adc8b_0.sar12b_0.sg13cmos5l_buf_8_0.X vdd sg13_lv_pmos ad=0.3864p pd=2.93u as=0.2128p ps=1.5u w=1.12u l=0.13u
M973 sg13cmos5l_Corner_1.iovdd a_102044_42476# data[2] sg13cmos5l_Corner_1.iovdd sg13_hv_pmos ad=2.1312p pd=7.3u as=3.9294p ps=7.84u w=6.66u l=0.6u
M974 a_85175_95421# a_84333_95071# a_83916_95064# vdd sg13_lv_pmos ad=0.2048p pd=1.63u as=0.34p ps=2.68u w=1u l=0.13u
M975 vddr adc8b_0.sar12b_0.nl_sw[4] adc8b_0.side_cap8b_1.buf_8_0.z vddr sg13_lv_pmos ad=0.19p pd=1.38u as=0.19p ps=1.38u w=1u l=0.13u
M976 data[1] a_86044_42476# sg13cmos5l_Corner_1.iovdd sg13cmos5l_Corner_1.iovdd sg13_hv_pmos ad=3.9294p pd=7.84u as=2.1312p ps=7.3u w=6.66u l=0.6u
M977 adc8b_0.side_cap8b_1.buf_32_0.z adc8b_0.sar12b_0.nl_sw[0] vddr vddr sg13_lv_pmos ad=0.19p pd=1.38u as=0.19p ps=1.38u w=1u l=0.13u
M978 sg13cmos5l_Corner_1.iovdd a_131639_164698# sg13cmos5l_IOPadAnalog_12.pad sg13cmos5l_Corner_1.iovdd sg13_hv_pmos ad=2.1312p pd=7.3u as=3.9294p ps=7.84u w=6.66u l=0.6u
M979 vdd adc8b_0.sar12b_0.sg13cmos5l_buf_1_96.A a_93232_99596# vdd sg13_lv_pmos ad=0.2114p pd=1.54u as=0.2856p ps=2.36u w=0.84u l=0.13u
M980 a_100995_95814# adc8b_0.sar12b_0.sg13cmos5l_buf_8_0.A sg13cmos5l_Corner_1.vss sg13cmos5l_Corner_1.vss sg13_lv_nmos ad=0.1406p pd=1.12u as=0.1406p ps=1.12u w=0.74u l=0.13u
M981 vip a_42476_102044# sg13cmos5l_Corner_1.iovdd sg13cmos5l_Corner_1.iovdd sg13_hv_pmos ad=3.9294p pd=7.84u as=2.1312p ps=7.3u w=6.66u l=0.6u
M982 adc8b_0.side_cap8b_0.buf_32_0.z adc8b_0.side_cap8b_0.in_l_sw[0] sg13cmos5l_Corner_1.vss sg13cmos5l_Corner_1.vss sg13_lv_nmos ad=95f pd=0.88u as=95f ps=0.88u w=0.5u l=0.13u
M983 a_93754_98834# adc8b_0.sar12b_0.sg13cmos5l_dfrbp_1_6.RESET_B sg13cmos5l_Corner_1.vss sg13cmos5l_Corner_1.vss sg13_lv_nmos ad=37.8f pd=0.6u as=79.8f ps=0.8u w=0.42u l=0.13u
M984 sg13cmos5l_Corner_1.iovdd a_67639_164698# sg13cmos5l_IOPadAnalog_10.pad sg13cmos5l_Corner_1.iovdd sg13_hv_pmos ad=2.1312p pd=7.3u as=3.9294p ps=7.84u w=6.66u l=0.6u
M985 sg13cmos5l_Corner_1.vss a_134044_30676# frame sg13cmos5l_Corner_1.vss sg13_hv_nmos ad=1.408p pd=5.04u as=2.596p ps=5.58u w=4.4u l=0.6u
M986 sg13cmos5l_Corner_1.vss vdd sg13cmos5l_Corner_1.vss sg13cmos5l_Corner_1.vss sg13_lv_nmos ad=79.8f pd=0.8u as=0 ps=0 w=0.42u l=1u
M987 cko a_118044_42476# sg13cmos5l_Corner_1.iovdd sg13cmos5l_Corner_1.iovdd sg13_hv_pmos ad=3.9294p pd=7.84u as=2.1312p ps=7.3u w=6.66u l=0.6u
M988 vdd a_97652_94262# adc8b_0.sar12b_0.nh_sw[7] vdd sg13_lv_pmos ad=0.2114p pd=1.54u as=0.42p ps=2.99u w=1.12u l=0.13u
M989 sg13cmos5l_IOPadAnalog_10.pad a_67639_164698# sg13cmos5l_Corner_1.iovdd sg13cmos5l_Corner_1.iovdd sg13_hv_pmos ad=3.9294p pd=7.84u as=2.1312p ps=7.3u w=6.66u l=0.6u
M990 adc8b_0.side_cap8b_0.buf_32_0.z adc8b_0.side_cap8b_0.in_l_sw[0] vddr vddr sg13_lv_pmos ad=0.19p pd=1.38u as=0.19p ps=1.38u w=1u l=0.13u
M991 adc8b_0.sar12b_0.sg13cmos5l_buf_1_79.X a_91024_100384# vdd vdd sg13_lv_pmos ad=0.42p pd=2.99u as=0.2114p ps=1.54u w=1.12u l=0.13u
M992 adc8b_0.sar12b_0.sg13cmos5l_dfrbp_1_21.Q_N a_99287_97399# sg13cmos5l_Corner_1.vss sg13cmos5l_Corner_1.vss sg13_lv_nmos ad=0.2849p pd=2.25u as=0.2516p ps=2.16u w=0.74u l=0.13u
M993 sg13cmos5l_Corner_1.iovdd a_42476_70044# vddr sg13cmos5l_Corner_1.iovdd sg13_hv_pmos ad=2.1312p pd=7.3u as=3.9294p ps=7.84u w=6.66u l=0.6u
M994 vddr adc8b_0.side_cap8b_0.in_h_sw[2] adc8b_0.side_cap8b_0.buf_16_0.z vddr sg13_lv_pmos ad=0.19p pd=1.38u as=0.19p ps=1.38u w=1u l=0.13u
M995 a_82190_98522# a_82995_98095# a_82450_98052# vdd sg13_lv_pmos ad=0.1428p pd=1.52u as=79.8f ps=0.8u w=0.42u l=0.13u
M996 vdd a_100767_97338# a_100898_97332# vdd sg13_lv_pmos ad=1.07253p pd=6.75u as=0.2856p ps=2.36u w=0.84u l=0.13u
M997 sg13cmos5l_Corner_1.vss sg13cmos5l_IOPadVdd$1_0.sg13cmos5l_Clamp_N43N43D4R$1_0.gate vdd sg13cmos5l_Corner_1.vss sg13_hv_nmos ad=1.408p pd=5.04u as=2.596p ps=5.58u w=4.4u l=0.6u
M998 a_100113_98834# a_99932_99156# vdd vdd sg13_lv_pmos ad=0.2128p pd=1.5u as=0.2387p ps=1.84u w=1.12u l=0.13u
M999 sg13cmos5l_Corner_1.iovdd a_99639_164698# sg13cmos5l_IOPadAnalog_15.pad sg13cmos5l_Corner_1.iovdd sg13_hv_pmos ad=2.1312p pd=7.3u as=3.9294p ps=7.84u w=6.66u l=0.6u
M1000 a_87567_96659# a_87719_96543# sg13cmos5l_Corner_1.vss sg13cmos5l_Corner_1.vss sg13_lv_nmos ad=0.2516p pd=2.16u as=1.97045p ps=12.335u w=0.74u l=0.13u
M1001 a_84273_99643# a_83916_99600# vdd vdd sg13_lv_pmos ad=63f pd=0.72u as=0.1563p ps=1.22u w=0.42u l=0.13u
M1002 a_95409_98834# a_95228_99156# vdd vdd sg13_lv_pmos ad=0.2128p pd=1.5u as=0.2387p ps=1.84u w=1.12u l=0.13u
M1003 a_85569_94613# a_84627_94420# a_85367_94375# vdd sg13_lv_pmos ad=93.45f pd=0.865u as=0.2048p ps=1.63u w=0.42u l=0.13u
M1004 vdd adc8b_0.sar12b_0.sg13cmos5l_dfrbp_1_0.Q a_96022_93604# vdd sg13_lv_pmos ad=0.2618p pd=1.63u as=0.2856p ps=2.36u w=0.84u l=0.13u
M1005 vdd a_99729_99953# a_100254_100026# vdd sg13_lv_pmos ad=0.1974p pd=1.5u as=0.2856p ps=2.36u w=0.84u l=0.13u
M1006 cks a_42476_118044# sg13cmos5l_Corner_1.iovdd sg13cmos5l_Corner_1.iovdd sg13_hv_pmos ad=3.9294p pd=7.84u as=2.1312p ps=7.3u w=6.66u l=0.6u
M1007 a_92252_98084# a_91970_98448# a_92185_98486# sg13cmos5l_Corner_1.vss sg13_lv_nmos ad=0.141p pd=1.17u as=71.99999f ps=0.865u w=0.64u l=0.13u
M1008 adc8b_0.sar12b_0.sg13cmos5l_dlhr_1_6.Q_N a_91326_97304# sg13cmos5l_Corner_1.vss sg13cmos5l_Corner_1.vss sg13_lv_nmos ad=0.2516p pd=2.16u as=0.1491p ps=1.18u w=0.74u l=0.13u
M1009 sg13cmos5l_Corner_1.vss sg13cmos5l_IOPadVdd$1_0.sg13cmos5l_Clamp_N43N43D4R$1_0.gate vdd sg13cmos5l_Corner_1.vss sg13_hv_nmos ad=1.408p pd=5.04u as=2.596p ps=5.58u w=4.4u l=0.6u
M1010 sg13cmos5l_Corner_1.iovdd a_102044_42476# data[2] sg13cmos5l_Corner_1.iovdd sg13_hv_pmos ad=2.1312p pd=7.3u as=3.9294p ps=7.84u w=6.66u l=0.6u
M1011 vddr adc8b_0.sar12b_0.nh_sw[1] adc8b_0.side_cap8b_1.buf_16_3.z vddr sg13_lv_pmos ad=0.19p pd=1.38u as=0.19p ps=1.38u w=1u l=0.13u
M1012 a_89412_92822# a_88863_92802# a_89276_93108# sg13cmos5l_Corner_1.vss sg13_lv_nmos ad=47.25f pd=0.645u as=0.141p ps=1.17u w=0.42u l=0.13u
M1013 a_85437_97480# a_84495_97540# a_85343_97713# vdd sg13_lv_pmos ad=79.8f pd=0.8u as=0.1428p ps=1.52u w=0.42u l=0.13u
M1014 sg13cmos5l_IOPadAnalog_15.pad a_99639_164698# sg13cmos5l_Corner_1.iovdd sg13cmos5l_Corner_1.iovdd sg13_hv_pmos ad=3.9294p pd=7.84u as=2.1312p ps=7.3u w=6.66u l=0.6u
M1015 vdd sg13cmos5l_IOPadVdd$1_0.sg13cmos5l_Clamp_N43N43D4R$1_0.gate sg13cmos5l_Corner_1.vss sg13cmos5l_Corner_1.vss sg13_hv_nmos ad=2.596p pd=5.58u as=1.408p ps=5.04u w=4.4u l=0.6u
M1016 sg13cmos5l_IOPadAnalog_13.pad a_115639_164698# sg13cmos5l_Corner_1.iovdd sg13cmos5l_Corner_1.iovdd sg13_hv_pmos ad=3.9294p pd=7.84u as=2.1312p ps=7.3u w=6.66u l=0.6u
M1017 sg13cmos5l_Corner_1.iovdd a_42476_118044# cks sg13cmos5l_Corner_1.iovdd sg13_hv_pmos ad=2.1312p pd=7.3u as=3.9294p ps=7.84u w=6.66u l=0.6u
M1018 adc8b_0.sar12b_0.nl_sw[1] a_83632_92824# sg13cmos5l_Corner_1.vss sg13cmos5l_Corner_1.vss sg13_lv_nmos ad=0.2886p pd=2.26u as=0.14875p ps=1.16u w=0.74u l=0.13u
M1019 a_85215_93906# adc8b_0.sar12b_0.sg13cmos5l_dfrbp_1_9.Q sg13cmos5l_Corner_1.vss sg13cmos5l_Corner_1.vss sg13_lv_nmos ad=0.2516p pd=2.16u as=0.15055p ps=1.17u w=0.74u l=0.13u
M1020 sg13cmos5l_Corner_1.vss sg13cmos5l_IOPadVdd$1_0.sg13cmos5l_Clamp_N43N43D4R$1_0.gate vdd sg13cmos5l_Corner_1.vss sg13_hv_nmos ad=1.408p pd=5.04u as=2.596p ps=5.58u w=4.4u l=0.6u
M1021 vdd a_95469_94277# a_95571_94420# vdd sg13_lv_pmos ad=1.43437p pd=9.105u as=0.3864p ps=2.93u w=1.12u l=0.13u
M1022 sg13cmos5l_Corner_1.iovdd a_134044_42476# frame sg13cmos5l_Corner_1.iovdd sg13_hv_pmos ad=2.1312p pd=7.3u as=3.9294p ps=7.84u w=6.66u l=0.6u
M1023 sg13cmos5l_Corner_1.iovdd a_164624_70044# sg13cmos5l_IOPadAnalog_1.pad sg13cmos5l_Corner_1.iovdd sg13_hv_pmos ad=2.1312p pd=7.3u as=3.9294p ps=7.84u w=6.66u l=0.6u
M1024 adc8b_0.sar12b_0.sg13cmos5l_buf_1_34.X a_86608_92824# vdd vdd sg13_lv_pmos ad=0.42p pd=2.99u as=0.2114p ps=1.54u w=1.12u l=0.13u
M1025 vddr adc8b_0.side_cap8b_0.in_h_sw[0] adc8b_0.side_cap8b_0.buf_32_1.z vddr sg13_lv_pmos ad=0.19p pd=1.38u as=0.19p ps=1.38u w=1u l=0.13u
M1026 a_70946_94286# vdd a_70852_94286# sg13cmos5l_Corner_1.vss sg13_lv_nmos ad=0.57p pd=3.38u as=1.02p ps=6.68u w=3u l=0.13u
M1027 cko a_118044_42476# sg13cmos5l_Corner_1.iovdd sg13cmos5l_Corner_1.iovdd sg13_hv_pmos ad=3.9294p pd=7.84u as=2.1312p ps=7.3u w=6.66u l=0.6u
X1028 a_134044_42476# sg13cmos5l_Corner_1.iovdd sg13cmos5l_Corner_1.iovdd rppd l=12.9u w=0.5u
M1029 sg13cmos5l_IOPadAnalog_0.pad a_164624_86044# sg13cmos5l_Corner_1.iovdd sg13cmos5l_Corner_1.iovdd sg13_hv_pmos ad=3.9294p pd=7.84u as=2.1312p ps=7.3u w=6.66u l=0.6u
M1030 adc8b_0.side_cap8b_1.buf_16_0.z adc8b_0.sar12b_0.nh_sw[2] sg13cmos5l_Corner_1.vss sg13cmos5l_Corner_1.vss sg13_lv_nmos ad=95f pd=0.88u as=95f ps=0.88u w=0.5u l=0.13u
M1031 vddr adc8b_0.sar12b_0.nl_sw[2] adc8b_0.side_cap8b_1.buf_16_1.z vddr sg13_lv_pmos ad=0.19p pd=1.38u as=0.34p ps=2.68u w=1u l=0.13u
M1032 vdd a_98776_93790# a_98721_93671# vdd sg13_lv_pmos ad=1.86162p pd=11.935u as=93.45f ps=0.865u w=0.42u l=0.13u
M1033 sg13cmos5l_Corner_1.vss a_70044_30676# data[0] sg13cmos5l_Corner_1.vss sg13_hv_nmos ad=1.408p pd=5.04u as=2.596p ps=5.58u w=4.4u l=0.6u
M1034 vdd sg13cmos5l_IOPadVdd$1_0.sg13cmos5l_Clamp_N43N43D4R$1_0.gate sg13cmos5l_Corner_1.vss sg13cmos5l_Corner_1.vss sg13_hv_nmos ad=2.596p pd=5.58u as=1.408p ps=5.04u w=4.4u l=0.6u
M1035 sg13cmos5l_Corner_1.vss adc8b_0.sar12b_0.nl_sw[1] adc8b_0.side_cap8b_1.buf_16_2.z sg13cmos5l_Corner_1.vss sg13_lv_nmos ad=95f pd=0.88u as=95f ps=0.88u w=0.5u l=0.13u
M1036 a_87182_97322# a_87987_97444# a_87442_97545# vdd sg13_lv_pmos ad=0.1428p pd=1.52u as=79.8f ps=0.8u w=0.42u l=0.13u
M1037 adc8b_0.sar12b_0.sg13cmos5l_o21ai_1_0.A1 adc8b_0.sar12b_0.sg13cmos5l_a221oi_1_0.C1 sg13cmos5l_Corner_1.vss sg13cmos5l_Corner_1.vss sg13_lv_nmos ad=0.2516p pd=2.16u as=0.1406p ps=1.12u w=0.74u l=0.13u
M1038 a_96311_94375# a_95469_94277# a_95052_94616# vdd sg13_lv_pmos ad=0.2048p pd=1.63u as=0.34p ps=2.68u w=1u l=0.13u
M1039 frame a_134044_30676# sg13cmos5l_Corner_1.vss sg13cmos5l_Corner_1.vss sg13_hv_nmos ad=2.596p pd=5.58u as=1.408p ps=5.04u w=4.4u l=0.6u
M1040 vdd adc8b_0.sar12b_0.sg13cmos5l_dfrbp_1_8.RESET_B a_96370_99564# vdd sg13_lv_pmos ad=0.1563p pd=1.22u as=0.147p ps=1.54u w=0.42u l=0.13u
X1041 sg13cmos5l_Corner_1.vss sg13cmos5l_IOPadAnalog_5.padres dantenna l=0.64u w=3.1u
M1042 vdd adc8b_0.sar12b_0.sg13cmos5l_dfrbp_1_0.RESET_B a_98894_92786# vdd sg13_lv_pmos ad=0.36237p pd=2.605u as=79.8f ps=0.8u w=0.42u l=0.13u
M1043 adc8b_0.side_cap8b_0.buf_16_3.z adc8b_0.side_cap8b_0.in_h_sw[1] vddr vddr sg13_lv_pmos ad=0.19p pd=1.38u as=0.19p ps=1.38u w=1u l=0.13u
M1044 adc8b_0.side_cap8b_0.buf_8_5.z adc8b_0.side_cap8b_0.in_h_sw[5] vddr vddr sg13_lv_pmos ad=0.19p pd=1.38u as=0.19p ps=1.38u w=1u l=0.13u
M1045 adc8b_0.side_cap8b_1.buf_16_2.z adc8b_0.sar12b_0.nl_sw[1] vddr vddr sg13_lv_pmos ad=0.19p pd=1.38u as=0.19p ps=1.38u w=1u l=0.13u
X1046 a_36456_134755# a_40542_135085# sg13cmos5l_Corner_1.vss rppd l=20u w=1u
M1047 sg13cmos5l_Corner_1.vss adc8b_0.side_cap8b_0.in_h_sw[0] adc8b_0.side_cap8b_0.buf_32_1.z sg13cmos5l_Corner_1.vss sg13_lv_nmos ad=95f pd=0.88u as=95f ps=0.88u w=0.5u l=0.13u
M1048 sg13cmos5l_Corner_1.iovdd a_164624_70044# sg13cmos5l_IOPadAnalog_1.pad sg13cmos5l_Corner_1.iovdd sg13_hv_pmos ad=2.1312p pd=7.3u as=3.9294p ps=7.84u w=6.66u l=0.6u
M1049 a_99597_92765# adc8b_0.sar12b_0.sg13cmos5l_dfrbp_1_0.CLK vdd vdd sg13_lv_pmos ad=0.4088p pd=2.97u as=1.777p ps=11.395u w=1.12u l=0.13u
M1050 sg13cmos5l_Corner_1.iovdd a_67639_164698# sg13cmos5l_IOPadAnalog_10.pad sg13cmos5l_Corner_1.iovdd sg13_hv_pmos ad=2.1312p pd=7.3u as=3.9294p ps=7.84u w=6.66u l=0.6u
M1051 adc8b_0.sar12b_0.sg13cmos5l_dfrbp_1_6.RESET_B cks vdd vdd sg13_lv_pmos ad=0.2128p pd=1.5u as=0.2128p ps=1.5u w=1.12u l=0.13u
M1052 sg13cmos5l_Corner_1.iovdd a_164624_86044# sg13cmos5l_IOPadAnalog_0.pad sg13cmos5l_Corner_1.iovdd sg13_hv_pmos ad=3.1302p pd=14.26u as=3.9294p ps=7.84u w=6.66u l=0.6u
M1053 a_94840_93006# a_94583_92863# a_95002_92786# sg13cmos5l_Corner_1.vss sg13_lv_nmos ad=0.1428p pd=1.52u as=37.8f ps=0.6u w=0.42u l=0.13u
M1054 vdd adc8b_0.sar12b_0.sg13cmos5l_dfrbp_1_8.RESET_B a_97358_95810# vdd sg13_lv_pmos ad=0.36237p pd=2.605u as=79.8f ps=0.8u w=0.42u l=0.13u
M1055 vddr adc8b_0.side_cap8b_0.in_h_sw[0] adc8b_0.side_cap8b_0.buf_32_1.z vddr sg13_lv_pmos ad=0.19p pd=1.38u as=0.19p ps=1.38u w=1u l=0.13u
M1056 sg13cmos5l_Corner_1.vss adc8b_0.side_cap8b_0.in_l_sw[5] adc8b_0.side_cap8b_0.buf_8_4.z sg13cmos5l_Corner_1.vss sg13_lv_nmos ad=95f pd=0.88u as=95f ps=0.88u w=0.5u l=0.13u
M1057 sg13cmos5l_IOPadAnalog_11.pad a_178296_118044# sg13cmos5l_Corner_1.vss sg13cmos5l_Corner_1.vss sg13_hv_nmos ad=2.596p pd=5.58u as=1.408p ps=5.04u w=4.4u l=0.6u
M1058 sg13cmos5l_Corner_1.vss sg13cmos5l_IOPadVdd$1_0.sg13cmos5l_Clamp_N43N43D4R$1_0.gate vdd sg13cmos5l_Corner_1.vss sg13_hv_nmos ad=1.408p pd=5.04u as=2.596p ps=5.58u w=4.4u l=0.6u
M1059 vddr a_30676_70044# sg13cmos5l_Corner_1.vss sg13cmos5l_Corner_1.vss sg13_hv_nmos ad=2.596p pd=5.58u as=1.408p ps=5.04u w=4.4u l=0.6u
M1060 vdd sg13cmos5l_IOPadVdd$1_0.sg13cmos5l_RCClampInverter$1_0.in sg13cmos5l_IOPadVdd$1_0.sg13cmos5l_Clamp_N43N43D4R$1_0.gate vdd sg13_hv_pmos ad=2.38p pd=14.68u as=1.33p ps=7.38u w=7u l=0.5u
M1061 sg13cmos5l_Corner_1.iovdd a_164624_102044# sg13cmos5l_IOPadAnalog_16.pad sg13cmos5l_Corner_1.iovdd sg13_hv_pmos ad=2.1312p pd=7.3u as=3.9294p ps=7.84u w=6.66u l=0.6u
M1062 vddr adc8b_0.sar12b_0.nl_sw[0] adc8b_0.side_cap8b_1.buf_32_0.z vddr sg13_lv_pmos ad=0.19p pd=1.38u as=0.19p ps=1.38u w=1u l=0.13u
M1063 a_99297_98207# a_98355_98095# a_99095_98445# vdd sg13_lv_pmos ad=93.45f pd=0.865u as=0.2048p ps=1.63u w=0.42u l=0.13u
M1064 sg13cmos5l_IOPadAnalog_11.pad a_164624_118044# sg13cmos5l_Corner_1.iovdd sg13cmos5l_Corner_1.iovdd sg13_hv_pmos ad=3.9294p pd=7.84u as=2.1312p ps=7.3u w=6.66u l=0.6u
M1065 sg13cmos5l_IOPadAnalog_10.pad a_67639_164698# sg13cmos5l_Corner_1.iovdd sg13cmos5l_Corner_1.iovdd sg13_hv_pmos ad=3.9294p pd=7.84u as=2.1312p ps=7.3u w=6.66u l=0.6u
M1066 vddr a_42476_70044# sg13cmos5l_Corner_1.iovdd sg13cmos5l_Corner_1.iovdd sg13_hv_pmos ad=3.9294p pd=7.84u as=2.1312p ps=7.3u w=6.66u l=0.6u
M1067 a_89266_99057# a_89709_98813# a_89006_98834# sg13cmos5l_Corner_1.vss sg13_lv_nmos ad=79.8f pd=0.8u as=0.1296p ps=1.52u w=0.42u l=0.13u
M1068 sg13cmos5l_Corner_1.iovdd a_70044_42476# data[0] sg13cmos5l_Corner_1.iovdd sg13_hv_pmos ad=2.1312p pd=7.3u as=3.9294p ps=7.84u w=6.66u l=0.6u
M1069 sg13cmos5l_Corner_1.iovdd a_134044_42476# frame sg13cmos5l_Corner_1.iovdd sg13_hv_pmos ad=2.1312p pd=7.3u as=3.9294p ps=7.84u w=6.66u l=0.6u
M1070 vdd a_98036_92750# adc8b_0.sar12b_0.nl_sw[7] vdd sg13_lv_pmos ad=0.2114p pd=1.54u as=0.42p ps=2.99u w=1.12u l=0.13u
M1071 adc8b_0.sar12b_0.sg13cmos5l_o21ai_1_0.A1 adc8b_0.sar12b_0.sg13cmos5l_inv_1_0.Y a_92950_95836# sg13cmos5l_Corner_1.vss sg13_lv_nmos ad=0.2516p pd=2.16u as=0.1406p ps=1.12u w=0.74u l=0.13u
M1072 sg13cmos5l_Corner_1.vss a_83170_95024# a_82889_95326# sg13cmos5l_Corner_1.vss sg13_lv_nmos ad=79.8f pd=0.8u as=0.1428p ps=1.52u w=0.42u l=0.5u
M1073 sg13cmos5l_Corner_1.iovdd a_99639_164698# sg13cmos5l_IOPadAnalog_15.pad sg13cmos5l_Corner_1.iovdd sg13_hv_pmos ad=2.1312p pd=7.3u as=3.9294p ps=7.84u w=6.66u l=0.6u
M1074 vip a_30676_102044# sg13cmos5l_Corner_1.vss sg13cmos5l_Corner_1.vss sg13_hv_nmos ad=2.596p pd=5.58u as=1.408p ps=5.04u w=4.4u l=0.6u
M1075 vddr adc8b_0.side_cap8b_0.in_l_sw[0] adc8b_0.side_cap8b_0.buf_32_0.z vddr sg13_lv_pmos ad=0.19p pd=1.38u as=0.19p ps=1.38u w=1u l=0.13u
M1076 vdd a_100439_92863# a_101276_93084# vdd sg13_lv_pmos ad=0.2128p pd=1.5u as=0.3864p ps=2.93u w=1.12u l=0.13u
M1077 a_84500_92750# adc8b_0.sar12b_0.sg13cmos5l_buf_1_37.A sg13cmos5l_Corner_1.vss sg13cmos5l_Corner_1.vss sg13_lv_nmos ad=0.187p pd=1.78u as=0.14875p ps=1.16u w=0.55u l=0.13u
M1078 sg13cmos5l_Corner_1.iovdd a_115639_164698# sg13cmos5l_IOPadAnalog_13.pad sg13cmos5l_Corner_1.iovdd sg13_hv_pmos ad=2.1312p pd=7.3u as=3.9294p ps=7.84u w=6.66u l=0.6u
M1079 a_88509_96619# a_87567_96659# a_88415_96619# vdd sg13_lv_pmos ad=79.8f pd=0.8u as=0.1428p ps=1.52u w=0.42u l=0.13u
M1080 data[0] a_70044_30676# sg13cmos5l_Corner_1.vss sg13cmos5l_Corner_1.vss sg13_hv_nmos ad=2.596p pd=5.58u as=1.408p ps=5.04u w=4.4u l=0.6u
M1081 adc8b_0.side_cap8b_1.buf_32_1.z adc8b_0.sar12b_0.nh_sw[0] vddr vddr sg13_lv_pmos ad=0.19p pd=1.38u as=0.19p ps=1.38u w=1u l=0.13u
M1082 a_89580_98847# a_89292_99152# a_89518_98847# sg13cmos5l_Corner_1.vss sg13_lv_nmos ad=0.1428p pd=1.52u as=37.8f ps=0.6u w=0.42u l=0.13u
M1083 sg13cmos5l_Corner_1.iovdd a_164624_118044# sg13cmos5l_IOPadAnalog_11.pad sg13cmos5l_Corner_1.iovdd sg13_hv_pmos ad=3.1302p pd=14.26u as=3.9294p ps=7.84u w=6.66u l=0.6u
M1084 vddr a_42476_70044# sg13cmos5l_Corner_1.iovdd sg13cmos5l_Corner_1.iovdd sg13_hv_pmos ad=3.9294p pd=7.84u as=3.1302p ps=14.26u w=6.66u l=0.6u
M1085 adc8b_0.side_cap8b_0.in_h_sw[3] a_87184_100384# vdd vdd sg13_lv_pmos ad=0.42p pd=2.99u as=0.2114p ps=1.54u w=1.12u l=0.13u
M1086 sg13cmos5l_Corner_1.vss a_95800_97542# a_95449_97399# sg13cmos5l_Corner_1.vss sg13_lv_nmos ad=79.8f pd=0.8u as=0.1428p ps=1.52u w=0.42u l=0.13u
M1087 a_94701_97301# adc8b_0.sar12b_0.sg13cmos5l_dfrbp_1_23.CLK sg13cmos5l_Corner_1.vss sg13cmos5l_Corner_1.vss sg13_lv_nmos ad=0.2516p pd=2.16u as=1.97045p ps=12.335u w=0.74u l=0.13u
X1088 a_164624_118044# sg13cmos5l_Corner_1.iovdd sg13cmos5l_Corner_1.iovdd rppd l=12.9u w=0.5u
M1089 adc8b_0.side_cap8b_1.buf_16_1.z adc8b_0.sar12b_0.nl_sw[2] sg13cmos5l_Corner_1.vss sg13cmos5l_Corner_1.vss sg13_lv_nmos ad=0.17p pd=1.68u as=95f ps=0.88u w=0.5u l=0.13u
M1090 vdd a_86420_97286# adc8b_0.sar12b_0.sg13cmos5l_inv_1_19.A vdd sg13_lv_pmos ad=0.2114p pd=1.54u as=0.42p ps=2.99u w=1.12u l=0.13u
M1091 vdd a_95543_97399# a_95800_97542# vdd sg13_lv_pmos ad=0.2639p pd=1.81u as=79.8f ps=0.8u w=0.42u l=0.13u
M1092 sg13cmos5l_Corner_1.vss vdd sg13cmos5l_Corner_1.vss sg13cmos5l_Corner_1.vss sg13_lv_nmos ad=0.1428p pd=1.52u as=0 ps=0 w=0.42u l=1u
M1093 adc8b_0.sar12b_0.sg13cmos5l_buf_1_8.X a_92656_92824# vdd vdd sg13_lv_pmos ad=0.42p pd=2.99u as=0.2114p ps=1.54u w=1.12u l=0.13u
M1094 a_96878_96572# a_96482_96936# a_96764_96572# vdd sg13_lv_pmos ad=0.1008p pd=0.9u as=0.191p ps=1.44u w=0.42u l=0.13u
M1095 adc8b_0.sar12b_0.sg13cmos5l_a22oi_1_1.Y adc8b_0.sar12b_0.sg13cmos5l_a22oi_1_1.A1 a_96582_95452# sg13cmos5l_Corner_1.vss sg13_lv_nmos ad=0.2664p pd=1.46u as=96.2f ps=1u w=0.74u l=0.13u
M1096 adc8b_0.side_cap8b_1.buf_8_4.z adc8b_0.sar12b_0.nl_sw[5] vddr vddr sg13_lv_pmos ad=0.19p pd=1.38u as=0.19p ps=1.38u w=1u l=0.13u
M1097 a_96974_93986# a_97779_93559# a_97234_93516# vdd sg13_lv_pmos ad=0.1428p pd=1.52u as=79.8f ps=0.8u w=0.42u l=0.13u
M1098 vddr a_42476_70044# sg13cmos5l_Corner_1.iovdd sg13cmos5l_Corner_1.iovdd sg13_hv_pmos ad=3.9294p pd=7.84u as=2.1312p ps=7.3u w=6.66u l=0.6u
M1099 a_98241_99149# a_97299_98956# a_98039_98911# vdd sg13_lv_pmos ad=93.45f pd=0.865u as=0.2048p ps=1.63u w=0.42u l=0.13u
M1100 a_91292_96132# a_91010_95820# a_91225_95802# sg13cmos5l_Corner_1.vss sg13_lv_nmos ad=0.141p pd=1.17u as=71.99999f ps=0.865u w=0.64u l=0.13u
M1101 sg13cmos5l_IOPadAnalog_0.pad a_178296_86044# sg13cmos5l_Corner_1.vss sg13cmos5l_Corner_1.vss sg13_hv_nmos ad=2.596p pd=5.58u as=2.068p ps=9.74u w=4.4u l=0.6u
M1102 vdd adc8b_0.sar12b_0.sg13cmos5l_dfrbp_1_6.RESET_B a_98002_97545# vdd sg13_lv_pmos ad=0.1563p pd=1.22u as=0.147p ps=1.54u w=0.42u l=0.13u
M1103 sg13cmos5l_Corner_1.vss adc8b_0.sar12b_0.sg13cmos5l_buf_8_1.A a_98471_95031# sg13cmos5l_Corner_1.vss sg13_lv_nmos ad=2.41737p pd=15.64u as=0.2516p ps=2.16u w=0.74u l=0.13u
M1104 adc8b_0.side_cap8b_1.buf_16_3.z adc8b_0.sar12b_0.nh_sw[1] vddr vddr sg13_lv_pmos ad=0.19p pd=1.38u as=0.19p ps=1.38u w=1u l=0.13u
M1105 a_82476_96576# a_82450_96540# sg13cmos5l_Corner_1.vss sg13cmos5l_Corner_1.vss sg13_lv_nmos ad=0.2516p pd=2.16u as=0.1626p ps=1.415u w=0.74u l=0.13u
M1106 cks a_30676_118044# sg13cmos5l_Corner_1.vss sg13cmos5l_Corner_1.vss sg13_hv_nmos ad=2.596p pd=5.58u as=1.408p ps=5.04u w=4.4u l=0.6u
M1107 a_86817_96125# a_85875_95932# a_86615_95887# vdd sg13_lv_pmos ad=93.45f pd=0.865u as=0.2048p ps=1.63u w=0.42u l=0.13u
M1108 sg13cmos5l_Corner_1.vss adc8b_0.side_cap8b_0.in_l_sw[2] adc8b_0.side_cap8b_0.buf_16_1.z sg13cmos5l_Corner_1.vss sg13_lv_nmos ad=95f pd=0.88u as=95f ps=0.88u w=0.5u l=0.13u
M1109 adc8b_0.sar12b_0.sg13cmos5l_buf_1_31.X a_82192_92824# sg13cmos5l_Corner_1.vss sg13cmos5l_Corner_1.vss sg13_lv_nmos ad=0.2886p pd=2.26u as=0.14875p ps=1.16u w=0.74u l=0.13u
M1110 a_87756_99600# a_87730_99564# vdd vdd sg13_lv_pmos ad=0.34p pd=2.68u as=0.36237p ps=2.605u w=1u l=0.13u
M1111 vdd a_94929_98441# a_94862_98084# vdd sg13_lv_pmos ad=0.2387p pd=1.84u as=0.1008p ps=0.9u w=0.42u l=0.13u
M1112 sg13cmos5l_Corner_1.vss adc8b_0.side_cap8b_0.in_l_sw[8] adc8b_0.side_cap8b_0.buf_2_1.z sg13cmos5l_Corner_1.vss sg13_lv_nmos ad=95f pd=0.88u as=0.17p ps=1.68u w=0.5u l=0.13u
M1113 sg13cmos5l_Corner_1.vss sg13cmos5l_IOPadVdd$1_0.sg13cmos5l_Clamp_N43N43D4R$1_0.gate vdd sg13cmos5l_Corner_1.vss sg13_hv_nmos ad=1.408p pd=5.04u as=2.596p ps=5.58u w=4.4u l=0.6u
M1114 a_88366_95823# adc8b_0.sar12b_0.sg13cmos5l_dfrbp_1_8.RESET_B sg13cmos5l_Corner_1.vss sg13cmos5l_Corner_1.vss sg13_lv_nmos ad=37.8f pd=0.6u as=0.1701p ps=1.65u w=0.42u l=0.13u
M1115 sg13cmos5l_Corner_1.vss adc8b_0.sar12b_0.nh_sw[2] adc8b_0.side_cap8b_1.buf_16_0.z sg13cmos5l_Corner_1.vss sg13_lv_nmos ad=95f pd=0.88u as=95f ps=0.88u w=0.5u l=0.13u
M1116 adc8b_0.side_cap8b_0.buf_8_3.z adc8b_0.side_cap8b_0.in_h_sw[3] vddr vddr sg13_lv_pmos ad=0.19p pd=1.38u as=0.19p ps=1.38u w=1u l=0.13u
M1117 vdd a_100131_95430# adc8b_0.sar12b_0.sg13cmos5l_or2_1_0.A vdd sg13_lv_pmos ad=0.2128p pd=1.5u as=0.2128p ps=1.5u w=1.12u l=0.13u
M1118 sg13cmos5l_Corner_1.iovdd a_70044_42476# data[0] sg13cmos5l_Corner_1.iovdd sg13_hv_pmos ad=2.1312p pd=7.3u as=3.9294p ps=7.84u w=6.66u l=0.6u
M1119 adc8b_0.side_cap8b_1.buf_32_1.z adc8b_0.sar12b_0.nh_sw[0] sg13cmos5l_Corner_1.vss sg13cmos5l_Corner_1.vss sg13_lv_nmos ad=95f pd=0.88u as=95f ps=0.88u w=0.5u l=0.13u
M1120 a_88449_93671# a_87507_93559# a_88247_93909# vdd sg13_lv_pmos ad=93.45f pd=0.865u as=0.2048p ps=1.63u w=0.42u l=0.13u
M1121 sg13cmos5l_Corner_1.vss a_99729_99953# a_100254_100026# sg13cmos5l_Corner_1.vss sg13_lv_nmos ad=0.1491p pd=1.18u as=0.187p ps=1.78u w=0.55u l=0.13u
M1122 vdd a_89457_92786# a_89982_92768# vdd sg13_lv_pmos ad=0.1974p pd=1.5u as=0.2856p ps=2.36u w=0.84u l=0.13u
M1123 sg13cmos5l_Corner_1.iovdd a_42476_86044# vin sg13cmos5l_Corner_1.iovdd sg13_hv_pmos ad=2.1312p pd=7.3u as=3.9294p ps=7.84u w=6.66u l=0.6u
M1124 adc8b_0.sar12b_0.sg13cmos5l_buf_1_78.X a_87952_100384# vdd vdd sg13_lv_pmos ad=0.42p pd=2.99u as=0.2114p ps=1.54u w=1.12u l=0.13u
M1125 sg13cmos5l_Corner_1.vss a_102260_99560# adc8b_0.side_cap8b_0.in_l_sw[10] sg13cmos5l_Corner_1.vss sg13_lv_nmos ad=0.14875p pd=1.16u as=0.2886p ps=2.26u w=0.74u l=0.13u
M1126 vdd sg13cmos5l_Corner_1.vss vdd vdd sg13_lv_pmos ad=0.34p pd=2.68u as=0 ps=0 w=1u l=1u
M1127 a_74586_95659# adc8b_0.cmp_0.clk sg13cmos5l_Corner_1.vss sg13cmos5l_Corner_1.vss sg13_lv_nmos ad=0.17p pd=1.68u as=95f ps=0.88u w=0.5u l=0.13u
M1128 a_86847_94314# adc8b_0.sar12b_0.sg13cmos5l_dfrbp_1_9.Q sg13cmos5l_Corner_1.vss sg13cmos5l_Corner_1.vss sg13_lv_nmos ad=0.2516p pd=2.16u as=0.15055p ps=1.17u w=0.74u l=0.13u
M1129 vddr adc8b_0.sar12b_0.nl_sw[6] adc8b_0.side_cap8b_1.buf_4_3.z vddr sg13_lv_pmos ad=0.19p pd=1.38u as=0.19p ps=1.38u w=1u l=0.13u
M1130 vdd sg13cmos5l_IOPadVdd$1_0.sg13cmos5l_Clamp_N43N43D4R$1_0.gate sg13cmos5l_Corner_1.vss sg13cmos5l_Corner_1.vss sg13_hv_nmos ad=2.596p pd=5.58u as=1.408p ps=5.04u w=4.4u l=0.6u
M1131 sg13cmos5l_Corner_1.vss adc8b_0.sar12b_0.sg13cmos5l_dfrbp_1_15.D a_84389_98796# sg13cmos5l_Corner_1.vss sg13_lv_nmos ad=0.15055p pd=1.17u as=0.2516p ps=2.16u w=0.74u l=0.13u
M1132 sg13cmos5l_Corner_1.iovdd a_164624_118044# sg13cmos5l_IOPadAnalog_11.pad sg13cmos5l_Corner_1.iovdd sg13_hv_pmos ad=2.1312p pd=7.3u as=3.9294p ps=7.84u w=6.66u l=0.6u
M1133 sg13cmos5l_Corner_1.vss sg13cmos5l_IOPadVdd$1_0.sg13cmos5l_Clamp_N43N43D4R$1_0.gate vdd sg13cmos5l_Corner_1.vss sg13_hv_nmos ad=1.408p pd=5.04u as=2.596p ps=5.58u w=4.4u l=0.6u
M1134 adc8b_0.sar12b_0.sg13cmos5l_dlhr_1_12.Q_N a_100254_100026# sg13cmos5l_Corner_1.vss sg13cmos5l_Corner_1.vss sg13_lv_nmos ad=0.2516p pd=2.16u as=0.1491p ps=1.18u w=0.74u l=0.13u
M1135 sg13cmos5l_Corner_1.vss adc8b_0.sar12b_0.sg13cmos5l_dfrbp_1_6.RESET_B a_96892_98472# sg13cmos5l_Corner_1.vss sg13_lv_nmos ad=0.1406p pd=1.12u as=77.7f ps=0.95u w=0.74u l=0.13u
M1136 a_87276_97322# adc8b_0.sar12b_0.sg13cmos5l_dfrbp_1_6.D a_87182_97322# sg13cmos5l_Corner_1.vss sg13_lv_nmos ad=60.89999f pd=0.71u as=0.1428p ps=1.52u w=0.42u l=0.13u
M1137 a_93038_95498# adc8b_0.sar12b_0.sg13cmos5l_dfrbp_1_2.D vdd vdd sg13_lv_pmos ad=79.8f pd=0.8u as=0.1428p ps=1.52u w=0.42u l=0.13u
M1138 a_96582_95452# adc8b_0.sar12b_0.sg13cmos5l_nand2_1_1.B sg13cmos5l_Corner_1.vss sg13cmos5l_Corner_1.vss sg13_lv_nmos ad=96.2f pd=1u as=0.2516p ps=2.16u w=0.74u l=0.13u
M1139 sg13cmos5l_Corner_1.vss a_178296_86044# sg13cmos5l_IOPadAnalog_0.pad sg13cmos5l_Corner_1.vss sg13_hv_nmos ad=1.408p pd=5.04u as=2.596p ps=5.58u w=4.4u l=0.6u
M1140 vdd sg13cmos5l_IOPadVdd$1_0.sg13cmos5l_Clamp_N43N43D4R$1_0.gate sg13cmos5l_Corner_1.vss sg13cmos5l_Corner_1.vss sg13_hv_nmos ad=2.596p pd=5.58u as=1.408p ps=5.04u w=4.4u l=0.6u
M1141 a_89272_99838# adc8b_0.sar12b_0.sg13cmos5l_dfrbp_1_8.RESET_B vdd vdd sg13_lv_pmos ad=79.8f pd=0.8u as=1.12242p ps=7u w=0.42u l=0.13u
M1142 sg13cmos5l_Corner_1.iovdd a_67639_164698# sg13cmos5l_IOPadAnalog_10.pad sg13cmos5l_Corner_1.iovdd sg13_hv_pmos ad=2.1312p pd=7.3u as=3.9294p ps=7.84u w=6.66u l=0.6u
M1143 vdd a_90609_96929# a_90542_96572# vdd sg13_lv_pmos ad=0.2387p pd=1.84u as=0.1008p ps=0.9u w=0.42u l=0.13u
M1144 adc8b_0.side_cap8b_1.buf_32_0.z adc8b_0.sar12b_0.nl_sw[0] vddr vddr sg13_lv_pmos ad=0.19p pd=1.38u as=0.19p ps=1.38u w=1u l=0.13u
M1145 vdd adc8b_0.sar12b_0.sg13cmos5l_buf_1_3.X a_102160_94336# vdd sg13_lv_pmos ad=0.2114p pd=1.54u as=0.2856p ps=2.36u w=0.84u l=0.13u
M1146 sg13cmos5l_Corner_1.vss a_99639_178370# sg13cmos5l_IOPadAnalog_15.pad sg13cmos5l_Corner_1.vss sg13_hv_nmos ad=1.408p pd=5.04u as=2.596p ps=5.58u w=4.4u l=0.6u
M1147 adc8b_0.side_cap8b_1.buf_2_1.z adc8b_0.sar12b_0.nl_sw[8] sg13cmos5l_Corner_1.vss sg13cmos5l_Corner_1.vss sg13_lv_nmos ad=0.17p pd=1.68u as=95f ps=0.88u w=0.5u l=0.13u
M1148 vddr adc8b_0.sar12b_0.nh_sw[2] adc8b_0.side_cap8b_1.buf_16_0.z vddr sg13_lv_pmos ad=0.19p pd=1.38u as=0.19p ps=1.38u w=1u l=0.13u
M1149 a_92494_96920# adc8b_0.sar12b_0.sg13cmos5l_dfrbp_1_20.Q adc8b_0.sar12b_0.sg13cmos5l_a22oi_1_2.B2 sg13cmos5l_Corner_1.vss sg13_lv_nmos ad=0.1406p pd=1.12u as=0.2516p ps=2.16u w=0.74u l=0.13u
M1150 a_85809_93905# a_85628_93548# vdd vdd sg13_lv_pmos ad=0.2128p pd=1.5u as=0.2387p ps=1.84u w=1.12u l=0.13u
M1151 adc8b_0.side_cap8b_0.buf_16_0.z adc8b_0.side_cap8b_0.in_h_sw[2] sg13cmos5l_Corner_1.vss sg13cmos5l_Corner_1.vss sg13_lv_nmos ad=95f pd=0.88u as=95f ps=0.88u w=0.5u l=0.13u
M1152 vdd sg13cmos5l_Corner_1.vss vdd vdd sg13_lv_pmos ad=0.19p pd=1.38u as=0 ps=0 w=1u l=1u
M1153 cko a_118044_42476# sg13cmos5l_Corner_1.iovdd sg13cmos5l_Corner_1.iovdd sg13_hv_pmos ad=3.9294p pd=7.84u as=2.1312p ps=7.3u w=6.66u l=0.6u
M1154 sg13cmos5l_Corner_1.vss adc8b_0.sar12b_0.sg13cmos5l_dfrbp_1_1.Q a_102160_93548# sg13cmos5l_Corner_1.vss sg13_lv_nmos ad=0.14875p pd=1.16u as=0.187p ps=1.78u w=0.55u l=0.13u
M1155 sg13cmos5l_IOPadVdd$1_0.sg13cmos5l_Clamp_N43N43D4R$1_0.gate sg13cmos5l_IOPadVdd$1_0.sg13cmos5l_RCClampInverter$1_0.in vdd vdd sg13_hv_pmos ad=1.33p pd=7.38u as=1.33p ps=7.38u w=7u l=0.5u
M1156 a_95002_95498# adc8b_0.sar12b_0.sg13cmos5l_dfrbp_1_0.RESET_B sg13cmos5l_Corner_1.vss sg13cmos5l_Corner_1.vss sg13_lv_nmos ad=37.8f pd=0.6u as=79.8f ps=0.8u w=0.42u l=0.13u
M1157 vddr adc8b_0.sar12b_0.nl_sw[4] adc8b_0.side_cap8b_1.buf_8_0.z vddr sg13_lv_pmos ad=0.19p pd=1.38u as=0.19p ps=1.38u w=1u l=0.13u
M1158 vdd sg13cmos5l_IOPadVdd$1_0.sg13cmos5l_Clamp_N43N43D4R$1_0.gate sg13cmos5l_Corner_1.vss sg13cmos5l_Corner_1.vss sg13_hv_nmos ad=2.596p pd=5.58u as=1.408p ps=5.04u w=4.4u l=0.6u
M1159 a_82893_98095# adc8b_0.sar12b_0.sg13cmos5l_dfrbp_1_15.D vdd vdd sg13_lv_pmos ad=0.4088p pd=2.97u as=1.04815p ps=6.595u w=1.12u l=0.13u
M1160 a_92252_98084# a_91839_98442# a_92184_98084# vdd sg13_lv_pmos ad=0.191p pd=1.44u as=0.105p ps=1.21u w=1u l=0.13u
M1161 sg13cmos5l_Corner_1.vss a_92840_96507# adc8b_0.sar12b_0.sg13cmos5l_a221oi_1_1.C1 sg13cmos5l_Corner_1.vss sg13_lv_nmos ad=0.1371p pd=1.12u as=0.2516p ps=2.16u w=0.74u l=0.13u
M1162 vdd adc8b_0.sar12b_0.sg13cmos5l_dfrbp_1_8.RESET_B a_85070_95810# vdd sg13_lv_pmos ad=0.36237p pd=2.605u as=79.8f ps=0.8u w=0.42u l=0.13u
M1163 adc8b_0.side_cap8b_1.buf_32_0.z adc8b_0.sar12b_0.nl_sw[0] vddr vddr sg13_lv_pmos ad=0.19p pd=1.38u as=0.19p ps=1.38u w=1u l=0.13u
M1164 a_87981_95071# adc8b_0.sar12b_0.sg13cmos5l_dfrbp_1_11.Q vdd vdd sg13_lv_pmos ad=0.4088p pd=2.97u as=1.43437p ps=9.105u w=1.12u l=0.13u
M1165 data[2] a_102044_30676# sg13cmos5l_Corner_1.vss sg13cmos5l_Corner_1.vss sg13_hv_nmos ad=2.596p pd=5.58u as=2.068p ps=9.74u w=4.4u l=0.6u
M1166 adc8b_0.side_cap8b_0.buf_32_0.z adc8b_0.side_cap8b_0.in_l_sw[0] sg13cmos5l_Corner_1.vss sg13cmos5l_Corner_1.vss sg13_lv_nmos ad=95f pd=0.88u as=95f ps=0.88u w=0.5u l=0.13u
M1167 sg13cmos5l_Corner_1.vss adc8b_0.side_cap8b_0.in_l_sw[4] adc8b_0.side_cap8b_0.buf_8_0.z sg13cmos5l_Corner_1.vss sg13_lv_nmos ad=95f pd=0.88u as=95f ps=0.88u w=0.5u l=0.13u
M1168 adc8b_0.side_cap8b_0.in_h_sw[1] a_83632_100384# vdd vdd sg13_lv_pmos ad=0.42p pd=2.99u as=0.2114p ps=1.54u w=1.12u l=0.13u
M1169 sg13cmos5l_Corner_1.vss a_99544_97542# a_99193_97399# sg13cmos5l_Corner_1.vss sg13_lv_nmos ad=79.8f pd=0.8u as=0.1428p ps=1.52u w=0.42u l=0.13u
M1170 adc8b_0.side_cap8b_1.buf_8_1.z adc8b_0.sar12b_0.nl_sw[3] sg13cmos5l_Corner_1.vss sg13cmos5l_Corner_1.vss sg13_lv_nmos ad=0.17p pd=1.68u as=95f ps=0.88u w=0.5u l=0.13u
M1171 vddr adc8b_0.side_cap8b_0.in_h_sw[4] adc8b_0.side_cap8b_0.buf_8_2.z vddr sg13_lv_pmos ad=0.19p pd=1.38u as=0.19p ps=1.38u w=1u l=0.13u
M1172 a_93539_96572# adc8b_0.sar12b_0.sg13cmos5l_nor2b_1_0.Y adc8b_0.sar12b_0.sg13cmos5l_a221oi_1_0.B2 vdd sg13_lv_pmos ad=0.2128p pd=1.5u as=0.3808p ps=2.92u w=1.12u l=0.13u
M1173 a_95340_94311# a_95052_94616# a_95278_94311# sg13cmos5l_Corner_1.vss sg13_lv_nmos ad=0.1428p pd=1.52u as=37.8f ps=0.6u w=0.42u l=0.13u
M1174 a_86282_98826# a_86092_99156# a_85844_98784# sg13cmos5l_Corner_1.vss sg13_lv_nmos ad=71.99999f pd=0.865u as=0.141p ps=1.17u w=0.64u l=0.13u
M1175 vip a_72090_98590# adc8b_0.diff_bsw_0.vcp sg13cmos5l_Corner_1.vss sg13_lv_nmos ad=0.85p pd=5.68u as=0.85p ps=5.68u w=2.5u l=0.13u
M1176 sg13cmos5l_Corner_1.vss a_178296_70044# sg13cmos5l_IOPadAnalog_1.pad sg13cmos5l_Corner_1.vss sg13_hv_nmos ad=1.408p pd=5.04u as=2.596p ps=5.58u w=4.4u l=0.6u
M1177 a_93324_93104# a_93298_93009# vdd vdd sg13_lv_pmos ad=0.34p pd=2.68u as=0.36237p ps=2.605u w=1u l=0.13u
M1178 vddr adc8b_0.side_cap8b_0.in_l_sw[1] adc8b_0.side_cap8b_0.buf_16_2.z vddr sg13_lv_pmos ad=0.19p pd=1.38u as=0.19p ps=1.38u w=1u l=0.13u
M1179 sg13cmos5l_Corner_1.vss a_93335_98911# a_94172_99132# sg13cmos5l_Corner_1.vss sg13_lv_nmos ad=0.1406p pd=1.12u as=0.2516p ps=2.16u w=0.74u l=0.13u
M1180 vdd a_83646_97497# adc8b_0.sar12b_0.sg13cmos5l_dlhr_1_1.GATE vdd sg13_lv_pmos ad=0.2128p pd=1.5u as=0.3808p ps=2.92u w=1.12u l=0.13u
M1181 a_98036_94262# adc8b_0.sar12b_0.sg13cmos5l_buf_1_2.X vdd vdd sg13_lv_pmos ad=0.2856p pd=2.36u as=0.2114p ps=1.54u w=0.84u l=0.13u
M1182 vddr adc8b_0.side_cap8b_0.in_h_sw[2] adc8b_0.side_cap8b_0.buf_16_0.z vddr sg13_lv_pmos ad=0.19p pd=1.38u as=0.19p ps=1.38u w=1u l=0.13u
M1183 a_87372_95498# adc8b_0.sar12b_0.sg13cmos5l_dfrbp_1_6.D a_87278_95498# sg13cmos5l_Corner_1.vss sg13_lv_nmos ad=60.89999f pd=0.71u as=0.1428p ps=1.52u w=0.42u l=0.13u
M1184 sg13cmos5l_Corner_1.vss sg13cmos5l_IOPadVdd$1_0.sg13cmos5l_Clamp_N43N43D4R$1_0.gate vdd sg13cmos5l_Corner_1.vss sg13_hv_nmos ad=1.408p pd=5.04u as=2.596p ps=5.58u w=4.4u l=0.6u
M1185 sg13cmos5l_Corner_1.vss a_86044_30676# data[1] sg13cmos5l_Corner_1.vss sg13_hv_nmos ad=1.408p pd=5.04u as=2.596p ps=5.58u w=4.4u l=0.6u
M1186 sg13cmos5l_Corner_1.iovdd a_102044_42476# data[2] sg13cmos5l_Corner_1.iovdd sg13_hv_pmos ad=2.1312p pd=7.3u as=3.9294p ps=7.84u w=6.66u l=0.6u
M1187 a_98124_98509# a_98355_98095# a_97810_98052# sg13cmos5l_Corner_1.vss sg13_lv_nmos ad=0.2373p pd=1.97u as=79.8f ps=0.8u w=0.42u l=0.13u
M1188 sg13cmos5l_Corner_1.vss sg13cmos5l_IOPadVdd$1_0.sg13cmos5l_Clamp_N43N43D4R$1_0.gate vdd sg13cmos5l_Corner_1.vss sg13_hv_nmos ad=2.068p pd=9.74u as=2.596p ps=5.58u w=4.4u l=0.6u
M1189 sg13cmos5l_Corner_1.vss vdd sg13cmos5l_Corner_1.vss sg13cmos5l_Corner_1.vss sg13_lv_nmos ad=79.8f pd=0.8u as=0 ps=0 w=0.42u l=1u
M1190 adc8b_0.sar12b_0.sg13cmos5l_dlhr_1_10.Q_N a_101886_97304# sg13cmos5l_Corner_1.vss sg13cmos5l_Corner_1.vss sg13_lv_nmos ad=0.2516p pd=2.16u as=0.1491p ps=1.18u w=0.74u l=0.13u
M1191 adc8b_0.sar12b_0.sg13cmos5l_dfrbp_1_2.Q_N a_94583_95421# vdd vdd sg13_lv_pmos ad=0.4312p pd=3.01u as=0.2639p ps=1.81u w=1.12u l=0.13u
M1192 sg13cmos5l_IOPadVdd$1_0.sg13cmos5l_Clamp_N43N43D4R$1_0.gate sg13cmos5l_IOPadVdd$1_0.sg13cmos5l_RCClampInverter$1_0.in vdd vdd sg13_hv_pmos ad=1.33p pd=7.38u as=1.33p ps=7.38u w=7u l=0.5u
M1193 sg13cmos5l_Corner_1.iovdd a_42476_102044# vip sg13cmos5l_Corner_1.iovdd sg13_hv_pmos ad=2.1312p pd=7.3u as=3.9294p ps=7.84u w=6.66u l=0.6u
M1194 a_97550_98522# adc8b_0.sar12b_0.sg13cmos5l_dfrbp_1_22.D vdd vdd sg13_lv_pmos ad=79.8f pd=0.8u as=0.1428p ps=1.52u w=0.42u l=0.13u
M1195 a_86837_96536# a_87567_96659# a_87588_96933# sg13cmos5l_Corner_1.vss sg13_lv_nmos ad=0.12665p pd=1.145u as=0.3473p ps=2.71u w=0.74u l=0.13u
M1196 a_83724_95498# adc8b_0.sar12b_0.sg13cmos5l_dlhr_1_1.GATE a_83630_95498# sg13cmos5l_Corner_1.vss sg13_lv_nmos ad=60.89999f pd=0.71u as=0.1428p ps=1.52u w=0.42u l=0.13u
M1197 sg13cmos5l_Corner_1.vss adc8b_0.sar12b_0.nl_sw[2] adc8b_0.side_cap8b_1.buf_16_1.z sg13cmos5l_Corner_1.vss sg13_lv_nmos ad=95f pd=0.88u as=95f ps=0.88u w=0.5u l=0.13u
M1198 adc8b_0.sar12b_0.sg13cmos5l_buf_1_28.X a_91216_92824# vdd vdd sg13_lv_pmos ad=0.42p pd=2.99u as=0.2114p ps=1.54u w=1.12u l=0.13u
M1199 sg13cmos5l_IOPadVdd$1_0.sg13cmos5l_Clamp_N43N43D4R$1_0.gate sg13cmos5l_IOPadVdd$1_0.sg13cmos5l_RCClampInverter$1_0.in vdd vdd sg13_hv_pmos ad=1.33p pd=7.38u as=1.33p ps=7.38u w=7u l=0.5u
M1200 adc8b_0.sar12b_0.sg13cmos5l_a22oi_1_0.B1 adc8b_0.sar12b_0.sg13cmos5l_nor2_1_0.A a_92386_94302# sg13cmos5l_Corner_1.vss sg13_lv_nmos ad=0.2516p pd=2.16u as=0.1406p ps=1.12u w=0.74u l=0.13u
M1201 sg13cmos5l_Corner_1.vss adc8b_0.sar12b_0.sg13cmos5l_dfrbp_1_6.RESET_B a_82284_98522# sg13cmos5l_Corner_1.vss sg13_lv_nmos ad=0.1626p pd=1.415u as=60.89999f ps=0.71u w=0.42u l=0.13u
M1202 sg13cmos5l_IOPadAnalog_1.pad a_164624_70044# sg13cmos5l_Corner_1.iovdd sg13cmos5l_Corner_1.iovdd sg13_hv_pmos ad=3.9294p pd=7.84u as=2.1312p ps=7.3u w=6.66u l=0.6u
M1203 adc8b_0.side_cap8b_1.buf_16_3.z adc8b_0.sar12b_0.nh_sw[1] sg13cmos5l_Corner_1.vss sg13cmos5l_Corner_1.vss sg13_lv_nmos ad=95f pd=0.88u as=95f ps=0.88u w=0.5u l=0.13u
M1204 sg13cmos5l_Corner_1.vss a_67639_178370# sg13cmos5l_IOPadAnalog_10.pad sg13cmos5l_Corner_1.vss sg13_hv_nmos ad=1.408p pd=5.04u as=2.596p ps=5.58u w=4.4u l=0.6u
M1205 sg13cmos5l_Corner_1.vss adc8b_0.sar12b_0.sg13cmos5l_buf_1_34.X adc8b_0.sar12b_0.sg13cmos5l_buf_1_60.A sg13cmos5l_Corner_1.vss sg13_lv_nmos ad=0.2516p pd=2.16u as=0.2516p ps=2.16u w=0.74u l=0.13u
M1206 a_87921_95107# a_87564_95064# vdd vdd sg13_lv_pmos ad=63f pd=0.72u as=0.1563p ps=1.22u w=0.42u l=0.13u
M1207 vddr adc8b_0.sar12b_0.nh_sw[7] adc8b_0.side_cap8b_1.buf_4_2.z vddr sg13_lv_pmos ad=0.19p pd=1.38u as=0.34p ps=2.68u w=1u l=0.13u
M1208 sg13cmos5l_Corner_1.vss adc8b_0.sar12b_0.nl_sw[0] adc8b_0.side_cap8b_1.buf_32_0.z sg13cmos5l_Corner_1.vss sg13_lv_nmos ad=95f pd=0.88u as=95f ps=0.88u w=0.5u l=0.13u
M1209 vddr adc8b_0.side_cap8b_0.in_l_sw[6] adc8b_0.side_cap8b_0.buf_4_3.z vddr sg13_lv_pmos ad=0.19p pd=1.38u as=0.19p ps=1.38u w=1u l=0.13u
M1210 adc8b_0.side_cap8b_0.buf_2_3.z adc8b_0.side_cap8b_0.in_h_sw[9] sg13cmos5l_Corner_1.vss sg13cmos5l_Corner_1.vss sg13_lv_nmos ad=0.17p pd=1.68u as=95f ps=0.88u w=0.5u l=0.13u
M1211 vdd a_89265_94298# a_89790_94280# vdd sg13_lv_pmos ad=0.1974p pd=1.5u as=0.2856p ps=2.36u w=0.84u l=0.13u
M1212 sg13cmos5l_Corner_1.vss a_92056_99838# a_91705_99957# sg13cmos5l_Corner_1.vss sg13_lv_nmos ad=79.8f pd=0.8u as=0.1428p ps=1.52u w=0.42u l=0.13u
M1213 data[2] a_102044_42476# sg13cmos5l_Corner_1.iovdd sg13cmos5l_Corner_1.iovdd sg13_hv_pmos ad=3.9294p pd=7.84u as=2.1312p ps=7.3u w=6.66u l=0.6u
M1214 vdd a_100984_94518# a_100929_94613# vdd sg13_lv_pmos ad=1.43437p pd=9.105u as=93.45f ps=0.865u w=0.42u l=0.13u
M1215 adc8b_0.side_cap8b_1.buf_8_2.z adc8b_0.sar12b_0.nh_sw[4] sg13cmos5l_Corner_1.vss sg13cmos5l_Corner_1.vss sg13_lv_nmos ad=95f pd=0.88u as=95f ps=0.88u w=0.5u l=0.13u
M1216 sg13cmos5l_Corner_1.iovdd a_42476_86044# vin sg13cmos5l_Corner_1.iovdd sg13_hv_pmos ad=2.1312p pd=7.3u as=3.9294p ps=7.84u w=6.66u l=0.6u
M1217 vdd sg13cmos5l_IOPadVdd$1_0.sg13cmos5l_Clamp_N43N43D4R$1_0.gate sg13cmos5l_Corner_1.vss sg13cmos5l_Corner_1.vss sg13_hv_nmos ad=2.596p pd=5.58u as=1.408p ps=5.04u w=4.4u l=0.6u
M1218 vdd a_95543_97399# a_96380_97620# vdd sg13_lv_pmos ad=0.2128p pd=1.5u as=0.3864p ps=2.93u w=1.12u l=0.13u
M1219 a_85343_97713# a_84647_97592# a_85437_97480# sg13cmos5l_Corner_1.vss sg13_lv_nmos ad=0.1296p pd=1.52u as=79.8f ps=0.8u w=0.42u l=0.13u
M1220 sg13cmos5l_Corner_1.vss adc8b_0.sar12b_0.nl_sw[7] adc8b_0.side_cap8b_1.buf_4_0.z sg13cmos5l_Corner_1.vss sg13_lv_nmos ad=95f pd=0.88u as=0.17p ps=1.68u w=0.5u l=0.13u
M1221 sg13cmos5l_Corner_1.vss adc8b_0.sar12b_0.nh_sw[0] adc8b_0.side_cap8b_1.buf_32_1.z sg13cmos5l_Corner_1.vss sg13_lv_nmos ad=95f pd=0.88u as=95f ps=0.88u w=0.5u l=0.13u
M1222 sg13cmos5l_IOPadVdd$1_0.sg13cmos5l_Clamp_N43N43D4R$1_0.gate sg13cmos5l_IOPadVdd$1_0.sg13cmos5l_RCClampInverter$1_0.in vdd vdd sg13_hv_pmos ad=1.33p pd=7.38u as=1.33p ps=7.38u w=7u l=0.5u
M1223 vdd adc8b_0.sar12b_0.sg13cmos5l_nand2_1_1.A a_101776_95060# vdd sg13_lv_pmos ad=0.2114p pd=1.54u as=0.2856p ps=2.36u w=0.84u l=0.13u
M1224 frame a_134044_30676# sg13cmos5l_Corner_1.vss sg13cmos5l_Corner_1.vss sg13_hv_nmos ad=2.596p pd=5.58u as=1.408p ps=5.04u w=4.4u l=0.6u
M1225 adc8b_0.side_cap8b_1.buf_8_5.z adc8b_0.sar12b_0.nh_sw[5] vddr vddr sg13_lv_pmos ad=0.19p pd=1.38u as=0.19p ps=1.38u w=1u l=0.13u
M1226 adc8b_0.side_cap8b_0.buf_16_3.z adc8b_0.side_cap8b_0.in_h_sw[1] sg13cmos5l_Corner_1.vss sg13cmos5l_Corner_1.vss sg13_lv_nmos ad=95f pd=0.88u as=95f ps=0.88u w=0.5u l=0.13u
M1227 adc8b_0.side_cap8b_0.buf_4_2.z adc8b_0.side_cap8b_0.in_h_sw[7] vddr vddr sg13_lv_pmos ad=0.19p pd=1.38u as=0.19p ps=1.38u w=1u l=0.13u
M1228 vdd adc8b_0.sar12b_0.sg13cmos5l_nor2_1_0.A adc8b_0.sar12b_0.sg13cmos5l_a22oi_1_0.B1 vdd sg13_lv_pmos ad=0.3808p pd=2.92u as=0.2128p ps=1.5u w=1.12u l=0.13u
M1229 adc8b_0.side_cap8b_0.buf_16_3.z adc8b_0.side_cap8b_0.in_h_sw[1] vddr vddr sg13_lv_pmos ad=0.19p pd=1.38u as=0.19p ps=1.38u w=1u l=0.13u
M1230 adc8b_0.sar12b_0.sg13cmos5l_dfrbp_1_6.RESET_B cks sg13cmos5l_Corner_1.vss sg13cmos5l_Corner_1.vss sg13_lv_nmos ad=0.1406p pd=1.12u as=0.2516p ps=2.16u w=0.74u l=0.13u
M1231 a_96476_98084# a_96194_98448# a_96409_98486# sg13cmos5l_Corner_1.vss sg13_lv_nmos ad=0.141p pd=1.17u as=71.99999f ps=0.865u w=0.64u l=0.13u
M1232 sg13cmos5l_Corner_1.vss a_94335_98442# a_94466_98448# sg13cmos5l_Corner_1.vss sg13_lv_nmos ad=1.49685p pd=9.6u as=0.2775p ps=2.23u w=0.74u l=0.13u
M1233 sg13cmos5l_IOPadAnalog_16.pad a_164624_102044# sg13cmos5l_Corner_1.iovdd sg13cmos5l_Corner_1.iovdd sg13_hv_pmos ad=3.9294p pd=7.84u as=2.1312p ps=7.3u w=6.66u l=0.6u
M1234 vdd a_92232_93587# adc8b_0.sar12b_0.sg13cmos5l_dfrbp_1_4.D vdd sg13_lv_pmos ad=0.3808p pd=2.92u as=0.2408p ps=1.55u w=1.12u l=0.13u
M1235 sg13cmos5l_Corner_1.vss a_93984_96888# adc8b_0.sar12b_0.sg13cmos5l_a221oi_1_0.B1 sg13cmos5l_Corner_1.vss sg13_lv_nmos ad=0.1469p pd=1.155u as=0.2516p ps=2.16u w=0.74u l=0.13u
M1236 adc8b_0.side_cap8b_1.buf_8_4.z adc8b_0.sar12b_0.nl_sw[5] sg13cmos5l_Corner_1.vss sg13cmos5l_Corner_1.vss sg13_lv_nmos ad=95f pd=0.88u as=95f ps=0.88u w=0.5u l=0.13u
M1237 adc8b_0.side_cap8b_1.buf_16_0.z adc8b_0.sar12b_0.nh_sw[2] vddr vddr sg13_lv_pmos ad=0.19p pd=1.38u as=0.19p ps=1.38u w=1u l=0.13u
M1238 sg13cmos5l_Corner_1.vss sg13cmos5l_IOPadVdd$1_0.sg13cmos5l_Clamp_N43N43D4R$1_0.gate vdd sg13cmos5l_Corner_1.vss sg13_hv_nmos ad=1.408p pd=5.04u as=2.596p ps=5.58u w=4.4u l=0.6u
M1239 adc8b_0.side_cap8b_0.buf_8_1.z adc8b_0.side_cap8b_0.in_l_sw[3] vddr vddr sg13_lv_pmos ad=0.19p pd=1.38u as=0.19p ps=1.38u w=1u l=0.13u
M1240 sg13cmos5l_Corner_1.vss adc8b_0.sar12b_0.sg13cmos5l_dfrbp_1_6.RESET_B a_86044_93936# sg13cmos5l_Corner_1.vss sg13_lv_nmos ad=0.1406p pd=1.12u as=77.7f ps=0.95u w=0.74u l=0.13u
M1241 adc8b_0.sar12b_0.sg13cmos5l_buf_1_4.A a_97360_97360# sg13cmos5l_Corner_1.vss sg13cmos5l_Corner_1.vss sg13_lv_nmos ad=0.2886p pd=2.26u as=0.14875p ps=1.16u w=0.74u l=0.13u
M1242 sg13cmos5l_Corner_1.vss adc8b_0.sar12b_0.sg13cmos5l_buf_1_77.X a_89104_100384# sg13cmos5l_Corner_1.vss sg13_lv_nmos ad=0.14875p pd=1.16u as=0.187p ps=1.78u w=0.55u l=0.13u
M1243 sg13cmos5l_Corner_1.vss a_118044_30676# cko sg13cmos5l_Corner_1.vss sg13_hv_nmos ad=1.408p pd=5.04u as=2.596p ps=5.58u w=4.4u l=0.6u
M1244 sg13cmos5l_Corner_1.iovdd a_164624_86044# sg13cmos5l_IOPadAnalog_0.pad sg13cmos5l_Corner_1.iovdd sg13_hv_pmos ad=2.1312p pd=7.3u as=3.9294p ps=7.84u w=6.66u l=0.6u
X1245 sg13cmos5l_Corner_1.vss a_152182_76462# dantenna l=0.64u w=3.1u
M1246 sg13cmos5l_Corner_1.vss adc8b_0.sar12b_0.sg13cmos5l_buf_1_4.A adc8b_0.sar12b_0.sg13cmos5l_buf_1_110.A sg13cmos5l_Corner_1.vss sg13_lv_nmos ad=0.2516p pd=2.16u as=0.2516p ps=2.16u w=0.74u l=0.13u
M1247 sg13cmos5l_Corner_1.vss a_85773_95789# a_85875_95932# sg13cmos5l_Corner_1.vss sg13_lv_nmos ad=2.41737p pd=15.64u as=0.2516p ps=2.16u w=0.74u l=0.13u
M1248 sg13cmos5l_Corner_1.iovdd a_118044_42476# cko sg13cmos5l_Corner_1.iovdd sg13_hv_pmos ad=2.1312p pd=7.3u as=3.9294p ps=7.84u w=6.66u l=0.6u
M1249 vddr adc8b_0.sar12b_0.nl_sw[0] adc8b_0.side_cap8b_1.buf_32_0.z vddr sg13_lv_pmos ad=0.19p pd=1.38u as=0.34p ps=2.68u w=1u l=0.13u
M1250 sg13cmos5l_IOPadVdd$1_0.sg13cmos5l_Clamp_N43N43D4R$1_0.gate sg13cmos5l_IOPadVdd$1_0.sg13cmos5l_RCClampInverter$1_0.in vdd vdd sg13_hv_pmos ad=1.33p pd=7.38u as=1.33p ps=7.38u w=7u l=0.5u
M1251 sg13cmos5l_Corner_1.vss a_90015_96930# a_90146_96936# sg13cmos5l_Corner_1.vss sg13_lv_nmos ad=1.97045p pd=12.335u as=0.2775p ps=2.23u w=0.74u l=0.13u
M1252 data[2] a_102044_42476# sg13cmos5l_Corner_1.iovdd sg13cmos5l_Corner_1.iovdd sg13_hv_pmos ad=3.9294p pd=7.84u as=2.1312p ps=7.3u w=6.66u l=0.6u
M1253 sg13cmos5l_Corner_1.vss adc8b_0.side_cap8b_0.in_l_sw[0] adc8b_0.side_cap8b_0.buf_32_0.z sg13cmos5l_Corner_1.vss sg13_lv_nmos ad=95f pd=0.88u as=95f ps=0.88u w=0.5u l=0.13u
M1254 a_84177_95810# a_83996_96132# vdd vdd sg13_lv_pmos ad=0.2128p pd=1.5u as=0.2387p ps=1.84u w=1.12u l=0.13u
M1255 sg13cmos5l_Corner_1.vss a_100131_95430# adc8b_0.sar12b_0.sg13cmos5l_or2_1_0.A sg13cmos5l_Corner_1.vss sg13_lv_nmos ad=0.1406p pd=1.12u as=0.1406p ps=1.12u w=0.74u l=0.13u
X1256 a_36456_140035# a_40542_140365# sg13cmos5l_Corner_1.vss rppd l=20u w=1u
M1257 adc8b_0.side_cap8b_0.buf_32_0.z adc8b_0.side_cap8b_0.in_l_sw[0] sg13cmos5l_Corner_1.vss sg13cmos5l_Corner_1.vss sg13_lv_nmos ad=95f pd=0.88u as=95f ps=0.88u w=0.5u l=0.13u
M1258 sg13cmos5l_Corner_1.vss a_94484_99560# adc8b_0.side_cap8b_0.in_h_sw[5] sg13cmos5l_Corner_1.vss sg13_lv_nmos ad=0.14875p pd=1.16u as=0.2886p ps=2.26u w=0.74u l=0.13u
M1259 sg13cmos5l_Corner_1.vss adc8b_0.sar12b_0.sg13cmos5l_a221oi_1_0.A2 a_89809_96930# sg13cmos5l_Corner_1.vss sg13_lv_nmos ad=0.15055p pd=1.17u as=0.187p ps=1.78u w=0.55u l=0.13u
X1260 a_164624_102044# sg13cmos5l_Corner_1.iovdd sg13cmos5l_Corner_1.iovdd rppd l=12.9u w=0.5u
M1261 a_100995_100350# cks sg13cmos5l_Corner_1.vss sg13cmos5l_Corner_1.vss sg13_lv_nmos ad=0.1406p pd=1.12u as=0.1406p ps=1.12u w=0.74u l=0.13u
M1262 adc8b_0.sar12b_0.sg13cmos5l_dfrbp_1_2.Q_N a_94583_95421# sg13cmos5l_Corner_1.vss sg13cmos5l_Corner_1.vss sg13_lv_nmos ad=0.2849p pd=2.25u as=0.2516p ps=2.16u w=0.74u l=0.13u
M1263 frame a_134044_42476# sg13cmos5l_Corner_1.iovdd sg13cmos5l_Corner_1.iovdd sg13_hv_pmos ad=3.9294p pd=7.84u as=2.1312p ps=7.3u w=6.66u l=0.6u
M1264 vddr adc8b_0.side_cap8b_0.in_l_sw[0] adc8b_0.side_cap8b_0.buf_32_0.z vddr sg13_lv_pmos ad=0.19p pd=1.38u as=0.19p ps=1.38u w=1u l=0.13u
M1265 adc8b_0.side_cap8b_0.buf_16_2.z adc8b_0.side_cap8b_0.in_l_sw[1] vddr vddr sg13_lv_pmos ad=0.19p pd=1.38u as=0.19p ps=1.38u w=1u l=0.13u
M1266 a_93228_93552# a_93202_93516# sg13cmos5l_Corner_1.vss sg13cmos5l_Corner_1.vss sg13_lv_nmos ad=0.2516p pd=2.16u as=0.1626p ps=1.415u w=0.74u l=0.13u
M1267 adc8b_0.side_cap8b_0.buf_16_0.z adc8b_0.side_cap8b_0.in_h_sw[2] vddr vddr sg13_lv_pmos ad=0.19p pd=1.38u as=0.19p ps=1.38u w=1u l=0.13u
M1268 vddr adc8b_0.side_cap8b_0.in_h_sw[6] adc8b_0.side_cap8b_0.buf_4_1.z vddr sg13_lv_pmos ad=0.19p pd=1.38u as=0.19p ps=1.38u w=1u l=0.13u
M1269 data[0] a_70044_30676# sg13cmos5l_Corner_1.vss sg13cmos5l_Corner_1.vss sg13_hv_nmos ad=2.596p pd=5.58u as=1.408p ps=5.04u w=4.4u l=0.6u
M1270 sg13cmos5l_Corner_1.vss a_87956_92750# adc8b_0.sar12b_0.sg13cmos5l_buf_1_25.X sg13cmos5l_Corner_1.vss sg13_lv_nmos ad=0.14875p pd=1.16u as=0.2886p ps=2.26u w=0.74u l=0.13u
M1271 a_97836_98088# a_98355_98095# a_99095_98445# sg13cmos5l_Corner_1.vss sg13_lv_nmos ad=0.3473p pd=2.71u as=0.12665p ps=1.145u w=0.74u l=0.13u
M1272 sg13cmos5l_IOPadAnalog_1.pad a_178296_70044# sg13cmos5l_Corner_1.vss sg13cmos5l_Corner_1.vss sg13_hv_nmos ad=2.596p pd=5.58u as=2.068p ps=9.74u w=4.4u l=0.6u
M1273 adc8b_0.side_cap8b_1.buf_32_0.z adc8b_0.sar12b_0.nl_sw[0] sg13cmos5l_Corner_1.vss sg13cmos5l_Corner_1.vss sg13_lv_nmos ad=0.17p pd=1.68u as=95f ps=0.88u w=0.5u l=0.13u
M1274 a_93537_99149# a_92595_98956# a_93335_98911# vdd sg13_lv_pmos ad=93.45f pd=0.865u as=0.2048p ps=1.63u w=0.42u l=0.13u
M1275 adc8b_0.side_cap8b_1.buf_32_1.z adc8b_0.sar12b_0.nh_sw[0] vddr vddr sg13_lv_pmos ad=0.19p pd=1.38u as=0.19p ps=1.38u w=1u l=0.13u
M1276 a_84322_99272# a_83716_99124# vdd vdd sg13_lv_pmos ad=0.1008p pd=0.9u as=0.2387p ps=1.84u w=0.42u l=0.13u
M1277 adc8b_0.sar12b_0.sg13cmos5l_or2_1_1.B adc8b_0.sar12b_0.sg13cmos5l_nor2_1_0.A sg13cmos5l_Corner_1.vss sg13cmos5l_Corner_1.vss sg13_lv_nmos ad=0.1406p pd=1.12u as=0.2516p ps=2.16u w=0.74u l=0.13u
M1278 sg13cmos5l_IOPadAnalog_15.pad a_99639_164698# sg13cmos5l_Corner_1.iovdd sg13cmos5l_Corner_1.iovdd sg13_hv_pmos ad=3.9294p pd=7.84u as=2.1312p ps=7.3u w=6.66u l=0.6u
M1279 vip a_42476_102044# sg13cmos5l_Corner_1.iovdd sg13cmos5l_Corner_1.iovdd sg13_hv_pmos ad=3.9294p pd=7.84u as=2.1312p ps=7.3u w=6.66u l=0.6u
M1280 adc8b_0.sar12b_0.sg13cmos5l_buf_1_95.X a_94000_99596# vdd vdd sg13_lv_pmos ad=0.42p pd=2.99u as=0.2114p ps=1.54u w=1.12u l=0.13u
M1281 adc8b_0.sar12b_0.sg13cmos5l_dfrbp_1_6.D a_83440_94336# vdd vdd sg13_lv_pmos ad=0.42p pd=2.99u as=0.2114p ps=1.54u w=1.12u l=0.13u
M1282 sg13cmos5l_IOPadAnalog_1.pad a_178296_70044# sg13cmos5l_Corner_1.vss sg13cmos5l_Corner_1.vss sg13_hv_nmos ad=2.596p pd=5.58u as=1.408p ps=5.04u w=4.4u l=0.6u
M1283 vdd adc8b_0.sar12b_0.sg13cmos5l_dfrbp_1_6.RESET_B a_95409_98834# vdd sg13_lv_pmos ad=0.2128p pd=1.5u as=0.2128p ps=1.5u w=1.12u l=0.13u
M1284 a_99182_94298# adc8b_0.sar12b_0.sg13cmos5l_a22oi_1_1.Y vdd vdd sg13_lv_pmos ad=79.8f pd=0.8u as=0.1428p ps=1.52u w=0.42u l=0.13u
M1285 sg13cmos5l_Corner_1.vss adc8b_0.side_cap8b_0.in_h_sw[3] adc8b_0.side_cap8b_0.buf_8_3.z sg13cmos5l_Corner_1.vss sg13_lv_nmos ad=95f pd=0.88u as=95f ps=0.88u w=0.5u l=0.13u
M1286 adc8b_0.sar12b_0.sg13cmos5l_dlhr_1_12.Q_N a_100254_100026# vdd vdd sg13_lv_pmos ad=0.3808p pd=2.92u as=0.1974p ps=1.5u w=1.12u l=0.13u
M1287 vdd adc8b_0.sar12b_0.sg13cmos5l_a221oi_1_0.A2 a_89809_96930# vdd sg13_lv_pmos ad=1.28962p pd=8.195u as=0.2856p ps=2.36u w=0.84u l=0.13u
M1288 a_83583_95826# adc8b_0.sar12b_0.sg13cmos5l_dlhr_1_1.GATE vdd vdd sg13_lv_pmos ad=0.3234p pd=2.45u as=1.2517p ps=7.955u w=0.84u l=0.13u
M1289 sg13cmos5l_Corner_1.iovdd a_83639_164698# sg13cmos5l_IOPadAnalog_9.pad sg13cmos5l_Corner_1.iovdd sg13_hv_pmos ad=2.1312p pd=7.3u as=3.9294p ps=7.84u w=6.66u l=0.6u
M1290 sg13cmos5l_IOPadVdd$1_0.sg13cmos5l_Clamp_N43N43D4R$1_0.gate sg13cmos5l_IOPadVdd$1_0.sg13cmos5l_RCClampInverter$1_0.in vdd vdd sg13_hv_pmos ad=1.33p pd=7.38u as=1.33p ps=7.38u w=7u l=0.5u
M1291 adc8b_0.side_cap8b_1.buf_32_0.z adc8b_0.sar12b_0.nl_sw[0] sg13cmos5l_Corner_1.vss sg13cmos5l_Corner_1.vss sg13_lv_nmos ad=95f pd=0.88u as=95f ps=0.88u w=0.5u l=0.13u
M1292 sg13cmos5l_Corner_1.iovdd a_42476_70044# vddr sg13cmos5l_Corner_1.iovdd sg13_hv_pmos ad=2.1312p pd=7.3u as=3.9294p ps=7.84u w=6.66u l=0.6u
M1293 sg13cmos5l_Corner_1.iovdd a_118044_42476# cko sg13cmos5l_Corner_1.iovdd sg13_hv_pmos ad=2.1312p pd=7.3u as=3.9294p ps=7.84u w=6.66u l=0.6u
M1294 vddr adc8b_0.sar12b_0.nh_sw[3] adc8b_0.side_cap8b_1.buf_8_3.z vddr sg13_lv_pmos ad=0.19p pd=1.38u as=0.19p ps=1.38u w=1u l=0.13u
M1295 a_98036_92750# adc8b_0.sar12b_0.sg13cmos5l_buf_1_1.A sg13cmos5l_Corner_1.vss sg13cmos5l_Corner_1.vss sg13_lv_nmos ad=0.187p pd=1.78u as=0.14875p ps=1.16u w=0.55u l=0.13u
M1296 adc8b_0.side_cap8b_0.buf_32_1.z adc8b_0.side_cap8b_0.in_h_sw[0] sg13cmos5l_Corner_1.vss sg13cmos5l_Corner_1.vss sg13_lv_nmos ad=95f pd=0.88u as=95f ps=0.88u w=0.5u l=0.13u
M1297 sg13cmos5l_Corner_1.vss adc8b_0.side_cap8b_0.in_l_sw[2] adc8b_0.side_cap8b_0.buf_16_1.z sg13cmos5l_Corner_1.vss sg13_lv_nmos ad=95f pd=0.88u as=95f ps=0.88u w=0.5u l=0.13u
M1298 sg13cmos5l_Corner_1.iovdd a_164624_102044# sg13cmos5l_IOPadAnalog_16.pad sg13cmos5l_Corner_1.iovdd sg13_hv_pmos ad=2.1312p pd=7.3u as=3.9294p ps=7.84u w=6.66u l=0.6u
M1299 sg13cmos5l_Corner_1.vss sg13cmos5l_IOPadVdd$1_0.sg13cmos5l_Clamp_N43N43D4R$1_0.gate vdd sg13cmos5l_Corner_1.vss sg13_hv_nmos ad=1.408p pd=5.04u as=2.596p ps=5.58u w=4.4u l=0.6u
M1300 sg13cmos5l_Corner_1.vss adc8b_0.sar12b_0.sg13cmos5l_inv_1_8.A a_87719_96543# sg13cmos5l_Corner_1.vss sg13_lv_nmos ad=1.88087p pd=11.775u as=0.2516p ps=2.16u w=0.74u l=0.13u
M1301 sg13cmos5l_Corner_1.vss adc8b_0.sar12b_0.sg13cmos5l_buf_8_1.A a_100131_95430# sg13cmos5l_Corner_1.vss sg13_lv_nmos ad=0.1406p pd=1.12u as=0.1406p ps=1.12u w=0.74u l=0.13u
M1302 sg13cmos5l_Corner_1.vss adc8b_0.sar12b_0.sg13cmos5l_nand2_1_1.A a_101776_95060# sg13cmos5l_Corner_1.vss sg13_lv_nmos ad=0.14875p pd=1.16u as=0.187p ps=1.78u w=0.55u l=0.13u
M1303 sg13cmos5l_IOPadAnalog_0.pad a_164624_86044# sg13cmos5l_Corner_1.iovdd sg13cmos5l_Corner_1.iovdd sg13_hv_pmos ad=3.9294p pd=7.84u as=2.1312p ps=7.3u w=6.66u l=0.6u
M1304 a_99662_99596# a_99266_99960# a_99548_99596# vdd sg13_lv_pmos ad=0.1008p pd=0.9u as=0.191p ps=1.44u w=0.42u l=0.13u
M1305 cks a_30676_118044# sg13cmos5l_Corner_1.vss sg13cmos5l_Corner_1.vss sg13_hv_nmos ad=2.596p pd=5.58u as=1.408p ps=5.04u w=4.4u l=0.6u
M1306 a_92196_100382# a_91647_100362# a_92060_100668# sg13cmos5l_Corner_1.vss sg13_lv_nmos ad=47.25f pd=0.645u as=0.141p ps=1.17u w=0.42u l=0.13u
M1307 vdd a_89080_95302# a_89025_95183# vdd sg13_lv_pmos ad=1.43437p pd=9.105u as=93.45f ps=0.865u w=0.42u l=0.13u
X1308 sg13cmos5l_Corner_1.vss a_118222_176786# dantenna l=1.26u w=27.78u
M1309 adc8b_0.side_cap8b_0.buf_32_1.z adc8b_0.side_cap8b_0.in_h_sw[0] vddr vddr sg13_lv_pmos ad=0.19p pd=1.38u as=0.19p ps=1.38u w=1u l=0.13u
M1310 adc8b_0.side_cap8b_0.buf_8_3.z adc8b_0.side_cap8b_0.in_h_sw[3] vddr vddr sg13_lv_pmos ad=0.19p pd=1.38u as=0.19p ps=1.38u w=1u l=0.13u
M1311 a_85076_100310# adc8b_0.sar12b_0.sg13cmos5l_buf_1_65.X vdd vdd sg13_lv_pmos ad=0.2856p pd=2.36u as=0.2114p ps=1.54u w=0.84u l=0.13u
M1312 sg13cmos5l_Corner_1.vss adc8b_0.sar12b_0.sg13cmos5l_dfrbp_1_8.RESET_B a_83724_100034# sg13cmos5l_Corner_1.vss sg13_lv_nmos ad=0.1626p pd=1.415u as=60.89999f ps=0.71u w=0.42u l=0.13u
M1313 adc8b_0.sar12b_0.sg13cmos5l_dfrbp_1_15.D a_86012_99596# vdd vdd sg13_lv_pmos ad=0.3808p pd=2.92u as=0.2128p ps=1.5u w=1.12u l=0.13u
M1314 sg13cmos5l_Corner_1.vss adc8b_0.sar12b_0.sg13cmos5l_dfrbp_1_0.RESET_B a_97068_93986# sg13cmos5l_Corner_1.vss sg13_lv_nmos ad=0.1626p pd=1.415u as=60.89999f ps=0.71u w=0.42u l=0.13u
M1315 a_90828_100021# a_91059_99607# a_90514_99564# sg13cmos5l_Corner_1.vss sg13_lv_nmos ad=0.2373p pd=1.97u as=79.8f ps=0.8u w=0.42u l=0.13u
M1316 sg13cmos5l_Corner_1.vss sg13cmos5l_IOPadVdd$1_0.sg13cmos5l_Clamp_N43N43D4R$1_0.gate vdd sg13cmos5l_Corner_1.vss sg13_hv_nmos ad=1.408p pd=5.04u as=2.596p ps=5.58u w=4.4u l=0.6u
M1317 cks a_42476_118044# sg13cmos5l_Corner_1.iovdd sg13cmos5l_Corner_1.iovdd sg13_hv_pmos ad=3.9294p pd=7.84u as=2.1312p ps=7.3u w=6.66u l=0.6u
M1318 a_85560_93548# a_85009_93906# vdd vdd sg13_lv_pmos ad=0.105p pd=1.21u as=1.86162p ps=11.935u w=1u l=0.13u
M1319 a_96568_94518# a_96311_94375# a_96730_94298# sg13cmos5l_Corner_1.vss sg13_lv_nmos ad=0.1428p pd=1.52u as=37.8f ps=0.6u w=0.42u l=0.13u
M1320 vdd adc8b_0.sar12b_0.sg13cmos5l_buf_1_105.A a_100624_99596# vdd sg13_lv_pmos ad=0.2114p pd=1.54u as=0.2856p ps=2.36u w=0.84u l=0.13u
M1321 data[0] a_70044_42476# sg13cmos5l_Corner_1.iovdd sg13cmos5l_Corner_1.iovdd sg13_hv_pmos ad=3.9294p pd=7.84u as=2.1312p ps=7.3u w=6.66u l=0.6u
M1322 frame a_134044_42476# sg13cmos5l_Corner_1.iovdd sg13cmos5l_Corner_1.iovdd sg13_hv_pmos ad=3.9294p pd=7.84u as=2.1312p ps=7.3u w=6.66u l=0.6u
M1323 vdd sg13cmos5l_IOPadVdd$1_0.sg13cmos5l_Clamp_N43N43D4R$1_0.gate sg13cmos5l_Corner_1.vss sg13cmos5l_Corner_1.vss sg13_hv_nmos ad=2.596p pd=5.58u as=1.408p ps=5.04u w=4.4u l=0.6u
M1324 a_91992_100668# a_91441_100400# vdd vdd sg13_lv_pmos ad=0.105p pd=1.21u as=4.11675p ps=27.17u w=1u l=0.13u
M1325 vdd a_85432_95302# a_85377_95183# vdd sg13_lv_pmos ad=1.43437p pd=9.105u as=93.45f ps=0.865u w=0.42u l=0.13u
M1326 adc8b_0.side_cap8b_0.buf_8_2.z adc8b_0.side_cap8b_0.in_h_sw[4] sg13cmos5l_Corner_1.vss sg13cmos5l_Corner_1.vss sg13_lv_nmos ad=95f pd=0.88u as=95f ps=0.88u w=0.5u l=0.13u
M1327 vdd adc8b_0.sar12b_0.sg13cmos5l_buf_1_10.A adc8b_0.sar12b_0.sg13cmos5l_inv_1_28.Y vdd sg13_lv_pmos ad=0.3808p pd=2.92u as=0.3808p ps=2.92u w=1.12u l=0.13u
M1328 sg13cmos5l_Corner_1.iovdd a_131639_164698# sg13cmos5l_IOPadAnalog_12.pad sg13cmos5l_Corner_1.iovdd sg13_hv_pmos ad=2.1312p pd=7.3u as=3.9294p ps=7.84u w=6.66u l=0.6u
M1329 sg13cmos5l_Corner_1.vss a_85175_99957# a_86012_99596# sg13cmos5l_Corner_1.vss sg13_lv_nmos ad=0.1406p pd=1.12u as=0.2516p ps=2.16u w=0.74u l=0.13u
M1330 sg13cmos5l_Corner_1.vss a_98253_98095# a_98355_98095# sg13cmos5l_Corner_1.vss sg13_lv_nmos ad=1.49685p pd=9.6u as=0.2516p ps=2.16u w=0.74u l=0.13u
M1331 vdd adc8b_0.sar12b_0.sg13cmos5l_dfrbp_1_21.Q_N a_100561_97376# vdd sg13_lv_pmos ad=1.07253p pd=6.75u as=0.2856p ps=2.36u w=0.84u l=0.13u
M1332 sg13cmos5l_IOPadAnalog_16.pad a_164624_102044# sg13cmos5l_Corner_1.iovdd sg13cmos5l_Corner_1.iovdd sg13_hv_pmos ad=3.9294p pd=7.84u as=2.1312p ps=7.3u w=6.66u l=0.6u
M1333 vdd adc8b_0.sar12b_0.sg13cmos5l_dfrbp_1_6.RESET_B a_89457_92786# vdd sg13_lv_pmos ad=0.2128p pd=1.5u as=0.2128p ps=1.5u w=1.12u l=0.13u
M1334 sg13cmos5l_IOPadVdd$1_0.sg13cmos5l_Clamp_N43N43D4R$1_0.gate sg13cmos5l_IOPadVdd$1_0.sg13cmos5l_RCClampInverter$1_0.in vdd vdd sg13_hv_pmos ad=1.33p pd=7.38u as=1.33p ps=7.38u w=7u l=0.5u
M1335 sg13cmos5l_Corner_1.vss sg13cmos5l_IOPadVdd$1_0.sg13cmos5l_Clamp_N43N43D4R$1_0.gate vdd sg13cmos5l_Corner_1.vss sg13_hv_nmos ad=1.408p pd=5.04u as=3.256p ps=10.28u w=4.4u l=0.6u
M1336 sg13cmos5l_Corner_1.vss a_30676_118044# cks sg13cmos5l_Corner_1.vss sg13_hv_nmos ad=1.408p pd=5.04u as=2.596p ps=5.58u w=4.4u l=0.6u
M1337 cks a_42476_118044# sg13cmos5l_Corner_1.iovdd sg13cmos5l_Corner_1.iovdd sg13_hv_pmos ad=3.9294p pd=7.84u as=2.1312p ps=7.3u w=6.66u l=0.6u
M1338 sg13cmos5l_Corner_1.vss a_86847_94314# a_86978_94308# sg13cmos5l_Corner_1.vss sg13_lv_nmos ad=2.59257p pd=16.445u as=0.2775p ps=2.23u w=0.74u l=0.13u
M1339 sg13cmos5l_IOPadAnalog_16.pad a_178296_102044# sg13cmos5l_Corner_1.vss sg13cmos5l_Corner_1.vss sg13_hv_nmos ad=2.596p pd=5.58u as=1.408p ps=5.04u w=4.4u l=0.6u
M1340 sg13cmos5l_Corner_1.vss adc8b_0.sar12b_0.nh_sw[7] adc8b_0.side_cap8b_1.buf_4_2.z sg13cmos5l_Corner_1.vss sg13_lv_nmos ad=95f pd=0.88u as=95f ps=0.88u w=0.5u l=0.13u
M1341 sg13cmos5l_IOPadAnalog_12.pad a_131639_164698# sg13cmos5l_Corner_1.iovdd sg13cmos5l_Corner_1.iovdd sg13_hv_pmos ad=3.9294p pd=7.84u as=2.1312p ps=7.3u w=6.66u l=0.6u
M1342 vdd sg13cmos5l_IOPadVdd$1_0.sg13cmos5l_Clamp_N43N43D4R$1_0.gate sg13cmos5l_Corner_1.vss sg13cmos5l_Corner_1.vss sg13_hv_nmos ad=2.596p pd=5.58u as=1.408p ps=5.04u w=4.4u l=0.6u
M1343 adc8b_0.sar12b_0.sg13cmos5l_buf_1_19.A a_100624_99596# vdd vdd sg13_lv_pmos ad=0.42p pd=2.99u as=0.2114p ps=1.54u w=1.12u l=0.13u
M1344 adc8b_0.sar12b_0.sg13cmos5l_buf_1_18.A adc8b_0.sar12b_0.sg13cmos5l_buf_1_111.A sg13cmos5l_Corner_1.vss sg13cmos5l_Corner_1.vss sg13_lv_nmos ad=0.2516p pd=2.16u as=0.2516p ps=2.16u w=0.74u l=0.13u
M1345 a_92840_96507# adc8b_0.sar12b_0.sg13cmos5l_dlhr_1_15.D vdd vdd sg13_lv_pmos ad=0.1596p pd=1.22u as=0.36195p ps=1.84u w=0.84u l=0.13u
M1346 sg13cmos5l_IOPadAnalog_10.pad a_67639_164698# sg13cmos5l_Corner_1.iovdd sg13cmos5l_Corner_1.iovdd sg13_hv_pmos ad=3.9294p pd=7.84u as=2.1312p ps=7.3u w=6.66u l=0.6u
M1347 adc8b_0.side_cap8b_0.buf_16_2.z adc8b_0.side_cap8b_0.in_l_sw[1] sg13cmos5l_Corner_1.vss sg13cmos5l_Corner_1.vss sg13_lv_nmos ad=95f pd=0.88u as=95f ps=0.88u w=0.5u l=0.13u
M1348 sg13cmos5l_Corner_1.vss a_92241_100346# a_92196_100382# sg13cmos5l_Corner_1.vss sg13_lv_nmos ad=0.1428p pd=1.52u as=47.25f ps=0.645u w=0.42u l=0.13u
M1349 a_93038_92786# a_93843_92908# a_93298_93009# vdd sg13_lv_pmos ad=0.1428p pd=1.52u as=79.8f ps=0.8u w=0.42u l=0.13u
M1350 a_82476_98088# a_82450_98052# vdd vdd sg13_lv_pmos ad=0.34p pd=2.68u as=0.36237p ps=2.605u w=1u l=0.13u
M1351 vddr adc8b_0.sar12b_0.nh_sw[0] adc8b_0.side_cap8b_1.buf_32_1.z vddr sg13_lv_pmos ad=0.19p pd=1.38u as=0.19p ps=1.38u w=1u l=0.13u
M1352 sg13cmos5l_Corner_1.iovdd a_99639_164698# sg13cmos5l_IOPadAnalog_15.pad sg13cmos5l_Corner_1.iovdd sg13_hv_pmos ad=2.1312p pd=7.3u as=3.9294p ps=7.84u w=6.66u l=0.6u
M1353 a_96204_100034# adc8b_0.sar12b_0.sg13cmos5l_dfrbp_1_23.CLK a_96110_100034# sg13cmos5l_Corner_1.vss sg13_lv_nmos ad=60.89999f pd=0.71u as=0.1428p ps=1.52u w=0.42u l=0.13u
M1354 a_91428_95846# a_90879_95826# a_91292_96132# sg13cmos5l_Corner_1.vss sg13_lv_nmos ad=47.25f pd=0.645u as=0.141p ps=1.17u w=0.42u l=0.13u
M1355 sg13cmos5l_Corner_1.vss a_91473_95810# a_91428_95846# sg13cmos5l_Corner_1.vss sg13_lv_nmos ad=0.1428p pd=1.52u as=47.25f ps=0.645u w=0.42u l=0.13u
M1356 vddr adc8b_0.side_cap8b_0.in_h_sw[4] adc8b_0.side_cap8b_0.buf_8_2.z vddr sg13_lv_pmos ad=0.19p pd=1.38u as=0.19p ps=1.38u w=1u l=0.13u
M1357 vdd a_83765_97286# adc8b_0.sar12b_0.sg13cmos5l_dfrbp_1_15.Q_N vdd sg13_lv_pmos ad=0.2639p pd=1.81u as=0.4312p ps=3.01u w=1.12u l=0.13u
M1358 a_87790_95485# adc8b_0.sar12b_0.sg13cmos5l_dfrbp_1_6.RESET_B sg13cmos5l_Corner_1.vss sg13cmos5l_Corner_1.vss sg13_lv_nmos ad=37.8f pd=0.6u as=0.1701p ps=1.65u w=0.42u l=0.13u
M1359 vdd a_99597_92765# a_99699_92908# vdd sg13_lv_pmos ad=1.86162p pd=11.935u as=0.3864p ps=2.93u w=1.12u l=0.13u
M1360 adc8b_0.sar12b_0.sg13cmos5l_dlhr_1_1.Q a_84177_95810# sg13cmos5l_Corner_1.vss sg13cmos5l_Corner_1.vss sg13_lv_nmos ad=0.2516p pd=2.16u as=0.1406p ps=1.12u w=0.74u l=0.13u
M1361 sg13cmos5l_IOPadAnalog_11.pad a_164624_118044# sg13cmos5l_Corner_1.iovdd sg13cmos5l_Corner_1.iovdd sg13_hv_pmos ad=3.9294p pd=7.84u as=2.1312p ps=7.3u w=6.66u l=0.6u
M1362 sg13cmos5l_Corner_1.vss sg13cmos5l_IOPadVdd$1_0.sg13cmos5l_Clamp_N43N43D4R$1_0.gate vdd sg13cmos5l_Corner_1.vss sg13_hv_nmos ad=1.408p pd=5.04u as=2.596p ps=5.58u w=4.4u l=0.6u
M1363 a_84154_97010# adc8b_0.sar12b_0.sg13cmos5l_dfrbp_1_6.RESET_B sg13cmos5l_Corner_1.vss sg13cmos5l_Corner_1.vss sg13_lv_nmos ad=37.8f pd=0.6u as=79.8f ps=0.8u w=0.42u l=0.13u
M1364 vdd sg13cmos5l_Corner_1.vss vdd vdd sg13_lv_pmos ad=0.34p pd=2.68u as=0 ps=0 w=1u l=1u
M1365 a_89580_98847# a_89811_98956# a_89266_99057# sg13cmos5l_Corner_1.vss sg13_lv_nmos ad=0.2373p pd=1.97u as=79.8f ps=0.8u w=0.42u l=0.13u
M1366 a_91796_97286# adc8b_0.sar12b_0.sg13cmos5l_buf_1_56.A vdd vdd sg13_lv_pmos ad=0.2856p pd=2.36u as=0.2114p ps=1.54u w=0.84u l=0.13u
M1367 vdd sg13cmos5l_IOPadVdd$1_0.sg13cmos5l_Clamp_N43N43D4R$1_0.gate sg13cmos5l_Corner_1.vss sg13cmos5l_Corner_1.vss sg13_hv_nmos ad=2.596p pd=5.58u as=1.408p ps=5.04u w=4.4u l=0.6u
M1368 a_92099_93084# adc8b_0.sar12b_0.sg13cmos5l_nand2_1_1.B adc8b_0.sar12b_0.sg13cmos5l_a22oi_1_2.B1 vdd sg13_lv_pmos ad=0.2128p pd=1.5u as=0.3808p ps=2.92u w=1.12u l=0.13u
X1369 sg13cmos5l_Corner_1.vss a_86222_176786# dantenna l=1.26u w=27.78u
M1370 sg13cmos5l_Corner_1.vss sg13cmos5l_IOPadVdd$1_0.sg13cmos5l_Clamp_N43N43D4R$1_0.gate vdd sg13cmos5l_Corner_1.vss sg13_hv_nmos ad=2.068p pd=9.74u as=2.596p ps=5.58u w=4.4u l=0.6u
M1371 vdd a_85460_100310# adc8b_0.sar12b_0.sg13cmos5l_buf_1_62.X vdd sg13_lv_pmos ad=0.2114p pd=1.54u as=0.42p ps=2.99u w=1.12u l=0.13u
M1372 a_83716_99124# adc8b_0.sar12b_0.sg13cmos5l_dfrbp_1_6.RESET_B vdd vdd sg13_lv_pmos ad=0.2128p pd=1.5u as=0.2128p ps=1.5u w=1.12u l=0.13u
M1373 vdd a_92433_98441# a_92366_98084# vdd sg13_lv_pmos ad=0.2387p pd=1.84u as=0.1008p ps=0.9u w=0.42u l=0.13u
M1374 a_83916_95064# a_83890_95028# vdd vdd sg13_lv_pmos ad=0.34p pd=2.68u as=0.36237p ps=2.605u w=1u l=0.13u
M1375 data[0] a_70044_42476# sg13cmos5l_Corner_1.iovdd sg13cmos5l_Corner_1.iovdd sg13_hv_pmos ad=3.9294p pd=7.84u as=2.1312p ps=7.3u w=6.66u l=0.6u
M1376 sg13cmos5l_IOPadAnalog_11.pad a_178296_118044# sg13cmos5l_Corner_1.vss sg13cmos5l_Corner_1.vss sg13_hv_nmos ad=2.596p pd=5.58u as=1.408p ps=5.04u w=4.4u l=0.6u
M1377 vddr adc8b_0.sar12b_0.nh_sw[0] adc8b_0.side_cap8b_1.buf_32_1.z vddr sg13_lv_pmos ad=0.19p pd=1.38u as=0.19p ps=1.38u w=1u l=0.13u
M1378 sg13cmos5l_IOPadAnalog_15.pad a_99639_164698# sg13cmos5l_Corner_1.iovdd sg13cmos5l_Corner_1.iovdd sg13_hv_pmos ad=3.9294p pd=7.84u as=2.1312p ps=7.3u w=6.66u l=0.6u
M1379 sg13cmos5l_Corner_1.vss a_30676_102044# vip sg13cmos5l_Corner_1.vss sg13_hv_nmos ad=2.068p pd=9.74u as=2.596p ps=5.58u w=4.4u l=0.6u
M1380 adc8b_0.side_cap8b_0.in_l_sw[1] a_82768_100384# vdd vdd sg13_lv_pmos ad=0.42p pd=2.99u as=0.2114p ps=1.54u w=1.12u l=0.13u
M1381 a_92060_100668# a_91778_100356# a_91993_100338# sg13cmos5l_Corner_1.vss sg13_lv_nmos ad=0.141p pd=1.17u as=71.99999f ps=0.865u w=0.64u l=0.13u
X1382 sg13cmos5l_Corner_1.vss a_57198_85410# dantenna l=0.64u w=3.1u
M1383 sg13cmos5l_IOPadAnalog_13.pad a_115639_164698# sg13cmos5l_Corner_1.iovdd sg13cmos5l_Corner_1.iovdd sg13_hv_pmos ad=3.9294p pd=7.84u as=2.1312p ps=7.3u w=6.66u l=0.6u
M1384 a_90828_100021# a_90540_99600# a_90766_100021# sg13cmos5l_Corner_1.vss sg13_lv_nmos ad=0.1428p pd=1.52u as=37.8f ps=0.6u w=0.42u l=0.13u
M1385 vdd adc8b_0.sar12b_0.sg13cmos5l_buf_1_4.A adc8b_0.sar12b_0.sg13cmos5l_buf_1_110.A vdd sg13_lv_pmos ad=0.3808p pd=2.92u as=0.3808p ps=2.92u w=1.12u l=0.13u
M1386 sg13cmos5l_Corner_1.vss a_118044_30676# cko sg13cmos5l_Corner_1.vss sg13_hv_nmos ad=1.408p pd=5.04u as=2.596p ps=5.58u w=4.4u l=0.6u
X1387 a_36456_135415# a_40542_135745# sg13cmos5l_Corner_1.vss rppd l=20u w=1u
M1388 adc8b_0.cmp_0.sg13cmos5l_inv_1$1_1.Y adc8b_0.cmp_0.outn vdd vdd sg13_lv_pmos ad=0.3808p pd=2.92u as=0.3808p ps=2.92u w=1.12u l=0.13u
M1389 a_85802_98820# adc8b_0.sar12b_0.sg13cmos5l_dfrbp_1_6.RESET_B sg13cmos5l_Corner_1.vss sg13cmos5l_Corner_1.vss sg13_lv_nmos ad=77.7f pd=0.95u as=0.1406p ps=1.12u w=0.74u l=0.13u
M1390 a_99180_93104# a_99699_92908# a_100439_92863# sg13cmos5l_Corner_1.vss sg13_lv_nmos ad=0.3473p pd=2.71u as=0.12665p ps=1.145u w=0.74u l=0.13u
M1391 sg13cmos5l_Corner_1.iovdd a_42476_70044# vddr sg13cmos5l_Corner_1.iovdd sg13_hv_pmos ad=2.1312p pd=7.3u as=3.9294p ps=7.84u w=6.66u l=0.6u
M1392 a_91790_98834# adc8b_0.sar12b_0.sg13cmos5l_buf_1_57.X vdd vdd sg13_lv_pmos ad=79.8f pd=0.8u as=0.1428p ps=1.52u w=0.42u l=0.13u
M1393 adc8b_0.sar12b_0.sg13cmos5l_dlhr_1_2.D a_88247_93909# sg13cmos5l_Corner_1.vss sg13cmos5l_Corner_1.vss sg13_lv_nmos ad=0.2849p pd=2.25u as=0.2516p ps=2.16u w=0.74u l=0.13u
M1394 a_88415_96619# a_87719_96543# a_88509_96619# sg13cmos5l_Corner_1.vss sg13_lv_nmos ad=0.1296p pd=1.52u as=79.8f ps=0.8u w=0.42u l=0.13u
M1395 adc8b_0.side_cap8b_1.buf_16_3.z adc8b_0.sar12b_0.nh_sw[1] sg13cmos5l_Corner_1.vss sg13cmos5l_Corner_1.vss sg13_lv_nmos ad=95f pd=0.88u as=95f ps=0.88u w=0.5u l=0.13u
M1396 sg13cmos5l_Corner_1.vss vdd sg13cmos5l_Corner_1.vss sg13cmos5l_Corner_1.vss sg13_lv_nmos ad=0.1428p pd=1.52u as=0 ps=0 w=0.42u l=1u
M1397 sg13cmos5l_Corner_1.vss adc8b_0.sar12b_0.nl_sw[0] adc8b_0.side_cap8b_1.buf_32_0.z sg13cmos5l_Corner_1.vss sg13_lv_nmos ad=95f pd=0.88u as=95f ps=0.88u w=0.5u l=0.13u
M1398 vin a_70852_94286# a_70096_94286# sg13cmos5l_Corner_1.vss sg13_lv_nmos ad=1.02p pd=6.68u as=1.02p ps=6.68u w=3u l=0.13u
M1399 a_96626_93548# adc8b_0.sar12b_0.sg13cmos5l_dfrbp_1_0.Q adc8b_0.sar12b_0.sg13cmos5l_nand2_1_0.A vdd sg13_lv_pmos ad=0.1176p pd=1.33u as=0.3808p ps=2.92u w=1.12u l=0.13u
M1400 sg13cmos5l_IOPadAnalog_12.pad a_131639_178370# sg13cmos5l_Corner_1.vss sg13cmos5l_Corner_1.vss sg13_hv_nmos ad=2.596p pd=5.58u as=1.408p ps=5.04u w=4.4u l=0.6u
M1401 vdd a_90801_97322# a_91326_97304# vdd sg13_lv_pmos ad=0.1974p pd=1.5u as=0.2856p ps=2.36u w=0.84u l=0.13u
M1402 sg13cmos5l_Corner_1.vss a_178296_86044# sg13cmos5l_IOPadAnalog_0.pad sg13cmos5l_Corner_1.vss sg13_hv_nmos ad=1.408p pd=5.04u as=2.596p ps=5.58u w=4.4u l=0.6u
M1403 adc8b_0.side_cap8b_0.buf_16_1.z adc8b_0.side_cap8b_0.in_l_sw[2] sg13cmos5l_Corner_1.vss sg13cmos5l_Corner_1.vss sg13_lv_nmos ad=95f pd=0.88u as=95f ps=0.88u w=0.5u l=0.13u
M1404 adc8b_0.diff_bsw_0.single_bsw_0.sg13cmos5l_inv_1$1_2.Y adc8b_0.diff_bsw_0.single_bsw_0.sg13cmos5l_inv_1$1_2.A sg13cmos5l_Corner_1.vss sg13cmos5l_Corner_1.vss sg13_lv_nmos ad=0.2516p pd=2.16u as=0.2516p ps=2.16u w=0.74u l=0.13u
M1405 adc8b_0.sar12b_0.sg13cmos5l_nand2_1_0.B a_92355_95852# a_92557_95814# sg13cmos5l_Corner_1.vss sg13_lv_nmos ad=0.333p pd=2.38u as=0.1406p ps=1.12u w=0.74u l=0.13u
M1406 vdd adc8b_0.sar12b_0.sg13cmos5l_dfrbp_1_8.RESET_B a_97810_98052# vdd sg13_lv_pmos ad=0.1563p pd=1.22u as=0.147p ps=1.54u w=0.42u l=0.13u
M1407 sg13cmos5l_Corner_1.vss a_94701_97301# a_94803_97444# sg13cmos5l_Corner_1.vss sg13_lv_nmos ad=1.97045p pd=12.335u as=0.2516p ps=2.16u w=0.74u l=0.13u
M1408 adc8b_0.side_cap8b_1.buf_8_2.z adc8b_0.sar12b_0.nh_sw[4] sg13cmos5l_Corner_1.vss sg13cmos5l_Corner_1.vss sg13_lv_nmos ad=95f pd=0.88u as=95f ps=0.88u w=0.5u l=0.13u
M1409 vddr adc8b_0.side_cap8b_0.in_h_sw[0] adc8b_0.side_cap8b_0.buf_32_1.z vddr sg13_lv_pmos ad=0.19p pd=1.38u as=0.19p ps=1.38u w=1u l=0.13u
M1410 adc8b_0.cmp_0.outp adc8b_0.cmp_0.outn vdd vdd sg13_lv_pmos ad=0.425p pd=3.18u as=0.2375p ps=1.63u w=1.25u l=0.13u
M1411 adc8b_0.sar12b_0.sg13cmos5l_a22oi_1_2.B1 adc8b_0.sar12b_0.sg13cmos5l_nand2_1_1.B sg13cmos5l_Corner_1.vss sg13cmos5l_Corner_1.vss sg13_lv_nmos ad=0.1406p pd=1.12u as=0.2516p ps=2.16u w=0.74u l=0.13u
M1412 sg13cmos5l_Corner_1.vss adc8b_0.sar12b_0.nh_sw[0] adc8b_0.side_cap8b_1.buf_32_1.z sg13cmos5l_Corner_1.vss sg13_lv_nmos ad=95f pd=0.88u as=95f ps=0.88u w=0.5u l=0.13u
M1413 sg13cmos5l_Corner_1.iovdd a_67639_164698# sg13cmos5l_IOPadAnalog_10.pad sg13cmos5l_Corner_1.iovdd sg13_hv_pmos ad=2.1312p pd=7.3u as=3.9294p ps=7.84u w=6.66u l=0.6u
M1414 vdd a_82926_94302# a_83058_94366# vdd sg13_lv_pmos ad=0.2245p pd=1.53u as=0.445p ps=2.89u w=1u l=0.25u
X1415 a_86044_42476# sg13cmos5l_Corner_1.iovdd sg13cmos5l_Corner_1.iovdd rppd l=12.9u w=0.5u
M1416 adc8b_0.side_cap8b_0.buf_4_2.z adc8b_0.side_cap8b_0.in_h_sw[7] vddr vddr sg13_lv_pmos ad=0.34p pd=2.68u as=0.19p ps=1.38u w=1u l=0.13u
M1417 vdd sg13cmos5l_Corner_1.vss vdd vdd sg13_lv_pmos ad=0.34p pd=2.68u as=0 ps=0 w=1u l=1u
M1418 vdd adc8b_0.sar12b_0.sg13cmos5l_dlhr_1_1.D a_83377_95864# vdd sg13_lv_pmos ad=1.28962p pd=8.195u as=0.2856p ps=2.36u w=0.84u l=0.13u
M1419 adc8b_0.sar12b_0.sg13cmos5l_or2_1_0.A a_100131_95430# vdd vdd sg13_lv_pmos ad=0.2128p pd=1.5u as=0.2128p ps=1.5u w=1.12u l=0.13u
M1420 sg13cmos5l_Corner_1.vss adc8b_0.sar12b_0.sg13cmos5l_dfrbp_1_8.RESET_B a_97452_95810# sg13cmos5l_Corner_1.vss sg13_lv_nmos ad=0.1626p pd=1.415u as=60.89999f ps=0.71u w=0.42u l=0.13u
M1421 sg13cmos5l_Corner_1.vss sg13cmos5l_IOPadVdd$1_0.sg13cmos5l_Clamp_N43N43D4R$1_0.gate vdd sg13cmos5l_Corner_1.vss sg13_hv_nmos ad=1.408p pd=5.04u as=2.596p ps=5.58u w=4.4u l=0.6u
M1422 sg13cmos5l_IOPadVdd$1_0.sg13cmos5l_Clamp_N43N43D4R$1_0.gate sg13cmos5l_IOPadVdd$1_0.sg13cmos5l_RCClampInverter$1_0.in sg13cmos5l_Corner_1.vss sg13cmos5l_Corner_1.vss sg13_hv_nmos ad=1.71p pd=9.38u as=1.71p ps=9.38u w=9u l=0.5u
M1423 sg13cmos5l_Corner_1.iovdd a_118044_42476# cko sg13cmos5l_Corner_1.iovdd sg13_hv_pmos ad=3.1302p pd=14.26u as=3.9294p ps=7.84u w=6.66u l=0.6u
M1424 data[1] a_86044_30676# sg13cmos5l_Corner_1.vss sg13cmos5l_Corner_1.vss sg13_hv_nmos ad=2.596p pd=5.58u as=1.408p ps=5.04u w=4.4u l=0.6u
M1425 sg13cmos5l_Corner_1.iovdd a_164624_70044# sg13cmos5l_IOPadAnalog_1.pad sg13cmos5l_Corner_1.iovdd sg13_hv_pmos ad=2.1312p pd=7.3u as=3.9294p ps=7.84u w=6.66u l=0.6u
M1426 vdd a_89015_99957# a_89272_99838# vdd sg13_lv_pmos ad=0.2639p pd=1.81u as=79.8f ps=0.8u w=0.42u l=0.13u
M1427 data[2] a_102044_42476# sg13cmos5l_Corner_1.iovdd sg13cmos5l_Corner_1.iovdd sg13_hv_pmos ad=3.9294p pd=7.84u as=2.1312p ps=7.3u w=6.66u l=0.6u
M1428 a_85377_99719# a_84435_99607# a_85175_99957# vdd sg13_lv_pmos ad=93.45f pd=0.865u as=0.2048p ps=1.63u w=0.42u l=0.13u
M1429 adc8b_0.side_cap8b_1.buf_16_0.z adc8b_0.sar12b_0.nh_sw[2] vddr vddr sg13_lv_pmos ad=0.19p pd=1.38u as=0.19p ps=1.38u w=1u l=0.13u
M1430 sg13cmos5l_IOPadAnalog_10.pad a_67639_164698# sg13cmos5l_Corner_1.iovdd sg13cmos5l_Corner_1.iovdd sg13_hv_pmos ad=3.9294p pd=7.84u as=2.1312p ps=7.3u w=6.66u l=0.6u
M1431 adc8b_0.cmp_0.sg13cmos5l_dlygate4sd3_1$1_0.A a_79552_97015# vdd vdd sg13_lv_pmos ad=0.3976p pd=2.95u as=0.2226p ps=1.535u w=1.12u l=0.13u
M1432 a_89265_94298# a_89084_94620# vdd vdd sg13_lv_pmos ad=0.2128p pd=1.5u as=0.2387p ps=1.84u w=1.12u l=0.13u
M1433 adc8b_0.side_cap8b_0.buf_8_1.z adc8b_0.side_cap8b_0.in_l_sw[3] vddr vddr sg13_lv_pmos ad=0.19p pd=1.38u as=0.19p ps=1.38u w=1u l=0.13u
M1434 sg13cmos5l_Corner_1.vss adc8b_0.sar12b_0.sg13cmos5l_or2_1_1.B a_92494_96920# sg13cmos5l_Corner_1.vss sg13_lv_nmos ad=0.2516p pd=2.16u as=0.1406p ps=1.12u w=0.74u l=0.13u
M1435 a_100439_92863# a_99597_92765# a_100345_92863# sg13cmos5l_Corner_1.vss sg13_lv_nmos ad=0.12665p pd=1.145u as=0.1428p ps=1.52u w=0.42u l=0.13u
M1436 vdd adc8b_0.sar12b_0.sg13cmos5l_dfrbp_1_6.RESET_B a_85809_93905# vdd sg13_lv_pmos ad=0.2128p pd=1.5u as=0.2128p ps=1.5u w=1.12u l=0.13u
M1437 sg13cmos5l_IOPadVdd$1_0.sg13cmos5l_Clamp_N43N43D4R$1_0.gate sg13cmos5l_IOPadVdd$1_0.sg13cmos5l_RCClampInverter$1_0.in sg13cmos5l_Corner_1.vss sg13cmos5l_Corner_1.vss sg13_hv_nmos ad=1.71p pd=9.38u as=1.71p ps=9.38u w=9u l=0.5u
M1438 sg13cmos5l_Corner_1.vss a_83583_95826# a_83714_95820# sg13cmos5l_Corner_1.vss sg13_lv_nmos ad=2.41737p pd=15.64u as=0.2775p ps=2.23u w=0.74u l=0.13u
M1439 a_95186_95856# adc8b_0.sar12b_0.sg13cmos5l_nor2_1_0.A a_95092_95856# sg13cmos5l_Corner_1.vss sg13_lv_nmos ad=0.1216p pd=1.02u as=0.2176p ps=1.96u w=0.64u l=0.13u
M1440 vdd sg13cmos5l_IOPadVdd$1_0.sg13cmos5l_Clamp_N43N43D4R$1_0.gate sg13cmos5l_Corner_1.vss sg13cmos5l_Corner_1.vss sg13_hv_nmos ad=2.596p pd=5.58u as=1.408p ps=5.04u w=4.4u l=0.6u
M1441 sg13cmos5l_Corner_1.iovdd a_164624_118044# sg13cmos5l_IOPadAnalog_11.pad sg13cmos5l_Corner_1.iovdd sg13_hv_pmos ad=2.1312p pd=7.3u as=3.9294p ps=7.84u w=6.66u l=0.6u
M1442 adc8b_0.side_cap8b_1.buf_1_0.z adc8b_0.sar12b_0.nl_sw[10] sg13cmos5l_Corner_1.vss sg13cmos5l_Corner_1.vss sg13_lv_nmos ad=0.17p pd=1.68u as=0.17p ps=1.68u w=0.5u l=0.13u
M1443 vdd adc8b_0.sar12b_0.sg13cmos5l_buf_1_2.A a_97552_92824# vdd sg13_lv_pmos ad=0.2114p pd=1.54u as=0.2856p ps=2.36u w=0.84u l=0.13u
M1444 sg13cmos5l_Corner_1.iovdd a_99639_164698# sg13cmos5l_IOPadAnalog_15.pad sg13cmos5l_Corner_1.iovdd sg13_hv_pmos ad=2.1312p pd=7.3u as=3.9294p ps=7.84u w=6.66u l=0.6u
M1445 sg13cmos5l_Corner_1.vss adc8b_0.side_cap8b_0.in_l_sw[1] adc8b_0.side_cap8b_0.buf_16_2.z sg13cmos5l_Corner_1.vss sg13_lv_nmos ad=95f pd=0.88u as=95f ps=0.88u w=0.5u l=0.13u
M1446 vdd a_88340_92750# adc8b_0.sar12b_0.sg13cmos5l_buf_1_24.X vdd sg13_lv_pmos ad=0.2114p pd=1.54u as=0.42p ps=2.99u w=1.12u l=0.13u
M1447 sg13cmos5l_Corner_1.iovdd a_115639_164698# sg13cmos5l_IOPadAnalog_13.pad sg13cmos5l_Corner_1.iovdd sg13_hv_pmos ad=2.1312p pd=7.3u as=3.9294p ps=7.84u w=6.66u l=0.6u
M1448 a_100046_99272# a_99650_98844# a_99932_99156# vdd sg13_lv_pmos ad=0.1008p pd=0.9u as=0.191p ps=1.44u w=0.42u l=0.13u
M1449 sg13cmos5l_Corner_1.vss adc8b_0.sar12b_0.sg13cmos5l_dfrbp_1_0.RESET_B a_93132_95498# sg13cmos5l_Corner_1.vss sg13_lv_nmos ad=0.1626p pd=1.415u as=60.89999f ps=0.71u w=0.42u l=0.13u
M1450 a_95342_99272# a_94946_98844# a_95228_99156# vdd sg13_lv_pmos ad=0.1008p pd=0.9u as=0.191p ps=1.44u w=0.42u l=0.13u
M1451 vdd adc8b_0.sar12b_0.sg13cmos5l_dfrbp_1_8.RESET_B a_88114_96033# vdd sg13_lv_pmos ad=0.1563p pd=1.22u as=0.147p ps=1.54u w=0.42u l=0.13u
M1452 a_93741_95071# adc8b_0.sar12b_0.sg13cmos5l_dfrbp_1_0.CLK sg13cmos5l_Corner_1.vss sg13cmos5l_Corner_1.vss sg13_lv_nmos ad=0.2516p pd=2.16u as=2.41737p ps=15.64u w=0.74u l=0.13u
M1453 sg13cmos5l_Corner_1.vss adc8b_0.sar12b_0.nl_sw[3] adc8b_0.side_cap8b_1.buf_8_1.z sg13cmos5l_Corner_1.vss sg13_lv_nmos ad=95f pd=0.88u as=0.17p ps=1.68u w=0.5u l=0.13u
M1454 a_87214_93973# adc8b_0.sar12b_0.sg13cmos5l_dfrbp_1_6.RESET_B sg13cmos5l_Corner_1.vss sg13cmos5l_Corner_1.vss sg13_lv_nmos ad=37.8f pd=0.6u as=0.1701p ps=1.65u w=0.42u l=0.13u
M1455 a_97652_94262# adc8b_0.sar12b_0.sg13cmos5l_buf_1_5.X sg13cmos5l_Corner_1.vss sg13cmos5l_Corner_1.vss sg13_lv_nmos ad=0.187p pd=1.78u as=0.14875p ps=1.16u w=0.55u l=0.13u
M1456 adc8b_0.side_cap8b_0.buf_32_0.z adc8b_0.side_cap8b_0.in_l_sw[0] sg13cmos5l_Corner_1.vss sg13cmos5l_Corner_1.vss sg13_lv_nmos ad=95f pd=0.88u as=95f ps=0.88u w=0.5u l=0.13u
M1457 a_82284_98522# adc8b_0.sar12b_0.sg13cmos5l_dfrbp_1_6.D a_82190_98522# sg13cmos5l_Corner_1.vss sg13_lv_nmos ad=60.89999f pd=0.71u as=0.1428p ps=1.52u w=0.42u l=0.13u
M1458 a_98445_97301# adc8b_0.sar12b_0.sg13cmos5l_dfrbp_1_8.D vdd vdd sg13_lv_pmos ad=0.4088p pd=2.97u as=1.04815p ps=6.595u w=1.12u l=0.13u
M1459 a_99706_97322# adc8b_0.sar12b_0.sg13cmos5l_dfrbp_1_6.RESET_B sg13cmos5l_Corner_1.vss sg13cmos5l_Corner_1.vss sg13_lv_nmos ad=37.8f pd=0.6u as=79.8f ps=0.8u w=0.42u l=0.13u
M1460 a_100131_95430# adc8b_0.sar12b_0.sg13cmos5l_buf_8_1.A vdd vdd sg13_lv_pmos ad=0.2128p pd=1.5u as=0.2128p ps=1.5u w=1.12u l=0.13u
M1461 adc8b_0.side_cap8b_0.buf_16_2.z adc8b_0.side_cap8b_0.in_l_sw[1] vddr vddr sg13_lv_pmos ad=0.19p pd=1.38u as=0.19p ps=1.38u w=1u l=0.13u
M1462 vdd a_99287_97399# a_100124_97620# vdd sg13_lv_pmos ad=0.2128p pd=1.5u as=0.3864p ps=2.93u w=1.12u l=0.13u
M1463 sg13cmos5l_Corner_1.iovdd a_164624_102044# sg13cmos5l_IOPadAnalog_16.pad sg13cmos5l_Corner_1.iovdd sg13_hv_pmos ad=2.1312p pd=7.3u as=3.9294p ps=7.84u w=6.66u l=0.6u
X1464 a_36456_138715# a_40542_139045# sg13cmos5l_Corner_1.vss rppd l=20u w=1u
M1465 vddr adc8b_0.sar12b_0.nh_sw[9] adc8b_0.side_cap8b_1.buf_2_3.z vddr sg13_lv_pmos ad=0.19p pd=1.38u as=0.34p ps=2.68u w=1u l=0.13u
M1466 sg13cmos5l_Corner_1.vss adc8b_0.sar12b_0.nl_sw[1] adc8b_0.side_cap8b_1.buf_16_2.z sg13cmos5l_Corner_1.vss sg13_lv_nmos ad=95f pd=0.88u as=95f ps=0.88u w=0.5u l=0.13u
M1467 sg13cmos5l_Corner_1.vss adc8b_0.sar12b_0.sg13cmos5l_inv_1_3.A a_96784_100384# sg13cmos5l_Corner_1.vss sg13_lv_nmos ad=0.14875p pd=1.16u as=0.187p ps=1.78u w=0.55u l=0.13u
M1468 vdd a_82893_98095# a_82995_98095# vdd sg13_lv_pmos ad=1.07253p pd=6.75u as=0.3864p ps=2.93u w=1.12u l=0.13u
M1469 sg13cmos5l_Corner_1.vss a_131639_178370# sg13cmos5l_IOPadAnalog_12.pad sg13cmos5l_Corner_1.vss sg13_hv_nmos ad=2.068p pd=9.74u as=2.596p ps=5.58u w=4.4u l=0.6u
M1470 vdd a_87981_95071# a_88083_95071# vdd sg13_lv_pmos ad=1.43437p pd=9.105u as=0.3864p ps=2.93u w=1.12u l=0.13u
M1471 adc8b_0.side_cap8b_1.buf_8_3.z adc8b_0.sar12b_0.nh_sw[3] sg13cmos5l_Corner_1.vss sg13cmos5l_Corner_1.vss sg13_lv_nmos ad=0.17p pd=1.68u as=95f ps=0.88u w=0.5u l=0.13u
M1472 adc8b_0.side_cap8b_1.buf_32_1.z adc8b_0.sar12b_0.nh_sw[0] vddr vddr sg13_lv_pmos ad=0.19p pd=1.38u as=0.19p ps=1.38u w=1u l=0.13u
M1473 vddr adc8b_0.sar12b_0.nl_sw[2] adc8b_0.side_cap8b_1.buf_16_1.z vddr sg13_lv_pmos ad=0.19p pd=1.38u as=0.19p ps=1.38u w=1u l=0.13u
M1474 a_92188_96920# adc8b_0.sar12b_0.sg13cmos5l_dfrbp_1_16.Q sg13cmos5l_Corner_1.vss sg13cmos5l_Corner_1.vss sg13_lv_nmos ad=0.1406p pd=1.12u as=0.1406p ps=1.12u w=0.74u l=0.13u
M1475 vdd a_90879_95826# a_91010_95820# vdd sg13_lv_pmos ad=1.28962p pd=8.195u as=0.2856p ps=2.36u w=0.84u l=0.13u
M1476 sg13cmos5l_IOPadAnalog_1.pad a_164624_70044# sg13cmos5l_Corner_1.iovdd sg13cmos5l_Corner_1.iovdd sg13_hv_pmos ad=3.9294p pd=7.84u as=2.1312p ps=7.3u w=6.66u l=0.6u
M1477 vdd adc8b_0.sar12b_0.sg13cmos5l_dlhr_1_15.Q a_101008_98872# vdd sg13_lv_pmos ad=0.2114p pd=1.54u as=0.2856p ps=2.36u w=0.84u l=0.13u
M1478 vip a_30676_102044# sg13cmos5l_Corner_1.vss sg13cmos5l_Corner_1.vss sg13_hv_nmos ad=2.596p pd=5.58u as=1.408p ps=5.04u w=4.4u l=0.6u
M1479 vdd adc8b_0.sar12b_0.sg13cmos5l_dfrbp_1_8.RESET_B a_97550_98522# vdd sg13_lv_pmos ad=0.36237p pd=2.605u as=79.8f ps=0.8u w=0.42u l=0.13u
M1480 sg13cmos5l_Corner_1.vss adc8b_0.sar12b_0.sg13cmos5l_dfrbp_1_0.Q a_96022_93604# sg13cmos5l_Corner_1.vss sg13_lv_nmos ad=0.17255p pd=1.25u as=0.187p ps=1.78u w=0.55u l=0.13u
M1481 sg13cmos5l_Corner_1.vss adc8b_0.side_cap8b_0.in_h_sw[3] adc8b_0.side_cap8b_0.buf_8_3.z sg13cmos5l_Corner_1.vss sg13_lv_nmos ad=95f pd=0.88u as=95f ps=0.88u w=0.5u l=0.13u
M1482 sg13cmos5l_Corner_1.vss adc8b_0.sar12b_0.nh_sw[1] adc8b_0.side_cap8b_1.buf_16_3.z sg13cmos5l_Corner_1.vss sg13_lv_nmos ad=95f pd=0.88u as=0.17p ps=1.68u w=0.5u l=0.13u
M1483 adc8b_0.sar12b_0.sg13cmos5l_buf_1_5.X a_96208_92824# sg13cmos5l_Corner_1.vss sg13cmos5l_Corner_1.vss sg13_lv_nmos ad=0.2886p pd=2.26u as=0.14875p ps=1.16u w=0.74u l=0.13u
M1484 sg13cmos5l_IOPadAnalog_13.pad a_115639_178370# sg13cmos5l_Corner_1.vss sg13cmos5l_Corner_1.vss sg13_hv_nmos ad=2.596p pd=5.58u as=1.408p ps=5.04u w=4.4u l=0.6u
M1485 sg13cmos5l_Corner_1.vss sg13cmos5l_IOPadVdd$1_0.sg13cmos5l_RCClampInverter$1_0.in sg13cmos5l_Corner_1.vss sg13cmos5l_Corner_1.vss sg13_hv_nmos ad=1.71p pd=9.38u as=0 ps=0 w=9u l=9.5u
M1486 vdd a_84333_95071# a_84435_95071# vdd sg13_lv_pmos ad=1.43437p pd=9.105u as=0.3864p ps=2.93u w=1.12u l=0.13u
M1487 adc8b_0.side_cap8b_1.buf_32_0.z adc8b_0.sar12b_0.nl_sw[0] sg13cmos5l_Corner_1.vss sg13cmos5l_Corner_1.vss sg13_lv_nmos ad=95f pd=0.88u as=95f ps=0.88u w=0.5u l=0.13u
M1488 sg13cmos5l_Corner_1.vss a_90932_92750# adc8b_0.sar12b_0.sg13cmos5l_buf_1_26.X sg13cmos5l_Corner_1.vss sg13_lv_nmos ad=0.14875p pd=1.16u as=0.2886p ps=2.26u w=0.74u l=0.13u
M1489 a_88863_92802# adc8b_0.sar12b_0.sg13cmos5l_dlhr_1_0.GATE sg13cmos5l_Corner_1.vss sg13cmos5l_Corner_1.vss sg13_lv_nmos ad=0.2516p pd=2.16u as=0.15055p ps=1.17u w=0.74u l=0.13u
M1490 sg13cmos5l_Corner_1.vss a_87092_92750# adc8b_0.sar12b_0.sg13cmos5l_buf_1_39.A sg13cmos5l_Corner_1.vss sg13_lv_nmos ad=0.14875p pd=1.16u as=0.2886p ps=2.26u w=0.74u l=0.13u
M1491 sg13cmos5l_IOPadAnalog_12.pad a_131639_178370# sg13cmos5l_Corner_1.vss sg13cmos5l_Corner_1.vss sg13_hv_nmos ad=2.596p pd=5.58u as=1.408p ps=5.04u w=4.4u l=0.6u
M1492 frame a_134044_42476# sg13cmos5l_Corner_1.iovdd sg13cmos5l_Corner_1.iovdd sg13_hv_pmos ad=3.9294p pd=7.84u as=2.1312p ps=7.3u w=6.66u l=0.6u
M1493 vddr adc8b_0.sar12b_0.nh_sw[3] adc8b_0.side_cap8b_1.buf_8_3.z vddr sg13_lv_pmos ad=0.19p pd=1.38u as=0.19p ps=1.38u w=1u l=0.13u
M1494 a_91839_98442# adc8b_0.sar12b_0.sg13cmos5l_dfrbp_1_18.Q vdd vdd sg13_lv_pmos ad=0.3234p pd=2.45u as=1.07253p ps=6.75u w=0.84u l=0.13u
M1495 adc8b_0.side_cap8b_0.buf_32_1.z adc8b_0.side_cap8b_0.in_h_sw[0] sg13cmos5l_Corner_1.vss sg13cmos5l_Corner_1.vss sg13_lv_nmos ad=95f pd=0.88u as=95f ps=0.88u w=0.5u l=0.13u
M1496 a_89976_98084# a_89425_98442# vdd vdd sg13_lv_pmos ad=0.105p pd=1.21u as=1.07253p ps=6.75u w=1u l=0.13u
M1497 sg13cmos5l_Corner_1.iovdd a_67639_164698# sg13cmos5l_IOPadAnalog_10.pad sg13cmos5l_Corner_1.iovdd sg13_hv_pmos ad=2.1312p pd=7.3u as=3.9294p ps=7.84u w=6.66u l=0.6u
M1498 sg13cmos5l_Corner_1.vss sg13cmos5l_IOPadVdd$1_0.sg13cmos5l_RCClampInverter$1_0.in sg13cmos5l_Corner_1.vss sg13cmos5l_Corner_1.vss sg13_hv_nmos ad=1.71p pd=9.38u as=0 ps=0 w=9u l=9.5u
M1499 a_88823_95421# a_87981_95071# a_87564_95064# vdd sg13_lv_pmos ad=0.2048p pd=1.63u as=0.34p ps=2.68u w=1u l=0.13u
M1500 sg13cmos5l_Corner_1.vss adc8b_0.sar12b_0.sg13cmos5l_dfrbp_1_6.RESET_B a_83916_94298# sg13cmos5l_Corner_1.vss sg13_lv_nmos ad=0.1626p pd=1.415u as=60.89999f ps=0.71u w=0.42u l=0.13u
M1501 cko a_118044_30676# sg13cmos5l_Corner_1.vss sg13cmos5l_Corner_1.vss sg13_hv_nmos ad=2.596p pd=5.58u as=2.068p ps=9.74u w=4.4u l=0.6u
M1502 a_100984_94518# adc8b_0.sar12b_0.sg13cmos5l_dfrbp_1_0.RESET_B vdd vdd sg13_lv_pmos ad=79.8f pd=0.8u as=1.38655p ps=8.8u w=0.42u l=0.13u
M1503 sg13cmos5l_Corner_1.vss adc8b_0.sar12b_0.sg13cmos5l_buf_1_110.A a_97552_100384# sg13cmos5l_Corner_1.vss sg13_lv_nmos ad=0.14875p pd=1.16u as=0.187p ps=1.78u w=0.55u l=0.13u
M1504 vdd adc8b_0.sar12b_0.sg13cmos5l_dfrbp_1_6.RESET_B a_96494_98834# vdd sg13_lv_pmos ad=0.36237p pd=2.605u as=79.8f ps=0.8u w=0.42u l=0.13u
M1505 a_96513_94613# a_95571_94420# a_96311_94375# vdd sg13_lv_pmos ad=93.45f pd=0.865u as=0.2048p ps=1.63u w=0.42u l=0.13u
M1506 cko a_118044_42476# sg13cmos5l_Corner_1.iovdd sg13cmos5l_Corner_1.iovdd sg13_hv_pmos ad=3.9294p pd=7.84u as=2.1312p ps=7.3u w=6.66u l=0.6u
M1507 adc8b_0.sar12b_0.sg13cmos5l_dfrbp_1_23.Q a_96380_97620# vdd vdd sg13_lv_pmos ad=0.3808p pd=2.92u as=0.2128p ps=1.5u w=1.12u l=0.13u
M1508 adc8b_0.side_cap8b_1.buf_32_1.z adc8b_0.sar12b_0.nh_sw[0] sg13cmos5l_Corner_1.vss sg13cmos5l_Corner_1.vss sg13_lv_nmos ad=95f pd=0.88u as=95f ps=0.88u w=0.5u l=0.13u
M1509 sg13cmos5l_IOPadVdd$1_0.sg13cmos5l_Clamp_N43N43D4R$1_0.gate sg13cmos5l_IOPadVdd$1_0.sg13cmos5l_RCClampInverter$1_0.in vdd vdd sg13_hv_pmos ad=1.33p pd=7.38u as=1.33p ps=7.38u w=7u l=0.5u
M1510 sg13cmos5l_Corner_1.vss adc8b_0.side_cap8b_0.in_h_sw[1] adc8b_0.side_cap8b_0.buf_16_3.z sg13cmos5l_Corner_1.vss sg13_lv_nmos ad=95f pd=0.88u as=0.17p ps=1.68u w=0.5u l=0.13u
M1511 a_83716_99124# a_84116_98784# a_84074_98820# sg13cmos5l_Corner_1.vss sg13_lv_nmos ad=0.2516p pd=2.16u as=77.7f ps=0.95u w=0.74u l=0.13u
X1512 sg13cmos5l_Corner_1.vss a_67639_178370# sg13cmos5l_Corner_1.vss rppd l=3.54u w=0.5u
M1513 cks a_42476_118044# sg13cmos5l_Corner_1.iovdd sg13cmos5l_Corner_1.iovdd sg13_hv_pmos ad=3.9294p pd=7.84u as=2.1312p ps=7.3u w=6.66u l=0.6u
M1514 adc8b_0.sar12b_0.sg13cmos5l_dfrbp_1_4.Q_N a_94487_93909# sg13cmos5l_Corner_1.vss sg13cmos5l_Corner_1.vss sg13_lv_nmos ad=0.2849p pd=2.25u as=0.2516p ps=2.16u w=0.74u l=0.13u
M1515 sg13cmos5l_Corner_1.vss sg13cmos5l_IOPadVdd$1_0.sg13cmos5l_Clamp_N43N43D4R$1_0.gate vdd sg13cmos5l_Corner_1.vss sg13_hv_nmos ad=1.408p pd=5.04u as=3.256p ps=10.28u w=4.4u l=0.6u
M1516 adc8b_0.side_cap8b_0.buf_32_0.z adc8b_0.side_cap8b_0.in_l_sw[0] vddr vddr sg13_lv_pmos ad=0.19p pd=1.38u as=0.19p ps=1.38u w=1u l=0.13u
M1517 adc8b_0.diff_bsw_0.single_bsw_0.sg13cmos5l_inv_1$1_2.Y adc8b_0.diff_bsw_0.single_bsw_0.sg13cmos5l_inv_1$1_2.A vdd vdd sg13_lv_pmos ad=0.3808p pd=2.92u as=0.3808p ps=2.92u w=1.12u l=0.13u
M1518 adc8b_0.cmp_0.rdy a_80806_96705# sg13cmos5l_Corner_1.vss sg13cmos5l_Corner_1.vss sg13_lv_nmos ad=0.2516p pd=2.16u as=0.1426p ps=1.16u w=0.74u l=0.13u
M1519 vddr adc8b_0.sar12b_0.nh_sw[4] adc8b_0.side_cap8b_1.buf_8_2.z vddr sg13_lv_pmos ad=0.19p pd=1.38u as=0.19p ps=1.38u w=1u l=0.13u
M1520 adc8b_0.side_cap8b_0.buf_4_0.z adc8b_0.side_cap8b_0.in_l_sw[7] sg13cmos5l_Corner_1.vss sg13cmos5l_Corner_1.vss sg13_lv_nmos ad=95f pd=0.88u as=95f ps=0.88u w=0.5u l=0.13u
M1521 vdd adc8b_0.sar12b_0.sg13cmos5l_dlhr_1_15.D a_99313_98888# vdd sg13_lv_pmos ad=1.15047p pd=7.175u as=0.2856p ps=2.36u w=0.84u l=0.13u
M1522 vdd sg13cmos5l_IOPadVdd$1_0.sg13cmos5l_Clamp_N43N43D4R$1_0.gate sg13cmos5l_Corner_1.vss sg13cmos5l_Corner_1.vss sg13_hv_nmos ad=2.596p pd=5.58u as=1.408p ps=5.04u w=4.4u l=0.6u
M1523 sg13cmos5l_Corner_1.vss adc8b_0.sar12b_0.sg13cmos5l_dfrbp_1_23.Q a_95560_96920# sg13cmos5l_Corner_1.vss sg13_lv_nmos ad=0.1406p pd=1.12u as=0.1406p ps=1.12u w=0.74u l=0.13u
M1524 a_98894_92786# a_99699_92908# a_99154_93009# vdd sg13_lv_pmos ad=0.1428p pd=1.52u as=79.8f ps=0.8u w=0.42u l=0.13u
M1525 sg13cmos5l_Corner_1.iovdd a_102044_42476# data[2] sg13cmos5l_Corner_1.iovdd sg13_hv_pmos ad=2.1312p pd=7.3u as=3.9294p ps=7.84u w=6.66u l=0.6u
M1526 a_95543_97399# a_94701_97301# a_95449_97399# sg13cmos5l_Corner_1.vss sg13_lv_nmos ad=0.12665p pd=1.145u as=0.1428p ps=1.52u w=0.42u l=0.13u
M1527 adc8b_0.side_cap8b_0.buf_16_2.z adc8b_0.side_cap8b_0.in_l_sw[1] sg13cmos5l_Corner_1.vss sg13cmos5l_Corner_1.vss sg13_lv_nmos ad=0.17p pd=1.68u as=95f ps=0.88u w=0.5u l=0.13u
M1528 sg13cmos5l_Corner_1.vss adc8b_0.sar12b_0.sg13cmos5l_dfrbp_1_6.RESET_B a_92476_100332# sg13cmos5l_Corner_1.vss sg13_lv_nmos ad=0.1406p pd=1.12u as=77.7f ps=0.95u w=0.74u l=0.13u
M1529 a_83822_94298# a_84627_94420# a_84082_94521# vdd sg13_lv_pmos ad=0.1428p pd=1.52u as=79.8f ps=0.8u w=0.42u l=0.13u
M1530 adc8b_0.sar12b_0.sg13cmos5l_buf_8_2.X a_100995_100350# vdd vdd sg13_lv_pmos ad=0.2128p pd=1.5u as=0.2128p ps=1.5u w=1.12u l=0.13u
M1531 data[0] a_70044_42476# sg13cmos5l_Corner_1.iovdd sg13cmos5l_Corner_1.iovdd sg13_hv_pmos ad=3.9294p pd=7.84u as=2.1312p ps=7.3u w=6.66u l=0.6u
M1532 a_83252_97286# adc8b_0.sar12b_0.sg13cmos5l_buf_1_58.A vdd vdd sg13_lv_pmos ad=0.2856p pd=2.36u as=0.2114p ps=1.54u w=0.84u l=0.13u
M1533 a_101180_97644# a_100898_97332# a_101113_97314# sg13cmos5l_Corner_1.vss sg13_lv_nmos ad=0.141p pd=1.17u as=71.99999f ps=0.865u w=0.64u l=0.13u
M1534 a_97617_93595# a_97260_93552# vdd vdd sg13_lv_pmos ad=63f pd=0.72u as=0.1563p ps=1.22u w=0.42u l=0.13u
M1535 sg13cmos5l_IOPadAnalog_9.pad a_83639_178370# sg13cmos5l_Corner_1.vss sg13cmos5l_Corner_1.vss sg13_hv_nmos ad=2.596p pd=5.58u as=1.408p ps=5.04u w=4.4u l=0.6u
M1536 sg13cmos5l_Corner_1.iovdd a_42476_118044# cks sg13cmos5l_Corner_1.iovdd sg13_hv_pmos ad=2.1312p pd=7.3u as=3.9294p ps=7.84u w=6.66u l=0.6u
M1537 adc8b_0.sar12b_0.sg13cmos5l_dfrbp_1_1.D adc8b_0.sar12b_0.sg13cmos5l_a22oi_1_2.B1 a_91591_93524# vdd sg13_lv_pmos ad=0.2128p pd=1.5u as=0.2716p ps=1.605u w=1.12u l=0.13u
M1538 vin a_42476_86044# sg13cmos5l_Corner_1.iovdd sg13cmos5l_Corner_1.iovdd sg13_hv_pmos ad=3.9294p pd=7.84u as=3.1302p ps=14.26u w=6.66u l=0.6u
M1539 sg13cmos5l_Corner_1.vss adc8b_0.side_cap8b_0.in_h_sw[6] adc8b_0.side_cap8b_0.buf_4_1.z sg13cmos5l_Corner_1.vss sg13_lv_nmos ad=95f pd=0.88u as=0.17p ps=1.68u w=0.5u l=0.13u
M1540 a_86126_98084# a_85730_98448# a_86012_98084# vdd sg13_lv_pmos ad=0.1008p pd=0.9u as=0.191p ps=1.44u w=0.42u l=0.13u
M1541 cko a_118044_42476# sg13cmos5l_Corner_1.iovdd sg13cmos5l_Corner_1.iovdd sg13_hv_pmos ad=3.9294p pd=7.84u as=2.1312p ps=7.3u w=6.66u l=0.6u
M1542 a_96974_93986# adc8b_0.sar12b_0.sg13cmos5l_nor2b_1_1.Y vdd vdd sg13_lv_pmos ad=79.8f pd=0.8u as=0.1428p ps=1.52u w=0.42u l=0.13u
M1543 adc8b_0.sar12b_0.sg13cmos5l_buf_1_65.X a_82192_99596# vdd vdd sg13_lv_pmos ad=0.42p pd=2.99u as=0.2114p ps=1.54u w=1.12u l=0.13u
M1544 vdd sg13cmos5l_Corner_1.vss vdd vdd sg13_lv_pmos ad=0.34p pd=2.68u as=0 ps=0 w=1u l=1u
M1545 vdd sg13cmos5l_IOPadVdd$1_0.sg13cmos5l_Clamp_N43N43D4R$1_0.gate sg13cmos5l_Corner_1.vss sg13cmos5l_Corner_1.vss sg13_hv_nmos ad=2.596p pd=5.58u as=1.408p ps=5.04u w=4.4u l=0.6u
M1546 a_84204_100021# a_84435_99607# a_83890_99564# sg13cmos5l_Corner_1.vss sg13_lv_nmos ad=0.2373p pd=1.97u as=79.8f ps=0.8u w=0.42u l=0.13u
M1547 sg13cmos5l_Corner_1.vss a_98039_98911# a_98876_99132# sg13cmos5l_Corner_1.vss sg13_lv_nmos ad=0.1406p pd=1.12u as=0.2516p ps=2.16u w=0.74u l=0.13u
M1548 sg13cmos5l_Corner_1.vss sg13cmos5l_IOPadVdd$1_0.sg13cmos5l_Clamp_N43N43D4R$1_0.gate vdd sg13cmos5l_Corner_1.vss sg13_hv_nmos ad=2.068p pd=9.74u as=2.596p ps=5.58u w=4.4u l=0.6u
M1549 sg13cmos5l_Corner_1.vss a_131639_178370# sg13cmos5l_IOPadAnalog_12.pad sg13cmos5l_Corner_1.vss sg13_hv_nmos ad=1.408p pd=5.04u as=2.596p ps=5.58u w=4.4u l=0.6u
M1550 a_90620_97644# a_90207_97338# a_90552_97644# vdd sg13_lv_pmos ad=0.191p pd=1.44u as=0.105p ps=1.21u w=1u l=0.13u
M1551 a_89818_95810# adc8b_0.sar12b_0.sg13cmos5l_dfrbp_1_8.RESET_B sg13cmos5l_Corner_1.vss sg13cmos5l_Corner_1.vss sg13_lv_nmos ad=37.8f pd=0.6u as=79.8f ps=0.8u w=0.42u l=0.13u
M1552 vdd a_100995_95814# adc8b_0.sar12b_0.sg13cmos5l_buf_8_0.X vdd sg13_lv_pmos ad=0.2128p pd=1.5u as=0.2128p ps=1.5u w=1.12u l=0.13u
M1553 vdd sg13cmos5l_IOPadVdd$1_0.sg13cmos5l_Clamp_N43N43D4R$1_0.gate sg13cmos5l_Corner_1.vss sg13cmos5l_Corner_1.vss sg13_hv_nmos ad=2.596p pd=5.58u as=1.408p ps=5.04u w=4.4u l=0.6u
M1554 sg13cmos5l_Corner_1.vss adc8b_0.sar12b_0.sg13cmos5l_buf_1_18.A a_100144_93548# sg13cmos5l_Corner_1.vss sg13_lv_nmos ad=0.14875p pd=1.16u as=0.187p ps=1.78u w=0.55u l=0.13u
M1555 a_94744_93790# a_94487_93909# a_94906_93986# sg13cmos5l_Corner_1.vss sg13_lv_nmos ad=0.1428p pd=1.52u as=37.8f ps=0.6u w=0.42u l=0.13u
M1556 a_82764_98509# a_82476_98088# a_82702_98509# sg13cmos5l_Corner_1.vss sg13_lv_nmos ad=0.1428p pd=1.52u as=37.8f ps=0.6u w=0.42u l=0.13u
M1557 w_71686_98280# a_68824_97392# vdd sg13cmos5l_Corner_1.vss sg13_lv_nmos ad=0.442p pd=3.28u as=0.442p ps=3.28u w=1.3u l=0.13u
X1558 sg13cmos5l_IOPadAnalog_15.padres sg13cmos5l_Corner_1.iovdd dpantenna l=0.64u w=4.98u
M1559 adc8b_0.sar12b_0.sg13cmos5l_dlhr_1_5.Q a_90225_98441# vdd vdd sg13_lv_pmos ad=0.3808p pd=2.92u as=0.2128p ps=1.5u w=1.12u l=0.13u
M1560 sg13cmos5l_Corner_1.vss adc8b_0.sar12b_0.sg13cmos5l_dfrbp_1_6.RESET_B a_86796_93986# sg13cmos5l_Corner_1.vss sg13_lv_nmos ad=0.1626p pd=1.415u as=60.89999f ps=0.71u w=0.42u l=0.13u
X1561 sg13cmos5l_Corner_1.vss sg13cmos5l_Corner_1.iovdd dpantenna l=1.26u w=27.78u
M1562 a_95254_96920# adc8b_0.sar12b_0.sg13cmos5l_nor2b_1_0.Y sg13cmos5l_Corner_1.vss sg13cmos5l_Corner_1.vss sg13_lv_nmos ad=0.1406p pd=1.12u as=0.2516p ps=2.16u w=0.74u l=0.13u
M1563 sg13cmos5l_IOPadAnalog_11.pad a_178296_118044# sg13cmos5l_Corner_1.vss sg13cmos5l_Corner_1.vss sg13_hv_nmos ad=2.596p pd=5.58u as=1.408p ps=5.04u w=4.4u l=0.6u
M1564 a_94583_92863# a_93741_92765# a_93324_93104# vdd sg13_lv_pmos ad=0.2048p pd=1.63u as=0.34p ps=2.68u w=1u l=0.13u
M1565 sg13cmos5l_Corner_1.vss a_178296_70044# sg13cmos5l_IOPadAnalog_1.pad sg13cmos5l_Corner_1.vss sg13_hv_nmos ad=1.408p pd=5.04u as=2.596p ps=5.58u w=4.4u l=0.6u
M1566 adc8b_0.sar12b_0.sg13cmos5l_dfrbp_1_3.Q_N a_100727_94375# sg13cmos5l_Corner_1.vss sg13cmos5l_Corner_1.vss sg13_lv_nmos ad=0.2849p pd=2.25u as=0.2516p ps=2.16u w=0.74u l=0.13u
M1567 a_99167_95107# adc8b_0.sar12b_0.sg13cmos5l_dfrbp_1_6.D a_99914_95498# sg13cmos5l_Corner_1.vss sg13_lv_nmos ad=0.1428p pd=1.52u as=60.89999f ps=0.71u w=0.42u l=0.13u
M1568 sg13cmos5l_Corner_1.iovdd a_42476_86044# vin sg13cmos5l_Corner_1.iovdd sg13_hv_pmos ad=2.1312p pd=7.3u as=3.9294p ps=7.84u w=6.66u l=0.6u
X1569 sg13cmos5l_Corner_1.vss sg13cmos5l_IOPadAnalog_12.padres dantenna l=3.1u w=0.64u
M1570 vdd adc8b_0.sar12b_0.sg13cmos5l_buf_1_30.A adc8b_0.sar12b_0.sg13cmos5l_buf_1_73.A vdd sg13_lv_pmos ad=0.3808p pd=2.92u as=0.3808p ps=2.92u w=1.12u l=0.13u
M1571 a_99160_96030# adc8b_0.sar12b_0.sg13cmos5l_dfrbp_1_8.RESET_B vdd vdd sg13_lv_pmos ad=79.8f pd=0.8u as=1.2517p ps=7.955u w=0.42u l=0.13u
M1572 adc8b_0.sar12b_0.sg13cmos5l_o21ai_1_0.Y adc8b_0.sar12b_0.sg13cmos5l_o21ai_1_0.A2 a_93888_94616# vdd sg13_lv_pmos ad=0.2128p pd=1.5u as=0.2128p ps=1.5u w=1.12u l=0.15u
M1573 adc8b_0.side_cap8b_0.buf_32_1.z adc8b_0.side_cap8b_0.in_h_sw[0] sg13cmos5l_Corner_1.vss sg13cmos5l_Corner_1.vss sg13_lv_nmos ad=95f pd=0.88u as=95f ps=0.88u w=0.5u l=0.13u
M1574 sg13cmos5l_Corner_1.iovdd a_42476_102044# vip sg13cmos5l_Corner_1.iovdd sg13_hv_pmos ad=3.1302p pd=14.26u as=3.9294p ps=7.84u w=6.66u l=0.6u
M1575 sg13cmos5l_Corner_1.vss adc8b_0.sar12b_0.nl_sw[0] adc8b_0.side_cap8b_1.buf_32_0.z sg13cmos5l_Corner_1.vss sg13_lv_nmos ad=95f pd=0.88u as=95f ps=0.88u w=0.5u l=0.13u
M1576 a_88113_99643# a_87756_99600# vdd vdd sg13_lv_pmos ad=63f pd=0.72u as=0.1563p ps=1.22u w=0.42u l=0.13u
M1577 a_90957_99607# adc8b_0.sar12b_0.sg13cmos5l_inv_1_2.A sg13cmos5l_Corner_1.vss sg13cmos5l_Corner_1.vss sg13_lv_nmos ad=0.2516p pd=2.16u as=2.71505p ps=17.54u w=0.74u l=0.13u
M1578 sg13cmos5l_Corner_1.vss cks adc8b_0.sar12b_0.sg13cmos5l_dfrbp_1_0.RESET_B sg13cmos5l_Corner_1.vss sg13_lv_nmos ad=0.2516p pd=2.16u as=0.2516p ps=2.16u w=0.74u l=0.13u
M1579 vddr adc8b_0.side_cap8b_0.in_h_sw[5] adc8b_0.side_cap8b_0.buf_8_5.z vddr sg13_lv_pmos ad=0.19p pd=1.38u as=0.19p ps=1.38u w=1u l=0.13u
M1580 vdd a_96657_98441# a_96590_98084# vdd sg13_lv_pmos ad=0.2387p pd=1.84u as=0.1008p ps=0.9u w=0.42u l=0.13u
M1581 sg13cmos5l_Corner_1.vss sg13cmos5l_IOPadVdd$1_0.sg13cmos5l_Clamp_N43N43D4R$1_0.gate vdd sg13cmos5l_Corner_1.vss sg13_hv_nmos ad=1.408p pd=5.04u as=2.596p ps=5.58u w=4.4u l=0.6u
M1582 adc8b_0.cmp_0.outp adc8b_0.cmp_0.outn a_73970_98361# sg13cmos5l_Corner_1.vss sg13_lv_nmos ad=0.95p pd=5.38u as=1.7p ps=10.68u w=5u l=0.13u
M1583 sg13cmos5l_Corner_1.vss a_96351_96930# a_96482_96936# sg13cmos5l_Corner_1.vss sg13_lv_nmos ad=1.97045p pd=12.335u as=0.2775p ps=2.23u w=0.74u l=0.13u
M1584 sg13cmos5l_Corner_1.iovdd a_134044_42476# frame sg13cmos5l_Corner_1.iovdd sg13_hv_pmos ad=2.1312p pd=7.3u as=3.9294p ps=7.84u w=6.66u l=0.6u
M1585 sg13cmos5l_Corner_1.vss a_178296_118044# sg13cmos5l_IOPadAnalog_11.pad sg13cmos5l_Corner_1.vss sg13_hv_nmos ad=1.408p pd=5.04u as=2.596p ps=5.58u w=4.4u l=0.6u
M1586 a_96730_94298# adc8b_0.sar12b_0.sg13cmos5l_dfrbp_1_0.RESET_B sg13cmos5l_Corner_1.vss sg13cmos5l_Corner_1.vss sg13_lv_nmos ad=37.8f pd=0.6u as=79.8f ps=0.8u w=0.42u l=0.13u
M1587 sg13cmos5l_Corner_1.vss a_30676_70044# vddr sg13cmos5l_Corner_1.vss sg13_hv_nmos ad=1.408p pd=5.04u as=2.596p ps=5.58u w=4.4u l=0.6u
M1588 vddr adc8b_0.side_cap8b_0.in_h_sw[0] adc8b_0.side_cap8b_0.buf_32_1.z vddr sg13_lv_pmos ad=0.19p pd=1.38u as=0.19p ps=1.38u w=1u l=0.13u
M1589 a_90158_98084# a_89762_98448# a_90044_98084# vdd sg13_lv_pmos ad=0.1008p pd=0.9u as=0.191p ps=1.44u w=0.42u l=0.13u
M1590 vdd adc8b_0.sar12b_0.sg13cmos5l_buf_8_0.A a_100995_95814# vdd sg13_lv_pmos ad=0.2128p pd=1.5u as=0.2128p ps=1.5u w=1.12u l=0.13u
M1591 cko a_118044_42476# sg13cmos5l_Corner_1.iovdd sg13cmos5l_Corner_1.iovdd sg13_hv_pmos ad=3.9294p pd=7.84u as=2.1312p ps=7.3u w=6.66u l=0.6u
M1592 adc8b_0.sar12b_0.sg13cmos5l_buf_1_4.X a_98320_92824# sg13cmos5l_Corner_1.vss sg13cmos5l_Corner_1.vss sg13_lv_nmos ad=0.2886p pd=2.26u as=0.14875p ps=1.16u w=0.74u l=0.13u
M1593 vin a_30676_86044# sg13cmos5l_Corner_1.vss sg13cmos5l_Corner_1.vss sg13_hv_nmos ad=2.596p pd=5.58u as=1.408p ps=5.04u w=4.4u l=0.6u
M1594 sg13cmos5l_Corner_1.vss a_100767_97338# a_100898_97332# sg13cmos5l_Corner_1.vss sg13_lv_nmos ad=1.97045p pd=12.335u as=0.2775p ps=2.23u w=0.74u l=0.13u
M1595 a_90015_96930# adc8b_0.sar12b_0.sg13cmos5l_dfrbp_1_11.Q sg13cmos5l_Corner_1.vss sg13cmos5l_Corner_1.vss sg13_lv_nmos ad=0.2516p pd=2.16u as=0.15055p ps=1.17u w=0.74u l=0.13u
M1596 sg13cmos5l_IOPadAnalog_13.pad a_115639_178370# sg13cmos5l_Corner_1.vss sg13cmos5l_Corner_1.vss sg13_hv_nmos ad=2.596p pd=5.58u as=1.408p ps=5.04u w=4.4u l=0.6u
M1597 adc8b_0.diff_bsw_0.single_bsw_0.sg13cmos5l_inv_1$1_0.Y adc8b_0.diff_bsw_0.single_bsw_0.sg13cmos5l_inv_1$1_0.A sg13cmos5l_Corner_1.vss sg13cmos5l_Corner_1.vss sg13_lv_nmos ad=0.2516p pd=2.16u as=0.2516p ps=2.16u w=0.74u l=0.13u
M1598 adc8b_0.side_cap8b_1.buf_8_5.z adc8b_0.sar12b_0.nh_sw[5] sg13cmos5l_Corner_1.vss sg13cmos5l_Corner_1.vss sg13_lv_nmos ad=95f pd=0.88u as=95f ps=0.88u w=0.5u l=0.13u
M1599 a_87276_93973# a_86988_93552# a_87214_93973# sg13cmos5l_Corner_1.vss sg13_lv_nmos ad=0.1428p pd=1.52u as=37.8f ps=0.6u w=0.42u l=0.13u
M1600 sg13cmos5l_Corner_1.iovdd a_99639_164698# sg13cmos5l_IOPadAnalog_15.pad sg13cmos5l_Corner_1.iovdd sg13_hv_pmos ad=2.1312p pd=7.3u as=3.9294p ps=7.84u w=6.66u l=0.6u
M1601 sg13cmos5l_Corner_1.vss adc8b_0.sar12b_0.sg13cmos5l_dlhr_1_1.GATE a_86117_98796# sg13cmos5l_Corner_1.vss sg13_lv_nmos ad=0.15055p pd=1.17u as=0.2516p ps=2.16u w=0.74u l=0.13u
M1602 adc8b_0.side_cap8b_1.buf_32_0.z adc8b_0.sar12b_0.nl_sw[0] vddr vddr sg13_lv_pmos ad=0.19p pd=1.38u as=0.19p ps=1.38u w=1u l=0.13u
M1603 adc8b_0.sar12b_0.nh_sw[3] a_87472_92824# sg13cmos5l_Corner_1.vss sg13cmos5l_Corner_1.vss sg13_lv_nmos ad=0.2886p pd=2.26u as=0.14875p ps=1.16u w=0.74u l=0.13u
M1604 sg13cmos5l_Corner_1.iovdd a_42476_70044# vddr sg13cmos5l_Corner_1.iovdd sg13_hv_pmos ad=2.1312p pd=7.3u as=3.9294p ps=7.84u w=6.66u l=0.6u
M1605 adc8b_0.sar12b_0.sg13cmos5l_inv_1_1.A a_96976_97360# sg13cmos5l_Corner_1.vss sg13cmos5l_Corner_1.vss sg13_lv_nmos ad=0.2886p pd=2.26u as=0.14875p ps=1.16u w=0.74u l=0.13u
M1606 data[1] a_86044_30676# sg13cmos5l_Corner_1.vss sg13cmos5l_Corner_1.vss sg13_hv_nmos ad=2.596p pd=5.58u as=1.408p ps=5.04u w=4.4u l=0.6u
M1607 vdd adc8b_0.sar12b_0.sg13cmos5l_dfrbp_1_8.RESET_B a_90254_100034# vdd sg13_lv_pmos ad=0.36237p pd=2.605u as=79.8f ps=0.8u w=0.42u l=0.13u
M1608 sg13cmos5l_Corner_1.iovdd a_164624_102044# sg13cmos5l_IOPadAnalog_16.pad sg13cmos5l_Corner_1.iovdd sg13_hv_pmos ad=2.1312p pd=7.3u as=3.9294p ps=7.84u w=6.66u l=0.6u
M1609 sg13cmos5l_Corner_1.vss adc8b_0.sar12b_0.sg13cmos5l_dlhr_1_0.D a_88657_92840# sg13cmos5l_Corner_1.vss sg13_lv_nmos ad=0.15055p pd=1.17u as=0.187p ps=1.78u w=0.55u l=0.13u
M1610 sg13cmos5l_IOPadVdd$1_0.sg13cmos5l_Clamp_N43N43D4R$1_0.gate sg13cmos5l_IOPadVdd$1_0.sg13cmos5l_RCClampInverter$1_0.in vdd vdd sg13_hv_pmos ad=1.33p pd=7.38u as=1.33p ps=7.38u w=7u l=0.5u
X1611 sg13cmos5l_Corner_1.vss a_134222_33862# dantenna l=1.26u w=27.78u
M1612 vddr adc8b_0.side_cap8b_0.in_l_sw[0] adc8b_0.side_cap8b_0.buf_32_0.z vddr sg13_lv_pmos ad=0.19p pd=1.38u as=0.34p ps=2.68u w=1u l=0.13u
M1613 adc8b_0.sar12b_0.sg13cmos5l_buf_1_107.X a_99664_100384# vdd vdd sg13_lv_pmos ad=0.42p pd=2.99u as=0.2114p ps=1.54u w=1.12u l=0.13u
M1614 vip a_42476_102044# sg13cmos5l_Corner_1.iovdd sg13cmos5l_Corner_1.iovdd sg13_hv_pmos ad=3.9294p pd=7.84u as=2.1312p ps=7.3u w=6.66u l=0.6u
M1615 adc8b_0.sar12b_0.sg13cmos5l_dfrbp_1_24.Q_N a_95159_100423# vdd vdd sg13_lv_pmos ad=0.4312p pd=3.01u as=0.2639p ps=1.81u w=1.12u l=0.13u
M1616 adc8b_0.sar12b_0.sg13cmos5l_buf_8_2.X a_100995_100350# vdd vdd sg13_lv_pmos ad=0.2128p pd=1.5u as=0.2128p ps=1.5u w=1.12u l=0.13u
M1617 vdd adc8b_0.sar12b_0.sg13cmos5l_dfrbp_1_10.Q a_86641_94352# vdd sg13_lv_pmos ad=1.43437p pd=9.105u as=0.2856p ps=2.36u w=0.84u l=0.13u
M1618 adc8b_0.sar12b_0.sg13cmos5l_dlhr_1_0.Q a_89457_92786# vdd vdd sg13_lv_pmos ad=0.3808p pd=2.92u as=0.2128p ps=1.5u w=1.12u l=0.13u
M1619 a_93202_93516# a_93645_93559# a_93585_93595# vdd sg13_lv_pmos ad=79.8f pd=0.8u as=63f ps=0.72u w=0.42u l=0.13u
M1620 adc8b_0.sar12b_0.sg13cmos5l_dlhr_1_11.Q a_94929_98441# sg13cmos5l_Corner_1.vss sg13cmos5l_Corner_1.vss sg13_lv_nmos ad=0.2516p pd=2.16u as=0.1406p ps=1.12u w=0.74u l=0.13u
M1621 vdd a_92180_97286# adc8b_0.sar12b_0.sg13cmos5l_buf_1_29.A vdd sg13_lv_pmos ad=0.2114p pd=1.54u as=0.42p ps=2.99u w=1.12u l=0.13u
M1622 cko a_118044_30676# sg13cmos5l_Corner_1.vss sg13cmos5l_Corner_1.vss sg13_hv_nmos ad=2.596p pd=5.58u as=1.408p ps=5.04u w=4.4u l=0.6u
M1623 adc8b_0.side_cap8b_1.buf_4_0.z adc8b_0.sar12b_0.nl_sw[7] vddr vddr sg13_lv_pmos ad=0.19p pd=1.38u as=0.19p ps=1.38u w=1u l=0.13u
M1624 sg13cmos5l_Corner_1.vss adc8b_0.sar12b_0.nl_sw[2] adc8b_0.side_cap8b_1.buf_16_1.z sg13cmos5l_Corner_1.vss sg13_lv_nmos ad=95f pd=0.88u as=95f ps=0.88u w=0.5u l=0.13u
M1625 sg13cmos5l_Corner_1.vss a_30676_86044# vin sg13cmos5l_Corner_1.vss sg13_hv_nmos ad=1.408p pd=5.04u as=2.596p ps=5.58u w=4.4u l=0.6u
M1626 vdd adc8b_0.sar12b_0.sg13cmos5l_buf_1_40.A a_82960_92824# vdd sg13_lv_pmos ad=0.2114p pd=1.54u as=0.2856p ps=2.36u w=0.84u l=0.13u
M1627 sg13cmos5l_Corner_1.vss adc8b_0.side_cap8b_0.in_l_sw[1] adc8b_0.side_cap8b_0.buf_16_2.z sg13cmos5l_Corner_1.vss sg13_lv_nmos ad=95f pd=0.88u as=95f ps=0.88u w=0.5u l=0.13u
M1628 sg13cmos5l_Corner_1.vss adc8b_0.sar12b_0.sg13cmos5l_dfrbp_1_6.RESET_B a_100348_98820# sg13cmos5l_Corner_1.vss sg13_lv_nmos ad=0.1406p pd=1.12u as=77.7f ps=0.95u w=0.74u l=0.13u
M1629 sg13cmos5l_Corner_1.vss a_178296_102044# sg13cmos5l_IOPadAnalog_16.pad sg13cmos5l_Corner_1.vss sg13_hv_nmos ad=2.068p pd=9.74u as=2.596p ps=5.58u w=4.4u l=0.6u
M1630 vdd sg13cmos5l_IOPadVdd$1_0.sg13cmos5l_Clamp_N43N43D4R$1_0.gate sg13cmos5l_Corner_1.vss sg13cmos5l_Corner_1.vss sg13_hv_nmos ad=2.596p pd=5.58u as=1.408p ps=5.04u w=4.4u l=0.6u
M1631 sg13cmos5l_Corner_1.vss a_89272_99838# a_88921_99957# sg13cmos5l_Corner_1.vss sg13_lv_nmos ad=79.8f pd=0.8u as=0.1428p ps=1.52u w=0.42u l=0.13u
M1632 sg13cmos5l_Corner_1.vss adc8b_0.sar12b_0.sg13cmos5l_dfrbp_1_6.RESET_B a_95644_98820# sg13cmos5l_Corner_1.vss sg13_lv_nmos ad=0.1406p pd=1.12u as=77.7f ps=0.95u w=0.74u l=0.13u
M1633 vdd adc8b_0.sar12b_0.sg13cmos5l_dfrbp_1_6.RESET_B a_97972_95498# vdd sg13_lv_pmos ad=1.38655p pd=8.8u as=79.8f ps=0.8u w=0.42u l=0.13u
M1634 adc8b_0.sar12b_0.nh_sw[1] a_84592_93548# vdd vdd sg13_lv_pmos ad=0.42p pd=2.99u as=0.2114p ps=1.54u w=1.12u l=0.13u
M1635 vdd a_94840_93006# a_94785_93101# vdd sg13_lv_pmos ad=1.86162p pd=11.935u as=93.45f ps=0.865u w=0.42u l=0.13u
M1636 adc8b_0.side_cap8b_0.buf_16_1.z adc8b_0.side_cap8b_0.in_l_sw[2] vddr vddr sg13_lv_pmos ad=0.19p pd=1.38u as=0.19p ps=1.38u w=1u l=0.13u
M1637 adc8b_0.sar12b_0.sg13cmos5l_dfrbp_1_20.Q_N a_90551_98911# sg13cmos5l_Corner_1.vss sg13cmos5l_Corner_1.vss sg13_lv_nmos ad=0.2849p pd=2.25u as=0.2516p ps=2.16u w=0.74u l=0.13u
M1638 sg13cmos5l_Corner_1.vss adc8b_0.sar12b_0.sg13cmos5l_dfrbp_1_6.RESET_B a_96588_98834# sg13cmos5l_Corner_1.vss sg13_lv_nmos ad=0.1626p pd=1.415u as=60.89999f ps=0.71u w=0.42u l=0.13u
M1639 a_83916_99600# a_84435_99607# a_85175_99957# sg13cmos5l_Corner_1.vss sg13_lv_nmos ad=0.3473p pd=2.71u as=0.12665p ps=1.145u w=0.74u l=0.13u
M1640 sg13cmos5l_Corner_1.iovdd a_70044_42476# data[0] sg13cmos5l_Corner_1.iovdd sg13_hv_pmos ad=2.1312p pd=7.3u as=3.9294p ps=7.84u w=6.66u l=0.6u
M1641 vddr adc8b_0.sar12b_0.nl_sw[5] adc8b_0.side_cap8b_1.buf_8_4.z vddr sg13_lv_pmos ad=0.19p pd=1.38u as=0.19p ps=1.38u w=1u l=0.13u
M1642 sg13cmos5l_Corner_1.vss a_94583_92863# a_95420_93084# sg13cmos5l_Corner_1.vss sg13_lv_nmos ad=0.1406p pd=1.12u as=0.2516p ps=2.16u w=0.74u l=0.13u
M1643 cks a_42476_118044# sg13cmos5l_Corner_1.iovdd sg13cmos5l_Corner_1.iovdd sg13_hv_pmos ad=3.9294p pd=7.84u as=2.1312p ps=7.3u w=6.66u l=0.6u
M1644 a_83992_98326# adc8b_0.sar12b_0.sg13cmos5l_dfrbp_1_6.RESET_B vdd vdd sg13_lv_pmos ad=79.8f pd=0.8u as=1.04815p ps=6.595u w=0.42u l=0.13u
X1645 vip sg13cmos5l_IOPadAnalog_14.padres sg13cmos5l_Corner_1.vss rppd l=2u w=1u
M1646 adc8b_0.cmp_0.outp adc8b_0.cmp_0.clk vdd vdd sg13_lv_pmos ad=0.17p pd=1.68u as=95f ps=0.88u w=0.5u l=0.13u
M1647 a_90808_99054# adc8b_0.sar12b_0.sg13cmos5l_dfrbp_1_6.RESET_B vdd vdd sg13_lv_pmos ad=79.8f pd=0.8u as=1.12242p ps=7u w=0.42u l=0.13u
M1648 sg13cmos5l_Corner_1.vss a_102044_30676# data[2] sg13cmos5l_Corner_1.vss sg13_hv_nmos ad=1.408p pd=5.04u as=2.596p ps=5.58u w=4.4u l=0.6u
M1649 adc8b_0.sar12b_0.nh_sw[10] a_102160_94336# vdd vdd sg13_lv_pmos ad=0.42p pd=2.99u as=0.2114p ps=1.54u w=1.12u l=0.13u
M1650 a_89006_98834# adc8b_0.sar12b_0.sg13cmos5l_dfrbp_1_6.D vdd vdd sg13_lv_pmos ad=79.8f pd=0.8u as=0.1428p ps=1.52u w=0.42u l=0.13u
M1651 data[1] a_86044_42476# sg13cmos5l_Corner_1.iovdd sg13cmos5l_Corner_1.iovdd sg13_hv_pmos ad=3.9294p pd=7.84u as=2.1312p ps=7.3u w=6.66u l=0.6u
M1652 sg13cmos5l_Corner_1.vss adc8b_0.sar12b_0.nh_sw[6] adc8b_0.side_cap8b_1.buf_4_1.z sg13cmos5l_Corner_1.vss sg13_lv_nmos ad=95f pd=0.88u as=0.17p ps=1.68u w=0.5u l=0.13u
M1653 adc8b_0.side_cap8b_1.buf_32_1.z adc8b_0.sar12b_0.nh_sw[0] vddr vddr sg13_lv_pmos ad=0.19p pd=1.38u as=0.19p ps=1.38u w=1u l=0.13u
M1654 sg13cmos5l_Corner_1.iovdd a_67639_164698# sg13cmos5l_IOPadAnalog_10.pad sg13cmos5l_Corner_1.iovdd sg13_hv_pmos ad=2.1312p pd=7.3u as=3.9294p ps=7.84u w=6.66u l=0.6u
M1655 vddr adc8b_0.sar12b_0.nl_sw[2] adc8b_0.side_cap8b_1.buf_16_1.z vddr sg13_lv_pmos ad=0.19p pd=1.38u as=0.19p ps=1.38u w=1u l=0.13u
X1656 sg13cmos5l_Corner_1.vss a_70222_33862# dantenna l=1.26u w=27.78u
M1657 a_95161_98826# a_94609_98888# sg13cmos5l_Corner_1.vss sg13cmos5l_Corner_1.vss sg13_lv_nmos ad=71.99999f pd=0.865u as=1.49685p ps=9.6u w=0.64u l=0.13u
M1658 a_85175_95421# a_84333_95071# a_85081_95421# sg13cmos5l_Corner_1.vss sg13_lv_nmos ad=0.12665p pd=1.145u as=0.1428p ps=1.52u w=0.42u l=0.13u
M1659 a_84108_94616# a_84082_94521# sg13cmos5l_Corner_1.vss sg13cmos5l_Corner_1.vss sg13_lv_nmos ad=0.2516p pd=2.16u as=0.1626p ps=1.415u w=0.74u l=0.13u
M1660 cko a_118044_42476# sg13cmos5l_Corner_1.iovdd sg13cmos5l_Corner_1.iovdd sg13_hv_pmos ad=3.9294p pd=7.84u as=2.1312p ps=7.3u w=6.66u l=0.6u
M1661 sg13cmos5l_IOPadAnalog_0.pad a_164624_86044# sg13cmos5l_Corner_1.iovdd sg13cmos5l_Corner_1.iovdd sg13_hv_pmos ad=3.9294p pd=7.84u as=3.1302p ps=14.26u w=6.66u l=0.6u
M1662 a_88340_92750# adc8b_0.sar12b_0.sg13cmos5l_buf_1_24.A sg13cmos5l_Corner_1.vss sg13cmos5l_Corner_1.vss sg13_lv_nmos ad=0.187p pd=1.78u as=0.14875p ps=1.16u w=0.55u l=0.13u
M1663 a_92950_96108# adc8b_0.sar12b_0.sg13cmos5l_a221oi_1_0.B1 a_93162_96108# vdd sg13_lv_pmos ad=0.2128p pd=1.5u as=0.3808p ps=2.92u w=1.12u l=0.13u
M1664 vdd adc8b_0.sar12b_0.sg13cmos5l_dfrbp_1_6.RESET_B a_91790_98834# vdd sg13_lv_pmos ad=0.36237p pd=2.605u as=79.8f ps=0.8u w=0.42u l=0.13u
M1665 sg13cmos5l_Corner_1.vss a_95409_98834# a_95934_98816# sg13cmos5l_Corner_1.vss sg13_lv_nmos ad=0.1491p pd=1.18u as=0.187p ps=1.78u w=0.55u l=0.13u
M1666 a_87092_92750# adc8b_0.sar12b_0.sg13cmos5l_buf_1_34.X vdd vdd sg13_lv_pmos ad=0.2856p pd=2.36u as=0.2114p ps=1.54u w=0.84u l=0.13u
M1667 a_97452_95810# adc8b_0.sar12b_0.sg13cmos5l_dfrbp_1_8.D a_97358_95810# sg13cmos5l_Corner_1.vss sg13_lv_nmos ad=60.89999f pd=0.71u as=0.1428p ps=1.52u w=0.42u l=0.13u
M1668 sg13cmos5l_Corner_1.vss a_85940_92750# adc8b_0.sar12b_0.sg13cmos5l_buf_1_33.A sg13cmos5l_Corner_1.vss sg13_lv_nmos ad=0.14875p pd=1.16u as=0.2886p ps=2.26u w=0.74u l=0.13u
M1669 adc8b_0.side_cap8b_0.in_l_sw[4] a_87568_100384# vdd vdd sg13_lv_pmos ad=0.42p pd=2.99u as=0.2114p ps=1.54u w=1.12u l=0.13u
M1670 adc8b_0.sar12b_0.sg13cmos5l_buf_1_25.A adc8b_0.sar12b_0.sg13cmos5l_inv_1_14.A sg13cmos5l_Corner_1.vss sg13cmos5l_Corner_1.vss sg13_lv_nmos ad=0.2516p pd=2.16u as=0.2516p ps=2.16u w=0.74u l=0.13u
M1671 a_82450_98052# a_82893_98095# a_82190_98522# sg13cmos5l_Corner_1.vss sg13_lv_nmos ad=79.8f pd=0.8u as=0.1296p ps=1.52u w=0.42u l=0.13u
M1672 vip a_42476_102044# sg13cmos5l_Corner_1.iovdd sg13cmos5l_Corner_1.iovdd sg13_hv_pmos ad=3.9294p pd=7.84u as=2.1312p ps=7.3u w=6.66u l=0.6u
M1673 a_87588_96933# a_87719_96543# a_86837_96536# vdd sg13_lv_pmos ad=0.34p pd=2.68u as=0.2048p ps=1.63u w=1u l=0.13u
M1674 a_87538_95028# a_87981_95071# a_87278_95498# sg13cmos5l_Corner_1.vss sg13_lv_nmos ad=79.8f pd=0.8u as=0.1296p ps=1.52u w=0.42u l=0.13u
M1675 sg13cmos5l_Corner_1.vss adc8b_0.side_cap8b_0.in_h_sw[2] adc8b_0.side_cap8b_0.buf_16_0.z sg13cmos5l_Corner_1.vss sg13_lv_nmos ad=95f pd=0.88u as=95f ps=0.88u w=0.5u l=0.13u
M1676 sg13cmos5l_Corner_1.vss adc8b_0.sar12b_0.sg13cmos5l_dfrbp_1_0.RESET_B a_93036_93986# sg13cmos5l_Corner_1.vss sg13_lv_nmos ad=0.1626p pd=1.415u as=60.89999f ps=0.71u w=0.42u l=0.13u
M1677 a_88557_95789# adc8b_0.sar12b_0.sg13cmos5l_inv_1_8.A sg13cmos5l_Corner_1.vss sg13cmos5l_Corner_1.vss sg13_lv_nmos ad=0.2516p pd=2.16u as=2.27517p ps=14.72u w=0.74u l=0.13u
M1678 sg13cmos5l_Corner_1.iovdd a_164624_86044# sg13cmos5l_IOPadAnalog_0.pad sg13cmos5l_Corner_1.iovdd sg13_hv_pmos ad=2.1312p pd=7.3u as=3.9294p ps=7.84u w=6.66u l=0.6u
M1679 a_93645_93559# adc8b_0.sar12b_0.sg13cmos5l_dfrbp_1_0.CLK sg13cmos5l_Corner_1.vss sg13cmos5l_Corner_1.vss sg13_lv_nmos ad=0.2516p pd=2.16u as=2.43055p ps=15.415u w=0.74u l=0.13u
M1680 sg13cmos5l_Corner_1.vss a_84333_99607# a_84435_99607# sg13cmos5l_Corner_1.vss sg13_lv_nmos ad=2.92392p pd=18.89u as=0.2516p ps=2.16u w=0.74u l=0.13u
M1681 adc8b_0.sar12b_0.sg13cmos5l_buf_1_86.A a_101776_99596# vdd vdd sg13_lv_pmos ad=0.42p pd=2.99u as=0.2114p ps=1.54u w=1.12u l=0.13u
M1682 vdd adc8b_0.cmp_0.outp adc8b_0.cmp_0.outn vdd sg13_lv_pmos ad=0.2375p pd=1.63u as=0.425p ps=3.18u w=1.25u l=0.13u
M1683 sg13cmos5l_Corner_1.vss a_91796_97286# adc8b_0.sar12b_0.sg13cmos5l_inv_1_18.A sg13cmos5l_Corner_1.vss sg13_lv_nmos ad=0.14875p pd=1.16u as=0.2886p ps=2.26u w=0.74u l=0.13u
M1684 a_93984_96888# adc8b_0.sar12b_0.sg13cmos5l_dfrbp_1_21.Q sg13cmos5l_Corner_1.vss sg13cmos5l_Corner_1.vss sg13_lv_nmos ad=0.1045p pd=0.93u as=0.1469p ps=1.155u w=0.55u l=0.13u
M1685 sg13cmos5l_Corner_1.iovdd a_102044_42476# data[2] sg13cmos5l_Corner_1.iovdd sg13_hv_pmos ad=2.1312p pd=7.3u as=3.9294p ps=7.84u w=6.66u l=0.6u
M1686 sg13cmos5l_IOPadAnalog_12.pad a_131639_164698# sg13cmos5l_Corner_1.iovdd sg13cmos5l_Corner_1.iovdd sg13_hv_pmos ad=3.9294p pd=7.84u as=2.1312p ps=7.3u w=6.66u l=0.6u
M1687 adc8b_0.sar12b_0.sg13cmos5l_buf_8_2.X a_100995_100350# vdd vdd sg13_lv_pmos ad=0.2128p pd=1.5u as=0.2128p ps=1.5u w=1.12u l=0.13u
M1688 vddr adc8b_0.sar12b_0.nl_sw[0] adc8b_0.side_cap8b_1.buf_32_0.z vddr sg13_lv_pmos ad=0.19p pd=1.38u as=0.19p ps=1.38u w=1u l=0.13u
M1689 sg13cmos5l_Corner_1.vss sg13cmos5l_IOPadVdd$1_0.sg13cmos5l_Clamp_N43N43D4R$1_0.gate vdd sg13cmos5l_Corner_1.vss sg13_hv_nmos ad=1.408p pd=5.04u as=3.256p ps=10.28u w=4.4u l=0.6u
M1690 a_86193_98441# a_86012_98084# vdd vdd sg13_lv_pmos ad=0.2128p pd=1.5u as=0.2387p ps=1.84u w=1.12u l=0.13u
M1691 sg13cmos5l_IOPadAnalog_0.pad a_164624_86044# sg13cmos5l_Corner_1.iovdd sg13cmos5l_Corner_1.iovdd sg13_hv_pmos ad=3.9294p pd=7.84u as=2.1312p ps=7.3u w=6.66u l=0.6u
M1692 a_90356_93512# adc8b_0.sar12b_0.sg13cmos5l_buf_1_26.X vdd vdd sg13_lv_pmos ad=0.2856p pd=2.36u as=0.2114p ps=1.54u w=0.84u l=0.13u
M1693 a_92551_95452# adc8b_0.sar12b_0.sg13cmos5l_a22oi_1_0.B1 sg13cmos5l_Corner_1.vss sg13cmos5l_Corner_1.vss sg13_lv_nmos ad=0.13875p pd=1.115u as=0.2553p ps=2.17u w=0.74u l=0.13u
M1694 sg13cmos5l_IOPadAnalog_11.pad a_164624_118044# sg13cmos5l_Corner_1.iovdd sg13cmos5l_Corner_1.iovdd sg13_hv_pmos ad=3.9294p pd=7.84u as=3.1302p ps=14.26u w=6.66u l=0.6u
M1695 sg13cmos5l_Corner_1.vss adc8b_0.side_cap8b_0.in_l_sw[0] adc8b_0.side_cap8b_0.buf_32_0.z sg13cmos5l_Corner_1.vss sg13_lv_nmos ad=95f pd=0.88u as=95f ps=0.88u w=0.5u l=0.13u
M1696 adc8b_0.sar12b_0.sg13cmos5l_inv_1_3.A a_95536_99596# vdd vdd sg13_lv_pmos ad=0.42p pd=2.99u as=0.2114p ps=1.54u w=1.12u l=0.13u
M1697 adc8b_0.side_cap8b_0.buf_4_0.z adc8b_0.side_cap8b_0.in_l_sw[7] sg13cmos5l_Corner_1.vss sg13cmos5l_Corner_1.vss sg13_lv_nmos ad=0.17p pd=1.68u as=95f ps=0.88u w=0.5u l=0.13u
M1698 a_84110_96248# a_83714_95820# a_83996_96132# vdd sg13_lv_pmos ad=0.1008p pd=0.9u as=0.191p ps=1.44u w=0.42u l=0.13u
M1699 sg13cmos5l_Corner_1.vss a_134044_30676# frame sg13cmos5l_Corner_1.vss sg13_hv_nmos ad=1.408p pd=5.04u as=2.596p ps=5.58u w=4.4u l=0.6u
M1700 sg13cmos5l_Corner_1.vss adc8b_0.sar12b_0.sg13cmos5l_dfrbp_1_0.Q adc8b_0.sar12b_0.sg13cmos5l_dfrbp_1_0.D sg13cmos5l_Corner_1.vss sg13_lv_nmos ad=0.2516p pd=2.16u as=0.1406p ps=1.12u w=0.74u l=0.13u
M1701 vdd cks adc8b_0.sar12b_0.sg13cmos5l_dfrbp_1_0.RESET_B vdd sg13_lv_pmos ad=0.3808p pd=2.92u as=0.3808p ps=2.92u w=1.12u l=0.13u
M1702 vddr a_42476_70044# sg13cmos5l_Corner_1.iovdd sg13cmos5l_Corner_1.iovdd sg13_hv_pmos ad=3.9294p pd=7.84u as=3.1302p ps=14.26u w=6.66u l=0.6u
M1703 adc8b_0.side_cap8b_0.in_h_sw[4] a_88336_100384# vdd vdd sg13_lv_pmos ad=0.42p pd=2.99u as=0.2114p ps=1.54u w=1.12u l=0.13u
M1704 adc8b_0.sar12b_0.sg13cmos5l_nand2_1_1.A a_97148_94596# vdd vdd sg13_lv_pmos ad=0.3808p pd=2.92u as=0.2128p ps=1.5u w=1.12u l=0.13u
M1705 vdd adc8b_0.sar12b_0.sg13cmos5l_dfrbp_1_6.RESET_B a_87182_97322# vdd sg13_lv_pmos ad=0.36237p pd=2.605u as=79.8f ps=0.8u w=0.42u l=0.13u
M1706 a_94844_96536# adc8b_0.sar12b_0.sg13cmos5l_inv_1_0.A sg13cmos5l_Corner_1.vss sg13cmos5l_Corner_1.vss sg13_lv_nmos ad=0.187p pd=1.78u as=0.17255p ps=1.25u w=0.55u l=0.13u
M1707 a_93038_95498# a_93843_95071# a_93298_95028# vdd sg13_lv_pmos ad=0.1428p pd=1.52u as=79.8f ps=0.8u w=0.42u l=0.13u
M1708 cko a_118044_42476# sg13cmos5l_Corner_1.iovdd sg13cmos5l_Corner_1.iovdd sg13_hv_pmos ad=3.9294p pd=7.84u as=2.1312p ps=7.3u w=6.66u l=0.6u
M1709 vddr adc8b_0.side_cap8b_0.in_l_sw[4] adc8b_0.side_cap8b_0.buf_8_0.z vddr sg13_lv_pmos ad=0.19p pd=1.38u as=0.19p ps=1.38u w=1u l=0.13u
M1710 vdd a_95159_100423# a_95416_100566# vdd sg13_lv_pmos ad=0.2639p pd=1.81u as=79.8f ps=0.8u w=0.42u l=0.13u
X1711 sg13cmos5l_IOPadAnalog_12.pad sg13cmos5l_Corner_1.iovdd dpantenna l=1.26u w=27.78u
M1712 a_100977_96929# a_100796_96572# vdd vdd sg13_lv_pmos ad=0.2128p pd=1.5u as=0.2387p ps=1.84u w=1.12u l=0.13u
M1713 vddr a_42476_70044# sg13cmos5l_Corner_1.iovdd sg13cmos5l_Corner_1.iovdd sg13_hv_pmos ad=3.9294p pd=7.84u as=2.1312p ps=7.3u w=6.66u l=0.6u
M1714 sg13cmos5l_IOPadAnalog_16.pad a_164624_102044# sg13cmos5l_Corner_1.iovdd sg13cmos5l_Corner_1.iovdd sg13_hv_pmos ad=3.9294p pd=7.84u as=2.1312p ps=7.3u w=6.66u l=0.6u
M1715 adc8b_0.side_cap8b_0.buf_2_0.z adc8b_0.side_cap8b_0.in_h_sw[8] sg13cmos5l_Corner_1.vss sg13cmos5l_Corner_1.vss sg13_lv_nmos ad=0.17p pd=1.68u as=95f ps=0.88u w=0.5u l=0.13u
M1716 sg13cmos5l_Corner_1.iovdd a_164624_86044# sg13cmos5l_IOPadAnalog_0.pad sg13cmos5l_Corner_1.iovdd sg13_hv_pmos ad=2.1312p pd=7.3u as=3.9294p ps=7.84u w=6.66u l=0.6u
M1717 vdd sg13cmos5l_IOPadVdd$1_0.sg13cmos5l_Clamp_N43N43D4R$1_0.gate sg13cmos5l_Corner_1.vss sg13cmos5l_Corner_1.vss sg13_hv_nmos ad=2.596p pd=5.58u as=1.408p ps=5.04u w=4.4u l=0.6u
M1718 sg13cmos5l_Corner_1.iovdd a_164624_70044# sg13cmos5l_IOPadAnalog_1.pad sg13cmos5l_Corner_1.iovdd sg13_hv_pmos ad=2.1312p pd=7.3u as=3.9294p ps=7.84u w=6.66u l=0.6u
M1719 sg13cmos5l_Corner_1.iovdd a_164624_118044# sg13cmos5l_IOPadAnalog_11.pad sg13cmos5l_Corner_1.iovdd sg13_hv_pmos ad=2.1312p pd=7.3u as=3.9294p ps=7.84u w=6.66u l=0.6u
M1720 a_85844_96536# adc8b_0.sar12b_0.sg13cmos5l_dlhr_1_9.Q vdd vdd sg13_lv_pmos ad=0.2856p pd=2.36u as=0.2114p ps=1.54u w=0.84u l=0.13u
M1721 sg13cmos5l_Corner_1.vss a_30676_118044# cks sg13cmos5l_Corner_1.vss sg13_hv_nmos ad=1.408p pd=5.04u as=2.596p ps=5.58u w=4.4u l=0.6u
M1722 vddr adc8b_0.side_cap8b_0.in_l_sw[2] adc8b_0.side_cap8b_0.buf_16_1.z vddr sg13_lv_pmos ad=0.19p pd=1.38u as=0.19p ps=1.38u w=1u l=0.13u
M1723 sg13cmos5l_Corner_1.vss adc8b_0.sar12b_0.sg13cmos5l_inv_1_29.A adc8b_0.sar12b_0.sg13cmos5l_inv_1_29.Y sg13cmos5l_Corner_1.vss sg13_lv_nmos ad=0.2516p pd=2.16u as=0.2516p ps=2.16u w=0.74u l=0.13u
M1724 sg13cmos5l_IOPadAnalog_16.pad a_178296_102044# sg13cmos5l_Corner_1.vss sg13cmos5l_Corner_1.vss sg13_hv_nmos ad=2.596p pd=5.58u as=1.408p ps=5.04u w=4.4u l=0.6u
M1725 vdd sg13cmos5l_IOPadVdd$1_0.sg13cmos5l_Clamp_N43N43D4R$1_0.gate sg13cmos5l_Corner_1.vss sg13cmos5l_Corner_1.vss sg13_hv_nmos ad=2.596p pd=5.58u as=1.408p ps=5.04u w=4.4u l=0.6u
M1726 sg13cmos5l_Corner_1.vss adc8b_0.sar12b_0.sg13cmos5l_dfrbp_1_1.Q adc8b_0.sar12b_0.sg13cmos5l_inv_1_11.Y sg13cmos5l_Corner_1.vss sg13_lv_nmos ad=0.2516p pd=2.16u as=0.2516p ps=2.16u w=0.74u l=0.13u
M1727 vin a_30676_86044# sg13cmos5l_Corner_1.vss sg13cmos5l_Corner_1.vss sg13_hv_nmos ad=2.596p pd=5.58u as=1.408p ps=5.04u w=4.4u l=0.6u
M1728 a_97260_93552# a_97234_93516# vdd vdd sg13_lv_pmos ad=0.34p pd=2.68u as=0.36237p ps=2.605u w=1u l=0.13u
M1729 vdd a_88247_93909# a_89084_93548# vdd sg13_lv_pmos ad=0.2128p pd=1.5u as=0.3864p ps=2.93u w=1.12u l=0.13u
M1730 a_86044_93936# a_85628_93548# a_85809_93905# sg13cmos5l_Corner_1.vss sg13_lv_nmos ad=77.7f pd=0.95u as=0.2516p ps=2.16u w=0.74u l=0.13u
M1731 vdd adc8b_0.sar12b_0.sg13cmos5l_inv_1_19.A adc8b_0.sar12b_0.sg13cmos5l_buf_1_32.A vdd sg13_lv_pmos ad=0.3808p pd=2.92u as=0.3808p ps=2.92u w=1.12u l=0.13u
M1732 a_92001_99719# a_91059_99607# a_91799_99957# vdd sg13_lv_pmos ad=93.45f pd=0.865u as=0.2048p ps=1.63u w=0.42u l=0.13u
M1733 adc8b_0.side_cap8b_1.buf_4_2.z adc8b_0.sar12b_0.nh_sw[7] vddr vddr sg13_lv_pmos ad=0.34p pd=2.68u as=0.19p ps=1.38u w=1u l=0.13u
M1734 vdd sg13cmos5l_IOPadVdd$1_0.sg13cmos5l_RCClampInverter$1_0.in sg13cmos5l_IOPadVdd$1_0.sg13cmos5l_Clamp_N43N43D4R$1_0.gate vdd sg13_hv_pmos ad=1.33p pd=7.38u as=1.33p ps=7.38u w=7u l=0.5u
M1735 sg13cmos5l_Corner_1.iovdd a_102044_42476# data[2] sg13cmos5l_Corner_1.iovdd sg13_hv_pmos ad=2.1312p pd=7.3u as=3.9294p ps=7.84u w=6.66u l=0.6u
M1736 a_95361_100661# a_94419_100468# a_95159_100423# vdd sg13_lv_pmos ad=93.45f pd=0.865u as=0.2048p ps=1.63u w=0.42u l=0.13u
M1737 a_85644_95823# a_85356_96128# a_85582_95823# sg13cmos5l_Corner_1.vss sg13_lv_nmos ad=0.1428p pd=1.52u as=37.8f ps=0.6u w=0.42u l=0.13u
M1738 sg13cmos5l_Corner_1.vss adc8b_0.sar12b_0.nh_sw[3] adc8b_0.side_cap8b_1.buf_8_3.z sg13cmos5l_Corner_1.vss sg13_lv_nmos ad=95f pd=0.88u as=0.17p ps=1.68u w=0.5u l=0.13u
M1739 a_94284_97640# a_94803_97444# a_95543_97399# sg13cmos5l_Corner_1.vss sg13_lv_nmos ad=0.3473p pd=2.71u as=0.12665p ps=1.145u w=0.74u l=0.13u
M1740 sg13cmos5l_Corner_1.iovdd a_134044_42476# frame sg13cmos5l_Corner_1.iovdd sg13_hv_pmos ad=3.1302p pd=14.26u as=3.9294p ps=7.84u w=6.66u l=0.6u
M1741 adc8b_0.side_cap8b_1.buf_16_1.z adc8b_0.sar12b_0.nl_sw[2] vddr vddr sg13_lv_pmos ad=0.19p pd=1.38u as=0.19p ps=1.38u w=1u l=0.13u
M1742 sg13cmos5l_Corner_1.iovdd a_134044_42476# frame sg13cmos5l_Corner_1.iovdd sg13_hv_pmos ad=2.1312p pd=7.3u as=3.9294p ps=7.84u w=6.66u l=0.6u
M1743 vdd sg13cmos5l_IOPadVdd$1_0.sg13cmos5l_Clamp_N43N43D4R$1_0.gate sg13cmos5l_Corner_1.vss sg13cmos5l_Corner_1.vss sg13_hv_nmos ad=2.596p pd=5.58u as=1.408p ps=5.04u w=4.4u l=0.6u
M1744 vdd a_91799_99957# a_92636_99596# vdd sg13_lv_pmos ad=0.2128p pd=1.5u as=0.3864p ps=2.93u w=1.12u l=0.13u
M1745 sg13cmos5l_Corner_1.vss a_70044_30676# data[0] sg13cmos5l_Corner_1.vss sg13_hv_nmos ad=1.408p pd=5.04u as=2.596p ps=5.58u w=4.4u l=0.6u
M1746 sg13cmos5l_Corner_1.vss adc8b_0.side_cap8b_0.in_h_sw[5] adc8b_0.side_cap8b_0.buf_8_5.z sg13cmos5l_Corner_1.vss sg13_lv_nmos ad=95f pd=0.88u as=95f ps=0.88u w=0.5u l=0.13u
M1747 vdd adc8b_0.sar12b_0.sg13cmos5l_dfrbp_1_8.RESET_B a_83890_99564# vdd sg13_lv_pmos ad=0.1563p pd=1.22u as=0.147p ps=1.54u w=0.42u l=0.13u
M1748 a_96813_99607# adc8b_0.sar12b_0.sg13cmos5l_inv_1_2.A sg13cmos5l_Corner_1.vss sg13cmos5l_Corner_1.vss sg13_lv_nmos ad=0.2516p pd=2.16u as=2.71505p ps=17.54u w=0.74u l=0.13u
M1749 vddr a_30676_70044# sg13cmos5l_Corner_1.vss sg13cmos5l_Corner_1.vss sg13_hv_nmos ad=2.596p pd=5.58u as=1.408p ps=5.04u w=4.4u l=0.6u
M1750 sg13cmos5l_Corner_1.iovdd a_164624_70044# sg13cmos5l_IOPadAnalog_1.pad sg13cmos5l_Corner_1.iovdd sg13_hv_pmos ad=3.1302p pd=14.26u as=3.9294p ps=7.84u w=6.66u l=0.6u
M1751 a_95543_97399# a_94701_97301# a_94284_97640# vdd sg13_lv_pmos ad=0.2048p pd=1.63u as=0.34p ps=2.68u w=1u l=0.13u
M1752 sg13cmos5l_Corner_1.iovdd a_164624_102044# sg13cmos5l_IOPadAnalog_16.pad sg13cmos5l_Corner_1.iovdd sg13_hv_pmos ad=2.1312p pd=7.3u as=3.9294p ps=7.84u w=6.66u l=0.6u
M1753 sg13cmos5l_Corner_1.vss sg13cmos5l_IOPadVdd$1_0.sg13cmos5l_Clamp_N43N43D4R$1_0.gate vdd sg13cmos5l_Corner_1.vss sg13_hv_nmos ad=1.408p pd=5.04u as=2.596p ps=5.58u w=4.4u l=0.6u
M1754 vdd sg13cmos5l_IOPadVdd$1_0.sg13cmos5l_RCClampInverter$1_0.in sg13cmos5l_IOPadVdd$1_0.sg13cmos5l_Clamp_N43N43D4R$1_0.gate vdd sg13_hv_pmos ad=1.33p pd=7.38u as=1.33p ps=7.38u w=7u l=0.5u
M1755 vin a_42476_86044# sg13cmos5l_Corner_1.iovdd sg13cmos5l_Corner_1.iovdd sg13_hv_pmos ad=3.9294p pd=7.84u as=2.1312p ps=7.3u w=6.66u l=0.6u
M1756 data[2] a_102044_42476# sg13cmos5l_Corner_1.iovdd sg13cmos5l_Corner_1.iovdd sg13_hv_pmos ad=3.9294p pd=7.84u as=2.1312p ps=7.3u w=6.66u l=0.6u
M1757 vdd sg13cmos5l_IOPadVdd$1_0.sg13cmos5l_Clamp_N43N43D4R$1_0.gate sg13cmos5l_Corner_1.vss sg13cmos5l_Corner_1.vss sg13_hv_nmos ad=2.596p pd=5.58u as=1.408p ps=5.04u w=4.4u l=0.6u
M1758 vddr adc8b_0.side_cap8b_0.in_h_sw[1] adc8b_0.side_cap8b_0.buf_16_3.z vddr sg13_lv_pmos ad=0.19p pd=1.38u as=0.19p ps=1.38u w=1u l=0.13u
M1759 vddr adc8b_0.side_cap8b_0.in_h_sw[5] adc8b_0.side_cap8b_0.buf_8_5.z vddr sg13_lv_pmos ad=0.19p pd=1.38u as=0.19p ps=1.38u w=1u l=0.13u
M1760 a_99180_93104# a_99154_93009# vdd vdd sg13_lv_pmos ad=0.34p pd=2.68u as=0.36237p ps=2.605u w=1u l=0.13u
M1761 a_99442_94521# a_99885_94277# a_99825_94689# vdd sg13_lv_pmos ad=79.8f pd=0.8u as=63f ps=0.72u w=0.42u l=0.13u
M1762 vdd sg13cmos5l_IOPadVdd$1_0.sg13cmos5l_RCClampInverter$1_0.in sg13cmos5l_IOPadVdd$1_0.sg13cmos5l_Clamp_N43N43D4R$1_0.gate vdd sg13_hv_pmos ad=1.33p pd=7.38u as=1.33p ps=7.38u w=7u l=0.5u
M1763 a_83937_96695# a_82995_96583# a_83735_96933# vdd sg13_lv_pmos ad=93.45f pd=0.865u as=0.2048p ps=1.63u w=0.42u l=0.13u
M1764 adc8b_0.side_cap8b_0.in_h_sw[10] a_102160_98084# vdd vdd sg13_lv_pmos ad=0.42p pd=2.99u as=0.2114p ps=1.54u w=1.12u l=0.13u
M1765 adc8b_0.side_cap8b_1.buf_8_5.z adc8b_0.sar12b_0.nh_sw[5] sg13cmos5l_Corner_1.vss sg13cmos5l_Corner_1.vss sg13_lv_nmos ad=95f pd=0.88u as=95f ps=0.88u w=0.5u l=0.13u
X1766 a_36456_139375# a_40542_139705# sg13cmos5l_Corner_1.vss rppd l=20u w=1u
M1767 a_97644_96128# a_97618_96033# vdd vdd sg13_lv_pmos ad=0.34p pd=2.68u as=0.36237p ps=2.605u w=1u l=0.13u
M1768 a_93708_100346# adc8b_0.sar12b_0.sg13cmos5l_dlhr_1_11.GATE a_93614_100346# sg13cmos5l_Corner_1.vss sg13_lv_nmos ad=60.89999f pd=0.71u as=0.1428p ps=1.52u w=0.42u l=0.13u
M1769 vdd a_100439_92863# a_100696_93006# vdd sg13_lv_pmos ad=0.2639p pd=1.81u as=79.8f ps=0.8u w=0.42u l=0.13u
M1770 a_86702_93986# adc8b_0.sar12b_0.sg13cmos5l_dfrbp_1_6.D vdd vdd sg13_lv_pmos ad=79.8f pd=0.8u as=0.1428p ps=1.52u w=0.42u l=0.13u
M1771 adc8b_0.sar12b_0.sg13cmos5l_dlhr_1_5.Q a_90225_98441# sg13cmos5l_Corner_1.vss sg13cmos5l_Corner_1.vss sg13_lv_nmos ad=0.2516p pd=2.16u as=0.1406p ps=1.12u w=0.74u l=0.13u
M1772 adc8b_0.sar12b_0.sg13cmos5l_dlhr_1_5.Q_N a_90750_98514# sg13cmos5l_Corner_1.vss sg13cmos5l_Corner_1.vss sg13_lv_nmos ad=0.2516p pd=2.16u as=0.1491p ps=1.18u w=0.74u l=0.13u
M1773 a_94689_93671# a_93747_93559# a_94487_93909# vdd sg13_lv_pmos ad=93.45f pd=0.865u as=0.2048p ps=1.63u w=0.42u l=0.13u
M1774 adc8b_0.side_cap8b_0.buf_32_0.z adc8b_0.side_cap8b_0.in_l_sw[0] sg13cmos5l_Corner_1.vss sg13cmos5l_Corner_1.vss sg13_lv_nmos ad=95f pd=0.88u as=95f ps=0.88u w=0.5u l=0.13u
M1775 vdd a_95416_100566# a_95361_100661# vdd sg13_lv_pmos ad=4.11675p pd=27.17u as=93.45f ps=0.865u w=0.42u l=0.13u
M1776 a_87405_93559# adc8b_0.sar12b_0.sg13cmos5l_dlhr_1_0.GATE vdd vdd sg13_lv_pmos ad=0.4088p pd=2.97u as=1.777p ps=11.395u w=1.12u l=0.13u
M1777 vddr adc8b_0.side_cap8b_0.in_l_sw[0] adc8b_0.side_cap8b_0.buf_32_0.z vddr sg13_lv_pmos ad=0.19p pd=1.38u as=0.19p ps=1.38u w=1u l=0.13u
M1778 adc8b_0.sar12b_0.sg13cmos5l_buf_1_25.A adc8b_0.sar12b_0.sg13cmos5l_inv_1_14.A vdd vdd sg13_lv_pmos ad=0.3808p pd=2.92u as=0.3808p ps=2.92u w=1.12u l=0.13u
M1779 a_82964_99560# adc8b_0.sar12b_0.sg13cmos5l_buf_1_63.A vdd vdd sg13_lv_pmos ad=0.2856p pd=2.36u as=0.2114p ps=1.54u w=0.84u l=0.13u
M1780 sg13cmos5l_Corner_1.iovdd a_70044_42476# data[0] sg13cmos5l_Corner_1.iovdd sg13_hv_pmos ad=3.1302p pd=14.26u as=3.9294p ps=7.84u w=6.66u l=0.6u
M1781 vdd sg13cmos5l_IOPadVdd$1_0.sg13cmos5l_RCClampInverter$1_0.in sg13cmos5l_IOPadVdd$1_0.sg13cmos5l_Clamp_N43N43D4R$1_0.gate vdd sg13_hv_pmos ad=1.33p pd=7.38u as=1.33p ps=7.38u w=7u l=0.5u
M1782 sg13cmos5l_Corner_1.iovdd a_70044_42476# data[0] sg13cmos5l_Corner_1.iovdd sg13_hv_pmos ad=2.1312p pd=7.3u as=3.9294p ps=7.84u w=6.66u l=0.6u
M1783 sg13cmos5l_Corner_1.vss a_83348_93512# adc8b_0.sar12b_0.nh_sw[0] sg13cmos5l_Corner_1.vss sg13_lv_nmos ad=0.14875p pd=1.16u as=0.2886p ps=2.26u w=0.74u l=0.13u
M1784 vddr a_42476_70044# sg13cmos5l_Corner_1.iovdd sg13cmos5l_Corner_1.iovdd sg13_hv_pmos ad=3.9294p pd=7.84u as=2.1312p ps=7.3u w=6.66u l=0.6u
M1785 sg13cmos5l_Corner_1.vss adc8b_0.sar12b_0.sg13cmos5l_dfrbp_1_6.RESET_B a_91884_98834# sg13cmos5l_Corner_1.vss sg13_lv_nmos ad=0.1626p pd=1.415u as=60.89999f ps=0.71u w=0.42u l=0.13u
M1786 adc8b_0.side_cap8b_1.buf_4_0.z adc8b_0.sar12b_0.nl_sw[7] vddr vddr sg13_lv_pmos ad=0.34p pd=2.68u as=0.19p ps=1.38u w=1u l=0.13u
M1787 a_85844_96536# adc8b_0.sar12b_0.sg13cmos5l_dlhr_1_9.Q sg13cmos5l_Corner_1.vss sg13cmos5l_Corner_1.vss sg13_lv_nmos ad=0.187p pd=1.78u as=0.14875p ps=1.16u w=0.55u l=0.13u
M1788 a_68892_97356# a_68824_97392# vdd sg13cmos5l_Corner_1.vss sg13_lv_nmos ad=0.442p pd=3.28u as=0.442p ps=3.28u w=1.3u l=0.13u
M1789 vddr adc8b_0.sar12b_0.nh_sw[0] adc8b_0.side_cap8b_1.buf_32_1.z vddr sg13_lv_pmos ad=0.19p pd=1.38u as=0.19p ps=1.38u w=1u l=0.13u
M1790 sg13cmos5l_Corner_1.vss a_30676_86044# vin sg13cmos5l_Corner_1.vss sg13_hv_nmos ad=1.408p pd=5.04u as=2.596p ps=5.58u w=4.4u l=0.6u
M1791 sg13cmos5l_Corner_1.vss vdd sg13cmos5l_Corner_1.vss sg13cmos5l_Corner_1.vss sg13_lv_nmos ad=0.1428p pd=1.52u as=0 ps=0 w=0.42u l=1u
M1792 adc8b_0.side_cap8b_0.buf_16_1.z adc8b_0.side_cap8b_0.in_l_sw[2] vddr vddr sg13_lv_pmos ad=0.34p pd=2.68u as=0.19p ps=1.38u w=1u l=0.13u
M1793 a_99914_95498# adc8b_0.sar12b_0.sg13cmos5l_dfrbp_1_6.RESET_B sg13cmos5l_Corner_1.vss sg13cmos5l_Corner_1.vss sg13_lv_nmos ad=60.89999f pd=0.71u as=0.1626p ps=1.415u w=0.42u l=0.13u
M1794 vdd a_85624_94518# a_85569_94613# vdd sg13_lv_pmos ad=1.43437p pd=9.105u as=93.45f ps=0.865u w=0.42u l=0.13u
M1795 sg13cmos5l_Corner_1.vss sg13cmos5l_IOPadVdd$1_0.sg13cmos5l_RCClampInverter$1_0.in sg13cmos5l_Corner_1.vss sg13cmos5l_Corner_1.vss sg13_hv_nmos ad=1.71p pd=9.38u as=0 ps=0 w=9u l=9.5u
M1796 a_91036_97308# a_90620_97644# a_90801_97322# sg13cmos5l_Corner_1.vss sg13_lv_nmos ad=77.7f pd=0.95u as=0.2516p ps=2.16u w=0.74u l=0.13u
M1797 a_98028_97640# a_98547_97444# a_99287_97399# sg13cmos5l_Corner_1.vss sg13_lv_nmos ad=0.3473p pd=2.71u as=0.12665p ps=1.145u w=0.74u l=0.13u
M1798 sg13cmos5l_Corner_1.vss adc8b_0.side_cap8b_0.in_h_sw[0] adc8b_0.side_cap8b_0.buf_32_1.z sg13cmos5l_Corner_1.vss sg13_lv_nmos ad=95f pd=0.88u as=95f ps=0.88u w=0.5u l=0.13u
M1799 a_91591_93524# adc8b_0.sar12b_0.sg13cmos5l_a22oi_1_2.B2 adc8b_0.sar12b_0.sg13cmos5l_dfrbp_1_1.D vdd sg13_lv_pmos ad=0.2744p pd=1.61u as=0.2128p ps=1.5u w=1.12u l=0.13u
M1800 a_101972_96536# adc8b_0.sar12b_0.sg13cmos5l_dlhr_1_16.Q vdd vdd sg13_lv_pmos ad=0.2856p pd=2.36u as=0.2114p ps=1.54u w=0.84u l=0.13u
M1801 sg13cmos5l_Corner_1.iovdd a_42476_86044# vin sg13cmos5l_Corner_1.iovdd sg13_hv_pmos ad=2.1312p pd=7.3u as=3.9294p ps=7.84u w=6.66u l=0.6u
M1802 sg13cmos5l_Corner_1.vss a_89399_95887# a_90236_96108# sg13cmos5l_Corner_1.vss sg13_lv_nmos ad=0.1406p pd=1.12u as=0.2516p ps=2.16u w=0.74u l=0.13u
M1803 sg13cmos5l_Corner_1.vss a_90879_95826# a_91010_95820# sg13cmos5l_Corner_1.vss sg13_lv_nmos ad=2.41737p pd=15.64u as=0.2775p ps=2.23u w=0.74u l=0.13u
M1804 frame a_134044_42476# sg13cmos5l_Corner_1.iovdd sg13cmos5l_Corner_1.iovdd sg13_hv_pmos ad=3.9294p pd=7.84u as=2.1312p ps=7.3u w=6.66u l=0.6u
M1805 vdd sg13cmos5l_IOPadVdd$1_0.sg13cmos5l_Clamp_N43N43D4R$1_0.gate sg13cmos5l_Corner_1.vss sg13cmos5l_Corner_1.vss sg13_hv_nmos ad=2.596p pd=5.58u as=1.408p ps=5.04u w=4.4u l=0.6u
X1806 a_36456_140695# vdd sg13cmos5l_Corner_1.vss rppd l=20u w=1u
M1807 sg13cmos5l_IOPadAnalog_1.pad a_164624_70044# sg13cmos5l_Corner_1.iovdd sg13cmos5l_Corner_1.iovdd sg13_hv_pmos ad=3.9294p pd=7.84u as=3.1302p ps=14.26u w=6.66u l=0.6u
M1808 a_92232_93587# adc8b_0.sar12b_0.sg13cmos5l_nor2_1_0.A vdd vdd sg13_lv_pmos ad=0.1596p pd=1.22u as=0.4536p ps=2.76u w=0.84u l=0.13u
M1809 sg13cmos5l_Corner_1.vss sg13cmos5l_IOPadVdd$1_0.sg13cmos5l_RCClampInverter$1_0.in sg13cmos5l_Corner_1.vss sg13cmos5l_Corner_1.vss sg13_hv_nmos ad=1.71p pd=9.38u as=0 ps=0 w=9u l=9.5u
M1810 adc8b_0.side_cap8b_0.buf_32_1.z adc8b_0.side_cap8b_0.in_h_sw[0] vddr vddr sg13_lv_pmos ad=0.19p pd=1.38u as=0.19p ps=1.38u w=1u l=0.13u
M1811 cks a_42476_118044# sg13cmos5l_Corner_1.iovdd sg13cmos5l_Corner_1.iovdd sg13_hv_pmos ad=3.9294p pd=7.84u as=2.1312p ps=7.3u w=6.66u l=0.6u
M1812 sg13cmos5l_Corner_1.vss adc8b_0.side_cap8b_0.in_l_sw[3] adc8b_0.side_cap8b_0.buf_8_1.z sg13cmos5l_Corner_1.vss sg13_lv_nmos ad=95f pd=0.88u as=95f ps=0.88u w=0.5u l=0.13u
M1813 a_85076_100310# adc8b_0.sar12b_0.sg13cmos5l_buf_1_65.X sg13cmos5l_Corner_1.vss sg13cmos5l_Corner_1.vss sg13_lv_nmos ad=0.187p pd=1.78u as=0.14875p ps=1.16u w=0.55u l=0.13u
M1814 sg13cmos5l_Corner_1.vss a_100995_100350# adc8b_0.sar12b_0.sg13cmos5l_buf_8_2.X sg13cmos5l_Corner_1.vss sg13_lv_nmos ad=0.1406p pd=1.12u as=0.1406p ps=1.12u w=0.74u l=0.13u
M1815 vdd adc8b_0.sar12b_0.sg13cmos5l_dfrbp_1_8.RESET_B a_83630_100034# vdd sg13_lv_pmos ad=0.36237p pd=2.605u as=79.8f ps=0.8u w=0.42u l=0.13u
M1816 sg13cmos5l_Corner_1.vss a_91028_93512# adc8b_0.sar12b_0.nh_sw[4] sg13cmos5l_Corner_1.vss sg13_lv_nmos ad=0.14875p pd=1.16u as=0.2886p ps=2.26u w=0.74u l=0.13u
M1817 vdd sg13cmos5l_IOPadVdd$1_0.sg13cmos5l_RCClampInverter$1_0.in sg13cmos5l_IOPadVdd$1_0.sg13cmos5l_Clamp_N43N43D4R$1_0.gate vdd sg13_hv_pmos ad=1.33p pd=7.38u as=1.33p ps=7.38u w=7u l=0.5u
M1818 sg13cmos5l_IOPadAnalog_1.pad a_164624_70044# sg13cmos5l_Corner_1.iovdd sg13cmos5l_Corner_1.iovdd sg13_hv_pmos ad=3.9294p pd=7.84u as=2.1312p ps=7.3u w=6.66u l=0.6u
M1819 sg13cmos5l_Corner_1.vss a_100995_95814# adc8b_0.sar12b_0.sg13cmos5l_buf_8_0.X sg13cmos5l_Corner_1.vss sg13_lv_nmos ad=0.2516p pd=2.16u as=0.1406p ps=1.12u w=0.74u l=0.13u
M1820 sg13cmos5l_Corner_1.iovdd a_42476_86044# vin sg13cmos5l_Corner_1.iovdd sg13_hv_pmos ad=2.1312p pd=7.3u as=3.9294p ps=7.84u w=6.66u l=0.6u
M1821 vdd sg13cmos5l_Corner_1.vss vdd vdd sg13_lv_pmos ad=0.34p pd=2.68u as=0 ps=0 w=1u l=1u
M1822 adc8b_0.sar12b_0.sg13cmos5l_a22oi_1_1.B2 adc8b_0.sar12b_0.sg13cmos5l_dlhr_1_6.D a_95254_96920# sg13cmos5l_Corner_1.vss sg13_lv_nmos ad=0.2516p pd=2.16u as=0.1406p ps=1.12u w=0.74u l=0.13u
M1823 sg13cmos5l_Corner_1.vss a_91473_95810# a_91998_95792# sg13cmos5l_Corner_1.vss sg13_lv_nmos ad=0.1491p pd=1.18u as=0.187p ps=1.78u w=0.55u l=0.13u
M1824 sg13cmos5l_Corner_1.vss adc8b_0.sar12b_0.sg13cmos5l_a221oi_1_0.C1 a_92201_95408# sg13cmos5l_Corner_1.vss sg13_lv_nmos ad=0.2516p pd=2.16u as=0.1406p ps=1.12u w=0.74u l=0.13u
M1825 sg13cmos5l_IOPadAnalog_12.pad a_131639_164698# sg13cmos5l_Corner_1.iovdd sg13cmos5l_Corner_1.iovdd sg13_hv_pmos ad=3.9294p pd=7.84u as=2.1312p ps=7.3u w=6.66u l=0.6u
X1826 sg13cmos5l_Corner_1.vss sg13cmos5l_IOPadAnalog_14.padres dantenna l=0.64u w=3.1u
M1827 sg13cmos5l_Corner_1.vss a_92241_100346# a_92766_100328# sg13cmos5l_Corner_1.vss sg13_lv_nmos ad=0.1491p pd=1.18u as=0.187p ps=1.78u w=0.55u l=0.13u
M1828 vdd a_100628_98048# adc8b_0.side_cap8b_0.in_h_sw[9] vdd sg13_lv_pmos ad=0.2114p pd=1.54u as=0.42p ps=2.99u w=1.12u l=0.13u
M1829 vdd a_101780_92750# adc8b_0.sar12b_0.sg13cmos5l_buf_1_0.X vdd sg13_lv_pmos ad=0.2114p pd=1.54u as=0.42p ps=2.99u w=1.12u l=0.13u
M1830 a_99890_93548# adc8b_0.sar12b_0.sg13cmos5l_nor2_1_1.A vdd vdd sg13_lv_pmos ad=0.1176p pd=1.33u as=0.4032p ps=2.96u w=1.12u l=0.13u
M1831 sg13cmos5l_Corner_1.vss adc8b_0.sar12b_0.sg13cmos5l_a22oi_1_1.B1 a_96830_95452# sg13cmos5l_Corner_1.vss sg13_lv_nmos ad=0.2553p pd=2.17u as=0.13875p ps=1.115u w=0.74u l=0.13u
M1832 vdd adc8b_0.sar12b_0.sg13cmos5l_dfrbp_1_1.Q adc8b_0.sar12b_0.sg13cmos5l_inv_1_11.Y vdd sg13_lv_pmos ad=0.3808p pd=2.92u as=0.3808p ps=2.92u w=1.12u l=0.13u
M1833 sg13cmos5l_Corner_1.iovdd a_118044_42476# cko sg13cmos5l_Corner_1.iovdd sg13_hv_pmos ad=2.1312p pd=7.3u as=3.9294p ps=7.84u w=6.66u l=0.6u
M1834 adc8b_0.sar12b_0.sg13cmos5l_dfrbp_1_0.Q_N a_100439_92863# vdd vdd sg13_lv_pmos ad=0.4312p pd=3.01u as=0.2639p ps=1.81u w=1.12u l=0.13u
M1835 a_92076_99152# a_92050_99057# vdd vdd sg13_lv_pmos ad=0.34p pd=2.68u as=0.36237p ps=2.605u w=1u l=0.13u
M1836 a_86615_95887# a_85773_95789# a_85356_96128# vdd sg13_lv_pmos ad=0.2048p pd=1.63u as=0.34p ps=2.68u w=1u l=0.13u
M1837 adc8b_0.side_cap8b_0.in_h_sw[10] a_102160_98084# sg13cmos5l_Corner_1.vss sg13cmos5l_Corner_1.vss sg13_lv_nmos ad=0.2886p pd=2.26u as=0.14875p ps=1.16u w=0.74u l=0.13u
M1838 a_88929_97637# a_87987_97444# a_88727_97399# vdd sg13_lv_pmos ad=93.45f pd=0.865u as=0.2048p ps=1.63u w=0.42u l=0.13u
M1839 sg13cmos5l_Corner_1.iovdd a_42476_118044# cks sg13cmos5l_Corner_1.iovdd sg13_hv_pmos ad=2.1312p pd=7.3u as=3.9294p ps=7.84u w=6.66u l=0.6u
M1840 sg13cmos5l_Corner_1.vss adc8b_0.side_cap8b_0.in_h_sw[4] adc8b_0.side_cap8b_0.buf_8_2.z sg13cmos5l_Corner_1.vss sg13_lv_nmos ad=95f pd=0.88u as=95f ps=0.88u w=0.5u l=0.13u
M1841 sg13cmos5l_IOPadAnalog_1.pad a_164624_70044# sg13cmos5l_Corner_1.iovdd sg13cmos5l_Corner_1.iovdd sg13_hv_pmos ad=3.9294p pd=7.84u as=2.1312p ps=7.3u w=6.66u l=0.6u
M1842 adc8b_0.side_cap8b_1.buf_16_0.z adc8b_0.sar12b_0.nh_sw[2] vddr vddr sg13_lv_pmos ad=0.34p pd=2.68u as=0.19p ps=1.38u w=1u l=0.13u
M1843 sg13cmos5l_Corner_1.vss sg13cmos5l_IOPadVdd$1_0.sg13cmos5l_Clamp_N43N43D4R$1_0.gate vdd sg13cmos5l_Corner_1.vss sg13_hv_nmos ad=1.408p pd=5.04u as=2.596p ps=5.58u w=4.4u l=0.6u
M1844 sg13cmos5l_IOPadAnalog_16.pad a_164624_102044# sg13cmos5l_Corner_1.iovdd sg13cmos5l_Corner_1.iovdd sg13_hv_pmos ad=3.9294p pd=7.84u as=3.1302p ps=14.26u w=6.66u l=0.6u
X1845 sg13cmos5l_Corner_1.vss sg13cmos5l_IOPadVdd$1_0.sg13cmos5l_Clamp_N43N43D4R$1_0.gate dantenna l=0.48u w=0.48u
M1846 sg13cmos5l_Corner_1.vss adc8b_0.side_cap8b_0.in_h_sw[2] adc8b_0.side_cap8b_0.buf_16_0.z sg13cmos5l_Corner_1.vss sg13_lv_nmos ad=95f pd=0.88u as=95f ps=0.88u w=0.5u l=0.13u
M1847 adc8b_0.sar12b_0.sg13cmos5l_dlhr_1_18.Q_N a_92958_98514# sg13cmos5l_Corner_1.vss sg13cmos5l_Corner_1.vss sg13_lv_nmos ad=0.2516p pd=2.16u as=0.1491p ps=1.18u w=0.74u l=0.13u
M1848 a_95159_100423# a_94317_100325# a_95065_100423# sg13cmos5l_Corner_1.vss sg13_lv_nmos ad=0.12665p pd=1.145u as=0.1428p ps=1.52u w=0.42u l=0.13u
M1849 adc8b_0.sar12b_0.sg13cmos5l_buf_1_104.A adc8b_0.sar12b_0.sg13cmos5l_buf_1_3.A vdd vdd sg13_lv_pmos ad=0.3808p pd=2.92u as=0.3808p ps=2.92u w=1.12u l=0.13u
M1850 a_90207_97338# adc8b_0.sar12b_0.sg13cmos5l_dlhr_1_5.GATE sg13cmos5l_Corner_1.vss sg13cmos5l_Corner_1.vss sg13_lv_nmos ad=0.2516p pd=2.16u as=0.15055p ps=1.17u w=0.74u l=0.13u
M1851 sg13cmos5l_Corner_1.vss vdd sg13cmos5l_Corner_1.vss sg13cmos5l_Corner_1.vss sg13_lv_nmos ad=79.8f pd=0.8u as=0 ps=0 w=0.42u l=1u
M1852 adc8b_0.sar12b_0.sg13cmos5l_buf_8_0.X a_100995_95814# vdd vdd sg13_lv_pmos ad=0.2128p pd=1.5u as=0.2128p ps=1.5u w=1.12u l=0.13u
M1853 sg13cmos5l_Corner_1.iovdd a_102044_42476# data[2] sg13cmos5l_Corner_1.iovdd sg13_hv_pmos ad=2.1312p pd=7.3u as=3.9294p ps=7.84u w=6.66u l=0.6u
M1854 sg13cmos5l_Corner_1.vss adc8b_0.side_cap8b_0.in_l_sw[5] adc8b_0.side_cap8b_0.buf_8_4.z sg13cmos5l_Corner_1.vss sg13_lv_nmos ad=95f pd=0.88u as=0.17p ps=1.68u w=0.5u l=0.13u
M1855 data[0] a_70044_42476# sg13cmos5l_Corner_1.iovdd sg13cmos5l_Corner_1.iovdd sg13_hv_pmos ad=3.9294p pd=7.84u as=2.1312p ps=7.3u w=6.66u l=0.6u
M1856 sg13cmos5l_IOPadAnalog_16.pad a_164624_102044# sg13cmos5l_Corner_1.iovdd sg13cmos5l_Corner_1.iovdd sg13_hv_pmos ad=3.9294p pd=7.84u as=2.1312p ps=7.3u w=6.66u l=0.6u
M1857 vdd a_99352_98326# a_99297_98207# vdd sg13_lv_pmos ad=1.07253p pd=6.75u as=93.45f ps=0.865u w=0.42u l=0.13u
M1858 vddr adc8b_0.sar12b_0.nl_sw[0] adc8b_0.side_cap8b_1.buf_32_0.z vddr sg13_lv_pmos ad=0.19p pd=1.38u as=0.19p ps=1.38u w=1u l=0.13u
M1859 sg13cmos5l_Corner_1.vss adc8b_0.side_cap8b_0.in_l_sw[0] adc8b_0.side_cap8b_0.buf_32_0.z sg13cmos5l_Corner_1.vss sg13_lv_nmos ad=95f pd=0.88u as=95f ps=0.88u w=0.5u l=0.13u
M1860 sg13cmos5l_Corner_1.vss a_118044_30676# cko sg13cmos5l_Corner_1.vss sg13_hv_nmos ad=1.408p pd=5.04u as=2.596p ps=5.58u w=4.4u l=0.6u
M1861 a_89208_93108# a_88657_92840# vdd vdd sg13_lv_pmos ad=0.105p pd=1.21u as=1.86162p ps=11.935u w=1u l=0.13u
M1862 data[2] a_102044_30676# sg13cmos5l_Corner_1.vss sg13cmos5l_Corner_1.vss sg13_hv_nmos ad=2.596p pd=5.58u as=1.408p ps=5.04u w=4.4u l=0.6u
M1863 sg13cmos5l_Corner_1.vss sg13cmos5l_IOPadVdd$1_0.sg13cmos5l_Clamp_N43N43D4R$1_0.gate vdd sg13cmos5l_Corner_1.vss sg13_hv_nmos ad=1.408p pd=5.04u as=2.596p ps=5.58u w=4.4u l=0.6u
M1864 a_94572_97335# a_94284_97640# a_94510_97335# sg13cmos5l_Corner_1.vss sg13_lv_nmos ad=0.1428p pd=1.52u as=37.8f ps=0.6u w=0.42u l=0.13u
M1865 a_85356_96128# a_85330_96033# vdd vdd sg13_lv_pmos ad=0.34p pd=2.68u as=0.36237p ps=2.605u w=1u l=0.13u
M1866 adc8b_0.sar12b_0.sg13cmos5l_buf_8_0.A a_100248_96188# vdd vdd sg13_lv_pmos ad=0.3976p pd=2.95u as=0.2226p ps=1.535u w=1.12u l=0.13u
M1867 a_97548_93973# a_97260_93552# a_97486_93973# sg13cmos5l_Corner_1.vss sg13_lv_nmos ad=0.1428p pd=1.52u as=37.8f ps=0.6u w=0.42u l=0.13u
M1868 a_90801_97322# a_90620_97644# vdd vdd sg13_lv_pmos ad=0.2128p pd=1.5u as=0.2387p ps=1.84u w=1.12u l=0.13u
M1869 sg13cmos5l_Corner_1.vss adc8b_0.side_cap8b_0.in_l_sw[6] adc8b_0.side_cap8b_0.buf_4_3.z sg13cmos5l_Corner_1.vss sg13_lv_nmos ad=95f pd=0.88u as=95f ps=0.88u w=0.5u l=0.13u
M1870 adc8b_0.side_cap8b_1.buf_16_0.z adc8b_0.sar12b_0.nh_sw[2] sg13cmos5l_Corner_1.vss sg13cmos5l_Corner_1.vss sg13_lv_nmos ad=95f pd=0.88u as=95f ps=0.88u w=0.5u l=0.13u
M1871 sg13cmos5l_Corner_1.iovdd a_42476_102044# vip sg13cmos5l_Corner_1.iovdd sg13_hv_pmos ad=3.1302p pd=14.26u as=3.9294p ps=7.84u w=6.66u l=0.6u
M1872 adc8b_0.sar12b_0.sg13cmos5l_dlhr_1_7.Q_N a_86718_98514# vdd vdd sg13_lv_pmos ad=0.3808p pd=2.92u as=0.1974p ps=1.5u w=1.12u l=0.13u
M1873 a_87034_95810# adc8b_0.sar12b_0.sg13cmos5l_dfrbp_1_8.RESET_B sg13cmos5l_Corner_1.vss sg13cmos5l_Corner_1.vss sg13_lv_nmos ad=37.8f pd=0.6u as=79.8f ps=0.8u w=0.42u l=0.13u
M1874 a_101972_96536# adc8b_0.sar12b_0.sg13cmos5l_dlhr_1_16.Q sg13cmos5l_Corner_1.vss sg13cmos5l_Corner_1.vss sg13_lv_nmos ad=0.187p pd=1.78u as=0.14875p ps=1.16u w=0.55u l=0.13u
M1875 a_97932_95823# a_98163_95932# a_97618_96033# sg13cmos5l_Corner_1.vss sg13_lv_nmos ad=0.2373p pd=1.97u as=79.8f ps=0.8u w=0.42u l=0.13u
M1876 a_100439_92863# a_99597_92765# a_99180_93104# vdd sg13_lv_pmos ad=0.2048p pd=1.63u as=0.34p ps=2.68u w=1u l=0.13u
M1877 sg13cmos5l_IOPadAnalog_12.pad a_131639_178370# sg13cmos5l_Corner_1.vss sg13cmos5l_Corner_1.vss sg13_hv_nmos ad=2.596p pd=5.58u as=1.408p ps=5.04u w=4.4u l=0.6u
M1878 a_89588_100310# adc8b_0.sar12b_0.sg13cmos5l_buf_1_73.A vdd vdd sg13_lv_pmos ad=0.2856p pd=2.36u as=0.2114p ps=1.54u w=0.84u l=0.13u
M1879 a_86420_97286# adc8b_0.sar12b_0.sg13cmos5l_buf_1_59.A vdd vdd sg13_lv_pmos ad=0.2856p pd=2.36u as=0.2114p ps=1.54u w=0.84u l=0.13u
M1880 a_82893_96583# adc8b_0.sar12b_0.sg13cmos5l_dlhr_1_1.GATE vdd vdd sg13_lv_pmos ad=0.4088p pd=2.97u as=1.2517p ps=7.955u w=1.12u l=0.13u
M1881 adc8b_0.side_cap8b_1.buf_8_0.z adc8b_0.sar12b_0.nl_sw[4] sg13cmos5l_Corner_1.vss sg13cmos5l_Corner_1.vss sg13_lv_nmos ad=95f pd=0.88u as=95f ps=0.88u w=0.5u l=0.13u
M1882 vdd sg13cmos5l_IOPadVdd$1_0.sg13cmos5l_Clamp_N43N43D4R$1_0.gate sg13cmos5l_Corner_1.vss sg13cmos5l_Corner_1.vss sg13_hv_nmos ad=2.596p pd=5.58u as=1.408p ps=5.04u w=4.4u l=0.6u
M1883 vddr adc8b_0.side_cap8b_0.in_l_sw[2] adc8b_0.side_cap8b_0.buf_16_1.z vddr sg13_lv_pmos ad=0.19p pd=1.38u as=0.19p ps=1.38u w=1u l=0.13u
M1884 a_96753_99643# a_96396_99600# vdd vdd sg13_lv_pmos ad=63f pd=0.72u as=0.1563p ps=1.22u w=0.42u l=0.13u
M1885 sg13cmos5l_Corner_1.vss a_84980_92750# adc8b_0.sar12b_0.sg13cmos5l_buf_1_41.X sg13cmos5l_Corner_1.vss sg13_lv_nmos ad=0.14875p pd=1.16u as=0.2886p ps=2.26u w=0.74u l=0.13u
M1886 a_85070_95810# a_85875_95932# a_85330_96033# vdd sg13_lv_pmos ad=0.1428p pd=1.52u as=79.8f ps=0.8u w=0.42u l=0.13u
M1887 vdd adc8b_0.sar12b_0.sg13cmos5l_nor2b_1_0.Y a_92551_95036# vdd sg13_lv_pmos ad=0.3808p pd=2.92u as=0.2744p ps=1.61u w=1.12u l=0.13u
M1888 a_93790_94294# adc8b_0.sar12b_0.sg13cmos5l_o21ai_1_0.A2 sg13cmos5l_Corner_1.vss sg13cmos5l_Corner_1.vss sg13_lv_nmos ad=0.1406p pd=1.12u as=0.1406p ps=1.12u w=0.74u l=0.15u
M1889 sg13cmos5l_Corner_1.vss vdd sg13cmos5l_Corner_1.vss sg13cmos5l_Corner_1.vss sg13_lv_nmos ad=0.1428p pd=1.52u as=0 ps=0 w=0.42u l=1u
M1890 sg13cmos5l_Corner_1.vss adc8b_0.sar12b_0.nh_sw[1] adc8b_0.side_cap8b_1.buf_16_3.z sg13cmos5l_Corner_1.vss sg13_lv_nmos ad=95f pd=0.88u as=95f ps=0.88u w=0.5u l=0.13u
M1891 sg13cmos5l_Corner_1.iovdd a_131639_164698# sg13cmos5l_IOPadAnalog_12.pad sg13cmos5l_Corner_1.iovdd sg13_hv_pmos ad=3.1302p pd=14.26u as=3.9294p ps=7.84u w=6.66u l=0.6u
M1892 a_86228_100310# adc8b_0.sar12b_0.sg13cmos5l_buf_1_60.A vdd vdd sg13_lv_pmos ad=0.2856p pd=2.36u as=0.2114p ps=1.54u w=0.84u l=0.13u
M1893 sg13cmos5l_Corner_1.vss vdd sg13cmos5l_Corner_1.vss sg13cmos5l_Corner_1.vss sg13_lv_nmos ad=0.1428p pd=1.52u as=0 ps=0 w=0.42u l=1u
M1894 a_98988_92786# adc8b_0.sar12b_0.sg13cmos5l_dfrbp_1_0.D a_98894_92786# sg13cmos5l_Corner_1.vss sg13_lv_nmos ad=60.89999f pd=0.71u as=0.1428p ps=1.52u w=0.42u l=0.13u
M1895 sg13cmos5l_Corner_1.vss adc8b_0.sar12b_0.sg13cmos5l_buf_1_35.A a_83632_92824# sg13cmos5l_Corner_1.vss sg13_lv_nmos ad=0.14875p pd=1.16u as=0.187p ps=1.78u w=0.55u l=0.13u
M1896 adc8b_0.sar12b_0.sg13cmos5l_dfrbp_1_1.Q a_95420_93084# sg13cmos5l_Corner_1.vss sg13cmos5l_Corner_1.vss sg13_lv_nmos ad=0.2516p pd=2.16u as=0.1406p ps=1.12u w=0.74u l=0.13u
M1897 sg13cmos5l_Corner_1.iovdd a_42476_118044# cks sg13cmos5l_Corner_1.iovdd sg13_hv_pmos ad=2.1312p pd=7.3u as=3.9294p ps=7.84u w=6.66u l=0.6u
M1898 vdd a_82388_98798# adc8b_0.side_cap8b_0.in_l_sw[0] vdd sg13_lv_pmos ad=0.2114p pd=1.54u as=0.42p ps=2.99u w=1.12u l=0.13u
M1899 vdd a_83735_98445# a_83992_98326# vdd sg13_lv_pmos ad=0.2639p pd=1.81u as=79.8f ps=0.8u w=0.42u l=0.13u
M1900 vddr adc8b_0.side_cap8b_0.in_h_sw[0] adc8b_0.side_cap8b_0.buf_32_1.z vddr sg13_lv_pmos ad=0.19p pd=1.38u as=0.34p ps=2.68u w=1u l=0.13u
M1901 sg13cmos5l_Corner_1.vss a_85076_100310# adc8b_0.sar12b_0.sg13cmos5l_inv_1_8.A sg13cmos5l_Corner_1.vss sg13_lv_nmos ad=0.14875p pd=1.16u as=0.2886p ps=2.26u w=0.74u l=0.13u
M1902 adc8b_0.sar12b_0.sg13cmos5l_dfrbp_1_20.Q a_91388_99132# sg13cmos5l_Corner_1.vss sg13cmos5l_Corner_1.vss sg13_lv_nmos ad=0.2516p pd=2.16u as=0.1406p ps=1.12u w=0.74u l=0.13u
M1903 sg13cmos5l_Corner_1.vss a_100628_98048# adc8b_0.side_cap8b_0.in_h_sw[9] sg13cmos5l_Corner_1.vss sg13_lv_nmos ad=0.14875p pd=1.16u as=0.2886p ps=2.26u w=0.74u l=0.13u
M1904 a_92086_96572# adc8b_0.sar12b_0.sg13cmos5l_a221oi_1_1.C1 adc8b_0.sar12b_0.sg13cmos5l_a22oi_1_2.B2 vdd sg13_lv_pmos ad=0.2128p pd=1.5u as=0.3808p ps=2.92u w=1.12u l=0.13u
M1905 data[2] a_102044_42476# sg13cmos5l_Corner_1.iovdd sg13cmos5l_Corner_1.iovdd sg13_hv_pmos ad=3.9294p pd=7.84u as=2.1312p ps=7.3u w=6.66u l=0.6u
M1906 adc8b_0.side_cap8b_1.buf_8_0.z adc8b_0.sar12b_0.nl_sw[4] vddr vddr sg13_lv_pmos ad=0.34p pd=2.68u as=0.19p ps=1.38u w=1u l=0.13u
M1907 vdd sg13cmos5l_IOPadVdd$1_0.sg13cmos5l_Clamp_N43N43D4R$1_0.gate sg13cmos5l_Corner_1.vss sg13cmos5l_Corner_1.vss sg13_hv_nmos ad=2.596p pd=5.58u as=1.408p ps=5.04u w=4.4u l=0.6u
M1908 sg13cmos5l_Corner_1.vss adc8b_0.sar12b_0.nh_sw[0] adc8b_0.side_cap8b_1.buf_32_1.z sg13cmos5l_Corner_1.vss sg13_lv_nmos ad=95f pd=0.88u as=95f ps=0.88u w=0.5u l=0.13u
M1909 vdd adc8b_0.sar12b_0.sg13cmos5l_inv_1_17.A adc8b_0.sar12b_0.sg13cmos5l_buf_1_37.A vdd sg13_lv_pmos ad=0.3808p pd=2.92u as=0.3808p ps=2.92u w=1.12u l=0.13u
M1910 sg13cmos5l_IOPadAnalog_13.pad a_115639_164698# sg13cmos5l_Corner_1.iovdd sg13cmos5l_Corner_1.iovdd sg13_hv_pmos ad=3.9294p pd=7.84u as=2.1312p ps=7.3u w=6.66u l=0.6u
M1911 sg13cmos5l_IOPadAnalog_12.pad a_131639_164698# sg13cmos5l_Corner_1.iovdd sg13cmos5l_Corner_1.iovdd sg13_hv_pmos ad=3.9294p pd=7.84u as=2.1312p ps=7.3u w=6.66u l=0.6u
X1912 a_36456_136075# a_40542_136405# sg13cmos5l_Corner_1.vss rppd l=20u w=1u
M1913 vdd adc8b_0.sar12b_0.sg13cmos5l_buf_1_31.X a_91216_98084# vdd sg13_lv_pmos ad=0.2114p pd=1.54u as=0.2856p ps=2.36u w=0.84u l=0.13u
M1914 vdd a_88504_93790# a_88449_93671# vdd sg13_lv_pmos ad=1.86162p pd=11.935u as=93.45f ps=0.865u w=0.42u l=0.13u
M1915 vdd sg13cmos5l_IOPadVdd$1_0.sg13cmos5l_RCClampInverter$1_0.in sg13cmos5l_IOPadVdd$1_0.sg13cmos5l_Clamp_N43N43D4R$1_0.gate vdd sg13_hv_pmos ad=1.33p pd=7.38u as=1.33p ps=7.38u w=7u l=0.5u
M1916 vdd a_86837_96536# adc8b_0.sar12b_0.sg13cmos5l_dfrbp_1_29.Q_N vdd sg13_lv_pmos ad=0.2639p pd=1.81u as=0.4312p ps=3.01u w=1.12u l=0.13u
M1917 adc8b_0.sar12b_0.sg13cmos5l_buf_1_2.X a_97552_92824# vdd vdd sg13_lv_pmos ad=0.42p pd=2.99u as=0.2114p ps=1.54u w=1.12u l=0.13u
M1918 vdd sg13cmos5l_IOPadVdd$1_0.sg13cmos5l_Clamp_N43N43D4R$1_0.gate sg13cmos5l_Corner_1.vss sg13cmos5l_Corner_1.vss sg13_hv_nmos ad=2.596p pd=5.58u as=1.408p ps=5.04u w=4.4u l=0.6u
M1919 a_100696_93006# a_100439_92863# a_100858_92786# sg13cmos5l_Corner_1.vss sg13_lv_nmos ad=0.1428p pd=1.52u as=37.8f ps=0.6u w=0.42u l=0.13u
M1920 sg13cmos5l_Corner_1.vss sg13cmos5l_IOPadVdd$1_0.sg13cmos5l_Clamp_N43N43D4R$1_0.gate vdd sg13cmos5l_Corner_1.vss sg13_hv_nmos ad=1.408p pd=5.04u as=2.596p ps=5.58u w=4.4u l=0.6u
M1921 frame a_134044_30676# sg13cmos5l_Corner_1.vss sg13cmos5l_Corner_1.vss sg13_hv_nmos ad=2.596p pd=5.58u as=1.408p ps=5.04u w=4.4u l=0.6u
M1922 sg13cmos5l_IOPadAnalog_0.pad a_178296_86044# sg13cmos5l_Corner_1.vss sg13cmos5l_Corner_1.vss sg13_hv_nmos ad=2.596p pd=5.58u as=1.408p ps=5.04u w=4.4u l=0.6u
M1923 sg13cmos5l_Corner_1.iovdd a_164624_86044# sg13cmos5l_IOPadAnalog_0.pad sg13cmos5l_Corner_1.iovdd sg13_hv_pmos ad=2.1312p pd=7.3u as=3.9294p ps=7.84u w=6.66u l=0.6u
X1924 vddr sg13cmos5l_IOPadAnalog_5.padres sg13cmos5l_Corner_1.vss rppd l=2u w=1u
M1925 a_84500_92750# adc8b_0.sar12b_0.sg13cmos5l_buf_1_37.A vdd vdd sg13_lv_pmos ad=0.2856p pd=2.36u as=0.2114p ps=1.54u w=0.84u l=0.13u
M1926 vddr adc8b_0.side_cap8b_0.in_l_sw[0] adc8b_0.side_cap8b_0.buf_32_0.z vddr sg13_lv_pmos ad=0.19p pd=1.38u as=0.19p ps=1.38u w=1u l=0.13u
M1927 adc8b_0.side_cap8b_0.buf_16_0.z adc8b_0.side_cap8b_0.in_h_sw[2] vddr vddr sg13_lv_pmos ad=0.19p pd=1.38u as=0.19p ps=1.38u w=1u l=0.13u
M1928 adc8b_0.sar12b_0.sg13cmos5l_dlhr_1_5.Q_N a_90750_98514# vdd vdd sg13_lv_pmos ad=0.3808p pd=2.92u as=0.1974p ps=1.5u w=1.12u l=0.13u
M1929 sg13cmos5l_Corner_1.iovdd a_99639_164698# sg13cmos5l_IOPadAnalog_15.pad sg13cmos5l_Corner_1.iovdd sg13_hv_pmos ad=2.1312p pd=7.3u as=3.9294p ps=7.84u w=6.66u l=0.6u
M1930 vddr adc8b_0.side_cap8b_0.in_h_sw[1] adc8b_0.side_cap8b_0.buf_16_3.z vddr sg13_lv_pmos ad=0.19p pd=1.38u as=0.19p ps=1.38u w=1u l=0.13u
M1931 vdd sg13cmos5l_Corner_1.vss vdd vdd sg13_lv_pmos ad=0.34p pd=2.68u as=0 ps=0 w=1u l=1u
M1932 a_94862_98084# a_94466_98448# a_94748_98084# vdd sg13_lv_pmos ad=0.1008p pd=0.9u as=0.191p ps=1.44u w=0.42u l=0.13u
M1933 a_94258_97545# a_94701_97301# a_94641_97713# vdd sg13_lv_pmos ad=79.8f pd=0.8u as=63f ps=0.72u w=0.42u l=0.13u
M1934 a_92232_93587# adc8b_0.sar12b_0.sg13cmos5l_nand2_1_1.B a_92195_93896# sg13cmos5l_Corner_1.vss sg13_lv_nmos ad=0.2176p pd=1.96u as=78.39999f ps=0.885u w=0.64u l=0.13u
M1935 vddr adc8b_0.sar12b_0.nh_sw[2] adc8b_0.side_cap8b_1.buf_16_0.z vddr sg13_lv_pmos ad=0.19p pd=1.38u as=0.19p ps=1.38u w=1u l=0.13u
M1936 sg13cmos5l_Corner_1.vss sg13cmos5l_IOPadVdd$1_0.sg13cmos5l_RCClampInverter$1_0.in sg13cmos5l_Corner_1.vss sg13cmos5l_Corner_1.vss sg13_hv_nmos ad=1.71p pd=9.38u as=0 ps=0 w=9u l=9.5u
M1937 a_94317_100325# adc8b_0.sar12b_0.sg13cmos5l_inv_1_2.A sg13cmos5l_Corner_1.vss sg13cmos5l_Corner_1.vss sg13_lv_nmos ad=0.2516p pd=2.16u as=2.71505p ps=17.54u w=0.74u l=0.13u
M1938 cko a_102160_98872# sg13cmos5l_Corner_1.vss sg13cmos5l_Corner_1.vss sg13_lv_nmos ad=0.2886p pd=2.26u as=0.14875p ps=1.16u w=0.74u l=0.13u
M1939 adc8b_0.side_cap8b_0.buf_16_0.z adc8b_0.side_cap8b_0.in_h_sw[2] sg13cmos5l_Corner_1.vss sg13cmos5l_Corner_1.vss sg13_lv_nmos ad=95f pd=0.88u as=95f ps=0.88u w=0.5u l=0.13u
M1940 sg13cmos5l_Corner_1.vss adc8b_0.side_cap8b_0.in_h_sw[6] adc8b_0.side_cap8b_0.buf_4_1.z sg13cmos5l_Corner_1.vss sg13_lv_nmos ad=95f pd=0.88u as=95f ps=0.88u w=0.5u l=0.13u
M1941 vdd a_89972_100310# adc8b_0.sar12b_0.sg13cmos5l_buf_1_74.X vdd sg13_lv_pmos ad=0.2114p pd=1.54u as=0.42p ps=2.99u w=1.12u l=0.13u
M1942 a_101780_93512# adc8b_0.sar12b_0.sg13cmos5l_buf_1_0.X sg13cmos5l_Corner_1.vss sg13cmos5l_Corner_1.vss sg13_lv_nmos ad=0.187p pd=1.78u as=0.14875p ps=1.16u w=0.55u l=0.13u
M1943 a_84364_99156# a_84389_98796# sg13cmos5l_Corner_1.vss sg13cmos5l_Corner_1.vss sg13_lv_nmos ad=0.2775p pd=2.23u as=1.49685p ps=9.6u w=0.74u l=0.13u
M1944 a_86962_93516# a_87405_93559# a_86702_93986# sg13cmos5l_Corner_1.vss sg13_lv_nmos ad=79.8f pd=0.8u as=0.1296p ps=1.52u w=0.42u l=0.13u
M1945 a_93298_93009# a_93741_92765# a_93038_92786# sg13cmos5l_Corner_1.vss sg13_lv_nmos ad=79.8f pd=0.8u as=0.1296p ps=1.52u w=0.42u l=0.13u
M1946 a_94840_95302# a_94583_95421# a_95002_95498# sg13cmos5l_Corner_1.vss sg13_lv_nmos ad=0.1428p pd=1.52u as=37.8f ps=0.6u w=0.42u l=0.13u
M1947 sg13cmos5l_Corner_1.vss adc8b_0.sar12b_0.sg13cmos5l_inv_1_5.A adc8b_0.sar12b_0.sg13cmos5l_a22oi_1_1.A1 sg13cmos5l_Corner_1.vss sg13_lv_nmos ad=0.2516p pd=2.16u as=0.2516p ps=2.16u w=0.74u l=0.13u
X1948 sg13cmos5l_Corner_1.vss a_152182_124462# dantenna l=0.64u w=3.1u
M1949 sg13cmos5l_Corner_1.vss a_131639_178370# sg13cmos5l_IOPadAnalog_12.pad sg13cmos5l_Corner_1.vss sg13_hv_nmos ad=1.408p pd=5.04u as=2.596p ps=5.58u w=4.4u l=0.6u
M1950 adc8b_0.sar12b_0.sg13cmos5l_dlhr_1_2.Q_N a_89790_94280# sg13cmos5l_Corner_1.vss sg13cmos5l_Corner_1.vss sg13_lv_nmos ad=0.2516p pd=2.16u as=0.1491p ps=1.18u w=0.74u l=0.13u
M1951 adc8b_0.side_cap8b_1.buf_32_0.z adc8b_0.sar12b_0.nl_sw[0] vddr vddr sg13_lv_pmos ad=0.19p pd=1.38u as=0.19p ps=1.38u w=1u l=0.13u
M1952 vdd adc8b_0.sar12b_0.sg13cmos5l_dlygate4sd3_1_0.X adc8b_0.sar12b_0.sg13cmos5l_buf_1_43.A vdd sg13_lv_pmos ad=0.3808p pd=2.92u as=0.3808p ps=2.92u w=1.12u l=0.13u
M1953 sg13cmos5l_Corner_1.vss sg13cmos5l_IOPadVdd$1_0.sg13cmos5l_RCClampInverter$1_0.in sg13cmos5l_Corner_1.vss sg13cmos5l_Corner_1.vss sg13_hv_nmos ad=1.71p pd=9.38u as=0 ps=0 w=9u l=9.5u
M1954 adc8b_0.cmp_0.outn adc8b_0.cmp_0.outp vdd vdd sg13_lv_pmos ad=0.425p pd=3.18u as=0.2375p ps=1.63u w=1.25u l=0.13u
M1955 adc8b_0.sar12b_0.sg13cmos5l_buf_1_18.A adc8b_0.sar12b_0.sg13cmos5l_buf_1_111.A vdd vdd sg13_lv_pmos ad=0.3808p pd=2.92u as=0.3808p ps=2.92u w=1.12u l=0.13u
M1956 a_90542_96572# a_90146_96936# a_90428_96572# vdd sg13_lv_pmos ad=0.1008p pd=0.9u as=0.191p ps=1.44u w=0.42u l=0.13u
M1957 sg13cmos5l_Corner_1.vss adc8b_0.diff_bsw_0.single_bsw_1.sg13cmos5l_inv_1$1_0.A a_70946_94286# sg13cmos5l_Corner_1.vss sg13_lv_nmos ad=1.02p pd=6.68u as=0.57p ps=3.38u w=3u l=0.13u
M1958 a_99261_95107# a_98319_95147# a_99167_95107# vdd sg13_lv_pmos ad=79.8f pd=0.8u as=0.1428p ps=1.52u w=0.42u l=0.13u
M1959 sg13cmos5l_Corner_1.iovdd a_118044_42476# cko sg13cmos5l_Corner_1.iovdd sg13_hv_pmos ad=3.1302p pd=14.26u as=3.9294p ps=7.84u w=6.66u l=0.6u
M1960 sg13cmos5l_Corner_1.vss a_178296_118044# sg13cmos5l_IOPadAnalog_11.pad sg13cmos5l_Corner_1.vss sg13_hv_nmos ad=1.408p pd=5.04u as=2.596p ps=5.58u w=4.4u l=0.6u
M1961 sg13cmos5l_Corner_1.vss a_30676_70044# vddr sg13cmos5l_Corner_1.vss sg13_hv_nmos ad=1.408p pd=5.04u as=2.596p ps=5.58u w=4.4u l=0.6u
M1962 adc8b_0.side_cap8b_0.buf_32_0.z adc8b_0.side_cap8b_0.in_l_sw[0] sg13cmos5l_Corner_1.vss sg13cmos5l_Corner_1.vss sg13_lv_nmos ad=95f pd=0.88u as=95f ps=0.88u w=0.5u l=0.13u
M1963 sg13cmos5l_Corner_1.vss a_101108_99560# adc8b_0.side_cap8b_0.in_l_sw[9] sg13cmos5l_Corner_1.vss sg13_lv_nmos ad=0.14875p pd=1.16u as=0.2886p ps=2.26u w=0.74u l=0.13u
M1964 a_95254_96572# adc8b_0.sar12b_0.sg13cmos5l_or2_1_1.B a_95466_96572# vdd sg13_lv_pmos ad=0.2128p pd=1.5u as=0.3808p ps=2.92u w=1.12u l=0.13u
M1965 data[2] a_102044_42476# sg13cmos5l_Corner_1.iovdd sg13cmos5l_Corner_1.iovdd sg13_hv_pmos ad=3.9294p pd=7.84u as=2.1312p ps=7.3u w=6.66u l=0.6u
M1966 a_86988_93552# a_86962_93516# vdd vdd sg13_lv_pmos ad=0.34p pd=2.68u as=0.36237p ps=2.605u w=1u l=0.13u
M1967 vdd a_93741_95071# a_93843_95071# vdd sg13_lv_pmos ad=1.43437p pd=9.105u as=0.3864p ps=2.93u w=1.12u l=0.13u
M1968 sg13cmos5l_IOPadAnalog_1.pad a_178296_70044# sg13cmos5l_Corner_1.vss sg13cmos5l_Corner_1.vss sg13_hv_nmos ad=2.596p pd=5.58u as=1.408p ps=5.04u w=4.4u l=0.6u
X1969 sg13cmos5l_Corner_1.vss a_86222_33862# dantenna l=1.26u w=27.78u
M1970 vddr adc8b_0.side_cap8b_0.in_l_sw[1] adc8b_0.side_cap8b_0.buf_16_2.z vddr sg13_lv_pmos ad=0.19p pd=1.38u as=0.19p ps=1.38u w=1u l=0.13u
M1971 sg13cmos5l_IOPadAnalog_11.pad a_164624_118044# sg13cmos5l_Corner_1.iovdd sg13cmos5l_Corner_1.iovdd sg13_hv_pmos ad=3.9294p pd=7.84u as=2.1312p ps=7.3u w=6.66u l=0.6u
M1972 sg13cmos5l_IOPadAnalog_13.pad a_115639_178370# sg13cmos5l_Corner_1.vss sg13cmos5l_Corner_1.vss sg13_hv_nmos ad=2.596p pd=5.58u as=2.068p ps=9.74u w=4.4u l=0.6u
M1973 sg13cmos5l_IOPadAnalog_9.pad a_83639_164698# sg13cmos5l_Corner_1.iovdd sg13cmos5l_Corner_1.iovdd sg13_hv_pmos ad=3.9294p pd=7.84u as=2.1312p ps=7.3u w=6.66u l=0.6u
M1974 sg13cmos5l_IOPadAnalog_12.pad a_131639_178370# sg13cmos5l_Corner_1.vss sg13cmos5l_Corner_1.vss sg13_hv_nmos ad=2.596p pd=5.58u as=1.408p ps=5.04u w=4.4u l=0.6u
M1975 frame a_134044_42476# sg13cmos5l_Corner_1.iovdd sg13cmos5l_Corner_1.iovdd sg13_hv_pmos ad=3.9294p pd=7.84u as=2.1312p ps=7.3u w=6.66u l=0.6u
M1976 adc8b_0.side_cap8b_1.buf_16_2.z adc8b_0.sar12b_0.nl_sw[1] sg13cmos5l_Corner_1.vss sg13cmos5l_Corner_1.vss sg13_lv_nmos ad=95f pd=0.88u as=95f ps=0.88u w=0.5u l=0.13u
M1977 sg13cmos5l_Corner_1.iovdd a_42476_70044# vddr sg13cmos5l_Corner_1.iovdd sg13_hv_pmos ad=2.1312p pd=7.3u as=3.9294p ps=7.84u w=6.66u l=0.6u
M1978 sg13cmos5l_Corner_1.vss a_88727_97399# a_89564_97620# sg13cmos5l_Corner_1.vss sg13_lv_nmos ad=0.1406p pd=1.12u as=0.2516p ps=2.16u w=0.74u l=0.13u
M1979 data[0] a_70044_30676# sg13cmos5l_Corner_1.vss sg13cmos5l_Corner_1.vss sg13_hv_nmos ad=2.596p pd=5.58u as=1.408p ps=5.04u w=4.4u l=0.6u
M1980 vddr adc8b_0.sar12b_0.nl_sw[3] adc8b_0.side_cap8b_1.buf_8_1.z vddr sg13_lv_pmos ad=0.19p pd=1.38u as=0.19p ps=1.38u w=1u l=0.13u
M1981 a_95252_99560# adc8b_0.sar12b_0.sg13cmos5l_dlhr_1_11.Q sg13cmos5l_Corner_1.vss sg13cmos5l_Corner_1.vss sg13_lv_nmos ad=0.187p pd=1.78u as=0.14875p ps=1.16u w=0.55u l=0.13u
M1982 sg13cmos5l_Corner_1.vss adc8b_0.cmp_0.clk a_74586_95659# sg13cmos5l_Corner_1.vss sg13_lv_nmos ad=95f pd=0.88u as=0.17p ps=1.68u w=0.5u l=0.13u
M1983 vddr adc8b_0.sar12b_0.nh_sw[5] adc8b_0.side_cap8b_1.buf_8_5.z vddr sg13_lv_pmos ad=0.19p pd=1.38u as=0.19p ps=1.38u w=1u l=0.13u
M1984 sg13cmos5l_Corner_1.vss a_100977_96929# a_101502_97002# sg13cmos5l_Corner_1.vss sg13_lv_nmos ad=0.1491p pd=1.18u as=0.187p ps=1.78u w=0.55u l=0.13u
X1985 a_36456_140695# a_40542_140365# sg13cmos5l_Corner_1.vss rppd l=20u w=1u
M1986 a_89217_99719# a_88275_99607# a_89015_99957# vdd sg13_lv_pmos ad=93.45f pd=0.865u as=0.2048p ps=1.63u w=0.42u l=0.13u
M1987 sg13cmos5l_Corner_1.iovdd a_131639_164698# sg13cmos5l_IOPadAnalog_12.pad sg13cmos5l_Corner_1.iovdd sg13_hv_pmos ad=2.1312p pd=7.3u as=3.9294p ps=7.84u w=6.66u l=0.6u
M1988 cks a_30676_118044# sg13cmos5l_Corner_1.vss sg13cmos5l_Corner_1.vss sg13_hv_nmos ad=2.596p pd=5.58u as=1.408p ps=5.04u w=4.4u l=0.6u
M1989 sg13cmos5l_Corner_1.vss a_30676_102044# vip sg13cmos5l_Corner_1.vss sg13_hv_nmos ad=1.408p pd=5.04u as=2.596p ps=5.58u w=4.4u l=0.6u
M1990 vip a_42476_102044# sg13cmos5l_Corner_1.iovdd sg13cmos5l_Corner_1.iovdd sg13_hv_pmos ad=3.9294p pd=7.84u as=2.1312p ps=7.3u w=6.66u l=0.6u
M1991 sg13cmos5l_Corner_1.iovdd a_67639_164698# sg13cmos5l_IOPadAnalog_10.pad sg13cmos5l_Corner_1.iovdd sg13_hv_pmos ad=2.1312p pd=7.3u as=3.9294p ps=7.84u w=6.66u l=0.6u
M1992 sg13cmos5l_Corner_1.vss a_99135_99954# a_99266_99960# sg13cmos5l_Corner_1.vss sg13_lv_nmos ad=2.92392p pd=18.89u as=0.2775p ps=2.23u w=0.74u l=0.13u
M1993 sg13cmos5l_Corner_1.vss a_98445_97301# a_98547_97444# sg13cmos5l_Corner_1.vss sg13_lv_nmos ad=1.97045p pd=12.335u as=0.2516p ps=2.16u w=0.74u l=0.13u
X1994 frame sg13cmos5l_Corner_1.iovdd dpantenna l=1.26u w=27.78u
M1995 vddr adc8b_0.sar12b_0.nl_sw[1] adc8b_0.side_cap8b_1.buf_16_2.z vddr sg13_lv_pmos ad=0.19p pd=1.38u as=0.19p ps=1.38u w=1u l=0.13u
M1996 adc8b_0.side_cap8b_1.buf_32_0.z adc8b_0.sar12b_0.nl_sw[0] sg13cmos5l_Corner_1.vss sg13cmos5l_Corner_1.vss sg13_lv_nmos ad=95f pd=0.88u as=95f ps=0.88u w=0.5u l=0.13u
M1997 sg13cmos5l_Corner_1.iovdd a_42476_70044# vddr sg13cmos5l_Corner_1.iovdd sg13_hv_pmos ad=2.1312p pd=7.3u as=3.9294p ps=7.84u w=6.66u l=0.6u
M1998 vdd a_98061_95789# a_98163_95932# vdd sg13_lv_pmos ad=1.28962p pd=8.195u as=0.3864p ps=2.93u w=1.12u l=0.13u
M1999 sg13cmos5l_Corner_1.vss adc8b_0.cmp_0.outp a_82192_92824# sg13cmos5l_Corner_1.vss sg13_lv_nmos ad=0.14875p pd=1.16u as=0.187p ps=1.78u w=0.55u l=0.13u
M2000 sg13cmos5l_Corner_1.vss adc8b_0.sar12b_0.nl_sw[0] adc8b_0.side_cap8b_1.buf_32_0.z sg13cmos5l_Corner_1.vss sg13_lv_nmos ad=95f pd=0.88u as=95f ps=0.88u w=0.5u l=0.13u
X2001 sg13cmos5l_IOPadAnalog_4.padres sg13cmos5l_Corner_1.iovdd dpantenna l=4.98u w=0.64u
M2002 a_94785_93101# a_93843_92908# a_94583_92863# vdd sg13_lv_pmos ad=93.45f pd=0.865u as=0.2048p ps=1.63u w=0.42u l=0.13u
X2003 sg13cmos5l_Corner_1.vss a_102222_176786# dantenna l=1.26u w=27.78u
M2004 a_83430_99534# a_83231_99671# sg13cmos5l_Corner_1.vss sg13cmos5l_Corner_1.vss sg13_lv_nmos ad=0.27427p pd=2.28u as=2.92392p ps=18.89u w=0.795u l=0.13u
M2005 vdd a_88148_98798# adc8b_0.side_cap8b_0.in_l_sw[3] vdd sg13_lv_pmos ad=0.2114p pd=1.54u as=0.42p ps=2.99u w=1.12u l=0.13u
M2006 sg13cmos5l_Corner_1.vss adc8b_0.sar12b_0.sg13cmos5l_buf_1_31.X a_91216_98084# sg13cmos5l_Corner_1.vss sg13_lv_nmos ad=0.14875p pd=1.16u as=0.187p ps=1.78u w=0.55u l=0.13u
M2007 sg13cmos5l_Corner_1.vss a_86837_96536# adc8b_0.sar12b_0.sg13cmos5l_dfrbp_1_29.Q_N sg13cmos5l_Corner_1.vss sg13_lv_nmos ad=0.2516p pd=2.16u as=0.2849p ps=2.25u w=0.74u l=0.13u
M2008 a_99865_98826# a_99313_98888# sg13cmos5l_Corner_1.vss sg13cmos5l_Corner_1.vss sg13_lv_nmos ad=71.99999f pd=0.865u as=1.49685p ps=9.6u w=0.64u l=0.13u
M2009 a_98002_97545# a_98445_97301# a_98385_97713# vdd sg13_lv_pmos ad=79.8f pd=0.8u as=63f ps=0.72u w=0.42u l=0.13u
M2010 vdd sg13cmos5l_Corner_1.vss vdd vdd sg13_lv_pmos ad=0.19p pd=1.38u as=0 ps=0 w=1u l=1u
M2011 sg13cmos5l_Corner_1.vss a_178296_86044# sg13cmos5l_IOPadAnalog_0.pad sg13cmos5l_Corner_1.vss sg13_hv_nmos ad=1.408p pd=5.04u as=2.596p ps=5.58u w=4.4u l=0.6u
M2012 sg13cmos5l_IOPadAnalog_16.pad a_164624_102044# sg13cmos5l_Corner_1.iovdd sg13cmos5l_Corner_1.iovdd sg13_hv_pmos ad=3.9294p pd=7.84u as=2.1312p ps=7.3u w=6.66u l=0.6u
M2013 vdd sg13cmos5l_IOPadVdd$1_0.sg13cmos5l_Clamp_N43N43D4R$1_0.gate sg13cmos5l_Corner_1.vss sg13cmos5l_Corner_1.vss sg13_hv_nmos ad=2.596p pd=5.58u as=1.408p ps=5.04u w=4.4u l=0.6u
M2014 adc8b_0.sar12b_0.sg13cmos5l_dlhr_1_18.Q_N a_92958_98514# vdd vdd sg13_lv_pmos ad=0.3808p pd=2.92u as=0.1974p ps=1.5u w=1.12u l=0.13u
M2015 adc8b_0.cmp_0.sg13cmos5l_dlygate4sd3_1$1_0.A a_79552_97015# sg13cmos5l_Corner_1.vss sg13cmos5l_Corner_1.vss sg13_lv_nmos ad=0.2516p pd=2.16u as=0.1469p ps=1.155u w=0.74u l=0.13u
M2016 vdd a_98519_93909# a_99356_93548# vdd sg13_lv_pmos ad=0.2128p pd=1.5u as=0.3864p ps=2.93u w=1.12u l=0.13u
M2017 vdd a_97268_100310# adc8b_0.side_cap8b_0.in_h_sw[6] vdd sg13_lv_pmos ad=0.2114p pd=1.54u as=0.42p ps=2.99u w=1.12u l=0.13u
M2018 sg13cmos5l_Corner_1.vss a_30676_118044# cks sg13cmos5l_Corner_1.vss sg13_hv_nmos ad=1.408p pd=5.04u as=2.596p ps=5.58u w=4.4u l=0.6u
M2019 adc8b_0.sar12b_0.sg13cmos5l_or2_1_0.A a_100131_95430# vdd vdd sg13_lv_pmos ad=0.2128p pd=1.5u as=0.2128p ps=1.5u w=1.12u l=0.13u
M2020 sg13cmos5l_Corner_1.vss adc8b_0.sar12b_0.sg13cmos5l_dlhr_1_15.Q a_101008_98872# sg13cmos5l_Corner_1.vss sg13_lv_nmos ad=0.14875p pd=1.16u as=0.187p ps=1.78u w=0.55u l=0.13u
M2021 sg13cmos5l_Corner_1.vss adc8b_0.sar12b_0.sg13cmos5l_dfrbp_1_8.RESET_B a_84242_97322# sg13cmos5l_Corner_1.vss sg13_lv_nmos ad=79.8f pd=0.8u as=37.8f ps=0.6u w=0.42u l=0.13u
M2022 vdd a_90801_97322# a_90734_97760# vdd sg13_lv_pmos ad=0.2387p pd=1.84u as=0.1008p ps=0.9u w=0.42u l=0.13u
M2023 a_90552_97644# a_90001_97376# vdd vdd sg13_lv_pmos ad=0.105p pd=1.21u as=1.07253p ps=6.75u w=1u l=0.13u
M2024 frame a_134044_42476# sg13cmos5l_Corner_1.iovdd sg13cmos5l_Corner_1.iovdd sg13_hv_pmos ad=3.9294p pd=7.84u as=2.1312p ps=7.3u w=6.66u l=0.6u
M2025 adc8b_0.diff_bsw_0.single_bsw_0.sg13cmos5l_inv_1$1_0.A cks vdd vdd sg13_lv_pmos ad=0.3808p pd=2.92u as=0.3808p ps=2.92u w=1.12u l=0.13u
M2026 data[0] a_70044_42476# sg13cmos5l_Corner_1.iovdd sg13cmos5l_Corner_1.iovdd sg13_hv_pmos ad=3.9294p pd=7.84u as=2.1312p ps=7.3u w=6.66u l=0.6u
M2027 sg13cmos5l_Corner_1.vss a_82388_93512# adc8b_0.sar12b_0.nl_sw[0] sg13cmos5l_Corner_1.vss sg13_lv_nmos ad=0.14875p pd=1.16u as=0.2886p ps=2.26u w=0.74u l=0.13u
M2028 adc8b_0.side_cap8b_0.buf_32_0.z adc8b_0.side_cap8b_0.in_l_sw[0] vddr vddr sg13_lv_pmos ad=0.19p pd=1.38u as=0.19p ps=1.38u w=1u l=0.13u
M2029 sg13cmos5l_IOPadAnalog_9.pad a_83639_178370# sg13cmos5l_Corner_1.vss sg13cmos5l_Corner_1.vss sg13_hv_nmos ad=2.596p pd=5.58u as=2.068p ps=9.74u w=4.4u l=0.6u
M2030 adc8b_0.side_cap8b_0.buf_16_3.z adc8b_0.side_cap8b_0.in_h_sw[1] vddr vddr sg13_lv_pmos ad=0.19p pd=1.38u as=0.19p ps=1.38u w=1u l=0.13u
M2031 vddr adc8b_0.side_cap8b_0.in_h_sw[2] adc8b_0.side_cap8b_0.buf_16_0.z vddr sg13_lv_pmos ad=0.19p pd=1.38u as=0.19p ps=1.38u w=1u l=0.13u
M2032 sg13cmos5l_Corner_1.vss adc8b_0.side_cap8b_0.in_h_sw[4] adc8b_0.side_cap8b_0.buf_8_2.z sg13cmos5l_Corner_1.vss sg13_lv_nmos ad=95f pd=0.88u as=95f ps=0.88u w=0.5u l=0.13u
M2033 sg13cmos5l_Corner_1.vss sg13cmos5l_IOPadVdd$1_0.sg13cmos5l_Clamp_N43N43D4R$1_0.gate vdd sg13cmos5l_Corner_1.vss sg13_hv_nmos ad=1.408p pd=5.04u as=2.596p ps=5.58u w=4.4u l=0.6u
M2034 a_94317_100325# adc8b_0.sar12b_0.sg13cmos5l_inv_1_2.A vdd vdd sg13_lv_pmos ad=0.4088p pd=2.97u as=4.11675p ps=27.17u w=1.12u l=0.13u
M2035 adc8b_0.sar12b_0.sg13cmos5l_buf_1_104.X a_101392_99596# vdd vdd sg13_lv_pmos ad=0.42p pd=2.99u as=0.2114p ps=1.54u w=1.12u l=0.13u
M2036 sg13cmos5l_IOPadAnalog_13.pad a_115639_164698# sg13cmos5l_Corner_1.iovdd sg13cmos5l_Corner_1.iovdd sg13_hv_pmos ad=3.9294p pd=7.84u as=2.1312p ps=7.3u w=6.66u l=0.6u
M2037 vdd a_83992_96814# a_83937_96695# vdd sg13_lv_pmos ad=1.28962p pd=8.195u as=93.45f ps=0.865u w=0.42u l=0.13u
M2038 a_89972_93512# adc8b_0.sar12b_0.sg13cmos5l_dlhr_1_2.Q vdd vdd sg13_lv_pmos ad=0.2856p pd=2.36u as=0.2114p ps=1.54u w=0.84u l=0.13u
X2039 sg13cmos5l_IOPadAnalog_17.padres sg13cmos5l_Corner_1.iovdd dpantenna l=0.64u w=4.98u
M2040 a_91884_98834# adc8b_0.sar12b_0.sg13cmos5l_buf_1_57.X a_91790_98834# sg13cmos5l_Corner_1.vss sg13_lv_nmos ad=60.89999f pd=0.71u as=0.1428p ps=1.52u w=0.42u l=0.13u
M2041 a_89977_98486# a_89425_98442# sg13cmos5l_Corner_1.vss sg13cmos5l_Corner_1.vss sg13_lv_nmos ad=71.99999f pd=0.865u as=1.49685p ps=9.6u w=0.64u l=0.13u
M2042 sg13cmos5l_Corner_1.vss a_131639_178370# sg13cmos5l_IOPadAnalog_12.pad sg13cmos5l_Corner_1.vss sg13_hv_nmos ad=1.408p pd=5.04u as=2.596p ps=5.58u w=4.4u l=0.6u
M2043 sg13cmos5l_Corner_1.vss a_96813_99607# a_96915_99607# sg13cmos5l_Corner_1.vss sg13_lv_nmos ad=2.92392p pd=18.89u as=0.2516p ps=2.16u w=0.74u l=0.13u
M2044 vdd sg13cmos5l_Corner_1.vss vdd vdd sg13_lv_pmos ad=0.19p pd=1.38u as=0 ps=0 w=1u l=1u
X2045 data[0] sg13cmos5l_Corner_1.iovdd dpantenna l=1.26u w=27.78u
M2046 vdd a_101780_93512# adc8b_0.sar12b_0.nl_sw[10] vdd sg13_lv_pmos ad=0.2114p pd=1.54u as=0.42p ps=2.99u w=1.12u l=0.13u
M2047 sg13cmos5l_Corner_1.vss adc8b_0.side_cap8b_0.in_l_sw[5] adc8b_0.side_cap8b_0.buf_8_4.z sg13cmos5l_Corner_1.vss sg13_lv_nmos ad=95f pd=0.88u as=95f ps=0.88u w=0.5u l=0.13u
M2048 a_96754_99057# a_97197_98813# a_96494_98834# sg13cmos5l_Corner_1.vss sg13_lv_nmos ad=79.8f pd=0.8u as=0.1296p ps=1.52u w=0.42u l=0.13u
M2049 a_96780_99152# a_96754_99057# sg13cmos5l_Corner_1.vss sg13cmos5l_Corner_1.vss sg13_lv_nmos ad=0.2516p pd=2.16u as=0.1626p ps=1.415u w=0.74u l=0.13u
M2050 adc8b_0.side_cap8b_1.buf_2_2.z adc8b_0.sar12b_0.nl_sw[9] vddr vddr sg13_lv_pmos ad=0.34p pd=2.68u as=0.19p ps=1.38u w=1u l=0.13u
M2051 a_93900_100664# a_94419_100468# a_95159_100423# sg13cmos5l_Corner_1.vss sg13_lv_nmos ad=0.3473p pd=2.71u as=0.12665p ps=1.145u w=0.74u l=0.13u
M2052 a_90766_100021# adc8b_0.sar12b_0.sg13cmos5l_dfrbp_1_8.RESET_B sg13cmos5l_Corner_1.vss sg13cmos5l_Corner_1.vss sg13_lv_nmos ad=37.8f pd=0.6u as=0.1701p ps=1.65u w=0.42u l=0.13u
M2053 vdd adc8b_0.sar12b_0.sg13cmos5l_dfrbp_1_8.RESET_B a_90514_99564# vdd sg13_lv_pmos ad=0.1563p pd=1.22u as=0.147p ps=1.54u w=0.42u l=0.13u
M2054 a_84116_98784# a_84364_99156# a_84322_99272# vdd sg13_lv_pmos ad=0.191p pd=1.44u as=0.1008p ps=0.9u w=0.42u l=0.13u
M2055 adc8b_0.side_cap8b_1.buf_4_3.z adc8b_0.sar12b_0.nl_sw[6] sg13cmos5l_Corner_1.vss sg13cmos5l_Corner_1.vss sg13_lv_nmos ad=95f pd=0.88u as=95f ps=0.88u w=0.5u l=0.13u
M2056 vdd adc8b_0.sar12b_0.sg13cmos5l_dfrbp_1_0.RESET_B a_93038_92786# vdd sg13_lv_pmos ad=0.36237p pd=2.605u as=79.8f ps=0.8u w=0.42u l=0.13u
M2057 sg13cmos5l_Corner_1.vss sg13cmos5l_IOPadVdd$1_0.sg13cmos5l_Clamp_N43N43D4R$1_0.gate vdd sg13cmos5l_Corner_1.vss sg13_hv_nmos ad=1.408p pd=5.04u as=2.596p ps=5.58u w=4.4u l=0.6u
M2058 vddr adc8b_0.sar12b_0.nh_sw[1] adc8b_0.side_cap8b_1.buf_16_3.z vddr sg13_lv_pmos ad=0.19p pd=1.38u as=0.19p ps=1.38u w=1u l=0.13u
M2059 vdd sg13cmos5l_IOPadVdd$1_0.sg13cmos5l_Clamp_N43N43D4R$1_0.gate sg13cmos5l_Corner_1.vss sg13cmos5l_Corner_1.vss sg13_hv_nmos ad=2.596p pd=5.58u as=1.408p ps=5.04u w=4.4u l=0.6u
M2060 a_97652_94262# adc8b_0.sar12b_0.sg13cmos5l_buf_1_5.X vdd vdd sg13_lv_pmos ad=0.2856p pd=2.36u as=0.2114p ps=1.54u w=0.84u l=0.13u
M2061 adc8b_0.side_cap8b_0.buf_16_1.z adc8b_0.side_cap8b_0.in_l_sw[2] sg13cmos5l_Corner_1.vss sg13cmos5l_Corner_1.vss sg13_lv_nmos ad=95f pd=0.88u as=95f ps=0.88u w=0.5u l=0.13u
M2062 a_101780_92750# adc8b_0.sar12b_0.sg13cmos5l_buf_1_0.A sg13cmos5l_Corner_1.vss sg13cmos5l_Corner_1.vss sg13_lv_nmos ad=0.187p pd=1.78u as=0.14875p ps=1.16u w=0.55u l=0.13u
X2063 sg13cmos5l_Corner_1.vss a_70222_176786# dantenna l=1.26u w=27.78u
M2064 a_100248_96188# adc8b_0.sar12b_0.sg13cmos5l_dfrbp_1_0.D sg13cmos5l_Corner_1.vss sg13cmos5l_Corner_1.vss sg13_lv_nmos ad=0.1045p pd=0.93u as=0.187p ps=1.78u w=0.55u l=0.13u
M2065 a_97589_95024# a_98319_95147# a_98340_95421# sg13cmos5l_Corner_1.vss sg13_lv_nmos ad=0.12665p pd=1.145u as=0.3473p ps=2.71u w=0.74u l=0.13u
M2066 adc8b_0.sar12b_0.sg13cmos5l_buf_1_89.A a_96657_98441# sg13cmos5l_Corner_1.vss sg13cmos5l_Corner_1.vss sg13_lv_nmos ad=0.2516p pd=2.16u as=0.1406p ps=1.12u w=0.74u l=0.13u
M2067 vdd adc8b_0.sar12b_0.sg13cmos5l_nor2_1_0.A a_93748_96108# vdd sg13_lv_pmos ad=0.4032p pd=2.96u as=0.1176p ps=1.33u w=1.12u l=0.13u
M2068 adc8b_0.sar12b_0.sg13cmos5l_dlhr_1_4.Q_N a_87966_94280# vdd vdd sg13_lv_pmos ad=0.3808p pd=2.92u as=0.1974p ps=1.5u w=1.12u l=0.13u
M2069 adc8b_0.side_cap8b_1.buf_16_0.z adc8b_0.sar12b_0.nh_sw[2] sg13cmos5l_Corner_1.vss sg13cmos5l_Corner_1.vss sg13_lv_nmos ad=95f pd=0.88u as=95f ps=0.88u w=0.5u l=0.13u
M2070 sg13cmos5l_Corner_1.vss adc8b_0.sar12b_0.sg13cmos5l_dfrbp_1_6.RESET_B a_87276_97322# sg13cmos5l_Corner_1.vss sg13_lv_nmos ad=0.1626p pd=1.415u as=60.89999f ps=0.71u w=0.42u l=0.13u
X2071 sg13cmos5l_Corner_1.vss a_173384_130682# dantenna l=1.26u w=27.78u
M2072 a_72090_98590# adc8b_0.diff_bsw_0.single_bsw_0.sg13cmos5l_inv_1$1_2.Y w_71686_98280# w_71686_98280# sg13_lv_pmos ad=0.17p pd=1.68u as=0.17p ps=1.68u w=0.5u l=0.13u
M2073 adc8b_0.sar12b_0.sg13cmos5l_dlhr_1_13.Q_N a_97182_98514# sg13cmos5l_Corner_1.vss sg13cmos5l_Corner_1.vss sg13_lv_nmos ad=0.2516p pd=2.16u as=0.1491p ps=1.18u w=0.74u l=0.13u
M2074 vdd adc8b_0.sar12b_0.sg13cmos5l_dfrbp_1_0.RESET_B a_94766_94298# vdd sg13_lv_pmos ad=0.36237p pd=2.605u as=79.8f ps=0.8u w=0.42u l=0.13u
M2075 adc8b_0.sar12b_0.sg13cmos5l_dfrbp_1_17.D a_83430_99534# vdd vdd sg13_lv_pmos ad=0.3927p pd=2.99u as=1.15047p ps=7.175u w=1.155u l=0.13u
M2076 data[0] a_70044_42476# sg13cmos5l_Corner_1.iovdd sg13cmos5l_Corner_1.iovdd sg13_hv_pmos ad=3.9294p pd=7.84u as=2.1312p ps=7.3u w=6.66u l=0.6u
M2077 sg13cmos5l_Corner_1.vss adc8b_0.sar12b_0.nl_sw[1] adc8b_0.side_cap8b_1.buf_16_2.z sg13cmos5l_Corner_1.vss sg13_lv_nmos ad=95f pd=0.88u as=95f ps=0.88u w=0.5u l=0.13u
M2078 sg13cmos5l_Corner_1.vss adc8b_0.sar12b_0.sg13cmos5l_dfrbp_1_6.RESET_B a_89692_92772# sg13cmos5l_Corner_1.vss sg13_lv_nmos ad=0.1406p pd=1.12u as=77.7f ps=0.95u w=0.74u l=0.13u
M2079 vdd a_95252_99560# adc8b_0.sar12b_0.sg13cmos5l_buf_1_5.A vdd sg13_lv_pmos ad=0.2114p pd=1.54u as=0.42p ps=2.99u w=1.12u l=0.13u
M2080 vdd adc8b_0.sar12b_0.sg13cmos5l_inv_1_5.A adc8b_0.sar12b_0.sg13cmos5l_a22oi_1_1.A1 vdd sg13_lv_pmos ad=0.3808p pd=2.92u as=0.3808p ps=2.92u w=1.12u l=0.13u
M2081 adc8b_0.side_cap8b_1.buf_32_1.z adc8b_0.sar12b_0.nh_sw[0] vddr vddr sg13_lv_pmos ad=0.19p pd=1.38u as=0.19p ps=1.38u w=1u l=0.13u
X2082 a_36456_132775# a_40542_133105# sg13cmos5l_Corner_1.vss rppd l=20u w=1u
M2083 vdd a_93592_99054# a_93537_99149# vdd sg13_lv_pmos ad=1.15047p pd=7.175u as=93.45f ps=0.865u w=0.42u l=0.13u
M2084 adc8b_0.sar12b_0.sg13cmos5l_nand2_1_1.B a_97125_92976# vdd vdd sg13_lv_pmos ad=0.2128p pd=1.5u as=0.3808p ps=2.92u w=1.12u l=0.13u
M2085 a_82476_96576# a_82450_96540# vdd vdd sg13_lv_pmos ad=0.34p pd=2.68u as=0.36237p ps=2.605u w=1u l=0.13u
M2086 adc8b_0.sar12b_0.sg13cmos5l_dfrbp_1_8.Q_N a_98903_95887# sg13cmos5l_Corner_1.vss sg13cmos5l_Corner_1.vss sg13_lv_nmos ad=0.2849p pd=2.25u as=0.2516p ps=2.16u w=0.74u l=0.13u
M2087 adc8b_0.side_cap8b_1.buf_8_0.z adc8b_0.sar12b_0.nl_sw[4] sg13cmos5l_Corner_1.vss sg13cmos5l_Corner_1.vss sg13_lv_nmos ad=95f pd=0.88u as=95f ps=0.88u w=0.5u l=0.13u
M2088 vdd a_87405_93559# a_87507_93559# vdd sg13_lv_pmos ad=1.86162p pd=11.935u as=0.3864p ps=2.93u w=1.12u l=0.13u
M2089 a_82702_96997# adc8b_0.sar12b_0.sg13cmos5l_dfrbp_1_6.RESET_B sg13cmos5l_Corner_1.vss sg13cmos5l_Corner_1.vss sg13_lv_nmos ad=37.8f pd=0.6u as=0.1701p ps=1.65u w=0.42u l=0.13u
M2090 cko a_118044_42476# sg13cmos5l_Corner_1.iovdd sg13cmos5l_Corner_1.iovdd sg13_hv_pmos ad=3.9294p pd=7.84u as=2.1312p ps=7.3u w=6.66u l=0.6u
M2091 a_99514_98522# adc8b_0.sar12b_0.sg13cmos5l_dfrbp_1_8.RESET_B sg13cmos5l_Corner_1.vss sg13cmos5l_Corner_1.vss sg13_lv_nmos ad=37.8f pd=0.6u as=79.8f ps=0.8u w=0.42u l=0.13u
M2092 adc8b_0.side_cap8b_0.buf_32_1.z adc8b_0.side_cap8b_0.in_h_sw[0] sg13cmos5l_Corner_1.vss sg13cmos5l_Corner_1.vss sg13_lv_nmos ad=95f pd=0.88u as=95f ps=0.88u w=0.5u l=0.13u
M2093 a_85624_94518# adc8b_0.sar12b_0.sg13cmos5l_dfrbp_1_6.RESET_B vdd vdd sg13_lv_pmos ad=79.8f pd=0.8u as=1.38655p ps=8.8u w=0.42u l=0.13u
M2094 vdd a_96668_93512# a_96626_93548# vdd sg13_lv_pmos ad=0.2618p pd=1.63u as=0.1176p ps=1.33u w=1.12u l=0.13u
M2095 a_89588_93512# adc8b_0.sar12b_0.sg13cmos5l_dlhr_1_0.Q vdd vdd sg13_lv_pmos ad=0.2856p pd=2.36u as=0.2114p ps=1.54u w=0.84u l=0.13u
M2096 sg13cmos5l_IOPadAnalog_13.pad a_115639_178370# sg13cmos5l_Corner_1.vss sg13cmos5l_Corner_1.vss sg13_hv_nmos ad=2.596p pd=5.58u as=1.408p ps=5.04u w=4.4u l=0.6u
M2097 sg13cmos5l_Corner_1.vss adc8b_0.sar12b_0.nh_sw[1] adc8b_0.side_cap8b_1.buf_16_3.z sg13cmos5l_Corner_1.vss sg13_lv_nmos ad=95f pd=0.88u as=95f ps=0.88u w=0.5u l=0.13u
M2098 adc8b_0.side_cap8b_1.buf_16_2.z adc8b_0.sar12b_0.nl_sw[1] vddr vddr sg13_lv_pmos ad=0.19p pd=1.38u as=0.19p ps=1.38u w=1u l=0.13u
M2099 sg13cmos5l_IOPadAnalog_15.pad a_99639_178370# sg13cmos5l_Corner_1.vss sg13cmos5l_Corner_1.vss sg13_hv_nmos ad=2.596p pd=5.58u as=1.408p ps=5.04u w=4.4u l=0.6u
M2100 sg13cmos5l_Corner_1.vss adc8b_0.side_cap8b_0.in_h_sw[0] adc8b_0.side_cap8b_0.buf_32_1.z sg13cmos5l_Corner_1.vss sg13_lv_nmos ad=95f pd=0.88u as=95f ps=0.88u w=0.5u l=0.13u
M2101 a_95159_100423# a_94317_100325# a_93900_100664# vdd sg13_lv_pmos ad=0.2048p pd=1.63u as=0.34p ps=2.68u w=1u l=0.13u
M2102 vdd a_101361_97322# a_101886_97304# vdd sg13_lv_pmos ad=0.1974p pd=1.5u as=0.2856p ps=2.36u w=0.84u l=0.13u
M2103 a_92060_100668# a_91647_100362# a_91992_100668# vdd sg13_lv_pmos ad=0.191p pd=1.44u as=0.105p ps=1.21u w=1u l=0.13u
M2104 sg13cmos5l_Corner_1.vss vdd sg13cmos5l_Corner_1.vss sg13cmos5l_Corner_1.vss sg13_lv_nmos ad=79.8f pd=0.8u as=0 ps=0 w=0.42u l=1u
M2105 vdd sg13cmos5l_IOPadVdd$1_0.sg13cmos5l_Clamp_N43N43D4R$1_0.gate sg13cmos5l_Corner_1.vss sg13cmos5l_Corner_1.vss sg13_hv_nmos ad=2.596p pd=5.58u as=1.408p ps=5.04u w=4.4u l=0.6u
M2106 vddr adc8b_0.side_cap8b_0.in_h_sw[0] adc8b_0.side_cap8b_0.buf_32_1.z vddr sg13_lv_pmos ad=0.19p pd=1.38u as=0.19p ps=1.38u w=1u l=0.13u
M2107 vdd a_90957_99607# a_91059_99607# vdd sg13_lv_pmos ad=1.15047p pd=7.175u as=0.3864p ps=2.93u w=1.12u l=0.13u
M2108 a_100348_98820# a_99932_99156# a_100113_98834# sg13cmos5l_Corner_1.vss sg13_lv_nmos ad=77.7f pd=0.95u as=0.2516p ps=2.16u w=0.74u l=0.13u
M2109 sg13cmos5l_Corner_1.iovdd a_164624_70044# sg13cmos5l_IOPadAnalog_1.pad sg13cmos5l_Corner_1.iovdd sg13_hv_pmos ad=2.1312p pd=7.3u as=3.9294p ps=7.84u w=6.66u l=0.6u
M2110 sg13cmos5l_Corner_1.vss a_83639_178370# sg13cmos5l_IOPadAnalog_9.pad sg13cmos5l_Corner_1.vss sg13_hv_nmos ad=1.408p pd=5.04u as=2.596p ps=5.58u w=4.4u l=0.6u
M2111 data[2] a_102044_42476# sg13cmos5l_Corner_1.iovdd sg13cmos5l_Corner_1.iovdd sg13_hv_pmos ad=3.9294p pd=7.84u as=2.1312p ps=7.3u w=6.66u l=0.6u
M2112 sg13cmos5l_Corner_1.iovdd a_164624_118044# sg13cmos5l_IOPadAnalog_11.pad sg13cmos5l_Corner_1.iovdd sg13_hv_pmos ad=2.1312p pd=7.3u as=3.9294p ps=7.84u w=6.66u l=0.6u
M2113 a_89276_93108# a_88994_92796# a_89209_92778# sg13cmos5l_Corner_1.vss sg13_lv_nmos ad=0.141p pd=1.17u as=71.99999f ps=0.865u w=0.64u l=0.13u
M2114 a_88044_100021# a_88275_99607# a_87730_99564# sg13cmos5l_Corner_1.vss sg13_lv_nmos ad=0.2373p pd=1.97u as=79.8f ps=0.8u w=0.42u l=0.13u
M2115 a_95644_98820# a_95228_99156# a_95409_98834# sg13cmos5l_Corner_1.vss sg13_lv_nmos ad=77.7f pd=0.95u as=0.2516p ps=2.16u w=0.74u l=0.13u
M2116 vdd sg13cmos5l_IOPadVdd$1_0.sg13cmos5l_Clamp_N43N43D4R$1_0.gate sg13cmos5l_Corner_1.vss sg13cmos5l_Corner_1.vss sg13_hv_nmos ad=2.596p pd=5.58u as=1.408p ps=5.04u w=4.4u l=0.6u
M2117 vddr adc8b_0.side_cap8b_0.in_l_sw[5] adc8b_0.side_cap8b_0.buf_8_4.z vddr sg13_lv_pmos ad=0.19p pd=1.38u as=0.19p ps=1.38u w=1u l=0.13u
M2118 a_87470_100034# adc8b_0.sar12b_0.sg13cmos5l_dlhr_1_5.GATE vdd vdd sg13_lv_pmos ad=79.8f pd=0.8u as=0.1428p ps=1.52u w=0.42u l=0.13u
M2119 vdd adc8b_0.sar12b_0.sg13cmos5l_inv_1_29.A adc8b_0.sar12b_0.sg13cmos5l_inv_1_29.Y vdd sg13_lv_pmos ad=0.3808p pd=2.92u as=0.3808p ps=2.92u w=1.12u l=0.13u
M2120 cko a_118044_30676# sg13cmos5l_Corner_1.vss sg13cmos5l_Corner_1.vss sg13_hv_nmos ad=2.596p pd=5.58u as=1.408p ps=5.04u w=4.4u l=0.6u
M2121 adc8b_0.sar12b_0.sg13cmos5l_buf_1_40.X a_82960_92824# vdd vdd sg13_lv_pmos ad=0.42p pd=2.99u as=0.2114p ps=1.54u w=1.12u l=0.13u
M2122 a_97548_93973# a_97779_93559# a_97234_93516# sg13cmos5l_Corner_1.vss sg13_lv_nmos ad=0.2373p pd=1.97u as=79.8f ps=0.8u w=0.42u l=0.13u
M2123 sg13cmos5l_Corner_1.iovdd a_86044_42476# data[1] sg13cmos5l_Corner_1.iovdd sg13_hv_pmos ad=2.1312p pd=7.3u as=3.9294p ps=7.84u w=6.66u l=0.6u
X2124 sg13cmos5l_Corner_1.vss sg13cmos5l_IOPadAnalog_10.padres dantenna l=3.1u w=0.64u
M2125 vdd a_88984_97542# a_88929_97637# vdd sg13_lv_pmos ad=1.07253p pd=6.75u as=93.45f ps=0.865u w=0.42u l=0.13u
M2126 adc8b_0.sar12b_0.sg13cmos5l_dlygate4sd2_1_0.A adc8b_0.sar12b_0.sg13cmos5l_inv_1_8.Y vdd vdd sg13_lv_pmos ad=0.2128p pd=1.5u as=0.3808p ps=2.92u w=1.12u l=0.13u
M2127 adc8b_0.side_cap8b_0.buf_16_0.z adc8b_0.side_cap8b_0.in_h_sw[2] vddr vddr sg13_lv_pmos ad=0.34p pd=2.68u as=0.19p ps=1.38u w=1u l=0.13u
M2128 adc8b_0.sar12b_0.sg13cmos5l_a22oi_1_1.Y adc8b_0.sar12b_0.sg13cmos5l_a22oi_1_1.B2 a_96582_95036# vdd sg13_lv_pmos ad=0.2128p pd=1.5u as=0.2744p ps=1.61u w=1.12u l=0.13u
X2129 sg13cmos5l_Corner_1.vss a_134222_175886# dantenna l=1.26u w=27.78u
M2130 vdd a_89972_93512# adc8b_0.sar12b_0.sg13cmos5l_buf_1_24.A vdd sg13_lv_pmos ad=0.2114p pd=1.54u as=0.42p ps=2.99u w=1.12u l=0.13u
M2131 vdd sg13cmos5l_IOPadVdd$1_0.sg13cmos5l_Clamp_N43N43D4R$1_0.gate sg13cmos5l_Corner_1.vss sg13cmos5l_Corner_1.vss sg13_hv_nmos ad=2.596p pd=5.58u as=1.408p ps=5.04u w=4.4u l=0.6u
M2132 cks a_30676_118044# sg13cmos5l_Corner_1.vss sg13cmos5l_Corner_1.vss sg13_hv_nmos ad=2.596p pd=5.58u as=1.408p ps=5.04u w=4.4u l=0.6u
M2133 a_87854_95810# adc8b_0.sar12b_0.sg13cmos5l_dlhr_1_0.GATE vdd vdd sg13_lv_pmos ad=79.8f pd=0.8u as=0.1428p ps=1.52u w=0.42u l=0.13u
M2134 a_99154_93009# a_99597_92765# a_98894_92786# sg13cmos5l_Corner_1.vss sg13_lv_nmos ad=79.8f pd=0.8u as=0.1296p ps=1.52u w=0.42u l=0.13u
M2135 a_85594_100034# adc8b_0.sar12b_0.sg13cmos5l_dfrbp_1_8.RESET_B sg13cmos5l_Corner_1.vss sg13cmos5l_Corner_1.vss sg13_lv_nmos ad=37.8f pd=0.6u as=79.8f ps=0.8u w=0.42u l=0.13u
M2136 adc8b_0.side_cap8b_1.buf_16_1.z adc8b_0.sar12b_0.nl_sw[2] sg13cmos5l_Corner_1.vss sg13cmos5l_Corner_1.vss sg13_lv_nmos ad=95f pd=0.88u as=95f ps=0.88u w=0.5u l=0.13u
M2137 sg13cmos5l_Corner_1.vss a_102044_30676# data[2] sg13cmos5l_Corner_1.vss sg13_hv_nmos ad=1.408p pd=5.04u as=2.596p ps=5.58u w=4.4u l=0.6u
M2138 sg13cmos5l_Corner_1.iovdd a_164624_102044# sg13cmos5l_IOPadAnalog_16.pad sg13cmos5l_Corner_1.iovdd sg13_hv_pmos ad=2.1312p pd=7.3u as=3.9294p ps=7.84u w=6.66u l=0.6u
M2139 adc8b_0.side_cap8b_0.buf_16_2.z adc8b_0.side_cap8b_0.in_l_sw[1] sg13cmos5l_Corner_1.vss sg13cmos5l_Corner_1.vss sg13_lv_nmos ad=95f pd=0.88u as=95f ps=0.88u w=0.5u l=0.13u
M2140 a_94572_97335# a_94803_97444# a_94258_97545# sg13cmos5l_Corner_1.vss sg13_lv_nmos ad=0.2373p pd=1.97u as=79.8f ps=0.8u w=0.42u l=0.13u
M2141 vdd sg13cmos5l_Corner_1.vss vdd vdd sg13_lv_pmos ad=0.19p pd=1.38u as=0 ps=0 w=1u l=1u
M2142 a_98036_92750# adc8b_0.sar12b_0.sg13cmos5l_buf_1_1.A vdd vdd sg13_lv_pmos ad=0.2856p pd=2.36u as=0.2114p ps=1.54u w=0.84u l=0.13u
M2143 sg13cmos5l_IOPadAnalog_10.pad a_67639_178370# sg13cmos5l_Corner_1.vss sg13cmos5l_Corner_1.vss sg13_hv_nmos ad=2.596p pd=5.58u as=1.408p ps=5.04u w=4.4u l=0.6u
M2144 a_91796_97286# adc8b_0.sar12b_0.sg13cmos5l_buf_1_56.A sg13cmos5l_Corner_1.vss sg13cmos5l_Corner_1.vss sg13_lv_nmos ad=0.187p pd=1.78u as=0.14875p ps=1.16u w=0.55u l=0.13u
M2145 vdd sg13cmos5l_Corner_1.vss vdd vdd sg13_lv_pmos ad=0.34p pd=2.68u as=0 ps=0 w=1u l=1u
M2146 adc8b_0.side_cap8b_1.buf_8_1.z adc8b_0.sar12b_0.nl_sw[3] sg13cmos5l_Corner_1.vss sg13cmos5l_Corner_1.vss sg13_lv_nmos ad=95f pd=0.88u as=95f ps=0.88u w=0.5u l=0.13u
M2147 adc8b_0.side_cap8b_1.buf_16_3.z adc8b_0.sar12b_0.nh_sw[1] vddr vddr sg13_lv_pmos ad=0.19p pd=1.38u as=0.19p ps=1.38u w=1u l=0.13u
M2148 vdd a_86847_94314# a_86978_94308# vdd sg13_lv_pmos ad=1.43437p pd=9.105u as=0.2856p ps=2.36u w=0.84u l=0.13u
M2149 sg13cmos5l_Corner_1.vss adc8b_0.side_cap8b_0.in_l_sw[2] adc8b_0.side_cap8b_0.buf_16_1.z sg13cmos5l_Corner_1.vss sg13_lv_nmos ad=95f pd=0.88u as=95f ps=0.88u w=0.5u l=0.13u
M2150 a_94815_98850# adc8b_0.sar12b_0.sg13cmos5l_dlhr_1_11.GATE sg13cmos5l_Corner_1.vss sg13cmos5l_Corner_1.vss sg13_lv_nmos ad=0.2516p pd=2.16u as=0.15055p ps=1.17u w=0.74u l=0.13u
M2151 sg13cmos5l_Corner_1.vss a_99639_178370# sg13cmos5l_IOPadAnalog_15.pad sg13cmos5l_Corner_1.vss sg13_hv_nmos ad=1.408p pd=5.04u as=2.596p ps=5.58u w=4.4u l=0.6u
M2152 vip a_30676_102044# sg13cmos5l_Corner_1.vss sg13cmos5l_Corner_1.vss sg13_hv_nmos ad=2.596p pd=5.58u as=1.408p ps=5.04u w=4.4u l=0.6u
M2153 adc8b_0.sar12b_0.sg13cmos5l_buf_1_96.A a_92433_98441# vdd vdd sg13_lv_pmos ad=0.3808p pd=2.92u as=0.2128p ps=1.5u w=1.12u l=0.13u
M2154 sg13cmos5l_Corner_1.vss a_115639_178370# sg13cmos5l_IOPadAnalog_13.pad sg13cmos5l_Corner_1.vss sg13_hv_nmos ad=2.068p pd=9.74u as=2.596p ps=5.58u w=4.4u l=0.6u
M2155 vddr adc8b_0.side_cap8b_0.in_l_sw[1] adc8b_0.side_cap8b_0.buf_16_2.z vddr sg13_lv_pmos ad=0.19p pd=1.38u as=0.19p ps=1.38u w=1u l=0.13u
M2156 a_83735_98445# a_82893_98095# a_83641_98445# sg13cmos5l_Corner_1.vss sg13_lv_nmos ad=0.12665p pd=1.145u as=0.1428p ps=1.52u w=0.42u l=0.13u
M2157 a_96226_95430# adc8b_0.sar12b_0.sg13cmos5l_nand2_1_1.B sg13cmos5l_Corner_1.vss sg13cmos5l_Corner_1.vss sg13_lv_nmos ad=0.1406p pd=1.12u as=0.2516p ps=2.16u w=0.74u l=0.13u
M2158 sg13cmos5l_Corner_1.vss adc8b_0.sar12b_0.nh_sw[2] adc8b_0.side_cap8b_1.buf_16_0.z sg13cmos5l_Corner_1.vss sg13_lv_nmos ad=95f pd=0.88u as=0.17p ps=1.68u w=0.5u l=0.13u
X2159 sg13cmos5l_Corner_1.vss a_57198_117410# dantenna l=0.64u w=3.1u
M2160 vddr adc8b_0.sar12b_0.nl_sw[3] adc8b_0.side_cap8b_1.buf_8_1.z vddr sg13_lv_pmos ad=0.19p pd=1.38u as=0.19p ps=1.38u w=1u l=0.13u
M2161 adc8b_0.side_cap8b_1.buf_16_2.z adc8b_0.sar12b_0.nl_sw[1] sg13cmos5l_Corner_1.vss sg13cmos5l_Corner_1.vss sg13_lv_nmos ad=95f pd=0.88u as=95f ps=0.88u w=0.5u l=0.13u
M2162 adc8b_0.side_cap8b_1.buf_32_1.z adc8b_0.sar12b_0.nh_sw[0] sg13cmos5l_Corner_1.vss sg13cmos5l_Corner_1.vss sg13_lv_nmos ad=95f pd=0.88u as=95f ps=0.88u w=0.5u l=0.13u
M2163 a_84204_95485# a_83916_95064# a_84142_95485# sg13cmos5l_Corner_1.vss sg13_lv_nmos ad=0.1428p pd=1.52u as=37.8f ps=0.6u w=0.42u l=0.13u
M2164 vddr adc8b_0.sar12b_0.nh_sw[5] adc8b_0.side_cap8b_1.buf_8_5.z vddr sg13_lv_pmos ad=0.19p pd=1.38u as=0.19p ps=1.38u w=1u l=0.13u
M2165 sg13cmos5l_Corner_1.vss adc8b_0.side_cap8b_0.in_h_sw[1] adc8b_0.side_cap8b_0.buf_16_3.z sg13cmos5l_Corner_1.vss sg13_lv_nmos ad=95f pd=0.88u as=95f ps=0.88u w=0.5u l=0.13u
M2166 adc8b_0.sar12b_0.sg13cmos5l_buf_1_10.A a_93616_99596# vdd vdd sg13_lv_pmos ad=0.42p pd=2.99u as=0.2114p ps=1.54u w=1.12u l=0.13u
M2167 sg13cmos5l_Corner_1.vss adc8b_0.sar12b_0.sg13cmos5l_dfrbp_1_6.RESET_B a_82284_97010# sg13cmos5l_Corner_1.vss sg13_lv_nmos ad=0.1626p pd=1.415u as=60.89999f ps=0.71u w=0.42u l=0.13u
M2168 adc8b_0.side_cap8b_1.buf_4_1.z adc8b_0.sar12b_0.nh_sw[6] sg13cmos5l_Corner_1.vss sg13cmos5l_Corner_1.vss sg13_lv_nmos ad=0.17p pd=1.68u as=95f ps=0.88u w=0.5u l=0.13u
M2169 vddr adc8b_0.sar12b_0.nh_sw[0] adc8b_0.side_cap8b_1.buf_32_1.z vddr sg13_lv_pmos ad=0.19p pd=1.38u as=0.19p ps=1.38u w=1u l=0.13u
M2170 vdd sg13cmos5l_IOPadVdd$1_0.sg13cmos5l_RCClampInverter$1_0.in sg13cmos5l_IOPadVdd$1_0.sg13cmos5l_Clamp_N43N43D4R$1_0.gate vdd sg13_hv_pmos ad=1.33p pd=7.38u as=1.33p ps=7.38u w=7u l=0.5u
M2171 sg13cmos5l_IOPadAnalog_15.pad a_99639_178370# sg13cmos5l_Corner_1.vss sg13cmos5l_Corner_1.vss sg13_hv_nmos ad=2.596p pd=5.58u as=1.408p ps=5.04u w=4.4u l=0.6u
M2172 vdd a_84177_95810# a_84702_95792# vdd sg13_lv_pmos ad=0.1974p pd=1.5u as=0.2856p ps=2.36u w=0.84u l=0.13u
M2173 sg13cmos5l_Corner_1.vss adc8b_0.cmp_0.sg13cmos5l_inv_1$1_0.Y a_79552_97015# sg13cmos5l_Corner_1.vss sg13_lv_nmos ad=0.1469p pd=1.155u as=0.1045p ps=0.93u w=0.55u l=0.13u
M2174 sg13cmos5l_Corner_1.vss adc8b_0.sar12b_0.sg13cmos5l_or2_1_1.B a_93641_96920# sg13cmos5l_Corner_1.vss sg13_lv_nmos ad=0.2516p pd=2.16u as=0.1406p ps=1.12u w=0.74u l=0.13u
M2175 a_91473_95810# a_91292_96132# vdd vdd sg13_lv_pmos ad=0.2128p pd=1.5u as=0.2387p ps=1.84u w=1.12u l=0.13u
M2176 sg13cmos5l_Corner_1.vss a_178296_70044# sg13cmos5l_IOPadAnalog_1.pad sg13cmos5l_Corner_1.vss sg13_hv_nmos ad=1.408p pd=5.04u as=2.596p ps=5.58u w=4.4u l=0.6u
X2177 a_36456_139375# a_40542_139045# sg13cmos5l_Corner_1.vss rppd l=20u w=1u
M2178 adc8b_0.side_cap8b_1.buf_16_3.z adc8b_0.sar12b_0.nh_sw[1] sg13cmos5l_Corner_1.vss sg13cmos5l_Corner_1.vss sg13_lv_nmos ad=95f pd=0.88u as=95f ps=0.88u w=0.5u l=0.13u
M2179 vddr adc8b_0.side_cap8b_0.in_l_sw[3] adc8b_0.side_cap8b_0.buf_8_1.z vddr sg13_lv_pmos ad=0.19p pd=1.38u as=0.19p ps=1.38u w=1u l=0.13u
M2180 sg13cmos5l_IOPadAnalog_12.pad a_131639_164698# sg13cmos5l_Corner_1.iovdd sg13cmos5l_Corner_1.iovdd sg13_hv_pmos ad=3.9294p pd=7.84u as=2.1312p ps=7.3u w=6.66u l=0.6u
M2181 sg13cmos5l_Corner_1.vss a_30676_86044# vin sg13cmos5l_Corner_1.vss sg13_hv_nmos ad=1.408p pd=5.04u as=2.596p ps=5.58u w=4.4u l=0.6u
M2182 a_90740_100310# adc8b_0.sar12b_0.sg13cmos5l_buf_1_77.A vdd vdd sg13_lv_pmos ad=0.2856p pd=2.36u as=0.2114p ps=1.54u w=0.84u l=0.13u
M2183 cks a_42476_118044# sg13cmos5l_Corner_1.iovdd sg13cmos5l_Corner_1.iovdd sg13_hv_pmos ad=3.9294p pd=7.84u as=2.1312p ps=7.3u w=6.66u l=0.6u
M2184 sg13cmos5l_Corner_1.iovdd a_42476_102044# vip sg13cmos5l_Corner_1.iovdd sg13_hv_pmos ad=2.1312p pd=7.3u as=3.9294p ps=7.84u w=6.66u l=0.6u
M2185 a_98296_99054# adc8b_0.sar12b_0.sg13cmos5l_dfrbp_1_6.RESET_B vdd vdd sg13_lv_pmos ad=79.8f pd=0.8u as=1.12242p ps=7u w=0.42u l=0.13u
M2186 a_92366_98084# a_91970_98448# a_92252_98084# vdd sg13_lv_pmos ad=0.1008p pd=0.9u as=0.191p ps=1.44u w=0.42u l=0.13u
M2187 a_93998_97322# adc8b_0.sar12b_0.sg13cmos5l_buf_1_57.X vdd vdd sg13_lv_pmos ad=79.8f pd=0.8u as=0.1428p ps=1.52u w=0.42u l=0.13u
M2188 data[1] a_86044_42476# sg13cmos5l_Corner_1.iovdd sg13cmos5l_Corner_1.iovdd sg13_hv_pmos ad=3.9294p pd=7.84u as=2.1312p ps=7.3u w=6.66u l=0.6u
M2189 vdd a_101361_97322# a_101294_97760# vdd sg13_lv_pmos ad=0.2387p pd=1.84u as=0.1008p ps=0.9u w=0.42u l=0.13u
M2190 a_87756_99600# a_88275_99607# a_89015_99957# sg13cmos5l_Corner_1.vss sg13_lv_nmos ad=0.3473p pd=2.71u as=0.12665p ps=1.145u w=0.74u l=0.13u
M2191 vdd a_82893_96583# a_82995_96583# vdd sg13_lv_pmos ad=1.28962p pd=8.195u as=0.3864p ps=2.93u w=1.12u l=0.13u
M2192 adc8b_0.sar12b_0.sg13cmos5l_inv_1_9.Y cks sg13cmos5l_Corner_1.vss sg13cmos5l_Corner_1.vss sg13_lv_nmos ad=0.2516p pd=2.16u as=0.2516p ps=2.16u w=0.74u l=0.13u
M2193 a_101112_97644# a_100561_97376# vdd vdd sg13_lv_pmos ad=0.105p pd=1.21u as=1.07253p ps=6.75u w=1u l=0.13u
M2194 vddr adc8b_0.sar12b_0.nl_sw[4] adc8b_0.side_cap8b_1.buf_8_0.z vddr sg13_lv_pmos ad=0.19p pd=1.38u as=0.34p ps=2.68u w=1u l=0.13u
M2195 adc8b_0.side_cap8b_1.buf_8_2.z adc8b_0.sar12b_0.nh_sw[4] sg13cmos5l_Corner_1.vss sg13cmos5l_Corner_1.vss sg13_lv_nmos ad=95f pd=0.88u as=95f ps=0.88u w=0.5u l=0.13u
M2196 a_100858_92786# adc8b_0.sar12b_0.sg13cmos5l_dfrbp_1_0.RESET_B sg13cmos5l_Corner_1.vss sg13cmos5l_Corner_1.vss sg13_lv_nmos ad=37.8f pd=0.6u as=79.8f ps=0.8u w=0.42u l=0.13u
M2197 sg13cmos5l_Corner_1.vss a_134044_30676# frame sg13cmos5l_Corner_1.vss sg13_hv_nmos ad=1.408p pd=5.04u as=2.596p ps=5.58u w=4.4u l=0.6u
M2198 vdd a_96692_92750# adc8b_0.sar12b_0.nh_sw[6] vdd sg13_lv_pmos ad=0.2114p pd=1.54u as=0.42p ps=2.99u w=1.12u l=0.13u
M2199 cko a_118044_30676# sg13cmos5l_Corner_1.vss sg13cmos5l_Corner_1.vss sg13_hv_nmos ad=2.596p pd=5.58u as=1.408p ps=5.04u w=4.4u l=0.6u
M2200 adc8b_0.sar12b_0.sg13cmos5l_dfrbp_1_22.D a_98492_99596# vdd vdd sg13_lv_pmos ad=0.3808p pd=2.92u as=0.2128p ps=1.5u w=1.12u l=0.13u
M2201 sg13cmos5l_Corner_1.vss a_99261_95107# a_98340_95421# sg13cmos5l_Corner_1.vss sg13_lv_nmos ad=0.1626p pd=1.415u as=0.2516p ps=2.16u w=0.74u l=0.13u
M2202 cko a_118044_42476# sg13cmos5l_Corner_1.iovdd sg13cmos5l_Corner_1.iovdd sg13_hv_pmos ad=3.9294p pd=7.84u as=2.1312p ps=7.3u w=6.66u l=0.6u
M2203 sg13cmos5l_Corner_1.iovdd a_86044_42476# data[1] sg13cmos5l_Corner_1.iovdd sg13_hv_pmos ad=2.1312p pd=7.3u as=3.9294p ps=7.84u w=6.66u l=0.6u
M2204 sg13cmos5l_Corner_1.vss adc8b_0.side_cap8b_0.in_l_sw[0] adc8b_0.side_cap8b_0.buf_32_0.z sg13cmos5l_Corner_1.vss sg13_lv_nmos ad=95f pd=0.88u as=95f ps=0.88u w=0.5u l=0.13u
M2205 a_96780_99152# a_96754_99057# vdd vdd sg13_lv_pmos ad=0.34p pd=2.68u as=0.36237p ps=2.605u w=1u l=0.13u
M2206 adc8b_0.sar12b_0.sg13cmos5l_nand2_1_2.B adc8b_0.sar12b_0.sg13cmos5l_nor2_1_2.A sg13cmos5l_Corner_1.vss sg13cmos5l_Corner_1.vss sg13_lv_nmos ad=0.1406p pd=1.12u as=0.2516p ps=2.16u w=0.74u l=0.13u
M2207 a_93888_94616# adc8b_0.sar12b_0.sg13cmos5l_o21ai_1_0.A1 vdd vdd sg13_lv_pmos ad=0.2128p pd=1.5u as=0.3808p ps=2.92u w=1.12u l=0.15u
M2208 vdd a_93645_93559# a_93747_93559# vdd sg13_lv_pmos ad=1.86162p pd=11.935u as=0.3864p ps=2.93u w=1.12u l=0.13u
M2209 a_88504_93790# adc8b_0.sar12b_0.sg13cmos5l_dfrbp_1_6.RESET_B vdd vdd sg13_lv_pmos ad=79.8f pd=0.8u as=1.86162p ps=11.935u w=0.42u l=0.13u
M2210 a_98316_97335# a_98547_97444# a_98002_97545# sg13cmos5l_Corner_1.vss sg13_lv_nmos ad=0.2373p pd=1.97u as=79.8f ps=0.8u w=0.42u l=0.13u
M2211 a_87478_96695# a_87220_97010# vdd vdd sg13_lv_pmos ad=93.45f pd=0.865u as=1.28962p ps=8.195u w=0.42u l=0.13u
M2212 adc8b_0.sar12b_0.sg13cmos5l_buf_1_44.A a_87441_94298# vdd vdd sg13_lv_pmos ad=0.3808p pd=2.92u as=0.2128p ps=1.5u w=1.12u l=0.13u
M2213 sg13cmos5l_Corner_1.vss a_67639_178370# sg13cmos5l_IOPadAnalog_10.pad sg13cmos5l_Corner_1.vss sg13_hv_nmos ad=1.408p pd=5.04u as=2.596p ps=5.58u w=4.4u l=0.6u
M2214 a_98254_97335# adc8b_0.sar12b_0.sg13cmos5l_dfrbp_1_6.RESET_B sg13cmos5l_Corner_1.vss sg13cmos5l_Corner_1.vss sg13_lv_nmos ad=37.8f pd=0.6u as=0.1701p ps=1.65u w=0.42u l=0.13u
M2215 sg13cmos5l_Corner_1.vss a_83639_178370# sg13cmos5l_IOPadAnalog_9.pad sg13cmos5l_Corner_1.vss sg13_hv_nmos ad=2.068p pd=9.74u as=2.596p ps=5.58u w=4.4u l=0.6u
M2216 adc8b_0.side_cap8b_0.buf_32_0.z adc8b_0.side_cap8b_0.in_l_sw[0] vddr vddr sg13_lv_pmos ad=0.19p pd=1.38u as=0.19p ps=1.38u w=1u l=0.13u
M2217 vddr adc8b_0.side_cap8b_0.in_h_sw[2] adc8b_0.side_cap8b_0.buf_16_0.z vddr sg13_lv_pmos ad=0.19p pd=1.38u as=0.19p ps=1.38u w=1u l=0.13u
M2218 a_93324_95064# a_93298_95028# sg13cmos5l_Corner_1.vss sg13cmos5l_Corner_1.vss sg13_lv_nmos ad=0.2516p pd=2.16u as=0.1626p ps=1.415u w=0.74u l=0.13u
M2219 sg13cmos5l_Corner_1.iovdd a_42476_118044# cks sg13cmos5l_Corner_1.iovdd sg13_hv_pmos ad=2.1312p pd=7.3u as=3.9294p ps=7.84u w=6.66u l=0.6u
M2220 a_92050_99057# a_92493_98813# a_91790_98834# sg13cmos5l_Corner_1.vss sg13_lv_nmos ad=79.8f pd=0.8u as=0.1296p ps=1.52u w=0.42u l=0.13u
M2221 adc8b_0.sar12b_0.sg13cmos5l_nor2_1_2.A adc8b_0.sar12b_0.sg13cmos5l_inv_1_9.Y vdd vdd sg13_lv_pmos ad=0.3808p pd=2.92u as=0.3808p ps=2.92u w=1.12u l=0.13u
M2222 adc8b_0.side_cap8b_1.buf_8_2.z adc8b_0.sar12b_0.nh_sw[4] vddr vddr sg13_lv_pmos ad=0.34p pd=2.68u as=0.19p ps=1.38u w=1u l=0.13u
M2223 sg13cmos5l_Corner_1.vss a_97655_99957# a_98492_99596# sg13cmos5l_Corner_1.vss sg13_lv_nmos ad=0.1406p pd=1.12u as=0.2516p ps=2.16u w=0.74u l=0.13u
M2224 vdd a_85432_99838# a_85377_99719# vdd sg13_lv_pmos ad=1.15047p pd=7.175u as=93.45f ps=0.865u w=0.42u l=0.13u
M2225 vdd adc8b_0.diff_bsw_0.single_bsw_0.sg13cmos5l_inv_1$1_2.A a_70852_97472# vdd sg13_lv_pmos ad=0.17p pd=1.68u as=0.17p ps=1.68u w=0.5u l=0.13u
M2226 a_83735_96933# a_82893_96583# a_82476_96576# vdd sg13_lv_pmos ad=0.2048p pd=1.63u as=0.34p ps=2.68u w=1u l=0.13u
M2227 a_98001_96201# a_97644_96128# vdd vdd sg13_lv_pmos ad=63f pd=0.72u as=0.1563p ps=1.22u w=0.42u l=0.13u
M2228 adc8b_0.sar12b_0.sg13cmos5l_dlhr_1_13.Q_N a_97182_98514# vdd vdd sg13_lv_pmos ad=0.3808p pd=2.92u as=0.1974p ps=1.5u w=1.12u l=0.13u
M2229 a_92099_95060# adc8b_0.sar12b_0.sg13cmos5l_nand2_1_1.B adc8b_0.sar12b_0.sg13cmos5l_a22oi_1_1.B1 vdd sg13_lv_pmos ad=0.2128p pd=1.5u as=0.3808p ps=2.92u w=1.12u l=0.13u
M2230 sg13cmos5l_IOPadAnalog_10.pad a_67639_178370# sg13cmos5l_Corner_1.vss sg13cmos5l_Corner_1.vss sg13_hv_nmos ad=2.596p pd=5.58u as=1.408p ps=5.04u w=4.4u l=0.6u
X2231 sg13cmos5l_Corner_1.vss a_124462_57198# dantenna l=3.1u w=0.64u
M2232 sg13cmos5l_Corner_1.iovdd a_164624_102044# sg13cmos5l_IOPadAnalog_16.pad sg13cmos5l_Corner_1.iovdd sg13_hv_pmos ad=2.1312p pd=7.3u as=3.9294p ps=7.84u w=6.66u l=0.6u
M2233 sg13cmos5l_IOPadAnalog_11.pad a_164624_118044# sg13cmos5l_Corner_1.iovdd sg13cmos5l_Corner_1.iovdd sg13_hv_pmos ad=3.9294p pd=7.84u as=2.1312p ps=7.3u w=6.66u l=0.6u
M2234 sg13cmos5l_Corner_1.vss adc8b_0.sar12b_0.nl_sw[2] adc8b_0.side_cap8b_1.buf_16_1.z sg13cmos5l_Corner_1.vss sg13_lv_nmos ad=95f pd=0.88u as=95f ps=0.88u w=0.5u l=0.13u
M2235 a_99694_94311# adc8b_0.sar12b_0.sg13cmos5l_dfrbp_1_0.RESET_B sg13cmos5l_Corner_1.vss sg13cmos5l_Corner_1.vss sg13_lv_nmos ad=37.8f pd=0.6u as=0.1701p ps=1.65u w=0.42u l=0.13u
M2236 sg13cmos5l_Corner_1.vss sg13cmos5l_IOPadVdd$1_0.sg13cmos5l_Clamp_N43N43D4R$1_0.gate vdd sg13cmos5l_Corner_1.vss sg13_hv_nmos ad=1.408p pd=5.04u as=2.596p ps=5.58u w=4.4u l=0.6u
M2237 sg13cmos5l_Corner_1.vss cks adc8b_0.sar12b_0.sg13cmos5l_dfrbp_1_6.RESET_B sg13cmos5l_Corner_1.vss sg13_lv_nmos ad=0.2516p pd=2.16u as=0.1443p ps=1.13u w=0.74u l=0.13u
M2238 a_99352_98326# a_99095_98445# a_99514_98522# sg13cmos5l_Corner_1.vss sg13_lv_nmos ad=0.1428p pd=1.52u as=37.8f ps=0.6u w=0.42u l=0.13u
M2239 sg13cmos5l_Corner_1.iovdd a_102044_42476# data[2] sg13cmos5l_Corner_1.iovdd sg13_hv_pmos ad=2.1312p pd=7.3u as=3.9294p ps=7.84u w=6.66u l=0.6u
M2240 adc8b_0.sar12b_0.sg13cmos5l_buf_1_97.A a_92241_100346# vdd vdd sg13_lv_pmos ad=0.3808p pd=2.92u as=0.2128p ps=1.5u w=1.12u l=0.13u
M2241 adc8b_0.sar12b_0.sg13cmos5l_buf_1_111.A a_101008_98872# vdd vdd sg13_lv_pmos ad=0.42p pd=2.99u as=0.2114p ps=1.54u w=1.12u l=0.13u
M2242 a_99287_97399# a_98445_97301# a_98028_97640# vdd sg13_lv_pmos ad=0.2048p pd=1.63u as=0.34p ps=2.68u w=1u l=0.13u
M2243 sg13cmos5l_Corner_1.iovdd a_42476_118044# cks sg13cmos5l_Corner_1.iovdd sg13_hv_pmos ad=2.1312p pd=7.3u as=3.9294p ps=7.84u w=6.66u l=0.6u
M2244 a_96582_95036# adc8b_0.sar12b_0.sg13cmos5l_nand2_1_1.B vdd vdd sg13_lv_pmos ad=0.2744p pd=1.61u as=0.3808p ps=2.92u w=1.12u l=0.13u
M2245 sg13cmos5l_Corner_1.vss a_178296_102044# sg13cmos5l_IOPadAnalog_16.pad sg13cmos5l_Corner_1.vss sg13_hv_nmos ad=1.408p pd=5.04u as=2.596p ps=5.58u w=4.4u l=0.6u
M2246 adc8b_0.side_cap8b_1.buf_4_3.z adc8b_0.sar12b_0.nl_sw[6] sg13cmos5l_Corner_1.vss sg13cmos5l_Corner_1.vss sg13_lv_nmos ad=0.17p pd=1.68u as=95f ps=0.88u w=0.5u l=0.13u
M2247 sg13cmos5l_IOPadAnalog_11.pad a_178296_118044# sg13cmos5l_Corner_1.vss sg13cmos5l_Corner_1.vss sg13_hv_nmos ad=2.596p pd=5.58u as=1.408p ps=5.04u w=4.4u l=0.6u
M2248 sg13cmos5l_Corner_1.vss adc8b_0.side_cap8b_0.in_h_sw[0] adc8b_0.side_cap8b_0.buf_32_1.z sg13cmos5l_Corner_1.vss sg13_lv_nmos ad=95f pd=0.88u as=95f ps=0.88u w=0.5u l=0.13u
M2249 adc8b_0.side_cap8b_0.buf_16_1.z adc8b_0.side_cap8b_0.in_l_sw[2] sg13cmos5l_Corner_1.vss sg13cmos5l_Corner_1.vss sg13_lv_nmos ad=0.17p pd=1.68u as=95f ps=0.88u w=0.5u l=0.13u
M2250 cko a_118044_42476# sg13cmos5l_Corner_1.iovdd sg13cmos5l_Corner_1.iovdd sg13_hv_pmos ad=3.9294p pd=7.84u as=2.1312p ps=7.3u w=6.66u l=0.6u
M2251 sg13cmos5l_Corner_1.vss a_70044_30676# data[0] sg13cmos5l_Corner_1.vss sg13_hv_nmos ad=1.408p pd=5.04u as=2.596p ps=5.58u w=4.4u l=0.6u
M2252 a_93516_93973# a_93228_93552# a_93454_93973# sg13cmos5l_Corner_1.vss sg13_lv_nmos ad=0.1428p pd=1.52u as=37.8f ps=0.6u w=0.42u l=0.13u
M2253 vin a_42476_86044# sg13cmos5l_Corner_1.iovdd sg13cmos5l_Corner_1.iovdd sg13_hv_pmos ad=3.9294p pd=7.84u as=2.1312p ps=7.3u w=6.66u l=0.6u
M2254 a_85330_96033# a_85773_95789# a_85070_95810# sg13cmos5l_Corner_1.vss sg13_lv_nmos ad=79.8f pd=0.8u as=0.1296p ps=1.52u w=0.42u l=0.13u
X2255 a_36456_132775# sg13cmos5l_IOPadVdd$1_0.sg13cmos5l_RCClampInverter$1_0.in sg13cmos5l_Corner_1.vss rppd l=20u w=1u
M2256 vddr adc8b_0.side_cap8b_0.in_h_sw[0] adc8b_0.side_cap8b_0.buf_32_1.z vddr sg13_lv_pmos ad=0.19p pd=1.38u as=0.19p ps=1.38u w=1u l=0.13u
M2257 adc8b_0.side_cap8b_0.buf_16_2.z adc8b_0.side_cap8b_0.in_l_sw[1] vddr vddr sg13_lv_pmos ad=0.19p pd=1.38u as=0.19p ps=1.38u w=1u l=0.13u
M2258 sg13cmos5l_Corner_1.vss a_99160_96030# a_98809_95887# sg13cmos5l_Corner_1.vss sg13_lv_nmos ad=79.8f pd=0.8u as=0.1428p ps=1.52u w=0.42u l=0.13u
M2259 sg13cmos5l_Corner_1.iovdd a_131639_164698# sg13cmos5l_IOPadAnalog_12.pad sg13cmos5l_Corner_1.iovdd sg13_hv_pmos ad=3.1302p pd=14.26u as=3.9294p ps=7.84u w=6.66u l=0.6u
M2260 adc8b_0.sar12b_0.sg13cmos5l_dfrbp_1_18.Q a_89852_99596# sg13cmos5l_Corner_1.vss sg13cmos5l_Corner_1.vss sg13_lv_nmos ad=0.2516p pd=2.16u as=0.1406p ps=1.12u w=0.74u l=0.13u
M2261 a_88415_96619# adc8b_0.sar12b_0.sg13cmos5l_dfrbp_1_11.Q a_89162_97010# sg13cmos5l_Corner_1.vss sg13_lv_nmos ad=0.1428p pd=1.52u as=60.89999f ps=0.71u w=0.42u l=0.13u
M2262 sg13cmos5l_Corner_1.vss vdd sg13cmos5l_Corner_1.vss sg13cmos5l_Corner_1.vss sg13_lv_nmos ad=0.1428p pd=1.52u as=0 ps=0 w=0.42u l=1u
M2263 a_99167_95107# a_98471_95031# a_99261_95107# sg13cmos5l_Corner_1.vss sg13_lv_nmos ad=0.1296p pd=1.52u as=79.8f ps=0.8u w=0.42u l=0.13u
M2264 a_95052_94616# a_95026_94521# vdd vdd sg13_lv_pmos ad=0.34p pd=2.68u as=0.36237p ps=2.605u w=1u l=0.13u
M2265 sg13cmos5l_Corner_1.vss adc8b_0.sar12b_0.nl_sw[1] adc8b_0.side_cap8b_1.buf_16_2.z sg13cmos5l_Corner_1.vss sg13_lv_nmos ad=95f pd=0.88u as=95f ps=0.88u w=0.5u l=0.13u
M2266 vdd adc8b_0.sar12b_0.sg13cmos5l_nor2_1_0.A a_94582_95852# vdd sg13_lv_pmos ad=0.2618p pd=1.63u as=0.2856p ps=2.36u w=0.84u l=0.13u
M2267 sg13cmos5l_Corner_1.iovdd a_164624_118044# sg13cmos5l_IOPadAnalog_11.pad sg13cmos5l_Corner_1.iovdd sg13_hv_pmos ad=3.1302p pd=14.26u as=3.9294p ps=7.84u w=6.66u l=0.6u
M2268 adc8b_0.sar12b_0.sg13cmos5l_buf_1_8.A adc8b_0.sar12b_0.sg13cmos5l_inv_1_7.A vdd vdd sg13_lv_pmos ad=0.3808p pd=2.92u as=0.3808p ps=2.92u w=1.12u l=0.13u
M2269 adc8b_0.side_cap8b_0.buf_16_3.z adc8b_0.side_cap8b_0.in_h_sw[1] sg13cmos5l_Corner_1.vss sg13cmos5l_Corner_1.vss sg13_lv_nmos ad=95f pd=0.88u as=95f ps=0.88u w=0.5u l=0.13u
M2270 adc8b_0.side_cap8b_0.in_l_sw[5] a_89104_100384# vdd vdd sg13_lv_pmos ad=0.42p pd=2.99u as=0.2114p ps=1.54u w=1.12u l=0.13u
M2271 sg13cmos5l_Corner_1.vss sg13cmos5l_IOPadVdd$1_0.sg13cmos5l_Clamp_N43N43D4R$1_0.gate vdd sg13cmos5l_Corner_1.vss sg13_hv_nmos ad=1.408p pd=5.04u as=2.596p ps=5.58u w=4.4u l=0.6u
M2272 sg13cmos5l_Corner_1.vss a_178296_118044# sg13cmos5l_IOPadAnalog_11.pad sg13cmos5l_Corner_1.vss sg13_hv_nmos ad=1.408p pd=5.04u as=2.596p ps=5.58u w=4.4u l=0.6u
M2273 adc8b_0.sar12b_0.sg13cmos5l_inv_1_5.A a_101564_94596# sg13cmos5l_Corner_1.vss sg13cmos5l_Corner_1.vss sg13_lv_nmos ad=0.2516p pd=2.16u as=0.1406p ps=1.12u w=0.74u l=0.13u
M2274 sg13cmos5l_IOPadAnalog_13.pad a_115639_164698# sg13cmos5l_Corner_1.iovdd sg13cmos5l_Corner_1.iovdd sg13_hv_pmos ad=3.9294p pd=7.84u as=2.1312p ps=7.3u w=6.66u l=0.6u
M2275 adc8b_0.sar12b_0.sg13cmos5l_dfrbp_1_8.RESET_B cks vdd vdd sg13_lv_pmos ad=0.3808p pd=2.92u as=0.3808p ps=2.92u w=1.12u l=0.13u
M2276 adc8b_0.sar12b_0.sg13cmos5l_buf_1_46.A a_91473_95810# sg13cmos5l_Corner_1.vss sg13cmos5l_Corner_1.vss sg13_lv_nmos ad=0.2516p pd=2.16u as=0.1406p ps=1.12u w=0.74u l=0.13u
M2277 sg13cmos5l_Corner_1.vss a_87441_94298# a_87396_94334# sg13cmos5l_Corner_1.vss sg13_lv_nmos ad=0.1428p pd=1.52u as=47.25f ps=0.645u w=0.42u l=0.13u
M2278 adc8b_0.side_cap8b_1.buf_16_2.z adc8b_0.sar12b_0.nl_sw[1] vddr vddr sg13_lv_pmos ad=0.19p pd=1.38u as=0.19p ps=1.38u w=1u l=0.13u
M2279 sg13cmos5l_IOPadAnalog_12.pad a_131639_164698# sg13cmos5l_Corner_1.iovdd sg13cmos5l_Corner_1.iovdd sg13_hv_pmos ad=3.9294p pd=7.84u as=2.1312p ps=7.3u w=6.66u l=0.6u
M2280 sg13cmos5l_Corner_1.vss adc8b_0.side_cap8b_0.in_h_sw[0] adc8b_0.side_cap8b_0.buf_32_1.z sg13cmos5l_Corner_1.vss sg13_lv_nmos ad=95f pd=0.88u as=95f ps=0.88u w=0.5u l=0.13u
M2281 vdd adc8b_0.sar12b_0.sg13cmos5l_dfrbp_1_6.RESET_B a_84082_94521# vdd sg13_lv_pmos ad=0.1563p pd=1.22u as=0.147p ps=1.54u w=0.42u l=0.13u
M2282 a_92056_99838# adc8b_0.sar12b_0.sg13cmos5l_dfrbp_1_8.RESET_B vdd vdd sg13_lv_pmos ad=79.8f pd=0.8u as=1.12242p ps=7u w=0.42u l=0.13u
M2283 adc8b_0.side_cap8b_1.buf_8_4.z adc8b_0.sar12b_0.nl_sw[5] sg13cmos5l_Corner_1.vss sg13cmos5l_Corner_1.vss sg13_lv_nmos ad=95f pd=0.88u as=95f ps=0.88u w=0.5u l=0.13u
M2284 a_84273_95107# a_83916_95064# vdd vdd sg13_lv_pmos ad=63f pd=0.72u as=0.1563p ps=1.22u w=0.42u l=0.13u
M2285 vdd sg13cmos5l_IOPadVdd$1_0.sg13cmos5l_Clamp_N43N43D4R$1_0.gate sg13cmos5l_Corner_1.vss sg13cmos5l_Corner_1.vss sg13_hv_nmos ad=2.596p pd=5.58u as=1.408p ps=5.04u w=4.4u l=0.6u
M2286 a_84242_97322# a_83765_97286# a_84148_97322# sg13cmos5l_Corner_1.vss sg13_lv_nmos ad=37.8f pd=0.6u as=0.1428p ps=1.52u w=0.42u l=0.13u
M2287 adc8b_0.side_cap8b_0.in_l_sw[2] a_84016_100384# sg13cmos5l_Corner_1.vss sg13cmos5l_Corner_1.vss sg13_lv_nmos ad=0.2886p pd=2.26u as=0.14875p ps=1.16u w=0.74u l=0.13u
M2288 a_101212_96960# a_100796_96572# a_100977_96929# sg13cmos5l_Corner_1.vss sg13_lv_nmos ad=77.7f pd=0.95u as=0.2516p ps=2.16u w=0.74u l=0.13u
M2289 a_70096_94286# adc8b_0.diff_bsw_0.single_bsw_1.sg13cmos5l_inv_1$1_0.A sg13cmos5l_Corner_1.vss sg13cmos5l_Corner_1.vss sg13_lv_nmos ad=0.442p pd=3.28u as=0.442p ps=3.28u w=1.3u l=0.4u
M2290 sg13cmos5l_Corner_1.iovdd a_134044_42476# frame sg13cmos5l_Corner_1.iovdd sg13_hv_pmos ad=2.1312p pd=7.3u as=3.9294p ps=7.84u w=6.66u l=0.6u
M2291 sg13cmos5l_Corner_1.iovdd a_134044_42476# frame sg13cmos5l_Corner_1.iovdd sg13_hv_pmos ad=3.1302p pd=14.26u as=3.9294p ps=7.84u w=6.66u l=0.6u
X2292 sg13cmos5l_IOPadAnalog_11.padres sg13cmos5l_IOPadAnalog_11.pad sg13cmos5l_Corner_1.vss rppd l=2u w=1u
M2293 adc8b_0.sar12b_0.sg13cmos5l_dlhr_1_12.D a_98039_98911# sg13cmos5l_Corner_1.vss sg13cmos5l_Corner_1.vss sg13_lv_nmos ad=0.2849p pd=2.25u as=0.2516p ps=2.16u w=0.74u l=0.13u
M2294 a_95800_97542# a_95543_97399# a_95962_97322# sg13cmos5l_Corner_1.vss sg13_lv_nmos ad=0.1428p pd=1.52u as=37.8f ps=0.6u w=0.42u l=0.13u
M2295 vddr adc8b_0.side_cap8b_0.in_h_sw[10] adc8b_0.side_cap8b_0.buf_1_1.z vddr sg13_lv_pmos ad=0.34p pd=2.68u as=0.34p ps=2.68u w=1u l=0.13u
M2296 a_97810_98052# a_98253_98095# a_98193_98131# vdd sg13_lv_pmos ad=79.8f pd=0.8u as=63f ps=0.72u w=0.42u l=0.13u
M2297 sg13cmos5l_Corner_1.vss a_101012_93512# adc8b_0.sar12b_0.nl_sw[9] sg13cmos5l_Corner_1.vss sg13_lv_nmos ad=0.14875p pd=1.16u as=0.2886p ps=2.26u w=0.74u l=0.13u
M2298 sg13cmos5l_Corner_1.vss vdd sg13cmos5l_Corner_1.vss sg13cmos5l_Corner_1.vss sg13_lv_nmos ad=0.1428p pd=1.52u as=0 ps=0 w=0.42u l=1u
M2299 vdd adc8b_0.sar12b_0.sg13cmos5l_nor2_1_0.A a_95092_95856# vdd sg13_lv_pmos ad=0.1596p pd=1.22u as=0.2856p ps=2.36u w=0.84u l=0.13u
M2300 vdd a_100131_95430# adc8b_0.sar12b_0.sg13cmos5l_or2_1_0.A vdd sg13_lv_pmos ad=0.3864p pd=2.93u as=0.2128p ps=1.5u w=1.12u l=0.13u
M2301 a_84406_97322# a_84148_97322# sg13cmos5l_Corner_1.vss sg13cmos5l_Corner_1.vss sg13_lv_nmos ad=0.1428p pd=1.52u as=79.8f ps=0.8u w=0.42u l=0.13u
M2302 a_89100_98834# adc8b_0.sar12b_0.sg13cmos5l_dfrbp_1_6.D a_89006_98834# sg13cmos5l_Corner_1.vss sg13_lv_nmos ad=60.89999f pd=0.71u as=0.1428p ps=1.52u w=0.42u l=0.13u
M2303 vddr adc8b_0.side_cap8b_0.in_l_sw[0] adc8b_0.side_cap8b_0.buf_32_0.z vddr sg13_lv_pmos ad=0.19p pd=1.38u as=0.19p ps=1.38u w=1u l=0.13u
M2304 adc8b_0.sar12b_0.sg13cmos5l_dfrbp_1_23.CLK a_95996_100644# vdd vdd sg13_lv_pmos ad=0.3808p pd=2.92u as=0.2128p ps=1.5u w=1.12u l=0.13u
M2305 vdd sg13cmos5l_IOPadVdd$1_0.sg13cmos5l_Clamp_N43N43D4R$1_0.gate sg13cmos5l_Corner_1.vss sg13cmos5l_Corner_1.vss sg13_hv_nmos ad=2.596p pd=5.58u as=1.408p ps=5.04u w=4.4u l=0.6u
M2306 adc8b_0.side_cap8b_0.buf_32_0.z adc8b_0.side_cap8b_0.in_l_sw[0] vddr vddr sg13_lv_pmos ad=0.19p pd=1.38u as=0.19p ps=1.38u w=1u l=0.13u
M2307 adc8b_0.side_cap8b_1.buf_2_3.z adc8b_0.sar12b_0.nh_sw[9] sg13cmos5l_Corner_1.vss sg13cmos5l_Corner_1.vss sg13_lv_nmos ad=0.17p pd=1.68u as=95f ps=0.88u w=0.5u l=0.13u
M2308 adc8b_0.side_cap8b_1.buf_32_0.z adc8b_0.sar12b_0.nl_sw[0] sg13cmos5l_Corner_1.vss sg13cmos5l_Corner_1.vss sg13_lv_nmos ad=95f pd=0.88u as=95f ps=0.88u w=0.5u l=0.13u
M2309 sg13cmos5l_Corner_1.vss adc8b_0.sar12b_0.sg13cmos5l_dfrbp_1_0.RESET_B a_98988_92786# sg13cmos5l_Corner_1.vss sg13_lv_nmos ad=0.1626p pd=1.415u as=60.89999f ps=0.71u w=0.42u l=0.13u
M2310 a_91647_100362# adc8b_0.sar12b_0.sg13cmos5l_dfrbp_1_18.Q vdd vdd sg13_lv_pmos ad=0.3234p pd=2.45u as=4.11675p ps=27.17u w=0.84u l=0.13u
M2311 a_92241_100346# a_92060_100668# vdd vdd sg13_lv_pmos ad=0.2128p pd=1.5u as=0.2387p ps=1.84u w=1.12u l=0.13u
M2312 a_97857_99719# a_96915_99607# a_97655_99957# vdd sg13_lv_pmos ad=93.45f pd=0.865u as=0.2048p ps=1.63u w=0.42u l=0.13u
M2313 adc8b_0.sar12b_0.sg13cmos5l_buf_1_105.A a_99729_99953# sg13cmos5l_Corner_1.vss sg13cmos5l_Corner_1.vss sg13_lv_nmos ad=0.2516p pd=2.16u as=0.1406p ps=1.12u w=0.74u l=0.13u
M2314 a_97137_99225# a_96780_99152# vdd vdd sg13_lv_pmos ad=63f pd=0.72u as=0.1563p ps=1.22u w=0.42u l=0.13u
M2315 a_83252_97286# adc8b_0.sar12b_0.sg13cmos5l_buf_1_58.A sg13cmos5l_Corner_1.vss sg13cmos5l_Corner_1.vss sg13_lv_nmos ad=0.187p pd=1.78u as=0.14875p ps=1.16u w=0.55u l=0.13u
M2316 adc8b_0.side_cap8b_1.buf_16_1.z adc8b_0.sar12b_0.nl_sw[2] sg13cmos5l_Corner_1.vss sg13cmos5l_Corner_1.vss sg13_lv_nmos ad=95f pd=0.88u as=95f ps=0.88u w=0.5u l=0.13u
M2317 a_94188_100359# a_94419_100468# a_93874_100569# sg13cmos5l_Corner_1.vss sg13_lv_nmos ad=0.2373p pd=1.97u as=79.8f ps=0.8u w=0.42u l=0.13u
M2318 cko a_118044_30676# sg13cmos5l_Corner_1.vss sg13cmos5l_Corner_1.vss sg13_hv_nmos ad=2.596p pd=5.58u as=1.408p ps=5.04u w=4.4u l=0.6u
M2319 sg13cmos5l_Corner_1.vss a_85809_93905# a_86334_93978# sg13cmos5l_Corner_1.vss sg13_lv_nmos ad=0.1491p pd=1.18u as=0.187p ps=1.78u w=0.55u l=0.13u
M2320 sg13cmos5l_IOPadAnalog_9.pad a_83639_164698# sg13cmos5l_Corner_1.iovdd sg13cmos5l_Corner_1.iovdd sg13_hv_pmos ad=3.9294p pd=7.84u as=2.1312p ps=7.3u w=6.66u l=0.6u
M2321 adc8b_0.side_cap8b_0.buf_16_2.z adc8b_0.side_cap8b_0.in_l_sw[1] sg13cmos5l_Corner_1.vss sg13cmos5l_Corner_1.vss sg13_lv_nmos ad=95f pd=0.88u as=95f ps=0.88u w=0.5u l=0.13u
M2322 vdd adc8b_0.sar12b_0.sg13cmos5l_dfrbp_1_12.Q_N a_90673_95864# vdd sg13_lv_pmos ad=1.28962p pd=8.195u as=0.2856p ps=2.36u w=0.84u l=0.13u
M2323 a_96945_96929# a_96764_96572# vdd vdd sg13_lv_pmos ad=0.2128p pd=1.5u as=0.2387p ps=1.84u w=1.12u l=0.13u
M2324 cks a_42476_118044# sg13cmos5l_Corner_1.iovdd sg13cmos5l_Corner_1.iovdd sg13_hv_pmos ad=3.9294p pd=7.84u as=2.1312p ps=7.3u w=6.66u l=0.6u
M2325 sg13cmos5l_Corner_1.vss a_90808_99054# a_90457_98911# sg13cmos5l_Corner_1.vss sg13_lv_nmos ad=79.8f pd=0.8u as=0.1428p ps=1.52u w=0.42u l=0.13u
M2326 a_89709_98813# adc8b_0.sar12b_0.sg13cmos5l_dfrbp_1_18.Q sg13cmos5l_Corner_1.vss sg13cmos5l_Corner_1.vss sg13_lv_nmos ad=0.2516p pd=2.16u as=1.49685p ps=9.6u w=0.74u l=0.13u
X2327 a_134044_30676# sg13cmos5l_Corner_1.vss sg13cmos5l_Corner_1.vss rppd l=3.54u w=0.5u
M2328 adc8b_0.side_cap8b_1.buf_16_3.z adc8b_0.sar12b_0.nh_sw[1] vddr vddr sg13_lv_pmos ad=0.19p pd=1.38u as=0.19p ps=1.38u w=1u l=0.13u
M2329 adc8b_0.side_cap8b_1.buf_32_0.z adc8b_0.sar12b_0.nl_sw[0] sg13cmos5l_Corner_1.vss sg13cmos5l_Corner_1.vss sg13_lv_nmos ad=95f pd=0.88u as=95f ps=0.88u w=0.5u l=0.13u
X2330 a_36456_136075# a_40542_135745# sg13cmos5l_Corner_1.vss rppd l=20u w=1u
M2331 adc8b_0.sar12b_0.sg13cmos5l_dfrbp_1_10.Q a_86204_94596# sg13cmos5l_Corner_1.vss sg13cmos5l_Corner_1.vss sg13_lv_nmos ad=0.2516p pd=2.16u as=0.1406p ps=1.12u w=0.74u l=0.13u
M2332 sg13cmos5l_Corner_1.vss sg13cmos5l_IOPadVdd$1_0.sg13cmos5l_Clamp_N43N43D4R$1_0.gate vdd sg13cmos5l_Corner_1.vss sg13_hv_nmos ad=1.408p pd=5.04u as=2.596p ps=5.58u w=4.4u l=0.6u
M2333 sg13cmos5l_Corner_1.vss adc8b_0.side_cap8b_0.in_l_sw[2] adc8b_0.side_cap8b_0.buf_16_1.z sg13cmos5l_Corner_1.vss sg13_lv_nmos ad=95f pd=0.88u as=95f ps=0.88u w=0.5u l=0.13u
M2334 sg13cmos5l_Corner_1.iovdd a_131639_164698# sg13cmos5l_IOPadAnalog_12.pad sg13cmos5l_Corner_1.iovdd sg13_hv_pmos ad=2.1312p pd=7.3u as=3.9294p ps=7.84u w=6.66u l=0.6u
M2335 vdd a_93984_96888# adc8b_0.sar12b_0.sg13cmos5l_a221oi_1_0.B1 vdd sg13_lv_pmos ad=0.2226p pd=1.535u as=0.3976p ps=2.95u w=1.12u l=0.13u
M2336 sg13cmos5l_Corner_1.iovdd a_70044_42476# data[0] sg13cmos5l_Corner_1.iovdd sg13_hv_pmos ad=2.1312p pd=7.3u as=3.9294p ps=7.84u w=6.66u l=0.6u
M2337 sg13cmos5l_Corner_1.iovdd a_70044_42476# data[0] sg13cmos5l_Corner_1.iovdd sg13_hv_pmos ad=3.1302p pd=14.26u as=3.9294p ps=7.84u w=6.66u l=0.6u
M2338 a_93036_93986# adc8b_0.sar12b_0.sg13cmos5l_dfrbp_1_4.D a_92942_93986# sg13cmos5l_Corner_1.vss sg13_lv_nmos ad=60.89999f pd=0.71u as=0.1428p ps=1.52u w=0.42u l=0.13u
M2339 adc8b_0.side_cap8b_0.buf_32_1.z adc8b_0.side_cap8b_0.in_h_sw[0] vddr vddr sg13_lv_pmos ad=0.19p pd=1.38u as=0.19p ps=1.38u w=1u l=0.13u
M2340 vdd adc8b_0.sar12b_0.sg13cmos5l_dfrbp_1_15.D a_84389_98796# vdd sg13_lv_pmos ad=1.15047p pd=7.175u as=0.3234p ps=2.45u w=0.84u l=0.13u
M2341 a_88114_96033# a_88557_95789# a_88497_96201# vdd sg13_lv_pmos ad=79.8f pd=0.8u as=63f ps=0.72u w=0.42u l=0.13u
M2342 sg13cmos5l_IOPadAnalog_12.pad a_131639_164698# sg13cmos5l_Corner_1.iovdd sg13cmos5l_Corner_1.iovdd sg13_hv_pmos ad=3.9294p pd=7.84u as=2.1312p ps=7.3u w=6.66u l=0.6u
M2343 sg13cmos5l_Corner_1.vss sg13cmos5l_IOPadVdd$1_0.sg13cmos5l_Clamp_N43N43D4R$1_0.gate vdd sg13cmos5l_Corner_1.vss sg13_hv_nmos ad=1.408p pd=5.04u as=2.596p ps=5.58u w=4.4u l=0.6u
M2344 adc8b_0.side_cap8b_0.buf_8_3.z adc8b_0.side_cap8b_0.in_h_sw[3] vddr vddr sg13_lv_pmos ad=0.19p pd=1.38u as=0.19p ps=1.38u w=1u l=0.13u
M2345 vdd a_94840_95302# a_94785_95183# vdd sg13_lv_pmos ad=1.43437p pd=9.105u as=93.45f ps=0.865u w=0.42u l=0.13u
M2346 adc8b_0.side_cap8b_1.buf_32_1.z adc8b_0.sar12b_0.nh_sw[0] sg13cmos5l_Corner_1.vss sg13cmos5l_Corner_1.vss sg13_lv_nmos ad=95f pd=0.88u as=95f ps=0.88u w=0.5u l=0.13u
M2347 sg13cmos5l_Corner_1.vss a_102044_30676# data[2] sg13cmos5l_Corner_1.vss sg13_hv_nmos ad=1.408p pd=5.04u as=2.596p ps=5.58u w=4.4u l=0.6u
M2348 vddr adc8b_0.sar12b_0.nl_sw[6] adc8b_0.side_cap8b_1.buf_4_3.z vddr sg13_lv_pmos ad=0.19p pd=1.38u as=0.34p ps=2.68u w=1u l=0.13u
M2349 sg13cmos5l_Corner_1.vss a_30676_70044# vddr sg13cmos5l_Corner_1.vss sg13_hv_nmos ad=1.408p pd=5.04u as=2.596p ps=5.58u w=4.4u l=0.6u
M2350 a_85444_99124# adc8b_0.sar12b_0.sg13cmos5l_dfrbp_1_6.RESET_B vdd vdd sg13_lv_pmos ad=0.2128p pd=1.5u as=0.2128p ps=1.5u w=1.12u l=0.13u
M2351 a_98066_95498# a_97589_95024# a_97972_95498# sg13cmos5l_Corner_1.vss sg13_lv_nmos ad=37.8f pd=0.6u as=0.1428p ps=1.52u w=0.42u l=0.13u
M2352 vip a_42476_102044# sg13cmos5l_Corner_1.iovdd sg13cmos5l_Corner_1.iovdd sg13_hv_pmos ad=3.9294p pd=7.84u as=2.1312p ps=7.3u w=6.66u l=0.6u
M2353 a_90356_95024# adc8b_0.sar12b_0.sg13cmos5l_buf_1_46.A vdd vdd sg13_lv_pmos ad=0.2856p pd=2.36u as=0.2114p ps=1.54u w=0.84u l=0.13u
M2354 sg13cmos5l_Corner_1.vss adc8b_0.sar12b_0.sg13cmos5l_buf_1_5.A a_96208_92824# sg13cmos5l_Corner_1.vss sg13_lv_nmos ad=0.14875p pd=1.16u as=0.187p ps=1.78u w=0.55u l=0.13u
M2355 vin a_42476_86044# sg13cmos5l_Corner_1.iovdd sg13cmos5l_Corner_1.iovdd sg13_hv_pmos ad=3.9294p pd=7.84u as=2.1312p ps=7.3u w=6.66u l=0.6u
X2356 sg13cmos5l_Corner_1.vss a_102222_32962# dantenna l=1.26u w=27.78u
M2357 sg13cmos5l_IOPadVdd$1_0.sg13cmos5l_Clamp_N43N43D4R$1_0.gate sg13cmos5l_IOPadVdd$1_0.sg13cmos5l_RCClampInverter$1_0.in vdd vdd sg13_hv_pmos ad=1.33p pd=7.38u as=1.33p ps=7.38u w=7u l=0.5u
M2358 a_73970_98361# adc8b_0.diff_bsw_0.vcn a_74586_95659# sg13cmos5l_Corner_1.vss sg13_lv_nmos ad=1.7p pd=10.68u as=0.95p ps=5.38u w=5u l=0.13u
M2359 vddr adc8b_0.sar12b_0.nh_sw[2] adc8b_0.side_cap8b_1.buf_16_0.z vddr sg13_lv_pmos ad=0.19p pd=1.38u as=0.19p ps=1.38u w=1u l=0.13u
X2360 data[1] sg13cmos5l_Corner_1.iovdd dpantenna l=1.26u w=27.78u
M2361 vdd sg13cmos5l_IOPadVdd$1_0.sg13cmos5l_Clamp_N43N43D4R$1_0.gate sg13cmos5l_Corner_1.vss sg13cmos5l_Corner_1.vss sg13_hv_nmos ad=2.596p pd=5.58u as=1.408p ps=5.04u w=4.4u l=0.6u
M2362 sg13cmos5l_Corner_1.iovdd a_164624_70044# sg13cmos5l_IOPadAnalog_1.pad sg13cmos5l_Corner_1.iovdd sg13_hv_pmos ad=2.1312p pd=7.3u as=3.9294p ps=7.84u w=6.66u l=0.6u
M2363 sg13cmos5l_Corner_1.vss a_86900_100310# adc8b_0.sar12b_0.sg13cmos5l_buf_1_64.A sg13cmos5l_Corner_1.vss sg13_lv_nmos ad=0.14875p pd=1.16u as=0.2886p ps=2.26u w=0.74u l=0.13u
M2364 sg13cmos5l_IOPadAnalog_0.pad a_164624_86044# sg13cmos5l_Corner_1.iovdd sg13cmos5l_Corner_1.iovdd sg13_hv_pmos ad=3.9294p pd=7.84u as=2.1312p ps=7.3u w=6.66u l=0.6u
M2365 sg13cmos5l_Corner_1.vss a_30676_102044# vip sg13cmos5l_Corner_1.vss sg13_hv_nmos ad=1.408p pd=5.04u as=2.596p ps=5.58u w=4.4u l=0.6u
M2366 adc8b_0.sar12b_0.sg13cmos5l_dfrbp_1_6.RESET_B cks sg13cmos5l_Corner_1.vss sg13cmos5l_Corner_1.vss sg13_lv_nmos ad=0.1406p pd=1.12u as=0.1406p ps=1.12u w=0.74u l=0.13u
M2367 adc8b_0.sar12b_0.sg13cmos5l_dfrbp_1_22.Q_N a_99095_98445# vdd vdd sg13_lv_pmos ad=0.4312p pd=3.01u as=0.2639p ps=1.81u w=1.12u l=0.13u
M2368 a_93138_96920# adc8b_0.sar12b_0.sg13cmos5l_inv_1_0.A a_93036_96920# sg13cmos5l_Corner_1.vss sg13_lv_nmos ad=0.1216p pd=1.02u as=0.1216p ps=1.02u w=0.64u l=0.13u
M2369 a_84082_94521# a_84525_94277# a_83822_94298# sg13cmos5l_Corner_1.vss sg13_lv_nmos ad=79.8f pd=0.8u as=0.1296p ps=1.52u w=0.42u l=0.13u
M2370 vdd a_98516_100310# adc8b_0.side_cap8b_0.in_l_sw[7] vdd sg13_lv_pmos ad=0.2114p pd=1.54u as=0.42p ps=2.99u w=1.12u l=0.13u
M2371 data[2] a_102044_30676# sg13cmos5l_Corner_1.vss sg13cmos5l_Corner_1.vss sg13_hv_nmos ad=2.596p pd=5.58u as=1.408p ps=5.04u w=4.4u l=0.6u
X2372 sg13cmos5l_IOPadAnalog_7.padres sg13cmos5l_Corner_1.iovdd dpantenna l=0.64u w=4.98u
M2373 sg13cmos5l_IOPadAnalog_11.pad a_178296_118044# sg13cmos5l_Corner_1.vss sg13cmos5l_Corner_1.vss sg13_hv_nmos ad=2.596p pd=5.58u as=1.408p ps=5.04u w=4.4u l=0.6u
M2374 a_99756_94311# a_99468_94616# a_99694_94311# sg13cmos5l_Corner_1.vss sg13_lv_nmos ad=0.1428p pd=1.52u as=37.8f ps=0.6u w=0.42u l=0.13u
M2375 vddr a_30676_70044# sg13cmos5l_Corner_1.vss sg13cmos5l_Corner_1.vss sg13_hv_nmos ad=2.596p pd=5.58u as=1.408p ps=5.04u w=4.4u l=0.6u
M2376 a_93132_92786# adc8b_0.sar12b_0.sg13cmos5l_dfrbp_1_1.D a_93038_92786# sg13cmos5l_Corner_1.vss sg13_lv_nmos ad=60.89999f pd=0.71u as=0.1428p ps=1.52u w=0.42u l=0.13u
M2377 vdd a_94487_93909# a_95324_93548# vdd sg13_lv_pmos ad=0.2128p pd=1.5u as=0.3864p ps=2.93u w=1.12u l=0.13u
M2378 sg13cmos5l_IOPadAnalog_13.pad a_115639_164698# sg13cmos5l_Corner_1.iovdd sg13cmos5l_Corner_1.iovdd sg13_hv_pmos ad=3.9294p pd=7.84u as=2.1312p ps=7.3u w=6.66u l=0.6u
M2379 sg13cmos5l_Corner_1.vss adc8b_0.side_cap8b_0.in_l_sw[4] adc8b_0.side_cap8b_0.buf_8_0.z sg13cmos5l_Corner_1.vss sg13_lv_nmos ad=95f pd=0.88u as=95f ps=0.88u w=0.5u l=0.13u
M2380 adc8b_0.sar12b_0.sg13cmos5l_buf_1_96.A a_92433_98441# sg13cmos5l_Corner_1.vss sg13cmos5l_Corner_1.vss sg13_lv_nmos ad=0.2516p pd=2.16u as=0.1406p ps=1.12u w=0.74u l=0.13u
M2381 adc8b_0.cmp_0.sg13cmos5l_inv_1$1_1.Y adc8b_0.cmp_0.outn sg13cmos5l_Corner_1.vss sg13cmos5l_Corner_1.vss sg13_lv_nmos ad=0.2516p pd=2.16u as=0.2516p ps=2.16u w=0.74u l=0.13u
M2382 vddr adc8b_0.sar12b_0.nh_sw[0] adc8b_0.side_cap8b_1.buf_32_1.z vddr sg13_lv_pmos ad=0.19p pd=1.38u as=0.19p ps=1.38u w=1u l=0.13u
M2383 adc8b_0.sar12b_0.sg13cmos5l_dfrbp_1_23.Q_N a_95543_97399# vdd vdd sg13_lv_pmos ad=0.4312p pd=3.01u as=0.2639p ps=1.81u w=1.12u l=0.13u
M2384 vddr adc8b_0.side_cap8b_0.in_h_sw[4] adc8b_0.side_cap8b_0.buf_8_2.z vddr sg13_lv_pmos ad=0.19p pd=1.38u as=0.19p ps=1.38u w=1u l=0.13u
M2385 vddr adc8b_0.sar12b_0.nl_sw[0] adc8b_0.side_cap8b_1.buf_32_0.z vddr sg13_lv_pmos ad=0.19p pd=1.38u as=0.19p ps=1.38u w=1u l=0.13u
M2386 vdd adc8b_0.sar12b_0.sg13cmos5l_dfrbp_1_8.RESET_B a_87470_100034# vdd sg13_lv_pmos ad=0.36237p pd=2.605u as=79.8f ps=0.8u w=0.42u l=0.13u
M2387 a_100767_97338# adc8b_0.sar12b_0.sg13cmos5l_dfrbp_1_8.D vdd vdd sg13_lv_pmos ad=0.3234p pd=2.45u as=1.04815p ps=6.595u w=0.84u l=0.13u
M2388 vdd sg13cmos5l_Corner_1.vss vdd vdd sg13_lv_pmos ad=0.34p pd=2.68u as=0 ps=0 w=1u l=1u
M2389 vdd a_90740_95024# adc8b_0.sar12b_0.sg13cmos5l_buf_1_45.X vdd sg13_lv_pmos ad=0.2114p pd=1.54u as=0.42p ps=2.99u w=1.12u l=0.13u
M2390 vddr a_42476_70044# sg13cmos5l_Corner_1.iovdd sg13cmos5l_Corner_1.iovdd sg13_hv_pmos ad=3.9294p pd=7.84u as=2.1312p ps=7.3u w=6.66u l=0.6u
M2391 a_94804_96108# a_94582_95852# vdd vdd sg13_lv_pmos ad=0.1176p pd=1.33u as=0.2618p ps=1.63u w=1.12u l=0.13u
M2392 sg13cmos5l_IOPadAnalog_16.pad a_164624_102044# sg13cmos5l_Corner_1.iovdd sg13cmos5l_Corner_1.iovdd sg13_hv_pmos ad=3.9294p pd=7.84u as=2.1312p ps=7.3u w=6.66u l=0.6u
M2393 a_88984_97542# adc8b_0.sar12b_0.sg13cmos5l_dfrbp_1_6.RESET_B vdd vdd sg13_lv_pmos ad=79.8f pd=0.8u as=1.04815p ps=6.595u w=0.42u l=0.13u
M2394 sg13cmos5l_Corner_1.iovdd a_164624_86044# sg13cmos5l_IOPadAnalog_0.pad sg13cmos5l_Corner_1.iovdd sg13_hv_pmos ad=2.1312p pd=7.3u as=3.9294p ps=7.84u w=6.66u l=0.6u
M2395 a_93874_100569# a_94317_100325# a_94257_100737# vdd sg13_lv_pmos ad=79.8f pd=0.8u as=63f ps=0.72u w=0.42u l=0.13u
M2396 sg13cmos5l_Corner_1.vss a_30676_118044# cks sg13cmos5l_Corner_1.vss sg13_hv_nmos ad=1.408p pd=5.04u as=2.596p ps=5.58u w=4.4u l=0.6u
M2397 a_96590_98084# a_96194_98448# a_96476_98084# vdd sg13_lv_pmos ad=0.1008p pd=0.9u as=0.191p ps=1.44u w=0.42u l=0.13u
M2398 a_82450_96540# a_82893_96583# a_82190_97010# sg13cmos5l_Corner_1.vss sg13_lv_nmos ad=79.8f pd=0.8u as=0.1296p ps=1.52u w=0.42u l=0.13u
M2399 sg13cmos5l_Corner_1.vss sg13cmos5l_IOPadVdd$1_0.sg13cmos5l_RCClampInverter$1_0.in sg13cmos5l_Corner_1.vss sg13cmos5l_Corner_1.vss sg13_hv_nmos ad=1.71p pd=9.38u as=0 ps=0 w=9u l=9.5u
M2400 a_92180_97286# adc8b_0.sar12b_0.sg13cmos5l_dlhr_1_5.Q vdd vdd sg13_lv_pmos ad=0.2856p pd=2.36u as=0.2114p ps=1.54u w=0.84u l=0.13u
M2401 sg13cmos5l_Corner_1.vss a_100995_95814# adc8b_0.sar12b_0.sg13cmos5l_buf_8_0.X sg13cmos5l_Corner_1.vss sg13_lv_nmos ad=0.1406p pd=1.12u as=0.1406p ps=1.12u w=0.74u l=0.13u
M2402 sg13cmos5l_IOPadAnalog_16.pad a_178296_102044# sg13cmos5l_Corner_1.vss sg13cmos5l_Corner_1.vss sg13_hv_nmos ad=2.596p pd=5.58u as=1.408p ps=5.04u w=4.4u l=0.6u
M2403 sg13cmos5l_Corner_1.iovdd a_131639_164698# sg13cmos5l_IOPadAnalog_12.pad sg13cmos5l_Corner_1.iovdd sg13_hv_pmos ad=2.1312p pd=7.3u as=3.9294p ps=7.84u w=6.66u l=0.6u
M2404 vin a_30676_86044# sg13cmos5l_Corner_1.vss sg13cmos5l_Corner_1.vss sg13_hv_nmos ad=2.596p pd=5.58u as=1.408p ps=5.04u w=4.4u l=0.6u
M2405 a_98319_95147# a_98471_95031# sg13cmos5l_Corner_1.vss sg13cmos5l_Corner_1.vss sg13_lv_nmos ad=0.2516p pd=2.16u as=2.41737p ps=15.64u w=0.74u l=0.13u
M2406 sg13cmos5l_Corner_1.iovdd a_102044_42476# data[2] sg13cmos5l_Corner_1.iovdd sg13_hv_pmos ad=2.1312p pd=7.3u as=3.9294p ps=7.84u w=6.66u l=0.6u
M2407 sg13cmos5l_Corner_1.vss adc8b_0.sar12b_0.nl_sw[2] adc8b_0.side_cap8b_1.buf_16_1.z sg13cmos5l_Corner_1.vss sg13_lv_nmos ad=95f pd=0.88u as=95f ps=0.88u w=0.5u l=0.13u
M2408 vddr a_42476_70044# sg13cmos5l_Corner_1.iovdd sg13cmos5l_Corner_1.iovdd sg13_hv_pmos ad=3.9294p pd=7.84u as=2.1312p ps=7.3u w=6.66u l=0.6u
M2409 a_89588_100310# adc8b_0.sar12b_0.sg13cmos5l_buf_1_73.A sg13cmos5l_Corner_1.vss sg13cmos5l_Corner_1.vss sg13_lv_nmos ad=0.187p pd=1.78u as=0.14875p ps=1.16u w=0.55u l=0.13u
M2410 a_86092_99156# a_86117_98796# sg13cmos5l_Corner_1.vss sg13cmos5l_Corner_1.vss sg13_lv_nmos ad=0.2775p pd=2.23u as=1.49685p ps=9.6u w=0.74u l=0.13u
M2411 a_86702_93986# a_87507_93559# a_86962_93516# vdd sg13_lv_pmos ad=0.1428p pd=1.52u as=79.8f ps=0.8u w=0.42u l=0.13u
M2412 a_87468_97640# a_87442_97545# vdd vdd sg13_lv_pmos ad=0.34p pd=2.68u as=0.36237p ps=2.605u w=1u l=0.13u
M2413 a_82284_97010# adc8b_0.sar12b_0.sg13cmos5l_dfrbp_1_6.D a_82190_97010# sg13cmos5l_Corner_1.vss sg13_lv_nmos ad=60.89999f pd=0.71u as=0.1428p ps=1.52u w=0.42u l=0.13u
M2414 a_86900_95024# adc8b_0.sar12b_0.sg13cmos5l_buf_1_44.A vdd vdd sg13_lv_pmos ad=0.2856p pd=2.36u as=0.2114p ps=1.54u w=0.84u l=0.13u
M2415 sg13cmos5l_Corner_1.vss adc8b_0.sar12b_0.nh_sw[0] adc8b_0.side_cap8b_1.buf_32_1.z sg13cmos5l_Corner_1.vss sg13_lv_nmos ad=95f pd=0.88u as=95f ps=0.88u w=0.5u l=0.13u
M2416 sg13cmos5l_Corner_1.vss adc8b_0.sar12b_0.nl_sw[0] adc8b_0.side_cap8b_1.buf_32_0.z sg13cmos5l_Corner_1.vss sg13_lv_nmos ad=95f pd=0.88u as=95f ps=0.88u w=0.5u l=0.13u
M2417 sg13cmos5l_Corner_1.vss sg13cmos5l_IOPadVdd$1_0.sg13cmos5l_RCClampInverter$1_0.in sg13cmos5l_Corner_1.vss sg13cmos5l_Corner_1.vss sg13_hv_nmos ad=1.71p pd=9.38u as=0 ps=0 w=9u l=9.5u
M2418 vdd a_94815_98850# a_94946_98844# vdd sg13_lv_pmos ad=1.15047p pd=7.175u as=0.2856p ps=2.36u w=0.84u l=0.13u
X2419 sg13cmos5l_Corner_1.vss a_30676_102044# sg13cmos5l_Corner_1.vss rppd l=3.54u w=0.5u
M2420 vddr adc8b_0.side_cap8b_0.in_l_sw[6] adc8b_0.side_cap8b_0.buf_4_3.z vddr sg13_lv_pmos ad=0.19p pd=1.38u as=0.34p ps=2.68u w=1u l=0.13u
M2421 a_89084_94620# a_88671_94314# a_89016_94620# vdd sg13_lv_pmos ad=0.191p pd=1.44u as=0.105p ps=1.21u w=1u l=0.13u
M2422 adc8b_0.sar12b_0.nl_sw[6] a_93424_94336# vdd vdd sg13_lv_pmos ad=0.42p pd=2.99u as=0.2114p ps=1.54u w=1.12u l=0.13u
M2423 sg13cmos5l_Corner_1.iovdd a_134044_42476# frame sg13cmos5l_Corner_1.iovdd sg13_hv_pmos ad=2.1312p pd=7.3u as=3.9294p ps=7.84u w=6.66u l=0.6u
M2424 sg13cmos5l_IOPadAnalog_13.pad a_115639_164698# sg13cmos5l_Corner_1.iovdd sg13cmos5l_Corner_1.iovdd sg13_hv_pmos ad=3.9294p pd=7.84u as=3.1302p ps=14.26u w=6.66u l=0.6u
M2425 adc8b_0.side_cap8b_0.buf_16_1.z adc8b_0.side_cap8b_0.in_l_sw[2] vddr vddr sg13_lv_pmos ad=0.19p pd=1.38u as=0.19p ps=1.38u w=1u l=0.13u
M2426 a_86228_100310# adc8b_0.sar12b_0.sg13cmos5l_buf_1_60.A sg13cmos5l_Corner_1.vss sg13cmos5l_Corner_1.vss sg13_lv_nmos ad=0.187p pd=1.78u as=0.14875p ps=1.16u w=0.55u l=0.13u
M2427 a_99932_99156# a_99650_98844# a_99865_98826# sg13cmos5l_Corner_1.vss sg13_lv_nmos ad=0.141p pd=1.17u as=71.99999f ps=0.865u w=0.64u l=0.13u
M2428 sg13cmos5l_IOPadAnalog_0.pad a_178296_86044# sg13cmos5l_Corner_1.vss sg13cmos5l_Corner_1.vss sg13_hv_nmos ad=2.596p pd=5.58u as=1.408p ps=5.04u w=4.4u l=0.6u
M2429 sg13cmos5l_IOPadAnalog_12.pad a_131639_164698# sg13cmos5l_Corner_1.iovdd sg13cmos5l_Corner_1.iovdd sg13_hv_pmos ad=3.9294p pd=7.84u as=2.1312p ps=7.3u w=6.66u l=0.6u
M2430 a_83916_99600# a_83890_99564# sg13cmos5l_Corner_1.vss sg13cmos5l_Corner_1.vss sg13_lv_nmos ad=0.2516p pd=2.16u as=0.1626p ps=1.415u w=0.74u l=0.13u
M2431 a_85628_93548# a_85215_93906# a_85560_93548# vdd sg13_lv_pmos ad=0.191p pd=1.44u as=0.105p ps=1.21u w=1u l=0.13u
M2432 a_96684_100021# a_96915_99607# a_96370_99564# sg13cmos5l_Corner_1.vss sg13_lv_nmos ad=0.2373p pd=1.97u as=79.8f ps=0.8u w=0.42u l=0.13u
M2433 a_84142_95485# adc8b_0.sar12b_0.sg13cmos5l_dfrbp_1_8.RESET_B sg13cmos5l_Corner_1.vss sg13cmos5l_Corner_1.vss sg13_lv_nmos ad=37.8f pd=0.6u as=0.1701p ps=1.65u w=0.42u l=0.13u
M2434 a_90356_95024# adc8b_0.sar12b_0.sg13cmos5l_buf_1_46.A sg13cmos5l_Corner_1.vss sg13cmos5l_Corner_1.vss sg13_lv_nmos ad=0.187p pd=1.78u as=0.14875p ps=1.16u w=0.55u l=0.13u
M2435 a_95409_94689# a_95052_94616# vdd vdd sg13_lv_pmos ad=63f pd=0.72u as=0.1563p ps=1.22u w=0.42u l=0.13u
M2436 vdd a_98708_94262# adc8b_0.sar12b_0.nh_sw[8] vdd sg13_lv_pmos ad=0.2114p pd=1.54u as=0.42p ps=2.99u w=1.12u l=0.13u
M2437 vdd a_99095_98445# a_99932_98084# vdd sg13_lv_pmos ad=0.2128p pd=1.5u as=0.3864p ps=2.93u w=1.12u l=0.13u
M2438 sg13cmos5l_Corner_1.vss adc8b_0.sar12b_0.sg13cmos5l_dfrbp_1_10.Q a_86641_94352# sg13cmos5l_Corner_1.vss sg13_lv_nmos ad=0.15055p pd=1.17u as=0.187p ps=1.78u w=0.55u l=0.13u
M2439 frame a_134044_30676# sg13cmos5l_Corner_1.vss sg13cmos5l_Corner_1.vss sg13_hv_nmos ad=2.596p pd=5.58u as=1.408p ps=5.04u w=4.4u l=0.6u
M2440 sg13cmos5l_Corner_1.iovdd a_42476_86044# vin sg13cmos5l_Corner_1.iovdd sg13_hv_pmos ad=2.1312p pd=7.3u as=3.9294p ps=7.84u w=6.66u l=0.6u
M2441 sg13cmos5l_Corner_1.vss sg13cmos5l_IOPadVdd$1_0.sg13cmos5l_Clamp_N43N43D4R$1_0.gate vdd sg13cmos5l_Corner_1.vss sg13_hv_nmos ad=1.408p pd=5.04u as=2.596p ps=5.58u w=4.4u l=0.6u
M2442 sg13cmos5l_Corner_1.vss adc8b_0.sar12b_0.nh_sw[0] adc8b_0.side_cap8b_1.buf_32_1.z sg13cmos5l_Corner_1.vss sg13_lv_nmos ad=95f pd=0.88u as=95f ps=0.88u w=0.5u l=0.13u
M2443 vdd sg13cmos5l_IOPadVdd$1_0.sg13cmos5l_Clamp_N43N43D4R$1_0.gate sg13cmos5l_Corner_1.vss sg13cmos5l_Corner_1.vss sg13_hv_nmos ad=2.596p pd=5.58u as=1.408p ps=5.04u w=4.4u l=0.6u
M2444 adc8b_0.side_cap8b_0.buf_16_3.z adc8b_0.side_cap8b_0.in_h_sw[1] sg13cmos5l_Corner_1.vss sg13cmos5l_Corner_1.vss sg13_lv_nmos ad=95f pd=0.88u as=95f ps=0.88u w=0.5u l=0.13u
M2445 sg13cmos5l_Corner_1.vss adc8b_0.sar12b_0.sg13cmos5l_buf_8_0.A a_100995_95814# sg13cmos5l_Corner_1.vss sg13_lv_nmos ad=0.1406p pd=1.12u as=0.1406p ps=1.12u w=0.74u l=0.13u
M2446 sg13cmos5l_IOPadVdd$1_0.sg13cmos5l_Clamp_N43N43D4R$1_0.gate sg13cmos5l_IOPadVdd$1_0.sg13cmos5l_RCClampInverter$1_0.in sg13cmos5l_Corner_1.vss sg13cmos5l_Corner_1.vss sg13_hv_nmos ad=1.71p pd=9.38u as=1.71p ps=9.38u w=9u l=0.5u
M2447 vdd a_86327_98790# a_86286_99156# vdd sg13_lv_pmos ad=1.15047p pd=7.175u as=0.105p ps=1.21u w=1u l=0.13u
M2448 adc8b_0.sar12b_0.sg13cmos5l_dfrbp_1_22.Q_N a_99095_98445# sg13cmos5l_Corner_1.vss sg13cmos5l_Corner_1.vss sg13_lv_nmos ad=0.2849p pd=2.25u as=0.2516p ps=2.16u w=0.74u l=0.13u
M2449 adc8b_0.side_cap8b_0.buf_8_5.z adc8b_0.side_cap8b_0.in_h_sw[5] sg13cmos5l_Corner_1.vss sg13cmos5l_Corner_1.vss sg13_lv_nmos ad=0.17p pd=1.68u as=95f ps=0.88u w=0.5u l=0.13u
M2450 a_88428_95823# a_88140_96128# a_88366_95823# sg13cmos5l_Corner_1.vss sg13_lv_nmos ad=0.1428p pd=1.52u as=37.8f ps=0.6u w=0.42u l=0.13u
X2451 sg13cmos5l_Corner_1.vss sg13cmos5l_Corner_1.iovdd dpantenna l=1.26u w=27.78u
M2452 adc8b_0.side_cap8b_1.buf_8_4.z adc8b_0.sar12b_0.nl_sw[5] sg13cmos5l_Corner_1.vss sg13cmos5l_Corner_1.vss sg13_lv_nmos ad=95f pd=0.88u as=95f ps=0.88u w=0.5u l=0.13u
M2453 a_92195_93896# adc8b_0.sar12b_0.sg13cmos5l_nor2_1_0.A sg13cmos5l_Corner_1.vss sg13cmos5l_Corner_1.vss sg13_lv_nmos ad=78.39999f pd=0.885u as=0.2272p ps=1.99u w=0.64u l=0.13u
M2454 sg13cmos5l_Corner_1.vss adc8b_0.sar12b_0.sg13cmos5l_buf_1_96.A a_93232_99596# sg13cmos5l_Corner_1.vss sg13_lv_nmos ad=0.14875p pd=1.16u as=0.187p ps=1.78u w=0.55u l=0.13u
M2455 sg13cmos5l_IOPadVdd$1_0.sg13cmos5l_Clamp_N43N43D4R$1_0.gate sg13cmos5l_IOPadVdd$1_0.sg13cmos5l_RCClampInverter$1_0.in sg13cmos5l_Corner_1.vss sg13cmos5l_Corner_1.vss sg13_hv_nmos ad=1.71p pd=9.38u as=1.71p ps=9.38u w=9u l=0.5u
M2456 sg13cmos5l_IOPadVdd$1_0.sg13cmos5l_Clamp_N43N43D4R$1_0.gate sg13cmos5l_IOPadVdd$1_0.sg13cmos5l_RCClampInverter$1_0.in vdd vdd sg13_hv_pmos ad=1.33p pd=7.38u as=1.33p ps=7.38u w=7u l=0.5u
M2457 adc8b_0.sar12b_0.sg13cmos5l_dlhr_1_11.D a_93335_98911# sg13cmos5l_Corner_1.vss sg13cmos5l_Corner_1.vss sg13_lv_nmos ad=0.2849p pd=2.25u as=0.2516p ps=2.16u w=0.74u l=0.13u
M2458 sg13cmos5l_Corner_1.vss adc8b_0.sar12b_0.sg13cmos5l_buf_1_4.A a_98320_92824# sg13cmos5l_Corner_1.vss sg13_lv_nmos ad=0.14875p pd=1.16u as=0.187p ps=1.78u w=0.55u l=0.13u
M2459 sg13cmos5l_Corner_1.vss a_118044_30676# cko sg13cmos5l_Corner_1.vss sg13_hv_nmos ad=1.408p pd=5.04u as=2.596p ps=5.58u w=4.4u l=0.6u
M2460 vdd adc8b_0.sar12b_0.sg13cmos5l_dfrbp_1_6.RESET_B a_100113_98834# vdd sg13_lv_pmos ad=0.2128p pd=1.5u as=0.2128p ps=1.5u w=1.12u l=0.13u
M2461 vdd a_84177_95810# a_84110_96248# vdd sg13_lv_pmos ad=0.2387p pd=1.84u as=0.1008p ps=0.9u w=0.42u l=0.13u
M2462 vddr adc8b_0.sar12b_0.nh_sw[6] adc8b_0.side_cap8b_1.buf_4_1.z vddr sg13_lv_pmos ad=0.19p pd=1.38u as=0.19p ps=1.38u w=1u l=0.13u
M2463 adc8b_0.sar12b_0.sg13cmos5l_dlhr_1_15.D a_98876_99132# sg13cmos5l_Corner_1.vss sg13cmos5l_Corner_1.vss sg13_lv_nmos ad=0.2516p pd=2.16u as=0.1406p ps=1.12u w=0.74u l=0.13u
M2464 vdd adc8b_0.sar12b_0.sg13cmos5l_buf_1_116.A a_97360_97360# vdd sg13_lv_pmos ad=0.2114p pd=1.54u as=0.2856p ps=2.36u w=0.84u l=0.13u
M2465 data[2] a_102044_42476# sg13cmos5l_Corner_1.iovdd sg13cmos5l_Corner_1.iovdd sg13_hv_pmos ad=3.9294p pd=7.84u as=2.1312p ps=7.3u w=6.66u l=0.6u
M2466 sg13cmos5l_Corner_1.vss a_90740_95024# adc8b_0.sar12b_0.sg13cmos5l_buf_1_45.X sg13cmos5l_Corner_1.vss sg13_lv_nmos ad=0.14875p pd=1.16u as=0.2886p ps=2.26u w=0.74u l=0.13u
M2467 vdd a_87441_94298# a_87374_94736# vdd sg13_lv_pmos ad=0.2387p pd=1.84u as=0.1008p ps=0.9u w=0.42u l=0.13u
M2468 sg13cmos5l_Corner_1.iovdd a_70044_42476# data[0] sg13cmos5l_Corner_1.iovdd sg13_hv_pmos ad=2.1312p pd=7.3u as=3.9294p ps=7.84u w=6.66u l=0.6u
M2469 adc8b_0.sar12b_0.sg13cmos5l_buf_1_94.X a_96784_100384# vdd vdd sg13_lv_pmos ad=0.42p pd=2.99u as=0.2114p ps=1.54u w=1.12u l=0.13u
M2470 sg13cmos5l_Corner_1.vss adc8b_0.sar12b_0.sg13cmos5l_buf_1_24.X a_87472_92824# sg13cmos5l_Corner_1.vss sg13_lv_nmos ad=0.14875p pd=1.16u as=0.187p ps=1.78u w=0.55u l=0.13u
M2471 sg13cmos5l_IOPadAnalog_9.pad a_83639_164698# sg13cmos5l_Corner_1.iovdd sg13cmos5l_Corner_1.iovdd sg13_hv_pmos ad=3.9294p pd=7.84u as=3.1302p ps=14.26u w=6.66u l=0.6u
M2472 sg13cmos5l_IOPadAnalog_0.pad a_164624_86044# sg13cmos5l_Corner_1.iovdd sg13cmos5l_Corner_1.iovdd sg13_hv_pmos ad=3.9294p pd=7.84u as=2.1312p ps=7.3u w=6.66u l=0.6u
M2473 adc8b_0.side_cap8b_0.buf_32_0.z adc8b_0.side_cap8b_0.in_l_sw[0] sg13cmos5l_Corner_1.vss sg13cmos5l_Corner_1.vss sg13_lv_nmos ad=95f pd=0.88u as=95f ps=0.88u w=0.5u l=0.13u
M2474 vdd cks a_100995_100350# vdd sg13_lv_pmos ad=0.2128p pd=1.5u as=0.2128p ps=1.5u w=1.12u l=0.13u
M2475 sg13cmos5l_Corner_1.vss adc8b_0.sar12b_0.sg13cmos5l_buf_1_5.A adc8b_0.sar12b_0.sg13cmos5l_inv_1_27.Y sg13cmos5l_Corner_1.vss sg13_lv_nmos ad=0.2516p pd=2.16u as=0.2516p ps=2.16u w=0.74u l=0.13u
M2476 a_85539_97713# a_84647_97592# a_85437_97480# vdd sg13_lv_pmos ad=63f pd=0.72u as=79.8f ps=0.8u w=0.42u l=0.13u
M2477 data[0] a_70044_30676# sg13cmos5l_Corner_1.vss sg13cmos5l_Corner_1.vss sg13_hv_nmos ad=2.596p pd=5.58u as=1.408p ps=5.04u w=4.4u l=0.6u
M2478 vdd sg13cmos5l_IOPadVdd$1_0.sg13cmos5l_Clamp_N43N43D4R$1_0.gate sg13cmos5l_Corner_1.vss sg13cmos5l_Corner_1.vss sg13_hv_nmos ad=2.596p pd=5.58u as=1.408p ps=5.04u w=4.4u l=0.6u
M2479 sg13cmos5l_Corner_1.vss a_30676_86044# vin sg13cmos5l_Corner_1.vss sg13_hv_nmos ad=1.408p pd=5.04u as=2.596p ps=5.58u w=4.4u l=0.6u
M2480 sg13cmos5l_Corner_1.iovdd a_131639_164698# sg13cmos5l_IOPadAnalog_12.pad sg13cmos5l_Corner_1.iovdd sg13_hv_pmos ad=2.1312p pd=7.3u as=3.9294p ps=7.84u w=6.66u l=0.6u
M2481 a_85444_99124# a_85844_98784# a_85802_98820# sg13cmos5l_Corner_1.vss sg13_lv_nmos ad=0.2516p pd=2.16u as=77.7f ps=0.95u w=0.74u l=0.13u
M2482 a_96696_96572# a_96145_96930# vdd vdd sg13_lv_pmos ad=0.105p pd=1.21u as=1.28962p ps=8.195u w=1u l=0.13u
M2483 adc8b_0.side_cap8b_1.buf_32_0.z adc8b_0.sar12b_0.nl_sw[0] sg13cmos5l_Corner_1.vss sg13cmos5l_Corner_1.vss sg13_lv_nmos ad=95f pd=0.88u as=95f ps=0.88u w=0.5u l=0.13u
M2484 adc8b_0.side_cap8b_0.buf_32_0.z adc8b_0.side_cap8b_0.in_l_sw[0] vddr vddr sg13_lv_pmos ad=0.19p pd=1.38u as=0.19p ps=1.38u w=1u l=0.13u
M2485 a_87468_97640# a_87442_97545# sg13cmos5l_Corner_1.vss sg13cmos5l_Corner_1.vss sg13_lv_nmos ad=0.2516p pd=2.16u as=0.1626p ps=1.415u w=0.74u l=0.13u
M2486 vddr adc8b_0.sar12b_0.nh_sw[4] adc8b_0.side_cap8b_1.buf_8_2.z vddr sg13_lv_pmos ad=0.19p pd=1.38u as=0.34p ps=2.68u w=1u l=0.13u
M2487 a_98776_93790# adc8b_0.sar12b_0.sg13cmos5l_dfrbp_1_0.RESET_B vdd vdd sg13_lv_pmos ad=79.8f pd=0.8u as=1.777p ps=11.395u w=0.42u l=0.13u
M2488 sg13cmos5l_IOPadVdd$1_0.sg13cmos5l_Clamp_N43N43D4R$1_0.gate sg13cmos5l_IOPadVdd$1_0.sg13cmos5l_RCClampInverter$1_0.in vdd vdd sg13_hv_pmos ad=1.33p pd=7.38u as=1.33p ps=7.38u w=7u l=0.5u
X2489 sg13cmos5l_IOPadAnalog_14.padres sg13cmos5l_Corner_1.iovdd dpantenna l=4.98u w=0.64u
M2490 a_86900_95024# adc8b_0.sar12b_0.sg13cmos5l_buf_1_44.A sg13cmos5l_Corner_1.vss sg13cmos5l_Corner_1.vss sg13_lv_nmos ad=0.187p pd=1.78u as=0.14875p ps=1.16u w=0.55u l=0.13u
M2491 adc8b_0.side_cap8b_1.buf_8_3.z adc8b_0.sar12b_0.nh_sw[3] sg13cmos5l_Corner_1.vss sg13cmos5l_Corner_1.vss sg13_lv_nmos ad=95f pd=0.88u as=95f ps=0.88u w=0.5u l=0.13u
M2492 adc8b_0.sar12b_0.sg13cmos5l_dfrbp_1_27.Q_N a_91799_99957# vdd vdd sg13_lv_pmos ad=0.4312p pd=3.01u as=0.2639p ps=1.81u w=1.12u l=0.13u
M2493 sg13cmos5l_Corner_1.vss vdd sg13cmos5l_Corner_1.vss sg13cmos5l_Corner_1.vss sg13_lv_nmos ad=79.8f pd=0.8u as=0 ps=0 w=0.42u l=1u
M2494 a_91988_94262# adc8b_0.sar12b_0.sg13cmos5l_buf_1_28.X sg13cmos5l_Corner_1.vss sg13cmos5l_Corner_1.vss sg13_lv_nmos ad=0.187p pd=1.78u as=0.14875p ps=1.16u w=0.55u l=0.13u
M2495 a_88340_92750# adc8b_0.sar12b_0.sg13cmos5l_buf_1_24.A vdd vdd sg13_lv_pmos ad=0.2856p pd=2.36u as=0.2114p ps=1.54u w=0.84u l=0.13u
M2496 vddr adc8b_0.side_cap8b_0.in_l_sw[4] adc8b_0.side_cap8b_0.buf_8_0.z vddr sg13_lv_pmos ad=0.19p pd=1.38u as=0.34p ps=2.68u w=1u l=0.13u
M2497 sg13cmos5l_Corner_1.vss vdd sg13cmos5l_Corner_1.vss sg13cmos5l_Corner_1.vss sg13_lv_nmos ad=0.1428p pd=1.52u as=0 ps=0 w=0.42u l=1u
M2498 a_89162_97010# adc8b_0.sar12b_0.sg13cmos5l_dfrbp_1_8.RESET_B sg13cmos5l_Corner_1.vss sg13cmos5l_Corner_1.vss sg13_lv_nmos ad=60.89999f pd=0.71u as=0.1626p ps=1.415u w=0.42u l=0.13u
X2499 a_178296_118044# sg13cmos5l_Corner_1.vss sg13cmos5l_Corner_1.vss rppd l=3.54u w=0.5u
M2500 sg13cmos5l_Corner_1.vss a_89588_100310# adc8b_0.sar12b_0.sg13cmos5l_buf_1_73.X sg13cmos5l_Corner_1.vss sg13_lv_nmos ad=0.14875p pd=1.16u as=0.2886p ps=2.26u w=0.74u l=0.13u
M2501 adc8b_0.sar12b_0.sg13cmos5l_buf_1_3.A a_101296_98084# vdd vdd sg13_lv_pmos ad=0.42p pd=2.99u as=0.2114p ps=1.54u w=1.12u l=0.13u
M2502 sg13cmos5l_Corner_1.iovdd a_42476_102044# vip sg13cmos5l_Corner_1.iovdd sg13_hv_pmos ad=2.1312p pd=7.3u as=3.9294p ps=7.84u w=6.66u l=0.6u
M2503 vdd a_83252_100310# adc8b_0.sar12b_0.sg13cmos5l_buf_1_68.X vdd sg13_lv_pmos ad=0.2114p pd=1.54u as=0.42p ps=2.99u w=1.12u l=0.13u
M2504 adc8b_0.sar12b_0.sg13cmos5l_buf_1_103.A a_97552_100384# vdd vdd sg13_lv_pmos ad=0.42p pd=2.99u as=0.2114p ps=1.54u w=1.12u l=0.13u
M2505 sg13cmos5l_Corner_1.vss adc8b_0.sar12b_0.sg13cmos5l_dfrbp_1_6.RESET_B a_91036_97308# sg13cmos5l_Corner_1.vss sg13_lv_nmos ad=0.1406p pd=1.12u as=77.7f ps=0.95u w=0.74u l=0.13u
M2506 sg13cmos5l_Corner_1.vss vdd sg13cmos5l_Corner_1.vss sg13cmos5l_Corner_1.vss sg13_lv_nmos ad=0.1428p pd=1.52u as=0 ps=0 w=0.42u l=1u
M2507 sg13cmos5l_Corner_1.vss a_98903_95887# a_99740_96108# sg13cmos5l_Corner_1.vss sg13_lv_nmos ad=0.1406p pd=1.12u as=0.2516p ps=2.16u w=0.74u l=0.13u
M2508 cks a_42476_118044# sg13cmos5l_Corner_1.iovdd sg13cmos5l_Corner_1.iovdd sg13_hv_pmos ad=3.9294p pd=7.84u as=2.1312p ps=7.3u w=6.66u l=0.6u
M2509 sg13cmos5l_Corner_1.vss adc8b_0.side_cap8b_0.in_h_sw[3] adc8b_0.side_cap8b_0.buf_8_3.z sg13cmos5l_Corner_1.vss sg13_lv_nmos ad=95f pd=0.88u as=95f ps=0.88u w=0.5u l=0.13u
M2510 a_85844_98784# a_86092_99156# a_86050_99272# vdd sg13_lv_pmos ad=0.191p pd=1.44u as=0.1008p ps=0.9u w=0.42u l=0.13u
M2511 a_101596_97308# a_101180_97644# a_101361_97322# sg13cmos5l_Corner_1.vss sg13_lv_nmos ad=77.7f pd=0.95u as=0.2516p ps=2.16u w=0.74u l=0.13u
M2512 sg13cmos5l_Corner_1.vss a_99095_98445# a_99932_98084# sg13cmos5l_Corner_1.vss sg13_lv_nmos ad=0.1406p pd=1.12u as=0.2516p ps=2.16u w=0.74u l=0.13u
M2513 sg13cmos5l_IOPadAnalog_1.pad a_164624_70044# sg13cmos5l_Corner_1.iovdd sg13cmos5l_Corner_1.iovdd sg13_hv_pmos ad=3.9294p pd=7.84u as=2.1312p ps=7.3u w=6.66u l=0.6u
M2514 sg13cmos5l_IOPadAnalog_0.pad a_164624_86044# sg13cmos5l_Corner_1.iovdd sg13cmos5l_Corner_1.iovdd sg13_hv_pmos ad=3.9294p pd=7.84u as=2.1312p ps=7.3u w=6.66u l=0.6u
M2515 adc8b_0.side_cap8b_1.buf_32_0.z adc8b_0.sar12b_0.nl_sw[0] sg13cmos5l_Corner_1.vss sg13cmos5l_Corner_1.vss sg13_lv_nmos ad=95f pd=0.88u as=95f ps=0.88u w=0.5u l=0.13u
M2516 sg13cmos5l_IOPadAnalog_11.pad a_164624_118044# sg13cmos5l_Corner_1.iovdd sg13cmos5l_Corner_1.iovdd sg13_hv_pmos ad=3.9294p pd=7.84u as=2.1312p ps=7.3u w=6.66u l=0.6u
M2517 vddr adc8b_0.sar12b_0.nh_sw[3] adc8b_0.side_cap8b_1.buf_8_3.z vddr sg13_lv_pmos ad=0.19p pd=1.38u as=0.19p ps=1.38u w=1u l=0.13u
M2518 adc8b_0.side_cap8b_0.buf_32_1.z adc8b_0.side_cap8b_0.in_h_sw[0] sg13cmos5l_Corner_1.vss sg13cmos5l_Corner_1.vss sg13_lv_nmos ad=95f pd=0.88u as=95f ps=0.88u w=0.5u l=0.13u
M2519 sg13cmos5l_Corner_1.vss a_86228_100310# adc8b_0.sar12b_0.sg13cmos5l_buf_1_60.X sg13cmos5l_Corner_1.vss sg13_lv_nmos ad=0.14875p pd=1.16u as=0.2886p ps=2.26u w=0.74u l=0.13u
M2520 vdd cks adc8b_0.sar12b_0.sg13cmos5l_dfrbp_1_6.RESET_B vdd sg13_lv_pmos ad=0.2128p pd=1.5u as=0.2128p ps=1.5u w=1.12u l=0.13u
M2521 a_96396_99600# a_96915_99607# a_97655_99957# sg13cmos5l_Corner_1.vss sg13_lv_nmos ad=0.3473p pd=2.71u as=0.12665p ps=1.145u w=0.74u l=0.13u
M2522 vdd a_85175_95421# a_86012_95060# vdd sg13_lv_pmos ad=0.2128p pd=1.5u as=0.3864p ps=2.93u w=1.12u l=0.13u
M2523 adc8b_0.side_cap8b_0.buf_32_1.z adc8b_0.side_cap8b_0.in_h_sw[0] vddr vddr sg13_lv_pmos ad=0.19p pd=1.38u as=0.19p ps=1.38u w=1u l=0.13u
M2524 frame a_134044_42476# sg13cmos5l_Corner_1.iovdd sg13cmos5l_Corner_1.iovdd sg13_hv_pmos ad=3.9294p pd=7.84u as=2.1312p ps=7.3u w=6.66u l=0.6u
M2525 a_84204_100021# a_83916_99600# a_84142_100021# sg13cmos5l_Corner_1.vss sg13_lv_nmos ad=0.1428p pd=1.52u as=37.8f ps=0.6u w=0.42u l=0.13u
M2526 a_87564_95064# a_87538_95028# vdd vdd sg13_lv_pmos ad=0.34p pd=2.68u as=0.36237p ps=2.605u w=1u l=0.13u
M2527 sg13cmos5l_Corner_1.vss a_89457_92786# a_89982_92768# sg13cmos5l_Corner_1.vss sg13_lv_nmos ad=0.1491p pd=1.18u as=0.187p ps=1.78u w=0.55u l=0.13u
M2528 a_84364_99156# a_84389_98796# vdd vdd sg13_lv_pmos ad=0.2856p pd=2.36u as=1.15047p ps=7.175u w=0.84u l=0.13u
M2529 vdd sg13cmos5l_Corner_1.vss vdd vdd sg13_lv_pmos ad=0.19p pd=1.38u as=0 ps=0 w=1u l=1u
M2530 vdd sg13cmos5l_Corner_1.vss vdd vdd sg13_lv_pmos ad=0.34p pd=2.68u as=0 ps=0 w=1u l=1u
M2531 vdd adc8b_0.sar12b_0.sg13cmos5l_dlhr_1_9.D a_92355_95852# vdd sg13_lv_pmos ad=0.2198p pd=1.53u as=0.2856p ps=2.36u w=0.84u l=0.13u
M2532 adc8b_0.side_cap8b_1.buf_32_1.z adc8b_0.sar12b_0.nh_sw[0] sg13cmos5l_Corner_1.vss sg13cmos5l_Corner_1.vss sg13_lv_nmos ad=95f pd=0.88u as=95f ps=0.88u w=0.5u l=0.13u
M2533 sg13cmos5l_Corner_1.iovdd a_42476_118044# cks sg13cmos5l_Corner_1.iovdd sg13_hv_pmos ad=2.1312p pd=7.3u as=3.9294p ps=7.84u w=6.66u l=0.6u
M2534 sg13cmos5l_Corner_1.vss a_85599_98442# a_85730_98448# sg13cmos5l_Corner_1.vss sg13_lv_nmos ad=1.49685p pd=9.6u as=0.2775p ps=2.23u w=0.74u l=0.13u
M2535 sg13cmos5l_IOPadAnalog_9.pad a_83639_178370# sg13cmos5l_Corner_1.vss sg13cmos5l_Corner_1.vss sg13_hv_nmos ad=2.596p pd=5.58u as=1.408p ps=5.04u w=4.4u l=0.6u
M2536 sg13cmos5l_IOPadAnalog_15.pad a_99639_164698# sg13cmos5l_Corner_1.iovdd sg13cmos5l_Corner_1.iovdd sg13_hv_pmos ad=3.9294p pd=7.84u as=2.1312p ps=7.3u w=6.66u l=0.6u
M2537 sg13cmos5l_IOPadAnalog_13.pad a_115639_164698# sg13cmos5l_Corner_1.iovdd sg13cmos5l_Corner_1.iovdd sg13_hv_pmos ad=3.9294p pd=7.84u as=2.1312p ps=7.3u w=6.66u l=0.6u
M2538 vdd a_89015_99957# a_89852_99596# vdd sg13_lv_pmos ad=0.2128p pd=1.5u as=0.3864p ps=2.93u w=1.12u l=0.13u
M2539 sg13cmos5l_IOPadAnalog_1.pad a_164624_70044# sg13cmos5l_Corner_1.iovdd sg13cmos5l_Corner_1.iovdd sg13_hv_pmos ad=3.9294p pd=7.84u as=2.1312p ps=7.3u w=6.66u l=0.6u
M2540 sg13cmos5l_Corner_1.iovdd a_83639_164698# sg13cmos5l_IOPadAnalog_9.pad sg13cmos5l_Corner_1.iovdd sg13_hv_pmos ad=2.1312p pd=7.3u as=3.9294p ps=7.84u w=6.66u l=0.6u
M2541 vdd sg13cmos5l_IOPadVdd$1_0.sg13cmos5l_Clamp_N43N43D4R$1_0.gate sg13cmos5l_Corner_1.vss sg13cmos5l_Corner_1.vss sg13_hv_nmos ad=2.596p pd=5.58u as=1.408p ps=5.04u w=4.4u l=0.6u
M2542 sg13cmos5l_Corner_1.vss a_131639_178370# sg13cmos5l_IOPadAnalog_12.pad sg13cmos5l_Corner_1.vss sg13_hv_nmos ad=1.408p pd=5.04u as=2.596p ps=5.58u w=4.4u l=0.6u
M2543 sg13cmos5l_Corner_1.vss a_98900_100310# adc8b_0.side_cap8b_0.in_h_sw[7] sg13cmos5l_Corner_1.vss sg13_lv_nmos ad=0.14875p pd=1.16u as=0.2886p ps=2.26u w=0.74u l=0.13u
M2544 vdd sg13cmos5l_Corner_1.vss vdd vdd sg13_lv_pmos ad=0.34p pd=2.68u as=0 ps=0 w=1u l=1u
M2545 a_93748_96108# adc8b_0.sar12b_0.sg13cmos5l_inv_1_0.A adc8b_0.sar12b_0.sg13cmos5l_a221oi_1_0.C1 vdd sg13_lv_pmos ad=0.1176p pd=1.33u as=0.3808p ps=2.92u w=1.12u l=0.13u
M2546 sg13cmos5l_Corner_1.vss adc8b_0.sar12b_0.sg13cmos5l_o21ai_1_0.A1 a_93790_94294# sg13cmos5l_Corner_1.vss sg13_lv_nmos ad=0.1406p pd=1.12u as=0.2516p ps=2.16u w=0.74u l=0.15u
M2547 sg13cmos5l_IOPadAnalog_16.pad a_164624_102044# sg13cmos5l_Corner_1.iovdd sg13cmos5l_Corner_1.iovdd sg13_hv_pmos ad=3.9294p pd=7.84u as=2.1312p ps=7.3u w=6.66u l=0.6u
M2548 adc8b_0.sar12b_0.sg13cmos5l_dfrbp_1_0.Q a_101276_93084# vdd vdd sg13_lv_pmos ad=0.3808p pd=2.92u as=0.2128p ps=1.5u w=1.12u l=0.13u
M2549 sg13cmos5l_Corner_1.vss adc8b_0.sar12b_0.nh_sw[7] adc8b_0.side_cap8b_1.buf_4_2.z sg13cmos5l_Corner_1.vss sg13_lv_nmos ad=95f pd=0.88u as=0.17p ps=1.68u w=0.5u l=0.13u
M2550 a_88611_96619# a_87719_96543# a_88509_96619# vdd sg13_lv_pmos ad=63f pd=0.72u as=79.8f ps=0.8u w=0.42u l=0.13u
M2551 sg13cmos5l_Corner_1.iovdd a_164624_86044# sg13cmos5l_IOPadAnalog_0.pad sg13cmos5l_Corner_1.iovdd sg13_hv_pmos ad=2.1312p pd=7.3u as=3.9294p ps=7.84u w=6.66u l=0.6u
M2552 a_95962_97322# adc8b_0.sar12b_0.sg13cmos5l_dfrbp_1_6.RESET_B sg13cmos5l_Corner_1.vss sg13cmos5l_Corner_1.vss sg13_lv_nmos ad=37.8f pd=0.6u as=79.8f ps=0.8u w=0.42u l=0.13u
M2553 vdd a_91473_95810# a_91998_95792# vdd sg13_lv_pmos ad=0.1974p pd=1.5u as=0.2856p ps=2.36u w=0.84u l=0.13u
M2554 adc8b_0.side_cap8b_0.buf_4_0.z adc8b_0.side_cap8b_0.in_l_sw[7] vddr vddr sg13_lv_pmos ad=0.19p pd=1.38u as=0.19p ps=1.38u w=1u l=0.13u
M2555 vdd cks a_100995_100350# vdd sg13_lv_pmos ad=0.2128p pd=1.5u as=0.3808p ps=2.92u w=1.12u l=0.13u
M2556 adc8b_0.sar12b_0.sg13cmos5l_buf_1_90.X a_93232_100384# sg13cmos5l_Corner_1.vss sg13cmos5l_Corner_1.vss sg13_lv_nmos ad=0.2886p pd=2.26u as=0.14875p ps=1.16u w=0.74u l=0.13u
M2557 a_89399_95887# a_88557_95789# a_88140_96128# vdd sg13_lv_pmos ad=0.2048p pd=1.63u as=0.34p ps=2.68u w=1u l=0.13u
M2558 vddr adc8b_0.sar12b_0.nh_sw[0] adc8b_0.side_cap8b_1.buf_32_1.z vddr sg13_lv_pmos ad=0.19p pd=1.38u as=0.19p ps=1.38u w=1u l=0.13u
M2559 a_94868_99560# adc8b_0.sar12b_0.sg13cmos5l_buf_1_90.X vdd vdd sg13_lv_pmos ad=0.2856p pd=2.36u as=0.2114p ps=1.54u w=0.84u l=0.13u
M2560 vdd a_90551_98911# a_90808_99054# vdd sg13_lv_pmos ad=0.2639p pd=1.81u as=79.8f ps=0.8u w=0.42u l=0.13u
M2561 sg13cmos5l_Corner_1.iovdd a_42476_102044# vip sg13cmos5l_Corner_1.iovdd sg13_hv_pmos ad=2.1312p pd=7.3u as=3.9294p ps=7.84u w=6.66u l=0.6u
M2562 adc8b_0.sar12b_0.sg13cmos5l_dfrbp_1_11.Q_N a_89399_95887# sg13cmos5l_Corner_1.vss sg13cmos5l_Corner_1.vss sg13_lv_nmos ad=0.2849p pd=2.25u as=0.2516p ps=2.16u w=0.74u l=0.13u
M2563 data[0] a_70044_42476# sg13cmos5l_Corner_1.iovdd sg13cmos5l_Corner_1.iovdd sg13_hv_pmos ad=3.9294p pd=7.84u as=2.1312p ps=7.3u w=6.66u l=0.6u
M2564 sg13cmos5l_Corner_1.iovdd a_102044_42476# data[2] sg13cmos5l_Corner_1.iovdd sg13_hv_pmos ad=2.1312p pd=7.3u as=3.9294p ps=7.84u w=6.66u l=0.6u
M2565 adc8b_0.side_cap8b_1.buf_8_5.z adc8b_0.sar12b_0.nh_sw[5] sg13cmos5l_Corner_1.vss sg13cmos5l_Corner_1.vss sg13_lv_nmos ad=95f pd=0.88u as=95f ps=0.88u w=0.5u l=0.13u
M2566 a_89266_99057# a_89709_98813# a_89649_99225# vdd sg13_lv_pmos ad=79.8f pd=0.8u as=63f ps=0.72u w=0.42u l=0.13u
M2567 vdd a_68892_97356# a_68824_97392# sg13cmos5l_Corner_1.vss sg13_lv_nmos ad=0.442p pd=3.28u as=0.442p ps=3.28u w=1.3u l=0.13u
M2568 vdd a_91988_94262# adc8b_0.sar12b_0.nl_sw[5] vdd sg13_lv_pmos ad=0.2114p pd=1.54u as=0.42p ps=2.99u w=1.12u l=0.13u
M2569 a_101361_97322# a_101180_97644# vdd vdd sg13_lv_pmos ad=0.2128p pd=1.5u as=0.2387p ps=1.84u w=1.12u l=0.13u
M2570 vdd a_94744_93790# a_94689_93671# vdd sg13_lv_pmos ad=1.86162p pd=11.935u as=93.45f ps=0.865u w=0.42u l=0.13u
M2571 sg13cmos5l_Corner_1.vss a_118044_30676# cko sg13cmos5l_Corner_1.vss sg13_hv_nmos ad=2.068p pd=9.74u as=2.596p ps=5.58u w=4.4u l=0.6u
M2572 adc8b_0.sar12b_0.sg13cmos5l_buf_1_3.A a_101296_98084# sg13cmos5l_Corner_1.vss sg13cmos5l_Corner_1.vss sg13_lv_nmos ad=0.2886p pd=2.26u as=0.14875p ps=1.16u w=0.74u l=0.13u
M2573 data[2] a_102044_30676# sg13cmos5l_Corner_1.vss sg13cmos5l_Corner_1.vss sg13_hv_nmos ad=2.596p pd=5.58u as=1.408p ps=5.04u w=4.4u l=0.6u
M2574 vddr adc8b_0.sar12b_0.nh_sw[0] adc8b_0.side_cap8b_1.buf_32_1.z vddr sg13_lv_pmos ad=0.19p pd=1.38u as=0.19p ps=1.38u w=1u l=0.13u
M2575 vdd a_100383_96930# a_100514_96936# vdd sg13_lv_pmos ad=1.28962p pd=8.195u as=0.2856p ps=2.36u w=0.84u l=0.13u
M2576 sg13cmos5l_IOPadAnalog_1.pad a_178296_70044# sg13cmos5l_Corner_1.vss sg13cmos5l_Corner_1.vss sg13_hv_nmos ad=2.596p pd=5.58u as=1.408p ps=5.04u w=4.4u l=0.6u
M2577 sg13cmos5l_Corner_1.iovdd a_164624_86044# sg13cmos5l_IOPadAnalog_0.pad sg13cmos5l_Corner_1.iovdd sg13_hv_pmos ad=2.1312p pd=7.3u as=3.9294p ps=7.84u w=6.66u l=0.6u
M2578 sg13cmos5l_Corner_1.iovdd a_164624_118044# sg13cmos5l_IOPadAnalog_11.pad sg13cmos5l_Corner_1.iovdd sg13_hv_pmos ad=2.1312p pd=7.3u as=3.9294p ps=7.84u w=6.66u l=0.6u
M2579 sg13cmos5l_IOPadAnalog_15.pad a_99639_178370# sg13cmos5l_Corner_1.vss sg13cmos5l_Corner_1.vss sg13_hv_nmos ad=2.596p pd=5.58u as=1.408p ps=5.04u w=4.4u l=0.6u
M2580 sg13cmos5l_IOPadAnalog_10.pad a_67639_164698# sg13cmos5l_Corner_1.iovdd sg13cmos5l_Corner_1.iovdd sg13_hv_pmos ad=3.9294p pd=7.84u as=2.1312p ps=7.3u w=6.66u l=0.6u
X2581 sg13cmos5l_Corner_1.vss a_30676_86044# sg13cmos5l_Corner_1.vss rppd l=3.54u w=0.5u
M2582 sg13cmos5l_Corner_1.vss adc8b_0.sar12b_0.nh_sw[2] adc8b_0.side_cap8b_1.buf_16_0.z sg13cmos5l_Corner_1.vss sg13_lv_nmos ad=95f pd=0.88u as=95f ps=0.88u w=0.5u l=0.13u
M2583 sg13cmos5l_IOPadAnalog_13.pad a_115639_178370# sg13cmos5l_Corner_1.vss sg13cmos5l_Corner_1.vss sg13_hv_nmos ad=2.596p pd=5.58u as=1.408p ps=5.04u w=4.4u l=0.6u
M2584 sg13cmos5l_Corner_1.vss a_30676_118044# cks sg13cmos5l_Corner_1.vss sg13_hv_nmos ad=1.408p pd=5.04u as=2.596p ps=5.58u w=4.4u l=0.6u
M2585 adc8b_0.side_cap8b_1.buf_32_1.z adc8b_0.sar12b_0.nh_sw[0] vddr vddr sg13_lv_pmos ad=0.19p pd=1.38u as=0.19p ps=1.38u w=1u l=0.13u
M2586 vdd adc8b_0.sar12b_0.sg13cmos5l_dfrbp_1_0.RESET_B a_93038_95498# vdd sg13_lv_pmos ad=0.36237p pd=2.605u as=79.8f ps=0.8u w=0.42u l=0.13u
M2587 sg13cmos5l_Corner_1.iovdd a_42476_118044# cks sg13cmos5l_Corner_1.iovdd sg13_hv_pmos ad=2.1312p pd=7.3u as=3.9294p ps=7.84u w=6.66u l=0.6u
M2588 vin a_30676_86044# sg13cmos5l_Corner_1.vss sg13cmos5l_Corner_1.vss sg13_hv_nmos ad=2.596p pd=5.58u as=1.408p ps=5.04u w=4.4u l=0.6u
M2589 sg13cmos5l_Corner_1.vss a_85175_95421# a_86012_95060# sg13cmos5l_Corner_1.vss sg13_lv_nmos ad=0.1406p pd=1.12u as=0.2516p ps=2.16u w=0.74u l=0.13u
M2590 sg13cmos5l_Corner_1.vss a_83639_178370# sg13cmos5l_IOPadAnalog_9.pad sg13cmos5l_Corner_1.vss sg13_hv_nmos ad=1.408p pd=5.04u as=2.596p ps=5.58u w=4.4u l=0.6u
M2591 sg13cmos5l_Corner_1.iovdd a_99639_164698# sg13cmos5l_IOPadAnalog_15.pad sg13cmos5l_Corner_1.iovdd sg13_hv_pmos ad=2.1312p pd=7.3u as=3.9294p ps=7.84u w=6.66u l=0.6u
M2592 sg13cmos5l_Corner_1.iovdd a_42476_70044# vddr sg13cmos5l_Corner_1.iovdd sg13_hv_pmos ad=2.1312p pd=7.3u as=3.9294p ps=7.84u w=6.66u l=0.6u
M2593 a_87852_95485# a_88083_95071# a_87538_95028# sg13cmos5l_Corner_1.vss sg13_lv_nmos ad=0.2373p pd=1.97u as=79.8f ps=0.8u w=0.42u l=0.13u
X2594 sg13cmos5l_Corner_1.vss a_76462_57198# dantenna l=3.1u w=0.64u
M2595 a_82190_98522# adc8b_0.sar12b_0.sg13cmos5l_dfrbp_1_6.D vdd vdd sg13_lv_pmos ad=79.8f pd=0.8u as=0.1428p ps=1.52u w=0.42u l=0.13u
M2596 sg13cmos5l_Corner_1.vss adc8b_0.sar12b_0.nl_sw[4] adc8b_0.side_cap8b_1.buf_8_0.z sg13cmos5l_Corner_1.vss sg13_lv_nmos ad=95f pd=0.88u as=95f ps=0.88u w=0.5u l=0.13u
M2597 sg13cmos5l_Corner_1.iovdd a_115639_164698# sg13cmos5l_IOPadAnalog_13.pad sg13cmos5l_Corner_1.iovdd sg13_hv_pmos ad=3.1302p pd=14.26u as=3.9294p ps=7.84u w=6.66u l=0.6u
M2598 sg13cmos5l_Corner_1.vss adc8b_0.sar12b_0.nl_sw[0] adc8b_0.side_cap8b_1.buf_32_0.z sg13cmos5l_Corner_1.vss sg13_lv_nmos ad=95f pd=0.88u as=0.17p ps=1.68u w=0.5u l=0.13u
M2599 adc8b_0.side_cap8b_0.buf_16_1.z adc8b_0.side_cap8b_0.in_l_sw[2] vddr vddr sg13_lv_pmos ad=0.19p pd=1.38u as=0.19p ps=1.38u w=1u l=0.13u
M2600 adc8b_0.sar12b_0.sg13cmos5l_dlhr_1_14.Q_N a_95934_98816# vdd vdd sg13_lv_pmos ad=0.3808p pd=2.92u as=0.1974p ps=1.5u w=1.12u l=0.13u
M2601 sg13cmos5l_Corner_1.vss a_86615_95887# a_87452_96108# sg13cmos5l_Corner_1.vss sg13_lv_nmos ad=0.1406p pd=1.12u as=0.2516p ps=2.16u w=0.74u l=0.13u
M2602 sg13cmos5l_Corner_1.vss adc8b_0.side_cap8b_0.in_h_sw[0] adc8b_0.side_cap8b_0.buf_32_1.z sg13cmos5l_Corner_1.vss sg13_lv_nmos ad=95f pd=0.88u as=95f ps=0.88u w=0.5u l=0.13u
M2603 a_91406_96248# a_91010_95820# a_91292_96132# vdd sg13_lv_pmos ad=0.1008p pd=0.9u as=0.191p ps=1.44u w=0.42u l=0.13u
M2604 a_93202_93516# a_93645_93559# a_92942_93986# sg13cmos5l_Corner_1.vss sg13_lv_nmos ad=79.8f pd=0.8u as=0.1296p ps=1.52u w=0.42u l=0.13u
M2605 sg13cmos5l_Corner_1.vss adc8b_0.sar12b_0.sg13cmos5l_dlhr_1_12.D a_98929_99954# sg13cmos5l_Corner_1.vss sg13_lv_nmos ad=0.15055p pd=1.17u as=0.187p ps=1.78u w=0.55u l=0.13u
M2606 sg13cmos5l_Corner_1.iovdd a_164624_102044# sg13cmos5l_IOPadAnalog_16.pad sg13cmos5l_Corner_1.iovdd sg13_hv_pmos ad=2.1312p pd=7.3u as=3.9294p ps=7.84u w=6.66u l=0.6u
M2607 sg13cmos5l_Corner_1.vss a_89457_92786# a_89412_92822# sg13cmos5l_Corner_1.vss sg13_lv_nmos ad=0.1428p pd=1.52u as=47.25f ps=0.645u w=0.42u l=0.13u
M2608 a_97260_93552# a_97779_93559# a_98519_93909# sg13cmos5l_Corner_1.vss sg13_lv_nmos ad=0.3473p pd=2.71u as=0.12665p ps=1.145u w=0.74u l=0.13u
M2609 a_90540_99600# a_90514_99564# sg13cmos5l_Corner_1.vss sg13cmos5l_Corner_1.vss sg13_lv_nmos ad=0.2516p pd=2.16u as=0.1626p ps=1.415u w=0.74u l=0.13u
M2610 sg13cmos5l_Corner_1.vss sg13cmos5l_IOPadVdd$1_0.sg13cmos5l_Clamp_N43N43D4R$1_0.gate vdd sg13cmos5l_Corner_1.vss sg13_hv_nmos ad=1.408p pd=5.04u as=2.596p ps=5.58u w=4.4u l=0.6u
M2611 vddr adc8b_0.side_cap8b_0.in_h_sw[0] adc8b_0.side_cap8b_0.buf_32_1.z vddr sg13_lv_pmos ad=0.19p pd=1.38u as=0.19p ps=1.38u w=1u l=0.13u
M2612 adc8b_0.side_cap8b_0.buf_16_0.z adc8b_0.side_cap8b_0.in_h_sw[2] sg13cmos5l_Corner_1.vss sg13cmos5l_Corner_1.vss sg13_lv_nmos ad=95f pd=0.88u as=95f ps=0.88u w=0.5u l=0.13u
M2613 a_82926_94302# a_82670_94302# sg13cmos5l_Corner_1.vss sg13cmos5l_Corner_1.vss sg13_lv_nmos ad=0.1428p pd=1.52u as=0.1323p ps=1.05u w=0.42u l=0.18u
M2614 sg13cmos5l_IOPadAnalog_15.pad a_99639_164698# sg13cmos5l_Corner_1.iovdd sg13cmos5l_Corner_1.iovdd sg13_hv_pmos ad=3.9294p pd=7.84u as=2.1312p ps=7.3u w=6.66u l=0.6u
M2615 adc8b_0.side_cap8b_0.buf_32_1.z adc8b_0.side_cap8b_0.in_h_sw[0] vddr vddr sg13_lv_pmos ad=0.19p pd=1.38u as=0.19p ps=1.38u w=1u l=0.13u
M2616 adc8b_0.sar12b_0.sg13cmos5l_buf_8_2.X a_100995_100350# sg13cmos5l_Corner_1.vss sg13cmos5l_Corner_1.vss sg13_lv_nmos ad=0.1406p pd=1.12u as=0.1406p ps=1.12u w=0.74u l=0.13u
M2617 sg13cmos5l_Corner_1.vss a_178296_102044# sg13cmos5l_IOPadAnalog_16.pad sg13cmos5l_Corner_1.vss sg13_hv_nmos ad=1.408p pd=5.04u as=2.596p ps=5.58u w=4.4u l=0.6u
M2618 sg13cmos5l_Corner_1.vss a_89709_98813# a_89811_98956# sg13cmos5l_Corner_1.vss sg13_lv_nmos ad=1.49685p pd=9.6u as=0.2516p ps=2.16u w=0.74u l=0.13u
M2619 vdd a_97470_95347# adc8b_0.sar12b_0.sg13cmos5l_and3_1_0.C vdd sg13_lv_pmos ad=0.2128p pd=1.5u as=0.3808p ps=2.92u w=1.12u l=0.13u
M2620 sg13cmos5l_Corner_1.vss adc8b_0.side_cap8b_0.in_l_sw[3] adc8b_0.side_cap8b_0.buf_8_1.z sg13cmos5l_Corner_1.vss sg13_lv_nmos ad=95f pd=0.88u as=0.17p ps=1.68u w=0.5u l=0.13u
M2621 a_98253_98095# adc8b_0.sar12b_0.sg13cmos5l_inv_1_2.A sg13cmos5l_Corner_1.vss sg13cmos5l_Corner_1.vss sg13_lv_nmos ad=0.2516p pd=2.16u as=1.49685p ps=9.6u w=0.74u l=0.13u
M2622 adc8b_0.side_cap8b_1.buf_2_0.z adc8b_0.sar12b_0.nh_sw[8] vddr vddr sg13_lv_pmos ad=0.34p pd=2.68u as=0.19p ps=1.38u w=1u l=0.13u
M2623 vdd sg13cmos5l_Corner_1.vss vdd vdd sg13_lv_pmos ad=0.34p pd=2.68u as=0 ps=0 w=1u l=1u
M2624 vdd adc8b_0.sar12b_0.sg13cmos5l_inv_1_29.Y a_93539_96572# vdd sg13_lv_pmos ad=0.2128p pd=1.5u as=0.2128p ps=1.5u w=1.12u l=0.13u
M2625 adc8b_0.side_cap8b_1.buf_32_0.z adc8b_0.sar12b_0.nl_sw[0] vddr vddr sg13_lv_pmos ad=0.19p pd=1.38u as=0.19p ps=1.38u w=1u l=0.13u
M2626 vin a_42476_86044# sg13cmos5l_Corner_1.iovdd sg13cmos5l_Corner_1.iovdd sg13_hv_pmos ad=3.9294p pd=7.84u as=2.1312p ps=7.3u w=6.66u l=0.6u
M2627 vdd sg13cmos5l_IOPadVdd$1_0.sg13cmos5l_Clamp_N43N43D4R$1_0.gate sg13cmos5l_Corner_1.vss sg13cmos5l_Corner_1.vss sg13_hv_nmos ad=2.596p pd=5.58u as=1.408p ps=5.04u w=4.4u l=0.6u
M2628 adc8b_0.side_cap8b_0.buf_32_0.z adc8b_0.side_cap8b_0.in_l_sw[0] sg13cmos5l_Corner_1.vss sg13cmos5l_Corner_1.vss sg13_lv_nmos ad=95f pd=0.88u as=95f ps=0.88u w=0.5u l=0.13u
M2629 vdd a_89656_96030# a_89601_96125# vdd sg13_lv_pmos ad=1.28962p pd=8.195u as=93.45f ps=0.865u w=0.42u l=0.13u
M2630 a_83646_97497# a_83765_97286# vdd vdd sg13_lv_pmos ad=0.3864p pd=2.93u as=0.2128p ps=1.5u w=1.12u l=0.13u
M2631 a_94860_94298# adc8b_0.sar12b_0.sg13cmos5l_o21ai_1_0.Y a_94766_94298# sg13cmos5l_Corner_1.vss sg13_lv_nmos ad=60.89999f pd=0.71u as=0.1428p ps=1.52u w=0.42u l=0.13u
M2632 sg13cmos5l_Corner_1.vss adc8b_0.sar12b_0.sg13cmos5l_nor2_1_0.A a_92381_93918# sg13cmos5l_Corner_1.vss sg13_lv_nmos ad=0.1898p pd=1.36u as=0.2516p ps=2.16u w=0.74u l=0.13u
M2633 adc8b_0.sar12b_0.sg13cmos5l_inv_1_29.A a_94172_99132# sg13cmos5l_Corner_1.vss sg13cmos5l_Corner_1.vss sg13_lv_nmos ad=0.2516p pd=2.16u as=0.1406p ps=1.12u w=0.74u l=0.13u
M2634 vdd a_89399_95887# a_90236_96108# vdd sg13_lv_pmos ad=0.2128p pd=1.5u as=0.3864p ps=2.93u w=1.12u l=0.13u
M2635 a_87825_97713# a_87468_97640# vdd vdd sg13_lv_pmos ad=63f pd=0.72u as=0.1563p ps=1.22u w=0.42u l=0.13u
M2636 frame a_134044_30676# sg13cmos5l_Corner_1.vss sg13cmos5l_Corner_1.vss sg13_hv_nmos ad=2.596p pd=5.58u as=1.408p ps=5.04u w=4.4u l=0.6u
M2637 sg13cmos5l_IOPadAnalog_10.pad a_67639_178370# sg13cmos5l_Corner_1.vss sg13cmos5l_Corner_1.vss sg13_hv_nmos ad=2.596p pd=5.58u as=1.408p ps=5.04u w=4.4u l=0.6u
M2638 sg13cmos5l_Corner_1.vss sg13cmos5l_IOPadVdd$1_0.sg13cmos5l_Clamp_N43N43D4R$1_0.gate vdd sg13cmos5l_Corner_1.vss sg13_hv_nmos ad=1.408p pd=5.04u as=2.596p ps=5.58u w=4.4u l=0.6u
M2639 a_83890_99564# a_84333_99607# a_84273_99643# vdd sg13_lv_pmos ad=79.8f pd=0.8u as=63f ps=0.72u w=0.42u l=0.13u
M2640 adc8b_0.sar12b_0.sg13cmos5l_a221oi_1_0.C1 adc8b_0.sar12b_0.sg13cmos5l_inv_1_0.A sg13cmos5l_Corner_1.vss sg13cmos5l_Corner_1.vss sg13_lv_nmos ad=0.1406p pd=1.12u as=0.2516p ps=2.16u w=0.74u l=0.13u
M2641 data[2] a_102044_42476# sg13cmos5l_Corner_1.iovdd sg13cmos5l_Corner_1.iovdd sg13_hv_pmos ad=3.9294p pd=7.84u as=2.1312p ps=7.3u w=6.66u l=0.6u
M2642 sg13cmos5l_IOPadAnalog_9.pad a_83639_178370# sg13cmos5l_Corner_1.vss sg13cmos5l_Corner_1.vss sg13_hv_nmos ad=2.596p pd=5.58u as=1.408p ps=5.04u w=4.4u l=0.6u
X2643 a_36456_136735# a_40542_136405# sg13cmos5l_Corner_1.vss rppd l=20u w=1u
M2644 cks a_42476_118044# sg13cmos5l_Corner_1.iovdd sg13cmos5l_Corner_1.iovdd sg13_hv_pmos ad=3.9294p pd=7.84u as=2.1312p ps=7.3u w=6.66u l=0.6u
M2645 a_89709_98813# adc8b_0.sar12b_0.sg13cmos5l_dfrbp_1_18.Q vdd vdd sg13_lv_pmos ad=0.4088p pd=2.97u as=1.15047p ps=7.175u w=1.12u l=0.13u
M2646 sg13cmos5l_Corner_1.vss a_178296_118044# sg13cmos5l_IOPadAnalog_11.pad sg13cmos5l_Corner_1.vss sg13_hv_nmos ad=1.408p pd=5.04u as=2.596p ps=5.58u w=4.4u l=0.6u
M2647 a_94487_93909# a_93645_93559# a_93228_93552# vdd sg13_lv_pmos ad=0.2048p pd=1.63u as=0.34p ps=2.68u w=1u l=0.13u
M2648 sg13cmos5l_Corner_1.vss a_30676_70044# vddr sg13cmos5l_Corner_1.vss sg13_hv_nmos ad=1.408p pd=5.04u as=2.596p ps=5.58u w=4.4u l=0.6u
M2649 sg13cmos5l_Corner_1.vss adc8b_0.side_cap8b_0.in_l_sw[1] adc8b_0.side_cap8b_0.buf_16_2.z sg13cmos5l_Corner_1.vss sg13_lv_nmos ad=95f pd=0.88u as=95f ps=0.88u w=0.5u l=0.13u
M2650 sg13cmos5l_Corner_1.vss cks adc8b_0.sar12b_0.sg13cmos5l_dfrbp_1_6.RESET_B sg13cmos5l_Corner_1.vss sg13_lv_nmos ad=0.1406p pd=1.12u as=0.1406p ps=1.12u w=0.74u l=0.13u
M2651 a_99167_95107# adc8b_0.sar12b_0.sg13cmos5l_dfrbp_1_6.RESET_B vdd vdd sg13_lv_pmos ad=79.8f pd=0.8u as=0.36237p ps=2.605u w=0.42u l=0.13u
M2652 sg13cmos5l_Corner_1.vss a_99639_178370# sg13cmos5l_IOPadAnalog_15.pad sg13cmos5l_Corner_1.vss sg13_hv_nmos ad=1.408p pd=5.04u as=2.596p ps=5.58u w=4.4u l=0.6u
M2653 sg13cmos5l_Corner_1.iovdd a_67639_164698# sg13cmos5l_IOPadAnalog_10.pad sg13cmos5l_Corner_1.iovdd sg13_hv_pmos ad=2.1312p pd=7.3u as=3.9294p ps=7.84u w=6.66u l=0.6u
M2654 sg13cmos5l_Corner_1.vss a_115639_178370# sg13cmos5l_IOPadAnalog_13.pad sg13cmos5l_Corner_1.vss sg13_hv_nmos ad=1.408p pd=5.04u as=2.596p ps=5.58u w=4.4u l=0.6u
M2655 sg13cmos5l_Corner_1.iovdd a_83639_164698# sg13cmos5l_IOPadAnalog_9.pad sg13cmos5l_Corner_1.iovdd sg13_hv_pmos ad=3.1302p pd=14.26u as=3.9294p ps=7.84u w=6.66u l=0.6u
M2656 sg13cmos5l_Corner_1.vss sg13cmos5l_IOPadVdd$1_0.sg13cmos5l_Clamp_N43N43D4R$1_0.gate vdd sg13cmos5l_Corner_1.vss sg13_hv_nmos ad=1.408p pd=5.04u as=2.596p ps=5.58u w=4.4u l=0.6u
M2657 sg13cmos5l_Corner_1.iovdd a_42476_86044# vin sg13cmos5l_Corner_1.iovdd sg13_hv_pmos ad=2.1312p pd=7.3u as=3.9294p ps=7.84u w=6.66u l=0.6u
M2658 sg13cmos5l_Corner_1.vss adc8b_0.sar12b_0.sg13cmos5l_dfrbp_1_8.RESET_B a_93708_100346# sg13cmos5l_Corner_1.vss sg13_lv_nmos ad=0.1626p pd=1.415u as=60.89999f ps=0.71u w=0.42u l=0.13u
M2659 frame a_134044_42476# sg13cmos5l_Corner_1.iovdd sg13cmos5l_Corner_1.iovdd sg13_hv_pmos ad=3.9294p pd=7.84u as=3.1302p ps=14.26u w=6.66u l=0.6u
M2660 sg13cmos5l_Corner_1.vss a_91839_98442# a_91970_98448# sg13cmos5l_Corner_1.vss sg13_lv_nmos ad=1.49685p pd=9.6u as=0.2775p ps=2.23u w=0.74u l=0.13u
M2661 vdd a_100995_100350# adc8b_0.sar12b_0.sg13cmos5l_buf_8_2.X vdd sg13_lv_pmos ad=0.3864p pd=2.93u as=0.2128p ps=1.5u w=1.12u l=0.13u
M2662 sg13cmos5l_Corner_1.vss a_88509_96619# a_87588_96933# sg13cmos5l_Corner_1.vss sg13_lv_nmos ad=0.1626p pd=1.415u as=0.2516p ps=2.16u w=0.74u l=0.13u
M2663 sg13cmos5l_Corner_1.iovdd a_86044_42476# data[1] sg13cmos5l_Corner_1.iovdd sg13_hv_pmos ad=2.1312p pd=7.3u as=3.9294p ps=7.84u w=6.66u l=0.6u
M2664 a_91591_93940# adc8b_0.sar12b_0.sg13cmos5l_a22oi_1_2.B1 sg13cmos5l_Corner_1.vss sg13cmos5l_Corner_1.vss sg13_lv_nmos ad=0.13875p pd=1.115u as=0.2553p ps=2.17u w=0.74u l=0.13u
X2665 a_178296_102044# sg13cmos5l_Corner_1.vss sg13cmos5l_Corner_1.vss rppd l=3.54u w=0.5u
M2666 vddr adc8b_0.sar12b_0.nl_sw[5] adc8b_0.side_cap8b_1.buf_8_4.z vddr sg13_lv_pmos ad=0.19p pd=1.38u as=0.19p ps=1.38u w=1u l=0.13u
M2667 sg13cmos5l_Corner_1.vss a_93741_92765# a_93843_92908# sg13cmos5l_Corner_1.vss sg13_lv_nmos ad=7.01497p pd=46.005u as=0.2516p ps=2.16u w=0.74u l=0.13u
M2668 vdd adc8b_0.sar12b_0.sg13cmos5l_dfrbp_1_6.RESET_B a_82450_96540# vdd sg13_lv_pmos ad=0.1563p pd=1.22u as=0.147p ps=1.54u w=0.42u l=0.13u
M2669 a_96900_96974# a_96351_96930# a_96764_96572# sg13cmos5l_Corner_1.vss sg13_lv_nmos ad=47.25f pd=0.645u as=0.141p ps=1.17u w=0.42u l=0.13u
M2670 a_94583_95421# a_93741_95071# a_94489_95421# sg13cmos5l_Corner_1.vss sg13_lv_nmos ad=0.12665p pd=1.145u as=0.1428p ps=1.52u w=0.42u l=0.13u
M2671 a_86847_94314# adc8b_0.sar12b_0.sg13cmos5l_dfrbp_1_9.Q vdd vdd sg13_lv_pmos ad=0.3234p pd=2.45u as=1.38655p ps=8.8u w=0.84u l=0.13u
M2672 sg13cmos5l_IOPadAnalog_15.pad a_99639_178370# sg13cmos5l_Corner_1.vss sg13cmos5l_Corner_1.vss sg13_hv_nmos ad=2.596p pd=5.58u as=2.068p ps=9.74u w=4.4u l=0.6u
M2673 sg13cmos5l_IOPadAnalog_10.pad a_67639_164698# sg13cmos5l_Corner_1.iovdd sg13cmos5l_Corner_1.iovdd sg13_hv_pmos ad=3.9294p pd=7.84u as=2.1312p ps=7.3u w=6.66u l=0.6u
M2674 vip a_42476_102044# sg13cmos5l_Corner_1.iovdd sg13cmos5l_Corner_1.iovdd sg13_hv_pmos ad=3.9294p pd=7.84u as=2.1312p ps=7.3u w=6.66u l=0.6u
M2675 a_84142_100021# adc8b_0.sar12b_0.sg13cmos5l_dfrbp_1_8.RESET_B sg13cmos5l_Corner_1.vss sg13cmos5l_Corner_1.vss sg13_lv_nmos ad=37.8f pd=0.6u as=0.1701p ps=1.65u w=0.42u l=0.13u
M2676 a_87852_95485# a_87564_95064# a_87790_95485# sg13cmos5l_Corner_1.vss sg13_lv_nmos ad=0.1428p pd=1.52u as=37.8f ps=0.6u w=0.42u l=0.13u
M2677 vdd a_90551_98911# a_91388_99132# vdd sg13_lv_pmos ad=0.2128p pd=1.5u as=0.3864p ps=2.93u w=1.12u l=0.13u
M2678 vddr adc8b_0.sar12b_0.nl_sw[2] adc8b_0.side_cap8b_1.buf_16_1.z vddr sg13_lv_pmos ad=0.19p pd=1.38u as=0.19p ps=1.38u w=1u l=0.13u
M2679 adc8b_0.side_cap8b_1.buf_8_3.z adc8b_0.sar12b_0.nh_sw[3] sg13cmos5l_Corner_1.vss sg13cmos5l_Corner_1.vss sg13_lv_nmos ad=95f pd=0.88u as=95f ps=0.88u w=0.5u l=0.13u
M2680 a_86420_97286# adc8b_0.sar12b_0.sg13cmos5l_buf_1_59.A sg13cmos5l_Corner_1.vss sg13cmos5l_Corner_1.vss sg13_lv_nmos ad=0.187p pd=1.78u as=0.14875p ps=1.16u w=0.55u l=0.13u
M2681 a_99489_97637# a_98547_97444# a_99287_97399# vdd sg13_lv_pmos ad=93.45f pd=0.865u as=0.2048p ps=1.63u w=0.42u l=0.13u
X2682 sg13cmos5l_Corner_1.vss a_118222_32962# dantenna l=1.26u w=27.78u
M2683 vddr adc8b_0.side_cap8b_0.in_l_sw[4] adc8b_0.side_cap8b_0.buf_8_0.z vddr sg13_lv_pmos ad=0.19p pd=1.38u as=0.19p ps=1.38u w=1u l=0.13u
M2684 a_99480_99596# a_98929_99954# vdd vdd sg13_lv_pmos ad=0.105p pd=1.21u as=1.15047p ps=7.175u w=1u l=0.13u
M2685 sg13cmos5l_IOPadAnalog_12.pad a_131639_164698# sg13cmos5l_Corner_1.iovdd sg13cmos5l_Corner_1.iovdd sg13_hv_pmos ad=3.9294p pd=7.84u as=2.1312p ps=7.3u w=6.66u l=0.6u
X2686 sg13cmos5l_IOPadAnalog_11.padres sg13cmos5l_Corner_1.iovdd dpantenna l=4.98u w=0.64u
M2687 adc8b_0.sar12b_0.sg13cmos5l_dlhr_1_1.Q_N a_84702_95792# sg13cmos5l_Corner_1.vss sg13cmos5l_Corner_1.vss sg13_lv_nmos ad=0.2516p pd=2.16u as=0.1491p ps=1.18u w=0.74u l=0.13u
M2688 data[0] a_70044_30676# sg13cmos5l_Corner_1.vss sg13cmos5l_Corner_1.vss sg13_hv_nmos ad=2.596p pd=5.58u as=1.408p ps=5.04u w=4.4u l=0.6u
M2689 sg13cmos5l_Corner_1.iovdd a_42476_70044# vddr sg13cmos5l_Corner_1.iovdd sg13_hv_pmos ad=3.1302p pd=14.26u as=3.9294p ps=7.84u w=6.66u l=0.6u
M2690 sg13cmos5l_Corner_1.vss cks adc8b_0.sar12b_0.sg13cmos5l_dfrbp_1_6.RESET_B sg13cmos5l_Corner_1.vss sg13_lv_nmos ad=0.1406p pd=1.12u as=0.1406p ps=1.12u w=0.74u l=0.13u
M2691 sg13cmos5l_Corner_1.vss adc8b_0.sar12b_0.sg13cmos5l_dfrbp_1_8.RESET_B a_85164_95810# sg13cmos5l_Corner_1.vss sg13_lv_nmos ad=0.1626p pd=1.415u as=60.89999f ps=0.71u w=0.42u l=0.13u
M2692 adc8b_0.side_cap8b_0.buf_16_3.z adc8b_0.side_cap8b_0.in_h_sw[1] vddr vddr sg13_lv_pmos ad=0.19p pd=1.38u as=0.19p ps=1.38u w=1u l=0.13u
M2693 cko a_118044_30676# sg13cmos5l_Corner_1.vss sg13cmos5l_Corner_1.vss sg13_hv_nmos ad=2.596p pd=5.58u as=1.408p ps=5.04u w=4.4u l=0.6u
M2694 sg13cmos5l_Corner_1.vss sg13cmos5l_IOPadVdd$1_0.sg13cmos5l_Clamp_N43N43D4R$1_0.gate vdd sg13cmos5l_Corner_1.vss sg13_hv_nmos ad=1.408p pd=5.04u as=2.596p ps=5.58u w=4.4u l=0.6u
M2695 adc8b_0.sar12b_0.sg13cmos5l_buf_8_2.X a_100995_100350# sg13cmos5l_Corner_1.vss sg13cmos5l_Corner_1.vss sg13_lv_nmos ad=0.1406p pd=1.12u as=0.1406p ps=1.12u w=0.74u l=0.13u
M2696 sg13cmos5l_Corner_1.vss a_97470_95347# adc8b_0.sar12b_0.sg13cmos5l_and3_1_0.C sg13cmos5l_Corner_1.vss sg13_lv_nmos ad=0.1406p pd=1.12u as=0.2516p ps=2.16u w=0.74u l=0.13u
X2697 a_86044_30676# sg13cmos5l_Corner_1.vss sg13cmos5l_Corner_1.vss rppd l=3.54u w=0.5u
M2698 adc8b_0.side_cap8b_1.buf_16_2.z adc8b_0.sar12b_0.nl_sw[1] vddr vddr sg13_lv_pmos ad=0.34p pd=2.68u as=0.19p ps=1.38u w=1u l=0.13u
M2699 adc8b_0.sar12b_0.sg13cmos5l_buf_1_34.A a_85809_93905# sg13cmos5l_Corner_1.vss sg13cmos5l_Corner_1.vss sg13_lv_nmos ad=0.2516p pd=2.16u as=0.1406p ps=1.12u w=0.74u l=0.13u
M2700 a_90740_100310# adc8b_0.sar12b_0.sg13cmos5l_buf_1_77.A sg13cmos5l_Corner_1.vss sg13cmos5l_Corner_1.vss sg13_lv_nmos ad=0.187p pd=1.78u as=0.14875p ps=1.16u w=0.55u l=0.13u
M2701 sg13cmos5l_Corner_1.vss a_95159_100423# a_95996_100644# sg13cmos5l_Corner_1.vss sg13_lv_nmos ad=0.1406p pd=1.12u as=0.2516p ps=2.16u w=0.74u l=0.13u
M2702 vdd a_96568_94518# a_96513_94613# vdd sg13_lv_pmos ad=1.43437p pd=9.105u as=93.45f ps=0.865u w=0.42u l=0.13u
M2703 data[0] a_70044_42476# sg13cmos5l_Corner_1.iovdd sg13cmos5l_Corner_1.iovdd sg13_hv_pmos ad=3.9294p pd=7.84u as=3.1302p ps=14.26u w=6.66u l=0.6u
M2704 a_82388_98798# adc8b_0.sar12b_0.sg13cmos5l_buf_1_63.X vdd vdd sg13_lv_pmos ad=0.2856p pd=2.36u as=0.2114p ps=1.54u w=0.84u l=0.13u
X2705 sg13cmos5l_IOPadAnalog_17.padres data[2] sg13cmos5l_Corner_1.vss rppd l=2u w=1u
M2706 sg13cmos5l_Corner_1.vss a_67639_178370# sg13cmos5l_IOPadAnalog_10.pad sg13cmos5l_Corner_1.vss sg13_hv_nmos ad=1.408p pd=5.04u as=2.596p ps=5.58u w=4.4u l=0.6u
M2707 sg13cmos5l_Corner_1.vss adc8b_0.side_cap8b_0.in_h_sw[2] adc8b_0.side_cap8b_0.buf_16_0.z sg13cmos5l_Corner_1.vss sg13_lv_nmos ad=95f pd=0.88u as=95f ps=0.88u w=0.5u l=0.13u
M2708 sg13cmos5l_Corner_1.vss a_83639_178370# sg13cmos5l_IOPadAnalog_9.pad sg13cmos5l_Corner_1.vss sg13_hv_nmos ad=1.408p pd=5.04u as=2.596p ps=5.58u w=4.4u l=0.6u
M2709 a_98124_98509# a_97836_98088# a_98062_98509# sg13cmos5l_Corner_1.vss sg13_lv_nmos ad=0.1428p pd=1.52u as=37.8f ps=0.6u w=0.42u l=0.13u
M2710 adc8b_0.side_cap8b_1.buf_32_1.z adc8b_0.sar12b_0.nh_sw[0] sg13cmos5l_Corner_1.vss sg13cmos5l_Corner_1.vss sg13_lv_nmos ad=95f pd=0.88u as=95f ps=0.88u w=0.5u l=0.13u
M2711 sg13cmos5l_Corner_1.vss sg13cmos5l_IOPadVdd$1_0.sg13cmos5l_Clamp_N43N43D4R$1_0.gate vdd sg13cmos5l_Corner_1.vss sg13_hv_nmos ad=1.408p pd=5.04u as=2.596p ps=5.58u w=4.4u l=0.6u
M2712 sg13cmos5l_Corner_1.iovdd a_164624_70044# sg13cmos5l_IOPadAnalog_1.pad sg13cmos5l_Corner_1.iovdd sg13_hv_pmos ad=2.1312p pd=7.3u as=3.9294p ps=7.84u w=6.66u l=0.6u
M2713 sg13cmos5l_Corner_1.vss adc8b_0.sar12b_0.nl_sw[9] adc8b_0.side_cap8b_1.buf_2_2.z sg13cmos5l_Corner_1.vss sg13_lv_nmos ad=95f pd=0.88u as=0.17p ps=1.68u w=0.5u l=0.13u
M2714 vdd sg13cmos5l_IOPadVdd$1_0.sg13cmos5l_Clamp_N43N43D4R$1_0.gate sg13cmos5l_Corner_1.vss sg13cmos5l_Corner_1.vss sg13_hv_nmos ad=2.596p pd=5.58u as=1.408p ps=5.04u w=4.4u l=0.6u
M2715 sg13cmos5l_Corner_1.vss adc8b_0.sar12b_0.sg13cmos5l_dlhr_1_11.D a_94129_98442# sg13cmos5l_Corner_1.vss sg13_lv_nmos ad=0.15055p pd=1.17u as=0.187p ps=1.78u w=0.55u l=0.13u
M2716 vdd adc8b_0.sar12b_0.sg13cmos5l_dfrbp_1_6.RESET_B a_84177_95810# vdd sg13_lv_pmos ad=0.2128p pd=1.5u as=0.2128p ps=1.5u w=1.12u l=0.13u
M2717 adc8b_0.sar12b_0.sg13cmos5l_buf_8_0.X a_100995_95814# sg13cmos5l_Corner_1.vss sg13cmos5l_Corner_1.vss sg13_lv_nmos ad=0.1406p pd=1.12u as=0.1406p ps=1.12u w=0.74u l=0.13u
M2718 adc8b_0.sar12b_0.sg13cmos5l_or2_1_0.A a_100131_95430# sg13cmos5l_Corner_1.vss sg13cmos5l_Corner_1.vss sg13_lv_nmos ad=0.1406p pd=1.12u as=0.1406p ps=1.12u w=0.74u l=0.13u
M2719 adc8b_0.sar12b_0.sg13cmos5l_dfrbp_1_17.Q_N a_85175_99957# vdd vdd sg13_lv_pmos ad=0.4312p pd=3.01u as=0.2639p ps=1.81u w=1.12u l=0.13u
M2720 a_94785_95183# a_93843_95071# a_94583_95421# vdd sg13_lv_pmos ad=93.45f pd=0.865u as=0.2048p ps=1.63u w=0.42u l=0.13u
M2721 a_99885_94277# adc8b_0.sar12b_0.sg13cmos5l_dfrbp_1_0.CLK sg13cmos5l_Corner_1.vss sg13cmos5l_Corner_1.vss sg13_lv_nmos ad=0.2516p pd=2.16u as=2.43055p ps=15.415u w=0.74u l=0.13u
M2722 sg13cmos5l_Corner_1.vss adc8b_0.side_cap8b_0.in_l_sw[0] adc8b_0.side_cap8b_0.buf_32_0.z sg13cmos5l_Corner_1.vss sg13_lv_nmos ad=95f pd=0.88u as=95f ps=0.88u w=0.5u l=0.13u
M2723 sg13cmos5l_IOPadAnalog_10.pad a_67639_178370# sg13cmos5l_Corner_1.vss sg13cmos5l_Corner_1.vss sg13_hv_nmos ad=2.596p pd=5.58u as=2.068p ps=9.74u w=4.4u l=0.6u
M2724 sg13cmos5l_Corner_1.vss sg13cmos5l_IOPadVdd$1_0.sg13cmos5l_Clamp_N43N43D4R$1_0.gate vdd sg13cmos5l_Corner_1.vss sg13_hv_nmos ad=1.408p pd=5.04u as=2.596p ps=5.58u w=4.4u l=0.6u
M2725 vdd sg13cmos5l_Corner_1.vss vdd vdd sg13_lv_pmos ad=0.34p pd=2.68u as=0 ps=0 w=1u l=1u
M2726 vddr adc8b_0.side_cap8b_0.in_l_sw[0] adc8b_0.side_cap8b_0.buf_32_0.z vddr sg13_lv_pmos ad=0.19p pd=1.38u as=0.19p ps=1.38u w=1u l=0.13u
M2727 adc8b_0.sar12b_0.sg13cmos5l_dlhr_1_5.D a_88727_97399# sg13cmos5l_Corner_1.vss sg13cmos5l_Corner_1.vss sg13_lv_nmos ad=0.2849p pd=2.25u as=0.2516p ps=2.16u w=0.74u l=0.13u
M2728 adc8b_0.side_cap8b_0.buf_16_0.z adc8b_0.side_cap8b_0.in_h_sw[2] vddr vddr sg13_lv_pmos ad=0.19p pd=1.38u as=0.19p ps=1.38u w=1u l=0.13u
M2729 a_83996_96132# a_83583_95826# a_83928_96132# vdd sg13_lv_pmos ad=0.191p pd=1.44u as=0.105p ps=1.21u w=1u l=0.13u
M2730 adc8b_0.side_cap8b_0.buf_4_0.z adc8b_0.side_cap8b_0.in_l_sw[7] vddr vddr sg13_lv_pmos ad=0.34p pd=2.68u as=0.19p ps=1.38u w=1u l=0.13u
M2731 vdd adc8b_0.sar12b_0.sg13cmos5l_buf_1_60.X a_84016_100384# vdd sg13_lv_pmos ad=0.2114p pd=1.54u as=0.2856p ps=2.36u w=0.84u l=0.13u
M2732 sg13cmos5l_Corner_1.vss a_99639_178370# sg13cmos5l_IOPadAnalog_15.pad sg13cmos5l_Corner_1.vss sg13_hv_nmos ad=1.408p pd=5.04u as=2.596p ps=5.58u w=4.4u l=0.6u
M2733 sg13cmos5l_Corner_1.vss a_94844_96536# adc8b_0.sar12b_0.sg13cmos5l_or2_1_1.B sg13cmos5l_Corner_1.vss sg13_lv_nmos ad=0.17255p pd=1.25u as=0.1406p ps=1.12u w=0.74u l=0.13u
M2734 a_87193_94290# a_86641_94352# sg13cmos5l_Corner_1.vss sg13cmos5l_Corner_1.vss sg13_lv_nmos ad=71.99999f pd=0.865u as=2.59257p ps=16.445u w=0.64u l=0.13u
M2735 vdd sg13cmos5l_Corner_1.vss vdd vdd sg13_lv_pmos ad=0.34p pd=2.68u as=0 ps=0 w=1u l=1u
M2736 adc8b_0.sar12b_0.sg13cmos5l_buf_1_98.A a_95409_98834# vdd vdd sg13_lv_pmos ad=0.3808p pd=2.92u as=0.2128p ps=1.5u w=1.12u l=0.13u
M2737 a_83890_95028# a_84333_95071# a_83630_95498# sg13cmos5l_Corner_1.vss sg13_lv_nmos ad=79.8f pd=0.8u as=0.1296p ps=1.52u w=0.42u l=0.13u
M2738 vdd adc8b_0.sar12b_0.sg13cmos5l_dfrbp_1_0.RESET_B a_99182_94298# vdd sg13_lv_pmos ad=0.36237p pd=2.605u as=79.8f ps=0.8u w=0.42u l=0.13u
M2739 vdd adc8b_0.sar12b_0.sg13cmos5l_dlhr_1_11.D a_94129_98442# vdd sg13_lv_pmos ad=1.07253p pd=6.75u as=0.2856p ps=2.36u w=0.84u l=0.13u
M2740 sg13cmos5l_Corner_1.vss a_87441_94298# a_87966_94280# sg13cmos5l_Corner_1.vss sg13_lv_nmos ad=0.1491p pd=1.18u as=0.187p ps=1.78u w=0.55u l=0.13u
M2741 a_89500_94284# a_89084_94620# a_89265_94298# sg13cmos5l_Corner_1.vss sg13_lv_nmos ad=77.7f pd=0.95u as=0.2516p ps=2.16u w=0.74u l=0.13u
M2742 sg13cmos5l_Corner_1.iovdd a_86044_42476# data[1] sg13cmos5l_Corner_1.iovdd sg13_hv_pmos ad=2.1312p pd=7.3u as=3.9294p ps=7.84u w=6.66u l=0.6u
M2743 sg13cmos5l_Corner_1.iovdd a_131639_164698# sg13cmos5l_IOPadAnalog_12.pad sg13cmos5l_Corner_1.iovdd sg13_hv_pmos ad=2.1312p pd=7.3u as=3.9294p ps=7.84u w=6.66u l=0.6u
M2744 sg13cmos5l_Corner_1.iovdd a_164624_70044# sg13cmos5l_IOPadAnalog_1.pad sg13cmos5l_Corner_1.iovdd sg13_hv_pmos ad=2.1312p pd=7.3u as=3.9294p ps=7.84u w=6.66u l=0.6u
M2745 sg13cmos5l_Corner_1.iovdd a_164624_102044# sg13cmos5l_IOPadAnalog_16.pad sg13cmos5l_Corner_1.iovdd sg13_hv_pmos ad=2.1312p pd=7.3u as=3.9294p ps=7.84u w=6.66u l=0.6u
M2746 vdd adc8b_0.sar12b_0.sg13cmos5l_buf_1_35.A a_83632_92824# vdd sg13_lv_pmos ad=0.2114p pd=1.54u as=0.2856p ps=2.36u w=0.84u l=0.13u
M2747 sg13cmos5l_Corner_1.vss a_83614_99010# adc8b_0.sar12b_0.sg13cmos5l_dlhr_1_8.Q_N sg13cmos5l_Corner_1.vss sg13_lv_nmos ad=0.1491p pd=1.18u as=0.2516p ps=2.16u w=0.74u l=0.13u
M2748 sg13cmos5l_Corner_1.vss a_30676_102044# vip sg13cmos5l_Corner_1.vss sg13_hv_nmos ad=1.408p pd=5.04u as=2.596p ps=5.58u w=4.4u l=0.6u
M2749 a_84516_97286# a_84647_97592# a_83765_97286# vdd sg13_lv_pmos ad=0.34p pd=2.68u as=0.2048p ps=1.63u w=1u l=0.13u
M2750 vdd sg13cmos5l_Corner_1.vss vdd vdd sg13_lv_pmos ad=0.34p pd=2.68u as=0 ps=0 w=1u l=1u
M2751 a_94188_100359# a_93900_100664# a_94126_100359# sg13cmos5l_Corner_1.vss sg13_lv_nmos ad=0.1428p pd=1.52u as=37.8f ps=0.6u w=0.42u l=0.13u
M2752 sg13cmos5l_Corner_1.vss a_86327_98790# a_86282_98826# sg13cmos5l_Corner_1.vss sg13_lv_nmos ad=1.49685p pd=9.6u as=71.99999f ps=0.865u w=0.64u l=0.13u
M2753 a_98445_97301# adc8b_0.sar12b_0.sg13cmos5l_dfrbp_1_8.D sg13cmos5l_Corner_1.vss sg13cmos5l_Corner_1.vss sg13_lv_nmos ad=0.2516p pd=2.16u as=1.97045p ps=12.335u w=0.74u l=0.13u
M2754 adc8b_0.side_cap8b_1.buf_16_3.z adc8b_0.sar12b_0.nh_sw[1] vddr vddr sg13_lv_pmos ad=0.34p pd=2.68u as=0.19p ps=1.38u w=1u l=0.13u
M2755 vddr a_30676_70044# sg13cmos5l_Corner_1.vss sg13cmos5l_Corner_1.vss sg13_hv_nmos ad=2.596p pd=5.58u as=1.408p ps=5.04u w=4.4u l=0.6u
M2756 adc8b_0.sar12b_0.sg13cmos5l_buf_1_95.X a_94000_99596# sg13cmos5l_Corner_1.vss sg13cmos5l_Corner_1.vss sg13_lv_nmos ad=0.2886p pd=2.26u as=0.14875p ps=1.16u w=0.74u l=0.13u
M2757 adc8b_0.sar12b_0.sg13cmos5l_or2_1_0.A a_100131_95430# sg13cmos5l_Corner_1.vss sg13cmos5l_Corner_1.vss sg13_lv_nmos ad=0.1406p pd=1.12u as=0.1406p ps=1.12u w=0.74u l=0.13u
M2758 a_89080_95302# adc8b_0.sar12b_0.sg13cmos5l_dfrbp_1_6.RESET_B vdd vdd sg13_lv_pmos ad=79.8f pd=0.8u as=1.38655p ps=8.8u w=0.42u l=0.13u
M2759 a_99518_95485# a_98340_95421# a_99122_95340# sg13cmos5l_Corner_1.vss sg13_lv_nmos ad=37.8f pd=0.6u as=0.1428p ps=1.52u w=0.42u l=0.13u
M2760 adc8b_0.sar12b_0.sg13cmos5l_dfrbp_1_5.Q_N a_98519_93909# vdd vdd sg13_lv_pmos ad=0.4312p pd=3.01u as=0.2639p ps=1.81u w=1.12u l=0.13u
M2761 sg13cmos5l_IOPadVdd$1_0.sg13cmos5l_Clamp_N43N43D4R$1_0.gate sg13cmos5l_IOPadVdd$1_0.sg13cmos5l_RCClampInverter$1_0.in vdd vdd sg13_hv_pmos ad=1.33p pd=7.38u as=1.33p ps=7.38u w=7u l=0.5u
M2762 sg13cmos5l_Corner_1.vss a_95416_100566# a_95065_100423# sg13cmos5l_Corner_1.vss sg13_lv_nmos ad=79.8f pd=0.8u as=0.1428p ps=1.52u w=0.42u l=0.13u
M2763 sg13cmos5l_Corner_1.vss a_94815_98850# a_94946_98844# sg13cmos5l_Corner_1.vss sg13_lv_nmos ad=1.49685p pd=9.6u as=0.2775p ps=2.23u w=0.74u l=0.13u
M2764 sg13cmos5l_IOPadAnalog_13.pad a_115639_164698# sg13cmos5l_Corner_1.iovdd sg13cmos5l_Corner_1.iovdd sg13_hv_pmos ad=3.9294p pd=7.84u as=3.1302p ps=14.26u w=6.66u l=0.6u
X2765 vin sg13cmos5l_Corner_1.iovdd dpantenna l=27.78u w=1.26u
X2766 sg13cmos5l_IOPadAnalog_0.padres sg13cmos5l_Corner_1.iovdd dpantenna l=4.98u w=0.64u
M2767 sg13cmos5l_IOPadAnalog_12.pad a_131639_164698# sg13cmos5l_Corner_1.iovdd sg13cmos5l_Corner_1.iovdd sg13_hv_pmos ad=3.9294p pd=7.84u as=2.1312p ps=7.3u w=6.66u l=0.6u
M2768 sg13cmos5l_Corner_1.vss sg13cmos5l_IOPadVdd$1_0.sg13cmos5l_Clamp_N43N43D4R$1_0.gate vdd sg13cmos5l_Corner_1.vss sg13_hv_nmos ad=1.408p pd=5.04u as=2.596p ps=5.58u w=4.4u l=0.6u
M2769 sg13cmos5l_Corner_1.vss adc8b_0.sar12b_0.nh_sw[2] adc8b_0.side_cap8b_1.buf_16_0.z sg13cmos5l_Corner_1.vss sg13_lv_nmos ad=95f pd=0.88u as=95f ps=0.88u w=0.5u l=0.13u
M2770 adc8b_0.side_cap8b_1.buf_16_1.z adc8b_0.sar12b_0.nl_sw[2] vddr vddr sg13_lv_pmos ad=0.19p pd=1.38u as=0.19p ps=1.38u w=1u l=0.13u
M2771 a_99544_97542# a_99287_97399# a_99706_97322# sg13cmos5l_Corner_1.vss sg13_lv_nmos ad=0.1428p pd=1.52u as=37.8f ps=0.6u w=0.42u l=0.13u
M2772 a_84333_95071# adc8b_0.sar12b_0.sg13cmos5l_inv_1_8.A vdd vdd sg13_lv_pmos ad=0.4088p pd=2.97u as=1.43437p ps=9.105u w=1.12u l=0.13u
M2773 a_100383_96930# adc8b_0.sar12b_0.sg13cmos5l_dfrbp_1_8.D vdd vdd sg13_lv_pmos ad=0.3234p pd=2.45u as=1.28962p ps=8.195u w=0.84u l=0.13u
M2774 adc8b_0.sar12b_0.sg13cmos5l_buf_8_2.X a_100995_100350# sg13cmos5l_Corner_1.vss sg13cmos5l_Corner_1.vss sg13_lv_nmos ad=0.1406p pd=1.12u as=0.1406p ps=1.12u w=0.74u l=0.13u
M2775 vdd a_99519_98850# a_99650_98844# vdd sg13_lv_pmos ad=1.15047p pd=7.175u as=0.2856p ps=2.36u w=0.84u l=0.13u
M2776 a_85432_95302# adc8b_0.sar12b_0.sg13cmos5l_dfrbp_1_8.RESET_B vdd vdd sg13_lv_pmos ad=79.8f pd=0.8u as=1.43437p ps=9.105u w=0.42u l=0.13u
M2777 a_102260_99560# adc8b_0.sar12b_0.sg13cmos5l_buf_1_104.X vdd vdd sg13_lv_pmos ad=0.2856p pd=2.36u as=0.2114p ps=1.54u w=0.84u l=0.13u
M2778 vip a_30676_102044# sg13cmos5l_Corner_1.vss sg13cmos5l_Corner_1.vss sg13_hv_nmos ad=2.596p pd=5.58u as=1.408p ps=5.04u w=4.4u l=0.6u
M2779 adc8b_0.sar12b_0.sg13cmos5l_dfrbp_1_15.D a_86012_99596# sg13cmos5l_Corner_1.vss sg13cmos5l_Corner_1.vss sg13_lv_nmos ad=0.2516p pd=2.16u as=0.1406p ps=1.12u w=0.74u l=0.13u
M2780 adc8b_0.sar12b_0.sg13cmos5l_buf_1_56.A a_90801_97322# sg13cmos5l_Corner_1.vss sg13cmos5l_Corner_1.vss sg13_lv_nmos ad=0.2516p pd=2.16u as=0.1406p ps=1.12u w=0.74u l=0.13u
M2781 adc8b_0.sar12b_0.sg13cmos5l_buf_8_1.A a_99740_96108# sg13cmos5l_Corner_1.vss sg13cmos5l_Corner_1.vss sg13_lv_nmos ad=0.2516p pd=2.16u as=0.1406p ps=1.12u w=0.74u l=0.13u
M2782 a_96396_99600# a_96370_99564# sg13cmos5l_Corner_1.vss sg13cmos5l_Corner_1.vss sg13_lv_nmos ad=0.2516p pd=2.16u as=0.1626p ps=1.415u w=0.74u l=0.13u
M2783 a_92551_95036# adc8b_0.sar12b_0.sg13cmos5l_nand2_1_0.A vdd vdd sg13_lv_pmos ad=0.2716p pd=1.605u as=0.3808p ps=2.92u w=1.12u l=0.13u
M2784 sg13cmos5l_Corner_1.iovdd a_42476_118044# cks sg13cmos5l_Corner_1.iovdd sg13_hv_pmos ad=2.1312p pd=7.3u as=3.9294p ps=7.84u w=6.66u l=0.6u
M2785 vddr adc8b_0.side_cap8b_0.in_h_sw[1] adc8b_0.side_cap8b_0.buf_16_3.z vddr sg13_lv_pmos ad=0.19p pd=1.38u as=0.19p ps=1.38u w=1u l=0.13u
M2786 cko a_118044_42476# sg13cmos5l_Corner_1.iovdd sg13cmos5l_Corner_1.iovdd sg13_hv_pmos ad=3.9294p pd=7.84u as=2.1312p ps=7.3u w=6.66u l=0.6u
M2787 vdd a_100727_94375# a_101564_94596# vdd sg13_lv_pmos ad=0.2128p pd=1.5u as=0.3864p ps=2.93u w=1.12u l=0.13u
M2788 sg13cmos5l_Corner_1.vss adc8b_0.side_cap8b_0.in_h_sw[0] adc8b_0.side_cap8b_0.buf_32_1.z sg13cmos5l_Corner_1.vss sg13_lv_nmos ad=95f pd=0.88u as=95f ps=0.88u w=0.5u l=0.13u
M2789 vddr adc8b_0.side_cap8b_0.in_h_sw[5] adc8b_0.side_cap8b_0.buf_8_5.z vddr sg13_lv_pmos ad=0.19p pd=1.38u as=0.19p ps=1.38u w=1u l=0.13u
M2790 sg13cmos5l_Corner_1.vss adc8b_0.sar12b_0.sg13cmos5l_buf_1_105.A a_100624_99596# sg13cmos5l_Corner_1.vss sg13_lv_nmos ad=0.14875p pd=1.16u as=0.187p ps=1.78u w=0.55u l=0.13u
M2791 a_89631_98442# adc8b_0.sar12b_0.sg13cmos5l_dlhr_1_5.GATE sg13cmos5l_Corner_1.vss sg13cmos5l_Corner_1.vss sg13_lv_nmos ad=0.2516p pd=2.16u as=0.15055p ps=1.17u w=0.74u l=0.13u
M2792 a_84525_94277# adc8b_0.sar12b_0.sg13cmos5l_dfrbp_1_9.Q sg13cmos5l_Corner_1.vss sg13cmos5l_Corner_1.vss sg13_lv_nmos ad=0.2516p pd=2.16u as=2.59257p ps=16.445u w=0.74u l=0.13u
M2793 sg13cmos5l_Corner_1.iovdd a_86044_42476# data[1] sg13cmos5l_Corner_1.iovdd sg13_hv_pmos ad=2.1312p pd=7.3u as=3.9294p ps=7.84u w=6.66u l=0.6u
M2794 vddr a_42476_70044# sg13cmos5l_Corner_1.iovdd sg13cmos5l_Corner_1.iovdd sg13_hv_pmos ad=3.9294p pd=7.84u as=2.1312p ps=7.3u w=6.66u l=0.6u
M2795 sg13cmos5l_Corner_1.vss a_90740_100310# adc8b_0.sar12b_0.sg13cmos5l_buf_1_77.X sg13cmos5l_Corner_1.vss sg13_lv_nmos ad=0.14875p pd=1.16u as=0.2886p ps=2.26u w=0.74u l=0.13u
M2796 vddr adc8b_0.sar12b_0.nl_sw[1] adc8b_0.side_cap8b_1.buf_16_2.z vddr sg13_lv_pmos ad=0.19p pd=1.38u as=0.19p ps=1.38u w=1u l=0.13u
M2797 sg13cmos5l_Corner_1.vss a_67639_178370# sg13cmos5l_IOPadAnalog_10.pad sg13cmos5l_Corner_1.vss sg13_hv_nmos ad=1.408p pd=5.04u as=2.596p ps=5.58u w=4.4u l=0.6u
M2798 sg13cmos5l_Corner_1.vss sg13cmos5l_IOPadVdd$1_0.sg13cmos5l_RCClampInverter$1_0.in sg13cmos5l_Corner_1.vss sg13cmos5l_Corner_1.vss sg13_hv_nmos ad=1.71p pd=9.38u as=0 ps=0 w=9u l=9.5u
M2799 vdd adc8b_0.sar12b_0.sg13cmos5l_inv_1_0.A a_92840_96507# vdd sg13_lv_pmos ad=0.1596p pd=1.22u as=0.1596p ps=1.22u w=0.84u l=0.13u
X2800 a_36456_133435# a_40542_133105# sg13cmos5l_Corner_1.vss rppd l=20u w=1u
M2801 adc8b_0.side_cap8b_0.buf_16_0.z adc8b_0.side_cap8b_0.in_h_sw[2] sg13cmos5l_Corner_1.vss sg13cmos5l_Corner_1.vss sg13_lv_nmos ad=0.17p pd=1.68u as=95f ps=0.88u w=0.5u l=0.13u
M2802 a_88148_98798# adc8b_0.sar12b_0.sg13cmos5l_buf_1_78.X vdd vdd sg13_lv_pmos ad=0.2856p pd=2.36u as=0.2114p ps=1.54u w=0.84u l=0.13u
M2803 adc8b_0.sar12b_0.sg13cmos5l_dfrbp_1_1.Q_N a_94583_92863# sg13cmos5l_Corner_1.vss sg13cmos5l_Corner_1.vss sg13_lv_nmos ad=0.2849p pd=2.25u as=0.2516p ps=2.16u w=0.74u l=0.13u
M2804 a_91799_99957# a_90957_99607# a_91705_99957# sg13cmos5l_Corner_1.vss sg13_lv_nmos ad=0.12665p pd=1.145u as=0.1428p ps=1.52u w=0.42u l=0.13u
M2805 adc8b_0.side_cap8b_0.buf_32_1.z adc8b_0.side_cap8b_0.in_h_sw[0] vddr vddr sg13_lv_pmos ad=0.19p pd=1.38u as=0.19p ps=1.38u w=1u l=0.13u
M2806 adc8b_0.side_cap8b_0.buf_8_4.z adc8b_0.side_cap8b_0.in_l_sw[5] sg13cmos5l_Corner_1.vss sg13cmos5l_Corner_1.vss sg13_lv_nmos ad=95f pd=0.88u as=95f ps=0.88u w=0.5u l=0.13u
M2807 vdd a_93140_94262# adc8b_0.sar12b_0.nh_sw[5] vdd sg13_lv_pmos ad=0.2114p pd=1.54u as=0.42p ps=2.99u w=1.12u l=0.13u
M2808 data[1] a_86044_30676# sg13cmos5l_Corner_1.vss sg13cmos5l_Corner_1.vss sg13_hv_nmos ad=2.596p pd=5.58u as=1.408p ps=5.04u w=4.4u l=0.6u
X2809 sg13cmos5l_Corner_1.iovdd a_42476_102044# sg13cmos5l_Corner_1.iovdd rppd l=12.9u w=0.5u
M2810 sg13cmos5l_Corner_1.vss adc8b_0.side_cap8b_0.in_l_sw[3] adc8b_0.side_cap8b_0.buf_8_1.z sg13cmos5l_Corner_1.vss sg13_lv_nmos ad=95f pd=0.88u as=95f ps=0.88u w=0.5u l=0.13u
M2811 adc8b_0.sar12b_0.sg13cmos5l_buf_1_6.A a_94288_94336# sg13cmos5l_Corner_1.vss sg13cmos5l_Corner_1.vss sg13_lv_nmos ad=0.2886p pd=2.26u as=0.14875p ps=1.16u w=0.74u l=0.13u
M2812 sg13cmos5l_Corner_1.iovdd a_118044_42476# cko sg13cmos5l_Corner_1.iovdd sg13_hv_pmos ad=2.1312p pd=7.3u as=3.9294p ps=7.84u w=6.66u l=0.6u
M2813 sg13cmos5l_Corner_1.vss a_88863_92802# a_88994_92796# sg13cmos5l_Corner_1.vss sg13_lv_nmos ad=7.01497p pd=46.005u as=0.2775p ps=2.23u w=0.74u l=0.13u
M2814 data[0] a_102160_93548# vdd vdd sg13_lv_pmos ad=0.42p pd=2.99u as=0.2114p ps=1.54u w=1.12u l=0.13u
M2815 data[2] a_102044_42476# sg13cmos5l_Corner_1.iovdd sg13cmos5l_Corner_1.iovdd sg13_hv_pmos ad=3.9294p pd=7.84u as=2.1312p ps=7.3u w=6.66u l=0.6u
M2816 sg13cmos5l_IOPadAnalog_0.pad a_178296_86044# sg13cmos5l_Corner_1.vss sg13cmos5l_Corner_1.vss sg13_hv_nmos ad=2.596p pd=5.58u as=1.408p ps=5.04u w=4.4u l=0.6u
M2817 adc8b_0.side_cap8b_1.buf_32_0.z adc8b_0.sar12b_0.nl_sw[0] vddr vddr sg13_lv_pmos ad=0.19p pd=1.38u as=0.19p ps=1.38u w=1u l=0.13u
M2818 sg13cmos5l_Corner_1.vss sg13cmos5l_IOPadVdd$1_0.sg13cmos5l_RCClampInverter$1_0.in sg13cmos5l_Corner_1.vss sg13cmos5l_Corner_1.vss sg13_hv_nmos ad=1.71p pd=9.38u as=0 ps=0 w=9u l=9.5u
M2819 vdd adc8b_0.sar12b_0.sg13cmos5l_dfrbp_1_6.RESET_B a_92050_99057# vdd sg13_lv_pmos ad=0.1563p pd=1.22u as=0.147p ps=1.54u w=0.42u l=0.13u
M2820 a_89220_94334# a_88671_94314# a_89084_94620# sg13cmos5l_Corner_1.vss sg13_lv_nmos ad=47.25f pd=0.645u as=0.141p ps=1.17u w=0.42u l=0.13u
M2821 cks a_30676_118044# sg13cmos5l_Corner_1.vss sg13cmos5l_Corner_1.vss sg13_hv_nmos ad=2.596p pd=5.58u as=1.408p ps=5.04u w=4.4u l=0.6u
M2822 adc8b_0.side_cap8b_0.buf_32_0.z adc8b_0.side_cap8b_0.in_l_sw[0] sg13cmos5l_Corner_1.vss sg13cmos5l_Corner_1.vss sg13_lv_nmos ad=0.17p pd=1.68u as=95f ps=0.88u w=0.5u l=0.13u
M2823 vdd a_100628_100310# adc8b_0.side_cap8b_0.in_h_sw[8] vdd sg13_lv_pmos ad=0.2114p pd=1.54u as=0.42p ps=2.99u w=1.12u l=0.13u
M2824 adc8b_0.sar12b_0.sg13cmos5l_buf_1_19.A a_100624_99596# sg13cmos5l_Corner_1.vss sg13cmos5l_Corner_1.vss sg13_lv_nmos ad=0.2886p pd=2.26u as=0.14875p ps=1.16u w=0.74u l=0.13u
M2825 vdd adc8b_0.sar12b_0.sg13cmos5l_buf_1_89.A a_96976_97360# vdd sg13_lv_pmos ad=0.2114p pd=1.54u as=0.2856p ps=2.36u w=0.84u l=0.13u
M2826 adc8b_0.sar12b_0.sg13cmos5l_inv_1_9.Y cks vdd vdd sg13_lv_pmos ad=0.3808p pd=2.92u as=0.3808p ps=2.92u w=1.12u l=0.13u
M2827 cko a_118044_30676# sg13cmos5l_Corner_1.vss sg13cmos5l_Corner_1.vss sg13_hv_nmos ad=2.596p pd=5.58u as=1.408p ps=5.04u w=4.4u l=0.6u
M2828 vdd adc8b_0.sar12b_0.sg13cmos5l_dlhr_1_0.D a_92099_93084# vdd sg13_lv_pmos ad=0.2128p pd=1.5u as=0.2128p ps=1.5u w=1.12u l=0.13u
M2829 sg13cmos5l_Corner_1.vss a_98036_94262# adc8b_0.sar12b_0.nl_sw[8] sg13cmos5l_Corner_1.vss sg13_lv_nmos ad=0.14875p pd=1.16u as=0.2886p ps=2.26u w=0.74u l=0.13u
M2830 sg13cmos5l_IOPadAnalog_9.pad a_83639_164698# sg13cmos5l_Corner_1.iovdd sg13cmos5l_Corner_1.iovdd sg13_hv_pmos ad=3.9294p pd=7.84u as=3.1302p ps=14.26u w=6.66u l=0.6u
M2831 sg13cmos5l_Corner_1.vss sg13cmos5l_IOPadVdd$1_0.sg13cmos5l_Clamp_N43N43D4R$1_0.gate vdd sg13cmos5l_Corner_1.vss sg13_hv_nmos ad=1.408p pd=5.04u as=2.596p ps=5.58u w=4.4u l=0.6u
M2832 vdd a_84116_98784# a_83716_99124# vdd sg13_lv_pmos ad=0.2387p pd=1.84u as=0.2128p ps=1.5u w=1.12u l=0.13u
M2833 a_93256_95836# adc8b_0.sar12b_0.sg13cmos5l_a221oi_1_0.B1 adc8b_0.sar12b_0.sg13cmos5l_o21ai_1_0.A1 sg13cmos5l_Corner_1.vss sg13_lv_nmos ad=0.1406p pd=1.12u as=0.2516p ps=2.16u w=0.74u l=0.13u
M2834 vdd adc8b_0.sar12b_0.sg13cmos5l_buf_1_19.A a_100528_93548# vdd sg13_lv_pmos ad=0.2114p pd=1.54u as=0.2856p ps=2.36u w=0.84u l=0.13u
M2835 adc8b_0.side_cap8b_0.buf_32_0.z adc8b_0.side_cap8b_0.in_l_sw[0] vddr vddr sg13_lv_pmos ad=0.19p pd=1.38u as=0.19p ps=1.38u w=1u l=0.13u
M2836 adc8b_0.side_cap8b_0.buf_4_1.z adc8b_0.side_cap8b_0.in_h_sw[6] vddr vddr sg13_lv_pmos ad=0.19p pd=1.38u as=0.19p ps=1.38u w=1u l=0.13u
M2837 frame a_101776_98872# sg13cmos5l_Corner_1.vss sg13cmos5l_Corner_1.vss sg13_lv_nmos ad=0.2886p pd=2.26u as=0.14875p ps=1.16u w=0.74u l=0.13u
M2838 a_87567_96659# a_87719_96543# vdd vdd sg13_lv_pmos ad=0.3864p pd=2.93u as=1.28962p ps=8.195u w=1.12u l=0.13u
M2839 sg13cmos5l_Corner_1.vss a_178296_86044# sg13cmos5l_IOPadAnalog_0.pad sg13cmos5l_Corner_1.vss sg13_hv_nmos ad=1.408p pd=5.04u as=2.596p ps=5.58u w=4.4u l=0.6u
M2840 sg13cmos5l_Corner_1.iovdd a_131639_164698# sg13cmos5l_IOPadAnalog_12.pad sg13cmos5l_Corner_1.iovdd sg13_hv_pmos ad=2.1312p pd=7.3u as=3.9294p ps=7.84u w=6.66u l=0.6u
M2841 sg13cmos5l_Corner_1.vss adc8b_0.sar12b_0.sg13cmos5l_dfrbp_1_6.RESET_B a_94092_97322# sg13cmos5l_Corner_1.vss sg13_lv_nmos ad=0.1626p pd=1.415u as=60.89999f ps=0.71u w=0.42u l=0.13u
M2842 adc8b_0.sar12b_0.sg13cmos5l_dfrbp_1_6.RESET_B cks vdd vdd sg13_lv_pmos ad=0.2128p pd=1.5u as=0.3808p ps=2.92u w=1.12u l=0.13u
M2843 sg13cmos5l_Corner_1.vss a_80694_96641# a_80806_96705# sg13cmos5l_Corner_1.vss sg13_lv_nmos ad=0.1426p pd=1.16u as=0.1428p ps=1.52u w=0.42u l=0.5u
M2844 sg13cmos5l_Corner_1.vss a_178296_118044# sg13cmos5l_IOPadAnalog_11.pad sg13cmos5l_Corner_1.vss sg13_hv_nmos ad=1.408p pd=5.04u as=2.596p ps=5.58u w=4.4u l=0.6u
M2845 a_92056_99838# a_91799_99957# a_92218_100034# sg13cmos5l_Corner_1.vss sg13_lv_nmos ad=0.1428p pd=1.52u as=37.8f ps=0.6u w=0.42u l=0.13u
M2846 sg13cmos5l_Corner_1.vss adc8b_0.sar12b_0.sg13cmos5l_dfrbp_1_16.Q a_85393_98442# sg13cmos5l_Corner_1.vss sg13_lv_nmos ad=0.15055p pd=1.17u as=0.187p ps=1.78u w=0.55u l=0.13u
M2847 a_87538_95028# a_87981_95071# a_87921_95107# vdd sg13_lv_pmos ad=79.8f pd=0.8u as=63f ps=0.72u w=0.42u l=0.13u
M2848 vdd adc8b_0.sar12b_0.sg13cmos5l_dfrbp_1_8.RESET_B a_87730_99564# vdd sg13_lv_pmos ad=0.1563p pd=1.22u as=0.147p ps=1.54u w=0.42u l=0.13u
M2849 vdd adc8b_0.cmp_0.outp a_82192_92824# vdd sg13_lv_pmos ad=0.2114p pd=1.54u as=0.2856p ps=2.36u w=0.84u l=0.13u
M2850 adc8b_0.sar12b_0.sg13cmos5l_buf_1_19.X a_100528_93548# vdd vdd sg13_lv_pmos ad=0.42p pd=2.99u as=0.2114p ps=1.54u w=1.12u l=0.13u
M2851 vin a_42476_86044# sg13cmos5l_Corner_1.iovdd sg13cmos5l_Corner_1.iovdd sg13_hv_pmos ad=3.9294p pd=7.84u as=2.1312p ps=7.3u w=6.66u l=0.6u
M2852 sg13cmos5l_Corner_1.vss a_102044_30676# data[2] sg13cmos5l_Corner_1.vss sg13_hv_nmos ad=1.408p pd=5.04u as=2.596p ps=5.58u w=4.4u l=0.6u
M2853 sg13cmos5l_IOPadAnalog_11.pad a_164624_118044# sg13cmos5l_Corner_1.iovdd sg13cmos5l_Corner_1.iovdd sg13_hv_pmos ad=3.9294p pd=7.84u as=3.1302p ps=14.26u w=6.66u l=0.6u
M2854 vddr adc8b_0.sar12b_0.nl_sw[5] adc8b_0.side_cap8b_1.buf_8_4.z vddr sg13_lv_pmos ad=0.19p pd=1.38u as=0.19p ps=1.38u w=1u l=0.13u
M2855 vddr adc8b_0.sar12b_0.nh_sw[1] adc8b_0.side_cap8b_1.buf_16_3.z vddr sg13_lv_pmos ad=0.19p pd=1.38u as=0.19p ps=1.38u w=1u l=0.13u
M2856 vdd adc8b_0.sar12b_0.sg13cmos5l_inv_1_7.A a_94000_99596# vdd sg13_lv_pmos ad=0.2114p pd=1.54u as=0.2856p ps=2.36u w=0.84u l=0.13u
M2857 sg13cmos5l_Corner_1.vss vdd sg13cmos5l_Corner_1.vss sg13cmos5l_Corner_1.vss sg13_lv_nmos ad=79.8f pd=0.8u as=0 ps=0 w=0.42u l=1u
M2858 a_97006_98847# adc8b_0.sar12b_0.sg13cmos5l_dfrbp_1_6.RESET_B sg13cmos5l_Corner_1.vss sg13cmos5l_Corner_1.vss sg13_lv_nmos ad=37.8f pd=0.6u as=0.1701p ps=1.65u w=0.42u l=0.13u
M2859 adc8b_0.sar12b_0.sg13cmos5l_buf_1_101.X a_98032_100384# sg13cmos5l_Corner_1.vss sg13cmos5l_Corner_1.vss sg13_lv_nmos ad=0.2886p pd=2.26u as=0.14875p ps=1.16u w=0.74u l=0.13u
M2860 a_89006_98834# a_89811_98956# a_89266_99057# vdd sg13_lv_pmos ad=0.1428p pd=1.52u as=79.8f ps=0.8u w=0.42u l=0.13u
M2861 adc8b_0.side_cap8b_0.buf_16_1.z adc8b_0.side_cap8b_0.in_l_sw[2] sg13cmos5l_Corner_1.vss sg13cmos5l_Corner_1.vss sg13_lv_nmos ad=95f pd=0.88u as=95f ps=0.88u w=0.5u l=0.13u
M2862 vdd a_85367_94375# a_86204_94596# vdd sg13_lv_pmos ad=0.2128p pd=1.5u as=0.3864p ps=2.93u w=1.12u l=0.13u
M2863 a_95026_94521# a_95469_94277# a_94766_94298# sg13cmos5l_Corner_1.vss sg13_lv_nmos ad=79.8f pd=0.8u as=0.1296p ps=1.52u w=0.42u l=0.13u
M2864 a_92201_92812# adc8b_0.sar12b_0.sg13cmos5l_dlhr_1_0.D adc8b_0.sar12b_0.sg13cmos5l_a22oi_1_2.B1 sg13cmos5l_Corner_1.vss sg13_lv_nmos ad=0.1406p pd=1.12u as=0.1406p ps=1.12u w=0.74u l=0.13u
M2865 a_94744_93790# adc8b_0.sar12b_0.sg13cmos5l_dfrbp_1_0.RESET_B vdd vdd sg13_lv_pmos ad=79.8f pd=0.8u as=1.777p ps=11.395u w=0.42u l=0.13u
M2866 vdd adc8b_0.sar12b_0.sg13cmos5l_inv_1_29.A a_94609_98888# vdd sg13_lv_pmos ad=1.15047p pd=7.175u as=0.2856p ps=2.36u w=0.84u l=0.13u
M2867 sg13cmos5l_Corner_1.vss adc8b_0.sar12b_0.sg13cmos5l_dfrbp_1_21.Q a_100177_96930# sg13cmos5l_Corner_1.vss sg13_lv_nmos ad=0.15055p pd=1.17u as=0.187p ps=1.78u w=0.55u l=0.13u
M2868 vddr adc8b_0.side_cap8b_0.in_h_sw[3] adc8b_0.side_cap8b_0.buf_8_3.z vddr sg13_lv_pmos ad=0.19p pd=1.38u as=0.19p ps=1.38u w=1u l=0.13u
M2869 vdd a_84500_100310# adc8b_0.sar12b_0.sg13cmos5l_buf_1_61.X vdd sg13_lv_pmos ad=0.2114p pd=1.54u as=0.42p ps=2.99u w=1.12u l=0.13u
M2870 adc8b_0.sar12b_0.sg13cmos5l_buf_1_104.A adc8b_0.sar12b_0.sg13cmos5l_buf_1_3.A sg13cmos5l_Corner_1.vss sg13cmos5l_Corner_1.vss sg13_lv_nmos ad=0.2516p pd=2.16u as=0.2516p ps=2.16u w=0.74u l=0.13u
M2871 a_99684_99998# a_99135_99954# a_99548_99596# sg13cmos5l_Corner_1.vss sg13_lv_nmos ad=47.25f pd=0.645u as=0.141p ps=1.17u w=0.42u l=0.13u
M2872 a_92076_99152# a_92050_99057# sg13cmos5l_Corner_1.vss sg13cmos5l_Corner_1.vss sg13_lv_nmos ad=0.2516p pd=2.16u as=0.1626p ps=1.415u w=0.74u l=0.13u
M2873 vdd a_100131_95430# adc8b_0.sar12b_0.sg13cmos5l_or2_1_0.A vdd sg13_lv_pmos ad=0.2128p pd=1.5u as=0.2128p ps=1.5u w=1.12u l=0.13u
M2874 adc8b_0.side_cap8b_1.buf_16_0.z adc8b_0.sar12b_0.nh_sw[2] sg13cmos5l_Corner_1.vss sg13cmos5l_Corner_1.vss sg13_lv_nmos ad=95f pd=0.88u as=95f ps=0.88u w=0.5u l=0.13u
M2875 a_89656_96030# a_89399_95887# a_89818_95810# sg13cmos5l_Corner_1.vss sg13_lv_nmos ad=0.1428p pd=1.52u as=37.8f ps=0.6u w=0.42u l=0.13u
M2876 sg13cmos5l_Corner_1.vss adc8b_0.sar12b_0.nh_sw[0] adc8b_0.side_cap8b_1.buf_32_1.z sg13cmos5l_Corner_1.vss sg13_lv_nmos ad=95f pd=0.88u as=95f ps=0.88u w=0.5u l=0.13u
M2877 vdd adc8b_0.sar12b_0.sg13cmos5l_dfrbp_1_16.Q a_85393_98442# vdd sg13_lv_pmos ad=1.07253p pd=6.75u as=0.2856p ps=2.36u w=0.84u l=0.13u
M2878 sg13cmos5l_Corner_1.vss adc8b_0.sar12b_0.sg13cmos5l_inv_1_1.A adc8b_0.sar12b_0.sg13cmos5l_buf_1_2.A sg13cmos5l_Corner_1.vss sg13_lv_nmos ad=0.2516p pd=2.16u as=0.2516p ps=2.16u w=0.74u l=0.13u
M2879 sg13cmos5l_Corner_1.vss a_178296_70044# sg13cmos5l_IOPadAnalog_1.pad sg13cmos5l_Corner_1.vss sg13_hv_nmos ad=2.068p pd=9.74u as=2.596p ps=5.58u w=4.4u l=0.6u
M2880 sg13cmos5l_Corner_1.vss a_96063_98442# a_96194_98448# sg13cmos5l_Corner_1.vss sg13_lv_nmos ad=1.49685p pd=9.6u as=0.2775p ps=2.23u w=0.74u l=0.13u
M2881 sg13cmos5l_Corner_1.vss adc8b_0.sar12b_0.sg13cmos5l_inv_1_8.A adc8b_0.sar12b_0.sg13cmos5l_inv_1_8.Y sg13cmos5l_Corner_1.vss sg13_lv_nmos ad=0.2516p pd=2.16u as=0.2516p ps=2.16u w=0.74u l=0.13u
M2882 a_84599_98790# adc8b_0.sar12b_0.sg13cmos5l_dfrbp_1_16.Q_N vdd vdd sg13_lv_pmos ad=0.2856p pd=2.36u as=1.15047p ps=7.175u w=0.84u l=0.13u
M2883 sg13cmos5l_Corner_1.vss a_98296_99054# a_97945_98911# sg13cmos5l_Corner_1.vss sg13_lv_nmos ad=79.8f pd=0.8u as=0.1428p ps=1.52u w=0.42u l=0.13u
M2884 a_84148_97322# a_83765_97286# vdd vdd sg13_lv_pmos ad=79.8f pd=0.8u as=0.2639p ps=1.81u w=0.42u l=0.13u
M2885 sg13cmos5l_Corner_1.iovdd a_164624_118044# sg13cmos5l_IOPadAnalog_11.pad sg13cmos5l_Corner_1.iovdd sg13_hv_pmos ad=2.1312p pd=7.3u as=3.9294p ps=7.84u w=6.66u l=0.6u
X2886 sg13cmos5l_IOPadAnalog_13.pad sg13cmos5l_IOPadAnalog_13.padres sg13cmos5l_Corner_1.vss rppd l=2u w=1u
M2887 sg13cmos5l_Corner_1.vss sg13cmos5l_IOPadVdd$1_0.sg13cmos5l_Clamp_N43N43D4R$1_0.gate vdd sg13cmos5l_Corner_1.vss sg13_hv_nmos ad=1.408p pd=5.04u as=2.596p ps=5.58u w=4.4u l=0.6u
M2888 adc8b_0.side_cap8b_0.buf_16_3.z adc8b_0.side_cap8b_0.in_h_sw[1] vddr vddr sg13_lv_pmos ad=0.34p pd=2.68u as=0.19p ps=1.38u w=1u l=0.13u
M2889 sg13cmos5l_Corner_1.vss a_90801_97322# a_91326_97304# sg13cmos5l_Corner_1.vss sg13_lv_nmos ad=0.1491p pd=1.18u as=0.187p ps=1.78u w=0.55u l=0.13u
M2890 a_82774_95327# a_82889_95326# sg13cmos5l_Corner_1.vss sg13cmos5l_Corner_1.vss sg13_lv_nmos ad=0.1428p pd=1.52u as=0.1426p ps=1.16u w=0.42u l=0.5u
M2891 sg13cmos5l_IOPadAnalog_15.pad a_99639_164698# sg13cmos5l_Corner_1.iovdd sg13cmos5l_Corner_1.iovdd sg13_hv_pmos ad=3.9294p pd=7.84u as=2.1312p ps=7.3u w=6.66u l=0.6u
M2892 sg13cmos5l_IOPadAnalog_13.pad a_115639_164698# sg13cmos5l_Corner_1.iovdd sg13cmos5l_Corner_1.iovdd sg13_hv_pmos ad=3.9294p pd=7.84u as=2.1312p ps=7.3u w=6.66u l=0.6u
M2893 vdd adc8b_0.sar12b_0.sg13cmos5l_dfrbp_1_6.RESET_B a_82190_98522# vdd sg13_lv_pmos ad=0.36237p pd=2.605u as=79.8f ps=0.8u w=0.42u l=0.13u
M2894 vddr adc8b_0.sar12b_0.nl_sw[0] adc8b_0.side_cap8b_1.buf_32_0.z vddr sg13_lv_pmos ad=0.19p pd=1.38u as=0.19p ps=1.38u w=1u l=0.13u
M2895 vdd adc8b_0.sar12b_0.sg13cmos5l_dfrbp_1_6.RESET_B a_89265_94298# vdd sg13_lv_pmos ad=0.2128p pd=1.5u as=0.2128p ps=1.5u w=1.12u l=0.13u
M2896 a_98708_94262# adc8b_0.sar12b_0.sg13cmos5l_buf_1_4.X sg13cmos5l_Corner_1.vss sg13cmos5l_Corner_1.vss sg13_lv_nmos ad=0.187p pd=1.78u as=0.14875p ps=1.16u w=0.55u l=0.13u
M2897 a_83735_98445# a_82893_98095# a_82476_98088# vdd sg13_lv_pmos ad=0.2048p pd=1.63u as=0.34p ps=2.68u w=1u l=0.13u
M2898 adc8b_0.side_cap8b_1.buf_16_0.z adc8b_0.sar12b_0.nh_sw[2] vddr vddr sg13_lv_pmos ad=0.19p pd=1.38u as=0.19p ps=1.38u w=1u l=0.13u
M2899 adc8b_0.sar12b_0.sg13cmos5l_buf_1_34.A a_85809_93905# vdd vdd sg13_lv_pmos ad=0.3808p pd=2.92u as=0.2128p ps=1.5u w=1.12u l=0.13u
M2900 a_95288_95856# adc8b_0.sar12b_0.sg13cmos5l_inv_1_0.A a_95186_95856# sg13cmos5l_Corner_1.vss sg13_lv_nmos ad=0.1216p pd=1.02u as=0.1216p ps=1.02u w=0.64u l=0.13u
M2901 sg13cmos5l_Corner_1.iovdd a_83639_164698# sg13cmos5l_IOPadAnalog_9.pad sg13cmos5l_Corner_1.iovdd sg13_hv_pmos ad=2.1312p pd=7.3u as=3.9294p ps=7.84u w=6.66u l=0.6u
M2902 sg13cmos5l_Corner_1.vss sg13cmos5l_IOPadVdd$1_0.sg13cmos5l_Clamp_N43N43D4R$1_0.gate vdd sg13cmos5l_Corner_1.vss sg13_hv_nmos ad=1.408p pd=5.04u as=2.596p ps=5.58u w=4.4u l=0.6u
M2903 sg13cmos5l_Corner_1.vss a_30676_118044# cks sg13cmos5l_Corner_1.vss sg13_hv_nmos ad=1.408p pd=5.04u as=2.596p ps=5.58u w=4.4u l=0.6u
M2904 sg13cmos5l_Corner_1.iovdd a_42476_102044# vip sg13cmos5l_Corner_1.iovdd sg13_hv_pmos ad=2.1312p pd=7.3u as=3.9294p ps=7.84u w=6.66u l=0.6u
M2905 sg13cmos5l_Corner_1.vss adc8b_0.side_cap8b_0.in_h_sw[2] adc8b_0.side_cap8b_0.buf_16_0.z sg13cmos5l_Corner_1.vss sg13_lv_nmos ad=95f pd=0.88u as=95f ps=0.88u w=0.5u l=0.13u
M2906 vdd adc8b_0.sar12b_0.sg13cmos5l_dfrbp_1_21.Q a_100177_96930# vdd sg13_lv_pmos ad=1.28962p pd=8.195u as=0.2856p ps=2.36u w=0.84u l=0.13u
X2907 sg13cmos5l_IOPadAnalog_0.padres sg13cmos5l_IOPadAnalog_0.pad sg13cmos5l_Corner_1.vss rppd l=2u w=1u
M2908 a_83735_96933# a_82893_96583# a_83641_96933# sg13cmos5l_Corner_1.vss sg13_lv_nmos ad=0.12665p pd=1.145u as=0.1428p ps=1.52u w=0.42u l=0.13u
M2909 a_85764_93950# a_85215_93906# a_85628_93548# sg13cmos5l_Corner_1.vss sg13_lv_nmos ad=47.25f pd=0.645u as=0.141p ps=1.17u w=0.42u l=0.13u
M2910 vdd sg13cmos5l_Corner_1.vss vdd vdd sg13_lv_pmos ad=0.34p pd=2.68u as=0 ps=0 w=1u l=1u
M2911 sg13cmos5l_IOPadAnalog_11.pad a_164624_118044# sg13cmos5l_Corner_1.iovdd sg13cmos5l_Corner_1.iovdd sg13_hv_pmos ad=3.9294p pd=7.84u as=2.1312p ps=7.3u w=6.66u l=0.6u
M2912 vin a_30676_86044# sg13cmos5l_Corner_1.vss sg13cmos5l_Corner_1.vss sg13_hv_nmos ad=2.596p pd=5.58u as=1.408p ps=5.04u w=4.4u l=0.6u
M2913 adc8b_0.sar12b_0.sg13cmos5l_dlhr_1_14.Q_N a_95934_98816# sg13cmos5l_Corner_1.vss sg13cmos5l_Corner_1.vss sg13_lv_nmos ad=0.2516p pd=2.16u as=0.1491p ps=1.18u w=0.74u l=0.13u
M2914 a_97180_96960# a_96764_96572# a_96945_96929# sg13cmos5l_Corner_1.vss sg13_lv_nmos ad=77.7f pd=0.95u as=0.2516p ps=2.16u w=0.74u l=0.13u
M2915 adc8b_0.side_cap8b_1.buf_8_0.z adc8b_0.sar12b_0.nl_sw[4] vddr vddr sg13_lv_pmos ad=0.19p pd=1.38u as=0.19p ps=1.38u w=1u l=0.13u
M2916 sg13cmos5l_Corner_1.vss adc8b_0.side_cap8b_0.in_h_sw[7] adc8b_0.side_cap8b_0.buf_4_2.z sg13cmos5l_Corner_1.vss sg13_lv_nmos ad=95f pd=0.88u as=0.17p ps=1.68u w=0.5u l=0.13u
M2917 adc8b_0.sar12b_0.sg13cmos5l_dfrbp_1_8.Q_N a_98903_95887# vdd vdd sg13_lv_pmos ad=0.4312p pd=3.01u as=0.2639p ps=1.81u w=1.12u l=0.13u
M2918 vddr adc8b_0.sar12b_0.nl_sw[0] adc8b_0.side_cap8b_1.buf_32_0.z vddr sg13_lv_pmos ad=0.19p pd=1.38u as=0.19p ps=1.38u w=1u l=0.13u
X2919 sg13cmos5l_Corner_1.vss a_99639_178370# sg13cmos5l_Corner_1.vss rppd l=3.54u w=0.5u
M2920 sg13cmos5l_Corner_1.vss a_134044_30676# frame sg13cmos5l_Corner_1.vss sg13_hv_nmos ad=2.068p pd=9.74u as=2.596p ps=5.58u w=4.4u l=0.6u
M2921 sg13cmos5l_Corner_1.vss a_134044_30676# frame sg13cmos5l_Corner_1.vss sg13_hv_nmos ad=1.408p pd=5.04u as=2.596p ps=5.58u w=4.4u l=0.6u
M2922 sg13cmos5l_Corner_1.vss adc8b_0.side_cap8b_0.in_l_sw[0] adc8b_0.side_cap8b_0.buf_32_0.z sg13cmos5l_Corner_1.vss sg13_lv_nmos ad=95f pd=0.88u as=95f ps=0.88u w=0.5u l=0.13u
M2923 vddr adc8b_0.side_cap8b_0.in_l_sw[5] adc8b_0.side_cap8b_0.buf_8_4.z vddr sg13_lv_pmos ad=0.19p pd=1.38u as=0.34p ps=2.68u w=1u l=0.13u
M2924 sg13cmos5l_Corner_1.vss a_86193_98441# a_86718_98514# sg13cmos5l_Corner_1.vss sg13_lv_nmos ad=0.1491p pd=1.18u as=0.187p ps=1.78u w=0.55u l=0.13u
M2925 vdd adc8b_0.sar12b_0.sg13cmos5l_buf_8_1.A a_100131_95430# vdd sg13_lv_pmos ad=0.2128p pd=1.5u as=0.2128p ps=1.5u w=1.12u l=0.13u
M2926 sg13cmos5l_Corner_1.vss adc8b_0.sar12b_0.sg13cmos5l_dfrbp_1_6.RESET_B a_87676_94284# sg13cmos5l_Corner_1.vss sg13_lv_nmos ad=0.1406p pd=1.12u as=77.7f ps=0.95u w=0.74u l=0.13u
M2927 a_101780_92750# adc8b_0.sar12b_0.sg13cmos5l_buf_1_0.A vdd vdd sg13_lv_pmos ad=0.2856p pd=2.36u as=0.2114p ps=1.54u w=0.84u l=0.13u
M2928 a_94126_100359# adc8b_0.sar12b_0.sg13cmos5l_dfrbp_1_8.RESET_B sg13cmos5l_Corner_1.vss sg13cmos5l_Corner_1.vss sg13_lv_nmos ad=37.8f pd=0.6u as=0.1701p ps=1.65u w=0.42u l=0.13u
M2929 adc8b_0.sar12b_0.sg13cmos5l_dfrbp_1_21.Q a_100124_97620# vdd vdd sg13_lv_pmos ad=0.3808p pd=2.92u as=0.2128p ps=1.5u w=1.12u l=0.13u
M2930 a_72090_94286# adc8b_0.diff_bsw_0.single_bsw_1.sg13cmos5l_inv_1$1_2.Y w_71686_95000# w_71686_95000# sg13_lv_pmos ad=0.17p pd=1.68u as=0.17p ps=1.68u w=0.5u l=0.13u
M2931 sg13cmos5l_Corner_1.iovdd a_164624_102044# sg13cmos5l_IOPadAnalog_16.pad sg13cmos5l_Corner_1.iovdd sg13_hv_pmos ad=2.1312p pd=7.3u as=3.9294p ps=7.84u w=6.66u l=0.6u
M2932 a_74586_95659# adc8b_0.cmp_0.clk sg13cmos5l_Corner_1.vss sg13cmos5l_Corner_1.vss sg13_lv_nmos ad=95f pd=0.88u as=95f ps=0.88u w=0.5u l=0.13u
M2933 sg13cmos5l_Corner_1.iovdd a_86044_42476# data[1] sg13cmos5l_Corner_1.iovdd sg13_hv_pmos ad=2.1312p pd=7.3u as=3.9294p ps=7.84u w=6.66u l=0.6u
M2934 adc8b_0.side_cap8b_0.buf_16_2.z adc8b_0.side_cap8b_0.in_l_sw[1] vddr vddr sg13_lv_pmos ad=0.19p pd=1.38u as=0.19p ps=1.38u w=1u l=0.13u
M2935 a_94484_99560# adc8b_0.sar12b_0.sg13cmos5l_buf_1_79.X vdd vdd sg13_lv_pmos ad=0.2856p pd=2.36u as=0.2114p ps=1.54u w=0.84u l=0.13u
M2936 sg13cmos5l_Corner_1.iovdd a_42476_118044# cks sg13cmos5l_Corner_1.iovdd sg13_hv_pmos ad=2.1312p pd=7.3u as=3.9294p ps=7.84u w=6.66u l=0.6u
M2937 vddr adc8b_0.side_cap8b_0.in_l_sw[0] adc8b_0.side_cap8b_0.buf_32_0.z vddr sg13_lv_pmos ad=0.19p pd=1.38u as=0.19p ps=1.38u w=1u l=0.13u
M2938 adc8b_0.side_cap8b_0.buf_16_0.z adc8b_0.side_cap8b_0.in_h_sw[2] vddr vddr sg13_lv_pmos ad=0.19p pd=1.38u as=0.19p ps=1.38u w=1u l=0.13u
M2939 adc8b_0.side_cap8b_1.buf_8_1.z adc8b_0.sar12b_0.nl_sw[3] vddr vddr sg13_lv_pmos ad=0.34p pd=2.68u as=0.19p ps=1.38u w=1u l=0.13u
M2940 a_88820_100310# adc8b_0.sar12b_0.sg13cmos5l_inv_1_14.A vdd vdd sg13_lv_pmos ad=0.2856p pd=2.36u as=0.2114p ps=1.54u w=0.84u l=0.13u
M2941 vdd adc8b_0.cmp_0.clk adc8b_0.cmp_0.outn vdd sg13_lv_pmos ad=95f pd=0.88u as=0.17p ps=1.68u w=0.5u l=0.13u
M2942 adc8b_0.sar12b_0.sg13cmos5l_a22oi_1_2.B2 adc8b_0.sar12b_0.sg13cmos5l_a221oi_1_0.C1 a_92188_96920# sg13cmos5l_Corner_1.vss sg13_lv_nmos ad=0.2516p pd=2.16u as=0.1406p ps=1.12u w=0.74u l=0.13u
M2943 sg13cmos5l_Corner_1.vss adc8b_0.sar12b_0.sg13cmos5l_nor2_1_0.A adc8b_0.sar12b_0.sg13cmos5l_a221oi_1_0.C1 sg13cmos5l_Corner_1.vss sg13_lv_nmos ad=0.2516p pd=2.16u as=0.1406p ps=1.12u w=0.74u l=0.13u
M2944 vdd sg13cmos5l_IOPadVdd$1_0.sg13cmos5l_Clamp_N43N43D4R$1_0.gate sg13cmos5l_Corner_1.vss sg13cmos5l_Corner_1.vss sg13_hv_nmos ad=2.596p pd=5.58u as=1.408p ps=5.04u w=4.4u l=0.6u
M2945 vdd sg13cmos5l_IOPadVdd$1_0.sg13cmos5l_RCClampInverter$1_0.in sg13cmos5l_IOPadVdd$1_0.sg13cmos5l_Clamp_N43N43D4R$1_0.gate vdd sg13_hv_pmos ad=1.33p pd=7.38u as=1.33p ps=7.38u w=7u l=0.5u
M2946 vdd sg13cmos5l_Corner_1.vss vdd vdd sg13_lv_pmos ad=0.19p pd=1.38u as=0 ps=0 w=1u l=1u
X2947 sg13cmos5l_IOPadAnalog_9.pad sg13cmos5l_IOPadAnalog_9.padres sg13cmos5l_Corner_1.vss rppd l=2u w=1u
M2948 vdd sg13cmos5l_Corner_1.vss vdd vdd sg13_lv_pmos ad=0.19p pd=1.38u as=0 ps=0 w=1u l=1u
X2949 vddr sg13cmos5l_Corner_1.iovdd dpantenna l=27.78u w=1.26u
M2950 vddr adc8b_0.side_cap8b_0.in_l_sw[2] adc8b_0.side_cap8b_0.buf_16_1.z vddr sg13_lv_pmos ad=0.19p pd=1.38u as=0.19p ps=1.38u w=1u l=0.13u
M2951 vdd adc8b_0.sar12b_0.sg13cmos5l_buf_8_1.A a_98471_95031# vdd sg13_lv_pmos ad=1.43437p pd=9.105u as=0.4088p ps=2.97u w=1.12u l=0.13u
M2952 sg13cmos5l_IOPadAnalog_10.pad a_67639_164698# sg13cmos5l_Corner_1.iovdd sg13cmos5l_Corner_1.iovdd sg13_hv_pmos ad=3.9294p pd=7.84u as=2.1312p ps=7.3u w=6.66u l=0.6u
M2953 a_97207_92790# a_97125_92976# adc8b_0.sar12b_0.sg13cmos5l_nand2_1_1.B sg13cmos5l_Corner_1.vss sg13_lv_nmos ad=0.1406p pd=1.12u as=0.333p ps=2.38u w=0.74u l=0.13u
M2954 vdd a_99284_100310# adc8b_0.side_cap8b_0.in_l_sw[8] vdd sg13_lv_pmos ad=0.2114p pd=1.54u as=0.42p ps=2.99u w=1.12u l=0.13u
M2955 a_80694_96641# a_80424_96641# vdd vdd sg13_lv_pmos ad=0.34p pd=2.68u as=0.1523p ps=1.38u w=1u l=0.5u
M2956 a_85164_95810# adc8b_0.sar12b_0.sg13cmos5l_dfrbp_1_9.Q a_85070_95810# sg13cmos5l_Corner_1.vss sg13_lv_nmos ad=60.89999f pd=0.71u as=0.1428p ps=1.52u w=0.42u l=0.13u
M2957 vdd adc8b_0.sar12b_0.sg13cmos5l_a22oi_1_1.A1 a_96582_95036# vdd sg13_lv_pmos ad=0.3808p pd=2.92u as=0.2716p ps=1.605u w=1.12u l=0.13u
M2958 adc8b_0.side_cap8b_1.buf_4_2.z adc8b_0.sar12b_0.nh_sw[7] vddr vddr sg13_lv_pmos ad=0.19p pd=1.38u as=0.19p ps=1.38u w=1u l=0.13u
M2959 adc8b_0.side_cap8b_1.buf_32_0.z adc8b_0.sar12b_0.nl_sw[0] sg13cmos5l_Corner_1.vss sg13cmos5l_Corner_1.vss sg13_lv_nmos ad=95f pd=0.88u as=95f ps=0.88u w=0.5u l=0.13u
M2960 a_93681_93177# a_93324_93104# vdd vdd sg13_lv_pmos ad=63f pd=0.72u as=0.1563p ps=1.22u w=0.42u l=0.13u
M2961 vdd a_89709_98813# a_89811_98956# vdd sg13_lv_pmos ad=1.15047p pd=7.175u as=0.3864p ps=2.93u w=1.12u l=0.13u
M2962 a_100342_96188# adc8b_0.sar12b_0.sg13cmos5l_dfrbp_1_0.D a_100248_96188# vdd sg13_lv_pmos ad=0.1596p pd=1.22u as=0.2856p ps=2.36u w=0.84u l=0.13u
M2963 sg13cmos5l_Corner_1.iovdd a_99639_164698# sg13cmos5l_IOPadAnalog_15.pad sg13cmos5l_Corner_1.iovdd sg13_hv_pmos ad=2.1312p pd=7.3u as=3.9294p ps=7.84u w=6.66u l=0.6u
M2964 a_71988_94286# adc8b_0.diff_bsw_0.single_bsw_1.sg13cmos5l_inv_1$1_0.A sg13cmos5l_Corner_1.vss sg13cmos5l_Corner_1.vss sg13_lv_nmos ad=95f pd=0.88u as=0.17p ps=1.68u w=0.5u l=0.13u
M2965 vdd a_100727_94375# a_100984_94518# vdd sg13_lv_pmos ad=0.2639p pd=1.81u as=79.8f ps=0.8u w=0.42u l=0.13u
M2966 sg13cmos5l_Corner_1.vss a_96311_94375# a_97148_94596# sg13cmos5l_Corner_1.vss sg13_lv_nmos ad=0.1406p pd=1.12u as=0.2516p ps=2.16u w=0.74u l=0.13u
M2967 sg13cmos5l_Corner_1.iovdd a_115639_164698# sg13cmos5l_IOPadAnalog_13.pad sg13cmos5l_Corner_1.iovdd sg13_hv_pmos ad=3.1302p pd=14.26u as=3.9294p ps=7.84u w=6.66u l=0.6u
X2968 sg13cmos5l_IOPadAnalog_12.padres sg13cmos5l_Corner_1.iovdd dpantenna l=0.64u w=4.98u
M2969 a_90514_99564# a_90957_99607# a_90897_99643# vdd sg13_lv_pmos ad=79.8f pd=0.8u as=63f ps=0.72u w=0.42u l=0.13u
M2970 adc8b_0.sar12b_0.sg13cmos5l_dfrbp_1_0.D adc8b_0.sar12b_0.sg13cmos5l_dfrbp_1_0.Q a_99890_93548# vdd sg13_lv_pmos ad=0.3808p pd=2.92u as=0.1176p ps=1.33u w=1.12u l=0.13u
M2971 sg13cmos5l_Corner_1.vss a_70044_30676# data[0] sg13cmos5l_Corner_1.vss sg13_hv_nmos ad=1.408p pd=5.04u as=2.596p ps=5.58u w=4.4u l=0.6u
M2972 sg13cmos5l_Corner_1.vss a_70044_30676# data[0] sg13cmos5l_Corner_1.vss sg13_hv_nmos ad=2.068p pd=9.74u as=2.596p ps=5.58u w=4.4u l=0.6u
M2973 sg13cmos5l_Corner_1.vss adc8b_0.sar12b_0.nh_sw[4] adc8b_0.side_cap8b_1.buf_8_2.z sg13cmos5l_Corner_1.vss sg13_lv_nmos ad=95f pd=0.88u as=95f ps=0.88u w=0.5u l=0.13u
M2974 sg13cmos5l_Corner_1.iovdd a_42476_102044# vip sg13cmos5l_Corner_1.iovdd sg13_hv_pmos ad=2.1312p pd=7.3u as=3.9294p ps=7.84u w=6.66u l=0.6u
M2975 adc8b_0.side_cap8b_1.buf_16_1.z adc8b_0.sar12b_0.nl_sw[2] vddr vddr sg13_lv_pmos ad=0.19p pd=1.38u as=0.19p ps=1.38u w=1u l=0.13u
M2976 sg13cmos5l_Corner_1.vss sg13cmos5l_IOPadVdd$1_0.sg13cmos5l_Clamp_N43N43D4R$1_0.gate vdd sg13cmos5l_Corner_1.vss sg13_hv_nmos ad=2.068p pd=9.74u as=2.596p ps=5.58u w=4.4u l=0.6u
X2977 sg13cmos5l_IOPadAnalog_11.pad sg13cmos5l_Corner_1.iovdd dpantenna l=27.78u w=1.26u
M2978 adc8b_0.side_cap8b_1.buf_4_0.z adc8b_0.sar12b_0.nl_sw[7] sg13cmos5l_Corner_1.vss sg13cmos5l_Corner_1.vss sg13_lv_nmos ad=95f pd=0.88u as=95f ps=0.88u w=0.5u l=0.13u
M2979 sg13cmos5l_Corner_1.vss adc8b_0.side_cap8b_0.in_h_sw[5] adc8b_0.side_cap8b_0.buf_8_5.z sg13cmos5l_Corner_1.vss sg13_lv_nmos ad=95f pd=0.88u as=0.17p ps=1.68u w=0.5u l=0.13u
M2980 sg13cmos5l_Corner_1.vss adc8b_0.sar12b_0.sg13cmos5l_buf_1_24.A adc8b_0.sar12b_0.sg13cmos5l_buf_1_78.A sg13cmos5l_Corner_1.vss sg13_lv_nmos ad=0.2516p pd=2.16u as=0.2516p ps=2.16u w=0.74u l=0.13u
M2981 sg13cmos5l_IOPadAnalog_0.pad a_164624_86044# sg13cmos5l_Corner_1.iovdd sg13cmos5l_Corner_1.iovdd sg13_hv_pmos ad=3.9294p pd=7.84u as=2.1312p ps=7.3u w=6.66u l=0.6u
M2982 sg13cmos5l_IOPadAnalog_15.pad a_99639_164698# sg13cmos5l_Corner_1.iovdd sg13cmos5l_Corner_1.iovdd sg13_hv_pmos ad=3.9294p pd=7.84u as=2.1312p ps=7.3u w=6.66u l=0.6u
M2983 sg13cmos5l_Corner_1.vss adc8b_0.side_cap8b_0.in_h_sw[1] adc8b_0.side_cap8b_0.buf_16_3.z sg13cmos5l_Corner_1.vss sg13_lv_nmos ad=95f pd=0.88u as=95f ps=0.88u w=0.5u l=0.13u
M2984 sg13cmos5l_Corner_1.iovdd a_134044_42476# frame sg13cmos5l_Corner_1.iovdd sg13_hv_pmos ad=2.1312p pd=7.3u as=3.9294p ps=7.84u w=6.66u l=0.6u
M2985 a_89292_99152# a_89811_98956# a_90551_98911# sg13cmos5l_Corner_1.vss sg13_lv_nmos ad=0.3473p pd=2.71u as=0.12665p ps=1.145u w=0.74u l=0.13u
M2986 vin a_72090_94286# adc8b_0.diff_bsw_0.vcn sg13cmos5l_Corner_1.vss sg13_lv_nmos ad=0.85p pd=5.68u as=0.85p ps=5.68u w=2.5u l=0.13u
M2987 sg13cmos5l_Corner_1.iovdd a_164624_86044# sg13cmos5l_IOPadAnalog_0.pad sg13cmos5l_Corner_1.iovdd sg13_hv_pmos ad=2.1312p pd=7.3u as=3.9294p ps=7.84u w=6.66u l=0.6u
M2988 vddr adc8b_0.side_cap8b_0.in_h_sw[1] adc8b_0.side_cap8b_0.buf_16_3.z vddr sg13_lv_pmos ad=0.19p pd=1.38u as=0.19p ps=1.38u w=1u l=0.13u
M2989 adc8b_0.side_cap8b_0.in_h_sw[2] a_85744_100384# sg13cmos5l_Corner_1.vss sg13cmos5l_Corner_1.vss sg13_lv_nmos ad=0.2886p pd=2.26u as=0.14875p ps=1.16u w=0.74u l=0.13u
M2990 adc8b_0.sar12b_0.sg13cmos5l_a22oi_1_1.B2 adc8b_0.sar12b_0.sg13cmos5l_and3_1_0.X sg13cmos5l_Corner_1.vss sg13cmos5l_Corner_1.vss sg13_lv_nmos ad=0.2516p pd=2.16u as=0.1406p ps=1.12u w=0.74u l=0.13u
M2991 sg13cmos5l_IOPadAnalog_1.pad a_178296_70044# sg13cmos5l_Corner_1.vss sg13cmos5l_Corner_1.vss sg13_hv_nmos ad=2.596p pd=5.58u as=1.408p ps=5.04u w=4.4u l=0.6u
X2992 sg13cmos5l_Corner_1.vss a_173384_129782# dantenna l=1.26u w=27.78u
M2993 adc8b_0.sar12b_0.sg13cmos5l_buf_1_30.X a_90448_92824# sg13cmos5l_Corner_1.vss sg13cmos5l_Corner_1.vss sg13_lv_nmos ad=0.2886p pd=2.26u as=0.14875p ps=1.16u w=0.74u l=0.13u
M2994 adc8b_0.sar12b_0.nl_sw[3] a_86224_92824# vdd vdd sg13_lv_pmos ad=0.42p pd=2.99u as=0.2114p ps=1.54u w=1.12u l=0.13u
M2995 a_84333_99607# adc8b_0.sar12b_0.sg13cmos5l_inv_1_8.A sg13cmos5l_Corner_1.vss sg13cmos5l_Corner_1.vss sg13_lv_nmos ad=0.2516p pd=2.16u as=2.71505p ps=17.54u w=0.74u l=0.13u
M2996 a_98062_98509# adc8b_0.sar12b_0.sg13cmos5l_dfrbp_1_8.RESET_B sg13cmos5l_Corner_1.vss sg13cmos5l_Corner_1.vss sg13_lv_nmos ad=37.8f pd=0.6u as=0.1701p ps=1.65u w=0.42u l=0.13u
M2997 a_82978_95814# adc8b_0.sar12b_0.sg13cmos5l_inv_1_8.Y adc8b_0.sar12b_0.sg13cmos5l_dlygate4sd2_1_0.A sg13cmos5l_Corner_1.vss sg13_lv_nmos ad=0.1406p pd=1.12u as=0.2516p ps=2.16u w=0.74u l=0.13u
M2998 sg13cmos5l_IOPadAnalog_9.pad a_83639_164698# sg13cmos5l_Corner_1.iovdd sg13cmos5l_Corner_1.iovdd sg13_hv_pmos ad=3.9294p pd=7.84u as=2.1312p ps=7.3u w=6.66u l=0.6u
M2999 adc8b_0.sar12b_0.sg13cmos5l_dfrbp_1_21.Q_N a_99287_97399# vdd vdd sg13_lv_pmos ad=0.4312p pd=3.01u as=0.2639p ps=1.81u w=1.12u l=0.13u
M3000 sg13cmos5l_Corner_1.vss adc8b_0.sar12b_0.nl_sw[5] adc8b_0.side_cap8b_1.buf_8_4.z sg13cmos5l_Corner_1.vss sg13_lv_nmos ad=95f pd=0.88u as=95f ps=0.88u w=0.5u l=0.13u
M3001 vddr adc8b_0.sar12b_0.nh_sw[2] adc8b_0.side_cap8b_1.buf_16_0.z vddr sg13_lv_pmos ad=0.19p pd=1.38u as=0.19p ps=1.38u w=1u l=0.13u
M3002 vip a_42476_102044# sg13cmos5l_Corner_1.iovdd sg13cmos5l_Corner_1.iovdd sg13_hv_pmos ad=3.9294p pd=7.84u as=2.1312p ps=7.3u w=6.66u l=0.6u
M3003 a_100796_96572# a_100383_96930# a_100728_96572# vdd sg13_lv_pmos ad=0.191p pd=1.44u as=0.105p ps=1.21u w=1u l=0.13u
M3004 a_89276_93108# a_88863_92802# a_89208_93108# vdd sg13_lv_pmos ad=0.191p pd=1.44u as=0.105p ps=1.21u w=1u l=0.13u
M3005 adc8b_0.side_cap8b_0.buf_8_4.z adc8b_0.side_cap8b_0.in_l_sw[5] sg13cmos5l_Corner_1.vss sg13cmos5l_Corner_1.vss sg13_lv_nmos ad=0.17p pd=1.68u as=95f ps=0.88u w=0.5u l=0.13u
M3006 vdd sg13cmos5l_IOPadVdd$1_0.sg13cmos5l_RCClampInverter$1_0.in sg13cmos5l_IOPadVdd$1_0.sg13cmos5l_Clamp_N43N43D4R$1_0.gate vdd sg13_hv_pmos ad=1.33p pd=7.38u as=1.33p ps=7.38u w=7u l=0.5u
M3007 a_87982_100021# adc8b_0.sar12b_0.sg13cmos5l_dfrbp_1_8.RESET_B sg13cmos5l_Corner_1.vss sg13cmos5l_Corner_1.vss sg13_lv_nmos ad=37.8f pd=0.6u as=0.1701p ps=1.65u w=0.42u l=0.13u
M3008 vdd adc8b_0.sar12b_0.sg13cmos5l_dfrbp_1_0.RESET_B a_96974_93986# vdd sg13_lv_pmos ad=0.36237p pd=2.605u as=79.8f ps=0.8u w=0.42u l=0.13u
M3009 sg13cmos5l_Corner_1.iovdd a_131639_164698# sg13cmos5l_IOPadAnalog_12.pad sg13cmos5l_Corner_1.iovdd sg13_hv_pmos ad=2.1312p pd=7.3u as=3.9294p ps=7.84u w=6.66u l=0.6u
M3010 vdd a_91647_100362# a_91778_100356# vdd sg13_lv_pmos ad=4.11675p pd=27.17u as=0.2856p ps=2.36u w=0.84u l=0.13u
M3011 a_79646_97015# adc8b_0.cmp_0.sg13cmos5l_inv_1$1_1.Y a_79552_97015# vdd sg13_lv_pmos ad=0.1596p pd=1.22u as=0.2856p ps=2.36u w=0.84u l=0.13u
M3012 vdd adc8b_0.sar12b_0.sg13cmos5l_inv_1_8.A adc8b_0.sar12b_0.sg13cmos5l_inv_1_8.Y vdd sg13_lv_pmos ad=0.3808p pd=2.92u as=0.3808p ps=2.92u w=1.12u l=0.13u
M3013 adc8b_0.side_cap8b_1.buf_32_0.z adc8b_0.sar12b_0.nl_sw[0] vddr vddr sg13_lv_pmos ad=0.19p pd=1.38u as=0.19p ps=1.38u w=1u l=0.13u
M3014 vdd a_85809_93905# a_86334_93978# vdd sg13_lv_pmos ad=0.1974p pd=1.5u as=0.2856p ps=2.36u w=0.84u l=0.13u
M3015 sg13cmos5l_Corner_1.vss sg13cmos5l_IOPadVdd$1_0.sg13cmos5l_Clamp_N43N43D4R$1_0.gate vdd sg13cmos5l_Corner_1.vss sg13_hv_nmos ad=1.408p pd=5.04u as=2.596p ps=5.58u w=4.4u l=0.6u
M3016 sg13cmos5l_Corner_1.vss adc8b_0.sar12b_0.sg13cmos5l_inv_1_0.A adc8b_0.sar12b_0.sg13cmos5l_inv_1_0.Y sg13cmos5l_Corner_1.vss sg13_lv_nmos ad=0.2516p pd=2.16u as=0.2516p ps=2.16u w=0.74u l=0.13u
M3017 sg13cmos5l_Corner_1.iovdd a_67639_164698# sg13cmos5l_IOPadAnalog_10.pad sg13cmos5l_Corner_1.iovdd sg13_hv_pmos ad=2.1312p pd=7.3u as=3.9294p ps=7.84u w=6.66u l=0.6u
M3018 adc8b_0.side_cap8b_0.buf_32_0.z adc8b_0.side_cap8b_0.in_l_sw[0] sg13cmos5l_Corner_1.vss sg13cmos5l_Corner_1.vss sg13_lv_nmos ad=95f pd=0.88u as=95f ps=0.88u w=0.5u l=0.13u
M3019 adc8b_0.sar12b_0.sg13cmos5l_dlhr_1_1.Q a_84177_95810# vdd vdd sg13_lv_pmos ad=0.3808p pd=2.92u as=0.2128p ps=1.5u w=1.12u l=0.13u
M3020 adc8b_0.sar12b_0.sg13cmos5l_buf_8_0.X a_100995_95814# vdd vdd sg13_lv_pmos ad=0.2128p pd=1.5u as=0.2128p ps=1.5u w=1.12u l=0.13u
M3021 a_99180_93104# a_99154_93009# sg13cmos5l_Corner_1.vss sg13cmos5l_Corner_1.vss sg13_lv_nmos ad=0.2516p pd=2.16u as=0.1626p ps=1.415u w=0.74u l=0.13u
M3022 sg13cmos5l_Corner_1.iovdd a_83639_164698# sg13cmos5l_IOPadAnalog_9.pad sg13cmos5l_Corner_1.iovdd sg13_hv_pmos ad=3.1302p pd=14.26u as=3.9294p ps=7.84u w=6.66u l=0.6u
M3023 sg13cmos5l_Corner_1.vss a_178296_102044# sg13cmos5l_IOPadAnalog_16.pad sg13cmos5l_Corner_1.vss sg13_hv_nmos ad=1.408p pd=5.04u as=2.596p ps=5.58u w=4.4u l=0.6u
M3024 vddr adc8b_0.side_cap8b_0.in_l_sw[1] adc8b_0.side_cap8b_0.buf_16_2.z vddr sg13_lv_pmos ad=0.19p pd=1.38u as=0.19p ps=1.38u w=1u l=0.13u
M3025 a_86837_96536# a_87567_96659# a_87478_96695# vdd sg13_lv_pmos ad=0.2048p pd=1.63u as=93.45f ps=0.865u w=0.42u l=0.13u
M3026 cks a_42476_118044# sg13cmos5l_Corner_1.iovdd sg13cmos5l_Corner_1.iovdd sg13_hv_pmos ad=3.9294p pd=7.84u as=2.1312p ps=7.3u w=6.66u l=0.6u
M3027 adc8b_0.side_cap8b_0.buf_32_0.z adc8b_0.side_cap8b_0.in_l_sw[0] vddr vddr sg13_lv_pmos ad=0.19p pd=1.38u as=0.19p ps=1.38u w=1u l=0.13u
M3028 adc8b_0.side_cap8b_0.buf_4_1.z adc8b_0.side_cap8b_0.in_h_sw[6] vddr vddr sg13_lv_pmos ad=0.34p pd=2.68u as=0.19p ps=1.38u w=1u l=0.13u
X3029 sg13cmos5l_Corner_1.iovdd a_131639_164698# sg13cmos5l_Corner_1.iovdd rppd l=12.9u w=0.5u
M3030 vddr a_42476_70044# sg13cmos5l_Corner_1.iovdd sg13cmos5l_Corner_1.iovdd sg13_hv_pmos ad=3.9294p pd=7.84u as=2.1312p ps=7.3u w=6.66u l=0.6u
M3031 adc8b_0.sar12b_0.sg13cmos5l_buf_1_65.X a_82192_99596# sg13cmos5l_Corner_1.vss sg13cmos5l_Corner_1.vss sg13_lv_nmos ad=0.2886p pd=2.26u as=0.14875p ps=1.16u w=0.74u l=0.13u
M3032 a_89601_96125# a_88659_95932# a_89399_95887# vdd sg13_lv_pmos ad=93.45f pd=0.865u as=0.2048p ps=1.63u w=0.42u l=0.13u
M3033 sg13cmos5l_IOPadAnalog_16.pad a_164624_102044# sg13cmos5l_Corner_1.iovdd sg13cmos5l_Corner_1.iovdd sg13_hv_pmos ad=3.9294p pd=7.84u as=3.1302p ps=14.26u w=6.66u l=0.6u
M3034 adc8b_0.side_cap8b_1.buf_16_2.z adc8b_0.sar12b_0.nl_sw[1] sg13cmos5l_Corner_1.vss sg13cmos5l_Corner_1.vss sg13_lv_nmos ad=95f pd=0.88u as=95f ps=0.88u w=0.5u l=0.13u
M3035 a_97644_96128# a_97618_96033# sg13cmos5l_Corner_1.vss sg13cmos5l_Corner_1.vss sg13_lv_nmos ad=0.2516p pd=2.16u as=0.1626p ps=1.415u w=0.74u l=0.13u
M3036 sg13cmos5l_Corner_1.iovdd a_70044_42476# data[0] sg13cmos5l_Corner_1.iovdd sg13_hv_pmos ad=2.1312p pd=7.3u as=3.9294p ps=7.84u w=6.66u l=0.6u
M3037 vddr adc8b_0.sar12b_0.nh_sw[0] adc8b_0.side_cap8b_1.buf_32_1.z vddr sg13_lv_pmos ad=0.19p pd=1.38u as=0.19p ps=1.38u w=1u l=0.13u
M3038 sg13cmos5l_IOPadAnalog_10.pad a_67639_164698# sg13cmos5l_Corner_1.iovdd sg13cmos5l_Corner_1.iovdd sg13_hv_pmos ad=3.9294p pd=7.84u as=2.1312p ps=7.3u w=6.66u l=0.6u
M3039 vdd adc8b_0.sar12b_0.sg13cmos5l_inv_1_28.Y a_93232_100384# vdd sg13_lv_pmos ad=0.2114p pd=1.54u as=0.2856p ps=2.36u w=0.84u l=0.13u
M3040 a_90551_98911# a_89709_98813# a_90457_98911# sg13cmos5l_Corner_1.vss sg13_lv_nmos ad=0.12665p pd=1.145u as=0.1428p ps=1.52u w=0.42u l=0.13u
M3041 a_87442_97545# a_87885_97301# a_87182_97322# sg13cmos5l_Corner_1.vss sg13_lv_nmos ad=79.8f pd=0.8u as=0.1296p ps=1.52u w=0.42u l=0.13u
M3042 vdd adc8b_0.sar12b_0.sg13cmos5l_dfrbp_1_8.RESET_B a_83890_95028# vdd sg13_lv_pmos ad=0.1563p pd=1.22u as=0.147p ps=1.54u w=0.42u l=0.13u
M3043 vdd a_82676_92750# adc8b_0.sar12b_0.sg13cmos5l_buf_1_32.X vdd sg13_lv_pmos ad=0.2114p pd=1.54u as=0.42p ps=2.99u w=1.12u l=0.13u
M3044 sg13cmos5l_Corner_1.vss a_99885_94277# a_99987_94420# sg13cmos5l_Corner_1.vss sg13_lv_nmos ad=2.59257p pd=16.445u as=0.2516p ps=2.16u w=0.74u l=0.13u
X3045 sg13cmos5l_IOPadAnalog_13.pad sg13cmos5l_Corner_1.iovdd dpantenna l=1.26u w=27.78u
M3046 vdd a_98903_95887# a_99160_96030# vdd sg13_lv_pmos ad=0.2639p pd=1.81u as=79.8f ps=0.8u w=0.42u l=0.13u
M3047 sg13cmos5l_IOPadAnalog_16.pad a_164624_102044# sg13cmos5l_Corner_1.iovdd sg13cmos5l_Corner_1.iovdd sg13_hv_pmos ad=3.9294p pd=7.84u as=2.1312p ps=7.3u w=6.66u l=0.6u
M3048 vdd sg13cmos5l_IOPadVdd$1_0.sg13cmos5l_RCClampInverter$1_0.in sg13cmos5l_IOPadVdd$1_0.sg13cmos5l_Clamp_N43N43D4R$1_0.gate vdd sg13_hv_pmos ad=1.33p pd=7.38u as=1.33p ps=7.38u w=7u l=0.5u
M3049 adc8b_0.sar12b_0.sg13cmos5l_buf_1_93.X a_96400_100384# sg13cmos5l_Corner_1.vss sg13cmos5l_Corner_1.vss sg13_lv_nmos ad=0.2886p pd=2.26u as=0.14875p ps=1.16u w=0.74u l=0.13u
M3050 sg13cmos5l_Corner_1.vss a_102044_30676# data[2] sg13cmos5l_Corner_1.vss sg13_hv_nmos ad=1.408p pd=5.04u as=2.596p ps=5.58u w=4.4u l=0.6u
M3051 data[1] a_86044_42476# sg13cmos5l_Corner_1.iovdd sg13cmos5l_Corner_1.iovdd sg13_hv_pmos ad=3.9294p pd=7.84u as=3.1302p ps=14.26u w=6.66u l=0.6u
M3052 sg13cmos5l_Corner_1.vss sg13cmos5l_IOPadVdd$1_0.sg13cmos5l_Clamp_N43N43D4R$1_0.gate vdd sg13cmos5l_Corner_1.vss sg13_hv_nmos ad=1.408p pd=5.04u as=2.596p ps=5.58u w=4.4u l=0.6u
M3053 adc8b_0.side_cap8b_0.buf_32_1.z adc8b_0.side_cap8b_0.in_h_sw[0] sg13cmos5l_Corner_1.vss sg13cmos5l_Corner_1.vss sg13_lv_nmos ad=95f pd=0.88u as=95f ps=0.88u w=0.5u l=0.13u
M3054 a_96684_100021# a_96396_99600# a_96622_100021# sg13cmos5l_Corner_1.vss sg13_lv_nmos ad=0.1428p pd=1.52u as=37.8f ps=0.6u w=0.42u l=0.13u
M3055 vdd a_83735_98445# a_84572_98084# vdd sg13_lv_pmos ad=0.2128p pd=1.5u as=0.3864p ps=2.93u w=1.12u l=0.13u
M3056 sg13cmos5l_IOPadAnalog_16.pad a_178296_102044# sg13cmos5l_Corner_1.vss sg13cmos5l_Corner_1.vss sg13_hv_nmos ad=2.596p pd=5.58u as=1.408p ps=5.04u w=4.4u l=0.6u
M3057 a_93324_95064# a_93298_95028# vdd vdd sg13_lv_pmos ad=0.34p pd=2.68u as=0.36237p ps=2.605u w=1u l=0.13u
M3058 vddr adc8b_0.sar12b_0.nl_sw[8] adc8b_0.side_cap8b_1.buf_2_1.z vddr sg13_lv_pmos ad=0.19p pd=1.38u as=0.34p ps=2.68u w=1u l=0.13u
M3059 sg13cmos5l_Corner_1.vss adc8b_0.sar12b_0.nl_sw[0] adc8b_0.side_cap8b_1.buf_32_0.z sg13cmos5l_Corner_1.vss sg13_lv_nmos ad=95f pd=0.88u as=95f ps=0.88u w=0.5u l=0.13u
M3060 sg13cmos5l_IOPadAnalog_15.pad a_99639_164698# sg13cmos5l_Corner_1.iovdd sg13cmos5l_Corner_1.iovdd sg13_hv_pmos ad=3.9294p pd=7.84u as=2.1312p ps=7.3u w=6.66u l=0.6u
M3061 a_73970_98361# adc8b_0.cmp_0.outn adc8b_0.cmp_0.outp sg13cmos5l_Corner_1.vss sg13_lv_nmos ad=1.7p pd=10.68u as=0.95p ps=5.38u w=5u l=0.13u
M3062 sg13cmos5l_IOPadAnalog_13.pad a_115639_164698# sg13cmos5l_Corner_1.iovdd sg13cmos5l_Corner_1.iovdd sg13_hv_pmos ad=3.9294p pd=7.84u as=2.1312p ps=7.3u w=6.66u l=0.6u
M3063 adc8b_0.side_cap8b_0.buf_16_1.z adc8b_0.side_cap8b_0.in_l_sw[2] sg13cmos5l_Corner_1.vss sg13cmos5l_Corner_1.vss sg13_lv_nmos ad=95f pd=0.88u as=95f ps=0.88u w=0.5u l=0.13u
M3064 adc8b_0.sar12b_0.sg13cmos5l_buf_8_2.X a_100995_100350# vdd vdd sg13_lv_pmos ad=0.2128p pd=1.5u as=0.2128p ps=1.5u w=1.12u l=0.13u
X3065 frame sg13cmos5l_Corner_1.iovdd dpantenna l=1.26u w=27.78u
M3066 sg13cmos5l_Corner_1.iovdd a_83639_164698# sg13cmos5l_IOPadAnalog_9.pad sg13cmos5l_Corner_1.iovdd sg13_hv_pmos ad=2.1312p pd=7.3u as=3.9294p ps=7.84u w=6.66u l=0.6u
M3067 a_96697_96974# a_96145_96930# sg13cmos5l_Corner_1.vss sg13cmos5l_Corner_1.vss sg13_lv_nmos ad=71.99999f pd=0.865u as=1.97045p ps=12.335u w=0.64u l=0.13u
M3068 vdd adc8b_0.sar12b_0.sg13cmos5l_nand2_1_2.B adc8b_0.sar12b_0.sg13cmos5l_dlygate4sd2_1_0.A vdd sg13_lv_pmos ad=0.3808p pd=2.92u as=0.2128p ps=1.5u w=1.12u l=0.13u
M3069 vddr adc8b_0.side_cap8b_0.in_h_sw[0] adc8b_0.side_cap8b_0.buf_32_1.z vddr sg13_lv_pmos ad=0.19p pd=1.38u as=0.19p ps=1.38u w=1u l=0.13u
M3070 a_85432_99838# a_85175_99957# a_85594_100034# sg13cmos5l_Corner_1.vss sg13_lv_nmos ad=0.1428p pd=1.52u as=37.8f ps=0.6u w=0.42u l=0.13u
X3071 sg13cmos5l_IOPadAnalog_7.padres data[1] sg13cmos5l_Corner_1.vss rppd l=2u w=1u
M3072 vdd a_89457_92786# a_89390_93224# vdd sg13_lv_pmos ad=0.2387p pd=1.84u as=0.1008p ps=0.9u w=0.42u l=0.13u
M3073 vddr adc8b_0.side_cap8b_0.in_h_sw[3] adc8b_0.side_cap8b_0.buf_8_3.z vddr sg13_lv_pmos ad=0.19p pd=1.38u as=0.19p ps=1.38u w=1u l=0.13u
M3074 sg13cmos5l_Corner_1.vss a_91647_100362# a_91778_100356# sg13cmos5l_Corner_1.vss sg13_lv_nmos ad=2.92392p pd=18.89u as=0.2775p ps=2.23u w=0.74u l=0.13u
M3075 a_99729_99953# a_99548_99596# vdd vdd sg13_lv_pmos ad=0.2128p pd=1.5u as=0.2387p ps=1.84u w=1.12u l=0.13u
M3076 adc8b_0.side_cap8b_0.buf_2_1.z adc8b_0.side_cap8b_0.in_l_sw[8] vddr vddr sg13_lv_pmos ad=0.34p pd=2.68u as=0.19p ps=1.38u w=1u l=0.13u
M3077 sg13cmos5l_Corner_1.vss sg13cmos5l_IOPadVdd$1_0.sg13cmos5l_Clamp_N43N43D4R$1_0.gate vdd sg13cmos5l_Corner_1.vss sg13_hv_nmos ad=1.408p pd=5.04u as=2.596p ps=5.58u w=4.4u l=0.6u
M3078 adc8b_0.sar12b_0.sg13cmos5l_dfrbp_1_7.Q_N a_96311_94375# sg13cmos5l_Corner_1.vss sg13cmos5l_Corner_1.vss sg13_lv_nmos ad=0.2849p pd=2.25u as=0.2516p ps=2.16u w=0.74u l=0.13u
M3079 sg13cmos5l_Corner_1.vss a_30676_102044# vip sg13cmos5l_Corner_1.vss sg13_hv_nmos ad=1.408p pd=5.04u as=2.596p ps=5.58u w=4.4u l=0.6u
M3080 a_92188_96572# adc8b_0.sar12b_0.sg13cmos5l_dfrbp_1_20.Q vdd vdd sg13_lv_pmos ad=0.2128p pd=1.5u as=0.3808p ps=2.92u w=1.12u l=0.13u
M3081 vdd adc8b_0.sar12b_0.sg13cmos5l_dfrbp_1_8.RESET_B a_87854_95810# vdd sg13_lv_pmos ad=0.36237p pd=2.605u as=79.8f ps=0.8u w=0.42u l=0.13u
M3082 vdd a_85175_95421# a_85432_95302# vdd sg13_lv_pmos ad=0.2639p pd=1.81u as=79.8f ps=0.8u w=0.42u l=0.13u
M3083 sg13cmos5l_IOPadAnalog_11.pad a_178296_118044# sg13cmos5l_Corner_1.vss sg13cmos5l_Corner_1.vss sg13_hv_nmos ad=2.596p pd=5.58u as=1.408p ps=5.04u w=4.4u l=0.6u
M3084 vddr a_30676_70044# sg13cmos5l_Corner_1.vss sg13cmos5l_Corner_1.vss sg13_hv_nmos ad=2.596p pd=5.58u as=1.408p ps=5.04u w=4.4u l=0.6u
M3085 sg13cmos5l_Corner_1.vss vdd sg13cmos5l_Corner_1.vss sg13cmos5l_Corner_1.vss sg13_lv_nmos ad=0.1428p pd=1.52u as=0 ps=0 w=0.42u l=1u
M3086 sg13cmos5l_Corner_1.vss adc8b_0.side_cap8b_0.in_h_sw[4] adc8b_0.side_cap8b_0.buf_8_2.z sg13cmos5l_Corner_1.vss sg13_lv_nmos ad=95f pd=0.88u as=95f ps=0.88u w=0.5u l=0.13u
M3087 a_92942_93986# a_93747_93559# a_93202_93516# vdd sg13_lv_pmos ad=0.1428p pd=1.52u as=79.8f ps=0.8u w=0.42u l=0.13u
M3088 sg13cmos5l_Corner_1.vss sg13cmos5l_IOPadVdd$1_0.sg13cmos5l_Clamp_N43N43D4R$1_0.gate vdd sg13cmos5l_Corner_1.vss sg13_hv_nmos ad=1.408p pd=5.04u as=2.596p ps=5.58u w=4.4u l=0.6u
M3089 a_98519_93909# a_97677_93559# a_98425_93909# sg13cmos5l_Corner_1.vss sg13_lv_nmos ad=0.12665p pd=1.145u as=0.1428p ps=1.52u w=0.42u l=0.13u
M3090 adc8b_0.side_cap8b_1.buf_16_0.z adc8b_0.sar12b_0.nh_sw[2] vddr vddr sg13_lv_pmos ad=0.19p pd=1.38u as=0.19p ps=1.38u w=1u l=0.13u
M3091 sg13cmos5l_Corner_1.iovdd a_102044_42476# data[2] sg13cmos5l_Corner_1.iovdd sg13_hv_pmos ad=2.1312p pd=7.3u as=3.9294p ps=7.84u w=6.66u l=0.6u
X3092 a_102044_42476# sg13cmos5l_Corner_1.iovdd sg13cmos5l_Corner_1.iovdd rppd l=12.9u w=0.5u
X3093 sg13cmos5l_IOPadAnalog_9.pad sg13cmos5l_Corner_1.iovdd dpantenna l=1.26u w=27.78u
M3094 adc8b_0.sar12b_0.sg13cmos5l_dlhr_1_15.Q a_100113_98834# sg13cmos5l_Corner_1.vss sg13cmos5l_Corner_1.vss sg13_lv_nmos ad=0.2516p pd=2.16u as=0.1406p ps=1.12u w=0.74u l=0.13u
M3095 adc8b_0.side_cap8b_1.buf_4_2.z adc8b_0.sar12b_0.nh_sw[7] sg13cmos5l_Corner_1.vss sg13cmos5l_Corner_1.vss sg13_lv_nmos ad=0.17p pd=1.68u as=95f ps=0.88u w=0.5u l=0.13u
M3096 adc8b_0.sar12b_0.sg13cmos5l_dlhr_1_20.Q_N a_91998_95792# sg13cmos5l_Corner_1.vss sg13cmos5l_Corner_1.vss sg13_lv_nmos ad=0.2516p pd=2.16u as=0.1491p ps=1.18u w=0.74u l=0.13u
M3097 sg13cmos5l_Corner_1.vss a_98061_95789# a_98163_95932# sg13cmos5l_Corner_1.vss sg13_lv_nmos ad=2.41737p pd=15.64u as=0.2516p ps=2.16u w=0.74u l=0.13u
M3098 adc8b_0.sar12b_0.sg13cmos5l_buf_1_98.A a_95409_98834# sg13cmos5l_Corner_1.vss sg13cmos5l_Corner_1.vss sg13_lv_nmos ad=0.2516p pd=2.16u as=0.1406p ps=1.12u w=0.74u l=0.13u
M3099 sg13cmos5l_Corner_1.vss adc8b_0.side_cap8b_0.in_l_sw[1] adc8b_0.side_cap8b_0.buf_16_2.z sg13cmos5l_Corner_1.vss sg13_lv_nmos ad=95f pd=0.88u as=95f ps=0.88u w=0.5u l=0.13u
M3100 a_98230_95183# a_97972_95498# vdd vdd sg13_lv_pmos ad=93.45f pd=0.865u as=1.43437p ps=9.105u w=0.42u l=0.13u
M3101 sg13cmos5l_Corner_1.vss adc8b_0.sar12b_0.sg13cmos5l_buf_8_1.A a_100131_95430# sg13cmos5l_Corner_1.vss sg13_lv_nmos ad=0.1406p pd=1.12u as=0.2553p ps=2.17u w=0.74u l=0.13u
M3102 a_94840_93006# adc8b_0.sar12b_0.sg13cmos5l_dfrbp_1_0.RESET_B vdd vdd sg13_lv_pmos ad=79.8f pd=0.8u as=1.777p ps=11.395u w=0.42u l=0.13u
M3103 a_94092_97322# adc8b_0.sar12b_0.sg13cmos5l_buf_1_57.X a_93998_97322# sg13cmos5l_Corner_1.vss sg13_lv_nmos ad=60.89999f pd=0.71u as=0.1428p ps=1.52u w=0.42u l=0.13u
M3104 data[2] a_102044_30676# sg13cmos5l_Corner_1.vss sg13cmos5l_Corner_1.vss sg13_hv_nmos ad=2.596p pd=5.58u as=1.408p ps=5.04u w=4.4u l=0.6u
M3105 adc8b_0.sar12b_0.sg13cmos5l_dfrbp_1_25.Q_N a_97655_99957# vdd vdd sg13_lv_pmos ad=0.4312p pd=3.01u as=0.2639p ps=1.81u w=1.12u l=0.13u
M3106 sg13cmos5l_Corner_1.iovdd a_42476_118044# cks sg13cmos5l_Corner_1.iovdd sg13_hv_pmos ad=2.1312p pd=7.3u as=3.9294p ps=7.84u w=6.66u l=0.6u
M3107 adc8b_0.side_cap8b_1.buf_32_1.z adc8b_0.sar12b_0.nh_sw[0] vddr vddr sg13_lv_pmos ad=0.34p pd=2.68u as=0.19p ps=1.38u w=1u l=0.13u
M3108 sg13cmos5l_Corner_1.vss a_98776_93790# a_98425_93909# sg13cmos5l_Corner_1.vss sg13_lv_nmos ad=79.8f pd=0.8u as=0.1428p ps=1.52u w=0.42u l=0.13u
M3109 sg13cmos5l_IOPadAnalog_10.pad a_67639_164698# sg13cmos5l_Corner_1.iovdd sg13cmos5l_Corner_1.iovdd sg13_hv_pmos ad=3.9294p pd=7.84u as=2.1312p ps=7.3u w=6.66u l=0.6u
M3110 vddr adc8b_0.side_cap8b_0.in_l_sw[5] adc8b_0.side_cap8b_0.buf_8_4.z vddr sg13_lv_pmos ad=0.19p pd=1.38u as=0.19p ps=1.38u w=1u l=0.13u
X3111 data[0] sg13cmos5l_Corner_1.iovdd dpantenna l=1.26u w=27.78u
M3112 adc8b_0.side_cap8b_0.buf_8_2.z adc8b_0.side_cap8b_0.in_h_sw[4] vddr vddr sg13_lv_pmos ad=0.34p pd=2.68u as=0.19p ps=1.38u w=1u l=0.13u
M3113 sg13cmos5l_IOPadAnalog_9.pad a_83639_164698# sg13cmos5l_Corner_1.iovdd sg13cmos5l_Corner_1.iovdd sg13_hv_pmos ad=3.9294p pd=7.84u as=2.1312p ps=7.3u w=6.66u l=0.6u
M3114 a_86148_98486# a_85599_98442# a_86012_98084# sg13cmos5l_Corner_1.vss sg13_lv_nmos ad=47.25f pd=0.645u as=0.141p ps=1.17u w=0.42u l=0.13u
M3115 sg13cmos5l_Corner_1.vss a_86193_98441# a_86148_98486# sg13cmos5l_Corner_1.vss sg13_lv_nmos ad=0.1428p pd=1.52u as=47.25f ps=0.645u w=0.42u l=0.13u
M3116 adc8b_0.side_cap8b_0.buf_16_2.z adc8b_0.side_cap8b_0.in_l_sw[1] vddr vddr sg13_lv_pmos ad=0.34p pd=2.68u as=0.19p ps=1.38u w=1u l=0.13u
M3117 a_84351_98870# a_83716_99124# sg13cmos5l_Corner_1.vss sg13cmos5l_Corner_1.vss sg13_lv_nmos ad=47.25f pd=0.645u as=0.1428p ps=1.52u w=0.42u l=0.13u
M3118 a_84116_98784# a_84389_98796# a_84351_98870# sg13cmos5l_Corner_1.vss sg13_lv_nmos ad=0.141p pd=1.17u as=47.25f ps=0.645u w=0.42u l=0.13u
M3119 adc8b_0.sar12b_0.nh_sw[1] a_84592_93548# sg13cmos5l_Corner_1.vss sg13cmos5l_Corner_1.vss sg13_lv_nmos ad=0.2886p pd=2.26u as=0.14875p ps=1.16u w=0.74u l=0.13u
M3120 sg13cmos5l_Corner_1.vss adc8b_0.side_cap8b_0.in_l_sw[6] adc8b_0.side_cap8b_0.buf_4_3.z sg13cmos5l_Corner_1.vss sg13_lv_nmos ad=95f pd=0.88u as=0.17p ps=1.68u w=0.5u l=0.13u
M3121 vdd adc8b_0.sar12b_0.sg13cmos5l_dfrbp_1_6.RESET_B a_89006_98834# vdd sg13_lv_pmos ad=0.36237p pd=2.605u as=79.8f ps=0.8u w=0.42u l=0.13u
M3122 sg13cmos5l_Corner_1.iovdd a_99639_164698# sg13cmos5l_IOPadAnalog_15.pad sg13cmos5l_Corner_1.iovdd sg13_hv_pmos ad=2.1312p pd=7.3u as=3.9294p ps=7.84u w=6.66u l=0.6u
M3123 sg13cmos5l_Corner_1.vss sg13cmos5l_IOPadVdd$1_0.sg13cmos5l_Clamp_N43N43D4R$1_0.gate vdd sg13cmos5l_Corner_1.vss sg13_hv_nmos ad=1.408p pd=5.04u as=3.256p ps=10.28u w=4.4u l=0.6u
M3124 vddr adc8b_0.side_cap8b_0.in_l_sw[10] adc8b_0.side_cap8b_0.buf_1_0.z vddr sg13_lv_pmos ad=0.34p pd=2.68u as=0.34p ps=2.68u w=1u l=0.13u
M3125 sg13cmos5l_Corner_1.iovdd a_115639_164698# sg13cmos5l_IOPadAnalog_13.pad sg13cmos5l_Corner_1.iovdd sg13_hv_pmos ad=2.1312p pd=7.3u as=3.9294p ps=7.84u w=6.66u l=0.6u
M3126 adc8b_0.diff_bsw_0.single_bsw_0.sg13cmos5l_inv_1$1_0.Y adc8b_0.diff_bsw_0.single_bsw_0.sg13cmos5l_inv_1$1_0.A vdd vdd sg13_lv_pmos ad=0.3808p pd=2.92u as=0.3808p ps=2.92u w=1.12u l=0.13u
M3127 vdd adc8b_0.cmp_0.rdy a_82192_99596# vdd sg13_lv_pmos ad=0.2114p pd=1.54u as=0.2856p ps=2.36u w=0.84u l=0.13u
M3128 sg13cmos5l_Corner_1.vss adc8b_0.sar12b_0.sg13cmos5l_dfrbp_1_8.RESET_B a_87564_100034# sg13cmos5l_Corner_1.vss sg13_lv_nmos ad=0.1626p pd=1.415u as=60.89999f ps=0.71u w=0.42u l=0.13u
M3129 sg13cmos5l_Corner_1.iovdd a_42476_118044# cks sg13cmos5l_Corner_1.iovdd sg13_hv_pmos ad=2.1312p pd=7.3u as=3.9294p ps=7.84u w=6.66u l=0.6u
M3130 sg13cmos5l_Corner_1.vss a_83735_98445# a_84572_98084# sg13cmos5l_Corner_1.vss sg13_lv_nmos ad=0.1406p pd=1.12u as=0.2516p ps=2.16u w=0.74u l=0.13u
M3131 adc8b_0.side_cap8b_1.buf_32_1.z adc8b_0.sar12b_0.nh_sw[0] vddr vddr sg13_lv_pmos ad=0.19p pd=1.38u as=0.19p ps=1.38u w=1u l=0.13u
M3132 vdd a_97912_99838# a_97857_99719# vdd sg13_lv_pmos ad=1.15047p pd=7.175u as=93.45f ps=0.865u w=0.42u l=0.13u
M3133 a_91988_94262# adc8b_0.sar12b_0.sg13cmos5l_buf_1_28.X vdd vdd sg13_lv_pmos ad=0.2856p pd=2.36u as=0.2114p ps=1.54u w=0.84u l=0.13u
M3134 a_93162_96108# adc8b_0.sar12b_0.sg13cmos5l_a221oi_1_0.B2 a_92950_96108# vdd sg13_lv_pmos ad=0.2128p pd=1.5u as=0.2128p ps=1.5u w=1.12u l=0.13u
M3135 vdd adc8b_0.sar12b_0.sg13cmos5l_dfrbp_1_6.RESET_B a_87538_95028# vdd sg13_lv_pmos ad=0.1563p pd=1.22u as=0.147p ps=1.54u w=0.42u l=0.13u
M3136 sg13cmos5l_Corner_1.iovdd a_102044_42476# data[2] sg13cmos5l_Corner_1.iovdd sg13_hv_pmos ad=2.1312p pd=7.3u as=3.9294p ps=7.84u w=6.66u l=0.6u
M3137 sg13cmos5l_IOPadAnalog_15.pad a_99639_164698# sg13cmos5l_Corner_1.iovdd sg13cmos5l_Corner_1.iovdd sg13_hv_pmos ad=3.9294p pd=7.84u as=3.1302p ps=14.26u w=6.66u l=0.6u
M3138 vdd a_85437_97480# a_84516_97286# vdd sg13_lv_pmos ad=0.36237p pd=2.605u as=0.34p ps=2.68u w=1u l=0.13u
M3139 vdd sg13cmos5l_Corner_1.vss vdd vdd sg13_lv_pmos ad=0.34p pd=2.68u as=0 ps=0 w=1u l=1u
X3140 sg13cmos5l_IOPadAnalog_16.pad sg13cmos5l_Corner_1.iovdd dpantenna l=27.78u w=1.26u
M3141 sg13cmos5l_Corner_1.vss adc8b_0.sar12b_0.nh_sw[1] adc8b_0.side_cap8b_1.buf_16_3.z sg13cmos5l_Corner_1.vss sg13_lv_nmos ad=95f pd=0.88u as=95f ps=0.88u w=0.5u l=0.13u
M3142 sg13cmos5l_Corner_1.vss adc8b_0.side_cap8b_0.in_h_sw[0] adc8b_0.side_cap8b_0.buf_32_1.z sg13cmos5l_Corner_1.vss sg13_lv_nmos ad=95f pd=0.88u as=0.17p ps=1.68u w=0.5u l=0.13u
M3143 vdd adc8b_0.sar12b_0.sg13cmos5l_inv_1_8.A a_87719_96543# vdd sg13_lv_pmos ad=1.2517p pd=7.955u as=0.4088p ps=2.97u w=1.12u l=0.13u
M3144 a_84465_94689# a_84108_94616# vdd vdd sg13_lv_pmos ad=63f pd=0.72u as=0.1563p ps=1.22u w=0.42u l=0.13u
M3145 sg13cmos5l_Corner_1.vss a_99519_98850# a_99650_98844# sg13cmos5l_Corner_1.vss sg13_lv_nmos ad=1.49685p pd=9.6u as=0.2775p ps=2.23u w=0.74u l=0.13u
M3146 a_82764_98509# a_82995_98095# a_82450_98052# sg13cmos5l_Corner_1.vss sg13_lv_nmos ad=0.2373p pd=1.97u as=79.8f ps=0.8u w=0.42u l=0.13u
M3147 vdd sg13cmos5l_IOPadVdd$1_0.sg13cmos5l_Clamp_N43N43D4R$1_0.gate sg13cmos5l_Corner_1.vss sg13cmos5l_Corner_1.vss sg13_hv_nmos ad=2.596p pd=5.58u as=1.408p ps=5.04u w=4.4u l=0.6u
M3148 sg13cmos5l_Corner_1.iovdd a_134044_42476# frame sg13cmos5l_Corner_1.iovdd sg13_hv_pmos ad=2.1312p pd=7.3u as=3.9294p ps=7.84u w=6.66u l=0.6u
M3149 sg13cmos5l_IOPadAnalog_1.pad a_164624_70044# sg13cmos5l_Corner_1.iovdd sg13cmos5l_Corner_1.iovdd sg13_hv_pmos ad=3.9294p pd=7.84u as=2.1312p ps=7.3u w=6.66u l=0.6u
M3150 sg13cmos5l_Corner_1.vss a_115639_178370# sg13cmos5l_IOPadAnalog_13.pad sg13cmos5l_Corner_1.vss sg13_hv_nmos ad=1.408p pd=5.04u as=2.596p ps=5.58u w=4.4u l=0.6u
M3151 vdd sg13cmos5l_Corner_1.vss vdd vdd sg13_lv_pmos ad=0.34p pd=2.68u as=0 ps=0 w=1u l=1u
M3152 sg13cmos5l_Corner_1.iovdd a_164624_70044# sg13cmos5l_IOPadAnalog_1.pad sg13cmos5l_Corner_1.iovdd sg13_hv_pmos ad=2.1312p pd=7.3u as=3.9294p ps=7.84u w=6.66u l=0.6u
M3153 sg13cmos5l_Corner_1.vss adc8b_0.sar12b_0.nh_sw[4] adc8b_0.side_cap8b_1.buf_8_2.z sg13cmos5l_Corner_1.vss sg13_lv_nmos ad=95f pd=0.88u as=95f ps=0.88u w=0.5u l=0.13u
M3154 a_95340_94311# a_95571_94420# a_95026_94521# sg13cmos5l_Corner_1.vss sg13_lv_nmos ad=0.2373p pd=1.97u as=79.8f ps=0.8u w=0.42u l=0.13u
M3155 sg13cmos5l_Corner_1.vss a_178296_118044# sg13cmos5l_IOPadAnalog_11.pad sg13cmos5l_Corner_1.vss sg13_hv_nmos ad=1.408p pd=5.04u as=2.596p ps=5.58u w=4.4u l=0.6u
M3156 adc8b_0.side_cap8b_0.buf_32_1.z adc8b_0.side_cap8b_0.in_h_sw[0] vddr vddr sg13_lv_pmos ad=0.19p pd=1.38u as=0.19p ps=1.38u w=1u l=0.13u
M3157 vdd adc8b_0.sar12b_0.sg13cmos5l_dfrbp_1_20.Q_N a_91441_100400# vdd sg13_lv_pmos ad=4.11675p pd=27.17u as=0.2856p ps=2.36u w=0.84u l=0.13u
M3158 sg13cmos5l_Corner_1.vss adc8b_0.sar12b_0.sg13cmos5l_or2_1_1.B a_93984_96888# sg13cmos5l_Corner_1.vss sg13_lv_nmos ad=0.187p pd=1.78u as=0.1045p ps=0.93u w=0.55u l=0.13u
M3159 frame a_134044_30676# sg13cmos5l_Corner_1.vss sg13cmos5l_Corner_1.vss sg13_hv_nmos ad=2.596p pd=5.58u as=1.408p ps=5.04u w=4.4u l=0.6u
M3160 adc8b_0.side_cap8b_1.buf_4_0.z adc8b_0.sar12b_0.nl_sw[7] sg13cmos5l_Corner_1.vss sg13cmos5l_Corner_1.vss sg13_lv_nmos ad=0.17p pd=1.68u as=95f ps=0.88u w=0.5u l=0.13u
M3161 a_99261_95107# adc8b_0.sar12b_0.sg13cmos5l_dfrbp_1_6.RESET_B vdd vdd sg13_lv_pmos ad=0.147p pd=1.54u as=0.1563p ps=1.22u w=0.42u l=0.13u
M3162 adc8b_0.side_cap8b_1.buf_32_1.z adc8b_0.sar12b_0.nh_sw[0] sg13cmos5l_Corner_1.vss sg13cmos5l_Corner_1.vss sg13_lv_nmos ad=95f pd=0.88u as=95f ps=0.88u w=0.5u l=0.13u
M3163 vdd adc8b_0.sar12b_0.sg13cmos5l_dfrbp_1_6.RESET_B a_86193_98441# vdd sg13_lv_pmos ad=0.2128p pd=1.5u as=0.2128p ps=1.5u w=1.12u l=0.13u
M3164 a_90180_98486# a_89631_98442# a_90044_98084# sg13cmos5l_Corner_1.vss sg13_lv_nmos ad=47.25f pd=0.645u as=0.141p ps=1.17u w=0.42u l=0.13u
M3165 sg13cmos5l_Corner_1.vss adc8b_0.side_cap8b_0.in_h_sw[1] adc8b_0.side_cap8b_0.buf_16_3.z sg13cmos5l_Corner_1.vss sg13_lv_nmos ad=95f pd=0.88u as=95f ps=0.88u w=0.5u l=0.13u
M3166 vdd adc8b_0.sar12b_0.sg13cmos5l_dfrbp_1_8.RESET_B a_93874_100569# vdd sg13_lv_pmos ad=0.1563p pd=1.22u as=0.147p ps=1.54u w=0.42u l=0.13u
M3167 sg13cmos5l_Corner_1.vss adc8b_0.sar12b_0.sg13cmos5l_inv_1_18.A adc8b_0.sar12b_0.sg13cmos5l_buf_1_28.A sg13cmos5l_Corner_1.vss sg13_lv_nmos ad=0.2516p pd=2.16u as=0.2516p ps=2.16u w=0.74u l=0.13u
M3168 vdd a_98253_98095# a_98355_98095# vdd sg13_lv_pmos ad=1.07253p pd=6.75u as=0.3864p ps=2.93u w=1.12u l=0.13u
M3169 data[1] a_86044_42476# sg13cmos5l_Corner_1.iovdd sg13cmos5l_Corner_1.iovdd sg13_hv_pmos ad=3.9294p pd=7.84u as=2.1312p ps=7.3u w=6.66u l=0.6u
M3170 vdd sg13cmos5l_Corner_1.vss vdd vdd sg13_lv_pmos ad=0.34p pd=2.68u as=0 ps=0 w=1u l=1u
M3171 sg13cmos5l_Corner_1.iovdd a_67639_164698# sg13cmos5l_IOPadAnalog_10.pad sg13cmos5l_Corner_1.iovdd sg13_hv_pmos ad=2.1312p pd=7.3u as=3.9294p ps=7.84u w=6.66u l=0.6u
M3172 vdd adc8b_0.sar12b_0.sg13cmos5l_dfrbp_1_6.RESET_B a_86962_93516# vdd sg13_lv_pmos ad=0.1563p pd=1.22u as=0.147p ps=1.54u w=0.42u l=0.13u
M3173 sg13cmos5l_Corner_1.iovdd a_83639_164698# sg13cmos5l_IOPadAnalog_9.pad sg13cmos5l_Corner_1.iovdd sg13_hv_pmos ad=2.1312p pd=7.3u as=3.9294p ps=7.84u w=6.66u l=0.6u
M3174 adc8b_0.sar12b_0.sg13cmos5l_buf_1_86.A a_101776_99596# sg13cmos5l_Corner_1.vss sg13cmos5l_Corner_1.vss sg13_lv_nmos ad=0.2886p pd=2.26u as=0.14875p ps=1.16u w=0.74u l=0.13u
M3175 a_85599_98442# adc8b_0.sar12b_0.sg13cmos5l_dfrbp_1_15.D sg13cmos5l_Corner_1.vss sg13cmos5l_Corner_1.vss sg13_lv_nmos ad=0.2516p pd=2.16u as=0.15055p ps=1.17u w=0.74u l=0.13u
M3176 a_94929_98441# a_94748_98084# vdd vdd sg13_lv_pmos ad=0.2128p pd=1.5u as=0.2387p ps=1.84u w=1.12u l=0.13u
M3177 sg13cmos5l_Corner_1.vss adc8b_0.sar12b_0.sg13cmos5l_dlhr_1_6.D a_90001_97376# sg13cmos5l_Corner_1.vss sg13_lv_nmos ad=0.15055p pd=1.17u as=0.187p ps=1.78u w=0.55u l=0.13u
M3178 a_87314_97010# a_86837_96536# a_87220_97010# sg13cmos5l_Corner_1.vss sg13_lv_nmos ad=37.8f pd=0.6u as=0.1428p ps=1.52u w=0.42u l=0.13u
M3179 vddr adc8b_0.sar12b_0.nh_sw[2] adc8b_0.side_cap8b_1.buf_16_0.z vddr sg13_lv_pmos ad=0.19p pd=1.38u as=0.19p ps=1.38u w=1u l=0.13u
M3180 adc8b_0.sar12b_0.nh_sw[2] a_85456_92824# sg13cmos5l_Corner_1.vss sg13cmos5l_Corner_1.vss sg13_lv_nmos ad=0.2886p pd=2.26u as=0.14875p ps=1.16u w=0.74u l=0.13u
M3181 sg13cmos5l_IOPadAnalog_1.pad a_164624_70044# sg13cmos5l_Corner_1.iovdd sg13cmos5l_Corner_1.iovdd sg13_hv_pmos ad=3.9294p pd=7.84u as=2.1312p ps=7.3u w=6.66u l=0.6u
M3182 a_90356_93512# adc8b_0.sar12b_0.sg13cmos5l_buf_1_26.X sg13cmos5l_Corner_1.vss sg13cmos5l_Corner_1.vss sg13_lv_nmos ad=0.187p pd=1.78u as=0.14875p ps=1.16u w=0.55u l=0.13u
M3183 sg13cmos5l_IOPadAnalog_16.pad a_164624_102044# sg13cmos5l_Corner_1.iovdd sg13cmos5l_Corner_1.iovdd sg13_hv_pmos ad=3.9294p pd=7.84u as=2.1312p ps=7.3u w=6.66u l=0.6u
M3184 vdd adc8b_0.sar12b_0.sg13cmos5l_dfrbp_1_6.RESET_B a_100977_96929# vdd sg13_lv_pmos ad=0.2128p pd=1.5u as=0.2128p ps=1.5u w=1.12u l=0.13u
M3185 adc8b_0.side_cap8b_1.buf_16_1.z adc8b_0.sar12b_0.nl_sw[2] sg13cmos5l_Corner_1.vss sg13cmos5l_Corner_1.vss sg13_lv_nmos ad=95f pd=0.88u as=95f ps=0.88u w=0.5u l=0.13u
M3186 vip a_30676_102044# sg13cmos5l_Corner_1.vss sg13cmos5l_Corner_1.vss sg13_hv_nmos ad=2.596p pd=5.58u as=1.408p ps=5.04u w=4.4u l=0.6u
M3187 adc8b_0.sar12b_0.sg13cmos5l_inv_1_3.A a_95536_99596# sg13cmos5l_Corner_1.vss sg13cmos5l_Corner_1.vss sg13_lv_nmos ad=0.2886p pd=2.26u as=0.14875p ps=1.16u w=0.74u l=0.13u
M3188 vdd adc8b_0.sar12b_0.sg13cmos5l_dfrbp_1_6.RESET_B a_96754_99057# vdd sg13_lv_pmos ad=0.1563p pd=1.22u as=0.147p ps=1.54u w=0.42u l=0.13u
M3189 sg13cmos5l_IOPadAnalog_10.pad a_67639_164698# sg13cmos5l_Corner_1.iovdd sg13cmos5l_Corner_1.iovdd sg13_hv_pmos ad=3.9294p pd=7.84u as=3.1302p ps=14.26u w=6.66u l=0.6u
M3190 sg13cmos5l_IOPadAnalog_15.pad a_99639_178370# sg13cmos5l_Corner_1.vss sg13cmos5l_Corner_1.vss sg13_hv_nmos ad=2.596p pd=5.58u as=1.408p ps=5.04u w=4.4u l=0.6u
M3191 sg13cmos5l_Corner_1.iovdd a_70044_42476# data[0] sg13cmos5l_Corner_1.iovdd sg13_hv_pmos ad=2.1312p pd=7.3u as=3.9294p ps=7.84u w=6.66u l=0.6u
M3192 adc8b_0.side_cap8b_1.buf_32_0.z adc8b_0.sar12b_0.nl_sw[0] vddr vddr sg13_lv_pmos ad=0.19p pd=1.38u as=0.19p ps=1.38u w=1u l=0.13u
M3193 sg13cmos5l_Corner_1.vss adc8b_0.side_cap8b_0.in_l_sw[4] adc8b_0.side_cap8b_0.buf_8_0.z sg13cmos5l_Corner_1.vss sg13_lv_nmos ad=95f pd=0.88u as=0.17p ps=1.68u w=0.5u l=0.13u
M3194 adc8b_0.cmp_0.outn adc8b_0.cmp_0.outp a_76796_95659# sg13cmos5l_Corner_1.vss sg13_lv_nmos ad=0.95p pd=5.38u as=1.7p ps=10.68u w=5u l=0.13u
M3195 adc8b_0.side_cap8b_1.buf_8_1.z adc8b_0.sar12b_0.nl_sw[3] sg13cmos5l_Corner_1.vss sg13cmos5l_Corner_1.vss sg13_lv_nmos ad=95f pd=0.88u as=95f ps=0.88u w=0.5u l=0.13u
M3196 a_100383_96930# adc8b_0.sar12b_0.sg13cmos5l_dfrbp_1_8.D sg13cmos5l_Corner_1.vss sg13cmos5l_Corner_1.vss sg13_lv_nmos ad=0.2516p pd=2.16u as=0.15055p ps=1.17u w=0.74u l=0.13u
M3197 a_87956_92750# adc8b_0.sar12b_0.sg13cmos5l_buf_1_25.A sg13cmos5l_Corner_1.vss sg13cmos5l_Corner_1.vss sg13_lv_nmos ad=0.187p pd=1.78u as=0.14875p ps=1.16u w=0.55u l=0.13u
M3198 adc8b_0.sar12b_0.sg13cmos5l_dlhr_1_0.D a_89084_93548# vdd vdd sg13_lv_pmos ad=0.3808p pd=2.92u as=0.2128p ps=1.5u w=1.12u l=0.13u
M3199 sg13cmos5l_Corner_1.vss a_83639_178370# sg13cmos5l_IOPadAnalog_9.pad sg13cmos5l_Corner_1.vss sg13_hv_nmos ad=1.408p pd=5.04u as=2.596p ps=5.58u w=4.4u l=0.6u
M3200 sg13cmos5l_Corner_1.vss adc8b_0.side_cap8b_0.in_l_sw[0] adc8b_0.side_cap8b_0.buf_32_0.z sg13cmos5l_Corner_1.vss sg13_lv_nmos ad=95f pd=0.88u as=95f ps=0.88u w=0.5u l=0.13u
M3201 a_83170_95024# adc8b_0.sar12b_0.sg13cmos5l_dlygate4sd2_1_0.X vdd vdd sg13_lv_pmos ad=0.1428p pd=1.52u as=0.1523p ps=1.38u w=0.42u l=0.13u
M3202 a_93612_95485# a_93324_95064# a_93550_95485# sg13cmos5l_Corner_1.vss sg13_lv_nmos ad=0.1428p pd=1.52u as=37.8f ps=0.6u w=0.42u l=0.13u
M3203 adc8b_0.sar12b_0.sg13cmos5l_buf_1_44.A a_87441_94298# sg13cmos5l_Corner_1.vss sg13cmos5l_Corner_1.vss sg13_lv_nmos ad=0.2516p pd=2.16u as=0.1406p ps=1.12u w=0.74u l=0.13u
M3204 sg13cmos5l_Corner_1.iovdd a_99639_164698# sg13cmos5l_IOPadAnalog_15.pad sg13cmos5l_Corner_1.iovdd sg13_hv_pmos ad=2.1312p pd=7.3u as=3.9294p ps=7.84u w=6.66u l=0.6u
M3205 vdd adc8b_0.sar12b_0.sg13cmos5l_dfrbp_1_8.RESET_B a_93614_100346# vdd sg13_lv_pmos ad=0.36237p pd=2.605u as=79.8f ps=0.8u w=0.42u l=0.13u
M3206 a_91224_96132# a_90673_95864# vdd vdd sg13_lv_pmos ad=0.105p pd=1.21u as=1.28962p ps=8.195u w=1u l=0.13u
M3207 vdd adc8b_0.sar12b_0.sg13cmos5l_buf_1_41.X a_84592_93548# vdd sg13_lv_pmos ad=0.2114p pd=1.54u as=0.2856p ps=2.36u w=0.84u l=0.13u
M3208 vdd sg13cmos5l_IOPadVdd$1_0.sg13cmos5l_RCClampInverter$1_0.in sg13cmos5l_IOPadVdd$1_0.sg13cmos5l_Clamp_N43N43D4R$1_0.gate vdd sg13_hv_pmos ad=1.33p pd=7.38u as=1.33p ps=7.38u w=7u l=0.5u
M3209 vddr adc8b_0.side_cap8b_0.in_l_sw[1] adc8b_0.side_cap8b_0.buf_16_2.z vddr sg13_lv_pmos ad=0.19p pd=1.38u as=0.19p ps=1.38u w=1u l=0.13u
M3210 a_92180_97286# adc8b_0.sar12b_0.sg13cmos5l_dlhr_1_5.Q sg13cmos5l_Corner_1.vss sg13cmos5l_Corner_1.vss sg13_lv_nmos ad=0.187p pd=1.78u as=0.14875p ps=1.16u w=0.55u l=0.13u
M3211 data[0] a_70044_30676# sg13cmos5l_Corner_1.vss sg13cmos5l_Corner_1.vss sg13_hv_nmos ad=2.596p pd=5.58u as=1.408p ps=5.04u w=4.4u l=0.6u
M3212 sg13cmos5l_IOPadAnalog_0.pad a_164624_86044# sg13cmos5l_Corner_1.iovdd sg13cmos5l_Corner_1.iovdd sg13_hv_pmos ad=3.9294p pd=7.84u as=2.1312p ps=7.3u w=6.66u l=0.6u
M3213 sg13cmos5l_IOPadAnalog_11.pad a_164624_118044# sg13cmos5l_Corner_1.iovdd sg13cmos5l_Corner_1.iovdd sg13_hv_pmos ad=3.9294p pd=7.84u as=2.1312p ps=7.3u w=6.66u l=0.6u
M3214 vddr adc8b_0.sar12b_0.nl_sw[3] adc8b_0.side_cap8b_1.buf_8_1.z vddr sg13_lv_pmos ad=0.19p pd=1.38u as=0.34p ps=2.68u w=1u l=0.13u
M3215 adc8b_0.side_cap8b_1.buf_16_2.z adc8b_0.sar12b_0.nl_sw[1] sg13cmos5l_Corner_1.vss sg13cmos5l_Corner_1.vss sg13_lv_nmos ad=95f pd=0.88u as=95f ps=0.88u w=0.5u l=0.13u
M3216 adc8b_0.sar12b_0.sg13cmos5l_buf_1_18.X a_100144_93548# vdd vdd sg13_lv_pmos ad=0.42p pd=2.99u as=0.2114p ps=1.54u w=1.12u l=0.13u
M3217 a_97742_97322# adc8b_0.sar12b_0.sg13cmos5l_buf_1_57.X vdd vdd sg13_lv_pmos ad=79.8f pd=0.8u as=0.1428p ps=1.52u w=0.42u l=0.13u
M3218 vddr adc8b_0.sar12b_0.nh_sw[5] adc8b_0.side_cap8b_1.buf_8_5.z vddr sg13_lv_pmos ad=0.19p pd=1.38u as=0.19p ps=1.38u w=1u l=0.13u
M3219 a_88863_92802# adc8b_0.sar12b_0.sg13cmos5l_dlhr_1_0.GATE vdd vdd sg13_lv_pmos ad=0.3234p pd=2.45u as=1.777p ps=11.395u w=0.84u l=0.13u
M3220 vdd sg13cmos5l_IOPadVdd$1_0.sg13cmos5l_RCClampInverter$1_0.in sg13cmos5l_IOPadVdd$1_0.sg13cmos5l_Clamp_N43N43D4R$1_0.gate vdd sg13_hv_pmos ad=1.33p pd=7.38u as=1.33p ps=7.38u w=7u l=0.5u
M3221 sg13cmos5l_Corner_1.vss a_94929_98441# a_95454_98514# sg13cmos5l_Corner_1.vss sg13_lv_nmos ad=0.1491p pd=1.18u as=0.187p ps=1.78u w=0.55u l=0.13u
M3222 sg13cmos5l_Corner_1.vss vdd sg13cmos5l_Corner_1.vss sg13cmos5l_Corner_1.vss sg13_lv_nmos ad=0.1428p pd=1.52u as=0 ps=0 w=0.42u l=1u
X3223 a_164624_70044# sg13cmos5l_Corner_1.iovdd sg13cmos5l_Corner_1.iovdd rppd l=12.9u w=0.5u
M3224 vddr adc8b_0.sar12b_0.nh_sw[0] adc8b_0.side_cap8b_1.buf_32_1.z vddr sg13_lv_pmos ad=0.19p pd=1.38u as=0.19p ps=1.38u w=1u l=0.13u
M3225 vdd adc8b_0.sar12b_0.sg13cmos5l_buf_1_5.A a_96208_92824# vdd sg13_lv_pmos ad=0.2114p pd=1.54u as=0.2856p ps=2.36u w=0.84u l=0.13u
M3226 adc8b_0.sar12b_0.sg13cmos5l_nor2b_1_1.Y a_96022_93604# sg13cmos5l_Corner_1.vss sg13cmos5l_Corner_1.vss sg13_lv_nmos ad=0.1406p pd=1.12u as=0.17255p ps=1.25u w=0.74u l=0.13u
M3227 sg13cmos5l_Corner_1.vss a_88247_93909# a_89084_93548# sg13cmos5l_Corner_1.vss sg13_lv_nmos ad=0.1406p pd=1.12u as=0.2516p ps=2.16u w=0.74u l=0.13u
M3228 a_98903_95887# a_98061_95789# a_98809_95887# sg13cmos5l_Corner_1.vss sg13_lv_nmos ad=0.12665p pd=1.145u as=0.1428p ps=1.52u w=0.42u l=0.13u
M3229 adc8b_0.sar12b_0.sg13cmos5l_dlhr_1_11.GATE a_92636_99596# vdd vdd sg13_lv_pmos ad=0.3808p pd=2.92u as=0.2128p ps=1.5u w=1.12u l=0.13u
M3230 frame a_134044_42476# sg13cmos5l_Corner_1.iovdd sg13cmos5l_Corner_1.iovdd sg13_hv_pmos ad=3.9294p pd=7.84u as=3.1302p ps=14.26u w=6.66u l=0.6u
M3231 sg13cmos5l_Corner_1.vss sg13cmos5l_IOPadVdd$1_0.sg13cmos5l_Clamp_N43N43D4R$1_0.gate vdd sg13cmos5l_Corner_1.vss sg13_hv_nmos ad=1.408p pd=5.04u as=2.596p ps=5.58u w=4.4u l=0.6u
X3232 sg13cmos5l_Corner_1.vss a_175886_118222# dantenna l=27.78u w=1.26u
M3233 a_71988_99614# adc8b_0.diff_bsw_0.single_bsw_0.sg13cmos5l_inv_1$1_0.A sg13cmos5l_Corner_1.vss sg13cmos5l_Corner_1.vss sg13_lv_nmos ad=95f pd=0.88u as=0.17p ps=1.68u w=0.5u l=0.13u
M3234 a_87730_99564# a_88173_99607# a_88113_99643# vdd sg13_lv_pmos ad=79.8f pd=0.8u as=63f ps=0.72u w=0.42u l=0.13u
M3235 vddr adc8b_0.sar12b_0.nl_sw[1] adc8b_0.side_cap8b_1.buf_16_2.z vddr sg13_lv_pmos ad=0.19p pd=1.38u as=0.19p ps=1.38u w=1u l=0.13u
M3236 adc8b_0.side_cap8b_0.buf_8_3.z adc8b_0.side_cap8b_0.in_h_sw[3] sg13cmos5l_Corner_1.vss sg13cmos5l_Corner_1.vss sg13_lv_nmos ad=0.17p pd=1.68u as=95f ps=0.88u w=0.5u l=0.13u
M3237 sg13cmos5l_Corner_1.vss a_85342_99010# adc8b_0.sar12b_0.sg13cmos5l_dlhr_1_9.Q_N sg13cmos5l_Corner_1.vss sg13_lv_nmos ad=0.1491p pd=1.18u as=0.2516p ps=2.16u w=0.74u l=0.13u
M3238 a_90551_98911# a_89709_98813# a_89292_99152# vdd sg13_lv_pmos ad=0.2048p pd=1.63u as=0.34p ps=2.68u w=1u l=0.13u
M3239 adc8b_0.side_cap8b_1.buf_16_3.z adc8b_0.sar12b_0.nh_sw[1] sg13cmos5l_Corner_1.vss sg13cmos5l_Corner_1.vss sg13_lv_nmos ad=95f pd=0.88u as=95f ps=0.88u w=0.5u l=0.13u
M3240 adc8b_0.sar12b_0.sg13cmos5l_dfrbp_1_10.Q_N a_85367_94375# sg13cmos5l_Corner_1.vss sg13cmos5l_Corner_1.vss sg13_lv_nmos ad=0.2849p pd=2.25u as=0.2516p ps=2.16u w=0.74u l=0.13u
M3241 sg13cmos5l_Corner_1.vss adc8b_0.sar12b_0.nl_sw[0] adc8b_0.side_cap8b_1.buf_32_0.z sg13cmos5l_Corner_1.vss sg13_lv_nmos ad=95f pd=0.88u as=95f ps=0.88u w=0.5u l=0.13u
M3242 a_83928_96132# a_83377_95864# vdd vdd sg13_lv_pmos ad=0.105p pd=1.21u as=1.28962p ps=8.195u w=1u l=0.13u
M3243 adc8b_0.side_cap8b_1.buf_8_3.z adc8b_0.sar12b_0.nh_sw[3] vddr vddr sg13_lv_pmos ad=0.34p pd=2.68u as=0.19p ps=1.38u w=1u l=0.13u
M3244 a_99182_94298# a_99987_94420# a_99442_94521# vdd sg13_lv_pmos ad=0.1428p pd=1.52u as=79.8f ps=0.8u w=0.42u l=0.13u
M3245 sg13cmos5l_Corner_1.vss a_91799_99957# a_92636_99596# sg13cmos5l_Corner_1.vss sg13_lv_nmos ad=0.1406p pd=1.12u as=0.2516p ps=2.16u w=0.74u l=0.13u
X3246 sg13cmos5l_Corner_1.vss a_32962_118222# dantenna l=27.78u w=1.26u
M3247 adc8b_0.cmp_0.rdy a_80806_96705# vdd vdd sg13_lv_pmos ad=0.4256p pd=3u as=0.2254p ps=1.53u w=1.12u l=0.13u
M3248 vin a_42476_86044# sg13cmos5l_Corner_1.iovdd sg13cmos5l_Corner_1.iovdd sg13_hv_pmos ad=3.9294p pd=7.84u as=2.1312p ps=7.3u w=6.66u l=0.6u
M3249 vddr adc8b_0.side_cap8b_0.in_h_sw[0] adc8b_0.side_cap8b_0.buf_32_1.z vddr sg13_lv_pmos ad=0.19p pd=1.38u as=0.19p ps=1.38u w=1u l=0.13u
M3250 a_83822_94298# adc8b_0.sar12b_0.sg13cmos5l_dfrbp_1_6.D vdd vdd sg13_lv_pmos ad=79.8f pd=0.8u as=0.1428p ps=1.52u w=0.42u l=0.13u
M3251 sg13cmos5l_IOPadAnalog_10.pad a_67639_178370# sg13cmos5l_Corner_1.vss sg13cmos5l_Corner_1.vss sg13_hv_nmos ad=2.596p pd=5.58u as=1.408p ps=5.04u w=4.4u l=0.6u
M3252 sg13cmos5l_Corner_1.vss adc8b_0.sar12b_0.sg13cmos5l_dfrbp_1_6.RESET_B a_89100_98834# sg13cmos5l_Corner_1.vss sg13_lv_nmos ad=0.1626p pd=1.415u as=60.89999f ps=0.71u w=0.42u l=0.13u
M3253 adc8b_0.sar12b_0.sg13cmos5l_buf_1_4.A a_97360_97360# vdd vdd sg13_lv_pmos ad=0.42p pd=2.99u as=0.2114p ps=1.54u w=1.12u l=0.13u
M3254 a_94126_96548# adc8b_0.sar12b_0.sg13cmos5l_dfrbp_1_21.Q vdd vdd sg13_lv_pmos ad=0.1596p pd=1.22u as=0.2226p ps=1.535u w=0.84u l=0.13u
M3255 a_94802_96572# adc8b_0.sar12b_0.sg13cmos5l_nor2_1_0.A adc8b_0.sar12b_0.sg13cmos5l_or2_1_1.B vdd sg13_lv_pmos ad=0.1176p pd=1.33u as=0.3808p ps=2.92u w=1.12u l=0.13u
M3256 sg13cmos5l_Corner_1.vss adc8b_0.sar12b_0.nh_sw[0] adc8b_0.side_cap8b_1.buf_32_1.z sg13cmos5l_Corner_1.vss sg13_lv_nmos ad=95f pd=0.88u as=95f ps=0.88u w=0.5u l=0.13u
M3257 sg13cmos5l_Corner_1.vss adc8b_0.sar12b_0.sg13cmos5l_buf_1_7.A a_95824_92824# sg13cmos5l_Corner_1.vss sg13_lv_nmos ad=0.14875p pd=1.16u as=0.187p ps=1.78u w=0.55u l=0.13u
M3258 vdd adc8b_0.sar12b_0.sg13cmos5l_dfrbp_1_6.RESET_B a_86702_93986# vdd sg13_lv_pmos ad=0.36237p pd=2.605u as=79.8f ps=0.8u w=0.42u l=0.13u
M3259 a_82676_92750# adc8b_0.sar12b_0.sg13cmos5l_buf_1_32.A sg13cmos5l_Corner_1.vss sg13cmos5l_Corner_1.vss sg13_lv_nmos ad=0.187p pd=1.78u as=0.14875p ps=1.16u w=0.55u l=0.13u
M3260 a_97677_93559# adc8b_0.sar12b_0.sg13cmos5l_dfrbp_1_0.CLK sg13cmos5l_Corner_1.vss sg13cmos5l_Corner_1.vss sg13_lv_nmos ad=0.2516p pd=2.16u as=2.43055p ps=15.415u w=0.74u l=0.13u
M3261 a_99481_99998# a_98929_99954# sg13cmos5l_Corner_1.vss sg13cmos5l_Corner_1.vss sg13_lv_nmos ad=71.99999f pd=0.865u as=2.92392p ps=18.89u w=0.64u l=0.13u
M3262 a_95228_99156# a_94946_98844# a_95161_98826# sg13cmos5l_Corner_1.vss sg13_lv_nmos ad=0.141p pd=1.17u as=71.99999f ps=0.865u w=0.64u l=0.13u
M3263 vdd a_87441_94298# a_87966_94280# vdd sg13_lv_pmos ad=0.1974p pd=1.5u as=0.2856p ps=2.36u w=0.84u l=0.13u
M3264 sg13cmos5l_Corner_1.vss a_99639_178370# sg13cmos5l_IOPadAnalog_15.pad sg13cmos5l_Corner_1.vss sg13_hv_nmos ad=1.408p pd=5.04u as=2.596p ps=5.58u w=4.4u l=0.6u
M3265 sg13cmos5l_Corner_1.iovdd a_67639_164698# sg13cmos5l_IOPadAnalog_10.pad sg13cmos5l_Corner_1.iovdd sg13_hv_pmos ad=2.1312p pd=7.3u as=3.9294p ps=7.84u w=6.66u l=0.6u
M3266 adc8b_0.side_cap8b_0.buf_16_3.z adc8b_0.side_cap8b_0.in_h_sw[1] sg13cmos5l_Corner_1.vss sg13cmos5l_Corner_1.vss sg13_lv_nmos ad=95f pd=0.88u as=95f ps=0.88u w=0.5u l=0.13u
M3267 vdd a_82774_95327# adc8b_0.sar12b_0.sg13cmos5l_dlygate4sd3_1_0.X vdd sg13_lv_pmos ad=0.2254p pd=1.53u as=0.4256p ps=3u w=1.12u l=0.13u
M3268 sg13cmos5l_Corner_1.vss a_115639_178370# sg13cmos5l_IOPadAnalog_13.pad sg13cmos5l_Corner_1.vss sg13_hv_nmos ad=1.408p pd=5.04u as=2.596p ps=5.58u w=4.4u l=0.6u
M3269 sg13cmos5l_Corner_1.vss sg13cmos5l_IOPadVdd$1_0.sg13cmos5l_Clamp_N43N43D4R$1_0.gate vdd sg13cmos5l_Corner_1.vss sg13_hv_nmos ad=1.408p pd=5.04u as=2.596p ps=5.58u w=4.4u l=0.6u
M3270 vdd sg13cmos5l_IOPadVdd$1_0.sg13cmos5l_Clamp_N43N43D4R$1_0.gate sg13cmos5l_Corner_1.vss sg13cmos5l_Corner_1.vss sg13_hv_nmos ad=2.596p pd=5.58u as=1.408p ps=5.04u w=4.4u l=0.6u
M3271 vddr adc8b_0.side_cap8b_0.in_h_sw[2] adc8b_0.side_cap8b_0.buf_16_0.z vddr sg13_lv_pmos ad=0.19p pd=1.38u as=0.19p ps=1.38u w=1u l=0.13u
M3272 sg13cmos5l_Corner_1.vss vdd sg13cmos5l_Corner_1.vss sg13cmos5l_Corner_1.vss sg13_lv_nmos ad=79.8f pd=0.8u as=0 ps=0 w=0.42u l=1u
M3273 adc8b_0.side_cap8b_1.buf_8_2.z adc8b_0.sar12b_0.nh_sw[4] vddr vddr sg13_lv_pmos ad=0.19p pd=1.38u as=0.19p ps=1.38u w=1u l=0.13u
M3274 adc8b_0.sar12b_0.nl_sw[1] a_83632_92824# vdd vdd sg13_lv_pmos ad=0.42p pd=2.99u as=0.2114p ps=1.54u w=1.12u l=0.13u
M3275 vddr adc8b_0.side_cap8b_0.in_l_sw[0] adc8b_0.side_cap8b_0.buf_32_0.z vddr sg13_lv_pmos ad=0.19p pd=1.38u as=0.19p ps=1.38u w=1u l=0.13u
M3276 vdd adc8b_0.sar12b_0.sg13cmos5l_inv_1_6.A a_101776_99596# vdd sg13_lv_pmos ad=0.2114p pd=1.54u as=0.2856p ps=2.36u w=0.84u l=0.13u
M3277 adc8b_0.sar12b_0.nl_sw[2] a_84016_92824# sg13cmos5l_Corner_1.vss sg13cmos5l_Corner_1.vss sg13_lv_nmos ad=0.2886p pd=2.26u as=0.14875p ps=1.16u w=0.74u l=0.13u
M3278 sg13cmos5l_Corner_1.iovdd a_42476_102044# vip sg13cmos5l_Corner_1.iovdd sg13_hv_pmos ad=2.1312p pd=7.3u as=3.9294p ps=7.84u w=6.66u l=0.6u
M3279 sg13cmos5l_Corner_1.vss adc8b_0.side_cap8b_0.in_l_sw[7] adc8b_0.side_cap8b_0.buf_4_0.z sg13cmos5l_Corner_1.vss sg13_lv_nmos ad=95f pd=0.88u as=95f ps=0.88u w=0.5u l=0.13u
M3280 sg13cmos5l_Corner_1.vss adc8b_0.sar12b_0.sg13cmos5l_buf_1_116.A a_97360_97360# sg13cmos5l_Corner_1.vss sg13_lv_nmos ad=0.14875p pd=1.16u as=0.187p ps=1.78u w=0.55u l=0.13u
M3281 adc8b_0.sar12b_0.sg13cmos5l_nor2b_1_0.Y a_94582_95852# sg13cmos5l_Corner_1.vss sg13cmos5l_Corner_1.vss sg13_lv_nmos ad=0.1406p pd=1.12u as=0.17255p ps=1.25u w=0.74u l=0.13u
M3282 data[0] a_70044_42476# sg13cmos5l_Corner_1.iovdd sg13cmos5l_Corner_1.iovdd sg13_hv_pmos ad=3.9294p pd=7.84u as=3.1302p ps=14.26u w=6.66u l=0.6u
M3283 sg13cmos5l_Corner_1.vss adc8b_0.sar12b_0.sg13cmos5l_buf_1_60.X a_84016_100384# sg13cmos5l_Corner_1.vss sg13_lv_nmos ad=0.14875p pd=1.16u as=0.187p ps=1.78u w=0.55u l=0.13u
M3284 vdd a_99261_95107# a_98340_95421# vdd sg13_lv_pmos ad=0.36237p pd=2.605u as=0.34p ps=2.68u w=1u l=0.13u
M3285 a_93140_94262# adc8b_0.sar12b_0.sg13cmos5l_buf_1_9.A sg13cmos5l_Corner_1.vss sg13cmos5l_Corner_1.vss sg13_lv_nmos ad=0.187p pd=1.78u as=0.14875p ps=1.16u w=0.55u l=0.13u
M3286 vdd a_90356_93512# adc8b_0.sar12b_0.nl_sw[4] vdd sg13_lv_pmos ad=0.2114p pd=1.54u as=0.42p ps=2.99u w=1.12u l=0.13u
M3287 sg13cmos5l_Corner_1.iovdd a_42476_86044# vin sg13cmos5l_Corner_1.iovdd sg13_hv_pmos ad=2.1312p pd=7.3u as=3.9294p ps=7.84u w=6.66u l=0.6u
M3288 sg13cmos5l_Corner_1.iovdd a_164624_118044# sg13cmos5l_IOPadAnalog_11.pad sg13cmos5l_Corner_1.iovdd sg13_hv_pmos ad=2.1312p pd=7.3u as=3.9294p ps=7.84u w=6.66u l=0.6u
M3289 a_82388_98798# adc8b_0.sar12b_0.sg13cmos5l_buf_1_63.X sg13cmos5l_Corner_1.vss sg13cmos5l_Corner_1.vss sg13_lv_nmos ad=0.187p pd=1.78u as=0.14875p ps=1.16u w=0.55u l=0.13u
M3290 vdd adc8b_0.sar12b_0.sg13cmos5l_buf_1_98.A a_95536_99596# vdd sg13_lv_pmos ad=0.2114p pd=1.54u as=0.2856p ps=2.36u w=0.84u l=0.13u
M3291 data[2] a_102044_30676# sg13cmos5l_Corner_1.vss sg13cmos5l_Corner_1.vss sg13_hv_nmos ad=2.596p pd=5.58u as=1.408p ps=5.04u w=4.4u l=0.6u
M3292 a_82964_99560# adc8b_0.sar12b_0.sg13cmos5l_buf_1_63.A sg13cmos5l_Corner_1.vss sg13cmos5l_Corner_1.vss sg13_lv_nmos ad=0.187p pd=1.78u as=0.14875p ps=1.16u w=0.55u l=0.13u
M3293 a_93741_95071# adc8b_0.sar12b_0.sg13cmos5l_dfrbp_1_0.CLK vdd vdd sg13_lv_pmos ad=0.4088p pd=2.97u as=1.38655p ps=8.8u w=1.12u l=0.13u
M3294 vdd adc8b_0.sar12b_0.sg13cmos5l_dfrbp_1_10.Q_N a_85009_93906# vdd sg13_lv_pmos ad=1.86162p pd=11.935u as=0.2856p ps=2.36u w=0.84u l=0.13u
M3295 sg13cmos5l_Corner_1.vss adc8b_0.sar12b_0.sg13cmos5l_buf_1_44.X adc8b_0.sar12b_0.sg13cmos5l_buf_1_38.A sg13cmos5l_Corner_1.vss sg13_lv_nmos ad=0.2516p pd=2.16u as=0.2516p ps=2.16u w=0.74u l=0.13u
M3296 a_88671_94314# adc8b_0.sar12b_0.sg13cmos5l_dlhr_1_0.GATE sg13cmos5l_Corner_1.vss sg13cmos5l_Corner_1.vss sg13_lv_nmos ad=0.2516p pd=2.16u as=0.15055p ps=1.17u w=0.74u l=0.13u
M3297 a_85561_93950# a_85009_93906# sg13cmos5l_Corner_1.vss sg13cmos5l_Corner_1.vss sg13_lv_nmos ad=71.99999f pd=0.865u as=2.59257p ps=16.445u w=0.64u l=0.13u
M3298 sg13cmos5l_Corner_1.vss sg13cmos5l_IOPadVdd$1_0.sg13cmos5l_Clamp_N43N43D4R$1_0.gate vdd sg13cmos5l_Corner_1.vss sg13_hv_nmos ad=1.408p pd=5.04u as=2.596p ps=5.58u w=4.4u l=0.6u
M3299 sg13cmos5l_Corner_1.vss sg13cmos5l_IOPadVdd$1_0.sg13cmos5l_RCClampInverter$1_0.in sg13cmos5l_Corner_1.vss sg13cmos5l_Corner_1.vss sg13_hv_nmos ad=1.71p pd=9.38u as=0 ps=0 w=9u l=9.5u
M3300 vddr adc8b_0.sar12b_0.nh_sw[1] adc8b_0.side_cap8b_1.buf_16_3.z vddr sg13_lv_pmos ad=0.19p pd=1.38u as=0.19p ps=1.38u w=1u l=0.13u
M3301 sg13cmos5l_Corner_1.iovdd a_164624_86044# sg13cmos5l_IOPadAnalog_0.pad sg13cmos5l_Corner_1.iovdd sg13_hv_pmos ad=2.1312p pd=7.3u as=3.9294p ps=7.84u w=6.66u l=0.6u
M3302 sg13cmos5l_Corner_1.iovdd a_42476_102044# vip sg13cmos5l_Corner_1.iovdd sg13_hv_pmos ad=2.1312p pd=7.3u as=3.9294p ps=7.84u w=6.66u l=0.6u
M3303 a_85175_99957# a_84333_99607# a_83916_99600# vdd sg13_lv_pmos ad=0.2048p pd=1.63u as=0.34p ps=2.68u w=1u l=0.13u
M3304 adc8b_0.sar12b_0.sg13cmos5l_dfrbp_1_11.Q a_90236_96108# sg13cmos5l_Corner_1.vss sg13cmos5l_Corner_1.vss sg13_lv_nmos ad=0.2516p pd=2.16u as=0.1406p ps=1.12u w=0.74u l=0.13u
M3305 adc8b_0.sar12b_0.sg13cmos5l_dlhr_1_3.Q_N a_86334_93978# vdd vdd sg13_lv_pmos ad=0.3808p pd=2.92u as=0.1974p ps=1.5u w=1.12u l=0.13u
M3306 vdd adc8b_0.sar12b_0.sg13cmos5l_nand2_1_1.B a_92232_93587# vdd sg13_lv_pmos ad=0.2891p pd=1.695u as=0.1596p ps=1.22u w=0.84u l=0.13u
M3307 sg13cmos5l_Corner_1.vss a_30676_70044# vddr sg13cmos5l_Corner_1.vss sg13_hv_nmos ad=1.408p pd=5.04u as=2.596p ps=5.58u w=4.4u l=0.6u
M3308 a_93132_95498# adc8b_0.sar12b_0.sg13cmos5l_dfrbp_1_2.D a_93038_95498# sg13cmos5l_Corner_1.vss sg13_lv_nmos ad=60.89999f pd=0.71u as=0.1428p ps=1.52u w=0.42u l=0.13u
M3309 sg13cmos5l_Corner_1.vss a_86044_30676# data[1] sg13cmos5l_Corner_1.vss sg13_hv_nmos ad=1.408p pd=5.04u as=2.596p ps=5.58u w=4.4u l=0.6u
X3310 a_178296_86044# sg13cmos5l_Corner_1.vss sg13cmos5l_Corner_1.vss rppd l=3.54u w=0.5u
M3311 vin a_30676_86044# sg13cmos5l_Corner_1.vss sg13cmos5l_Corner_1.vss sg13_hv_nmos ad=2.596p pd=5.58u as=1.408p ps=5.04u w=4.4u l=0.6u
M3312 vdd a_100995_95814# adc8b_0.sar12b_0.sg13cmos5l_buf_8_0.X vdd sg13_lv_pmos ad=0.2128p pd=1.5u as=0.2128p ps=1.5u w=1.12u l=0.13u
M3313 sg13cmos5l_Corner_1.vss sg13cmos5l_IOPadVdd$1_0.sg13cmos5l_RCClampInverter$1_0.in sg13cmos5l_Corner_1.vss sg13cmos5l_Corner_1.vss sg13_hv_nmos ad=1.71p pd=9.38u as=0 ps=0 w=9u l=9.5u
M3314 a_82774_95327# a_82889_95326# vdd vdd sg13_lv_pmos ad=0.34p pd=2.68u as=0.2254p ps=1.53u w=1u l=0.5u
M3315 a_100068_98870# a_99519_98850# a_99932_99156# sg13cmos5l_Corner_1.vss sg13_lv_nmos ad=47.25f pd=0.645u as=0.141p ps=1.17u w=0.42u l=0.13u
M3316 vdd a_85844_96536# adc8b_0.sar12b_0.sg13cmos5l_inv_1_17.A vdd sg13_lv_pmos ad=0.2114p pd=1.54u as=0.42p ps=2.99u w=1.12u l=0.13u
M3317 a_95364_98870# a_94815_98850# a_95228_99156# sg13cmos5l_Corner_1.vss sg13_lv_nmos ad=47.25f pd=0.645u as=0.141p ps=1.17u w=0.42u l=0.13u
M3318 sg13cmos5l_Corner_1.vss adc8b_0.sar12b_0.nl_sw[1] adc8b_0.side_cap8b_1.buf_16_2.z sg13cmos5l_Corner_1.vss sg13_lv_nmos ad=95f pd=0.88u as=0.17p ps=1.68u w=0.5u l=0.13u
M3319 vdd sg13cmos5l_IOPadVdd$1_0.sg13cmos5l_RCClampInverter$1_0.in sg13cmos5l_IOPadVdd$1_0.sg13cmos5l_Clamp_N43N43D4R$1_0.gate vdd sg13_hv_pmos ad=1.33p pd=7.38u as=1.33p ps=7.38u w=7u l=0.5u
M3320 adc8b_0.sar12b_0.sg13cmos5l_dfrbp_1_18.Q_N a_89015_99957# vdd vdd sg13_lv_pmos ad=0.4312p pd=3.01u as=0.2639p ps=1.81u w=1.12u l=0.13u
M3321 adc8b_0.side_cap8b_1.buf_32_1.z adc8b_0.sar12b_0.nh_sw[0] vddr vddr sg13_lv_pmos ad=0.19p pd=1.38u as=0.19p ps=1.38u w=1u l=0.13u
M3322 sg13cmos5l_Corner_1.iovdd a_42476_70044# vddr sg13cmos5l_Corner_1.iovdd sg13_hv_pmos ad=3.1302p pd=14.26u as=3.9294p ps=7.84u w=6.66u l=0.6u
M3323 adc8b_0.sar12b_0.sg13cmos5l_buf_1_87.A a_100144_100384# sg13cmos5l_Corner_1.vss sg13cmos5l_Corner_1.vss sg13_lv_nmos ad=0.2886p pd=2.26u as=0.14875p ps=1.16u w=0.74u l=0.13u
M3324 a_98061_95789# adc8b_0.sar12b_0.sg13cmos5l_inv_1_2.A vdd vdd sg13_lv_pmos ad=0.4088p pd=2.97u as=1.28962p ps=8.195u w=1.12u l=0.13u
M3325 sg13cmos5l_Corner_1.iovdd a_164624_102044# sg13cmos5l_IOPadAnalog_16.pad sg13cmos5l_Corner_1.iovdd sg13_hv_pmos ad=2.1312p pd=7.3u as=3.9294p ps=7.84u w=6.66u l=0.6u
M3326 sg13cmos5l_Corner_1.vss a_67639_178370# sg13cmos5l_IOPadAnalog_10.pad sg13cmos5l_Corner_1.vss sg13_hv_nmos ad=1.408p pd=5.04u as=2.596p ps=5.58u w=4.4u l=0.6u
M3327 sg13cmos5l_Corner_1.vss vdd sg13cmos5l_Corner_1.vss sg13cmos5l_Corner_1.vss sg13_lv_nmos ad=0.1428p pd=1.52u as=0 ps=0 w=0.42u l=1u
M3328 vip a_42476_102044# sg13cmos5l_Corner_1.iovdd sg13cmos5l_Corner_1.iovdd sg13_hv_pmos ad=3.9294p pd=7.84u as=2.1312p ps=7.3u w=6.66u l=0.6u
M3329 a_93681_95107# a_93324_95064# vdd vdd sg13_lv_pmos ad=63f pd=0.72u as=0.1563p ps=1.22u w=0.42u l=0.13u
M3330 a_85343_97713# adc8b_0.sar12b_0.sg13cmos5l_dfrbp_1_8.RESET_B vdd vdd sg13_lv_pmos ad=79.8f pd=0.8u as=0.36237p ps=2.605u w=0.42u l=0.13u
M3331 a_101180_97644# a_100767_97338# a_101112_97644# vdd sg13_lv_pmos ad=0.191p pd=1.44u as=0.105p ps=1.21u w=1u l=0.13u
M3332 sg13cmos5l_Corner_1.vss a_178296_102044# sg13cmos5l_IOPadAnalog_16.pad sg13cmos5l_Corner_1.vss sg13_hv_nmos ad=1.408p pd=5.04u as=2.596p ps=5.58u w=4.4u l=0.6u
M3333 sg13cmos5l_Corner_1.vss adc8b_0.side_cap8b_0.in_h_sw[0] adc8b_0.side_cap8b_0.buf_32_1.z sg13cmos5l_Corner_1.vss sg13_lv_nmos ad=95f pd=0.88u as=95f ps=0.88u w=0.5u l=0.13u
M3334 vdd adc8b_0.sar12b_0.sg13cmos5l_buf_1_4.A a_98320_92824# vdd sg13_lv_pmos ad=0.2114p pd=1.54u as=0.2856p ps=2.36u w=0.84u l=0.13u
M3335 sg13cmos5l_Corner_1.vss a_30676_86044# vin sg13cmos5l_Corner_1.vss sg13_hv_nmos ad=2.068p pd=9.74u as=2.596p ps=5.58u w=4.4u l=0.6u
M3336 sg13cmos5l_Corner_1.vss adc8b_0.sar12b_0.sg13cmos5l_dfrbp_1_8.RESET_B a_87314_97010# sg13cmos5l_Corner_1.vss sg13_lv_nmos ad=79.8f pd=0.8u as=37.8f ps=0.6u w=0.42u l=0.13u
M3337 data[2] a_102044_42476# sg13cmos5l_Corner_1.iovdd sg13cmos5l_Corner_1.iovdd sg13_hv_pmos ad=3.9294p pd=7.84u as=2.1312p ps=7.3u w=6.66u l=0.6u
M3338 vdd adc8b_0.sar12b_0.sg13cmos5l_inv_1_1.A a_98032_100384# vdd sg13_lv_pmos ad=0.2114p pd=1.54u as=0.2856p ps=2.36u w=0.84u l=0.13u
M3339 adc8b_0.side_cap8b_1.buf_32_0.z adc8b_0.sar12b_0.nl_sw[0] sg13cmos5l_Corner_1.vss sg13cmos5l_Corner_1.vss sg13_lv_nmos ad=95f pd=0.88u as=95f ps=0.88u w=0.5u l=0.13u
M3340 vin a_42476_86044# sg13cmos5l_Corner_1.iovdd sg13cmos5l_Corner_1.iovdd sg13_hv_pmos ad=3.9294p pd=7.84u as=2.1312p ps=7.3u w=6.66u l=0.6u
M3341 sg13cmos5l_Corner_1.iovdd a_42476_70044# vddr sg13cmos5l_Corner_1.iovdd sg13_hv_pmos ad=2.1312p pd=7.3u as=3.9294p ps=7.84u w=6.66u l=0.6u
M3342 vdd adc8b_0.sar12b_0.sg13cmos5l_dlhr_1_0.D a_88657_92840# vdd sg13_lv_pmos ad=1.86162p pd=11.935u as=0.2856p ps=2.36u w=0.84u l=0.13u
M3343 a_99276_94298# adc8b_0.sar12b_0.sg13cmos5l_a22oi_1_1.Y a_99182_94298# sg13cmos5l_Corner_1.vss sg13_lv_nmos ad=60.89999f pd=0.71u as=0.1428p ps=1.52u w=0.42u l=0.13u
M3344 vdd sg13cmos5l_IOPadVdd$1_0.sg13cmos5l_Clamp_N43N43D4R$1_0.gate sg13cmos5l_Corner_1.vss sg13cmos5l_Corner_1.vss sg13_hv_nmos ad=2.596p pd=5.58u as=1.408p ps=5.04u w=4.4u l=0.6u
M3345 adc8b_0.sar12b_0.sg13cmos5l_buf_1_9.A a_91600_92824# sg13cmos5l_Corner_1.vss sg13cmos5l_Corner_1.vss sg13_lv_nmos ad=0.2886p pd=2.26u as=0.14875p ps=1.16u w=0.74u l=0.13u
M3346 adc8b_0.side_cap8b_0.buf_2_2.z adc8b_0.side_cap8b_0.in_l_sw[9] vddr vddr sg13_lv_pmos ad=0.34p pd=2.68u as=0.19p ps=1.38u w=1u l=0.13u
M3347 sg13cmos5l_Corner_1.vss adc8b_0.side_cap8b_0.in_h_sw[7] adc8b_0.side_cap8b_0.buf_4_2.z sg13cmos5l_Corner_1.vss sg13_lv_nmos ad=95f pd=0.88u as=95f ps=0.88u w=0.5u l=0.13u
M3348 vdd a_100995_95814# adc8b_0.sar12b_0.sg13cmos5l_buf_8_0.X vdd sg13_lv_pmos ad=0.2128p pd=1.5u as=0.2128p ps=1.5u w=1.12u l=0.13u
M3349 vdd adc8b_0.sar12b_0.sg13cmos5l_buf_1_24.X a_87472_92824# vdd sg13_lv_pmos ad=0.2114p pd=1.54u as=0.2856p ps=2.36u w=0.84u l=0.13u
M3350 sg13cmos5l_Corner_1.vss a_100984_94518# a_100633_94375# sg13cmos5l_Corner_1.vss sg13_lv_nmos ad=79.8f pd=0.8u as=0.1428p ps=1.52u w=0.42u l=0.13u
M3351 adc8b_0.side_cap8b_0.buf_32_1.z adc8b_0.side_cap8b_0.in_h_sw[0] vddr vddr sg13_lv_pmos ad=0.19p pd=1.38u as=0.19p ps=1.38u w=1u l=0.13u
M3352 a_94680_98084# a_94129_98442# vdd vdd sg13_lv_pmos ad=0.105p pd=1.21u as=1.07253p ps=6.75u w=1u l=0.13u
M3353 a_99095_98445# a_98253_98095# a_99001_98445# sg13cmos5l_Corner_1.vss sg13_lv_nmos ad=0.12665p pd=1.145u as=0.1428p ps=1.52u w=0.42u l=0.13u
M3354 sg13cmos5l_IOPadAnalog_9.pad a_83639_164698# sg13cmos5l_Corner_1.iovdd sg13cmos5l_Corner_1.iovdd sg13_hv_pmos ad=3.9294p pd=7.84u as=2.1312p ps=7.3u w=6.66u l=0.6u
M3355 a_99352_98326# adc8b_0.sar12b_0.sg13cmos5l_dfrbp_1_8.RESET_B vdd vdd sg13_lv_pmos ad=79.8f pd=0.8u as=1.04815p ps=6.595u w=0.42u l=0.13u
M3356 vdd a_98903_95887# a_99740_96108# vdd sg13_lv_pmos ad=0.2128p pd=1.5u as=0.3864p ps=2.93u w=1.12u l=0.13u
M3357 a_90225_98441# a_90044_98084# vdd vdd sg13_lv_pmos ad=0.2128p pd=1.5u as=0.2387p ps=1.84u w=1.12u l=0.13u
M3358 a_97618_96033# a_98061_95789# a_98001_96201# vdd sg13_lv_pmos ad=79.8f pd=0.8u as=63f ps=0.72u w=0.42u l=0.13u
M3359 vdd a_97589_95024# adc8b_0.sar12b_0.sg13cmos5l_dfrbp_1_6.Q_N vdd sg13_lv_pmos ad=0.2639p pd=1.81u as=0.4312p ps=3.01u w=1.12u l=0.13u
M3360 cks a_42476_118044# sg13cmos5l_Corner_1.iovdd sg13cmos5l_Corner_1.iovdd sg13_hv_pmos ad=3.9294p pd=7.84u as=2.1312p ps=7.3u w=6.66u l=0.6u
M3361 a_86050_99272# a_85444_99124# vdd vdd sg13_lv_pmos ad=0.1008p pd=0.9u as=0.2387p ps=1.84u w=0.42u l=0.13u
M3362 vdd sg13cmos5l_Corner_1.vss vdd vdd sg13_lv_pmos ad=0.19p pd=1.38u as=0 ps=0 w=1u l=1u
M3363 sg13cmos5l_Corner_1.vss adc8b_0.sar12b_0.nh_sw[5] adc8b_0.side_cap8b_1.buf_8_5.z sg13cmos5l_Corner_1.vss sg13_lv_nmos ad=95f pd=0.88u as=95f ps=0.88u w=0.5u l=0.13u
M3364 vddr adc8b_0.sar12b_0.nl_sw[0] adc8b_0.side_cap8b_1.buf_32_0.z vddr sg13_lv_pmos ad=0.19p pd=1.38u as=0.19p ps=1.38u w=1u l=0.13u
M3365 vdd adc8b_0.sar12b_0.sg13cmos5l_dfrbp_1_6.RESET_B a_82450_98052# vdd sg13_lv_pmos ad=0.1563p pd=1.22u as=0.147p ps=1.54u w=0.42u l=0.13u
M3366 vdd sg13cmos5l_Corner_1.vss vdd vdd sg13_lv_pmos ad=0.19p pd=1.38u as=0 ps=0 w=1u l=1u
M3367 a_100984_94518# a_100727_94375# a_101146_94298# sg13cmos5l_Corner_1.vss sg13_lv_nmos ad=0.1428p pd=1.52u as=37.8f ps=0.6u w=0.42u l=0.13u
M3368 vdd adc8b_0.sar12b_0.sg13cmos5l_buf_1_86.A a_102160_98084# vdd sg13_lv_pmos ad=0.2114p pd=1.54u as=0.2856p ps=2.36u w=0.84u l=0.13u
M3369 vdd adc8b_0.sar12b_0.sg13cmos5l_dfrbp_1_6.RESET_B a_90801_97322# vdd sg13_lv_pmos ad=0.2128p pd=1.5u as=0.2128p ps=1.5u w=1.12u l=0.13u
M3370 vdd adc8b_0.sar12b_0.sg13cmos5l_or2_1_1.B a_92188_96572# vdd sg13_lv_pmos ad=0.3808p pd=2.92u as=0.2128p ps=1.5u w=1.12u l=0.13u
M3371 sg13cmos5l_Corner_1.iovdd a_131639_164698# sg13cmos5l_IOPadAnalog_12.pad sg13cmos5l_Corner_1.iovdd sg13_hv_pmos ad=2.1312p pd=7.3u as=3.9294p ps=7.84u w=6.66u l=0.6u
M3372 sg13cmos5l_Corner_1.iovdd a_42476_86044# vin sg13cmos5l_Corner_1.iovdd sg13_hv_pmos ad=2.1312p pd=7.3u as=3.9294p ps=7.84u w=6.66u l=0.6u
M3373 sg13cmos5l_Corner_1.iovdd a_86044_42476# data[1] sg13cmos5l_Corner_1.iovdd sg13_hv_pmos ad=2.1312p pd=7.3u as=3.9294p ps=7.84u w=6.66u l=0.6u
M3374 adc8b_0.sar12b_0.sg13cmos5l_buf_1_31.X a_82192_92824# vdd vdd sg13_lv_pmos ad=0.42p pd=2.99u as=0.2114p ps=1.54u w=1.12u l=0.13u
M3375 vdd a_86718_96859# adc8b_0.sar12b_0.sg13cmos5l_dlhr_1_5.GATE vdd sg13_lv_pmos ad=0.2128p pd=1.5u as=0.3808p ps=2.92u w=1.12u l=0.13u
M3376 sg13cmos5l_Corner_1.vss adc8b_0.sar12b_0.sg13cmos5l_dlygate4sd2_1_0.A a_82670_94302# sg13cmos5l_Corner_1.vss sg13_lv_nmos ad=0.1323p pd=1.05u as=0.1428p ps=1.52u w=0.42u l=0.13u
M3377 sg13cmos5l_Corner_1.vss a_84500_92750# adc8b_0.sar12b_0.sg13cmos5l_buf_1_35.A sg13cmos5l_Corner_1.vss sg13_lv_nmos ad=0.14875p pd=1.16u as=0.2886p ps=2.26u w=0.74u l=0.13u
M3378 sg13cmos5l_Corner_1.vss sg13cmos5l_IOPadVdd$1_0.sg13cmos5l_Clamp_N43N43D4R$1_0.gate vdd sg13cmos5l_Corner_1.vss sg13_hv_nmos ad=1.408p pd=5.04u as=2.596p ps=5.58u w=4.4u l=0.6u
M3379 a_90360_96572# a_89809_96930# vdd vdd sg13_lv_pmos ad=0.105p pd=1.21u as=1.28962p ps=8.195u w=1u l=0.13u
M3380 sg13cmos5l_IOPadAnalog_0.pad a_164624_86044# sg13cmos5l_Corner_1.iovdd sg13cmos5l_Corner_1.iovdd sg13_hv_pmos ad=3.9294p pd=7.84u as=2.1312p ps=7.3u w=6.66u l=0.6u
M3381 vddr adc8b_0.sar12b_0.nl_sw[7] adc8b_0.side_cap8b_1.buf_4_0.z vddr sg13_lv_pmos ad=0.19p pd=1.38u as=0.19p ps=1.38u w=1u l=0.13u
M3382 adc8b_0.side_cap8b_1.buf_16_1.z adc8b_0.sar12b_0.nl_sw[2] sg13cmos5l_Corner_1.vss sg13cmos5l_Corner_1.vss sg13_lv_nmos ad=95f pd=0.88u as=95f ps=0.88u w=0.5u l=0.13u
M3383 a_88148_98798# adc8b_0.sar12b_0.sg13cmos5l_buf_1_78.X sg13cmos5l_Corner_1.vss sg13cmos5l_Corner_1.vss sg13_lv_nmos ad=0.187p pd=1.78u as=0.14875p ps=1.16u w=0.55u l=0.13u
M3384 sg13cmos5l_Corner_1.iovdd a_118044_42476# cko sg13cmos5l_Corner_1.iovdd sg13_hv_pmos ad=2.1312p pd=7.3u as=3.9294p ps=7.84u w=6.66u l=0.6u
M3385 adc8b_0.side_cap8b_0.buf_16_2.z adc8b_0.side_cap8b_0.in_l_sw[1] sg13cmos5l_Corner_1.vss sg13cmos5l_Corner_1.vss sg13_lv_nmos ad=95f pd=0.88u as=95f ps=0.88u w=0.5u l=0.13u
M3386 data[2] a_102044_42476# sg13cmos5l_Corner_1.iovdd sg13cmos5l_Corner_1.iovdd sg13_hv_pmos ad=3.9294p pd=7.84u as=2.1312p ps=7.3u w=6.66u l=0.6u
M3387 adc8b_0.sar12b_0.sg13cmos5l_buf_8_0.A a_100248_96188# sg13cmos5l_Corner_1.vss sg13cmos5l_Corner_1.vss sg13_lv_nmos ad=0.2516p pd=2.16u as=0.1469p ps=1.155u w=0.74u l=0.13u
M3388 sg13cmos5l_Corner_1.vss a_89080_95302# a_88729_95421# sg13cmos5l_Corner_1.vss sg13_lv_nmos ad=79.8f pd=0.8u as=0.1428p ps=1.52u w=0.42u l=0.13u
M3389 adc8b_0.sar12b_0.sg13cmos5l_dfrbp_1_14.Q_N a_86615_95887# sg13cmos5l_Corner_1.vss sg13cmos5l_Corner_1.vss sg13_lv_nmos ad=0.2849p pd=2.25u as=0.2516p ps=2.16u w=0.74u l=0.13u
M3390 vdd adc8b_0.sar12b_0.sg13cmos5l_buf_8_0.A a_100995_95814# vdd sg13_lv_pmos ad=0.2128p pd=1.5u as=0.3808p ps=2.92u w=1.12u l=0.13u
M3391 sg13cmos5l_Corner_1.vss adc8b_0.side_cap8b_0.in_l_sw[4] adc8b_0.side_cap8b_0.buf_8_0.z sg13cmos5l_Corner_1.vss sg13_lv_nmos ad=95f pd=0.88u as=95f ps=0.88u w=0.5u l=0.13u
M3392 sg13cmos5l_Corner_1.vss a_100113_98834# a_100638_98816# sg13cmos5l_Corner_1.vss sg13_lv_nmos ad=0.1491p pd=1.18u as=0.187p ps=1.78u w=0.55u l=0.13u
M3393 sg13cmos5l_Corner_1.vss a_85844_96536# adc8b_0.sar12b_0.sg13cmos5l_inv_1_17.A sg13cmos5l_Corner_1.vss sg13_lv_nmos ad=0.14875p pd=1.16u as=0.2886p ps=2.26u w=0.74u l=0.13u
M3394 adc8b_0.side_cap8b_1.buf_8_1.z adc8b_0.sar12b_0.nl_sw[3] sg13cmos5l_Corner_1.vss sg13cmos5l_Corner_1.vss sg13_lv_nmos ad=95f pd=0.88u as=95f ps=0.88u w=0.5u l=0.13u
M3395 vip a_42476_102044# sg13cmos5l_Corner_1.iovdd sg13cmos5l_Corner_1.iovdd sg13_hv_pmos ad=3.9294p pd=7.84u as=2.1312p ps=7.3u w=6.66u l=0.6u
M3396 vddr adc8b_0.side_cap8b_0.in_l_sw[2] adc8b_0.side_cap8b_0.buf_16_1.z vddr sg13_lv_pmos ad=0.19p pd=1.38u as=0.19p ps=1.38u w=1u l=0.13u
M3397 sg13cmos5l_Corner_1.vss adc8b_0.sar12b_0.sg13cmos5l_nand2_1_1.B a_91862_93940# sg13cmos5l_Corner_1.vss sg13_lv_nmos ad=0.2516p pd=2.16u as=96.2f ps=1u w=0.74u l=0.13u
M3398 a_100727_94375# a_99885_94277# a_100633_94375# sg13cmos5l_Corner_1.vss sg13_lv_nmos ad=0.12665p pd=1.145u as=0.1428p ps=1.52u w=0.42u l=0.13u
M3399 sg13cmos5l_Corner_1.vss adc8b_0.side_cap8b_0.in_l_sw[2] adc8b_0.side_cap8b_0.buf_16_1.z sg13cmos5l_Corner_1.vss sg13_lv_nmos ad=95f pd=0.88u as=95f ps=0.88u w=0.5u l=0.13u
M3400 frame a_134044_42476# sg13cmos5l_Corner_1.iovdd sg13cmos5l_Corner_1.iovdd sg13_hv_pmos ad=3.9294p pd=7.84u as=2.1312p ps=7.3u w=6.66u l=0.6u
M3401 sg13cmos5l_Corner_1.vss a_86044_30676# data[1] sg13cmos5l_Corner_1.vss sg13_hv_nmos ad=1.408p pd=5.04u as=2.596p ps=5.58u w=4.4u l=0.6u
M3402 sg13cmos5l_Corner_1.vss adc8b_0.sar12b_0.sg13cmos5l_dfrbp_1_6.RESET_B a_86428_98472# sg13cmos5l_Corner_1.vss sg13_lv_nmos ad=0.1406p pd=1.12u as=77.7f ps=0.95u w=0.74u l=0.13u
M3403 sg13cmos5l_Corner_1.vss vdd sg13cmos5l_Corner_1.vss sg13cmos5l_Corner_1.vss sg13_lv_nmos ad=79.8f pd=0.8u as=0 ps=0 w=0.42u l=1u
X3404 sg13cmos5l_Corner_1.vss a_175886_102222# dantenna l=27.78u w=1.26u
M3405 sg13cmos5l_Corner_1.iovdd a_164624_86044# sg13cmos5l_IOPadAnalog_0.pad sg13cmos5l_Corner_1.iovdd sg13_hv_pmos ad=2.1312p pd=7.3u as=3.9294p ps=7.84u w=6.66u l=0.6u
M3406 vdd a_89631_98442# a_89762_98448# vdd sg13_lv_pmos ad=1.07253p pd=6.75u as=0.2856p ps=2.36u w=0.84u l=0.13u
M3407 a_92188_96572# adc8b_0.sar12b_0.sg13cmos5l_dfrbp_1_16.Q a_92086_96572# vdd sg13_lv_pmos ad=0.2128p pd=1.5u as=0.2128p ps=1.5u w=1.12u l=0.13u
M3408 vdd a_91473_95810# a_91406_96248# vdd sg13_lv_pmos ad=0.2387p pd=1.84u as=0.1008p ps=0.9u w=0.42u l=0.13u
M3409 sg13cmos5l_Corner_1.vss a_85432_95302# a_85081_95421# sg13cmos5l_Corner_1.vss sg13_lv_nmos ad=79.8f pd=0.8u as=0.1428p ps=1.52u w=0.42u l=0.13u
M3410 vdd adc8b_0.sar12b_0.sg13cmos5l_dfrbp_1_6.RESET_B a_87442_97545# vdd sg13_lv_pmos ad=0.1563p pd=1.22u as=0.147p ps=1.54u w=0.42u l=0.13u
M3411 sg13cmos5l_IOPadAnalog_15.pad a_99639_164698# sg13cmos5l_Corner_1.iovdd sg13cmos5l_Corner_1.iovdd sg13_hv_pmos ad=3.9294p pd=7.84u as=2.1312p ps=7.3u w=6.66u l=0.6u
M3412 a_85437_97480# adc8b_0.sar12b_0.sg13cmos5l_dfrbp_1_8.RESET_B vdd vdd sg13_lv_pmos ad=0.147p pd=1.54u as=0.1563p ps=1.22u w=0.42u l=0.13u
M3413 sg13cmos5l_Corner_1.vss sg13cmos5l_IOPadVdd$1_0.sg13cmos5l_Clamp_N43N43D4R$1_0.gate vdd sg13cmos5l_Corner_1.vss sg13_hv_nmos ad=1.408p pd=5.04u as=2.596p ps=5.58u w=4.4u l=0.6u
M3414 a_90879_95826# adc8b_0.sar12b_0.sg13cmos5l_dfrbp_1_11.Q vdd vdd sg13_lv_pmos ad=0.3234p pd=2.45u as=1.2517p ps=7.955u w=0.84u l=0.13u
M3415 vdd adc8b_0.sar12b_0.sg13cmos5l_buf_1_44.X adc8b_0.sar12b_0.sg13cmos5l_buf_1_38.A vdd sg13_lv_pmos ad=0.3808p pd=2.92u as=0.3808p ps=2.92u w=1.12u l=0.13u
M3416 sg13cmos5l_IOPadAnalog_0.pad a_164624_86044# sg13cmos5l_Corner_1.iovdd sg13cmos5l_Corner_1.iovdd sg13_hv_pmos ad=3.9294p pd=7.84u as=2.1312p ps=7.3u w=6.66u l=0.6u
M3417 adc8b_0.side_cap8b_1.buf_4_1.z adc8b_0.sar12b_0.nh_sw[6] sg13cmos5l_Corner_1.vss sg13cmos5l_Corner_1.vss sg13_lv_nmos ad=95f pd=0.88u as=95f ps=0.88u w=0.5u l=0.13u
M3418 vddr adc8b_0.sar12b_0.nh_sw[0] adc8b_0.side_cap8b_1.buf_32_1.z vddr sg13_lv_pmos ad=0.19p pd=1.38u as=0.19p ps=1.38u w=1u l=0.13u
M3419 sg13cmos5l_IOPadAnalog_13.pad a_115639_164698# sg13cmos5l_Corner_1.iovdd sg13cmos5l_Corner_1.iovdd sg13_hv_pmos ad=3.9294p pd=7.84u as=2.1312p ps=7.3u w=6.66u l=0.6u
M3420 sg13cmos5l_IOPadAnalog_11.pad a_164624_118044# sg13cmos5l_Corner_1.iovdd sg13cmos5l_Corner_1.iovdd sg13_hv_pmos ad=3.9294p pd=7.84u as=2.1312p ps=7.3u w=6.66u l=0.6u
M3421 adc8b_0.side_cap8b_1.buf_16_1.z adc8b_0.sar12b_0.nl_sw[2] vddr vddr sg13_lv_pmos ad=0.34p pd=2.68u as=0.19p ps=1.38u w=1u l=0.13u
M3422 a_90932_92750# adc8b_0.sar12b_0.sg13cmos5l_buf_1_26.A sg13cmos5l_Corner_1.vss sg13cmos5l_Corner_1.vss sg13_lv_nmos ad=0.187p pd=1.78u as=0.14875p ps=1.16u w=0.55u l=0.13u
M3423 sg13cmos5l_Corner_1.vss adc8b_0.sar12b_0.sg13cmos5l_dlhr_1_2.D a_88465_94352# sg13cmos5l_Corner_1.vss sg13_lv_nmos ad=0.15055p pd=1.17u as=0.187p ps=1.78u w=0.55u l=0.13u
M3424 sg13cmos5l_Corner_1.iovdd a_83639_164698# sg13cmos5l_IOPadAnalog_9.pad sg13cmos5l_Corner_1.iovdd sg13_hv_pmos ad=2.1312p pd=7.3u as=3.9294p ps=7.84u w=6.66u l=0.6u
X3425 sg13cmos5l_Corner_1.vss a_32962_102222# dantenna l=27.78u w=1.26u
M3426 adc8b_0.sar12b_0.sg13cmos5l_dfrbp_1_11.Q_N a_89399_95887# vdd vdd sg13_lv_pmos ad=0.4312p pd=3.01u as=0.2639p ps=1.81u w=1.12u l=0.13u
M3427 vddr a_42476_70044# sg13cmos5l_Corner_1.iovdd sg13cmos5l_Corner_1.iovdd sg13_hv_pmos ad=3.9294p pd=7.84u as=2.1312p ps=7.3u w=6.66u l=0.6u
M3428 a_90957_99607# adc8b_0.sar12b_0.sg13cmos5l_inv_1_2.A vdd vdd sg13_lv_pmos ad=0.4088p pd=2.97u as=1.12242p ps=7u w=1.12u l=0.13u
M3429 sg13cmos5l_Corner_1.vss adc8b_0.sar12b_0.sg13cmos5l_dfrbp_1_6.RESET_B a_101212_96960# sg13cmos5l_Corner_1.vss sg13_lv_nmos ad=0.1406p pd=1.12u as=77.7f ps=0.95u w=0.74u l=0.13u
M3430 vdd a_99135_99954# a_99266_99960# vdd sg13_lv_pmos ad=1.15047p pd=7.175u as=0.2856p ps=2.36u w=0.84u l=0.13u
M3431 vdd a_93335_98911# a_94172_99132# vdd sg13_lv_pmos ad=0.2128p pd=1.5u as=0.3864p ps=2.93u w=1.12u l=0.13u
X3432 a_118044_42476# sg13cmos5l_Corner_1.iovdd sg13cmos5l_Corner_1.iovdd rppd l=12.9u w=0.5u
M3433 adc8b_0.side_cap8b_1.buf_16_3.z adc8b_0.sar12b_0.nh_sw[1] sg13cmos5l_Corner_1.vss sg13cmos5l_Corner_1.vss sg13_lv_nmos ad=95f pd=0.88u as=95f ps=0.88u w=0.5u l=0.13u
M3434 a_91862_93940# adc8b_0.sar12b_0.sg13cmos5l_inv_1_11.Y adc8b_0.sar12b_0.sg13cmos5l_dfrbp_1_1.D sg13cmos5l_Corner_1.vss sg13_lv_nmos ad=96.2f pd=1u as=0.2664p ps=1.46u w=0.74u l=0.13u
M3435 vddr adc8b_0.side_cap8b_0.in_l_sw[3] adc8b_0.side_cap8b_0.buf_8_1.z vddr sg13_lv_pmos ad=0.19p pd=1.38u as=0.19p ps=1.38u w=1u l=0.13u
M3436 a_93998_97322# a_94803_97444# a_94258_97545# vdd sg13_lv_pmos ad=0.1428p pd=1.52u as=79.8f ps=0.8u w=0.42u l=0.13u
M3437 adc8b_0.cmp_0.sg13cmos5l_inv_1$1_0.Y adc8b_0.cmp_0.outp vdd vdd sg13_lv_pmos ad=0.3808p pd=2.92u as=0.3808p ps=2.92u w=1.12u l=0.13u
M3438 vdd adc8b_0.sar12b_0.sg13cmos5l_buf_8_0.X a_102160_98872# vdd sg13_lv_pmos ad=0.2114p pd=1.54u as=0.2856p ps=2.36u w=0.84u l=0.13u
M3439 adc8b_0.sar12b_0.sg13cmos5l_buf_1_3.X a_102064_92824# sg13cmos5l_Corner_1.vss sg13cmos5l_Corner_1.vss sg13_lv_nmos ad=0.2886p pd=2.26u as=0.14875p ps=1.16u w=0.74u l=0.13u
X3440 sg13cmos5l_Corner_1.vss a_134222_176786# dantenna l=1.26u w=27.78u
M3441 sg13cmos5l_Corner_1.iovdd a_42476_118044# cks sg13cmos5l_Corner_1.iovdd sg13_hv_pmos ad=2.1312p pd=7.3u as=3.9294p ps=7.84u w=6.66u l=0.6u
M3442 a_97197_98813# adc8b_0.sar12b_0.sg13cmos5l_dfrbp_1_22.D sg13cmos5l_Corner_1.vss sg13cmos5l_Corner_1.vss sg13_lv_nmos ad=0.2516p pd=2.16u as=1.49685p ps=9.6u w=0.74u l=0.13u
M3443 sg13cmos5l_Corner_1.vss a_97589_95024# adc8b_0.sar12b_0.sg13cmos5l_dfrbp_1_6.Q_N sg13cmos5l_Corner_1.vss sg13_lv_nmos ad=0.2516p pd=2.16u as=0.2849p ps=2.25u w=0.74u l=0.13u
M3444 cko a_118044_30676# sg13cmos5l_Corner_1.vss sg13cmos5l_Corner_1.vss sg13_hv_nmos ad=2.596p pd=5.58u as=1.408p ps=5.04u w=4.4u l=0.6u
M3445 a_82764_96997# a_82476_96576# a_82702_96997# sg13cmos5l_Corner_1.vss sg13_lv_nmos ad=0.1428p pd=1.52u as=37.8f ps=0.6u w=0.42u l=0.13u
M3446 sg13cmos5l_Corner_1.iovdd a_86044_42476# data[1] sg13cmos5l_Corner_1.iovdd sg13_hv_pmos ad=2.1312p pd=7.3u as=3.9294p ps=7.84u w=6.66u l=0.6u
M3447 sg13cmos5l_Corner_1.iovdd a_164624_70044# sg13cmos5l_IOPadAnalog_1.pad sg13cmos5l_Corner_1.iovdd sg13_hv_pmos ad=3.1302p pd=14.26u as=3.9294p ps=7.84u w=6.66u l=0.6u
M3448 sg13cmos5l_Corner_1.iovdd a_164624_118044# sg13cmos5l_IOPadAnalog_11.pad sg13cmos5l_Corner_1.iovdd sg13_hv_pmos ad=2.1312p pd=7.3u as=3.9294p ps=7.84u w=6.66u l=0.6u
M3449 a_87276_93973# a_87507_93559# a_86962_93516# sg13cmos5l_Corner_1.vss sg13_lv_nmos ad=0.2373p pd=1.97u as=79.8f ps=0.8u w=0.42u l=0.13u
M3450 vdd a_95800_97542# a_95745_97637# vdd sg13_lv_pmos ad=1.07253p pd=6.75u as=93.45f ps=0.865u w=0.42u l=0.13u
X3451 data[1] sg13cmos5l_Corner_1.iovdd dpantenna l=1.26u w=27.78u
M3452 a_93612_92799# a_93843_92908# a_93298_93009# sg13cmos5l_Corner_1.vss sg13_lv_nmos ad=0.2373p pd=1.97u as=79.8f ps=0.8u w=0.42u l=0.13u
M3453 adc8b_0.side_cap8b_0.buf_16_0.z adc8b_0.side_cap8b_0.in_h_sw[2] sg13cmos5l_Corner_1.vss sg13cmos5l_Corner_1.vss sg13_lv_nmos ad=95f pd=0.88u as=95f ps=0.88u w=0.5u l=0.13u
M3454 sg13cmos5l_Corner_1.vss adc8b_0.sar12b_0.sg13cmos5l_buf_1_86.A a_102160_98084# sg13cmos5l_Corner_1.vss sg13_lv_nmos ad=0.14875p pd=1.16u as=0.187p ps=1.78u w=0.55u l=0.13u
M3455 data[0] a_70044_42476# sg13cmos5l_Corner_1.iovdd sg13cmos5l_Corner_1.iovdd sg13_hv_pmos ad=3.9294p pd=7.84u as=2.1312p ps=7.3u w=6.66u l=0.6u
M3456 sg13cmos5l_IOPadAnalog_16.pad a_178296_102044# sg13cmos5l_Corner_1.vss sg13cmos5l_Corner_1.vss sg13_hv_nmos ad=2.596p pd=5.58u as=1.408p ps=5.04u w=4.4u l=0.6u
M3457 adc8b_0.sar12b_0.sg13cmos5l_buf_1_1.A a_95824_92824# sg13cmos5l_Corner_1.vss sg13cmos5l_Corner_1.vss sg13_lv_nmos ad=0.2886p pd=2.26u as=0.14875p ps=1.16u w=0.74u l=0.13u
M3458 vdd sg13cmos5l_IOPadVdd$1_0.sg13cmos5l_Clamp_N43N43D4R$1_0.gate sg13cmos5l_Corner_1.vss sg13cmos5l_Corner_1.vss sg13_hv_nmos ad=2.596p pd=5.58u as=1.408p ps=5.04u w=4.4u l=0.6u
M3459 vdd a_92241_100346# a_92174_100784# vdd sg13_lv_pmos ad=0.2387p pd=1.84u as=0.1008p ps=0.9u w=0.42u l=0.13u
M3460 sg13cmos5l_Corner_1.vss a_86718_96859# adc8b_0.sar12b_0.sg13cmos5l_dlhr_1_5.GATE sg13cmos5l_Corner_1.vss sg13_lv_nmos ad=0.1406p pd=1.12u as=0.2516p ps=2.16u w=0.74u l=0.13u
M3461 vdd a_98519_93909# a_98776_93790# vdd sg13_lv_pmos ad=0.2639p pd=1.81u as=79.8f ps=0.8u w=0.42u l=0.13u
M3462 a_97644_96128# a_98163_95932# a_98903_95887# sg13cmos5l_Corner_1.vss sg13_lv_nmos ad=0.3473p pd=2.71u as=0.12665p ps=1.145u w=0.74u l=0.13u
M3463 a_99363_95107# a_98471_95031# a_99261_95107# vdd sg13_lv_pmos ad=63f pd=0.72u as=79.8f ps=0.8u w=0.42u l=0.13u
M3464 a_95466_96572# adc8b_0.sar12b_0.sg13cmos5l_dfrbp_1_23.Q a_95254_96572# vdd sg13_lv_pmos ad=0.2128p pd=1.5u as=0.2128p ps=1.5u w=1.12u l=0.13u
M3465 vdd adc8b_0.sar12b_0.sg13cmos5l_buf_1_64.A a_85744_100384# vdd sg13_lv_pmos ad=0.2114p pd=1.54u as=0.2856p ps=2.36u w=0.84u l=0.13u
M3466 vdd a_86615_95887# a_87452_96108# vdd sg13_lv_pmos ad=0.2128p pd=1.5u as=0.3864p ps=2.93u w=1.12u l=0.13u
M3467 cks a_30676_118044# sg13cmos5l_Corner_1.vss sg13cmos5l_Corner_1.vss sg13_hv_nmos ad=2.596p pd=5.58u as=1.408p ps=5.04u w=4.4u l=0.6u
M3468 adc8b_0.side_cap8b_0.buf_32_0.z adc8b_0.side_cap8b_0.in_l_sw[0] sg13cmos5l_Corner_1.vss sg13cmos5l_Corner_1.vss sg13_lv_nmos ad=95f pd=0.88u as=95f ps=0.88u w=0.5u l=0.13u
M3469 a_85367_94375# a_84525_94277# a_85273_94375# sg13cmos5l_Corner_1.vss sg13_lv_nmos ad=0.12665p pd=1.145u as=0.1428p ps=1.52u w=0.42u l=0.13u
M3470 adc8b_0.side_cap8b_1.buf_8_2.z adc8b_0.sar12b_0.nh_sw[4] vddr vddr sg13_lv_pmos ad=0.19p pd=1.38u as=0.19p ps=1.38u w=1u l=0.13u
M3471 sg13cmos5l_Corner_1.vss adc8b_0.sar12b_0.sg13cmos5l_dfrbp_1_6.RESET_B a_97836_97322# sg13cmos5l_Corner_1.vss sg13_lv_nmos ad=0.1626p pd=1.415u as=60.89999f ps=0.71u w=0.42u l=0.13u
M3472 sg13cmos5l_IOPadAnalog_10.pad a_67639_164698# sg13cmos5l_Corner_1.iovdd sg13cmos5l_Corner_1.iovdd sg13_hv_pmos ad=3.9294p pd=7.84u as=2.1312p ps=7.3u w=6.66u l=0.6u
M3473 sg13cmos5l_Corner_1.iovdd a_164624_70044# sg13cmos5l_IOPadAnalog_1.pad sg13cmos5l_Corner_1.iovdd sg13_hv_pmos ad=2.1312p pd=7.3u as=3.9294p ps=7.84u w=6.66u l=0.6u
M3474 sg13cmos5l_IOPadAnalog_9.pad a_83639_164698# sg13cmos5l_Corner_1.iovdd sg13cmos5l_Corner_1.iovdd sg13_hv_pmos ad=3.9294p pd=7.84u as=2.1312p ps=7.3u w=6.66u l=0.6u
M3475 a_88820_100310# adc8b_0.sar12b_0.sg13cmos5l_inv_1_14.A sg13cmos5l_Corner_1.vss sg13cmos5l_Corner_1.vss sg13_lv_nmos ad=0.187p pd=1.78u as=0.14875p ps=1.16u w=0.55u l=0.13u
M3476 vdd adc8b_0.sar12b_0.sg13cmos5l_dfrbp_1_6.RESET_B a_94929_98441# vdd sg13_lv_pmos ad=0.2128p pd=1.5u as=0.2128p ps=1.5u w=1.12u l=0.13u
M3477 adc8b_0.sar12b_0.sg13cmos5l_dlhr_1_6.D a_89564_97620# sg13cmos5l_Corner_1.vss sg13cmos5l_Corner_1.vss sg13_lv_nmos ad=0.2516p pd=2.16u as=0.1406p ps=1.12u w=0.74u l=0.13u
M3478 vdd sg13cmos5l_IOPadVdd$1_0.sg13cmos5l_Clamp_N43N43D4R$1_0.gate sg13cmos5l_Corner_1.vss sg13cmos5l_Corner_1.vss sg13_hv_nmos ad=2.596p pd=5.58u as=1.408p ps=5.04u w=4.4u l=0.6u
M3479 a_83348_93512# adc8b_0.sar12b_0.sg13cmos5l_buf_1_40.X vdd vdd sg13_lv_pmos ad=0.2856p pd=2.36u as=0.2114p ps=1.54u w=0.84u l=0.13u
M3480 adc8b_0.side_cap8b_0.buf_8_0.z adc8b_0.side_cap8b_0.in_l_sw[4] vddr vddr sg13_lv_pmos ad=0.19p pd=1.38u as=0.19p ps=1.38u w=1u l=0.13u
M3481 sg13cmos5l_Corner_1.vss a_83252_97286# adc8b_0.sar12b_0.sg13cmos5l_buf_1_40.A sg13cmos5l_Corner_1.vss sg13_lv_nmos ad=0.14875p pd=1.16u as=0.2886p ps=2.26u w=0.74u l=0.13u
M3482 sg13cmos5l_Corner_1.vss adc8b_0.sar12b_0.nl_sw[2] adc8b_0.side_cap8b_1.buf_16_1.z sg13cmos5l_Corner_1.vss sg13_lv_nmos ad=95f pd=0.88u as=0.17p ps=1.68u w=0.5u l=0.13u
M3483 sg13cmos5l_Corner_1.iovdd a_99639_164698# sg13cmos5l_IOPadAnalog_15.pad sg13cmos5l_Corner_1.iovdd sg13_hv_pmos ad=2.1312p pd=7.3u as=3.9294p ps=7.84u w=6.66u l=0.6u
M3484 sg13cmos5l_Corner_1.vss sg13cmos5l_IOPadVdd$1_0.sg13cmos5l_Clamp_N43N43D4R$1_0.gate vdd sg13cmos5l_Corner_1.vss sg13_hv_nmos ad=1.408p pd=5.04u as=2.596p ps=5.58u w=4.4u l=0.6u
M3485 vddr a_30676_70044# sg13cmos5l_Corner_1.vss sg13cmos5l_Corner_1.vss sg13_hv_nmos ad=2.596p pd=5.58u as=1.408p ps=5.04u w=4.4u l=0.6u
M3486 sg13cmos5l_Corner_1.vss vdd sg13cmos5l_Corner_1.vss sg13cmos5l_Corner_1.vss sg13_lv_nmos ad=0.1428p pd=1.52u as=0 ps=0 w=0.42u l=1u
M3487 vdd adc8b_0.sar12b_0.sg13cmos5l_dfrbp_1_0.RESET_B a_97234_93516# vdd sg13_lv_pmos ad=0.1563p pd=1.22u as=0.147p ps=1.54u w=0.42u l=0.13u
M3488 adc8b_0.sar12b_0.sg13cmos5l_dlhr_1_16.Q a_100977_96929# vdd vdd sg13_lv_pmos ad=0.3808p pd=2.92u as=0.2128p ps=1.5u w=1.12u l=0.13u
M3489 sg13cmos5l_Corner_1.iovdd a_164624_102044# sg13cmos5l_IOPadAnalog_16.pad sg13cmos5l_Corner_1.iovdd sg13_hv_pmos ad=3.1302p pd=14.26u as=3.9294p ps=7.84u w=6.66u l=0.6u
M3490 sg13cmos5l_Corner_1.iovdd a_115639_164698# sg13cmos5l_IOPadAnalog_13.pad sg13cmos5l_Corner_1.iovdd sg13_hv_pmos ad=2.1312p pd=7.3u as=3.9294p ps=7.84u w=6.66u l=0.6u
M3491 a_93550_95485# adc8b_0.sar12b_0.sg13cmos5l_dfrbp_1_0.RESET_B sg13cmos5l_Corner_1.vss sg13cmos5l_Corner_1.vss sg13_lv_nmos ad=37.8f pd=0.6u as=0.1701p ps=1.65u w=0.42u l=0.13u
M3492 sg13cmos5l_Corner_1.vss adc8b_0.sar12b_0.nh_sw[0] adc8b_0.side_cap8b_1.buf_32_1.z sg13cmos5l_Corner_1.vss sg13_lv_nmos ad=95f pd=0.88u as=95f ps=0.88u w=0.5u l=0.13u
M3493 vin a_42476_86044# sg13cmos5l_Corner_1.iovdd sg13cmos5l_Corner_1.iovdd sg13_hv_pmos ad=3.9294p pd=7.84u as=2.1312p ps=7.3u w=6.66u l=0.6u
M3494 sg13cmos5l_Corner_1.vss adc8b_0.side_cap8b_0.in_h_sw[0] adc8b_0.side_cap8b_0.buf_32_1.z sg13cmos5l_Corner_1.vss sg13_lv_nmos ad=95f pd=0.88u as=95f ps=0.88u w=0.5u l=0.13u
M3495 a_84495_97540# a_84647_97592# vdd vdd sg13_lv_pmos ad=0.3864p pd=2.93u as=1.07253p ps=6.75u w=1.12u l=0.13u
M3496 sg13cmos5l_Corner_1.vss a_90609_96929# a_91134_97002# sg13cmos5l_Corner_1.vss sg13_lv_nmos ad=0.1491p pd=1.18u as=0.187p ps=1.78u w=0.55u l=0.13u
M3497 vddr adc8b_0.side_cap8b_0.in_h_sw[8] adc8b_0.side_cap8b_0.buf_2_0.z vddr sg13_lv_pmos ad=0.19p pd=1.38u as=0.34p ps=2.68u w=1u l=0.13u
M3498 sg13cmos5l_Corner_1.iovdd a_86044_42476# data[1] sg13cmos5l_Corner_1.iovdd sg13_hv_pmos ad=2.1312p pd=7.3u as=3.9294p ps=7.84u w=6.66u l=0.6u
M3499 sg13cmos5l_IOPadVdd$1_0.sg13cmos5l_Clamp_N43N43D4R$1_0.gate sg13cmos5l_IOPadVdd$1_0.sg13cmos5l_RCClampInverter$1_0.in vdd vdd sg13_hv_pmos ad=1.33p pd=7.38u as=2.38p ps=14.68u w=7u l=0.5u
M3500 a_99468_94616# a_99442_94521# vdd vdd sg13_lv_pmos ad=0.34p pd=2.68u as=0.36237p ps=2.605u w=1u l=0.13u
M3501 a_85460_100310# adc8b_0.sar12b_0.sg13cmos5l_inv_1_17.A vdd vdd sg13_lv_pmos ad=0.2856p pd=2.36u as=0.2114p ps=1.54u w=0.84u l=0.13u
M3502 a_95254_96572# adc8b_0.sar12b_0.sg13cmos5l_nor2b_1_0.Y vdd vdd sg13_lv_pmos ad=0.2128p pd=1.5u as=0.3808p ps=2.92u w=1.12u l=0.13u
M3503 sg13cmos5l_IOPadAnalog_15.pad a_99639_164698# sg13cmos5l_Corner_1.iovdd sg13cmos5l_Corner_1.iovdd sg13_hv_pmos ad=3.9294p pd=7.84u as=3.1302p ps=14.26u w=6.66u l=0.6u
M3504 a_100728_96572# a_100177_96930# vdd vdd sg13_lv_pmos ad=0.105p pd=1.21u as=1.28962p ps=8.195u w=1u l=0.13u
M3505 vip a_30676_102044# sg13cmos5l_Corner_1.vss sg13cmos5l_Corner_1.vss sg13_hv_nmos ad=2.596p pd=5.58u as=1.408p ps=5.04u w=4.4u l=0.6u
M3506 a_97742_97322# a_98547_97444# a_98002_97545# vdd sg13_lv_pmos ad=0.1428p pd=1.52u as=79.8f ps=0.8u w=0.42u l=0.13u
M3507 data[2] a_102160_95060# vdd vdd sg13_lv_pmos ad=0.42p pd=2.99u as=0.2114p ps=1.54u w=1.12u l=0.13u
M3508 adc8b_0.sar12b_0.sg13cmos5l_nor2_1_1.A a_99356_93548# vdd vdd sg13_lv_pmos ad=0.3808p pd=2.92u as=0.2128p ps=1.5u w=1.12u l=0.13u
X3509 sg13cmos5l_Corner_1.vss a_30676_118044# sg13cmos5l_Corner_1.vss rppd l=3.54u w=0.5u
M3510 a_91028_93512# adc8b_0.sar12b_0.sg13cmos5l_buf_1_30.X vdd vdd sg13_lv_pmos ad=0.2856p pd=2.36u as=0.2114p ps=1.54u w=0.84u l=0.13u
M3511 vddr a_42476_70044# sg13cmos5l_Corner_1.iovdd sg13cmos5l_Corner_1.iovdd sg13_hv_pmos ad=3.9294p pd=7.84u as=2.1312p ps=7.3u w=6.66u l=0.6u
M3512 sg13cmos5l_Corner_1.vss adc8b_0.sar12b_0.sg13cmos5l_dfrbp_1_23.Q_N a_96145_96930# sg13cmos5l_Corner_1.vss sg13_lv_nmos ad=0.15055p pd=1.17u as=0.187p ps=1.78u w=0.55u l=0.13u
M3513 adc8b_0.side_cap8b_1.buf_8_3.z adc8b_0.sar12b_0.nh_sw[3] sg13cmos5l_Corner_1.vss sg13cmos5l_Corner_1.vss sg13_lv_nmos ad=95f pd=0.88u as=95f ps=0.88u w=0.5u l=0.13u
M3514 vddr adc8b_0.sar12b_0.nl_sw[2] adc8b_0.side_cap8b_1.buf_16_1.z vddr sg13_lv_pmos ad=0.19p pd=1.38u as=0.19p ps=1.38u w=1u l=0.13u
M3515 vdd adc8b_0.sar12b_0.sg13cmos5l_inv_1_27.Y a_96400_100384# vdd sg13_lv_pmos ad=0.2114p pd=1.54u as=0.2856p ps=2.36u w=0.84u l=0.13u
M3516 vdd a_99544_97542# a_99489_97637# vdd sg13_lv_pmos ad=1.07253p pd=6.75u as=93.45f ps=0.865u w=0.42u l=0.13u
M3517 a_82292_95774# adc8b_0.sar12b_0.sg13cmos5l_buf_1_43.A sg13cmos5l_Corner_1.vss sg13cmos5l_Corner_1.vss sg13_lv_nmos ad=0.187p pd=1.78u as=0.14875p ps=1.16u w=0.55u l=0.13u
M3518 sg13cmos5l_Corner_1.vss adc8b_0.sar12b_0.sg13cmos5l_nor2_1_1.A adc8b_0.sar12b_0.sg13cmos5l_nor2b_1_1.Y sg13cmos5l_Corner_1.vss sg13_lv_nmos ad=0.2516p pd=2.16u as=0.1406p ps=1.12u w=0.74u l=0.13u
M3519 a_84412_95796# a_83996_96132# a_84177_95810# sg13cmos5l_Corner_1.vss sg13_lv_nmos ad=77.7f pd=0.95u as=0.2516p ps=2.16u w=0.74u l=0.13u
M3520 a_88766_96997# a_87588_96933# a_88370_96852# sg13cmos5l_Corner_1.vss sg13_lv_nmos ad=37.8f pd=0.6u as=0.1428p ps=1.52u w=0.42u l=0.13u
M3521 adc8b_0.side_cap8b_0.buf_8_5.z adc8b_0.side_cap8b_0.in_h_sw[5] sg13cmos5l_Corner_1.vss sg13cmos5l_Corner_1.vss sg13_lv_nmos ad=95f pd=0.88u as=95f ps=0.88u w=0.5u l=0.13u
M3522 sg13cmos5l_Corner_1.vss a_178296_70044# sg13cmos5l_IOPadAnalog_1.pad sg13cmos5l_Corner_1.vss sg13_hv_nmos ad=1.408p pd=5.04u as=2.596p ps=5.58u w=4.4u l=0.6u
M3523 sg13cmos5l_IOPadAnalog_0.pad a_178296_86044# sg13cmos5l_Corner_1.vss sg13cmos5l_Corner_1.vss sg13_hv_nmos ad=2.596p pd=5.58u as=1.408p ps=5.04u w=4.4u l=0.6u
M3524 sg13cmos5l_Corner_1.vss a_98519_93909# a_99356_93548# sg13cmos5l_Corner_1.vss sg13_lv_nmos ad=0.1406p pd=1.12u as=0.2516p ps=2.16u w=0.74u l=0.13u
M3525 sg13cmos5l_IOPadAnalog_12.pad a_131639_178370# sg13cmos5l_Corner_1.vss sg13cmos5l_Corner_1.vss sg13_hv_nmos ad=2.596p pd=5.58u as=1.408p ps=5.04u w=4.4u l=0.6u
M3526 a_92942_93986# adc8b_0.sar12b_0.sg13cmos5l_dfrbp_1_4.D vdd vdd sg13_lv_pmos ad=79.8f pd=0.8u as=0.1428p ps=1.52u w=0.42u l=0.13u
M3527 a_83992_96814# adc8b_0.sar12b_0.sg13cmos5l_dfrbp_1_6.RESET_B vdd vdd sg13_lv_pmos ad=79.8f pd=0.8u as=1.28962p ps=8.195u w=0.42u l=0.13u
M3528 vddr adc8b_0.sar12b_0.nh_sw[3] adc8b_0.side_cap8b_1.buf_8_3.z vddr sg13_lv_pmos ad=0.19p pd=1.38u as=0.34p ps=2.68u w=1u l=0.13u
M3529 vdd a_87956_92750# adc8b_0.sar12b_0.sg13cmos5l_buf_1_25.X vdd sg13_lv_pmos ad=0.2114p pd=1.54u as=0.42p ps=2.99u w=1.12u l=0.13u
M3530 a_98708_94262# adc8b_0.sar12b_0.sg13cmos5l_buf_1_4.X vdd vdd sg13_lv_pmos ad=0.2856p pd=2.36u as=0.2114p ps=1.54u w=0.84u l=0.13u
M3531 adc8b_0.side_cap8b_0.buf_16_3.z adc8b_0.side_cap8b_0.in_h_sw[1] vddr vddr sg13_lv_pmos ad=0.19p pd=1.38u as=0.19p ps=1.38u w=1u l=0.13u
M3532 vdd adc8b_0.sar12b_0.sg13cmos5l_inv_1_1.A adc8b_0.sar12b_0.sg13cmos5l_buf_1_2.A vdd sg13_lv_pmos ad=0.3808p pd=2.92u as=0.3808p ps=2.92u w=1.12u l=0.13u
M3533 sg13cmos5l_Corner_1.vss a_30676_86044# vin sg13cmos5l_Corner_1.vss sg13_hv_nmos ad=1.408p pd=5.04u as=2.596p ps=5.58u w=4.4u l=0.6u
M3534 adc8b_0.side_cap8b_0.buf_8_5.z adc8b_0.side_cap8b_0.in_h_sw[5] vddr vddr sg13_lv_pmos ad=0.34p pd=2.68u as=0.19p ps=1.38u w=1u l=0.13u
M3535 sg13cmos5l_Corner_1.vss a_94840_93006# a_94489_92863# sg13cmos5l_Corner_1.vss sg13_lv_nmos ad=79.8f pd=0.8u as=0.1428p ps=1.52u w=0.42u l=0.13u
M3536 sg13cmos5l_Corner_1.iovdd a_67639_164698# sg13cmos5l_IOPadAnalog_10.pad sg13cmos5l_Corner_1.iovdd sg13_hv_pmos ad=2.1312p pd=7.3u as=3.9294p ps=7.84u w=6.66u l=0.6u
M3537 a_93645_93559# adc8b_0.sar12b_0.sg13cmos5l_dfrbp_1_0.CLK vdd vdd sg13_lv_pmos ad=0.4088p pd=2.97u as=1.777p ps=11.395u w=1.12u l=0.13u
M3538 a_86988_93552# a_87507_93559# a_88247_93909# sg13cmos5l_Corner_1.vss sg13_lv_nmos ad=0.3473p pd=2.71u as=0.12665p ps=1.145u w=0.74u l=0.13u
M3539 sg13cmos5l_Corner_1.iovdd a_83639_164698# sg13cmos5l_IOPadAnalog_9.pad sg13cmos5l_Corner_1.iovdd sg13_hv_pmos ad=2.1312p pd=7.3u as=3.9294p ps=7.84u w=6.66u l=0.6u
X3540 sg13cmos5l_IOPadAnalog_10.padres sg13cmos5l_Corner_1.iovdd dpantenna l=0.64u w=4.98u
M3541 sg13cmos5l_Corner_1.vss adc8b_0.side_cap8b_0.in_h_sw[10] adc8b_0.side_cap8b_0.buf_1_1.z sg13cmos5l_Corner_1.vss sg13_lv_nmos ad=0.17p pd=1.68u as=0.17p ps=1.68u w=0.5u l=0.13u
M3542 vdd a_84333_99607# a_84435_99607# vdd sg13_lv_pmos ad=1.15047p pd=7.175u as=0.3864p ps=2.93u w=1.12u l=0.13u
M3543 a_97068_98847# a_97299_98956# a_96754_99057# sg13cmos5l_Corner_1.vss sg13_lv_nmos ad=0.2373p pd=1.97u as=79.8f ps=0.8u w=0.42u l=0.13u
M3544 a_85713_96201# a_85356_96128# vdd vdd sg13_lv_pmos ad=63f pd=0.72u as=0.1563p ps=1.22u w=0.42u l=0.13u
M3545 sg13cmos5l_Corner_1.iovdd a_86044_42476# data[1] sg13cmos5l_Corner_1.iovdd sg13_hv_pmos ad=2.1312p pd=7.3u as=3.9294p ps=7.84u w=6.66u l=0.6u
M3546 sg13cmos5l_Corner_1.vss vdd sg13cmos5l_Corner_1.vss sg13cmos5l_Corner_1.vss sg13_lv_nmos ad=79.8f pd=0.8u as=0 ps=0 w=0.42u l=1u
M3547 a_94884_98486# a_94335_98442# a_94748_98084# sg13cmos5l_Corner_1.vss sg13_lv_nmos ad=47.25f pd=0.645u as=0.141p ps=1.17u w=0.42u l=0.13u
M3548 vdd adc8b_0.sar12b_0.sg13cmos5l_dfrbp_1_23.Q_N a_96145_96930# vdd sg13_lv_pmos ad=1.28962p pd=8.195u as=0.2856p ps=2.36u w=0.84u l=0.13u
M3549 vdd a_86872_96030# a_86817_96125# vdd sg13_lv_pmos ad=1.28962p pd=8.195u as=93.45f ps=0.865u w=0.42u l=0.13u
M3550 adc8b_0.sar12b_0.sg13cmos5l_nor2b_1_0.Y adc8b_0.sar12b_0.sg13cmos5l_inv_1_0.A a_94804_96108# vdd sg13_lv_pmos ad=0.3808p pd=2.92u as=0.1176p ps=1.33u w=1.12u l=0.13u
M3551 adc8b_0.sar12b_0.sg13cmos5l_buf_1_34.X a_86608_92824# sg13cmos5l_Corner_1.vss sg13cmos5l_Corner_1.vss sg13_lv_nmos ad=0.2886p pd=2.26u as=0.14875p ps=1.16u w=0.74u l=0.13u
M3552 adc8b_0.side_cap8b_0.buf_4_1.z adc8b_0.side_cap8b_0.in_h_sw[6] sg13cmos5l_Corner_1.vss sg13cmos5l_Corner_1.vss sg13_lv_nmos ad=95f pd=0.88u as=95f ps=0.88u w=0.5u l=0.13u
X3553 sg13cmos5l_Corner_1.vss a_32962_86222# dantenna l=27.78u w=1.26u
M3554 adc8b_0.sar12b_0.sg13cmos5l_buf_1_104.X a_101392_99596# sg13cmos5l_Corner_1.vss sg13cmos5l_Corner_1.vss sg13_lv_nmos ad=0.2886p pd=2.26u as=0.14875p ps=1.16u w=0.74u l=0.13u
M3555 a_93900_100664# a_93874_100569# vdd vdd sg13_lv_pmos ad=0.34p pd=2.68u as=0.36237p ps=2.605u w=1u l=0.13u
M3556 sg13cmos5l_Corner_1.vss adc8b_0.sar12b_0.nh_sw[5] adc8b_0.side_cap8b_1.buf_8_5.z sg13cmos5l_Corner_1.vss sg13_lv_nmos ad=95f pd=0.88u as=95f ps=0.88u w=0.5u l=0.13u
M3557 a_89972_93512# adc8b_0.sar12b_0.sg13cmos5l_dlhr_1_2.Q sg13cmos5l_Corner_1.vss sg13cmos5l_Corner_1.vss sg13_lv_nmos ad=0.187p pd=1.78u as=0.14875p ps=1.16u w=0.55u l=0.13u
M3558 vdd sg13cmos5l_IOPadVdd$1_0.sg13cmos5l_Clamp_N43N43D4R$1_0.gate sg13cmos5l_Corner_1.vss sg13cmos5l_Corner_1.vss sg13_hv_nmos ad=2.596p pd=5.58u as=1.408p ps=5.04u w=4.4u l=0.6u
M3559 adc8b_0.side_cap8b_0.in_h_sw[0] a_82384_100384# sg13cmos5l_Corner_1.vss sg13cmos5l_Corner_1.vss sg13_lv_nmos ad=0.2886p pd=2.26u as=0.14875p ps=1.16u w=0.74u l=0.13u
M3560 adc8b_0.diff_bsw_0.single_bsw_1.sg13cmos5l_inv_1$1_0.A cks sg13cmos5l_Corner_1.vss sg13cmos5l_Corner_1.vss sg13_lv_nmos ad=0.2516p pd=2.16u as=0.2516p ps=2.16u w=0.74u l=0.13u
M3561 sg13cmos5l_IOPadAnalog_1.pad a_164624_70044# sg13cmos5l_Corner_1.iovdd sg13cmos5l_Corner_1.iovdd sg13_hv_pmos ad=3.9294p pd=7.84u as=2.1312p ps=7.3u w=6.66u l=0.6u
M3562 sg13cmos5l_Corner_1.iovdd a_118044_42476# cko sg13cmos5l_Corner_1.iovdd sg13_hv_pmos ad=2.1312p pd=7.3u as=3.9294p ps=7.84u w=6.66u l=0.6u
M3563 a_96780_99152# a_97299_98956# a_98039_98911# sg13cmos5l_Corner_1.vss sg13_lv_nmos ad=0.3473p pd=2.71u as=0.12665p ps=1.145u w=0.74u l=0.13u
M3564 data[2] a_102044_42476# sg13cmos5l_Corner_1.iovdd sg13cmos5l_Corner_1.iovdd sg13_hv_pmos ad=3.9294p pd=7.84u as=2.1312p ps=7.3u w=6.66u l=0.6u
M3565 sg13cmos5l_Corner_1.vss a_178296_86044# sg13cmos5l_IOPadAnalog_0.pad sg13cmos5l_Corner_1.vss sg13_hv_nmos ad=1.408p pd=5.04u as=2.596p ps=5.58u w=4.4u l=0.6u
M3566 sg13cmos5l_IOPadAnalog_10.pad a_67639_164698# sg13cmos5l_Corner_1.iovdd sg13cmos5l_Corner_1.iovdd sg13_hv_pmos ad=3.9294p pd=7.84u as=3.1302p ps=14.26u w=6.66u l=0.6u
M3567 a_92218_100034# adc8b_0.sar12b_0.sg13cmos5l_dfrbp_1_8.RESET_B sg13cmos5l_Corner_1.vss sg13cmos5l_Corner_1.vss sg13_lv_nmos ad=37.8f pd=0.6u as=79.8f ps=0.8u w=0.42u l=0.13u
M3568 sg13cmos5l_Corner_1.vss a_101780_93512# adc8b_0.sar12b_0.nl_sw[10] sg13cmos5l_Corner_1.vss sg13_lv_nmos ad=0.14875p pd=1.16u as=0.2886p ps=2.26u w=0.74u l=0.13u
X3569 a_36456_133435# a_40542_133765# sg13cmos5l_Corner_1.vss rppd l=20u w=1u
M3570 sg13cmos5l_Corner_1.vss adc8b_0.sar12b_0.sg13cmos5l_or2_1_0.A a_100248_96188# sg13cmos5l_Corner_1.vss sg13_lv_nmos ad=0.1469p pd=1.155u as=0.1045p ps=0.93u w=0.55u l=0.13u
M3571 sg13cmos5l_IOPadVdd$1_0.sg13cmos5l_Clamp_N43N43D4R$1_0.gate sg13cmos5l_IOPadVdd$1_0.sg13cmos5l_RCClampInverter$1_0.in vdd vdd sg13_hv_pmos ad=1.33p pd=7.38u as=1.33p ps=7.38u w=7u l=0.5u
M3572 a_90756_97358# a_90207_97338# a_90620_97644# sg13cmos5l_Corner_1.vss sg13_lv_nmos ad=47.25f pd=0.645u as=0.141p ps=1.17u w=0.42u l=0.13u
M3573 a_82833_96619# a_82476_96576# vdd vdd sg13_lv_pmos ad=63f pd=0.72u as=0.1563p ps=1.22u w=0.42u l=0.13u
M3574 adc8b_0.side_cap8b_0.buf_32_0.z adc8b_0.side_cap8b_0.in_l_sw[0] vddr vddr sg13_lv_pmos ad=0.19p pd=1.38u as=0.19p ps=1.38u w=1u l=0.13u
M3575 a_90564_96974# a_90015_96930# a_90428_96572# sg13cmos5l_Corner_1.vss sg13_lv_nmos ad=47.25f pd=0.645u as=0.141p ps=1.17u w=0.42u l=0.13u
M3576 a_99537_93177# a_99180_93104# vdd vdd sg13_lv_pmos ad=63f pd=0.72u as=0.1563p ps=1.22u w=0.42u l=0.13u
M3577 sg13cmos5l_Corner_1.iovdd a_42476_86044# vin sg13cmos5l_Corner_1.iovdd sg13_hv_pmos ad=2.1312p pd=7.3u as=3.9294p ps=7.84u w=6.66u l=0.6u
M3578 vdd sg13cmos5l_Corner_1.vss vdd vdd sg13_lv_pmos ad=0.19p pd=1.38u as=0 ps=0 w=1u l=1u
M3579 adc8b_0.sar12b_0.sg13cmos5l_dlhr_1_0.Q a_89457_92786# sg13cmos5l_Corner_1.vss sg13cmos5l_Corner_1.vss sg13_lv_nmos ad=0.2516p pd=2.16u as=0.1406p ps=1.12u w=0.74u l=0.13u
M3580 sg13cmos5l_Corner_1.vss a_88820_100310# adc8b_0.sar12b_0.sg13cmos5l_buf_1_76.X sg13cmos5l_Corner_1.vss sg13_lv_nmos ad=0.14875p pd=1.16u as=0.2886p ps=2.26u w=0.74u l=0.13u
M3581 a_83724_100034# adc8b_0.sar12b_0.sg13cmos5l_dfrbp_1_17.D a_83630_100034# sg13cmos5l_Corner_1.vss sg13_lv_nmos ad=60.89999f pd=0.71u as=0.1428p ps=1.52u w=0.42u l=0.13u
M3582 sg13cmos5l_Corner_1.vss adc8b_0.sar12b_0.sg13cmos5l_inv_1_0.A adc8b_0.sar12b_0.sg13cmos5l_nor2b_1_0.Y sg13cmos5l_Corner_1.vss sg13_lv_nmos ad=0.2516p pd=2.16u as=0.1406p ps=1.12u w=0.74u l=0.13u
M3583 sg13cmos5l_Corner_1.vss a_97677_93559# a_97779_93559# sg13cmos5l_Corner_1.vss sg13_lv_nmos ad=2.59257p pd=16.445u as=0.2516p ps=2.16u w=0.74u l=0.13u
M3584 sg13cmos5l_Corner_1.iovdd a_99639_164698# sg13cmos5l_IOPadAnalog_15.pad sg13cmos5l_Corner_1.iovdd sg13_hv_pmos ad=2.1312p pd=7.3u as=3.9294p ps=7.84u w=6.66u l=0.6u
M3585 sg13cmos5l_Corner_1.vss adc8b_0.sar12b_0.sg13cmos5l_inv_1_28.Y a_93232_100384# sg13cmos5l_Corner_1.vss sg13_lv_nmos ad=0.14875p pd=1.16u as=0.187p ps=1.78u w=0.55u l=0.13u
M3586 a_93592_99054# adc8b_0.sar12b_0.sg13cmos5l_dfrbp_1_6.RESET_B vdd vdd sg13_lv_pmos ad=79.8f pd=0.8u as=1.12242p ps=7u w=0.42u l=0.13u
M3587 vdd adc8b_0.sar12b_0.sg13cmos5l_nor2_1_1.A adc8b_0.sar12b_0.sg13cmos5l_nand2_1_1.B vdd sg13_lv_pmos ad=0.2198p pd=1.53u as=0.2128p ps=1.5u w=1.12u l=0.13u
M3588 a_96370_99564# a_96813_99607# a_96753_99643# vdd sg13_lv_pmos ad=79.8f pd=0.8u as=63f ps=0.72u w=0.42u l=0.13u
M3589 a_99406_92799# adc8b_0.sar12b_0.sg13cmos5l_dfrbp_1_0.RESET_B sg13cmos5l_Corner_1.vss sg13cmos5l_Corner_1.vss sg13_lv_nmos ad=37.8f pd=0.6u as=0.1701p ps=1.65u w=0.42u l=0.13u
M3590 a_96754_99057# a_97197_98813# a_97137_99225# vdd sg13_lv_pmos ad=79.8f pd=0.8u as=63f ps=0.72u w=0.42u l=0.13u
M3591 sg13cmos5l_IOPadAnalog_9.pad a_83639_178370# sg13cmos5l_Corner_1.vss sg13cmos5l_Corner_1.vss sg13_hv_nmos ad=2.596p pd=5.58u as=1.408p ps=5.04u w=4.4u l=0.6u
M3592 a_88173_99607# adc8b_0.sar12b_0.sg13cmos5l_inv_1_8.A sg13cmos5l_Corner_1.vss sg13cmos5l_Corner_1.vss sg13_lv_nmos ad=0.2516p pd=2.16u as=2.71505p ps=17.54u w=0.74u l=0.13u
M3593 adc8b_0.sar12b_0.sg13cmos5l_dfrbp_1_3.Q_N a_100727_94375# vdd vdd sg13_lv_pmos ad=0.4312p pd=3.01u as=0.2639p ps=1.81u w=1.12u l=0.13u
M3594 vdd a_85367_94375# a_85624_94518# vdd sg13_lv_pmos ad=0.2639p pd=1.81u as=79.8f ps=0.8u w=0.42u l=0.13u
X3595 sg13cmos5l_Corner_1.vss a_115639_178370# sg13cmos5l_Corner_1.vss rppd l=3.54u w=0.5u
M3596 data[2] a_102160_95060# sg13cmos5l_Corner_1.vss sg13cmos5l_Corner_1.vss sg13_lv_nmos ad=0.2886p pd=2.26u as=0.14875p ps=1.16u w=0.74u l=0.13u
M3597 sg13cmos5l_IOPadAnalog_1.pad a_164624_70044# sg13cmos5l_Corner_1.iovdd sg13cmos5l_Corner_1.iovdd sg13_hv_pmos ad=3.9294p pd=7.84u as=2.1312p ps=7.3u w=6.66u l=0.6u
M3598 a_97125_92976# adc8b_0.sar12b_0.sg13cmos5l_dfrbp_1_0.Q sg13cmos5l_Corner_1.vss sg13cmos5l_Corner_1.vss sg13_lv_nmos ad=0.187p pd=1.78u as=0.14505p ps=1.15u w=0.55u l=0.13u
M3599 adc8b_0.side_cap8b_0.buf_32_1.z adc8b_0.side_cap8b_0.in_h_sw[0] sg13cmos5l_Corner_1.vss sg13cmos5l_Corner_1.vss sg13_lv_nmos ad=95f pd=0.88u as=95f ps=0.88u w=0.5u l=0.13u
M3600 sg13cmos5l_Corner_1.vss a_95252_99560# adc8b_0.sar12b_0.sg13cmos5l_buf_1_5.A sg13cmos5l_Corner_1.vss sg13_lv_nmos ad=0.14875p pd=1.16u as=0.2886p ps=2.26u w=0.74u l=0.13u
M3601 sg13cmos5l_IOPadAnalog_16.pad a_164624_102044# sg13cmos5l_Corner_1.iovdd sg13cmos5l_Corner_1.iovdd sg13_hv_pmos ad=3.9294p pd=7.84u as=2.1312p ps=7.3u w=6.66u l=0.6u
M3602 sg13cmos5l_Corner_1.vss adc8b_0.sar12b_0.sg13cmos5l_nor2_1_0.A a_94582_95852# sg13cmos5l_Corner_1.vss sg13_lv_nmos ad=0.17255p pd=1.25u as=0.187p ps=1.78u w=0.55u l=0.13u
M3603 sg13cmos5l_Corner_1.vss a_98036_92750# adc8b_0.sar12b_0.nl_sw[7] sg13cmos5l_Corner_1.vss sg13_lv_nmos ad=0.14875p pd=1.16u as=0.2886p ps=2.26u w=0.74u l=0.13u
M3604 sg13cmos5l_Corner_1.vss a_131639_178370# sg13cmos5l_IOPadAnalog_12.pad sg13cmos5l_Corner_1.vss sg13_hv_nmos ad=1.408p pd=5.04u as=2.596p ps=5.58u w=4.4u l=0.6u
M3605 a_86079_98870# a_85444_99124# sg13cmos5l_Corner_1.vss sg13cmos5l_Corner_1.vss sg13_lv_nmos ad=47.25f pd=0.645u as=0.1428p ps=1.52u w=0.42u l=0.13u
M3606 vdd a_100977_96929# a_101502_97002# vdd sg13_lv_pmos ad=0.1974p pd=1.5u as=0.2856p ps=2.36u w=0.84u l=0.13u
M3607 vdd a_100696_93006# a_100641_93101# vdd sg13_lv_pmos ad=1.86162p pd=11.935u as=93.45f ps=0.865u w=0.42u l=0.13u
M3608 vddr adc8b_0.side_cap8b_0.in_h_sw[0] adc8b_0.side_cap8b_0.buf_32_1.z vddr sg13_lv_pmos ad=0.19p pd=1.38u as=0.19p ps=1.38u w=1u l=0.13u
M3609 a_89588_93512# adc8b_0.sar12b_0.sg13cmos5l_dlhr_1_0.Q sg13cmos5l_Corner_1.vss sg13cmos5l_Corner_1.vss sg13_lv_nmos ad=0.187p pd=1.78u as=0.14875p ps=1.16u w=0.55u l=0.13u
X3610 sg13cmos5l_Corner_1.iovdd a_67639_164698# sg13cmos5l_Corner_1.iovdd rppd l=12.9u w=0.5u
M3611 adc8b_0.side_cap8b_0.buf_8_1.z adc8b_0.side_cap8b_0.in_l_sw[3] sg13cmos5l_Corner_1.vss sg13cmos5l_Corner_1.vss sg13_lv_nmos ad=95f pd=0.88u as=95f ps=0.88u w=0.5u l=0.13u
M3612 a_89631_98442# adc8b_0.sar12b_0.sg13cmos5l_dlhr_1_5.GATE vdd vdd sg13_lv_pmos ad=0.3234p pd=2.45u as=1.04815p ps=6.595u w=0.84u l=0.13u
M3613 sg13cmos5l_Corner_1.vss adc8b_0.sar12b_0.sg13cmos5l_dfrbp_1_0.RESET_B a_94860_94298# sg13cmos5l_Corner_1.vss sg13_lv_nmos ad=0.1626p pd=1.415u as=60.89999f ps=0.71u w=0.42u l=0.13u
M3614 sg13cmos5l_Corner_1.vss a_100439_92863# a_101276_93084# sg13cmos5l_Corner_1.vss sg13_lv_nmos ad=0.1406p pd=1.12u as=0.2516p ps=2.16u w=0.74u l=0.13u
M3615 a_98039_98911# a_97197_98813# a_97945_98911# sg13cmos5l_Corner_1.vss sg13_lv_nmos ad=0.12665p pd=1.145u as=0.1428p ps=1.52u w=0.42u l=0.13u
M3616 a_96813_99607# adc8b_0.sar12b_0.sg13cmos5l_inv_1_2.A vdd vdd sg13_lv_pmos ad=0.4088p pd=2.97u as=1.12242p ps=7u w=1.12u l=0.13u
M3617 a_82450_96540# a_82893_96583# a_82833_96619# vdd sg13_lv_pmos ad=79.8f pd=0.8u as=63f ps=0.72u w=0.42u l=0.13u
M3618 sg13cmos5l_Corner_1.iovdd a_42476_102044# vip sg13cmos5l_Corner_1.iovdd sg13_hv_pmos ad=2.1312p pd=7.3u as=3.9294p ps=7.84u w=6.66u l=0.6u
M3619 a_85940_92750# adc8b_0.sar12b_0.sg13cmos5l_buf_1_38.A sg13cmos5l_Corner_1.vss sg13cmos5l_Corner_1.vss sg13_lv_nmos ad=0.187p pd=1.78u as=0.14875p ps=1.16u w=0.55u l=0.13u
M3620 vdd a_101396_93512# adc8b_0.sar12b_0.nh_sw[9] vdd sg13_lv_pmos ad=0.2114p pd=1.54u as=0.42p ps=2.99u w=1.12u l=0.13u
M3621 sg13cmos5l_IOPadAnalog_12.pad a_131639_178370# sg13cmos5l_Corner_1.vss sg13cmos5l_Corner_1.vss sg13_hv_nmos ad=2.596p pd=5.58u as=1.408p ps=5.04u w=4.4u l=0.6u
X3622 sg13cmos5l_IOPadAnalog_15.pad sg13cmos5l_IOPadAnalog_15.padres sg13cmos5l_Corner_1.vss rppd l=2u w=1u
M3623 sg13cmos5l_Corner_1.vss sg13cmos5l_IOPadVdd$1_0.sg13cmos5l_Clamp_N43N43D4R$1_0.gate vdd sg13cmos5l_Corner_1.vss sg13_hv_nmos ad=1.408p pd=5.04u as=2.596p ps=5.58u w=4.4u l=0.6u
M3624 sg13cmos5l_Corner_1.vss cks a_100995_100350# sg13cmos5l_Corner_1.vss sg13_lv_nmos ad=0.1406p pd=1.12u as=0.1406p ps=1.12u w=0.74u l=0.13u
M3625 a_96582_95036# adc8b_0.sar12b_0.sg13cmos5l_a22oi_1_1.B1 adc8b_0.sar12b_0.sg13cmos5l_a22oi_1_1.Y vdd sg13_lv_pmos ad=0.2716p pd=1.605u as=0.2128p ps=1.5u w=1.12u l=0.13u
M3626 data[1] a_86044_42476# sg13cmos5l_Corner_1.iovdd sg13cmos5l_Corner_1.iovdd sg13_hv_pmos ad=3.9294p pd=7.84u as=3.1302p ps=14.26u w=6.66u l=0.6u
M3627 sg13cmos5l_Corner_1.iovdd a_115639_164698# sg13cmos5l_IOPadAnalog_13.pad sg13cmos5l_Corner_1.iovdd sg13_hv_pmos ad=2.1312p pd=7.3u as=3.9294p ps=7.84u w=6.66u l=0.6u
M3628 adc8b_0.sar12b_0.sg13cmos5l_buf_1_8.X a_92656_92824# sg13cmos5l_Corner_1.vss sg13cmos5l_Corner_1.vss sg13_lv_nmos ad=0.2886p pd=2.26u as=0.14875p ps=1.16u w=0.74u l=0.13u
M3629 adc8b_0.sar12b_0.sg13cmos5l_dfrbp_1_6.RESET_B cks sg13cmos5l_Corner_1.vss sg13cmos5l_Corner_1.vss sg13_lv_nmos ad=0.1443p pd=1.13u as=0.1406p ps=1.12u w=0.74u l=0.13u
M3630 adc8b_0.sar12b_0.sg13cmos5l_inv_1_1.A a_96976_97360# vdd vdd sg13_lv_pmos ad=0.42p pd=2.99u as=0.2114p ps=1.54u w=1.12u l=0.13u
M3631 sg13cmos5l_Corner_1.vss a_134044_30676# frame sg13cmos5l_Corner_1.vss sg13_hv_nmos ad=1.408p pd=5.04u as=2.596p ps=5.58u w=4.4u l=0.6u
M3632 sg13cmos5l_Corner_1.iovdd a_67639_164698# sg13cmos5l_IOPadAnalog_10.pad sg13cmos5l_Corner_1.iovdd sg13_hv_pmos ad=2.1312p pd=7.3u as=3.9294p ps=7.84u w=6.66u l=0.6u
M3633 adc8b_0.sar12b_0.sg13cmos5l_dlhr_1_21.Q_N a_92766_100328# sg13cmos5l_Corner_1.vss sg13cmos5l_Corner_1.vss sg13_lv_nmos ad=0.2516p pd=2.16u as=0.1491p ps=1.18u w=0.74u l=0.13u
M3634 a_99468_92799# a_99699_92908# a_99154_93009# sg13cmos5l_Corner_1.vss sg13_lv_nmos ad=0.2373p pd=1.97u as=79.8f ps=0.8u w=0.42u l=0.13u
M3635 vdd adc8b_0.sar12b_0.sg13cmos5l_buf_1_24.A adc8b_0.sar12b_0.sg13cmos5l_buf_1_78.A vdd sg13_lv_pmos ad=0.3808p pd=2.92u as=0.3808p ps=2.92u w=1.12u l=0.13u
M3636 a_94583_95421# a_93741_95071# a_93324_95064# vdd sg13_lv_pmos ad=0.2048p pd=1.63u as=0.34p ps=2.68u w=1u l=0.13u
M3637 vdd sg13cmos5l_IOPadVdd$1_0.sg13cmos5l_Clamp_N43N43D4R$1_0.gate sg13cmos5l_Corner_1.vss sg13cmos5l_Corner_1.vss sg13_hv_nmos ad=2.596p pd=5.58u as=1.408p ps=5.04u w=4.4u l=0.6u
X3638 sg13cmos5l_Corner_1.vss a_152182_92462# dantenna l=0.64u w=3.1u
M3639 a_101396_93512# adc8b_0.sar12b_0.sg13cmos5l_buf_1_19.X vdd vdd sg13_lv_pmos ad=0.2856p pd=2.36u as=0.2114p ps=1.54u w=0.84u l=0.13u
M3640 a_100727_94375# a_99885_94277# a_99468_94616# vdd sg13_lv_pmos ad=0.2048p pd=1.63u as=0.34p ps=2.68u w=1u l=0.13u
M3641 adc8b_0.side_cap8b_0.buf_16_0.z adc8b_0.side_cap8b_0.in_h_sw[2] sg13cmos5l_Corner_1.vss sg13cmos5l_Corner_1.vss sg13_lv_nmos ad=95f pd=0.88u as=95f ps=0.88u w=0.5u l=0.13u
M3642 a_85076_96536# adc8b_0.sar12b_0.sg13cmos5l_dlhr_1_1.Q vdd vdd sg13_lv_pmos ad=0.2856p pd=2.36u as=0.2114p ps=1.54u w=0.84u l=0.13u
M3643 vddr adc8b_0.side_cap8b_0.in_h_sw[4] adc8b_0.side_cap8b_0.buf_8_2.z vddr sg13_lv_pmos ad=0.19p pd=1.38u as=0.34p ps=2.68u w=1u l=0.13u
M3644 vdd adc8b_0.sar12b_0.sg13cmos5l_buf_1_104.A a_101392_99596# vdd sg13_lv_pmos ad=0.2114p pd=1.54u as=0.2856p ps=2.36u w=0.84u l=0.13u
M3645 sg13cmos5l_Corner_1.vss a_89972_93512# adc8b_0.sar12b_0.sg13cmos5l_buf_1_24.A sg13cmos5l_Corner_1.vss sg13_lv_nmos ad=0.14875p pd=1.16u as=0.2886p ps=2.26u w=0.74u l=0.13u
M3646 a_101146_94298# adc8b_0.sar12b_0.sg13cmos5l_dfrbp_1_0.RESET_B sg13cmos5l_Corner_1.vss sg13cmos5l_Corner_1.vss sg13_lv_nmos ad=37.8f pd=0.6u as=79.8f ps=0.8u w=0.42u l=0.13u
X3647 sg13cmos5l_Corner_1.vss a_83639_178370# sg13cmos5l_Corner_1.vss rppd l=3.54u w=0.5u
X3648 a_36456_136735# a_40542_137065# sg13cmos5l_Corner_1.vss rppd l=20u w=1u
M3649 adc8b_0.side_cap8b_0.buf_8_4.z adc8b_0.side_cap8b_0.in_l_sw[5] sg13cmos5l_Corner_1.vss sg13cmos5l_Corner_1.vss sg13_lv_nmos ad=95f pd=0.88u as=95f ps=0.88u w=0.5u l=0.13u
M3650 sg13cmos5l_Corner_1.vss adc8b_0.sar12b_0.sg13cmos5l_buf_1_89.A a_96976_97360# sg13cmos5l_Corner_1.vss sg13_lv_nmos ad=0.14875p pd=1.16u as=0.187p ps=1.78u w=0.55u l=0.13u
M3651 vdd a_99095_98445# a_99352_98326# vdd sg13_lv_pmos ad=0.2639p pd=1.81u as=79.8f ps=0.8u w=0.42u l=0.13u
M3652 adc8b_0.side_cap8b_1.buf_8_4.z adc8b_0.sar12b_0.nl_sw[5] vddr vddr sg13_lv_pmos ad=0.34p pd=2.68u as=0.19p ps=1.38u w=1u l=0.13u
M3653 adc8b_0.sar12b_0.sg13cmos5l_buf_8_1.A a_99740_96108# vdd vdd sg13_lv_pmos ad=0.3808p pd=2.92u as=0.2128p ps=1.5u w=1.12u l=0.13u
M3654 adc8b_0.side_cap8b_1.buf_32_0.z adc8b_0.sar12b_0.nl_sw[0] vddr vddr sg13_lv_pmos ad=0.19p pd=1.38u as=0.19p ps=1.38u w=1u l=0.13u
M3655 adc8b_0.side_cap8b_0.buf_32_0.z adc8b_0.side_cap8b_0.in_l_sw[0] sg13cmos5l_Corner_1.vss sg13cmos5l_Corner_1.vss sg13_lv_nmos ad=95f pd=0.88u as=95f ps=0.88u w=0.5u l=0.13u
M3656 adc8b_0.sar12b_0.sg13cmos5l_a22oi_1_1.B1 adc8b_0.sar12b_0.sg13cmos5l_nand2_1_1.B sg13cmos5l_Corner_1.vss sg13cmos5l_Corner_1.vss sg13_lv_nmos ad=0.1406p pd=1.12u as=0.2516p ps=2.16u w=0.74u l=0.13u
M3657 vdd sg13cmos5l_IOPadVdd$1_0.sg13cmos5l_Clamp_N43N43D4R$1_0.gate sg13cmos5l_Corner_1.vss sg13cmos5l_Corner_1.vss sg13_hv_nmos ad=2.596p pd=5.58u as=1.408p ps=5.04u w=4.4u l=0.6u
M3658 a_101108_99560# adc8b_0.sar12b_0.sg13cmos5l_buf_1_107.X vdd vdd sg13_lv_pmos ad=0.2856p pd=2.36u as=0.2114p ps=1.54u w=0.84u l=0.13u
M3659 adc8b_0.sar12b_0.sg13cmos5l_o21ai_1_0.B1 adc8b_0.sar12b_0.sg13cmos5l_nand2_1_1.A a_96226_95430# sg13cmos5l_Corner_1.vss sg13_lv_nmos ad=0.2516p pd=2.16u as=0.1406p ps=1.12u w=0.74u l=0.13u
M3660 sg13cmos5l_Corner_1.vss a_84525_94277# a_84627_94420# sg13cmos5l_Corner_1.vss sg13_lv_nmos ad=2.59257p pd=16.445u as=0.2516p ps=2.16u w=0.74u l=0.13u
M3661 sg13cmos5l_Corner_1.iovdd a_102044_42476# data[2] sg13cmos5l_Corner_1.iovdd sg13_hv_pmos ad=2.1312p pd=7.3u as=3.9294p ps=7.84u w=6.66u l=0.6u
X3662 vin sg13cmos5l_Corner_1.iovdd dpantenna l=27.78u w=1.26u
M3663 sg13cmos5l_Corner_1.vss sg13cmos5l_IOPadVdd$1_0.sg13cmos5l_Clamp_N43N43D4R$1_0.gate vdd sg13cmos5l_Corner_1.vss sg13_hv_nmos ad=1.408p pd=5.04u as=2.596p ps=5.58u w=4.4u l=0.6u
M3664 sg13cmos5l_IOPadAnalog_15.pad a_99639_164698# sg13cmos5l_Corner_1.iovdd sg13cmos5l_Corner_1.iovdd sg13_hv_pmos ad=3.9294p pd=7.84u as=2.1312p ps=7.3u w=6.66u l=0.6u
M3665 adc8b_0.side_cap8b_0.buf_8_0.z adc8b_0.side_cap8b_0.in_l_sw[4] vddr vddr sg13_lv_pmos ad=0.34p pd=2.68u as=0.19p ps=1.38u w=1u l=0.13u
M3666 a_99964_99984# a_99548_99596# a_99729_99953# sg13cmos5l_Corner_1.vss sg13_lv_nmos ad=77.7f pd=0.95u as=0.2516p ps=2.16u w=0.74u l=0.13u
M3667 vdd sg13cmos5l_IOPadVdd$1_0.sg13cmos5l_Clamp_N43N43D4R$1_0.gate sg13cmos5l_Corner_1.vss sg13cmos5l_Corner_1.vss sg13_hv_nmos ad=2.596p pd=5.58u as=1.408p ps=5.04u w=4.4u l=0.6u
M3668 sg13cmos5l_Corner_1.vss a_83992_98326# a_83641_98445# sg13cmos5l_Corner_1.vss sg13_lv_nmos ad=79.8f pd=0.8u as=0.1428p ps=1.52u w=0.42u l=0.13u
M3669 vdd adc8b_0.sar12b_0.sg13cmos5l_inv_1_0.A adc8b_0.sar12b_0.sg13cmos5l_inv_1_0.Y vdd sg13_lv_pmos ad=0.3808p pd=2.92u as=0.3808p ps=2.92u w=1.12u l=0.13u
X3670 sg13cmos5l_IOPadAnalog_10.pad sg13cmos5l_IOPadAnalog_10.padres sg13cmos5l_Corner_1.vss rppd l=2u w=1u
M3671 cks a_42476_118044# sg13cmos5l_Corner_1.iovdd sg13cmos5l_Corner_1.iovdd sg13_hv_pmos ad=3.9294p pd=7.84u as=2.1312p ps=7.3u w=6.66u l=0.6u
M3672 sg13cmos5l_Corner_1.iovdd a_134044_42476# frame sg13cmos5l_Corner_1.iovdd sg13_hv_pmos ad=2.1312p pd=7.3u as=3.9294p ps=7.84u w=6.66u l=0.6u
M3673 sg13cmos5l_IOPadAnalog_0.pad a_178296_86044# sg13cmos5l_Corner_1.vss sg13cmos5l_Corner_1.vss sg13_hv_nmos ad=2.596p pd=5.58u as=1.408p ps=5.04u w=4.4u l=0.6u
M3674 sg13cmos5l_Corner_1.vss adc8b_0.side_cap8b_0.in_l_sw[1] adc8b_0.side_cap8b_0.buf_16_2.z sg13cmos5l_Corner_1.vss sg13_lv_nmos ad=95f pd=0.88u as=0.17p ps=1.68u w=0.5u l=0.13u
M3675 sg13cmos5l_Corner_1.vss adc8b_0.sar12b_0.nh_sw[0] adc8b_0.side_cap8b_1.buf_32_1.z sg13cmos5l_Corner_1.vss sg13_lv_nmos ad=95f pd=0.88u as=95f ps=0.88u w=0.5u l=0.13u
M3676 sg13cmos5l_Corner_1.iovdd a_83639_164698# sg13cmos5l_IOPadAnalog_9.pad sg13cmos5l_Corner_1.iovdd sg13_hv_pmos ad=2.1312p pd=7.3u as=3.9294p ps=7.84u w=6.66u l=0.6u
M3677 vdd adc8b_0.sar12b_0.sg13cmos5l_dfrbp_1_6.RESET_B a_91473_95810# vdd sg13_lv_pmos ad=0.2128p pd=1.5u as=0.2128p ps=1.5u w=1.12u l=0.13u
M3678 sg13cmos5l_Corner_1.vss a_70044_30676# data[0] sg13cmos5l_Corner_1.vss sg13_hv_nmos ad=1.408p pd=5.04u as=2.596p ps=5.58u w=4.4u l=0.6u
M3679 sg13cmos5l_Corner_1.vss adc8b_0.sar12b_0.nl_sw[4] adc8b_0.side_cap8b_1.buf_8_0.z sg13cmos5l_Corner_1.vss sg13_lv_nmos ad=95f pd=0.88u as=95f ps=0.88u w=0.5u l=0.13u
X3680 sg13cmos5l_Corner_1.vss a_102222_33862# dantenna l=1.26u w=27.78u
M3681 adc8b_0.side_cap8b_0.buf_16_1.z adc8b_0.side_cap8b_0.in_l_sw[2] vddr vddr sg13_lv_pmos ad=0.19p pd=1.38u as=0.19p ps=1.38u w=1u l=0.13u
M3682 adc8b_0.sar12b_0.sg13cmos5l_buf_1_10.A a_93616_99596# sg13cmos5l_Corner_1.vss sg13cmos5l_Corner_1.vss sg13_lv_nmos ad=0.2886p pd=2.26u as=0.14875p ps=1.16u w=0.74u l=0.13u
M3683 a_83992_98326# a_83735_98445# a_84154_98522# sg13cmos5l_Corner_1.vss sg13_lv_nmos ad=0.1428p pd=1.52u as=37.8f ps=0.6u w=0.42u l=0.13u
M3684 sg13cmos5l_Corner_1.vss sg13cmos5l_IOPadVdd$1_0.sg13cmos5l_Clamp_N43N43D4R$1_0.gate vdd sg13cmos5l_Corner_1.vss sg13_hv_nmos ad=1.408p pd=5.04u as=2.596p ps=5.58u w=4.4u l=0.6u
M3685 vdd a_98039_98911# a_98296_99054# vdd sg13_lv_pmos ad=0.2639p pd=1.81u as=79.8f ps=0.8u w=0.42u l=0.13u
M3686 a_83765_97286# a_84495_97540# a_84516_97286# sg13cmos5l_Corner_1.vss sg13_lv_nmos ad=0.12665p pd=1.145u as=0.3473p ps=2.71u w=0.74u l=0.13u
M3687 vdd adc8b_0.sar12b_0.sg13cmos5l_dfrbp_1_6.RESET_B a_93998_97322# vdd sg13_lv_pmos ad=0.36237p pd=2.605u as=79.8f ps=0.8u w=0.42u l=0.13u
M3688 a_100932_96974# a_100383_96930# a_100796_96572# sg13cmos5l_Corner_1.vss sg13_lv_nmos ad=47.25f pd=0.645u as=0.141p ps=1.17u w=0.42u l=0.13u
M3689 sg13cmos5l_Corner_1.vss a_100977_96929# a_100932_96974# sg13cmos5l_Corner_1.vss sg13_lv_nmos ad=0.1428p pd=1.52u as=47.25f ps=0.645u w=0.42u l=0.13u
M3690 a_97068_98847# a_96780_99152# a_97006_98847# sg13cmos5l_Corner_1.vss sg13_lv_nmos ad=0.1428p pd=1.52u as=37.8f ps=0.6u w=0.42u l=0.13u
M3691 sg13cmos5l_Corner_1.vss a_100131_95430# adc8b_0.sar12b_0.sg13cmos5l_or2_1_0.A sg13cmos5l_Corner_1.vss sg13_lv_nmos ad=0.1406p pd=1.12u as=0.1406p ps=1.12u w=0.74u l=0.13u
M3692 sg13cmos5l_Corner_1.vss adc8b_0.sar12b_0.nh_sw[0] adc8b_0.side_cap8b_1.buf_32_1.z sg13cmos5l_Corner_1.vss sg13_lv_nmos ad=95f pd=0.88u as=95f ps=0.88u w=0.5u l=0.13u
M3693 sg13cmos5l_Corner_1.vss cks a_100995_100350# sg13cmos5l_Corner_1.vss sg13_lv_nmos ad=0.1406p pd=1.12u as=0.2553p ps=2.17u w=0.74u l=0.13u
M3694 sg13cmos5l_IOPadAnalog_1.pad a_178296_70044# sg13cmos5l_Corner_1.vss sg13cmos5l_Corner_1.vss sg13_hv_nmos ad=2.596p pd=5.58u as=1.408p ps=5.04u w=4.4u l=0.6u
M3695 vdd a_89588_93512# adc8b_0.sar12b_0.sg13cmos5l_inv_1_14.A vdd sg13_lv_pmos ad=0.2114p pd=1.54u as=0.42p ps=2.99u w=1.12u l=0.13u
M3696 a_89292_99152# a_89266_99057# sg13cmos5l_Corner_1.vss sg13cmos5l_Corner_1.vss sg13_lv_nmos ad=0.2516p pd=2.16u as=0.1626p ps=1.415u w=0.74u l=0.13u
M3697 sg13cmos5l_Corner_1.vss a_96657_98441# a_97182_98514# sg13cmos5l_Corner_1.vss sg13_lv_nmos ad=0.1491p pd=1.18u as=0.187p ps=1.78u w=0.55u l=0.13u
M3698 a_92381_93918# adc8b_0.sar12b_0.sg13cmos5l_nand2_1_1.B sg13cmos5l_Corner_1.vss sg13cmos5l_Corner_1.vss sg13_lv_nmos ad=0.1406p pd=1.12u as=0.1898p ps=1.36u w=0.74u l=0.13u
M3699 a_83916_99600# a_83890_99564# vdd vdd sg13_lv_pmos ad=0.34p pd=2.68u as=0.36237p ps=2.605u w=1u l=0.13u
M3700 sg13cmos5l_Corner_1.vss adc8b_0.sar12b_0.sg13cmos5l_a22oi_1_0.Y adc8b_0.sar12b_0.sg13cmos5l_dfrbp_1_2.D sg13cmos5l_Corner_1.vss sg13_lv_nmos ad=0.2516p pd=2.16u as=0.2516p ps=2.16u w=0.74u l=0.13u
M3701 adc8b_0.side_cap8b_1.buf_32_1.z adc8b_0.sar12b_0.nh_sw[0] sg13cmos5l_Corner_1.vss sg13cmos5l_Corner_1.vss sg13_lv_nmos ad=95f pd=0.88u as=95f ps=0.88u w=0.5u l=0.13u
M3702 sg13cmos5l_Corner_1.vss a_30676_70044# vddr sg13cmos5l_Corner_1.vss sg13_hv_nmos ad=1.408p pd=5.04u as=2.596p ps=5.58u w=4.4u l=0.6u
M3703 a_92433_99225# a_92076_99152# vdd vdd sg13_lv_pmos ad=63f pd=0.72u as=0.1563p ps=1.22u w=0.42u l=0.13u
M3704 sg13cmos5l_Corner_1.vss adc8b_0.sar12b_0.sg13cmos5l_or2_1_0.A adc8b_0.sar12b_0.sg13cmos5l_nand2_1_2.B sg13cmos5l_Corner_1.vss sg13_lv_nmos ad=0.2516p pd=2.16u as=0.1406p ps=1.12u w=0.74u l=0.13u
M3705 a_85367_94375# a_84525_94277# a_84108_94616# vdd sg13_lv_pmos ad=0.2048p pd=1.63u as=0.34p ps=2.68u w=1u l=0.13u
M3706 vdd a_88247_93909# a_88504_93790# vdd sg13_lv_pmos ad=0.2639p pd=1.81u as=79.8f ps=0.8u w=0.42u l=0.13u
M3707 vip a_42476_102044# sg13cmos5l_Corner_1.iovdd sg13cmos5l_Corner_1.iovdd sg13_hv_pmos ad=3.9294p pd=7.84u as=2.1312p ps=7.3u w=6.66u l=0.6u
M3708 a_97836_98088# a_97810_98052# sg13cmos5l_Corner_1.vss sg13cmos5l_Corner_1.vss sg13_lv_nmos ad=0.2516p pd=2.16u as=0.1626p ps=1.415u w=0.74u l=0.13u
M3709 vdd a_91796_97286# adc8b_0.sar12b_0.sg13cmos5l_inv_1_18.A vdd sg13_lv_pmos ad=0.2114p pd=1.54u as=0.42p ps=2.99u w=1.12u l=0.13u
M3710 adc8b_0.sar12b_0.sg13cmos5l_buf_1_28.X a_91216_92824# sg13cmos5l_Corner_1.vss sg13cmos5l_Corner_1.vss sg13_lv_nmos ad=0.2886p pd=2.26u as=0.14875p ps=1.16u w=0.74u l=0.13u
M3711 adc8b_0.side_cap8b_0.buf_8_5.z adc8b_0.side_cap8b_0.in_h_sw[5] sg13cmos5l_Corner_1.vss sg13cmos5l_Corner_1.vss sg13_lv_nmos ad=95f pd=0.88u as=95f ps=0.88u w=0.5u l=0.13u
M3712 adc8b_0.sar12b_0.sg13cmos5l_inv_1_2.A a_90256_100384# sg13cmos5l_Corner_1.vss sg13cmos5l_Corner_1.vss sg13_lv_nmos ad=0.2886p pd=2.26u as=0.14875p ps=1.16u w=0.74u l=0.13u
M3713 sg13cmos5l_IOPadAnalog_11.pad a_164624_118044# sg13cmos5l_Corner_1.iovdd sg13cmos5l_Corner_1.iovdd sg13_hv_pmos ad=3.9294p pd=7.84u as=2.1312p ps=7.3u w=6.66u l=0.6u
M3714 a_92364_98847# a_92595_98956# a_92050_99057# sg13cmos5l_Corner_1.vss sg13_lv_nmos ad=0.2373p pd=1.97u as=79.8f ps=0.8u w=0.42u l=0.13u
M3715 a_92302_98847# adc8b_0.sar12b_0.sg13cmos5l_dfrbp_1_6.RESET_B sg13cmos5l_Corner_1.vss sg13cmos5l_Corner_1.vss sg13_lv_nmos ad=37.8f pd=0.6u as=0.1701p ps=1.65u w=0.42u l=0.13u
X3716 sg13cmos5l_Corner_1.vss a_32962_70222# dantenna l=27.78u w=1.26u
M3717 a_85175_99957# a_84333_99607# a_85081_99957# sg13cmos5l_Corner_1.vss sg13_lv_nmos ad=0.12665p pd=1.145u as=0.1428p ps=1.52u w=0.42u l=0.13u
M3718 a_85076_96536# adc8b_0.sar12b_0.sg13cmos5l_dlhr_1_1.Q sg13cmos5l_Corner_1.vss sg13cmos5l_Corner_1.vss sg13_lv_nmos ad=0.187p pd=1.78u as=0.14875p ps=1.16u w=0.55u l=0.13u
M3719 a_96830_95452# adc8b_0.sar12b_0.sg13cmos5l_a22oi_1_1.B2 adc8b_0.sar12b_0.sg13cmos5l_a22oi_1_1.Y sg13cmos5l_Corner_1.vss sg13_lv_nmos ad=0.13875p pd=1.115u as=0.2664p ps=1.46u w=0.74u l=0.13u
M3720 sg13cmos5l_Corner_1.vss adc8b_0.sar12b_0.sg13cmos5l_dfrbp_1_6.RESET_B a_98066_95498# sg13cmos5l_Corner_1.vss sg13_lv_nmos ad=79.8f pd=0.8u as=37.8f ps=0.6u w=0.42u l=0.13u
M3721 sg13cmos5l_IOPadAnalog_10.pad a_67639_164698# sg13cmos5l_Corner_1.iovdd sg13cmos5l_Corner_1.iovdd sg13_hv_pmos ad=3.9294p pd=7.84u as=2.1312p ps=7.3u w=6.66u l=0.6u
M3722 adc8b_0.side_cap8b_0.buf_32_0.z adc8b_0.side_cap8b_0.in_l_sw[0] vddr vddr sg13_lv_pmos ad=0.19p pd=1.38u as=0.19p ps=1.38u w=1u l=0.13u
M3723 vddr adc8b_0.side_cap8b_0.in_h_sw[2] adc8b_0.side_cap8b_0.buf_16_0.z vddr sg13_lv_pmos ad=0.19p pd=1.38u as=0.19p ps=1.38u w=1u l=0.13u
M3724 adc8b_0.sar12b_0.sg13cmos5l_dfrbp_1_22.D a_98492_99596# sg13cmos5l_Corner_1.vss sg13cmos5l_Corner_1.vss sg13_lv_nmos ad=0.2516p pd=2.16u as=0.1406p ps=1.12u w=0.74u l=0.13u
M3725 sg13cmos5l_Corner_1.iovdd a_70044_42476# data[0] sg13cmos5l_Corner_1.iovdd sg13_hv_pmos ad=2.1312p pd=7.3u as=3.9294p ps=7.84u w=6.66u l=0.6u
M3726 sg13cmos5l_Corner_1.iovdd a_134044_42476# frame sg13cmos5l_Corner_1.iovdd sg13_hv_pmos ad=2.1312p pd=7.3u as=3.9294p ps=7.84u w=6.66u l=0.6u
M3727 a_96668_93512# adc8b_0.sar12b_0.sg13cmos5l_nor2_1_1.A vdd vdd sg13_lv_pmos ad=0.2856p pd=2.36u as=0.2618p ps=1.63u w=0.84u l=0.13u
M3728 a_82388_93512# adc8b_0.sar12b_0.sg13cmos5l_buf_1_32.X vdd vdd sg13_lv_pmos ad=0.2856p pd=2.36u as=0.2114p ps=1.54u w=0.84u l=0.13u
M3729 adc8b_0.side_cap8b_0.buf_16_3.z adc8b_0.side_cap8b_0.in_h_sw[1] vddr vddr sg13_lv_pmos ad=0.19p pd=1.38u as=0.19p ps=1.38u w=1u l=0.13u
M3730 a_85432_99838# adc8b_0.sar12b_0.sg13cmos5l_dfrbp_1_8.RESET_B vdd vdd sg13_lv_pmos ad=79.8f pd=0.8u as=1.12242p ps=7u w=0.42u l=0.13u
M3731 sg13cmos5l_IOPadAnalog_11.pad a_178296_118044# sg13cmos5l_Corner_1.vss sg13cmos5l_Corner_1.vss sg13_hv_nmos ad=2.596p pd=5.58u as=1.408p ps=5.04u w=4.4u l=0.6u
M3732 vddr adc8b_0.sar12b_0.nh_sw[6] adc8b_0.side_cap8b_1.buf_4_1.z vddr sg13_lv_pmos ad=0.19p pd=1.38u as=0.34p ps=2.68u w=1u l=0.13u
M3733 sg13cmos5l_IOPadAnalog_0.pad a_164624_86044# sg13cmos5l_Corner_1.iovdd sg13cmos5l_Corner_1.iovdd sg13_hv_pmos ad=3.9294p pd=7.84u as=2.1312p ps=7.3u w=6.66u l=0.6u
M3734 a_92950_96108# adc8b_0.sar12b_0.sg13cmos5l_a221oi_1_0.A2 vdd vdd sg13_lv_pmos ad=0.2128p pd=1.5u as=0.3808p ps=2.92u w=1.12u l=0.13u
M3735 a_93228_93552# a_93202_93516# vdd vdd sg13_lv_pmos ad=0.34p pd=2.68u as=0.36237p ps=2.605u w=1u l=0.13u
M3736 cks a_30676_118044# sg13cmos5l_Corner_1.vss sg13cmos5l_Corner_1.vss sg13_hv_nmos ad=2.596p pd=5.58u as=1.408p ps=5.04u w=4.4u l=0.6u
M3737 sg13cmos5l_Corner_1.vss a_30676_102044# vip sg13cmos5l_Corner_1.vss sg13_hv_nmos ad=1.408p pd=5.04u as=2.596p ps=5.58u w=4.4u l=0.6u
M3738 vip a_42476_102044# sg13cmos5l_Corner_1.iovdd sg13cmos5l_Corner_1.iovdd sg13_hv_pmos ad=3.9294p pd=7.84u as=2.1312p ps=7.3u w=6.66u l=0.6u
M3739 vdd adc8b_0.sar12b_0.sg13cmos5l_dfrbp_1_10.Q a_92099_95060# vdd sg13_lv_pmos ad=0.2128p pd=1.5u as=0.2128p ps=1.5u w=1.12u l=0.13u
M3740 sg13cmos5l_Corner_1.vss adc8b_0.sar12b_0.sg13cmos5l_buf_1_10.A a_94288_94336# sg13cmos5l_Corner_1.vss sg13_lv_nmos ad=0.14875p pd=1.16u as=0.187p ps=1.78u w=0.55u l=0.13u
X3741 sg13cmos5l_IOPadAnalog_0.pad sg13cmos5l_Corner_1.iovdd dpantenna l=27.78u w=1.26u
M3742 a_93454_93973# adc8b_0.sar12b_0.sg13cmos5l_dfrbp_1_0.RESET_B sg13cmos5l_Corner_1.vss sg13cmos5l_Corner_1.vss sg13_lv_nmos ad=37.8f pd=0.6u as=0.1701p ps=1.65u w=0.42u l=0.13u
M3743 sg13cmos5l_Corner_1.iovdd a_99639_164698# sg13cmos5l_IOPadAnalog_15.pad sg13cmos5l_Corner_1.iovdd sg13_hv_pmos ad=2.1312p pd=7.3u as=3.9294p ps=7.84u w=6.66u l=0.6u
M3744 adc8b_0.side_cap8b_0.buf_4_1.z adc8b_0.side_cap8b_0.in_h_sw[6] sg13cmos5l_Corner_1.vss sg13cmos5l_Corner_1.vss sg13_lv_nmos ad=0.17p pd=1.68u as=95f ps=0.88u w=0.5u l=0.13u
M3745 sg13cmos5l_Corner_1.vss vdd sg13cmos5l_Corner_1.vss sg13cmos5l_Corner_1.vss sg13_lv_nmos ad=0.1428p pd=1.52u as=0 ps=0 w=0.42u l=1u
M3746 adc8b_0.sar12b_0.sg13cmos5l_buf_1_26.A adc8b_0.sar12b_0.sg13cmos5l_buf_1_45.X sg13cmos5l_Corner_1.vss sg13cmos5l_Corner_1.vss sg13_lv_nmos ad=0.2516p pd=2.16u as=0.2516p ps=2.16u w=0.74u l=0.13u
M3747 sg13cmos5l_Corner_1.iovdd a_115639_164698# sg13cmos5l_IOPadAnalog_13.pad sg13cmos5l_Corner_1.iovdd sg13_hv_pmos ad=2.1312p pd=7.3u as=3.9294p ps=7.84u w=6.66u l=0.6u
M3748 a_95469_94277# adc8b_0.sar12b_0.sg13cmos5l_dfrbp_1_0.CLK sg13cmos5l_Corner_1.vss sg13cmos5l_Corner_1.vss sg13_lv_nmos ad=0.2516p pd=2.16u as=2.43055p ps=15.415u w=0.74u l=0.13u
M3749 adc8b_0.side_cap8b_1.buf_2_0.z adc8b_0.sar12b_0.nh_sw[8] sg13cmos5l_Corner_1.vss sg13cmos5l_Corner_1.vss sg13_lv_nmos ad=0.17p pd=1.68u as=95f ps=0.88u w=0.5u l=0.13u
M3750 sg13cmos5l_Corner_1.iovdd a_42476_70044# vddr sg13cmos5l_Corner_1.iovdd sg13_hv_pmos ad=2.1312p pd=7.3u as=3.9294p ps=7.84u w=6.66u l=0.6u
M3751 adc8b_0.side_cap8b_0.buf_32_0.z adc8b_0.side_cap8b_0.in_l_sw[0] sg13cmos5l_Corner_1.vss sg13cmos5l_Corner_1.vss sg13_lv_nmos ad=95f pd=0.88u as=95f ps=0.88u w=0.5u l=0.13u
M3752 a_101316_97358# a_100767_97338# a_101180_97644# sg13cmos5l_Corner_1.vss sg13_lv_nmos ad=47.25f pd=0.645u as=0.141p ps=1.17u w=0.42u l=0.13u
M3753 data[1] a_86044_42476# sg13cmos5l_Corner_1.iovdd sg13cmos5l_Corner_1.iovdd sg13_hv_pmos ad=3.9294p pd=7.84u as=2.1312p ps=7.3u w=6.66u l=0.6u
M3754 adc8b_0.sar12b_0.sg13cmos5l_buf_1_5.X a_96208_92824# vdd vdd sg13_lv_pmos ad=0.42p pd=2.99u as=0.2114p ps=1.54u w=1.12u l=0.13u
M3755 vdd sg13cmos5l_IOPadVdd$1_0.sg13cmos5l_Clamp_N43N43D4R$1_0.gate sg13cmos5l_Corner_1.vss sg13cmos5l_Corner_1.vss sg13_hv_nmos ad=2.596p pd=5.58u as=1.408p ps=5.04u w=4.4u l=0.6u
M3756 vdd a_90932_92750# adc8b_0.sar12b_0.sg13cmos5l_buf_1_26.X vdd sg13_lv_pmos ad=0.2114p pd=1.54u as=0.42p ps=2.99u w=1.12u l=0.13u
M3757 vdd a_87092_92750# adc8b_0.sar12b_0.sg13cmos5l_buf_1_39.A vdd sg13_lv_pmos ad=0.2114p pd=1.54u as=0.42p ps=2.99u w=1.12u l=0.13u
M3758 a_91647_100362# adc8b_0.sar12b_0.sg13cmos5l_dfrbp_1_18.Q sg13cmos5l_Corner_1.vss sg13cmos5l_Corner_1.vss sg13_lv_nmos ad=0.2516p pd=2.16u as=0.15055p ps=1.17u w=0.74u l=0.13u
M3759 vddr adc8b_0.sar12b_0.nl_sw[0] adc8b_0.side_cap8b_1.buf_32_0.z vddr sg13_lv_pmos ad=0.19p pd=1.38u as=0.19p ps=1.38u w=1u l=0.13u
M3760 sg13cmos5l_Corner_1.vss a_97652_94262# adc8b_0.sar12b_0.nh_sw[7] sg13cmos5l_Corner_1.vss sg13_lv_nmos ad=0.14875p pd=1.16u as=0.2886p ps=2.26u w=0.74u l=0.13u
M3761 adc8b_0.sar12b_0.sg13cmos5l_buf_1_79.X a_91024_100384# sg13cmos5l_Corner_1.vss sg13cmos5l_Corner_1.vss sg13_lv_nmos ad=0.2886p pd=2.26u as=0.14875p ps=1.16u w=0.74u l=0.13u
M3762 sg13cmos5l_Corner_1.vss a_97197_98813# a_97299_98956# sg13cmos5l_Corner_1.vss sg13_lv_nmos ad=1.49685p pd=9.6u as=0.2516p ps=2.16u w=0.74u l=0.13u
M3763 a_85644_95823# a_85875_95932# a_85330_96033# sg13cmos5l_Corner_1.vss sg13_lv_nmos ad=0.2373p pd=1.97u as=79.8f ps=0.8u w=0.42u l=0.13u
M3764 vdd a_84516_97286# a_85539_97713# vdd sg13_lv_pmos ad=0.1563p pd=1.22u as=63f ps=0.72u w=0.42u l=0.13u
M3765 sg13cmos5l_Corner_1.vss a_178296_86044# sg13cmos5l_IOPadAnalog_0.pad sg13cmos5l_Corner_1.vss sg13_hv_nmos ad=1.408p pd=5.04u as=2.596p ps=5.58u w=4.4u l=0.6u
M3766 sg13cmos5l_IOPadAnalog_16.pad a_164624_102044# sg13cmos5l_Corner_1.iovdd sg13cmos5l_Corner_1.iovdd sg13_hv_pmos ad=3.9294p pd=7.84u as=2.1312p ps=7.3u w=6.66u l=0.6u
M3767 a_96622_100021# adc8b_0.sar12b_0.sg13cmos5l_dfrbp_1_8.RESET_B sg13cmos5l_Corner_1.vss sg13cmos5l_Corner_1.vss sg13_lv_nmos ad=37.8f pd=0.6u as=0.1701p ps=1.65u w=0.42u l=0.13u
M3768 a_92050_99057# a_92493_98813# a_92433_99225# vdd sg13_lv_pmos ad=79.8f pd=0.8u as=63f ps=0.72u w=0.42u l=0.13u
M3769 a_99322_95810# adc8b_0.sar12b_0.sg13cmos5l_dfrbp_1_8.RESET_B sg13cmos5l_Corner_1.vss sg13cmos5l_Corner_1.vss sg13_lv_nmos ad=37.8f pd=0.6u as=79.8f ps=0.8u w=0.42u l=0.13u
M3770 a_90609_96929# a_90428_96572# vdd vdd sg13_lv_pmos ad=0.2128p pd=1.5u as=0.2387p ps=1.84u w=1.12u l=0.13u
M3771 sg13cmos5l_Corner_1.vss a_30676_118044# cks sg13cmos5l_Corner_1.vss sg13_hv_nmos ad=2.068p pd=9.74u as=2.596p ps=5.58u w=4.4u l=0.6u
M3772 adc8b_0.side_cap8b_0.buf_16_2.z adc8b_0.side_cap8b_0.in_l_sw[1] vddr vddr sg13_lv_pmos ad=0.19p pd=1.38u as=0.19p ps=1.38u w=1u l=0.13u
M3773 sg13cmos5l_IOPadAnalog_16.pad a_178296_102044# sg13cmos5l_Corner_1.vss sg13cmos5l_Corner_1.vss sg13_hv_nmos ad=2.596p pd=5.58u as=1.408p ps=5.04u w=4.4u l=0.6u
M3774 a_87885_97301# adc8b_0.sar12b_0.sg13cmos5l_dlhr_1_5.GATE vdd vdd sg13_lv_pmos ad=0.4088p pd=2.97u as=1.04815p ps=6.595u w=1.12u l=0.13u
X3775 sg13cmos5l_IOPadAnalog_15.pad sg13cmos5l_Corner_1.iovdd dpantenna l=1.26u w=27.78u
M3776 sg13cmos5l_Corner_1.vss adc8b_0.sar12b_0.nl_sw[1] adc8b_0.side_cap8b_1.buf_16_2.z sg13cmos5l_Corner_1.vss sg13_lv_nmos ad=95f pd=0.88u as=95f ps=0.88u w=0.5u l=0.13u
M3777 adc8b_0.sar12b_0.sg13cmos5l_nand2_1_0.A adc8b_0.sar12b_0.sg13cmos5l_dfrbp_1_0.Q sg13cmos5l_Corner_1.vss sg13cmos5l_Corner_1.vss sg13_lv_nmos ad=0.1406p pd=1.12u as=0.2516p ps=2.16u w=0.74u l=0.13u
M3778 sg13cmos5l_IOPadVdd$1_0.sg13cmos5l_Clamp_N43N43D4R$1_0.gate sg13cmos5l_IOPadVdd$1_0.sg13cmos5l_RCClampInverter$1_0.in vdd vdd sg13_hv_pmos ad=1.33p pd=7.38u as=1.33p ps=7.38u w=7u l=0.5u
X3779 sg13cmos5l_Corner_1.vss a_30676_70044# sg13cmos5l_Corner_1.vss rppd l=3.54u w=0.5u
M3780 sg13cmos5l_Corner_1.vss adc8b_0.side_cap8b_0.in_h_sw[3] adc8b_0.side_cap8b_0.buf_8_3.z sg13cmos5l_Corner_1.vss sg13_lv_nmos ad=95f pd=0.88u as=0.17p ps=1.68u w=0.5u l=0.13u
M3781 a_97197_98813# adc8b_0.sar12b_0.sg13cmos5l_dfrbp_1_22.D vdd vdd sg13_lv_pmos ad=0.4088p pd=2.97u as=1.12242p ps=7u w=1.12u l=0.13u
M3782 sg13cmos5l_Corner_1.iovdd a_70044_42476# data[0] sg13cmos5l_Corner_1.iovdd sg13_hv_pmos ad=2.1312p pd=7.3u as=3.9294p ps=7.84u w=6.66u l=0.6u
M3783 vddr adc8b_0.side_cap8b_0.in_h_sw[9] adc8b_0.side_cap8b_0.buf_2_3.z vddr sg13_lv_pmos ad=0.19p pd=1.38u as=0.34p ps=2.68u w=1u l=0.13u
M3784 vdd adc8b_0.sar12b_0.sg13cmos5l_dlhr_1_6.D a_90001_97376# vdd sg13_lv_pmos ad=1.07253p pd=6.75u as=0.2856p ps=2.36u w=0.84u l=0.13u
M3785 a_95052_94616# a_95026_94521# sg13cmos5l_Corner_1.vss sg13cmos5l_Corner_1.vss sg13_lv_nmos ad=0.2516p pd=2.16u as=0.1626p ps=1.415u w=0.74u l=0.13u
M3786 adc8b_0.side_cap8b_0.buf_32_1.z adc8b_0.side_cap8b_0.in_h_sw[0] sg13cmos5l_Corner_1.vss sg13cmos5l_Corner_1.vss sg13_lv_nmos ad=95f pd=0.88u as=95f ps=0.88u w=0.5u l=0.13u
M3787 vdd a_91799_99957# a_92056_99838# vdd sg13_lv_pmos ad=0.2639p pd=1.81u as=79.8f ps=0.8u w=0.42u l=0.13u
M3788 a_87278_95498# adc8b_0.sar12b_0.sg13cmos5l_dfrbp_1_6.D vdd vdd sg13_lv_pmos ad=79.8f pd=0.8u as=0.1428p ps=1.52u w=0.42u l=0.13u
M3789 vdd adc8b_0.sar12b_0.sg13cmos5l_buf_1_97.A a_93616_99596# vdd sg13_lv_pmos ad=0.2114p pd=1.54u as=0.2856p ps=2.36u w=0.84u l=0.13u
M3790 a_95164_98472# a_94748_98084# a_94929_98441# sg13cmos5l_Corner_1.vss sg13_lv_nmos ad=77.7f pd=0.95u as=0.2516p ps=2.16u w=0.74u l=0.13u
M3791 sg13cmos5l_Corner_1.vss a_102044_30676# data[2] sg13cmos5l_Corner_1.vss sg13_hv_nmos ad=1.408p pd=5.04u as=2.596p ps=5.58u w=4.4u l=0.6u
M3792 adc8b_0.side_cap8b_1.buf_16_2.z adc8b_0.sar12b_0.nl_sw[1] vddr vddr sg13_lv_pmos ad=0.19p pd=1.38u as=0.19p ps=1.38u w=1u l=0.13u
M3793 sg13cmos5l_Corner_1.vss adc8b_0.sar12b_0.nl_sw[0] adc8b_0.side_cap8b_1.buf_32_0.z sg13cmos5l_Corner_1.vss sg13_lv_nmos ad=95f pd=0.88u as=95f ps=0.88u w=0.5u l=0.13u
X3794 sg13cmos5l_Corner_1.vss a_175886_86222# dantenna l=27.78u w=1.26u
M3795 data[1] a_86044_42476# sg13cmos5l_Corner_1.iovdd sg13cmos5l_Corner_1.iovdd sg13_hv_pmos ad=3.9294p pd=7.84u as=2.1312p ps=7.3u w=6.66u l=0.6u
M3796 sg13cmos5l_Corner_1.iovdd a_67639_164698# sg13cmos5l_IOPadAnalog_10.pad sg13cmos5l_Corner_1.iovdd sg13_hv_pmos ad=2.1312p pd=7.3u as=3.9294p ps=7.84u w=6.66u l=0.6u
M3797 vdd adc8b_0.sar12b_0.sg13cmos5l_dlhr_1_2.D a_88465_94352# vdd sg13_lv_pmos ad=1.43437p pd=9.105u as=0.2856p ps=2.36u w=0.84u l=0.13u
M3798 adc8b_0.side_cap8b_0.buf_8_1.z adc8b_0.side_cap8b_0.in_l_sw[3] sg13cmos5l_Corner_1.vss sg13cmos5l_Corner_1.vss sg13_lv_nmos ad=0.17p pd=1.68u as=95f ps=0.88u w=0.5u l=0.13u
M3799 vdd adc8b_0.sar12b_0.sg13cmos5l_dlhr_1_6.D a_95254_96572# vdd sg13_lv_pmos ad=0.3808p pd=2.92u as=0.2128p ps=1.5u w=1.12u l=0.13u
M3800 vdd adc8b_0.sar12b_0.sg13cmos5l_buf_1_111.A a_100144_100384# vdd sg13_lv_pmos ad=0.2114p pd=1.54u as=0.2856p ps=2.36u w=0.84u l=0.13u
M3801 a_92388_98486# a_91839_98442# a_92252_98084# sg13cmos5l_Corner_1.vss sg13_lv_nmos ad=47.25f pd=0.645u as=0.141p ps=1.17u w=0.42u l=0.13u
M3802 a_83630_95498# adc8b_0.sar12b_0.sg13cmos5l_dlhr_1_1.GATE vdd vdd sg13_lv_pmos ad=79.8f pd=0.8u as=0.1428p ps=1.52u w=0.42u l=0.13u
M3803 sg13cmos5l_Corner_1.iovdd a_164624_118044# sg13cmos5l_IOPadAnalog_11.pad sg13cmos5l_Corner_1.iovdd sg13_hv_pmos ad=2.1312p pd=7.3u as=3.9294p ps=7.84u w=6.66u l=0.6u
M3804 sg13cmos5l_Corner_1.vss sg13cmos5l_IOPadVdd$1_0.sg13cmos5l_Clamp_N43N43D4R$1_0.gate vdd sg13cmos5l_Corner_1.vss sg13_hv_nmos ad=1.408p pd=5.04u as=2.596p ps=5.58u w=4.4u l=0.6u
M3805 adc8b_0.side_cap8b_0.buf_2_2.z adc8b_0.side_cap8b_0.in_l_sw[9] sg13cmos5l_Corner_1.vss sg13cmos5l_Corner_1.vss sg13_lv_nmos ad=0.17p pd=1.68u as=95f ps=0.88u w=0.5u l=0.13u
M3806 a_97550_98522# a_98355_98095# a_97810_98052# vdd sg13_lv_pmos ad=0.1428p pd=1.52u as=79.8f ps=0.8u w=0.42u l=0.13u
M3807 cko a_118044_42476# sg13cmos5l_Corner_1.iovdd sg13cmos5l_Corner_1.iovdd sg13_hv_pmos ad=3.9294p pd=7.84u as=2.1312p ps=7.3u w=6.66u l=0.6u
M3808 sg13cmos5l_Corner_1.vss a_100995_100350# adc8b_0.sar12b_0.sg13cmos5l_buf_8_2.X sg13cmos5l_Corner_1.vss sg13_lv_nmos ad=0.2516p pd=2.16u as=0.1406p ps=1.12u w=0.74u l=0.13u
M3809 a_95092_95856# adc8b_0.sar12b_0.sg13cmos5l_inv_1_0.A vdd vdd sg13_lv_pmos ad=0.1596p pd=1.22u as=0.1596p ps=1.22u w=0.84u l=0.13u
M3810 vdd a_98039_98911# a_98876_99132# vdd sg13_lv_pmos ad=0.2128p pd=1.5u as=0.3864p ps=2.93u w=1.12u l=0.13u
M3811 a_91591_93524# adc8b_0.sar12b_0.sg13cmos5l_inv_1_11.Y vdd vdd sg13_lv_pmos ad=0.2716p pd=1.605u as=0.3808p ps=2.92u w=1.12u l=0.13u
M3812 sg13cmos5l_IOPadVdd$1_0.sg13cmos5l_Clamp_N43N43D4R$1_0.gate sg13cmos5l_IOPadVdd$1_0.sg13cmos5l_RCClampInverter$1_0.in vdd vdd sg13_hv_pmos ad=1.33p pd=7.38u as=1.33p ps=7.38u w=7u l=0.5u
M3813 sg13cmos5l_Corner_1.vss vdd sg13cmos5l_Corner_1.vss sg13cmos5l_Corner_1.vss sg13_lv_nmos ad=0.1428p pd=1.52u as=0 ps=0 w=0.42u l=1u
M3814 sg13cmos5l_Corner_1.vss a_94317_100325# a_94419_100468# sg13cmos5l_Corner_1.vss sg13_lv_nmos ad=2.92392p pd=18.89u as=0.2516p ps=2.16u w=0.74u l=0.13u
M3815 a_98039_98911# a_97197_98813# a_96780_99152# vdd sg13_lv_pmos ad=0.2048p pd=1.63u as=0.34p ps=2.68u w=1u l=0.13u
M3816 a_99544_97542# adc8b_0.sar12b_0.sg13cmos5l_dfrbp_1_6.RESET_B vdd vdd sg13_lv_pmos ad=79.8f pd=0.8u as=1.04815p ps=6.595u w=0.42u l=0.13u
M3817 vdd a_83735_96933# a_84572_96572# vdd sg13_lv_pmos ad=0.2128p pd=1.5u as=0.3864p ps=2.93u w=1.12u l=0.13u
M3818 adc8b_0.sar12b_0.sg13cmos5l_o21ai_1_0.B1 adc8b_0.sar12b_0.sg13cmos5l_nand2_1_1.B vdd vdd sg13_lv_pmos ad=0.2128p pd=1.5u as=0.3808p ps=2.92u w=1.12u l=0.13u
M3819 vddr adc8b_0.side_cap8b_0.in_l_sw[0] adc8b_0.side_cap8b_0.buf_32_0.z vddr sg13_lv_pmos ad=0.19p pd=1.38u as=0.19p ps=1.38u w=1u l=0.13u
M3820 a_86900_100310# adc8b_0.sar12b_0.sg13cmos5l_buf_1_44.X vdd vdd sg13_lv_pmos ad=0.2856p pd=2.36u as=0.2114p ps=1.54u w=0.84u l=0.13u
M3821 a_87278_95498# a_88083_95071# a_87538_95028# vdd sg13_lv_pmos ad=0.1428p pd=1.52u as=79.8f ps=0.8u w=0.42u l=0.13u
M3822 a_93298_95028# a_93741_95071# a_93038_95498# sg13cmos5l_Corner_1.vss sg13_lv_nmos ad=79.8f pd=0.8u as=0.1296p ps=1.52u w=0.42u l=0.13u
X3823 a_70044_42476# sg13cmos5l_Corner_1.iovdd sg13cmos5l_Corner_1.iovdd rppd l=12.9u w=0.5u
X3824 sg13cmos5l_IOPadAnalog_10.pad sg13cmos5l_Corner_1.iovdd dpantenna l=1.26u w=27.78u
M3825 adc8b_0.side_cap8b_0.buf_8_2.z adc8b_0.side_cap8b_0.in_h_sw[4] sg13cmos5l_Corner_1.vss sg13cmos5l_Corner_1.vss sg13_lv_nmos ad=0.17p pd=1.68u as=95f ps=0.88u w=0.5u l=0.13u
M3826 adc8b_0.sar12b_0.sg13cmos5l_nand2_1_0.B adc8b_0.sar12b_0.sg13cmos5l_a221oi_1_0.C1 vdd vdd sg13_lv_pmos ad=0.2128p pd=1.5u as=0.2198p ps=1.53u w=1.12u l=0.13u
M3827 adc8b_0.sar12b_0.sg13cmos5l_dlhr_1_21.Q_N a_92766_100328# vdd vdd sg13_lv_pmos ad=0.3808p pd=2.92u as=0.1974p ps=1.5u w=1.12u l=0.13u
M3828 sg13cmos5l_Corner_1.vss adc8b_0.cmp_0.sg13cmos5l_dlygate4sd3_1$1_0.A a_80424_96641# sg13cmos5l_Corner_1.vss sg13_lv_nmos ad=79.8f pd=0.8u as=0.1428p ps=1.52u w=0.42u l=0.13u
M3829 vdd a_83735_96933# a_83992_96814# vdd sg13_lv_pmos ad=0.2639p pd=1.81u as=79.8f ps=0.8u w=0.42u l=0.13u
M3830 a_88140_96128# a_88114_96033# vdd vdd sg13_lv_pmos ad=0.34p pd=2.68u as=0.36237p ps=2.605u w=1u l=0.13u
M3831 sg13cmos5l_Corner_1.vss a_96945_96929# a_97470_97002# sg13cmos5l_Corner_1.vss sg13_lv_nmos ad=0.1491p pd=1.18u as=0.187p ps=1.78u w=0.55u l=0.13u
M3832 vdd adc8b_0.sar12b_0.sg13cmos5l_a22oi_1_0.Y adc8b_0.sar12b_0.sg13cmos5l_dfrbp_1_2.D vdd sg13_lv_pmos ad=0.3808p pd=2.92u as=0.3808p ps=2.92u w=1.12u l=0.13u
M3833 sg13cmos5l_Corner_1.iovdd a_102044_42476# data[2] sg13cmos5l_Corner_1.iovdd sg13_hv_pmos ad=2.1312p pd=7.3u as=3.9294p ps=7.84u w=6.66u l=0.6u
M3834 sg13cmos5l_Corner_1.iovdd a_102044_42476# data[2] sg13cmos5l_Corner_1.iovdd sg13_hv_pmos ad=3.1302p pd=14.26u as=3.9294p ps=7.84u w=6.66u l=0.6u
M3835 vdd adc8b_0.cmp_0.clk a_73970_98361# vdd sg13_lv_pmos ad=95f pd=0.88u as=0.17p ps=1.68u w=0.5u l=0.13u
M3836 adc8b_0.sar12b_0.sg13cmos5l_dfrbp_1_16.Q_N a_83735_98445# vdd vdd sg13_lv_pmos ad=0.4312p pd=3.01u as=0.2639p ps=1.81u w=1.12u l=0.13u
M3837 a_96408_98084# a_95857_98442# vdd vdd sg13_lv_pmos ad=0.105p pd=1.21u as=1.07253p ps=6.75u w=1u l=0.13u
M3838 sg13cmos5l_Corner_1.vss vdd sg13cmos5l_Corner_1.vss sg13cmos5l_Corner_1.vss sg13_lv_nmos ad=0.1428p pd=1.52u as=0 ps=0 w=0.42u l=1u
M3839 vdd adc8b_0.sar12b_0.sg13cmos5l_dfrbp_1_6.RESET_B a_96945_96929# vdd sg13_lv_pmos ad=0.2128p pd=1.5u as=0.2128p ps=1.5u w=1.12u l=0.13u
X3840 vddr sg13cmos5l_Corner_1.iovdd dpantenna l=27.78u w=1.26u
M3841 adc8b_0.side_cap8b_0.buf_8_4.z adc8b_0.side_cap8b_0.in_l_sw[5] sg13cmos5l_Corner_1.vss sg13cmos5l_Corner_1.vss sg13_lv_nmos ad=95f pd=0.88u as=95f ps=0.88u w=0.5u l=0.13u
M3842 a_90970_98834# adc8b_0.sar12b_0.sg13cmos5l_dfrbp_1_6.RESET_B sg13cmos5l_Corner_1.vss sg13cmos5l_Corner_1.vss sg13_lv_nmos ad=37.8f pd=0.6u as=79.8f ps=0.8u w=0.42u l=0.13u
M3843 adc8b_0.sar12b_0.sg13cmos5l_dfrbp_1_12.Q_N a_88823_95421# vdd vdd sg13_lv_pmos ad=0.4312p pd=3.01u as=0.2639p ps=1.81u w=1.12u l=0.13u
M3844 a_84396_94311# a_84108_94616# a_84334_94311# sg13cmos5l_Corner_1.vss sg13_lv_nmos ad=0.1428p pd=1.52u as=37.8f ps=0.6u w=0.42u l=0.13u
M3845 sg13cmos5l_Corner_1.vss adc8b_0.sar12b_0.sg13cmos5l_inv_1_3.A adc8b_0.sar12b_0.sg13cmos5l_buf_1_7.A sg13cmos5l_Corner_1.vss sg13_lv_nmos ad=0.2516p pd=2.16u as=0.2516p ps=2.16u w=0.74u l=0.13u
M3846 sg13cmos5l_Corner_1.vss adc8b_0.sar12b_0.nl_sw[6] adc8b_0.side_cap8b_1.buf_4_3.z sg13cmos5l_Corner_1.vss sg13_lv_nmos ad=95f pd=0.88u as=95f ps=0.88u w=0.5u l=0.13u
M3847 vdd sg13cmos5l_IOPadVdd$1_0.sg13cmos5l_Clamp_N43N43D4R$1_0.gate sg13cmos5l_Corner_1.vss sg13cmos5l_Corner_1.vss sg13_hv_nmos ad=2.596p pd=5.58u as=1.408p ps=5.04u w=4.4u l=0.6u
M3848 a_95745_97637# a_94803_97444# a_95543_97399# vdd sg13_lv_pmos ad=93.45f pd=0.865u as=0.2048p ps=1.63u w=0.42u l=0.13u
M3849 adc8b_0.side_cap8b_1.buf_16_3.z adc8b_0.sar12b_0.nh_sw[1] vddr vddr sg13_lv_pmos ad=0.19p pd=1.38u as=0.19p ps=1.38u w=1u l=0.13u
M3850 a_99548_99596# a_99135_99954# a_99480_99596# vdd sg13_lv_pmos ad=0.191p pd=1.44u as=0.105p ps=1.21u w=1u l=0.13u
M3851 a_96351_96930# adc8b_0.sar12b_0.sg13cmos5l_dfrbp_1_23.CLK sg13cmos5l_Corner_1.vss sg13cmos5l_Corner_1.vss sg13_lv_nmos ad=0.2516p pd=2.16u as=0.15055p ps=1.17u w=0.74u l=0.13u
M3852 sg13cmos5l_Corner_1.iovdd a_164624_118044# sg13cmos5l_IOPadAnalog_11.pad sg13cmos5l_Corner_1.iovdd sg13_hv_pmos ad=2.1312p pd=7.3u as=3.9294p ps=7.84u w=6.66u l=0.6u
M3853 sg13cmos5l_Corner_1.vss adc8b_0.side_cap8b_0.in_l_sw[2] adc8b_0.side_cap8b_0.buf_16_1.z sg13cmos5l_Corner_1.vss sg13_lv_nmos ad=95f pd=0.88u as=95f ps=0.88u w=0.5u l=0.13u
M3854 a_94257_100737# a_93900_100664# vdd vdd sg13_lv_pmos ad=63f pd=0.72u as=0.1563p ps=1.22u w=0.42u l=0.13u
M3855 a_87854_95810# a_88659_95932# a_88114_96033# vdd sg13_lv_pmos ad=0.1428p pd=1.52u as=79.8f ps=0.8u w=0.42u l=0.13u
M3856 a_94840_95302# adc8b_0.sar12b_0.sg13cmos5l_dfrbp_1_0.RESET_B vdd vdd sg13_lv_pmos ad=79.8f pd=0.8u as=1.38655p ps=8.8u w=0.42u l=0.13u
M3857 adc8b_0.sar12b_0.sg13cmos5l_buf_1_4.X a_98320_92824# vdd vdd sg13_lv_pmos ad=0.42p pd=2.99u as=0.2114p ps=1.54u w=1.12u l=0.13u
M3858 vdd sg13cmos5l_IOPadVdd$1_0.sg13cmos5l_Clamp_N43N43D4R$1_0.gate sg13cmos5l_Corner_1.vss sg13cmos5l_Corner_1.vss sg13_hv_nmos ad=2.596p pd=5.58u as=1.408p ps=5.04u w=4.4u l=0.6u
M3859 vdd a_85809_93905# a_85742_93548# vdd sg13_lv_pmos ad=0.2387p pd=1.84u as=0.1008p ps=0.9u w=0.42u l=0.13u
M3860 sg13cmos5l_Corner_1.vss adc8b_0.sar12b_0.sg13cmos5l_dfrbp_1_6.RESET_B a_90844_96960# sg13cmos5l_Corner_1.vss sg13_lv_nmos ad=0.1406p pd=1.12u as=77.7f ps=0.95u w=0.74u l=0.13u
M3861 sg13cmos5l_Corner_1.vss adc8b_0.sar12b_0.nh_sw[2] adc8b_0.side_cap8b_1.buf_16_0.z sg13cmos5l_Corner_1.vss sg13_lv_nmos ad=95f pd=0.88u as=95f ps=0.88u w=0.5u l=0.13u
M3862 adc8b_0.side_cap8b_0.in_h_sw[3] a_87184_100384# sg13cmos5l_Corner_1.vss sg13cmos5l_Corner_1.vss sg13_lv_nmos ad=0.2886p pd=2.26u as=0.14875p ps=1.16u w=0.74u l=0.13u
M3863 a_82418_95060# adc8b_0.sar12b_0.sg13cmos5l_nor2_1_2.A vdd vdd sg13_lv_pmos ad=0.1176p pd=1.33u as=0.4032p ps=2.96u w=1.12u l=0.13u
M3864 vdd a_85844_98784# a_85444_99124# vdd sg13_lv_pmos ad=0.2387p pd=1.84u as=0.2128p ps=1.5u w=1.12u l=0.13u
M3865 sg13cmos5l_Corner_1.vss a_86420_97286# adc8b_0.sar12b_0.sg13cmos5l_inv_1_19.A sg13cmos5l_Corner_1.vss sg13_lv_nmos ad=0.14875p pd=1.16u as=0.2886p ps=2.26u w=0.74u l=0.13u
M3866 adc8b_0.sar12b_0.sg13cmos5l_buf_1_26.A adc8b_0.sar12b_0.sg13cmos5l_buf_1_45.X vdd vdd sg13_lv_pmos ad=0.3808p pd=2.92u as=0.3808p ps=2.92u w=1.12u l=0.13u
M3867 adc8b_0.side_cap8b_1.buf_32_1.z adc8b_0.sar12b_0.nh_sw[0] vddr vddr sg13_lv_pmos ad=0.19p pd=1.38u as=0.19p ps=1.38u w=1u l=0.13u
M3868 a_84980_92750# adc8b_0.sar12b_0.sg13cmos5l_buf_1_41.A sg13cmos5l_Corner_1.vss sg13cmos5l_Corner_1.vss sg13_lv_nmos ad=0.187p pd=1.78u as=0.14875p ps=1.16u w=0.55u l=0.13u
M3869 adc8b_0.sar12b_0.nh_sw[3] a_87472_92824# vdd vdd sg13_lv_pmos ad=0.42p pd=2.99u as=0.2114p ps=1.54u w=1.12u l=0.13u
M3870 a_89292_99152# a_89266_99057# vdd vdd sg13_lv_pmos ad=0.34p pd=2.68u as=0.36237p ps=2.605u w=1u l=0.13u
M3871 vdd a_93335_98911# a_93592_99054# vdd sg13_lv_pmos ad=0.2639p pd=1.81u as=79.8f ps=0.8u w=0.42u l=0.13u
M3872 vddr adc8b_0.sar12b_0.nh_sw[0] adc8b_0.side_cap8b_1.buf_32_1.z vddr sg13_lv_pmos ad=0.19p pd=1.38u as=0.19p ps=1.38u w=1u l=0.13u
M3873 sg13cmos5l_Corner_1.vss adc8b_0.sar12b_0.nl_sw[4] adc8b_0.side_cap8b_1.buf_8_0.z sg13cmos5l_Corner_1.vss sg13_lv_nmos ad=95f pd=0.88u as=95f ps=0.88u w=0.5u l=0.13u
M3874 sg13cmos5l_IOPadVdd$1_0.sg13cmos5l_Clamp_N43N43D4R$1_0.gate sg13cmos5l_IOPadVdd$1_0.sg13cmos5l_RCClampInverter$1_0.in vdd vdd sg13_hv_pmos ad=1.33p pd=7.38u as=1.33p ps=7.38u w=7u l=0.5u
M3875 sg13cmos5l_Corner_1.vss adc8b_0.sar12b_0.sg13cmos5l_dfrbp_1_8.RESET_B a_96204_100034# sg13cmos5l_Corner_1.vss sg13_lv_nmos ad=0.1626p pd=1.415u as=60.89999f ps=0.71u w=0.42u l=0.13u
M3876 a_97870_95823# adc8b_0.sar12b_0.sg13cmos5l_dfrbp_1_8.RESET_B sg13cmos5l_Corner_1.vss sg13cmos5l_Corner_1.vss sg13_lv_nmos ad=37.8f pd=0.6u as=0.1701p ps=1.65u w=0.42u l=0.13u
M3877 frame a_134044_30676# sg13cmos5l_Corner_1.vss sg13cmos5l_Corner_1.vss sg13_hv_nmos ad=2.596p pd=5.58u as=2.068p ps=9.74u w=4.4u l=0.6u
M3878 sg13cmos5l_Corner_1.vss adc8b_0.side_cap8b_0.in_h_sw[0] adc8b_0.side_cap8b_0.buf_32_1.z sg13cmos5l_Corner_1.vss sg13_lv_nmos ad=95f pd=0.88u as=95f ps=0.88u w=0.5u l=0.13u
M3879 sg13cmos5l_Corner_1.vss a_99639_178370# sg13cmos5l_IOPadAnalog_15.pad sg13cmos5l_Corner_1.vss sg13_hv_nmos ad=1.408p pd=5.04u as=2.596p ps=5.58u w=4.4u l=0.6u
M3880 sg13cmos5l_Corner_1.vss adc8b_0.sar12b_0.sg13cmos5l_inv_1_1.A a_98032_100384# sg13cmos5l_Corner_1.vss sg13_lv_nmos ad=0.14875p pd=1.16u as=0.187p ps=1.78u w=0.55u l=0.13u
M3881 sg13cmos5l_Corner_1.vss adc8b_0.sar12b_0.sg13cmos5l_dlhr_1_9.D a_92355_95852# sg13cmos5l_Corner_1.vss sg13_lv_nmos ad=0.14505p pd=1.15u as=0.187p ps=1.78u w=0.55u l=0.13u
M3882 adc8b_0.side_cap8b_1.buf_16_3.z adc8b_0.sar12b_0.nh_sw[1] sg13cmos5l_Corner_1.vss sg13cmos5l_Corner_1.vss sg13_lv_nmos ad=0.17p pd=1.68u as=95f ps=0.88u w=0.5u l=0.13u
M3883 vddr adc8b_0.sar12b_0.nl_sw[1] adc8b_0.side_cap8b_1.buf_16_2.z vddr sg13_lv_pmos ad=0.19p pd=1.38u as=0.19p ps=1.38u w=1u l=0.13u
X3884 sg13cmos5l_Corner_1.vss a_33862_86222# dantenna l=27.78u w=1.26u
M3885 adc8b_0.side_cap8b_0.buf_32_1.z adc8b_0.side_cap8b_0.in_h_sw[0] sg13cmos5l_Corner_1.vss sg13cmos5l_Corner_1.vss sg13_lv_nmos ad=95f pd=0.88u as=95f ps=0.88u w=0.5u l=0.13u
M3886 a_92840_96507# adc8b_0.sar12b_0.sg13cmos5l_nor2_1_0.A a_93138_96920# sg13cmos5l_Corner_1.vss sg13_lv_nmos ad=0.2176p pd=1.96u as=0.1216p ps=1.02u w=0.64u l=0.13u
M3887 a_84396_94311# a_84627_94420# a_84082_94521# sg13cmos5l_Corner_1.vss sg13_lv_nmos ad=0.2373p pd=1.97u as=79.8f ps=0.8u w=0.42u l=0.13u
M3888 vdd cks adc8b_0.sar12b_0.sg13cmos5l_dfrbp_1_6.RESET_B vdd sg13_lv_pmos ad=0.3808p pd=2.92u as=0.2184p ps=1.51u w=1.12u l=0.13u
M3889 sg13cmos5l_Corner_1.vss vdd sg13cmos5l_Corner_1.vss sg13cmos5l_Corner_1.vss sg13_lv_nmos ad=79.8f pd=0.8u as=0 ps=0 w=0.42u l=1u
M3890 adc8b_0.side_cap8b_0.buf_32_1.z adc8b_0.side_cap8b_0.in_h_sw[0] vddr vddr sg13_lv_pmos ad=0.19p pd=1.38u as=0.19p ps=1.38u w=1u l=0.13u
M3891 sg13cmos5l_Corner_1.vss a_88173_99607# a_88275_99607# sg13cmos5l_Corner_1.vss sg13_lv_nmos ad=2.92392p pd=18.89u as=0.2516p ps=2.16u w=0.74u l=0.13u
M3892 adc8b_0.sar12b_0.sg13cmos5l_nor2_1_0.A a_95324_93548# vdd vdd sg13_lv_pmos ad=0.3808p pd=2.92u as=0.2128p ps=1.5u w=1.12u l=0.13u
M3893 sg13cmos5l_Corner_1.iovdd a_134044_42476# frame sg13cmos5l_Corner_1.iovdd sg13_hv_pmos ad=2.1312p pd=7.3u as=3.9294p ps=7.84u w=6.66u l=0.6u
M3894 adc8b_0.sar12b_0.sg13cmos5l_buf_1_78.X a_87952_100384# sg13cmos5l_Corner_1.vss sg13cmos5l_Corner_1.vss sg13_lv_nmos ad=0.2886p pd=2.26u as=0.14875p ps=1.16u w=0.74u l=0.13u
M3895 sg13cmos5l_Corner_1.vss a_83735_96933# a_84572_96572# sg13cmos5l_Corner_1.vss sg13_lv_nmos ad=0.1406p pd=1.12u as=0.2516p ps=2.16u w=0.74u l=0.13u
M3896 adc8b_0.sar12b_0.sg13cmos5l_dfrbp_1_20.Q_N a_90551_98911# vdd vdd sg13_lv_pmos ad=0.4312p pd=3.01u as=0.2639p ps=1.81u w=1.12u l=0.13u
M3897 vdd a_94317_100325# a_94419_100468# vdd sg13_lv_pmos ad=4.11675p pd=27.17u as=0.3864p ps=2.93u w=1.12u l=0.13u
M3898 sg13cmos5l_IOPadAnalog_1.pad a_164624_70044# sg13cmos5l_Corner_1.iovdd sg13cmos5l_Corner_1.iovdd sg13_hv_pmos ad=3.9294p pd=7.84u as=2.1312p ps=7.3u w=6.66u l=0.6u
M3899 adc8b_0.side_cap8b_0.buf_8_4.z adc8b_0.side_cap8b_0.in_l_sw[5] vddr vddr sg13_lv_pmos ad=0.19p pd=1.38u as=0.19p ps=1.38u w=1u l=0.13u
M3900 a_70946_99114# vdd a_70852_97472# sg13cmos5l_Corner_1.vss sg13_lv_nmos ad=0.57p pd=3.38u as=1.02p ps=6.68u w=3u l=0.13u
M3901 vip a_30676_102044# sg13cmos5l_Corner_1.vss sg13cmos5l_Corner_1.vss sg13_hv_nmos ad=2.596p pd=5.58u as=1.408p ps=5.04u w=4.4u l=0.6u
X3902 sg13cmos5l_IOPadAnalog_1.pad sg13cmos5l_Corner_1.iovdd dpantenna l=27.78u w=1.26u
M3903 a_86428_98472# a_86012_98084# a_86193_98441# sg13cmos5l_Corner_1.vss sg13_lv_nmos ad=77.7f pd=0.95u as=0.2516p ps=2.16u w=0.74u l=0.13u
M3904 vdd a_88727_97399# a_88984_97542# vdd sg13_lv_pmos ad=0.2639p pd=1.81u as=79.8f ps=0.8u w=0.42u l=0.13u
M3905 data[2] a_102044_42476# sg13cmos5l_Corner_1.iovdd sg13cmos5l_Corner_1.iovdd sg13_hv_pmos ad=3.9294p pd=7.84u as=2.1312p ps=7.3u w=6.66u l=0.6u
M3906 vdd adc8b_0.sar12b_0.sg13cmos5l_dfrbp_1_0.RESET_B a_99154_93009# vdd sg13_lv_pmos ad=0.1563p pd=1.22u as=0.147p ps=1.54u w=0.42u l=0.13u
M3907 vdd a_94583_92863# a_95420_93084# vdd sg13_lv_pmos ad=0.2128p pd=1.5u as=0.3864p ps=2.93u w=1.12u l=0.13u
M3908 sg13cmos5l_Corner_1.vss adc8b_0.sar12b_0.sg13cmos5l_buf_1_30.A a_90448_92824# sg13cmos5l_Corner_1.vss sg13_lv_nmos ad=0.14875p pd=1.16u as=0.187p ps=1.78u w=0.55u l=0.13u
M3909 sg13cmos5l_Corner_1.vss a_94487_93909# a_95324_93548# sg13cmos5l_Corner_1.vss sg13_lv_nmos ad=0.1406p pd=1.12u as=0.2516p ps=2.16u w=0.74u l=0.13u
M3910 adc8b_0.side_cap8b_0.buf_32_0.z adc8b_0.side_cap8b_0.in_l_sw[0] vddr vddr sg13_lv_pmos ad=0.34p pd=2.68u as=0.19p ps=1.38u w=1u l=0.13u
M3911 a_82764_96997# a_82995_96583# a_82450_96540# sg13cmos5l_Corner_1.vss sg13_lv_nmos ad=0.2373p pd=1.97u as=79.8f ps=0.8u w=0.42u l=0.13u
M3912 data[1] a_86044_42476# sg13cmos5l_Corner_1.iovdd sg13cmos5l_Corner_1.iovdd sg13_hv_pmos ad=3.9294p pd=7.84u as=2.1312p ps=7.3u w=6.66u l=0.6u
M3913 a_86327_98790# adc8b_0.sar12b_0.sg13cmos5l_dlhr_1_9.D vdd vdd sg13_lv_pmos ad=0.2856p pd=2.36u as=1.15047p ps=7.175u w=0.84u l=0.13u
M3914 adc8b_0.sar12b_0.sg13cmos5l_dfrbp_1_16.Q_N a_83735_98445# sg13cmos5l_Corner_1.vss sg13cmos5l_Corner_1.vss sg13_lv_nmos ad=0.2849p pd=2.25u as=0.2516p ps=2.16u w=0.74u l=0.13u
M3915 a_74586_95659# adc8b_0.diff_bsw_0.vcp a_76796_95659# sg13cmos5l_Corner_1.vss sg13_lv_nmos ad=0.95p pd=5.38u as=1.7p ps=10.68u w=5u l=0.13u
M3916 adc8b_0.sar12b_0.sg13cmos5l_buf_8_0.X a_100995_95814# sg13cmos5l_Corner_1.vss sg13cmos5l_Corner_1.vss sg13_lv_nmos ad=0.1406p pd=1.12u as=0.1406p ps=1.12u w=0.74u l=0.13u
X3917 sg13cmos5l_Corner_1.iovdd a_42476_118044# sg13cmos5l_Corner_1.iovdd rppd l=12.9u w=0.5u
M3918 sg13cmos5l_Corner_1.vss adc8b_0.sar12b_0.sg13cmos5l_dfrbp_1_6.RESET_B a_89500_94284# sg13cmos5l_Corner_1.vss sg13_lv_nmos ad=0.1406p pd=1.12u as=77.7f ps=0.95u w=0.74u l=0.13u
M3919 vdd a_96813_99607# a_96915_99607# vdd sg13_lv_pmos ad=1.15047p pd=7.175u as=0.3864p ps=2.93u w=1.12u l=0.13u
M3920 adc8b_0.sar12b_0.sg13cmos5l_dfrbp_1_12.Q_N a_88823_95421# sg13cmos5l_Corner_1.vss sg13cmos5l_Corner_1.vss sg13_lv_nmos ad=0.2849p pd=2.25u as=0.2516p ps=2.16u w=0.74u l=0.13u
M3921 frame a_134044_42476# sg13cmos5l_Corner_1.iovdd sg13cmos5l_Corner_1.iovdd sg13_hv_pmos ad=3.9294p pd=7.84u as=2.1312p ps=7.3u w=6.66u l=0.6u
M3922 a_83614_99010# a_83716_99124# vdd vdd sg13_lv_pmos ad=0.2856p pd=2.36u as=0.1974p ps=1.5u w=0.84u l=0.13u
M3923 a_93140_94262# adc8b_0.sar12b_0.sg13cmos5l_buf_1_9.A vdd vdd sg13_lv_pmos ad=0.2856p pd=2.36u as=0.2114p ps=1.54u w=0.84u l=0.13u
M3924 sg13cmos5l_Corner_1.vss adc8b_0.sar12b_0.nh_sw[9] adc8b_0.side_cap8b_1.buf_2_3.z sg13cmos5l_Corner_1.vss sg13_lv_nmos ad=95f pd=0.88u as=0.17p ps=1.68u w=0.5u l=0.13u
M3925 data[0] a_70044_30676# sg13cmos5l_Corner_1.vss sg13cmos5l_Corner_1.vss sg13_hv_nmos ad=2.596p pd=5.58u as=2.068p ps=9.74u w=4.4u l=0.6u
M3926 a_89390_93224# a_88994_92796# a_89276_93108# vdd sg13_lv_pmos ad=0.1008p pd=0.9u as=0.191p ps=1.44u w=0.42u l=0.13u
M3927 a_87192_94620# a_86641_94352# vdd vdd sg13_lv_pmos ad=0.105p pd=1.21u as=1.43437p ps=9.105u w=1u l=0.13u
M3928 sg13cmos5l_Corner_1.vss a_178296_70044# sg13cmos5l_IOPadAnalog_1.pad sg13cmos5l_Corner_1.vss sg13_hv_nmos ad=1.408p pd=5.04u as=2.596p ps=5.58u w=4.4u l=0.6u
M3929 sg13cmos5l_Corner_1.vss adc8b_0.sar12b_0.nl_sw[2] adc8b_0.side_cap8b_1.buf_16_1.z sg13cmos5l_Corner_1.vss sg13_lv_nmos ad=95f pd=0.88u as=95f ps=0.88u w=0.5u l=0.13u
M3930 adc8b_0.side_cap8b_0.in_h_sw[1] a_83632_100384# sg13cmos5l_Corner_1.vss sg13cmos5l_Corner_1.vss sg13_lv_nmos ad=0.2886p pd=2.26u as=0.14875p ps=1.16u w=0.74u l=0.13u
M3931 a_72090_94286# vdd a_71988_94286# sg13cmos5l_Corner_1.vss sg13_lv_nmos ad=0.17p pd=1.68u as=95f ps=0.88u w=0.5u l=0.13u
M3932 a_90254_100034# a_91059_99607# a_90514_99564# vdd sg13_lv_pmos ad=0.1428p pd=1.52u as=79.8f ps=0.8u w=0.42u l=0.13u
M3933 a_94681_98486# a_94129_98442# sg13cmos5l_Corner_1.vss sg13cmos5l_Corner_1.vss sg13_lv_nmos ad=71.99999f pd=0.865u as=1.49685p ps=9.6u w=0.64u l=0.13u
M3934 a_97589_95024# a_98319_95147# a_98230_95183# vdd sg13_lv_pmos ad=0.2048p pd=1.63u as=93.45f ps=0.865u w=0.42u l=0.13u
M3935 vddr adc8b_0.sar12b_0.nl_sw[5] adc8b_0.side_cap8b_1.buf_8_4.z vddr sg13_lv_pmos ad=0.19p pd=1.38u as=0.34p ps=2.68u w=1u l=0.13u
M3936 sg13cmos5l_Corner_1.vss a_67639_178370# sg13cmos5l_IOPadAnalog_10.pad sg13cmos5l_Corner_1.vss sg13_hv_nmos ad=1.408p pd=5.04u as=2.596p ps=5.58u w=4.4u l=0.6u
M3937 cks a_42476_118044# sg13cmos5l_Corner_1.iovdd sg13cmos5l_Corner_1.iovdd sg13_hv_pmos ad=3.9294p pd=7.84u as=2.1312p ps=7.3u w=6.66u l=0.6u
M3938 sg13cmos5l_Corner_1.iovdd a_42476_102044# vip sg13cmos5l_Corner_1.iovdd sg13_hv_pmos ad=2.1312p pd=7.3u as=3.9294p ps=7.84u w=6.66u l=0.6u
M3939 vdd a_85940_92750# adc8b_0.sar12b_0.sg13cmos5l_buf_1_33.A vdd sg13_lv_pmos ad=0.2114p pd=1.54u as=0.42p ps=2.99u w=1.12u l=0.13u
M3940 vdd a_82964_99560# adc8b_0.sar12b_0.sg13cmos5l_buf_1_63.X vdd sg13_lv_pmos ad=0.2114p pd=1.54u as=0.42p ps=2.99u w=1.12u l=0.13u
M3941 sg13cmos5l_Corner_1.vss a_83646_97497# adc8b_0.sar12b_0.sg13cmos5l_dlhr_1_1.GATE sg13cmos5l_Corner_1.vss sg13_lv_nmos ad=0.1406p pd=1.12u as=0.2516p ps=2.16u w=0.74u l=0.13u
M3942 sg13cmos5l_Corner_1.vss adc8b_0.sar12b_0.nl_sw[3] adc8b_0.side_cap8b_1.buf_8_1.z sg13cmos5l_Corner_1.vss sg13_lv_nmos ad=95f pd=0.88u as=95f ps=0.88u w=0.5u l=0.13u
M3943 vddr adc8b_0.sar12b_0.nh_sw[1] adc8b_0.side_cap8b_1.buf_16_3.z vddr sg13_lv_pmos ad=0.19p pd=1.38u as=0.19p ps=1.38u w=1u l=0.13u
M3944 sg13cmos5l_Corner_1.iovdd a_70044_42476# data[0] sg13cmos5l_Corner_1.iovdd sg13_hv_pmos ad=2.1312p pd=7.3u as=3.9294p ps=7.84u w=6.66u l=0.6u
M3945 adc8b_0.sar12b_0.sg13cmos5l_dfrbp_1_8.D a_99932_98084# vdd vdd sg13_lv_pmos ad=0.3808p pd=2.92u as=0.2128p ps=1.5u w=1.12u l=0.13u
M3946 vddr adc8b_0.sar12b_0.nl_sw[2] adc8b_0.side_cap8b_1.buf_16_1.z vddr sg13_lv_pmos ad=0.19p pd=1.38u as=0.19p ps=1.38u w=1u l=0.13u
M3947 vdd sg13cmos5l_IOPadVdd$1_0.sg13cmos5l_Clamp_N43N43D4R$1_0.gate sg13cmos5l_Corner_1.vss sg13cmos5l_Corner_1.vss sg13_hv_nmos ad=2.596p pd=5.58u as=1.408p ps=5.04u w=4.4u l=0.6u
M3948 adc8b_0.side_cap8b_0.buf_16_2.z adc8b_0.side_cap8b_0.in_l_sw[1] vddr vddr sg13_lv_pmos ad=0.19p pd=1.38u as=0.19p ps=1.38u w=1u l=0.13u
M3949 vin a_30676_86044# sg13cmos5l_Corner_1.vss sg13cmos5l_Corner_1.vss sg13_hv_nmos ad=2.596p pd=5.58u as=2.068p ps=9.74u w=4.4u l=0.6u
M3950 adc8b_0.side_cap8b_1.buf_16_0.z adc8b_0.sar12b_0.nh_sw[2] sg13cmos5l_Corner_1.vss sg13cmos5l_Corner_1.vss sg13_lv_nmos ad=95f pd=0.88u as=95f ps=0.88u w=0.5u l=0.13u
M3951 vdd sg13cmos5l_Corner_1.vss vdd vdd sg13_lv_pmos ad=0.34p pd=2.68u as=0 ps=0 w=1u l=1u
M3952 a_90361_96974# a_89809_96930# sg13cmos5l_Corner_1.vss sg13cmos5l_Corner_1.vss sg13_lv_nmos ad=71.99999f pd=0.865u as=1.97045p ps=12.335u w=0.64u l=0.13u
X3953 sg13cmos5l_Corner_1.vss a_175886_70222# dantenna l=27.78u w=1.26u
M3954 adc8b_0.side_cap8b_1.buf_8_1.z adc8b_0.sar12b_0.nl_sw[3] vddr vddr sg13_lv_pmos ad=0.19p pd=1.38u as=0.19p ps=1.38u w=1u l=0.13u
M3955 sg13cmos5l_Corner_1.vss adc8b_0.sar12b_0.nl_sw[1] adc8b_0.side_cap8b_1.buf_16_2.z sg13cmos5l_Corner_1.vss sg13_lv_nmos ad=95f pd=0.88u as=95f ps=0.88u w=0.5u l=0.13u
M3956 vdd a_85076_100310# adc8b_0.sar12b_0.sg13cmos5l_inv_1_8.A vdd sg13_lv_pmos ad=0.2114p pd=1.54u as=0.42p ps=2.99u w=1.12u l=0.13u
M3957 a_90460_98472# a_90044_98084# a_90225_98441# sg13cmos5l_Corner_1.vss sg13_lv_nmos ad=77.7f pd=0.95u as=0.2516p ps=2.16u w=0.74u l=0.13u
M3958 sg13cmos5l_Corner_1.vss adc8b_0.sar12b_0.sg13cmos5l_nand2_1_2.B a_82978_95814# sg13cmos5l_Corner_1.vss sg13_lv_nmos ad=0.2516p pd=2.16u as=0.1406p ps=1.12u w=0.74u l=0.13u
M3959 adc8b_0.side_cap8b_1.buf_8_5.z adc8b_0.sar12b_0.nh_sw[5] vddr vddr sg13_lv_pmos ad=0.34p pd=2.68u as=0.19p ps=1.38u w=1u l=0.13u
M3960 adc8b_0.side_cap8b_0.buf_16_3.z adc8b_0.side_cap8b_0.in_h_sw[1] sg13cmos5l_Corner_1.vss sg13cmos5l_Corner_1.vss sg13_lv_nmos ad=95f pd=0.88u as=95f ps=0.88u w=0.5u l=0.13u
M3961 adc8b_0.diff_bsw_0.single_bsw_1.sg13cmos5l_inv_1$1_0.A cks vdd vdd sg13_lv_pmos ad=0.3808p pd=2.92u as=0.3808p ps=2.92u w=1.12u l=0.13u
M3962 vdd adc8b_0.sar12b_0.sg13cmos5l_inv_1_3.A adc8b_0.sar12b_0.sg13cmos5l_buf_1_7.A vdd sg13_lv_pmos ad=0.3808p pd=2.92u as=0.3808p ps=2.92u w=1.12u l=0.13u
M3963 sg13cmos5l_Corner_1.vss a_88340_92750# adc8b_0.sar12b_0.sg13cmos5l_buf_1_24.X sg13cmos5l_Corner_1.vss sg13_lv_nmos ad=0.14875p pd=1.16u as=0.2886p ps=2.26u w=0.74u l=0.13u
M3964 sg13cmos5l_Corner_1.iovdd a_42476_118044# cks sg13cmos5l_Corner_1.iovdd sg13_hv_pmos ad=3.1302p pd=14.26u as=3.9294p ps=7.84u w=6.66u l=0.6u
M3965 sg13cmos5l_Corner_1.iovdd a_42476_70044# vddr sg13cmos5l_Corner_1.iovdd sg13_hv_pmos ad=2.1312p pd=7.3u as=3.9294p ps=7.84u w=6.66u l=0.6u
M3966 vdd a_101972_96536# adc8b_0.sar12b_0.sg13cmos5l_inv_1_6.A vdd sg13_lv_pmos ad=0.2114p pd=1.54u as=0.42p ps=2.99u w=1.12u l=0.13u
M3967 vin a_42476_86044# sg13cmos5l_Corner_1.iovdd sg13cmos5l_Corner_1.iovdd sg13_hv_pmos ad=3.9294p pd=7.84u as=2.1312p ps=7.3u w=6.66u l=0.6u
M3968 data[0] a_70044_42476# sg13cmos5l_Corner_1.iovdd sg13cmos5l_Corner_1.iovdd sg13_hv_pmos ad=3.9294p pd=7.84u as=2.1312p ps=7.3u w=6.66u l=0.6u
M3969 frame a_134044_42476# sg13cmos5l_Corner_1.iovdd sg13cmos5l_Corner_1.iovdd sg13_hv_pmos ad=3.9294p pd=7.84u as=2.1312p ps=7.3u w=6.66u l=0.6u
M3970 sg13cmos5l_Corner_1.iovdd a_164624_102044# sg13cmos5l_IOPadAnalog_16.pad sg13cmos5l_Corner_1.iovdd sg13_hv_pmos ad=2.1312p pd=7.3u as=3.9294p ps=7.84u w=6.66u l=0.6u
M3971 sg13cmos5l_Corner_1.iovdd a_42476_86044# vin sg13cmos5l_Corner_1.iovdd sg13_hv_pmos ad=2.1312p pd=7.3u as=3.9294p ps=7.84u w=6.66u l=0.6u
M3972 vddr adc8b_0.side_cap8b_0.in_l_sw[2] adc8b_0.side_cap8b_0.buf_16_1.z vddr sg13_lv_pmos ad=0.19p pd=1.38u as=0.34p ps=2.68u w=1u l=0.13u
M3973 vdd a_100995_100350# adc8b_0.sar12b_0.sg13cmos5l_buf_8_2.X vdd sg13_lv_pmos ad=0.2128p pd=1.5u as=0.2128p ps=1.5u w=1.12u l=0.13u
M3974 adc8b_0.side_cap8b_1.buf_16_2.z adc8b_0.sar12b_0.nl_sw[1] vddr vddr sg13_lv_pmos ad=0.19p pd=1.38u as=0.19p ps=1.38u w=1u l=0.13u
M3975 vddr adc8b_0.sar12b_0.nl_sw[0] adc8b_0.side_cap8b_1.buf_32_0.z vddr sg13_lv_pmos ad=0.19p pd=1.38u as=0.19p ps=1.38u w=1u l=0.13u
M3976 a_83890_95028# a_84333_95071# a_84273_95107# vdd sg13_lv_pmos ad=79.8f pd=0.8u as=63f ps=0.72u w=0.42u l=0.13u
M3977 vdd a_90356_95024# adc8b_0.sar12b_0.sg13cmos5l_buf_1_30.A vdd sg13_lv_pmos ad=0.2114p pd=1.54u as=0.42p ps=2.99u w=1.12u l=0.13u
M3978 sg13cmos5l_Corner_1.vss a_85624_94518# a_85273_94375# sg13cmos5l_Corner_1.vss sg13_lv_nmos ad=79.8f pd=0.8u as=0.1428p ps=1.52u w=0.42u l=0.13u
M3979 a_96311_94375# a_95469_94277# a_96217_94375# sg13cmos5l_Corner_1.vss sg13_lv_nmos ad=0.12665p pd=1.145u as=0.1428p ps=1.52u w=0.42u l=0.13u
M3980 adc8b_0.side_cap8b_1.buf_16_0.z adc8b_0.sar12b_0.nh_sw[2] vddr vddr sg13_lv_pmos ad=0.19p pd=1.38u as=0.19p ps=1.38u w=1u l=0.13u
M3981 sg13cmos5l_Corner_1.vss adc8b_0.sar12b_0.nh_sw[1] adc8b_0.side_cap8b_1.buf_16_3.z sg13cmos5l_Corner_1.vss sg13_lv_nmos ad=95f pd=0.88u as=95f ps=0.88u w=0.5u l=0.13u
X3982 a_36456_137395# a_40542_137725# sg13cmos5l_Corner_1.vss rppd l=20u w=1u
M3983 adc8b_0.sar12b_0.sg13cmos5l_dlhr_1_15.Q a_100113_98834# vdd vdd sg13_lv_pmos ad=0.3808p pd=2.92u as=0.2128p ps=1.5u w=1.12u l=0.13u
M3984 sg13cmos5l_Corner_1.iovdd a_115639_164698# sg13cmos5l_IOPadAnalog_13.pad sg13cmos5l_Corner_1.iovdd sg13_hv_pmos ad=2.1312p pd=7.3u as=3.9294p ps=7.84u w=6.66u l=0.6u
M3985 sg13cmos5l_Corner_1.vss adc8b_0.side_cap8b_0.in_h_sw[2] adc8b_0.side_cap8b_0.buf_16_0.z sg13cmos5l_Corner_1.vss sg13_lv_nmos ad=95f pd=0.88u as=95f ps=0.88u w=0.5u l=0.13u
M3986 sg13cmos5l_Corner_1.vss sg13cmos5l_IOPadVdd$1_0.sg13cmos5l_Clamp_N43N43D4R$1_0.gate vdd sg13cmos5l_Corner_1.vss sg13_hv_nmos ad=1.408p pd=5.04u as=2.596p ps=5.58u w=4.4u l=0.6u
M3987 sg13cmos5l_Corner_1.vss a_30676_86044# vin sg13cmos5l_Corner_1.vss sg13_hv_nmos ad=1.408p pd=5.04u as=2.596p ps=5.58u w=4.4u l=0.6u
M3988 sg13cmos5l_Corner_1.vss a_95543_97399# a_96380_97620# sg13cmos5l_Corner_1.vss sg13_lv_nmos ad=0.1406p pd=1.12u as=0.2516p ps=2.16u w=0.74u l=0.13u
M3989 a_89434_100034# adc8b_0.sar12b_0.sg13cmos5l_dfrbp_1_8.RESET_B sg13cmos5l_Corner_1.vss sg13cmos5l_Corner_1.vss sg13_lv_nmos ad=37.8f pd=0.6u as=79.8f ps=0.8u w=0.42u l=0.13u
M3990 a_85599_98442# adc8b_0.sar12b_0.sg13cmos5l_dfrbp_1_15.D vdd vdd sg13_lv_pmos ad=0.3234p pd=2.45u as=1.04815p ps=6.595u w=0.84u l=0.13u
M3991 a_92433_98441# a_92252_98084# vdd vdd sg13_lv_pmos ad=0.2128p pd=1.5u as=0.2387p ps=1.84u w=1.12u l=0.13u
M3992 sg13cmos5l_Corner_1.vss a_178296_102044# sg13cmos5l_IOPadAnalog_16.pad sg13cmos5l_Corner_1.vss sg13_hv_nmos ad=1.408p pd=5.04u as=2.596p ps=5.58u w=4.4u l=0.6u
M3993 adc8b_0.side_cap8b_1.buf_8_0.z adc8b_0.sar12b_0.nl_sw[4] vddr vddr sg13_lv_pmos ad=0.19p pd=1.38u as=0.19p ps=1.38u w=1u l=0.13u
M3994 sg13cmos5l_IOPadAnalog_11.pad a_178296_118044# sg13cmos5l_Corner_1.vss sg13cmos5l_Corner_1.vss sg13_hv_nmos ad=2.596p pd=5.58u as=1.408p ps=5.04u w=4.4u l=0.6u
M3995 a_100641_93101# a_99699_92908# a_100439_92863# vdd sg13_lv_pmos ad=93.45f pd=0.865u as=0.2048p ps=1.63u w=0.42u l=0.13u
M3996 a_99885_94277# adc8b_0.sar12b_0.sg13cmos5l_dfrbp_1_0.CLK vdd vdd sg13_lv_pmos ad=0.4088p pd=2.97u as=1.38655p ps=8.8u w=1.12u l=0.13u
M3997 sg13cmos5l_IOPadAnalog_12.pad a_131639_164698# sg13cmos5l_Corner_1.iovdd sg13cmos5l_Corner_1.iovdd sg13_hv_pmos ad=3.9294p pd=7.84u as=2.1312p ps=7.3u w=6.66u l=0.6u
M3998 sg13cmos5l_Corner_1.iovdd a_42476_86044# vin sg13cmos5l_Corner_1.iovdd sg13_hv_pmos ad=2.1312p pd=7.3u as=3.9294p ps=7.84u w=6.66u l=0.6u
M3999 sg13cmos5l_Corner_1.vss adc8b_0.side_cap8b_0.in_l_sw[0] adc8b_0.side_cap8b_0.buf_32_0.z sg13cmos5l_Corner_1.vss sg13_lv_nmos ad=95f pd=0.88u as=95f ps=0.88u w=0.5u l=0.13u
M4000 sg13cmos5l_Corner_1.vss vdd sg13cmos5l_Corner_1.vss sg13cmos5l_Corner_1.vss sg13_lv_nmos ad=0.1428p pd=1.52u as=0 ps=0 w=0.42u l=1u
M4001 sg13cmos5l_Corner_1.vss adc8b_0.sar12b_0.sg13cmos5l_buf_1_64.A a_85744_100384# sg13cmos5l_Corner_1.vss sg13_lv_nmos ad=0.14875p pd=1.16u as=0.187p ps=1.78u w=0.55u l=0.13u
M4002 a_98900_100310# adc8b_0.sar12b_0.sg13cmos5l_buf_1_94.X vdd vdd sg13_lv_pmos ad=0.2856p pd=2.36u as=0.2114p ps=1.54u w=0.84u l=0.13u
M4003 a_101012_93512# adc8b_0.sar12b_0.sg13cmos5l_buf_1_18.X vdd vdd sg13_lv_pmos ad=0.2856p pd=2.36u as=0.2114p ps=1.54u w=0.84u l=0.13u
M4004 sg13cmos5l_Corner_1.vss sg13cmos5l_IOPadVdd$1_0.sg13cmos5l_Clamp_N43N43D4R$1_0.gate vdd sg13cmos5l_Corner_1.vss sg13_hv_nmos ad=1.408p pd=5.04u as=2.596p ps=5.58u w=4.4u l=0.6u
M4005 vddr adc8b_0.side_cap8b_0.in_h_sw[7] adc8b_0.side_cap8b_0.buf_4_2.z vddr sg13_lv_pmos ad=0.19p pd=1.38u as=0.34p ps=2.68u w=1u l=0.13u
M4006 cks a_42476_118044# sg13cmos5l_Corner_1.iovdd sg13cmos5l_Corner_1.iovdd sg13_hv_pmos ad=3.9294p pd=7.84u as=2.1312p ps=7.3u w=6.66u l=0.6u
M4007 vddr adc8b_0.side_cap8b_0.in_l_sw[0] adc8b_0.side_cap8b_0.buf_32_0.z vddr sg13_lv_pmos ad=0.19p pd=1.38u as=0.19p ps=1.38u w=1u l=0.13u
M4008 adc8b_0.side_cap8b_0.buf_16_0.z adc8b_0.side_cap8b_0.in_h_sw[2] vddr vddr sg13_lv_pmos ad=0.19p pd=1.38u as=0.19p ps=1.38u w=1u l=0.13u
M4009 adc8b_0.sar12b_0.sg13cmos5l_a221oi_1_0.B2 adc8b_0.sar12b_0.sg13cmos5l_nor2b_1_0.Y sg13cmos5l_Corner_1.vss sg13cmos5l_Corner_1.vss sg13_lv_nmos ad=0.1406p pd=1.12u as=0.2516p ps=2.16u w=0.74u l=0.13u
M4010 sg13cmos5l_Corner_1.vss adc8b_0.sar12b_0.sg13cmos5l_buf_8_0.X a_102160_98872# sg13cmos5l_Corner_1.vss sg13_lv_nmos ad=0.14875p pd=1.16u as=0.187p ps=1.78u w=0.55u l=0.13u
M4011 sg13cmos5l_Corner_1.vss a_86044_30676# data[1] sg13cmos5l_Corner_1.vss sg13_hv_nmos ad=1.408p pd=5.04u as=2.596p ps=5.58u w=4.4u l=0.6u
M4012 sg13cmos5l_Corner_1.vss sg13cmos5l_IOPadVdd$1_0.sg13cmos5l_Clamp_N43N43D4R$1_0.gate vdd sg13cmos5l_Corner_1.vss sg13_hv_nmos ad=1.408p pd=5.04u as=2.596p ps=5.58u w=4.4u l=0.6u
M4013 vdd a_85175_99957# a_85432_99838# vdd sg13_lv_pmos ad=0.2639p pd=1.81u as=79.8f ps=0.8u w=0.42u l=0.13u
M4014 sg13cmos5l_Corner_1.iovdd a_86044_42476# data[1] sg13cmos5l_Corner_1.iovdd sg13_hv_pmos ad=2.1312p pd=7.3u as=3.9294p ps=7.84u w=6.66u l=0.6u
M4015 sg13cmos5l_Corner_1.vss a_178296_118044# sg13cmos5l_IOPadAnalog_11.pad sg13cmos5l_Corner_1.vss sg13_hv_nmos ad=2.068p pd=9.74u as=2.596p ps=5.58u w=4.4u l=0.6u
X4016 sg13cmos5l_IOPadAnalog_5.padres sg13cmos5l_Corner_1.iovdd dpantenna l=4.98u w=0.64u
M4017 sg13cmos5l_Corner_1.vss a_30676_70044# vddr sg13cmos5l_Corner_1.vss sg13_hv_nmos ad=1.408p pd=5.04u as=2.596p ps=5.58u w=4.4u l=0.6u
M4018 data[0] a_70044_42476# sg13cmos5l_Corner_1.iovdd sg13cmos5l_Corner_1.iovdd sg13_hv_pmos ad=3.9294p pd=7.84u as=2.1312p ps=7.3u w=6.66u l=0.6u
M4019 a_96612_98486# a_96063_98442# a_96476_98084# sg13cmos5l_Corner_1.vss sg13_lv_nmos ad=47.25f pd=0.645u as=0.141p ps=1.17u w=0.42u l=0.13u
X4020 sg13cmos5l_Corner_1.vss a_118222_33862# dantenna l=1.26u w=27.78u
M4021 vdd a_88727_97399# a_89564_97620# vdd sg13_lv_pmos ad=0.2128p pd=1.5u as=0.3864p ps=2.93u w=1.12u l=0.13u
M4022 a_93741_92765# adc8b_0.sar12b_0.sg13cmos5l_dfrbp_1_0.CLK sg13cmos5l_Corner_1.vss sg13cmos5l_Corner_1.vss sg13_lv_nmos ad=0.2516p pd=2.16u as=5.84582p ps=38.34u w=0.74u l=0.13u
M4023 adc8b_0.sar12b_0.sg13cmos5l_inv_1_20.Y adc8b_0.sar12b_0.sg13cmos5l_buf_1_41.A sg13cmos5l_Corner_1.vss sg13cmos5l_Corner_1.vss sg13_lv_nmos ad=0.2516p pd=2.16u as=0.2516p ps=2.16u w=0.74u l=0.13u
M4024 sg13cmos5l_IOPadAnalog_15.pad a_99639_164698# sg13cmos5l_Corner_1.iovdd sg13cmos5l_Corner_1.iovdd sg13_hv_pmos ad=3.9294p pd=7.84u as=2.1312p ps=7.3u w=6.66u l=0.6u
M4025 vdd adc8b_0.sar12b_0.sg13cmos5l_buf_1_68.X a_82384_100384# vdd sg13_lv_pmos ad=0.2114p pd=1.54u as=0.2856p ps=2.36u w=0.84u l=0.13u
M4026 adc8b_0.sar12b_0.sg13cmos5l_dfrbp_1_8.D a_99932_98084# sg13cmos5l_Corner_1.vss sg13cmos5l_Corner_1.vss sg13_lv_nmos ad=0.2516p pd=2.16u as=0.1406p ps=1.12u w=0.74u l=0.13u
M4027 sg13cmos5l_Corner_1.vss a_118044_30676# cko sg13cmos5l_Corner_1.vss sg13_hv_nmos ad=1.408p pd=5.04u as=2.596p ps=5.58u w=4.4u l=0.6u
M4028 data[2] a_102044_30676# sg13cmos5l_Corner_1.vss sg13cmos5l_Corner_1.vss sg13_hv_nmos ad=2.596p pd=5.58u as=1.408p ps=5.04u w=4.4u l=0.6u
M4029 adc8b_0.sar12b_0.sg13cmos5l_dfrbp_1_6.RESET_B cks vdd vdd sg13_lv_pmos ad=0.2128p pd=1.5u as=0.2128p ps=1.5u w=1.12u l=0.13u
M4030 adc8b_0.sar12b_0.sg13cmos5l_dfrbp_1_27.Q_N a_91799_99957# sg13cmos5l_Corner_1.vss sg13cmos5l_Corner_1.vss sg13_lv_nmos ad=0.2849p pd=2.25u as=0.2516p ps=2.16u w=0.74u l=0.13u
M4031 sg13cmos5l_Corner_1.vss vdd sg13cmos5l_Corner_1.vss sg13cmos5l_Corner_1.vss sg13_lv_nmos ad=0.1428p pd=1.52u as=0 ps=0 w=0.42u l=1u
M4032 adc8b_0.side_cap8b_1.buf_16_3.z adc8b_0.sar12b_0.nh_sw[1] vddr vddr sg13_lv_pmos ad=0.19p pd=1.38u as=0.19p ps=1.38u w=1u l=0.13u
M4033 adc8b_0.side_cap8b_1.buf_32_0.z adc8b_0.sar12b_0.nl_sw[0] sg13cmos5l_Corner_1.vss sg13cmos5l_Corner_1.vss sg13_lv_nmos ad=95f pd=0.88u as=95f ps=0.88u w=0.5u l=0.13u
M4034 sg13cmos5l_Corner_1.iovdd a_83639_164698# sg13cmos5l_IOPadAnalog_9.pad sg13cmos5l_Corner_1.iovdd sg13_hv_pmos ad=2.1312p pd=7.3u as=3.9294p ps=7.84u w=6.66u l=0.6u
M4035 vdd adc8b_0.sar12b_0.sg13cmos5l_dlhr_1_1.GATE a_86117_98796# vdd sg13_lv_pmos ad=1.15047p pd=7.175u as=0.3234p ps=2.45u w=0.84u l=0.13u
M4036 adc8b_0.sar12b_0.sg13cmos5l_dfrbp_1_9.Q a_86012_95060# vdd vdd sg13_lv_pmos ad=0.3808p pd=2.92u as=0.2128p ps=1.5u w=1.12u l=0.13u
M4037 vdd sg13cmos5l_IOPadVdd$1_0.sg13cmos5l_Clamp_N43N43D4R$1_0.gate sg13cmos5l_Corner_1.vss sg13cmos5l_Corner_1.vss sg13_hv_nmos ad=2.596p pd=5.58u as=1.408p ps=5.04u w=4.4u l=0.6u
M4038 sg13cmos5l_IOPadVdd$1_0.sg13cmos5l_Clamp_N43N43D4R$1_0.gate sg13cmos5l_IOPadVdd$1_0.sg13cmos5l_RCClampInverter$1_0.in sg13cmos5l_Corner_1.vss sg13cmos5l_Corner_1.vss sg13_hv_nmos ad=1.71p pd=9.38u as=1.71p ps=9.38u w=9u l=0.5u
M4039 a_85460_100310# adc8b_0.sar12b_0.sg13cmos5l_inv_1_17.A sg13cmos5l_Corner_1.vss sg13cmos5l_Corner_1.vss sg13_lv_nmos ad=0.187p pd=1.78u as=0.14875p ps=1.16u w=0.55u l=0.13u
M4040 sg13cmos5l_Corner_1.vss a_88504_93790# a_88153_93909# sg13cmos5l_Corner_1.vss sg13_lv_nmos ad=79.8f pd=0.8u as=0.1428p ps=1.52u w=0.42u l=0.13u
M4041 vip a_42476_102044# sg13cmos5l_Corner_1.iovdd sg13cmos5l_Corner_1.iovdd sg13_hv_pmos ad=3.9294p pd=7.84u as=2.1312p ps=7.3u w=6.66u l=0.6u
M4042 a_87441_94298# a_87260_94620# vdd vdd sg13_lv_pmos ad=0.2128p pd=1.5u as=0.2387p ps=1.84u w=1.12u l=0.13u
M4043 sg13cmos5l_IOPadAnalog_9.pad a_83639_164698# sg13cmos5l_Corner_1.iovdd sg13cmos5l_Corner_1.iovdd sg13_hv_pmos ad=3.9294p pd=7.84u as=2.1312p ps=7.3u w=6.66u l=0.6u
X4044 cks sg13cmos5l_IOPadAnalog_8.padres sg13cmos5l_Corner_1.vss rppd l=2u w=1u
M4045 adc8b_0.side_cap8b_0.buf_32_1.z adc8b_0.side_cap8b_0.in_h_sw[0] vddr vddr sg13_lv_pmos ad=0.19p pd=1.38u as=0.19p ps=1.38u w=1u l=0.13u
M4046 sg13cmos5l_Corner_1.vss a_101972_96536# adc8b_0.sar12b_0.sg13cmos5l_inv_1_6.A sg13cmos5l_Corner_1.vss sg13_lv_nmos ad=0.14875p pd=1.16u as=0.2886p ps=2.26u w=0.74u l=0.13u
M4047 sg13cmos5l_IOPadAnalog_12.pad a_131639_178370# sg13cmos5l_Corner_1.vss sg13cmos5l_Corner_1.vss sg13_hv_nmos ad=2.596p pd=5.58u as=1.408p ps=5.04u w=4.4u l=0.6u
M4048 a_91799_99957# a_90957_99607# a_90540_99600# vdd sg13_lv_pmos ad=0.2048p pd=1.63u as=0.34p ps=2.68u w=1u l=0.13u
M4049 a_99135_99954# adc8b_0.sar12b_0.sg13cmos5l_dfrbp_1_22.D sg13cmos5l_Corner_1.vss sg13cmos5l_Corner_1.vss sg13_lv_nmos ad=0.2516p pd=2.16u as=0.15055p ps=1.17u w=0.74u l=0.13u
M4050 vdd adc8b_0.sar12b_0.sg13cmos5l_dfrbp_1_6.RESET_B a_90609_96929# vdd sg13_lv_pmos ad=0.2128p pd=1.5u as=0.2128p ps=1.5u w=1.12u l=0.13u
M4051 adc8b_0.sar12b_0.sg13cmos5l_and3_1_0.X a_95092_95856# sg13cmos5l_Corner_1.vss sg13cmos5l_Corner_1.vss sg13_lv_nmos ad=0.2516p pd=2.16u as=0.1371p ps=1.12u w=0.74u l=0.13u
M4052 sg13cmos5l_IOPadVdd$1_0.sg13cmos5l_Clamp_N43N43D4R$1_0.gate sg13cmos5l_IOPadVdd$1_0.sg13cmos5l_RCClampInverter$1_0.in sg13cmos5l_Corner_1.vss sg13cmos5l_Corner_1.vss sg13_hv_nmos ad=1.71p pd=9.38u as=1.71p ps=9.38u w=9u l=0.5u
M4053 vdd a_100995_100350# adc8b_0.sar12b_0.sg13cmos5l_buf_8_2.X vdd sg13_lv_pmos ad=0.2128p pd=1.5u as=0.2128p ps=1.5u w=1.12u l=0.13u
M4054 adc8b_0.sar12b_0.sg13cmos5l_dlhr_1_4.Q_N a_87966_94280# sg13cmos5l_Corner_1.vss sg13cmos5l_Corner_1.vss sg13_lv_nmos ad=0.2516p pd=2.16u as=0.1491p ps=1.18u w=0.74u l=0.13u
M4055 adc8b_0.side_cap8b_1.buf_16_2.z adc8b_0.sar12b_0.nl_sw[1] sg13cmos5l_Corner_1.vss sg13cmos5l_Corner_1.vss sg13_lv_nmos ad=95f pd=0.88u as=95f ps=0.88u w=0.5u l=0.13u
X4056 sg13cmos5l_Corner_1.vss a_33862_70222# dantenna l=27.78u w=1.26u
M4057 sg13cmos5l_Corner_1.vss adc8b_0.sar12b_0.sg13cmos5l_inv_1_27.Y a_96400_100384# sg13cmos5l_Corner_1.vss sg13_lv_nmos ad=0.14875p pd=1.16u as=0.187p ps=1.78u w=0.55u l=0.13u
M4058 vdd adc8b_0.sar12b_0.sg13cmos5l_buf_1_5.A adc8b_0.sar12b_0.sg13cmos5l_inv_1_27.Y vdd sg13_lv_pmos ad=0.3808p pd=2.92u as=0.3808p ps=2.92u w=1.12u l=0.13u
M4059 a_83583_95826# adc8b_0.sar12b_0.sg13cmos5l_dlhr_1_1.GATE sg13cmos5l_Corner_1.vss sg13cmos5l_Corner_1.vss sg13_lv_nmos ad=0.2516p pd=2.16u as=0.15055p ps=1.17u w=0.74u l=0.13u
M4060 adc8b_0.sar12b_0.sg13cmos5l_dfrbp_1_6.D a_83440_94336# sg13cmos5l_Corner_1.vss sg13cmos5l_Corner_1.vss sg13_lv_nmos ad=0.2886p pd=2.26u as=0.14875p ps=1.16u w=0.74u l=0.13u
M4061 a_83614_99010# a_83716_99124# sg13cmos5l_Corner_1.vss sg13cmos5l_Corner_1.vss sg13_lv_nmos ad=0.187p pd=1.78u as=0.1491p ps=1.18u w=0.55u l=0.13u
M4062 a_86012_98084# a_85730_98448# a_85945_98486# sg13cmos5l_Corner_1.vss sg13_lv_nmos ad=0.141p pd=1.17u as=71.99999f ps=0.865u w=0.64u l=0.13u
M4063 sg13cmos5l_Corner_1.vss a_90356_95024# adc8b_0.sar12b_0.sg13cmos5l_buf_1_30.A sg13cmos5l_Corner_1.vss sg13_lv_nmos ad=0.14875p pd=1.16u as=0.2886p ps=2.26u w=0.74u l=0.13u
M4064 sg13cmos5l_Corner_1.vss a_88671_94314# a_88802_94308# sg13cmos5l_Corner_1.vss sg13_lv_nmos ad=2.59257p pd=16.445u as=0.2775p ps=2.23u w=0.74u l=0.13u
M4065 sg13cmos5l_Corner_1.vss adc8b_0.side_cap8b_0.in_h_sw[1] adc8b_0.side_cap8b_0.buf_16_3.z sg13cmos5l_Corner_1.vss sg13_lv_nmos ad=95f pd=0.88u as=95f ps=0.88u w=0.5u l=0.13u
M4066 sg13cmos5l_Corner_1.iovdd a_86044_42476# data[1] sg13cmos5l_Corner_1.iovdd sg13_hv_pmos ad=2.1312p pd=7.3u as=3.9294p ps=7.84u w=6.66u l=0.6u
M4067 sg13cmos5l_Corner_1.iovdd a_131639_164698# sg13cmos5l_IOPadAnalog_12.pad sg13cmos5l_Corner_1.iovdd sg13_hv_pmos ad=2.1312p pd=7.3u as=3.9294p ps=7.84u w=6.66u l=0.6u
M4068 a_84525_94277# adc8b_0.sar12b_0.sg13cmos5l_dfrbp_1_9.Q vdd vdd sg13_lv_pmos ad=0.4088p pd=2.97u as=1.38655p ps=8.8u w=1.12u l=0.13u
M4069 a_96692_92750# adc8b_0.sar12b_0.sg13cmos5l_buf_1_6.A sg13cmos5l_Corner_1.vss sg13cmos5l_Corner_1.vss sg13_lv_nmos ad=0.187p pd=1.78u as=0.14875p ps=1.16u w=0.55u l=0.13u
M4070 a_93324_93104# a_93298_93009# sg13cmos5l_Corner_1.vss sg13cmos5l_Corner_1.vss sg13_lv_nmos ad=0.2516p pd=2.16u as=0.1626p ps=1.415u w=0.74u l=0.13u
M4071 vddr adc8b_0.side_cap8b_0.in_h_sw[1] adc8b_0.side_cap8b_0.buf_16_3.z vddr sg13_lv_pmos ad=0.19p pd=1.38u as=0.19p ps=1.38u w=1u l=0.13u
M4072 vddr adc8b_0.side_cap8b_0.in_h_sw[5] adc8b_0.side_cap8b_0.buf_8_5.z vddr sg13_lv_pmos ad=0.19p pd=1.38u as=0.34p ps=2.68u w=1u l=0.13u
X4073 sg13cmos5l_IOPadAnalog_0.pad sg13cmos5l_Corner_1.iovdd dpantenna l=27.78u w=1.26u
M4074 a_97260_93552# a_97234_93516# sg13cmos5l_Corner_1.vss sg13cmos5l_Corner_1.vss sg13_lv_nmos ad=0.2516p pd=2.16u as=0.1626p ps=1.415u w=0.74u l=0.13u
M4075 vdd a_87885_97301# a_87987_97444# vdd sg13_lv_pmos ad=1.07253p pd=6.75u as=0.3864p ps=2.93u w=1.12u l=0.13u
M4076 sg13cmos5l_Corner_1.vss adc8b_0.sar12b_0.sg13cmos5l_dfrbp_1_6.RESET_B a_97180_96960# sg13cmos5l_Corner_1.vss sg13_lv_nmos ad=0.1406p pd=1.12u as=77.7f ps=0.95u w=0.74u l=0.13u
M4077 vddr adc8b_0.sar12b_0.nl_sw[1] adc8b_0.side_cap8b_1.buf_16_2.z vddr sg13_lv_pmos ad=0.19p pd=1.38u as=0.19p ps=1.38u w=1u l=0.13u
M4078 a_87345_93595# a_86988_93552# vdd vdd sg13_lv_pmos ad=63f pd=0.72u as=0.1563p ps=1.22u w=0.42u l=0.13u
M4079 adc8b_0.side_cap8b_0.buf_32_1.z adc8b_0.side_cap8b_0.in_h_sw[0] sg13cmos5l_Corner_1.vss sg13cmos5l_Corner_1.vss sg13_lv_nmos ad=95f pd=0.88u as=95f ps=0.88u w=0.5u l=0.13u
M4080 sg13cmos5l_Corner_1.vss a_89015_99957# a_89852_99596# sg13cmos5l_Corner_1.vss sg13_lv_nmos ad=0.1406p pd=1.12u as=0.2516p ps=2.16u w=0.74u l=0.13u
M4081 vdd a_94583_92863# a_94840_93006# vdd sg13_lv_pmos ad=0.2639p pd=1.81u as=79.8f ps=0.8u w=0.42u l=0.13u
M4082 adc8b_0.sar12b_0.sg13cmos5l_inv_1_26.Y adc8b_0.sar12b_0.sg13cmos5l_buf_1_19.A sg13cmos5l_Corner_1.vss sg13cmos5l_Corner_1.vss sg13_lv_nmos ad=0.2516p pd=2.16u as=0.2516p ps=2.16u w=0.74u l=0.13u
M4083 sg13cmos5l_Corner_1.iovdd a_118044_42476# cko sg13cmos5l_Corner_1.iovdd sg13_hv_pmos ad=2.1312p pd=7.3u as=3.9294p ps=7.84u w=6.66u l=0.6u
M4084 sg13cmos5l_Corner_1.vss adc8b_0.sar12b_0.nl_sw[5] adc8b_0.side_cap8b_1.buf_8_4.z sg13cmos5l_Corner_1.vss sg13_lv_nmos ad=95f pd=0.88u as=95f ps=0.88u w=0.5u l=0.13u
M4085 vdd adc8b_0.cmp_0.clk a_76796_95659# vdd sg13_lv_pmos ad=95f pd=0.88u as=0.17p ps=1.68u w=0.5u l=0.13u
M4086 data[2] a_102044_42476# sg13cmos5l_Corner_1.iovdd sg13cmos5l_Corner_1.iovdd sg13_hv_pmos ad=3.9294p pd=7.84u as=2.1312p ps=7.3u w=6.66u l=0.6u
X4087 sg13cmos5l_IOPadAnalog_11.pad sg13cmos5l_Corner_1.iovdd dpantenna l=27.78u w=1.26u
M4088 a_100796_96572# a_100514_96936# a_100729_96974# sg13cmos5l_Corner_1.vss sg13_lv_nmos ad=0.141p pd=1.17u as=71.99999f ps=0.865u w=0.64u l=0.13u
M4089 sg13cmos5l_IOPadAnalog_12.pad a_131639_164698# sg13cmos5l_Corner_1.iovdd sg13cmos5l_Corner_1.iovdd sg13_hv_pmos ad=3.9294p pd=7.84u as=2.1312p ps=7.3u w=6.66u l=0.6u
M4090 vdd a_97197_98813# a_97299_98956# vdd sg13_lv_pmos ad=1.15047p pd=7.175u as=0.3864p ps=2.93u w=1.12u l=0.13u
M4091 a_90734_97760# a_90338_97332# a_90620_97644# vdd sg13_lv_pmos ad=0.1008p pd=0.9u as=0.191p ps=1.44u w=0.42u l=0.13u
M4092 a_88415_96619# adc8b_0.sar12b_0.sg13cmos5l_dfrbp_1_8.RESET_B vdd vdd sg13_lv_pmos ad=79.8f pd=0.8u as=0.36237p ps=2.605u w=0.42u l=0.13u
M4093 a_100729_96974# a_100177_96930# sg13cmos5l_Corner_1.vss sg13cmos5l_Corner_1.vss sg13_lv_nmos ad=71.99999f pd=0.865u as=1.97045p ps=12.335u w=0.64u l=0.13u
M4094 sg13cmos5l_IOPadAnalog_10.pad a_67639_164698# sg13cmos5l_Corner_1.iovdd sg13cmos5l_Corner_1.iovdd sg13_hv_pmos ad=3.9294p pd=7.84u as=2.1312p ps=7.3u w=6.66u l=0.6u
M4095 a_91993_100338# a_91441_100400# sg13cmos5l_Corner_1.vss sg13cmos5l_Corner_1.vss sg13_lv_nmos ad=71.99999f pd=0.865u as=2.92392p ps=18.89u w=0.64u l=0.13u
M4096 a_96396_99600# a_96370_99564# vdd vdd sg13_lv_pmos ad=0.34p pd=2.68u as=0.36237p ps=2.605u w=1u l=0.13u
M4097 a_87956_92750# adc8b_0.sar12b_0.sg13cmos5l_buf_1_25.A vdd vdd sg13_lv_pmos ad=0.2856p pd=2.36u as=0.2114p ps=1.54u w=0.84u l=0.13u
M4098 sg13cmos5l_Corner_1.vss sg13cmos5l_IOPadVdd$1_0.sg13cmos5l_Clamp_N43N43D4R$1_0.gate vdd sg13cmos5l_Corner_1.vss sg13_hv_nmos ad=1.408p pd=5.04u as=2.596p ps=5.58u w=4.4u l=0.6u
M4099 adc8b_0.side_cap8b_0.buf_8_4.z adc8b_0.side_cap8b_0.in_l_sw[5] vddr vddr sg13_lv_pmos ad=0.34p pd=2.68u as=0.19p ps=1.38u w=1u l=0.13u
M4100 sg13cmos5l_Corner_1.iovdd a_164624_70044# sg13cmos5l_IOPadAnalog_1.pad sg13cmos5l_Corner_1.iovdd sg13_hv_pmos ad=2.1312p pd=7.3u as=3.9294p ps=7.84u w=6.66u l=0.6u
M4101 sg13cmos5l_IOPadAnalog_0.pad a_164624_86044# sg13cmos5l_Corner_1.iovdd sg13cmos5l_Corner_1.iovdd sg13_hv_pmos ad=3.9294p pd=7.84u as=2.1312p ps=7.3u w=6.66u l=0.6u
M4102 sg13cmos5l_Corner_1.iovdd a_99639_164698# sg13cmos5l_IOPadAnalog_15.pad sg13cmos5l_Corner_1.iovdd sg13_hv_pmos ad=2.1312p pd=7.3u as=3.9294p ps=7.84u w=6.66u l=0.6u
M4103 a_82893_98095# adc8b_0.sar12b_0.sg13cmos5l_dfrbp_1_15.D sg13cmos5l_Corner_1.vss sg13cmos5l_Corner_1.vss sg13_lv_nmos ad=0.2516p pd=2.16u as=1.49685p ps=9.6u w=0.74u l=0.13u
X4104 data[2] sg13cmos5l_Corner_1.iovdd dpantenna l=1.26u w=27.78u
M4105 sg13cmos5l_Corner_1.iovdd a_115639_164698# sg13cmos5l_IOPadAnalog_13.pad sg13cmos5l_Corner_1.iovdd sg13_hv_pmos ad=2.1312p pd=7.3u as=3.9294p ps=7.84u w=6.66u l=0.6u
M4106 vdd adc8b_0.sar12b_0.sg13cmos5l_dlhr_1_12.D a_98929_99954# vdd sg13_lv_pmos ad=1.15047p pd=7.175u as=0.2856p ps=2.36u w=0.84u l=0.13u
M4107 vdd a_94335_98442# a_94466_98448# vdd sg13_lv_pmos ad=1.07253p pd=6.75u as=0.2856p ps=2.36u w=0.84u l=0.13u
M4108 vdd adc8b_0.sar12b_0.sg13cmos5l_dfrbp_1_6.RESET_B a_101361_97322# vdd sg13_lv_pmos ad=0.2128p pd=1.5u as=0.2128p ps=1.5u w=1.12u l=0.13u
M4109 a_87981_95071# adc8b_0.sar12b_0.sg13cmos5l_dfrbp_1_11.Q sg13cmos5l_Corner_1.vss sg13cmos5l_Corner_1.vss sg13_lv_nmos ad=0.2516p pd=2.16u as=2.41737p ps=15.64u w=0.74u l=0.13u
M4110 a_94868_99560# adc8b_0.sar12b_0.sg13cmos5l_buf_1_90.X sg13cmos5l_Corner_1.vss sg13cmos5l_Corner_1.vss sg13_lv_nmos ad=0.187p pd=1.78u as=0.14875p ps=1.16u w=0.55u l=0.13u
M4111 a_97912_99838# adc8b_0.sar12b_0.sg13cmos5l_dfrbp_1_8.RESET_B vdd vdd sg13_lv_pmos ad=79.8f pd=0.8u as=1.12242p ps=7u w=0.42u l=0.13u
M4112 sg13cmos5l_Corner_1.vss adc8b_0.sar12b_0.sg13cmos5l_buf_1_39.A a_85456_92824# sg13cmos5l_Corner_1.vss sg13_lv_nmos ad=0.14875p pd=1.16u as=0.187p ps=1.78u w=0.55u l=0.13u
M4113 sg13cmos5l_IOPadAnalog_9.pad a_83639_178370# sg13cmos5l_Corner_1.vss sg13cmos5l_Corner_1.vss sg13_hv_nmos ad=2.596p pd=5.58u as=1.408p ps=5.04u w=4.4u l=0.6u
M4114 adc8b_0.side_cap8b_0.buf_32_0.z adc8b_0.side_cap8b_0.in_l_sw[0] vddr vddr sg13_lv_pmos ad=0.19p pd=1.38u as=0.19p ps=1.38u w=1u l=0.13u
M4115 vip a_42476_102044# sg13cmos5l_Corner_1.iovdd sg13cmos5l_Corner_1.iovdd sg13_hv_pmos ad=3.9294p pd=7.84u as=2.1312p ps=7.3u w=6.66u l=0.6u
M4116 sg13cmos5l_Corner_1.iovdd a_86044_42476# data[1] sg13cmos5l_Corner_1.iovdd sg13_hv_pmos ad=2.1312p pd=7.3u as=3.9294p ps=7.84u w=6.66u l=0.6u
M4117 vin a_42476_86044# sg13cmos5l_Corner_1.iovdd sg13cmos5l_Corner_1.iovdd sg13_hv_pmos ad=3.9294p pd=7.84u as=2.1312p ps=7.3u w=6.66u l=0.6u
M4118 sg13cmos5l_Corner_1.vss a_131639_178370# sg13cmos5l_IOPadAnalog_12.pad sg13cmos5l_Corner_1.vss sg13_hv_nmos ad=1.408p pd=5.04u as=2.596p ps=5.58u w=4.4u l=0.6u
M4119 adc8b_0.sar12b_0.sg13cmos5l_dfrbp_1_9.Q a_86012_95060# sg13cmos5l_Corner_1.vss sg13cmos5l_Corner_1.vss sg13_lv_nmos ad=0.2516p pd=2.16u as=0.1406p ps=1.12u w=0.74u l=0.13u
M4120 sg13cmos5l_IOPadAnalog_11.pad a_164624_118044# sg13cmos5l_Corner_1.iovdd sg13cmos5l_Corner_1.iovdd sg13_hv_pmos ad=3.9294p pd=7.84u as=2.1312p ps=7.3u w=6.66u l=0.6u
M4121 sg13cmos5l_Corner_1.vss adc8b_0.sar12b_0.nl_sw[2] adc8b_0.side_cap8b_1.buf_16_1.z sg13cmos5l_Corner_1.vss sg13_lv_nmos ad=95f pd=0.88u as=95f ps=0.88u w=0.5u l=0.13u
X4122 sg13cmos5l_Corner_1.vss a_176786_86222# dantenna l=27.78u w=1.26u
M4123 sg13cmos5l_Corner_1.iovdd a_164624_86044# sg13cmos5l_IOPadAnalog_0.pad sg13cmos5l_Corner_1.iovdd sg13_hv_pmos ad=2.1312p pd=7.3u as=3.9294p ps=7.84u w=6.66u l=0.6u
M4124 vdd sg13cmos5l_IOPadVdd$1_0.sg13cmos5l_Clamp_N43N43D4R$1_0.gate sg13cmos5l_Corner_1.vss sg13cmos5l_Corner_1.vss sg13_hv_nmos ad=2.596p pd=5.58u as=1.408p ps=5.04u w=4.4u l=0.6u
M4125 vdd a_90015_96930# a_90146_96936# vdd sg13_lv_pmos ad=1.28962p pd=8.195u as=0.2856p ps=2.36u w=0.84u l=0.13u
M4126 a_73970_98361# adc8b_0.cmp_0.clk vdd vdd sg13_lv_pmos ad=0.17p pd=1.68u as=95f ps=0.88u w=0.5u l=0.13u
M4127 sg13cmos5l_Corner_1.vss a_83765_97286# adc8b_0.sar12b_0.sg13cmos5l_dfrbp_1_15.Q_N sg13cmos5l_Corner_1.vss sg13_lv_nmos ad=0.2516p pd=2.16u as=0.2849p ps=2.25u w=0.74u l=0.13u
M4128 sg13cmos5l_Corner_1.iovdd a_118044_42476# cko sg13cmos5l_Corner_1.iovdd sg13_hv_pmos ad=2.1312p pd=7.3u as=3.9294p ps=7.84u w=6.66u l=0.6u
M4129 vdd sg13cmos5l_IOPadVdd$1_0.sg13cmos5l_Clamp_N43N43D4R$1_0.gate sg13cmos5l_Corner_1.vss sg13cmos5l_Corner_1.vss sg13_hv_nmos ad=2.596p pd=5.58u as=1.408p ps=5.04u w=4.4u l=0.6u
M4130 vddr a_30676_70044# sg13cmos5l_Corner_1.vss sg13cmos5l_Corner_1.vss sg13_hv_nmos ad=2.596p pd=5.58u as=2.068p ps=9.74u w=4.4u l=0.6u
M4131 adc8b_0.sar12b_0.sg13cmos5l_dlhr_1_0.GATE a_87452_96108# sg13cmos5l_Corner_1.vss sg13cmos5l_Corner_1.vss sg13_lv_nmos ad=0.2516p pd=2.16u as=0.1406p ps=1.12u w=0.74u l=0.13u
M4132 data[2] a_102044_42476# sg13cmos5l_Corner_1.iovdd sg13cmos5l_Corner_1.iovdd sg13_hv_pmos ad=3.9294p pd=7.84u as=2.1312p ps=7.3u w=6.66u l=0.6u
M4133 sg13cmos5l_Corner_1.iovdd a_164624_70044# sg13cmos5l_IOPadAnalog_1.pad sg13cmos5l_Corner_1.iovdd sg13_hv_pmos ad=2.1312p pd=7.3u as=3.9294p ps=7.84u w=6.66u l=0.6u
M4134 sg13cmos5l_IOPadAnalog_0.pad a_164624_86044# sg13cmos5l_Corner_1.iovdd sg13cmos5l_Corner_1.iovdd sg13_hv_pmos ad=3.9294p pd=7.84u as=2.1312p ps=7.3u w=6.66u l=0.6u
M4135 sg13cmos5l_Corner_1.iovdd a_164624_102044# sg13cmos5l_IOPadAnalog_16.pad sg13cmos5l_Corner_1.iovdd sg13_hv_pmos ad=2.1312p pd=7.3u as=3.9294p ps=7.84u w=6.66u l=0.6u
M4136 a_93516_93973# a_93747_93559# a_93202_93516# sg13cmos5l_Corner_1.vss sg13_lv_nmos ad=0.2373p pd=1.97u as=79.8f ps=0.8u w=0.42u l=0.13u
M4137 a_99442_94521# a_99885_94277# a_99182_94298# sg13cmos5l_Corner_1.vss sg13_lv_nmos ad=79.8f pd=0.8u as=0.1296p ps=1.52u w=0.42u l=0.13u
M4138 sg13cmos5l_Corner_1.vss a_30676_102044# vip sg13cmos5l_Corner_1.vss sg13_hv_nmos ad=1.408p pd=5.04u as=2.596p ps=5.58u w=4.4u l=0.6u
M4139 a_98296_99054# a_98039_98911# a_98458_98834# sg13cmos5l_Corner_1.vss sg13_lv_nmos ad=0.1428p pd=1.52u as=37.8f ps=0.6u w=0.42u l=0.13u
M4140 sg13cmos5l_IOPadAnalog_11.pad a_164624_118044# sg13cmos5l_Corner_1.iovdd sg13cmos5l_Corner_1.iovdd sg13_hv_pmos ad=3.9294p pd=7.84u as=2.1312p ps=7.3u w=6.66u l=0.6u
M4141 vddr adc8b_0.sar12b_0.nh_sw[1] adc8b_0.side_cap8b_1.buf_16_3.z vddr sg13_lv_pmos ad=0.19p pd=1.38u as=0.19p ps=1.38u w=1u l=0.13u
M4142 vdd adc8b_0.sar12b_0.sg13cmos5l_dlhr_1_10.Q a_101296_98084# vdd sg13_lv_pmos ad=0.2114p pd=1.54u as=0.2856p ps=2.36u w=0.84u l=0.13u
X4143 a_36456_134095# a_40542_134425# sg13cmos5l_Corner_1.vss rppd l=20u w=1u
M4144 adc8b_0.side_cap8b_0.buf_16_1.z adc8b_0.side_cap8b_0.in_l_sw[2] sg13cmos5l_Corner_1.vss sg13cmos5l_Corner_1.vss sg13_lv_nmos ad=95f pd=0.88u as=95f ps=0.88u w=0.5u l=0.13u
M4145 sg13cmos5l_Corner_1.vss a_85460_100310# adc8b_0.sar12b_0.sg13cmos5l_buf_1_62.X sg13cmos5l_Corner_1.vss sg13_lv_nmos ad=0.14875p pd=1.16u as=0.2886p ps=2.26u w=0.74u l=0.13u
M4146 sg13cmos5l_IOPadAnalog_13.pad a_115639_178370# sg13cmos5l_Corner_1.vss sg13cmos5l_Corner_1.vss sg13_hv_nmos ad=2.596p pd=5.58u as=1.408p ps=5.04u w=4.4u l=0.6u
M4147 sg13cmos5l_IOPadAnalog_12.pad a_131639_178370# sg13cmos5l_Corner_1.vss sg13cmos5l_Corner_1.vss sg13_hv_nmos ad=2.596p pd=5.58u as=2.068p ps=9.74u w=4.4u l=0.6u
M4148 vddr a_30676_70044# sg13cmos5l_Corner_1.vss sg13cmos5l_Corner_1.vss sg13_hv_nmos ad=2.596p pd=5.58u as=1.408p ps=5.04u w=4.4u l=0.6u
M4149 frame a_134044_42476# sg13cmos5l_Corner_1.iovdd sg13cmos5l_Corner_1.iovdd sg13_hv_pmos ad=3.9294p pd=7.84u as=2.1312p ps=7.3u w=6.66u l=0.6u
M4150 sg13cmos5l_Corner_1.vss a_86044_30676# data[1] sg13cmos5l_Corner_1.vss sg13_hv_nmos ad=1.408p pd=5.04u as=2.596p ps=5.58u w=4.4u l=0.6u
M4151 vddr a_42476_70044# sg13cmos5l_Corner_1.iovdd sg13cmos5l_Corner_1.iovdd sg13_hv_pmos ad=3.9294p pd=7.84u as=2.1312p ps=7.3u w=6.66u l=0.6u
M4152 sg13cmos5l_Corner_1.iovdd a_42476_70044# vddr sg13cmos5l_Corner_1.iovdd sg13_hv_pmos ad=2.1312p pd=7.3u as=3.9294p ps=7.84u w=6.66u l=0.6u
M4153 vddr adc8b_0.side_cap8b_0.in_h_sw[0] adc8b_0.side_cap8b_0.buf_32_1.z vddr sg13_lv_pmos ad=0.19p pd=1.38u as=0.19p ps=1.38u w=1u l=0.13u
M4154 adc8b_0.side_cap8b_0.in_l_sw[1] a_82768_100384# sg13cmos5l_Corner_1.vss sg13cmos5l_Corner_1.vss sg13_lv_nmos ad=0.2886p pd=2.26u as=0.14875p ps=1.16u w=0.74u l=0.13u
M4155 a_97470_95347# a_97589_95024# vdd vdd sg13_lv_pmos ad=0.3864p pd=2.93u as=0.2128p ps=1.5u w=1.12u l=0.13u
M4156 adc8b_0.side_cap8b_1.buf_16_0.z adc8b_0.sar12b_0.nh_sw[2] sg13cmos5l_Corner_1.vss sg13cmos5l_Corner_1.vss sg13_lv_nmos ad=95f pd=0.88u as=95f ps=0.88u w=0.5u l=0.13u
M4157 vdd adc8b_0.sar12b_0.sg13cmos5l_buf_1_7.A a_95824_92824# vdd sg13_lv_pmos ad=0.2114p pd=1.54u as=0.2856p ps=2.36u w=0.84u l=0.13u
M4158 vddr adc8b_0.side_cap8b_0.in_h_sw[3] adc8b_0.side_cap8b_0.buf_8_3.z vddr sg13_lv_pmos ad=0.19p pd=1.38u as=0.19p ps=1.38u w=1u l=0.13u
M4159 a_92770_94302# adc8b_0.sar12b_0.sg13cmos5l_nand2_1_0.B sg13cmos5l_Corner_1.vss sg13cmos5l_Corner_1.vss sg13_lv_nmos ad=0.1406p pd=1.12u as=0.2516p ps=2.16u w=0.74u l=0.13u
M4160 sg13cmos5l_Corner_1.vss adc8b_0.sar12b_0.nh_sw[0] adc8b_0.side_cap8b_1.buf_32_1.z sg13cmos5l_Corner_1.vss sg13_lv_nmos ad=95f pd=0.88u as=95f ps=0.88u w=0.5u l=0.13u
M4161 a_82676_92750# adc8b_0.sar12b_0.sg13cmos5l_buf_1_32.A vdd vdd sg13_lv_pmos ad=0.2856p pd=2.36u as=0.2114p ps=1.54u w=0.84u l=0.13u
M4162 a_93539_96572# adc8b_0.sar12b_0.sg13cmos5l_or2_1_1.B vdd vdd sg13_lv_pmos ad=0.3808p pd=2.92u as=0.2128p ps=1.5u w=1.12u l=0.13u
M4163 sg13cmos5l_Corner_1.iovdd a_67639_164698# sg13cmos5l_IOPadAnalog_10.pad sg13cmos5l_Corner_1.iovdd sg13_hv_pmos ad=2.1312p pd=7.3u as=3.9294p ps=7.84u w=6.66u l=0.6u
M4164 adc8b_0.side_cap8b_0.buf_16_3.z adc8b_0.side_cap8b_0.in_h_sw[1] sg13cmos5l_Corner_1.vss sg13cmos5l_Corner_1.vss sg13_lv_nmos ad=0.17p pd=1.68u as=95f ps=0.88u w=0.5u l=0.13u
M4165 adc8b_0.side_cap8b_1.buf_4_3.z adc8b_0.sar12b_0.nl_sw[6] vddr vddr sg13_lv_pmos ad=0.19p pd=1.38u as=0.19p ps=1.38u w=1u l=0.13u
M4166 a_89656_96030# adc8b_0.sar12b_0.sg13cmos5l_dfrbp_1_8.RESET_B vdd vdd sg13_lv_pmos ad=79.8f pd=0.8u as=1.2517p ps=7.955u w=0.42u l=0.13u
M4167 a_95416_100566# adc8b_0.sar12b_0.sg13cmos5l_dfrbp_1_8.RESET_B vdd vdd sg13_lv_pmos ad=79.8f pd=0.8u as=4.11675p ps=27.17u w=0.42u l=0.13u
M4168 sg13cmos5l_Corner_1.vss adc8b_0.sar12b_0.sg13cmos5l_dfrbp_1_6.RESET_B a_99518_95485# sg13cmos5l_Corner_1.vss sg13_lv_nmos ad=0.1701p pd=1.65u as=37.8f ps=0.6u w=0.42u l=0.13u
M4169 sg13cmos5l_Corner_1.vss a_178296_86044# sg13cmos5l_IOPadAnalog_0.pad sg13cmos5l_Corner_1.vss sg13_hv_nmos ad=1.408p pd=5.04u as=2.596p ps=5.58u w=4.4u l=0.6u
M4170 sg13cmos5l_Corner_1.iovdd a_164624_86044# sg13cmos5l_IOPadAnalog_0.pad sg13cmos5l_Corner_1.iovdd sg13_hv_pmos ad=3.1302p pd=14.26u as=3.9294p ps=7.84u w=6.66u l=0.6u
M4171 a_97836_97322# adc8b_0.sar12b_0.sg13cmos5l_buf_1_57.X a_97742_97322# sg13cmos5l_Corner_1.vss sg13_lv_nmos ad=60.89999f pd=0.71u as=0.1428p ps=1.52u w=0.42u l=0.13u
M4172 sg13cmos5l_Corner_1.iovdd a_164624_118044# sg13cmos5l_IOPadAnalog_11.pad sg13cmos5l_Corner_1.iovdd sg13_hv_pmos ad=2.1312p pd=7.3u as=3.9294p ps=7.84u w=6.66u l=0.6u
M4173 vdd a_92241_100346# a_92766_100328# vdd sg13_lv_pmos ad=0.1974p pd=1.5u as=0.2856p ps=2.36u w=0.84u l=0.13u
M4174 adc8b_0.sar12b_0.sg13cmos5l_dfrbp_1_11.Q a_90236_96108# vdd vdd sg13_lv_pmos ad=0.3808p pd=2.92u as=0.2128p ps=1.5u w=1.12u l=0.13u
M4175 vddr adc8b_0.sar12b_0.nl_sw[0] adc8b_0.side_cap8b_1.buf_32_0.z vddr sg13_lv_pmos ad=0.19p pd=1.38u as=0.19p ps=1.38u w=1u l=0.13u
M4176 sg13cmos5l_IOPadAnalog_16.pad a_178296_102044# sg13cmos5l_Corner_1.vss sg13cmos5l_Corner_1.vss sg13_hv_nmos ad=2.596p pd=5.58u as=1.408p ps=5.04u w=4.4u l=0.6u
M4177 sg13cmos5l_Corner_1.vss adc8b_0.sar12b_0.sg13cmos5l_inv_1_2.A adc8b_0.sar12b_0.sg13cmos5l_dfrbp_1_0.CLK sg13cmos5l_Corner_1.vss sg13_lv_nmos ad=0.2516p pd=2.16u as=0.2516p ps=2.16u w=0.74u l=0.13u
M4178 adc8b_0.sar12b_0.sg13cmos5l_dlygate4sd2_1_0.X a_83058_94366# sg13cmos5l_Corner_1.vss sg13cmos5l_Corner_1.vss sg13_lv_nmos ad=0.2516p pd=2.16u as=0.1405p ps=1.15u w=0.74u l=0.13u
M4179 sg13cmos5l_Corner_1.vss adc8b_0.sar12b_0.nl_sw[8] adc8b_0.side_cap8b_1.buf_2_1.z sg13cmos5l_Corner_1.vss sg13_lv_nmos ad=95f pd=0.88u as=0.17p ps=1.68u w=0.5u l=0.13u
M4180 adc8b_0.side_cap8b_1.buf_16_0.z adc8b_0.sar12b_0.nh_sw[2] vddr vddr sg13_lv_pmos ad=0.19p pd=1.38u as=0.19p ps=1.38u w=1u l=0.13u
M4181 sg13cmos5l_Corner_1.iovdd a_118044_42476# cko sg13cmos5l_Corner_1.iovdd sg13_hv_pmos ad=2.1312p pd=7.3u as=3.9294p ps=7.84u w=6.66u l=0.6u
M4182 a_83630_100034# a_84435_99607# a_83890_99564# vdd sg13_lv_pmos ad=0.1428p pd=1.52u as=79.8f ps=0.8u w=0.42u l=0.13u
M4183 vddr a_42476_70044# sg13cmos5l_Corner_1.iovdd sg13cmos5l_Corner_1.iovdd sg13_hv_pmos ad=3.9294p pd=7.84u as=2.1312p ps=7.3u w=6.66u l=0.6u
M4184 adc8b_0.sar12b_0.sg13cmos5l_inv_1_7.A a_93232_99596# vdd vdd sg13_lv_pmos ad=0.42p pd=2.99u as=0.2114p ps=1.54u w=1.12u l=0.13u
M4185 vdd adc8b_0.sar12b_0.sg13cmos5l_dfrbp_1_6.D a_99167_95107# vdd sg13_lv_pmos ad=0.1428p pd=1.52u as=79.8f ps=0.8u w=0.42u l=0.13u
M4186 a_97268_100310# adc8b_0.sar12b_0.sg13cmos5l_buf_1_95.X vdd vdd sg13_lv_pmos ad=0.2856p pd=2.36u as=0.2114p ps=1.54u w=0.84u l=0.13u
M4187 adc8b_0.side_cap8b_1.buf_8_0.z adc8b_0.sar12b_0.nl_sw[4] vddr vddr sg13_lv_pmos ad=0.19p pd=1.38u as=0.19p ps=1.38u w=1u l=0.13u
M4188 sg13cmos5l_Corner_1.vss adc8b_0.sar12b_0.sg13cmos5l_dlhr_1_1.D a_83377_95864# sg13cmos5l_Corner_1.vss sg13_lv_nmos ad=0.15055p pd=1.17u as=0.187p ps=1.78u w=0.55u l=0.13u
M4189 adc8b_0.sar12b_0.sg13cmos5l_o21ai_1_0.A2 adc8b_0.sar12b_0.sg13cmos5l_nand2_1_0.B vdd vdd sg13_lv_pmos ad=0.2128p pd=1.5u as=0.3808p ps=2.92u w=1.12u l=0.13u
M4190 vddr adc8b_0.sar12b_0.nl_sw[0] adc8b_0.side_cap8b_1.buf_32_0.z vddr sg13_lv_pmos ad=0.19p pd=1.38u as=0.19p ps=1.38u w=1u l=0.13u
M4191 vdd a_93741_92765# a_93843_92908# vdd sg13_lv_pmos ad=1.86162p pd=11.935u as=0.3864p ps=2.93u w=1.12u l=0.13u
M4192 vdd sg13cmos5l_Corner_1.vss vdd vdd sg13_lv_pmos ad=0.34p pd=2.68u as=0 ps=0 w=1u l=1u
M4193 vdd a_84980_92750# adc8b_0.sar12b_0.sg13cmos5l_buf_1_41.X vdd sg13_lv_pmos ad=0.2114p pd=1.54u as=0.42p ps=2.99u w=1.12u l=0.13u
M4194 adc8b_0.side_cap8b_0.buf_8_0.z adc8b_0.side_cap8b_0.in_l_sw[4] sg13cmos5l_Corner_1.vss sg13cmos5l_Corner_1.vss sg13_lv_nmos ad=95f pd=0.88u as=95f ps=0.88u w=0.5u l=0.13u
M4195 sg13cmos5l_Corner_1.iovdd a_86044_42476# data[1] sg13cmos5l_Corner_1.iovdd sg13_hv_pmos ad=3.1302p pd=14.26u as=3.9294p ps=7.84u w=6.66u l=0.6u
M4196 adc8b_0.side_cap8b_1.buf_32_1.z adc8b_0.sar12b_0.nh_sw[0] vddr vddr sg13_lv_pmos ad=0.19p pd=1.38u as=0.19p ps=1.38u w=1u l=0.13u
M4197 sg13cmos5l_Corner_1.vss sg13cmos5l_IOPadVdd$1_0.sg13cmos5l_Clamp_N43N43D4R$1_0.gate vdd sg13cmos5l_Corner_1.vss sg13_hv_nmos ad=1.408p pd=5.04u as=2.596p ps=5.58u w=4.4u l=0.6u
M4198 vdd adc8b_0.sar12b_0.sg13cmos5l_buf_1_65.X a_90256_100384# vdd sg13_lv_pmos ad=0.2114p pd=1.54u as=0.2856p ps=2.36u w=0.84u l=0.13u
M4199 data[0] a_70044_42476# sg13cmos5l_Corner_1.iovdd sg13cmos5l_Corner_1.iovdd sg13_hv_pmos ad=3.9294p pd=7.84u as=2.1312p ps=7.3u w=6.66u l=0.6u
M4200 adc8b_0.side_cap8b_0.buf_8_2.z adc8b_0.side_cap8b_0.in_h_sw[4] vddr vddr sg13_lv_pmos ad=0.19p pd=1.38u as=0.19p ps=1.38u w=1u l=0.13u
M4201 adc8b_0.side_cap8b_1.buf_32_0.z adc8b_0.sar12b_0.nl_sw[0] vddr vddr sg13_lv_pmos ad=0.19p pd=1.38u as=0.19p ps=1.38u w=1u l=0.13u
M4202 sg13cmos5l_IOPadAnalog_9.pad a_83639_178370# sg13cmos5l_Corner_1.vss sg13cmos5l_Corner_1.vss sg13_hv_nmos ad=2.596p pd=5.58u as=1.408p ps=5.04u w=4.4u l=0.6u
M4203 sg13cmos5l_Corner_1.iovdd a_42476_86044# vin sg13cmos5l_Corner_1.iovdd sg13_hv_pmos ad=2.1312p pd=7.3u as=3.9294p ps=7.84u w=6.66u l=0.6u
M4204 sg13cmos5l_Corner_1.vss adc8b_0.sar12b_0.sg13cmos5l_buf_1_33.A a_84016_92824# sg13cmos5l_Corner_1.vss sg13_lv_nmos ad=0.14875p pd=1.16u as=0.187p ps=1.78u w=0.55u l=0.13u
M4205 adc8b_0.sar12b_0.sg13cmos5l_buf_8_2.X a_100995_100350# sg13cmos5l_Corner_1.vss sg13cmos5l_Corner_1.vss sg13_lv_nmos ad=0.1406p pd=1.12u as=0.1406p ps=1.12u w=0.74u l=0.13u
M4206 vdd a_94868_99560# adc8b_0.side_cap8b_0.in_l_sw[6] vdd sg13_lv_pmos ad=0.2114p pd=1.54u as=0.42p ps=2.99u w=1.12u l=0.13u
M4207 adc8b_0.sar12b_0.sg13cmos5l_dfrbp_1_1.Q a_95420_93084# vdd vdd sg13_lv_pmos ad=0.3808p pd=2.92u as=0.2128p ps=1.5u w=1.12u l=0.13u
M4208 sg13cmos5l_Corner_1.vss sg13cmos5l_IOPadVdd$1_0.sg13cmos5l_Clamp_N43N43D4R$1_0.gate vdd sg13cmos5l_Corner_1.vss sg13_hv_nmos ad=1.408p pd=5.04u as=2.596p ps=5.58u w=4.4u l=0.6u
M4209 vin a_42476_86044# sg13cmos5l_Corner_1.iovdd sg13cmos5l_Corner_1.iovdd sg13_hv_pmos ad=3.9294p pd=7.84u as=2.1312p ps=7.3u w=6.66u l=0.6u
M4210 adc8b_0.sar12b_0.sg13cmos5l_dlygate4sd2_1_0.X a_83058_94366# vdd vdd sg13_lv_pmos ad=0.3808p pd=2.92u as=0.2245p ps=1.53u w=1.12u l=0.13u
M4211 a_95052_94616# a_95571_94420# a_96311_94375# sg13cmos5l_Corner_1.vss sg13_lv_nmos ad=0.3473p pd=2.71u as=0.12665p ps=1.145u w=0.74u l=0.13u
M4212 vdd sg13cmos5l_IOPadVdd$1_0.sg13cmos5l_Clamp_N43N43D4R$1_0.gate sg13cmos5l_Corner_1.vss sg13cmos5l_Corner_1.vss sg13_hv_nmos ad=2.596p pd=5.58u as=1.408p ps=5.04u w=4.4u l=0.6u
M4213 adc8b_0.sar12b_0.sg13cmos5l_dfrbp_1_20.Q a_91388_99132# vdd vdd sg13_lv_pmos ad=0.3808p pd=2.92u as=0.2128p ps=1.5u w=1.12u l=0.13u
M4214 vdd adc8b_0.sar12b_0.sg13cmos5l_dfrbp_1_8.RESET_B a_97618_96033# vdd sg13_lv_pmos ad=0.1563p pd=1.22u as=0.147p ps=1.54u w=0.42u l=0.13u
M4215 a_96668_93512# adc8b_0.sar12b_0.sg13cmos5l_nor2_1_1.A sg13cmos5l_Corner_1.vss sg13cmos5l_Corner_1.vss sg13_lv_nmos ad=0.187p pd=1.78u as=0.17255p ps=1.25u w=0.55u l=0.13u
M4216 sg13cmos5l_Corner_1.vss a_115639_178370# sg13cmos5l_IOPadAnalog_13.pad sg13cmos5l_Corner_1.vss sg13_hv_nmos ad=1.408p pd=5.04u as=2.596p ps=5.58u w=4.4u l=0.6u
M4217 a_72090_98590# vdd a_71988_99614# sg13cmos5l_Corner_1.vss sg13_lv_nmos ad=0.17p pd=1.68u as=95f ps=0.88u w=0.5u l=0.13u
M4218 a_95160_99156# a_94609_98888# vdd vdd sg13_lv_pmos ad=0.105p pd=1.21u as=1.15047p ps=7.175u w=1u l=0.13u
M4219 a_86012_98084# a_85599_98442# a_85944_98084# vdd sg13_lv_pmos ad=0.191p pd=1.44u as=0.105p ps=1.21u w=1u l=0.13u
M4220 a_76796_95659# adc8b_0.diff_bsw_0.vcp a_74586_95659# sg13cmos5l_Corner_1.vss sg13_lv_nmos ad=1.7p pd=10.68u as=0.95p ps=5.38u w=5u l=0.13u
M4221 sg13cmos5l_Corner_1.vss a_100995_95814# adc8b_0.sar12b_0.sg13cmos5l_buf_8_0.X sg13cmos5l_Corner_1.vss sg13_lv_nmos ad=0.1406p pd=1.12u as=0.1406p ps=1.12u w=0.74u l=0.13u
M4222 a_93324_93104# a_93843_92908# a_94583_92863# sg13cmos5l_Corner_1.vss sg13_lv_nmos ad=0.3473p pd=2.71u as=0.12665p ps=1.145u w=0.74u l=0.13u
M4223 sg13cmos5l_Corner_1.vss a_131639_178370# sg13cmos5l_IOPadAnalog_12.pad sg13cmos5l_Corner_1.vss sg13_hv_nmos ad=1.408p pd=5.04u as=2.596p ps=5.58u w=4.4u l=0.6u
M4224 vdd adc8b_0.sar12b_0.sg13cmos5l_dfrbp_1_6.RESET_B a_99729_99953# vdd sg13_lv_pmos ad=0.2128p pd=1.5u as=0.2128p ps=1.5u w=1.12u l=0.13u
M4225 a_88114_96033# a_88557_95789# a_87854_95810# sg13cmos5l_Corner_1.vss sg13_lv_nmos ad=79.8f pd=0.8u as=0.1296p ps=1.52u w=0.42u l=0.13u
M4226 adc8b_0.side_cap8b_1.buf_32_1.z adc8b_0.sar12b_0.nh_sw[0] vddr vddr sg13_lv_pmos ad=0.19p pd=1.38u as=0.19p ps=1.38u w=1u l=0.13u
M4227 a_96657_98441# a_96476_98084# vdd vdd sg13_lv_pmos ad=0.2128p pd=1.5u as=0.2387p ps=1.84u w=1.12u l=0.13u
M4228 sg13cmos5l_Corner_1.vss adc8b_0.sar12b_0.sg13cmos5l_dlhr_1_10.Q a_101296_98084# sg13cmos5l_Corner_1.vss sg13_lv_nmos ad=0.14875p pd=1.16u as=0.187p ps=1.78u w=0.55u l=0.13u
M4229 a_100767_97338# adc8b_0.sar12b_0.sg13cmos5l_dfrbp_1_8.D sg13cmos5l_Corner_1.vss sg13cmos5l_Corner_1.vss sg13_lv_nmos ad=0.2516p pd=2.16u as=0.15055p ps=1.17u w=0.74u l=0.13u
M4230 adc8b_0.side_cap8b_1.buf_16_1.z adc8b_0.sar12b_0.nl_sw[2] sg13cmos5l_Corner_1.vss sg13cmos5l_Corner_1.vss sg13_lv_nmos ad=95f pd=0.88u as=95f ps=0.88u w=0.5u l=0.13u
M4231 adc8b_0.sar12b_0.sg13cmos5l_dfrbp_1_6.RESET_B cks sg13cmos5l_Corner_1.vss sg13cmos5l_Corner_1.vss sg13_lv_nmos ad=0.1406p pd=1.12u as=0.1406p ps=1.12u w=0.74u l=0.13u
M4232 adc8b_0.side_cap8b_1.buf_32_1.z adc8b_0.sar12b_0.nh_sw[0] sg13cmos5l_Corner_1.vss sg13cmos5l_Corner_1.vss sg13_lv_nmos ad=0.17p pd=1.68u as=95f ps=0.88u w=0.5u l=0.13u
M4233 adc8b_0.side_cap8b_1.buf_32_0.z adc8b_0.sar12b_0.nl_sw[0] sg13cmos5l_Corner_1.vss sg13cmos5l_Corner_1.vss sg13_lv_nmos ad=95f pd=0.88u as=95f ps=0.88u w=0.5u l=0.13u
M4234 a_93228_93552# a_93747_93559# a_94487_93909# sg13cmos5l_Corner_1.vss sg13_lv_nmos ad=0.3473p pd=2.71u as=0.12665p ps=1.145u w=0.74u l=0.13u
M4235 sg13cmos5l_Corner_1.vss a_83716_99124# adc8b_0.sar12b_0.sg13cmos5l_buf_1_58.A sg13cmos5l_Corner_1.vss sg13_lv_nmos ad=0.1406p pd=1.12u as=0.2516p ps=2.16u w=0.74u l=0.13u
M4236 a_97470_95347# a_97589_95024# sg13cmos5l_Corner_1.vss sg13cmos5l_Corner_1.vss sg13_lv_nmos ad=0.2516p pd=2.16u as=0.1406p ps=1.12u w=0.74u l=0.13u
X4237 sg13cmos5l_Corner_1.vss sg13cmos5l_IOPadAnalog_13.padres dantenna l=3.1u w=0.64u
M4238 adc8b_0.side_cap8b_0.buf_4_3.z adc8b_0.side_cap8b_0.in_l_sw[6] vddr vddr sg13_lv_pmos ad=0.19p pd=1.38u as=0.19p ps=1.38u w=1u l=0.13u
M4239 sg13cmos5l_Corner_1.vss adc8b_0.side_cap8b_0.in_h_sw[9] adc8b_0.side_cap8b_0.buf_2_3.z sg13cmos5l_Corner_1.vss sg13_lv_nmos ad=95f pd=0.88u as=0.17p ps=1.68u w=0.5u l=0.13u
M4240 a_89972_100310# adc8b_0.sar12b_0.sg13cmos5l_buf_1_45.X vdd vdd sg13_lv_pmos ad=0.2856p pd=2.36u as=0.2114p ps=1.54u w=0.84u l=0.13u
M4241 sg13cmos5l_Corner_1.vss a_99287_97399# a_100124_97620# sg13cmos5l_Corner_1.vss sg13_lv_nmos ad=0.1406p pd=1.12u as=0.2516p ps=2.16u w=0.74u l=0.13u
M4242 a_96568_94518# adc8b_0.sar12b_0.sg13cmos5l_dfrbp_1_0.RESET_B vdd vdd sg13_lv_pmos ad=79.8f pd=0.8u as=1.38655p ps=8.8u w=0.42u l=0.13u
M4243 a_97655_99957# a_96813_99607# a_96396_99600# vdd sg13_lv_pmos ad=0.2048p pd=1.63u as=0.34p ps=2.68u w=1u l=0.13u
M4244 a_86092_99156# a_86117_98796# vdd vdd sg13_lv_pmos ad=0.2856p pd=2.36u as=1.15047p ps=7.175u w=0.84u l=0.13u
M4245 a_99519_98850# adc8b_0.sar12b_0.sg13cmos5l_dfrbp_1_22.D vdd vdd sg13_lv_pmos ad=0.3234p pd=2.45u as=1.12242p ps=7u w=0.84u l=0.13u
M4246 adc8b_0.side_cap8b_0.buf_32_1.z adc8b_0.side_cap8b_0.in_h_sw[0] vddr vddr sg13_lv_pmos ad=0.34p pd=2.68u as=0.19p ps=1.38u w=1u l=0.13u
M4247 cko a_102160_98872# vdd vdd sg13_lv_pmos ad=0.42p pd=2.99u as=0.2114p ps=1.54u w=1.12u l=0.13u
M4248 vdd a_96945_96929# a_97470_97002# vdd sg13_lv_pmos ad=0.1974p pd=1.5u as=0.2856p ps=2.36u w=0.84u l=0.13u
M4249 sg13cmos5l_Corner_1.vss adc8b_0.sar12b_0.nh_sw[4] adc8b_0.side_cap8b_1.buf_8_2.z sg13cmos5l_Corner_1.vss sg13_lv_nmos ad=95f pd=0.88u as=95f ps=0.88u w=0.5u l=0.13u
X4250 sg13cmos5l_IOPadAnalog_1.pad sg13cmos5l_Corner_1.iovdd dpantenna l=27.78u w=1.26u
M4251 sg13cmos5l_IOPadAnalog_0.pad a_164624_86044# sg13cmos5l_Corner_1.iovdd sg13cmos5l_Corner_1.iovdd sg13_hv_pmos ad=3.9294p pd=7.84u as=2.1312p ps=7.3u w=6.66u l=0.6u
M4252 sg13cmos5l_Corner_1.iovdd a_134044_42476# frame sg13cmos5l_Corner_1.iovdd sg13_hv_pmos ad=2.1312p pd=7.3u as=3.9294p ps=7.84u w=6.66u l=0.6u
M4253 adc8b_0.side_cap8b_1.buf_32_1.z adc8b_0.sar12b_0.nh_sw[0] sg13cmos5l_Corner_1.vss sg13cmos5l_Corner_1.vss sg13_lv_nmos ad=95f pd=0.88u as=95f ps=0.88u w=0.5u l=0.13u
M4254 sg13cmos5l_Corner_1.vss vdd sg13cmos5l_Corner_1.vss sg13cmos5l_Corner_1.vss sg13_lv_nmos ad=79.8f pd=0.8u as=0 ps=0 w=0.42u l=1u
M4255 sg13cmos5l_Corner_1.vss a_100995_95814# adc8b_0.sar12b_0.sg13cmos5l_buf_8_0.X sg13cmos5l_Corner_1.vss sg13_lv_nmos ad=0.1406p pd=1.12u as=0.1406p ps=1.12u w=0.74u l=0.13u
M4256 vddr adc8b_0.sar12b_0.nh_sw[5] adc8b_0.side_cap8b_1.buf_8_5.z vddr sg13_lv_pmos ad=0.19p pd=1.38u as=0.34p ps=2.68u w=1u l=0.13u
M4257 sg13cmos5l_Corner_1.vss a_30676_86044# vin sg13cmos5l_Corner_1.vss sg13_hv_nmos ad=1.408p pd=5.04u as=2.596p ps=5.58u w=4.4u l=0.6u
M4258 sg13cmos5l_Corner_1.vss adc8b_0.side_cap8b_0.in_h_sw[1] adc8b_0.side_cap8b_0.buf_16_3.z sg13cmos5l_Corner_1.vss sg13_lv_nmos ad=95f pd=0.88u as=95f ps=0.88u w=0.5u l=0.13u
M4259 sg13cmos5l_Corner_1.vss vdd sg13cmos5l_Corner_1.vss sg13cmos5l_Corner_1.vss sg13_lv_nmos ad=0.1428p pd=1.52u as=0 ps=0 w=0.42u l=1u
M4260 adc8b_0.sar12b_0.sg13cmos5l_dfrbp_1_14.Q_N a_86615_95887# vdd vdd sg13_lv_pmos ad=0.4312p pd=3.01u as=0.2639p ps=1.81u w=1.12u l=0.13u
X4261 sg13cmos5l_IOPadAnalog_16.pad sg13cmos5l_Corner_1.iovdd dpantenna l=27.78u w=1.26u
M4262 vddr adc8b_0.sar12b_0.nh_sw[8] adc8b_0.side_cap8b_1.buf_2_0.z vddr sg13_lv_pmos ad=0.19p pd=1.38u as=0.34p ps=2.68u w=1u l=0.13u
M4263 sg13cmos5l_IOPadAnalog_15.pad a_99639_178370# sg13cmos5l_Corner_1.vss sg13cmos5l_Corner_1.vss sg13_hv_nmos ad=2.596p pd=5.58u as=1.408p ps=5.04u w=4.4u l=0.6u
M4264 sg13cmos5l_IOPadAnalog_13.pad a_115639_178370# sg13cmos5l_Corner_1.vss sg13cmos5l_Corner_1.vss sg13_hv_nmos ad=2.596p pd=5.58u as=1.408p ps=5.04u w=4.4u l=0.6u
M4265 a_82833_98131# a_82476_98088# vdd vdd sg13_lv_pmos ad=63f pd=0.72u as=0.1563p ps=1.22u w=0.42u l=0.13u
M4266 vdd a_87588_96933# a_88611_96619# vdd sg13_lv_pmos ad=0.1563p pd=1.22u as=63f ps=0.72u w=0.42u l=0.13u
M4267 a_87948_95810# adc8b_0.sar12b_0.sg13cmos5l_dlhr_1_0.GATE a_87854_95810# sg13cmos5l_Corner_1.vss sg13_lv_nmos ad=60.89999f pd=0.71u as=0.1428p ps=1.52u w=0.42u l=0.13u
X4268 sg13cmos5l_Corner_1.iovdd a_42476_86044# sg13cmos5l_Corner_1.iovdd rppd l=12.9u w=0.5u
M4269 a_101294_97760# a_100898_97332# a_101180_97644# vdd sg13_lv_pmos ad=0.1008p pd=0.9u as=0.191p ps=1.44u w=0.42u l=0.13u
M4270 data[1] a_86044_30676# sg13cmos5l_Corner_1.vss sg13cmos5l_Corner_1.vss sg13_hv_nmos ad=2.596p pd=5.58u as=2.068p ps=9.74u w=4.4u l=0.6u
M4271 a_94583_92863# a_93741_92765# a_94489_92863# sg13cmos5l_Corner_1.vss sg13_lv_nmos ad=0.12665p pd=1.145u as=0.1428p ps=1.52u w=0.42u l=0.13u
M4272 sg13cmos5l_Corner_1.vss a_83639_178370# sg13cmos5l_IOPadAnalog_9.pad sg13cmos5l_Corner_1.vss sg13_hv_nmos ad=1.408p pd=5.04u as=2.596p ps=5.58u w=4.4u l=0.6u
M4273 sg13cmos5l_Corner_1.iovdd a_118044_42476# cko sg13cmos5l_Corner_1.iovdd sg13_hv_pmos ad=2.1312p pd=7.3u as=3.9294p ps=7.84u w=6.66u l=0.6u
M4274 sg13cmos5l_Corner_1.vss adc8b_0.sar12b_0.nl_sw[5] adc8b_0.side_cap8b_1.buf_8_4.z sg13cmos5l_Corner_1.vss sg13_lv_nmos ad=95f pd=0.88u as=95f ps=0.88u w=0.5u l=0.13u
M4275 vddr adc8b_0.sar12b_0.nh_sw[2] adc8b_0.side_cap8b_1.buf_16_0.z vddr sg13_lv_pmos ad=0.19p pd=1.38u as=0.34p ps=2.68u w=1u l=0.13u
M4276 vddr adc8b_0.side_cap8b_0.in_l_sw[3] adc8b_0.side_cap8b_0.buf_8_1.z vddr sg13_lv_pmos ad=0.19p pd=1.38u as=0.34p ps=2.68u w=1u l=0.13u
M4277 a_85786_94298# adc8b_0.sar12b_0.sg13cmos5l_dfrbp_1_6.RESET_B sg13cmos5l_Corner_1.vss sg13cmos5l_Corner_1.vss sg13_lv_nmos ad=37.8f pd=0.6u as=79.8f ps=0.8u w=0.42u l=0.13u
M4278 sg13cmos5l_IOPadAnalog_1.pad a_164624_70044# sg13cmos5l_Corner_1.iovdd sg13cmos5l_Corner_1.iovdd sg13_hv_pmos ad=3.9294p pd=7.84u as=2.1312p ps=7.3u w=6.66u l=0.6u
M4279 sg13cmos5l_Corner_1.vss adc8b_0.sar12b_0.sg13cmos5l_buf_1_29.A a_91600_92824# sg13cmos5l_Corner_1.vss sg13_lv_nmos ad=0.14875p pd=1.16u as=0.187p ps=1.78u w=0.55u l=0.13u
M4280 adc8b_0.sar12b_0.sg13cmos5l_dfrbp_1_17.Q_N a_85175_99957# sg13cmos5l_Corner_1.vss sg13cmos5l_Corner_1.vss sg13_lv_nmos ad=0.2849p pd=2.25u as=0.2516p ps=2.16u w=0.74u l=0.13u
M4281 sg13cmos5l_Corner_1.vss vdd sg13cmos5l_Corner_1.vss sg13cmos5l_Corner_1.vss sg13_lv_nmos ad=0.1428p pd=1.52u as=0 ps=0 w=0.42u l=1u
M4282 sg13cmos5l_Corner_1.iovdd a_42476_102044# vip sg13cmos5l_Corner_1.iovdd sg13_hv_pmos ad=2.1312p pd=7.3u as=3.9294p ps=7.84u w=6.66u l=0.6u
M4283 cks a_42476_118044# sg13cmos5l_Corner_1.iovdd sg13cmos5l_Corner_1.iovdd sg13_hv_pmos ad=3.9294p pd=7.84u as=2.1312p ps=7.3u w=6.66u l=0.6u
M4284 vip a_70852_97472# a_70096_99454# sg13cmos5l_Corner_1.vss sg13_lv_nmos ad=1.02p pd=6.68u as=1.02p ps=6.68u w=3u l=0.13u
M4285 adc8b_0.side_cap8b_1.buf_4_1.z adc8b_0.sar12b_0.nh_sw[6] vddr vddr sg13_lv_pmos ad=0.34p pd=2.68u as=0.19p ps=1.38u w=1u l=0.13u
M4286 adc8b_0.sar12b_0.sg13cmos5l_dfrbp_1_23.Q a_96380_97620# sg13cmos5l_Corner_1.vss sg13cmos5l_Corner_1.vss sg13_lv_nmos ad=0.2516p pd=2.16u as=0.1406p ps=1.12u w=0.74u l=0.13u
M4287 a_84204_95485# a_84435_95071# a_83890_95028# sg13cmos5l_Corner_1.vss sg13_lv_nmos ad=0.2373p pd=1.97u as=79.8f ps=0.8u w=0.42u l=0.13u
M4288 sg13cmos5l_IOPadAnalog_11.pad a_164624_118044# sg13cmos5l_Corner_1.iovdd sg13cmos5l_Corner_1.iovdd sg13_hv_pmos ad=3.9294p pd=7.84u as=2.1312p ps=7.3u w=6.66u l=0.6u
M4289 vdd a_88823_95421# a_89660_95060# vdd sg13_lv_pmos ad=0.2128p pd=1.5u as=0.3864p ps=2.93u w=1.12u l=0.13u
M4290 sg13cmos5l_Corner_1.iovdd a_86044_42476# data[1] sg13cmos5l_Corner_1.iovdd sg13_hv_pmos ad=2.1312p pd=7.3u as=3.9294p ps=7.84u w=6.66u l=0.6u
M4291 sg13cmos5l_Corner_1.iovdd a_42476_86044# vin sg13cmos5l_Corner_1.iovdd sg13_hv_pmos ad=2.1312p pd=7.3u as=3.9294p ps=7.84u w=6.66u l=0.6u
X4292 sg13cmos5l_Corner_1.vss sg13cmos5l_IOPadAnalog_9.padres dantenna l=3.1u w=0.64u
M4293 adc8b_0.side_cap8b_0.buf_32_0.z adc8b_0.side_cap8b_0.in_l_sw[0] sg13cmos5l_Corner_1.vss sg13cmos5l_Corner_1.vss sg13_lv_nmos ad=95f pd=0.88u as=95f ps=0.88u w=0.5u l=0.13u
M4294 sg13cmos5l_Corner_1.vss adc8b_0.sar12b_0.sg13cmos5l_buf_8_0.A a_100995_95814# sg13cmos5l_Corner_1.vss sg13_lv_nmos ad=0.1406p pd=1.12u as=0.2553p ps=2.17u w=0.74u l=0.13u
M4295 vdd sg13cmos5l_IOPadVdd$1_0.sg13cmos5l_RCClampInverter$1_0.in sg13cmos5l_IOPadVdd$1_0.sg13cmos5l_Clamp_N43N43D4R$1_0.gate vdd sg13_hv_pmos ad=1.33p pd=7.38u as=1.33p ps=7.38u w=7u l=0.5u
M4296 sg13cmos5l_Corner_1.vss adc8b_0.side_cap8b_0.in_l_sw[0] adc8b_0.side_cap8b_0.buf_32_0.z sg13cmos5l_Corner_1.vss sg13_lv_nmos ad=95f pd=0.88u as=95f ps=0.88u w=0.5u l=0.13u
M4297 a_88497_96201# a_88140_96128# vdd vdd sg13_lv_pmos ad=63f pd=0.72u as=0.1563p ps=1.22u w=0.42u l=0.13u
M4298 vdd adc8b_0.sar12b_0.sg13cmos5l_inv_1_2.A adc8b_0.sar12b_0.sg13cmos5l_dfrbp_1_0.CLK vdd sg13_lv_pmos ad=0.3808p pd=2.92u as=0.3808p ps=2.92u w=1.12u l=0.13u
M4299 sg13cmos5l_Corner_1.vss a_100131_95430# adc8b_0.sar12b_0.sg13cmos5l_or2_1_0.A sg13cmos5l_Corner_1.vss sg13_lv_nmos ad=0.1406p pd=1.12u as=0.1406p ps=1.12u w=0.74u l=0.13u
M4300 sg13cmos5l_Corner_1.vss a_93592_99054# a_93241_98911# sg13cmos5l_Corner_1.vss sg13_lv_nmos ad=79.8f pd=0.8u as=0.1428p ps=1.52u w=0.42u l=0.13u
M4301 sg13cmos5l_Corner_1.vss adc8b_0.sar12b_0.sg13cmos5l_dlhr_1_15.D a_99313_98888# sg13cmos5l_Corner_1.vss sg13_lv_nmos ad=0.15055p pd=1.17u as=0.187p ps=1.78u w=0.55u l=0.13u
M4302 vdd a_88823_95421# a_89080_95302# vdd sg13_lv_pmos ad=0.2639p pd=1.81u as=79.8f ps=0.8u w=0.42u l=0.13u
X4303 sg13cmos5l_Corner_1.vss a_176786_70222# dantenna l=27.78u w=1.26u
M4304 vddr adc8b_0.side_cap8b_0.in_l_sw[1] adc8b_0.side_cap8b_0.buf_16_2.z vddr sg13_lv_pmos ad=0.19p pd=1.38u as=0.19p ps=1.38u w=1u l=0.13u
M4305 a_92493_98813# adc8b_0.sar12b_0.sg13cmos5l_dlhr_1_11.GATE sg13cmos5l_Corner_1.vss sg13cmos5l_Corner_1.vss sg13_lv_nmos ad=0.2516p pd=2.16u as=1.49685p ps=9.6u w=0.74u l=0.13u
M4306 a_94335_98442# adc8b_0.sar12b_0.sg13cmos5l_dlhr_1_11.GATE vdd vdd sg13_lv_pmos ad=0.3234p pd=2.45u as=1.07253p ps=6.75u w=0.84u l=0.13u
M4307 sg13cmos5l_Corner_1.iovdd a_70044_42476# data[0] sg13cmos5l_Corner_1.iovdd sg13_hv_pmos ad=2.1312p pd=7.3u as=3.9294p ps=7.84u w=6.66u l=0.6u
M4308 vddr adc8b_0.side_cap8b_0.in_h_sw[2] adc8b_0.side_cap8b_0.buf_16_0.z vddr sg13_lv_pmos ad=0.19p pd=1.38u as=0.34p ps=2.68u w=1u l=0.13u
M4309 sg13cmos5l_Corner_1.vss vdd sg13cmos5l_Corner_1.vss sg13cmos5l_Corner_1.vss sg13_lv_nmos ad=0.1428p pd=1.52u as=0 ps=0 w=0.42u l=1u
M4310 a_89017_94290# a_88465_94352# sg13cmos5l_Corner_1.vss sg13cmos5l_Corner_1.vss sg13_lv_nmos ad=71.99999f pd=0.865u as=2.59257p ps=16.445u w=0.64u l=0.13u
M4311 sg13cmos5l_Corner_1.iovdd a_42476_118044# cks sg13cmos5l_Corner_1.iovdd sg13_hv_pmos ad=3.1302p pd=14.26u as=3.9294p ps=7.84u w=6.66u l=0.6u
M4312 adc8b_0.side_cap8b_1.buf_8_2.z adc8b_0.sar12b_0.nh_sw[4] vddr vddr sg13_lv_pmos ad=0.19p pd=1.38u as=0.19p ps=1.38u w=1u l=0.13u
M4313 sg13cmos5l_Corner_1.vss adc8b_0.sar12b_0.nl_sw[0] adc8b_0.side_cap8b_1.buf_32_0.z sg13cmos5l_Corner_1.vss sg13_lv_nmos ad=95f pd=0.88u as=95f ps=0.88u w=0.5u l=0.13u
M4314 vddr adc8b_0.side_cap8b_0.in_l_sw[0] adc8b_0.side_cap8b_0.buf_32_0.z vddr sg13_lv_pmos ad=0.19p pd=1.38u as=0.19p ps=1.38u w=1u l=0.13u
M4315 a_98319_95147# a_98471_95031# vdd vdd sg13_lv_pmos ad=0.3864p pd=2.93u as=1.43437p ps=9.105u w=1.12u l=0.13u
M4316 sg13cmos5l_IOPadAnalog_1.pad a_164624_70044# sg13cmos5l_Corner_1.iovdd sg13cmos5l_Corner_1.iovdd sg13_hv_pmos ad=3.9294p pd=7.84u as=2.1312p ps=7.3u w=6.66u l=0.6u
M4317 vddr adc8b_0.sar12b_0.nh_sw[0] adc8b_0.side_cap8b_1.buf_32_1.z vddr sg13_lv_pmos ad=0.19p pd=1.38u as=0.19p ps=1.38u w=1u l=0.13u
M4318 a_90932_92750# adc8b_0.sar12b_0.sg13cmos5l_buf_1_26.A vdd vdd sg13_lv_pmos ad=0.2856p pd=2.36u as=0.2114p ps=1.54u w=0.84u l=0.13u
M4319 vdd a_99885_94277# a_99987_94420# vdd sg13_lv_pmos ad=1.43437p pd=9.105u as=0.3864p ps=2.93u w=1.12u l=0.13u
M4320 sg13cmos5l_Corner_1.vss adc8b_0.sar12b_0.sg13cmos5l_dfrbp_1_20.Q_N a_91441_100400# sg13cmos5l_Corner_1.vss sg13_lv_nmos ad=0.15055p pd=1.17u as=0.187p ps=1.78u w=0.55u l=0.13u
M4321 a_82450_98052# a_82893_98095# a_82833_98131# vdd sg13_lv_pmos ad=79.8f pd=0.8u as=63f ps=0.72u w=0.42u l=0.13u
M4322 sg13cmos5l_Corner_1.vss a_102044_30676# data[2] sg13cmos5l_Corner_1.vss sg13_hv_nmos ad=1.408p pd=5.04u as=2.596p ps=5.58u w=4.4u l=0.6u
M4323 sg13cmos5l_IOPadAnalog_16.pad a_164624_102044# sg13cmos5l_Corner_1.iovdd sg13cmos5l_Corner_1.iovdd sg13_hv_pmos ad=3.9294p pd=7.84u as=2.1312p ps=7.3u w=6.66u l=0.6u
M4324 vdd sg13cmos5l_IOPadVdd$1_0.sg13cmos5l_Clamp_N43N43D4R$1_0.gate sg13cmos5l_Corner_1.vss sg13cmos5l_Corner_1.vss sg13_hv_nmos ad=2.596p pd=5.58u as=1.408p ps=5.04u w=4.4u l=0.6u
M4325 a_93592_99054# a_93335_98911# a_93754_98834# sg13cmos5l_Corner_1.vss sg13_lv_nmos ad=0.1428p pd=1.52u as=37.8f ps=0.6u w=0.42u l=0.13u
M4326 sg13cmos5l_Corner_1.vss adc8b_0.sar12b_0.nh_sw[3] adc8b_0.side_cap8b_1.buf_8_3.z sg13cmos5l_Corner_1.vss sg13_lv_nmos ad=95f pd=0.88u as=95f ps=0.88u w=0.5u l=0.13u
M4327 data[1] a_86044_42476# sg13cmos5l_Corner_1.iovdd sg13cmos5l_Corner_1.iovdd sg13_hv_pmos ad=3.9294p pd=7.84u as=2.1312p ps=7.3u w=6.66u l=0.6u
M4328 a_92475_93548# adc8b_0.sar12b_0.sg13cmos5l_nor2_1_0.A vdd vdd sg13_lv_pmos ad=0.1428p pd=1.375u as=0.2891p ps=1.695u w=1.12u l=0.13u
M4329 sg13cmos5l_IOPadAnalog_10.pad a_67639_178370# sg13cmos5l_Corner_1.vss sg13cmos5l_Corner_1.vss sg13_hv_nmos ad=2.596p pd=5.58u as=1.408p ps=5.04u w=4.4u l=0.6u
M4330 vdd sg13cmos5l_IOPadVdd$1_0.sg13cmos5l_Clamp_N43N43D4R$1_0.gate sg13cmos5l_Corner_1.vss sg13cmos5l_Corner_1.vss sg13_hv_nmos ad=2.596p pd=5.58u as=1.408p ps=5.04u w=4.4u l=0.6u
M4331 adc8b_0.side_cap8b_0.buf_8_0.z adc8b_0.side_cap8b_0.in_l_sw[4] vddr vddr sg13_lv_pmos ad=0.19p pd=1.38u as=0.19p ps=1.38u w=1u l=0.13u
M4332 vdd adc8b_0.sar12b_0.sg13cmos5l_dfrbp_1_8.RESET_B a_85330_96033# vdd sg13_lv_pmos ad=0.1563p pd=1.22u as=0.147p ps=1.54u w=0.42u l=0.13u
M4333 adc8b_0.sar12b_0.sg13cmos5l_dfrbp_1_5.Q_N a_98519_93909# sg13cmos5l_Corner_1.vss sg13cmos5l_Corner_1.vss sg13_lv_nmos ad=0.2849p pd=2.25u as=0.2516p ps=2.16u w=0.74u l=0.13u
M4334 sg13cmos5l_IOPadAnalog_9.pad a_83639_178370# sg13cmos5l_Corner_1.vss sg13cmos5l_Corner_1.vss sg13_hv_nmos ad=2.596p pd=5.58u as=1.408p ps=5.04u w=4.4u l=0.6u
M4335 sg13cmos5l_Corner_1.vss adc8b_0.sar12b_0.sg13cmos5l_dfrbp_1_0.RESET_B a_99276_94298# sg13cmos5l_Corner_1.vss sg13_lv_nmos ad=0.1626p pd=1.415u as=60.89999f ps=0.71u w=0.42u l=0.13u
M4336 vdd sg13cmos5l_IOPadVdd$1_0.sg13cmos5l_Clamp_N43N43D4R$1_0.gate sg13cmos5l_Corner_1.vss sg13cmos5l_Corner_1.vss sg13_hv_nmos ad=2.596p pd=5.58u as=1.408p ps=5.04u w=4.4u l=0.6u
M4337 adc8b_0.side_cap8b_0.buf_8_3.z adc8b_0.side_cap8b_0.in_h_sw[3] sg13cmos5l_Corner_1.vss sg13cmos5l_Corner_1.vss sg13_lv_nmos ad=95f pd=0.88u as=95f ps=0.88u w=0.5u l=0.13u
M4338 a_90015_96930# adc8b_0.sar12b_0.sg13cmos5l_dfrbp_1_11.Q vdd vdd sg13_lv_pmos ad=0.3234p pd=2.45u as=1.2517p ps=7.955u w=0.84u l=0.13u
M4339 sg13cmos5l_Corner_1.iovdd a_164624_86044# sg13cmos5l_IOPadAnalog_0.pad sg13cmos5l_Corner_1.iovdd sg13_hv_pmos ad=2.1312p pd=7.3u as=3.9294p ps=7.84u w=6.66u l=0.6u
M4340 sg13cmos5l_Corner_1.vss adc8b_0.sar12b_0.nl_sw[0] adc8b_0.side_cap8b_1.buf_32_0.z sg13cmos5l_Corner_1.vss sg13_lv_nmos ad=95f pd=0.88u as=95f ps=0.88u w=0.5u l=0.13u
M4341 a_86988_93552# a_86962_93516# sg13cmos5l_Corner_1.vss sg13cmos5l_Corner_1.vss sg13_lv_nmos ad=0.2516p pd=2.16u as=0.1626p ps=1.415u w=0.74u l=0.13u
M4342 adc8b_0.sar12b_0.sg13cmos5l_inv_1_5.A a_101564_94596# vdd vdd sg13_lv_pmos ad=0.3808p pd=2.92u as=0.2128p ps=1.5u w=1.12u l=0.13u
M4343 sg13cmos5l_Corner_1.vss a_115639_178370# sg13cmos5l_IOPadAnalog_13.pad sg13cmos5l_Corner_1.vss sg13_hv_nmos ad=1.408p pd=5.04u as=2.596p ps=5.58u w=4.4u l=0.6u
M4344 adc8b_0.side_cap8b_1.buf_8_3.z adc8b_0.sar12b_0.nh_sw[3] vddr vddr sg13_lv_pmos ad=0.19p pd=1.38u as=0.19p ps=1.38u w=1u l=0.13u
M4345 a_92840_96507# adc8b_0.sar12b_0.sg13cmos5l_nor2_1_0.A vdd vdd sg13_lv_pmos ad=0.2856p pd=2.36u as=0.1596p ps=1.22u w=0.84u l=0.13u
M4346 vdd sg13cmos5l_IOPadVdd$1_0.sg13cmos5l_RCClampInverter$1_0.in sg13cmos5l_IOPadVdd$1_0.sg13cmos5l_Clamp_N43N43D4R$1_0.gate vdd sg13_hv_pmos ad=1.33p pd=7.38u as=1.33p ps=7.38u w=7u l=0.5u
M4347 sg13cmos5l_Corner_1.vss adc8b_0.side_cap8b_0.in_h_sw[0] adc8b_0.side_cap8b_0.buf_32_1.z sg13cmos5l_Corner_1.vss sg13_lv_nmos ad=95f pd=0.88u as=95f ps=0.88u w=0.5u l=0.13u
M4348 vdd cks adc8b_0.sar12b_0.sg13cmos5l_dfrbp_1_6.RESET_B vdd sg13_lv_pmos ad=0.2128p pd=1.5u as=0.2128p ps=1.5u w=1.12u l=0.13u
M4349 sg13cmos5l_Corner_1.vss a_178296_70044# sg13cmos5l_IOPadAnalog_1.pad sg13cmos5l_Corner_1.vss sg13_hv_nmos ad=1.408p pd=5.04u as=2.596p ps=5.58u w=4.4u l=0.6u
M4350 adc8b_0.side_cap8b_0.buf_2_1.z adc8b_0.side_cap8b_0.in_l_sw[8] sg13cmos5l_Corner_1.vss sg13cmos5l_Corner_1.vss sg13_lv_nmos ad=0.17p pd=1.68u as=95f ps=0.88u w=0.5u l=0.13u
M4351 a_102260_99560# adc8b_0.sar12b_0.sg13cmos5l_buf_1_104.X sg13cmos5l_Corner_1.vss sg13cmos5l_Corner_1.vss sg13_lv_nmos ad=0.187p pd=1.78u as=0.14875p ps=1.16u w=0.55u l=0.13u
M4352 a_88666_93986# adc8b_0.sar12b_0.sg13cmos5l_dfrbp_1_6.RESET_B sg13cmos5l_Corner_1.vss sg13cmos5l_Corner_1.vss sg13_lv_nmos ad=37.8f pd=0.6u as=79.8f ps=0.8u w=0.42u l=0.13u
M4353 sg13cmos5l_Corner_1.vss a_96945_96929# a_96900_96974# sg13cmos5l_Corner_1.vss sg13_lv_nmos ad=0.1428p pd=1.52u as=47.25f ps=0.645u w=0.42u l=0.13u
M4354 vdd sg13cmos5l_Corner_1.vss vdd vdd sg13_lv_pmos ad=0.34p pd=2.68u as=0 ps=0 w=1u l=1u
M4355 vddr adc8b_0.side_cap8b_0.in_h_sw[0] adc8b_0.side_cap8b_0.buf_32_1.z vddr sg13_lv_pmos ad=0.19p pd=1.38u as=0.19p ps=1.38u w=1u l=0.13u
M4356 vdd adc8b_0.sar12b_0.sg13cmos5l_buf_1_76.X a_87184_100384# vdd sg13_lv_pmos ad=0.2114p pd=1.54u as=0.2856p ps=2.36u w=0.84u l=0.13u
M4357 sg13cmos5l_Corner_1.vss adc8b_0.sar12b_0.sg13cmos5l_buf_1_111.A a_100144_100384# sg13cmos5l_Corner_1.vss sg13_lv_nmos ad=0.14875p pd=1.16u as=0.187p ps=1.78u w=0.55u l=0.13u
M4358 sg13cmos5l_Corner_1.iovdd a_42476_102044# vip sg13cmos5l_Corner_1.iovdd sg13_hv_pmos ad=2.1312p pd=7.3u as=3.9294p ps=7.84u w=6.66u l=0.6u
X4359 sg13cmos5l_Corner_1.vss a_176786_118222# dantenna l=27.78u w=1.26u
M4360 sg13cmos5l_Corner_1.vss adc8b_0.sar12b_0.nh_sw[0] adc8b_0.side_cap8b_1.buf_32_1.z sg13cmos5l_Corner_1.vss sg13_lv_nmos ad=95f pd=0.88u as=95f ps=0.88u w=0.5u l=0.13u
M4361 adc8b_0.side_cap8b_0.in_l_sw[2] a_84016_100384# vdd vdd sg13_lv_pmos ad=0.42p pd=2.99u as=0.2114p ps=1.54u w=1.12u l=0.13u
M4362 a_88727_97399# a_87885_97301# a_88633_97399# sg13cmos5l_Corner_1.vss sg13_lv_nmos ad=0.12665p pd=1.145u as=0.1428p ps=1.52u w=0.42u l=0.13u
M4363 adc8b_0.side_cap8b_1.buf_4_3.z adc8b_0.sar12b_0.nl_sw[6] vddr vddr sg13_lv_pmos ad=0.34p pd=2.68u as=0.19p ps=1.38u w=1u l=0.13u
M4364 sg13cmos5l_Corner_1.iovdd a_99639_164698# sg13cmos5l_IOPadAnalog_15.pad sg13cmos5l_Corner_1.iovdd sg13_hv_pmos ad=2.1312p pd=7.3u as=3.9294p ps=7.84u w=6.66u l=0.6u
X4365 cks sg13cmos5l_Corner_1.iovdd dpantenna l=27.78u w=1.26u
M4366 a_93612_92799# a_93324_93104# a_93550_92799# sg13cmos5l_Corner_1.vss sg13_lv_nmos ad=0.1428p pd=1.52u as=37.8f ps=0.6u w=0.42u l=0.13u
M4367 a_92099_93084# adc8b_0.sar12b_0.sg13cmos5l_nor2b_1_0.Y vdd vdd sg13_lv_pmos ad=0.3808p pd=2.92u as=0.2128p ps=1.5u w=1.12u l=0.13u
M4368 sg13cmos5l_Corner_1.vss adc8b_0.side_cap8b_0.in_h_sw[4] adc8b_0.side_cap8b_0.buf_8_2.z sg13cmos5l_Corner_1.vss sg13_lv_nmos ad=95f pd=0.88u as=0.17p ps=1.68u w=0.5u l=0.13u
M4369 a_87442_97545# a_87885_97301# a_87825_97713# vdd sg13_lv_pmos ad=79.8f pd=0.8u as=63f ps=0.72u w=0.42u l=0.13u
M4370 sg13cmos5l_Corner_1.vss adc8b_0.sar12b_0.sg13cmos5l_a221oi_1_0.B2 a_93256_95836# sg13cmos5l_Corner_1.vss sg13_lv_nmos ad=0.1406p pd=1.12u as=0.1406p ps=1.12u w=0.74u l=0.13u
M4371 vdd adc8b_0.sar12b_0.sg13cmos5l_inv_1_8.A a_84647_97592# vdd sg13_lv_pmos ad=1.07253p pd=6.75u as=0.4088p ps=2.97u w=1.12u l=0.13u
M4372 data[0] a_102160_93548# sg13cmos5l_Corner_1.vss sg13cmos5l_Corner_1.vss sg13_lv_nmos ad=0.2886p pd=2.26u as=0.14875p ps=1.16u w=0.74u l=0.13u
M4373 a_98776_93790# a_98519_93909# a_98938_93986# sg13cmos5l_Corner_1.vss sg13_lv_nmos ad=0.1428p pd=1.52u as=37.8f ps=0.6u w=0.42u l=0.13u
M4374 sg13cmos5l_IOPadAnalog_12.pad a_131639_164698# sg13cmos5l_Corner_1.iovdd sg13cmos5l_Corner_1.iovdd sg13_hv_pmos ad=3.9294p pd=7.84u as=2.1312p ps=7.3u w=6.66u l=0.6u
M4375 a_86900_100310# adc8b_0.sar12b_0.sg13cmos5l_buf_1_44.X sg13cmos5l_Corner_1.vss sg13cmos5l_Corner_1.vss sg13_lv_nmos ad=0.187p pd=1.78u as=0.14875p ps=1.16u w=0.55u l=0.13u
X4376 vin sg13cmos5l_IOPadAnalog_4.padres sg13cmos5l_Corner_1.vss rppd l=2u w=1u
M4377 vdd adc8b_0.sar12b_0.sg13cmos5l_buf_8_2.X a_101776_98872# vdd sg13_lv_pmos ad=0.2114p pd=1.54u as=0.2856p ps=2.36u w=0.84u l=0.13u
M4378 sg13cmos5l_IOPadAnalog_1.pad a_178296_70044# sg13cmos5l_Corner_1.vss sg13cmos5l_Corner_1.vss sg13_hv_nmos ad=2.596p pd=5.58u as=1.408p ps=5.04u w=4.4u l=0.6u
M4379 data[1] a_86044_42476# sg13cmos5l_Corner_1.iovdd sg13cmos5l_Corner_1.iovdd sg13_hv_pmos ad=3.9294p pd=7.84u as=2.1312p ps=7.3u w=6.66u l=0.6u
M4380 sg13cmos5l_Corner_1.iovdd a_164624_86044# sg13cmos5l_IOPadAnalog_0.pad sg13cmos5l_Corner_1.iovdd sg13_hv_pmos ad=2.1312p pd=7.3u as=3.9294p ps=7.84u w=6.66u l=0.6u
M4381 sg13cmos5l_Corner_1.vss adc8b_0.sar12b_0.sg13cmos5l_buf_1_3.A a_102064_92824# sg13cmos5l_Corner_1.vss sg13_lv_nmos ad=0.14875p pd=1.16u as=0.187p ps=1.78u w=0.55u l=0.13u
X4382 sg13cmos5l_Corner_1.vss a_33862_118222# dantenna l=27.78u w=1.26u
M4383 a_90844_96960# a_90428_96572# a_90609_96929# sg13cmos5l_Corner_1.vss sg13_lv_nmos ad=77.7f pd=0.95u as=0.2516p ps=2.16u w=0.74u l=0.13u
M4384 sg13cmos5l_Corner_1.vss a_88823_95421# a_89660_95060# sg13cmos5l_Corner_1.vss sg13_lv_nmos ad=0.1406p pd=1.12u as=0.2516p ps=2.16u w=0.74u l=0.13u
M4385 adc8b_0.side_cap8b_1.buf_4_2.z adc8b_0.sar12b_0.nh_sw[7] sg13cmos5l_Corner_1.vss sg13cmos5l_Corner_1.vss sg13_lv_nmos ad=95f pd=0.88u as=95f ps=0.88u w=0.5u l=0.13u
M4386 vdd sg13cmos5l_IOPadVdd$1_0.sg13cmos5l_RCClampInverter$1_0.in sg13cmos5l_IOPadVdd$1_0.sg13cmos5l_Clamp_N43N43D4R$1_0.gate vdd sg13_hv_pmos ad=1.33p pd=7.38u as=1.33p ps=7.38u w=7u l=0.5u
M4387 sg13cmos5l_Corner_1.vss a_134044_30676# frame sg13cmos5l_Corner_1.vss sg13_hv_nmos ad=1.408p pd=5.04u as=2.596p ps=5.58u w=4.4u l=0.6u
M4388 sg13cmos5l_Corner_1.iovdd a_42476_70044# vddr sg13cmos5l_Corner_1.iovdd sg13_hv_pmos ad=2.1312p pd=7.3u as=3.9294p ps=7.84u w=6.66u l=0.6u
M4389 sg13cmos5l_Corner_1.vss adc8b_0.side_cap8b_0.in_l_sw[1] adc8b_0.side_cap8b_0.buf_16_2.z sg13cmos5l_Corner_1.vss sg13_lv_nmos ad=95f pd=0.88u as=95f ps=0.88u w=0.5u l=0.13u
M4390 vdd cks adc8b_0.sar12b_0.sg13cmos5l_dfrbp_1_6.RESET_B vdd sg13_lv_pmos ad=0.2128p pd=1.5u as=0.2128p ps=1.5u w=1.12u l=0.13u
M4391 a_85356_96128# a_85330_96033# sg13cmos5l_Corner_1.vss sg13cmos5l_Corner_1.vss sg13_lv_nmos ad=0.2516p pd=2.16u as=0.1626p ps=1.415u w=0.74u l=0.13u
M4392 a_83916_95064# a_84435_95071# a_85175_95421# sg13cmos5l_Corner_1.vss sg13_lv_nmos ad=0.3473p pd=2.71u as=0.12665p ps=1.145u w=0.74u l=0.13u
M4393 vdd adc8b_0.sar12b_0.sg13cmos5l_buf_1_10.A a_94288_94336# vdd sg13_lv_pmos ad=0.2114p pd=1.54u as=0.2856p ps=2.36u w=0.84u l=0.13u
M4394 vddr adc8b_0.side_cap8b_0.in_l_sw[7] adc8b_0.side_cap8b_0.buf_4_0.z vddr sg13_lv_pmos ad=0.19p pd=1.38u as=0.19p ps=1.38u w=1u l=0.13u
M4395 vdd adc8b_0.sar12b_0.sg13cmos5l_buf_1_78.A a_87952_100384# vdd sg13_lv_pmos ad=0.2114p pd=1.54u as=0.2856p ps=2.36u w=0.84u l=0.13u
M4396 a_91292_96132# a_90879_95826# a_91224_96132# vdd sg13_lv_pmos ad=0.191p pd=1.44u as=0.105p ps=1.21u w=1u l=0.13u
M4397 a_97358_95810# adc8b_0.sar12b_0.sg13cmos5l_dfrbp_1_8.D vdd vdd sg13_lv_pmos ad=79.8f pd=0.8u as=0.1428p ps=1.52u w=0.42u l=0.13u
M4398 cko a_118044_42476# sg13cmos5l_Corner_1.iovdd sg13cmos5l_Corner_1.iovdd sg13_hv_pmos ad=3.9294p pd=7.84u as=2.1312p ps=7.3u w=6.66u l=0.6u
M4399 sg13cmos5l_Corner_1.vss adc8b_0.sar12b_0.sg13cmos5l_buf_1_19.A a_100528_93548# sg13cmos5l_Corner_1.vss sg13_lv_nmos ad=0.14875p pd=1.16u as=0.187p ps=1.78u w=0.55u l=0.13u
M4400 sg13cmos5l_Corner_1.vss sg13cmos5l_IOPadVdd$1_0.sg13cmos5l_Clamp_N43N43D4R$1_0.gate vdd sg13cmos5l_Corner_1.vss sg13_hv_nmos ad=1.408p pd=5.04u as=2.596p ps=5.58u w=4.4u l=0.6u
M4401 vdd adc8b_0.sar12b_0.sg13cmos5l_dfrbp_1_11.Q a_88415_96619# vdd sg13_lv_pmos ad=0.1428p pd=1.52u as=79.8f ps=0.8u w=0.42u l=0.13u
X4402 sg13cmos5l_IOPadAnalog_13.pad sg13cmos5l_Corner_1.iovdd dpantenna l=1.26u w=27.78u
M4403 adc8b_0.side_cap8b_0.buf_8_0.z adc8b_0.side_cap8b_0.in_l_sw[4] sg13cmos5l_Corner_1.vss sg13cmos5l_Corner_1.vss sg13_lv_nmos ad=0.17p pd=1.68u as=95f ps=0.88u w=0.5u l=0.13u
M4404 adc8b_0.side_cap8b_1.buf_32_1.z adc8b_0.sar12b_0.nh_sw[0] vddr vddr sg13_lv_pmos ad=0.19p pd=1.38u as=0.19p ps=1.38u w=1u l=0.13u
M4405 cks a_30676_118044# sg13cmos5l_Corner_1.vss sg13cmos5l_Corner_1.vss sg13_hv_nmos ad=2.596p pd=5.58u as=2.068p ps=9.74u w=4.4u l=0.6u
M4406 a_99597_92765# adc8b_0.sar12b_0.sg13cmos5l_dfrbp_1_0.CLK sg13cmos5l_Corner_1.vss sg13cmos5l_Corner_1.vss sg13_lv_nmos ad=0.2516p pd=2.16u as=5.84582p ps=38.34u w=0.74u l=0.13u
M4407 sg13cmos5l_Corner_1.vss a_83639_178370# sg13cmos5l_IOPadAnalog_9.pad sg13cmos5l_Corner_1.vss sg13_hv_nmos ad=1.408p pd=5.04u as=2.596p ps=5.58u w=4.4u l=0.6u
M4408 adc8b_0.side_cap8b_0.buf_8_2.z adc8b_0.side_cap8b_0.in_h_sw[4] vddr vddr sg13_lv_pmos ad=0.19p pd=1.38u as=0.19p ps=1.38u w=1u l=0.13u
X4409 sg13cmos5l_Corner_1.vss a_152182_108462# dantenna l=0.64u w=3.1u
M4410 sg13cmos5l_Corner_1.vss adc8b_0.side_cap8b_0.in_l_sw[10] adc8b_0.side_cap8b_0.buf_1_0.z sg13cmos5l_Corner_1.vss sg13_lv_nmos ad=0.17p pd=1.68u as=0.17p ps=1.68u w=0.5u l=0.13u
M4411 adc8b_0.sar12b_0.sg13cmos5l_dlhr_1_15.Q_N a_100638_98816# vdd vdd sg13_lv_pmos ad=0.3808p pd=2.92u as=0.1974p ps=1.5u w=1.12u l=0.13u
M4412 sg13cmos5l_Corner_1.vss sg13cmos5l_IOPadVdd$1_0.sg13cmos5l_Clamp_N43N43D4R$1_0.gate vdd sg13cmos5l_Corner_1.vss sg13_hv_nmos ad=1.408p pd=5.04u as=2.596p ps=5.58u w=4.4u l=0.6u
M4413 adc8b_0.sar12b_0.sg13cmos5l_buf_1_107.X a_99664_100384# sg13cmos5l_Corner_1.vss sg13cmos5l_Corner_1.vss sg13_lv_nmos ad=0.2886p pd=2.26u as=0.14875p ps=1.16u w=0.74u l=0.13u
M4414 sg13cmos5l_IOPadAnalog_0.pad a_178296_86044# sg13cmos5l_Corner_1.vss sg13cmos5l_Corner_1.vss sg13_hv_nmos ad=2.596p pd=5.58u as=1.408p ps=5.04u w=4.4u l=0.6u
M4415 data[1] a_86044_30676# sg13cmos5l_Corner_1.vss sg13cmos5l_Corner_1.vss sg13_hv_nmos ad=2.596p pd=5.58u as=1.408p ps=5.04u w=4.4u l=0.6u
M4416 adc8b_0.sar12b_0.sg13cmos5l_dfrbp_1_24.Q_N a_95159_100423# sg13cmos5l_Corner_1.vss sg13cmos5l_Corner_1.vss sg13_lv_nmos ad=0.2849p pd=2.25u as=0.2516p ps=2.16u w=0.74u l=0.13u
M4417 adc8b_0.sar12b_0.sg13cmos5l_dfrbp_1_10.Q a_86204_94596# vdd vdd sg13_lv_pmos ad=0.3808p pd=2.92u as=0.2128p ps=1.5u w=1.12u l=0.13u
M4418 sg13cmos5l_Corner_1.vss a_178296_102044# sg13cmos5l_IOPadAnalog_16.pad sg13cmos5l_Corner_1.vss sg13_hv_nmos ad=1.408p pd=5.04u as=2.596p ps=5.58u w=4.4u l=0.6u
M4419 sg13cmos5l_Corner_1.vss a_101780_92750# adc8b_0.sar12b_0.sg13cmos5l_buf_1_0.X sg13cmos5l_Corner_1.vss sg13_lv_nmos ad=0.14875p pd=1.16u as=0.2886p ps=2.26u w=0.74u l=0.13u
M4420 adc8b_0.sar12b_0.sg13cmos5l_dfrbp_1_0.Q_N a_100439_92863# sg13cmos5l_Corner_1.vss sg13cmos5l_Corner_1.vss sg13_lv_nmos ad=0.2849p pd=2.25u as=0.2516p ps=2.16u w=0.74u l=0.13u
M4421 sg13cmos5l_Corner_1.vss adc8b_0.sar12b_0.sg13cmos5l_nor2b_1_0.Y a_92201_92812# sg13cmos5l_Corner_1.vss sg13_lv_nmos ad=0.2516p pd=2.16u as=0.1406p ps=1.12u w=0.74u l=0.13u
M4422 vdd a_94487_93909# a_94744_93790# vdd sg13_lv_pmos ad=0.2639p pd=1.81u as=79.8f ps=0.8u w=0.42u l=0.13u
M4423 sg13cmos5l_Corner_1.vss a_92180_97286# adc8b_0.sar12b_0.sg13cmos5l_buf_1_29.A sg13cmos5l_Corner_1.vss sg13_lv_nmos ad=0.14875p pd=1.16u as=0.2886p ps=2.26u w=0.74u l=0.13u
M4424 a_88044_100021# a_87756_99600# a_87982_100021# sg13cmos5l_Corner_1.vss sg13_lv_nmos ad=0.1428p pd=1.52u as=37.8f ps=0.6u w=0.42u l=0.13u
M4425 vdd a_97655_99957# a_97912_99838# vdd sg13_lv_pmos ad=0.2639p pd=1.81u as=79.8f ps=0.8u w=0.42u l=0.13u
M4426 adc8b_0.sar12b_0.sg13cmos5l_buf_1_19.X a_100528_93548# sg13cmos5l_Corner_1.vss sg13cmos5l_Corner_1.vss sg13_lv_nmos ad=0.2886p pd=2.26u as=0.14875p ps=1.16u w=0.74u l=0.13u
M4427 adc8b_0.sar12b_0.sg13cmos5l_nor2b_1_1.Y adc8b_0.sar12b_0.sg13cmos5l_nor2_1_1.A a_96244_93548# vdd sg13_lv_pmos ad=0.3808p pd=2.92u as=0.1176p ps=1.33u w=1.12u l=0.13u
M4428 adc8b_0.side_cap8b_1.buf_32_1.z adc8b_0.sar12b_0.nh_sw[0] vddr vddr sg13_lv_pmos ad=0.19p pd=1.38u as=0.19p ps=1.38u w=1u l=0.13u
X4429 a_36456_137395# a_40542_137065# sg13cmos5l_Corner_1.vss rppd l=20u w=1u
M4430 a_85342_99010# a_85444_99124# vdd vdd sg13_lv_pmos ad=0.2856p pd=2.36u as=0.1974p ps=1.5u w=0.84u l=0.13u
M4431 a_82292_95774# adc8b_0.sar12b_0.sg13cmos5l_buf_1_43.A vdd vdd sg13_lv_pmos ad=0.2856p pd=2.36u as=0.2114p ps=1.54u w=0.84u l=0.13u
M4432 adc8b_0.sar12b_0.sg13cmos5l_or2_1_0.A a_100131_95430# vdd vdd sg13_lv_pmos ad=0.2128p pd=1.5u as=0.2128p ps=1.5u w=1.12u l=0.13u
M4433 sg13cmos5l_Corner_1.iovdd a_102044_42476# data[2] sg13cmos5l_Corner_1.iovdd sg13_hv_pmos ad=3.1302p pd=14.26u as=3.9294p ps=7.84u w=6.66u l=0.6u
M4434 sg13cmos5l_IOPadAnalog_16.pad a_164624_102044# sg13cmos5l_Corner_1.iovdd sg13cmos5l_Corner_1.iovdd sg13_hv_pmos ad=3.9294p pd=7.84u as=2.1312p ps=7.3u w=6.66u l=0.6u
M4435 vin a_42476_86044# sg13cmos5l_Corner_1.iovdd sg13cmos5l_Corner_1.iovdd sg13_hv_pmos ad=3.9294p pd=7.84u as=2.1312p ps=7.3u w=6.66u l=0.6u
M4436 sg13cmos5l_Corner_1.iovdd a_102044_42476# data[2] sg13cmos5l_Corner_1.iovdd sg13_hv_pmos ad=2.1312p pd=7.3u as=3.9294p ps=7.84u w=6.66u l=0.6u
M4437 sg13cmos5l_Corner_1.iovdd a_67639_164698# sg13cmos5l_IOPadAnalog_10.pad sg13cmos5l_Corner_1.iovdd sg13_hv_pmos ad=2.1312p pd=7.3u as=3.9294p ps=7.84u w=6.66u l=0.6u
M4438 sg13cmos5l_Corner_1.vss adc8b_0.sar12b_0.sg13cmos5l_inv_1_7.A a_94000_99596# sg13cmos5l_Corner_1.vss sg13_lv_nmos ad=0.14875p pd=1.16u as=0.187p ps=1.78u w=0.55u l=0.13u
M4439 sg13cmos5l_Corner_1.vss a_82893_98095# a_82995_98095# sg13cmos5l_Corner_1.vss sg13_lv_nmos ad=1.49685p pd=9.6u as=0.2516p ps=2.16u w=0.74u l=0.13u
M4440 sg13cmos5l_Corner_1.vss a_30676_118044# cks sg13cmos5l_Corner_1.vss sg13_hv_nmos ad=1.408p pd=5.04u as=2.596p ps=5.58u w=4.4u l=0.6u
M4441 vdd adc8b_0.sar12b_0.sg13cmos5l_buf_1_62.X a_83632_100384# vdd sg13_lv_pmos ad=0.2114p pd=1.54u as=0.2856p ps=2.36u w=0.84u l=0.13u
M4442 a_98458_98834# adc8b_0.sar12b_0.sg13cmos5l_dfrbp_1_6.RESET_B sg13cmos5l_Corner_1.vss sg13cmos5l_Corner_1.vss sg13_lv_nmos ad=37.8f pd=0.6u as=79.8f ps=0.8u w=0.42u l=0.13u
M4443 vdd adc8b_0.sar12b_0.sg13cmos5l_dfrbp_1_8.RESET_B a_84148_97322# vdd sg13_lv_pmos ad=1.04815p pd=6.595u as=79.8f ps=0.8u w=0.42u l=0.13u
M4444 sg13cmos5l_Corner_1.vss a_87981_95071# a_88083_95071# sg13cmos5l_Corner_1.vss sg13_lv_nmos ad=2.41737p pd=15.64u as=0.2516p ps=2.16u w=0.74u l=0.13u
M4445 a_87260_94620# a_86978_94308# a_87193_94290# sg13cmos5l_Corner_1.vss sg13_lv_nmos ad=0.141p pd=1.17u as=71.99999f ps=0.865u w=0.64u l=0.13u
M4446 sg13cmos5l_IOPadAnalog_9.pad a_83639_164698# sg13cmos5l_Corner_1.iovdd sg13cmos5l_Corner_1.iovdd sg13_hv_pmos ad=3.9294p pd=7.84u as=2.1312p ps=7.3u w=6.66u l=0.6u
M4447 a_94815_98850# adc8b_0.sar12b_0.sg13cmos5l_dlhr_1_11.GATE vdd vdd sg13_lv_pmos ad=0.3234p pd=2.45u as=1.12242p ps=7u w=0.84u l=0.13u
M4448 a_96409_98486# a_95857_98442# sg13cmos5l_Corner_1.vss sg13cmos5l_Corner_1.vss sg13_lv_nmos ad=71.99999f pd=0.865u as=1.49685p ps=9.6u w=0.64u l=0.13u
M4449 sg13cmos5l_Corner_1.iovdd a_134044_42476# frame sg13cmos5l_Corner_1.iovdd sg13_hv_pmos ad=2.1312p pd=7.3u as=3.9294p ps=7.84u w=6.66u l=0.6u
M4450 sg13cmos5l_Corner_1.vss adc8b_0.sar12b_0.nh_sw[1] adc8b_0.side_cap8b_1.buf_16_3.z sg13cmos5l_Corner_1.vss sg13_lv_nmos ad=95f pd=0.88u as=95f ps=0.88u w=0.5u l=0.13u
M4451 sg13cmos5l_Corner_1.vss sg13cmos5l_IOPadVdd$1_0.sg13cmos5l_Clamp_N43N43D4R$1_0.gate vdd sg13cmos5l_Corner_1.vss sg13_hv_nmos ad=1.408p pd=5.04u as=2.596p ps=5.58u w=4.4u l=0.6u
M4452 adc8b_0.side_cap8b_0.buf_4_3.z adc8b_0.side_cap8b_0.in_l_sw[6] vddr vddr sg13_lv_pmos ad=0.34p pd=2.68u as=0.19p ps=1.38u w=1u l=0.13u
M4453 adc8b_0.sar12b_0.sg13cmos5l_dlhr_1_2.Q a_89265_94298# vdd vdd sg13_lv_pmos ad=0.3808p pd=2.92u as=0.2128p ps=1.5u w=1.12u l=0.13u
M4454 sg13cmos5l_Corner_1.vss a_70044_30676# data[0] sg13cmos5l_Corner_1.vss sg13_hv_nmos ad=1.408p pd=5.04u as=2.596p ps=5.58u w=4.4u l=0.6u
M4455 adc8b_0.side_cap8b_1.buf_32_0.z adc8b_0.sar12b_0.nl_sw[0] sg13cmos5l_Corner_1.vss sg13cmos5l_Corner_1.vss sg13_lv_nmos ad=95f pd=0.88u as=95f ps=0.88u w=0.5u l=0.13u
M4456 vdd a_94844_96536# a_94802_96572# vdd sg13_lv_pmos ad=0.2618p pd=1.63u as=0.1176p ps=1.33u w=1.12u l=0.13u
M4457 a_97234_93516# a_97677_93559# a_97617_93595# vdd sg13_lv_pmos ad=79.8f pd=0.8u as=63f ps=0.72u w=0.42u l=0.13u
M4458 sg13cmos5l_Corner_1.vss a_30676_70044# vddr sg13cmos5l_Corner_1.vss sg13_hv_nmos ad=1.408p pd=5.04u as=2.596p ps=5.58u w=4.4u l=0.6u
M4459 sg13cmos5l_Corner_1.vss adc8b_0.sar12b_0.sg13cmos5l_and3_1_0.C a_95288_95856# sg13cmos5l_Corner_1.vss sg13_lv_nmos ad=0.1371p pd=1.12u as=0.1216p ps=1.02u w=0.64u l=0.13u
M4460 vdd adc8b_0.sar12b_0.sg13cmos5l_dfrbp_1_0.RESET_B a_95026_94521# vdd sg13_lv_pmos ad=0.1563p pd=1.22u as=0.147p ps=1.54u w=0.42u l=0.13u
M4461 adc8b_0.sar12b_0.nh_sw[10] a_102160_94336# sg13cmos5l_Corner_1.vss sg13cmos5l_Corner_1.vss sg13_lv_nmos ad=0.2886p pd=2.26u as=0.14875p ps=1.16u w=0.74u l=0.13u
M4462 sg13cmos5l_Corner_1.iovdd a_131639_164698# sg13cmos5l_IOPadAnalog_12.pad sg13cmos5l_Corner_1.iovdd sg13_hv_pmos ad=2.1312p pd=7.3u as=3.9294p ps=7.84u w=6.66u l=0.6u
M4463 adc8b_0.side_cap8b_0.buf_32_1.z adc8b_0.side_cap8b_0.in_h_sw[0] sg13cmos5l_Corner_1.vss sg13cmos5l_Corner_1.vss sg13_lv_nmos ad=95f pd=0.88u as=95f ps=0.88u w=0.5u l=0.13u
M4464 sg13cmos5l_Corner_1.vss adc8b_0.side_cap8b_0.in_l_sw[2] adc8b_0.side_cap8b_0.buf_16_1.z sg13cmos5l_Corner_1.vss sg13_lv_nmos ad=95f pd=0.88u as=0.17p ps=1.68u w=0.5u l=0.13u
M4465 vdd a_102260_99560# adc8b_0.side_cap8b_0.in_l_sw[10] vdd sg13_lv_pmos ad=0.2114p pd=1.54u as=0.42p ps=2.99u w=1.12u l=0.13u
M4466 sg13cmos5l_Corner_1.vss a_84333_95071# a_84435_95071# sg13cmos5l_Corner_1.vss sg13_lv_nmos ad=2.41737p pd=15.64u as=0.2516p ps=2.16u w=0.74u l=0.13u
M4467 data[1] a_101776_95060# vdd vdd sg13_lv_pmos ad=0.42p pd=2.99u as=0.2114p ps=1.54u w=1.12u l=0.13u
M4468 vdd sg13cmos5l_IOPadVdd$1_0.sg13cmos5l_RCClampInverter$1_0.in sg13cmos5l_IOPadVdd$1_0.sg13cmos5l_Clamp_N43N43D4R$1_0.gate vdd sg13_hv_pmos ad=1.33p pd=7.38u as=1.33p ps=7.38u w=7u l=0.5u
M4469 a_92476_100332# a_92060_100668# a_92241_100346# sg13cmos5l_Corner_1.vss sg13_lv_nmos ad=77.7f pd=0.95u as=0.2516p ps=2.16u w=0.74u l=0.13u
M4470 sg13cmos5l_IOPadAnalog_11.pad a_164624_118044# sg13cmos5l_Corner_1.iovdd sg13cmos5l_Corner_1.iovdd sg13_hv_pmos ad=3.9294p pd=7.84u as=2.1312p ps=7.3u w=6.66u l=0.6u
X4471 sg13cmos5l_IOPadAnalog_9.pad sg13cmos5l_Corner_1.iovdd dpantenna l=1.26u w=27.78u
M4472 adc8b_0.side_cap8b_0.buf_32_1.z adc8b_0.side_cap8b_0.in_h_sw[0] vddr vddr sg13_lv_pmos ad=0.19p pd=1.38u as=0.19p ps=1.38u w=1u l=0.13u
M4473 sg13cmos5l_Corner_1.vss adc8b_0.side_cap8b_0.in_h_sw[2] adc8b_0.side_cap8b_0.buf_16_0.z sg13cmos5l_Corner_1.vss sg13_lv_nmos ad=95f pd=0.88u as=95f ps=0.88u w=0.5u l=0.13u
M4474 vdd a_86900_100310# adc8b_0.sar12b_0.sg13cmos5l_buf_1_64.A vdd sg13_lv_pmos ad=0.2114p pd=1.54u as=0.42p ps=2.99u w=1.12u l=0.13u
M4475 data[1] a_86044_42476# sg13cmos5l_Corner_1.iovdd sg13cmos5l_Corner_1.iovdd sg13_hv_pmos ad=3.9294p pd=7.84u as=2.1312p ps=7.3u w=6.66u l=0.6u
X4476 cko sg13cmos5l_Corner_1.iovdd dpantenna l=1.26u w=27.78u
M4477 adc8b_0.side_cap8b_1.buf_32_1.z adc8b_0.sar12b_0.nh_sw[0] sg13cmos5l_Corner_1.vss sg13cmos5l_Corner_1.vss sg13_lv_nmos ad=95f pd=0.88u as=95f ps=0.88u w=0.5u l=0.13u
M4478 vdd sg13cmos5l_IOPadVdd$1_0.sg13cmos5l_Clamp_N43N43D4R$1_0.gate sg13cmos5l_Corner_1.vss sg13cmos5l_Corner_1.vss sg13_hv_nmos ad=2.596p pd=5.58u as=1.408p ps=5.04u w=4.4u l=0.6u
M4479 a_94284_97640# a_94258_97545# vdd vdd sg13_lv_pmos ad=0.34p pd=2.68u as=0.36237p ps=2.605u w=1u l=0.13u
M4480 adc8b_0.side_cap8b_0.buf_8_1.z adc8b_0.side_cap8b_0.in_l_sw[3] sg13cmos5l_Corner_1.vss sg13cmos5l_Corner_1.vss sg13_lv_nmos ad=95f pd=0.88u as=95f ps=0.88u w=0.5u l=0.13u
M4481 vddr adc8b_0.side_cap8b_0.in_h_sw[7] adc8b_0.side_cap8b_0.buf_4_2.z vddr sg13_lv_pmos ad=0.19p pd=1.38u as=0.19p ps=1.38u w=1u l=0.13u
M4482 adc8b_0.sar12b_0.sg13cmos5l_or2_1_0.A a_100131_95430# vdd vdd sg13_lv_pmos ad=0.2128p pd=1.5u as=0.2128p ps=1.5u w=1.12u l=0.13u
M4483 sg13cmos5l_IOPadAnalog_12.pad a_131639_164698# sg13cmos5l_Corner_1.iovdd sg13cmos5l_Corner_1.iovdd sg13_hv_pmos ad=3.9294p pd=7.84u as=2.1312p ps=7.3u w=6.66u l=0.6u
X4484 a_102044_30676# sg13cmos5l_Corner_1.vss sg13cmos5l_Corner_1.vss rppd l=3.54u w=0.5u
M4485 sg13cmos5l_Corner_1.vss a_30676_102044# vip sg13cmos5l_Corner_1.vss sg13_hv_nmos ad=1.408p pd=5.04u as=2.596p ps=5.58u w=4.4u l=0.6u
M4486 vip a_42476_102044# sg13cmos5l_Corner_1.iovdd sg13cmos5l_Corner_1.iovdd sg13_hv_pmos ad=3.9294p pd=7.84u as=2.1312p ps=7.3u w=6.66u l=0.6u
M4487 sg13cmos5l_Corner_1.vss adc8b_0.cmp_0.clk a_74586_95659# sg13cmos5l_Corner_1.vss sg13_lv_nmos ad=95f pd=0.88u as=95f ps=0.88u w=0.5u l=0.13u
X4488 sg13cmos5l_IOPadAnalog_3.padres sg13cmos5l_Corner_1.iovdd dpantenna l=0.64u w=4.98u
M4489 sg13cmos5l_Corner_1.vss adc8b_0.side_cap8b_0.in_l_sw[0] adc8b_0.side_cap8b_0.buf_32_0.z sg13cmos5l_Corner_1.vss sg13_lv_nmos ad=95f pd=0.88u as=95f ps=0.88u w=0.5u l=0.13u
M4490 adc8b_0.side_cap8b_0.in_l_sw[4] a_87568_100384# sg13cmos5l_Corner_1.vss sg13cmos5l_Corner_1.vss sg13_lv_nmos ad=0.2886p pd=2.26u as=0.14875p ps=1.16u w=0.74u l=0.13u
M4491 a_88247_93909# a_87405_93559# a_88153_93909# sg13cmos5l_Corner_1.vss sg13_lv_nmos ad=0.12665p pd=1.145u as=0.1428p ps=1.52u w=0.42u l=0.13u
M4492 a_98061_95789# adc8b_0.sar12b_0.sg13cmos5l_inv_1_2.A sg13cmos5l_Corner_1.vss sg13cmos5l_Corner_1.vss sg13_lv_nmos ad=0.2516p pd=2.16u as=2.41737p ps=15.64u w=0.74u l=0.13u
M4493 vdd adc8b_0.sar12b_0.sg13cmos5l_dfrbp_1_1.Q a_102160_93548# vdd sg13_lv_pmos ad=0.2114p pd=1.54u as=0.2856p ps=2.36u w=0.84u l=0.13u
M4494 vdd a_89272_99838# a_89217_99719# vdd sg13_lv_pmos ad=1.15047p pd=7.175u as=93.45f ps=0.865u w=0.42u l=0.13u
M4495 sg13cmos5l_Corner_1.iovdd a_42476_70044# vddr sg13cmos5l_Corner_1.iovdd sg13_hv_pmos ad=2.1312p pd=7.3u as=3.9294p ps=7.84u w=6.66u l=0.6u
M4496 vddr adc8b_0.side_cap8b_0.in_l_sw[3] adc8b_0.side_cap8b_0.buf_8_1.z vddr sg13_lv_pmos ad=0.19p pd=1.38u as=0.19p ps=1.38u w=1u l=0.13u
M4497 a_70096_99454# adc8b_0.diff_bsw_0.single_bsw_0.sg13cmos5l_inv_1$1_0.A sg13cmos5l_Corner_1.vss sg13cmos5l_Corner_1.vss sg13_lv_nmos ad=0.442p pd=3.28u as=0.442p ps=3.28u w=1.3u l=0.4u
M4498 adc8b_0.cmp_0.outn adc8b_0.cmp_0.clk vdd vdd sg13_lv_pmos ad=0.17p pd=1.68u as=95f ps=0.88u w=0.5u l=0.13u
M4499 vdd a_96351_96930# a_96482_96936# vdd sg13_lv_pmos ad=1.28962p pd=8.195u as=0.2856p ps=2.36u w=0.84u l=0.13u
M4500 sg13cmos5l_Corner_1.iovdd a_70044_42476# data[0] sg13cmos5l_Corner_1.iovdd sg13_hv_pmos ad=2.1312p pd=7.3u as=3.9294p ps=7.84u w=6.66u l=0.6u
M4501 sg13cmos5l_Corner_1.iovdd a_134044_42476# frame sg13cmos5l_Corner_1.iovdd sg13_hv_pmos ad=2.1312p pd=7.3u as=3.9294p ps=7.84u w=6.66u l=0.6u
M4502 sg13cmos5l_Corner_1.vss adc8b_0.sar12b_0.sg13cmos5l_buf_1_34.A a_86608_92824# sg13cmos5l_Corner_1.vss sg13_lv_nmos ad=0.14875p pd=1.16u as=0.187p ps=1.78u w=0.55u l=0.13u
M4503 a_90348_100034# adc8b_0.sar12b_0.sg13cmos5l_dfrbp_1_18.Q a_90254_100034# sg13cmos5l_Corner_1.vss sg13_lv_nmos ad=60.89999f pd=0.71u as=0.1428p ps=1.52u w=0.42u l=0.13u
M4504 sg13cmos5l_Corner_1.vss a_82388_98798# adc8b_0.side_cap8b_0.in_l_sw[0] sg13cmos5l_Corner_1.vss sg13_lv_nmos ad=0.14875p pd=1.16u as=0.2886p ps=2.26u w=0.74u l=0.13u
M4505 adc8b_0.side_cap8b_0.buf_16_2.z adc8b_0.side_cap8b_0.in_l_sw[1] sg13cmos5l_Corner_1.vss sg13cmos5l_Corner_1.vss sg13_lv_nmos ad=95f pd=0.88u as=95f ps=0.88u w=0.5u l=0.13u
M4506 sg13cmos5l_Corner_1.vss a_178296_86044# sg13cmos5l_IOPadAnalog_0.pad sg13cmos5l_Corner_1.vss sg13_hv_nmos ad=1.408p pd=5.04u as=2.596p ps=5.58u w=4.4u l=0.6u
M4507 a_94484_99560# adc8b_0.sar12b_0.sg13cmos5l_buf_1_79.X sg13cmos5l_Corner_1.vss sg13cmos5l_Corner_1.vss sg13_lv_nmos ad=0.187p pd=1.78u as=0.14875p ps=1.16u w=0.55u l=0.13u
M4508 a_84558_99156# a_84389_98796# a_84116_98784# vdd sg13_lv_pmos ad=0.105p pd=1.21u as=0.191p ps=1.44u w=1u l=0.13u
M4509 a_95416_100566# a_95159_100423# a_95578_100346# sg13cmos5l_Corner_1.vss sg13_lv_nmos ad=0.1428p pd=1.52u as=37.8f ps=0.6u w=0.42u l=0.13u
M4510 sg13cmos5l_Corner_1.vss adc8b_0.sar12b_0.sg13cmos5l_nor2_1_1.A a_97207_92790# sg13cmos5l_Corner_1.vss sg13_lv_nmos ad=0.14505p pd=1.15u as=0.1406p ps=1.12u w=0.74u l=0.13u
M4511 w_71686_95000# a_68824_96348# vdd sg13cmos5l_Corner_1.vss sg13_lv_nmos ad=0.442p pd=3.28u as=0.442p ps=3.28u w=1.3u l=0.13u
M4512 a_91708_95796# a_91292_96132# a_91473_95810# sg13cmos5l_Corner_1.vss sg13_lv_nmos ad=77.7f pd=0.95u as=0.2516p ps=2.16u w=0.74u l=0.13u
M4513 sg13cmos5l_Corner_1.vss a_94840_95302# a_94489_95421# sg13cmos5l_Corner_1.vss sg13_lv_nmos ad=79.8f pd=0.8u as=0.1428p ps=1.52u w=0.42u l=0.13u
M4514 sg13cmos5l_Corner_1.vss adc8b_0.side_cap8b_0.in_l_sw[0] adc8b_0.side_cap8b_0.buf_32_0.z sg13cmos5l_Corner_1.vss sg13_lv_nmos ad=95f pd=0.88u as=95f ps=0.88u w=0.5u l=0.13u
M4515 vdd adc8b_0.sar12b_0.sg13cmos5l_or2_1_0.A a_100342_96188# vdd sg13_lv_pmos ad=0.2226p pd=1.535u as=0.1596p ps=1.22u w=0.84u l=0.13u
M4516 sg13cmos5l_Corner_1.vss a_89265_94298# a_89220_94334# sg13cmos5l_Corner_1.vss sg13_lv_nmos ad=0.1428p pd=1.52u as=47.25f ps=0.645u w=0.42u l=0.13u
M4517 adc8b_0.sar12b_0.sg13cmos5l_buf_1_2.X a_97552_92824# sg13cmos5l_Corner_1.vss sg13cmos5l_Corner_1.vss sg13_lv_nmos ad=0.2886p pd=2.26u as=0.14875p ps=1.16u w=0.74u l=0.13u
M4518 adc8b_0.side_cap8b_0.in_h_sw[4] a_88336_100384# sg13cmos5l_Corner_1.vss sg13cmos5l_Corner_1.vss sg13_lv_nmos ad=0.2886p pd=2.26u as=0.14875p ps=1.16u w=0.74u l=0.13u
M4519 data[1] a_86044_42476# sg13cmos5l_Corner_1.iovdd sg13cmos5l_Corner_1.iovdd sg13_hv_pmos ad=3.9294p pd=7.84u as=2.1312p ps=7.3u w=6.66u l=0.6u
M4520 adc8b_0.sar12b_0.sg13cmos5l_nand2_1_1.A a_97148_94596# sg13cmos5l_Corner_1.vss sg13cmos5l_Corner_1.vss sg13_lv_nmos ad=0.2516p pd=2.16u as=0.1406p ps=1.12u w=0.74u l=0.13u
M4521 adc8b_0.cmp_0.sg13cmos5l_inv_1$1_0.Y adc8b_0.cmp_0.outp sg13cmos5l_Corner_1.vss sg13cmos5l_Corner_1.vss sg13_lv_nmos ad=0.2516p pd=2.16u as=0.2516p ps=2.16u w=0.74u l=0.13u
M4522 sg13cmos5l_Corner_1.vss sg13cmos5l_IOPadVdd$1_0.sg13cmos5l_Clamp_N43N43D4R$1_0.gate vdd sg13cmos5l_Corner_1.vss sg13_hv_nmos ad=1.408p pd=5.04u as=2.596p ps=5.58u w=4.4u l=0.6u
M4523 vdd sg13cmos5l_IOPadVdd$1_0.sg13cmos5l_Clamp_N43N43D4R$1_0.gate sg13cmos5l_Corner_1.vss sg13cmos5l_Corner_1.vss sg13_hv_nmos ad=2.596p pd=5.58u as=1.408p ps=5.04u w=4.4u l=0.6u
M4524 sg13cmos5l_Corner_1.vss sg13cmos5l_IOPadVdd$1_0.sg13cmos5l_RCClampInverter$1_0.in sg13cmos5l_IOPadVdd$1_0.sg13cmos5l_Clamp_N43N43D4R$1_0.gate sg13cmos5l_Corner_1.vss sg13_hv_nmos ad=1.71p pd=9.38u as=1.71p ps=9.38u w=9u l=0.5u
M4525 sg13cmos5l_Corner_1.vss a_82292_95774# adc8b_0.cmp_0.clk sg13cmos5l_Corner_1.vss sg13_lv_nmos ad=0.14875p pd=1.16u as=0.2886p ps=2.26u w=0.74u l=0.13u
M4526 frame a_134044_42476# sg13cmos5l_Corner_1.iovdd sg13cmos5l_Corner_1.iovdd sg13_hv_pmos ad=3.9294p pd=7.84u as=2.1312p ps=7.3u w=6.66u l=0.6u
M4527 sg13cmos5l_Corner_1.iovdd a_164624_70044# sg13cmos5l_IOPadAnalog_1.pad sg13cmos5l_Corner_1.iovdd sg13_hv_pmos ad=2.1312p pd=7.3u as=3.9294p ps=7.84u w=6.66u l=0.6u
M4528 vdd sg13cmos5l_IOPadVdd$1_0.sg13cmos5l_Clamp_N43N43D4R$1_0.gate sg13cmos5l_Corner_1.vss sg13cmos5l_Corner_1.vss sg13_hv_nmos ad=2.596p pd=5.58u as=1.408p ps=5.04u w=4.4u l=0.6u
M4529 vddr adc8b_0.sar12b_0.nh_sw[0] adc8b_0.side_cap8b_1.buf_32_1.z vddr sg13_lv_pmos ad=0.19p pd=1.38u as=0.34p ps=2.68u w=1u l=0.13u
M4530 a_85940_92750# adc8b_0.sar12b_0.sg13cmos5l_buf_1_38.A vdd vdd sg13_lv_pmos ad=0.2856p pd=2.36u as=0.2114p ps=1.54u w=0.84u l=0.13u
M4531 sg13cmos5l_Corner_1.vss adc8b_0.sar12b_0.sg13cmos5l_buf_1_8.X a_93424_94336# sg13cmos5l_Corner_1.vss sg13_lv_nmos ad=0.14875p pd=1.16u as=0.187p ps=1.78u w=0.55u l=0.13u
M4532 adc8b_0.side_cap8b_1.buf_16_1.z adc8b_0.sar12b_0.nl_sw[2] vddr vddr sg13_lv_pmos ad=0.19p pd=1.38u as=0.19p ps=1.38u w=1u l=0.13u
M4533 sg13cmos5l_Corner_1.vss adc8b_0.sar12b_0.nh_sw[3] adc8b_0.side_cap8b_1.buf_8_3.z sg13cmos5l_Corner_1.vss sg13_lv_nmos ad=95f pd=0.88u as=95f ps=0.88u w=0.5u l=0.13u
M4534 vdd sg13cmos5l_IOPadVdd$1_0.sg13cmos5l_Clamp_N43N43D4R$1_0.gate sg13cmos5l_Corner_1.vss sg13cmos5l_Corner_1.vss sg13_hv_nmos ad=2.596p pd=5.58u as=1.408p ps=5.04u w=4.4u l=0.6u
M4535 a_97810_98052# a_98253_98095# a_97550_98522# sg13cmos5l_Corner_1.vss sg13_lv_nmos ad=79.8f pd=0.8u as=0.1296p ps=1.52u w=0.42u l=0.13u
M4536 adc8b_0.side_cap8b_0.buf_8_0.z adc8b_0.side_cap8b_0.in_l_sw[4] vddr vddr sg13_lv_pmos ad=0.19p pd=1.38u as=0.19p ps=1.38u w=1u l=0.13u
M4537 sg13cmos5l_Corner_1.vss sg13cmos5l_IOPadVdd$1_0.sg13cmos5l_RCClampInverter$1_0.in sg13cmos5l_IOPadVdd$1_0.sg13cmos5l_Clamp_N43N43D4R$1_0.gate sg13cmos5l_Corner_1.vss sg13_hv_nmos ad=1.71p pd=9.38u as=1.71p ps=9.38u w=9u l=0.5u
M4538 adc8b_0.side_cap8b_0.buf_8_3.z adc8b_0.side_cap8b_0.in_h_sw[3] sg13cmos5l_Corner_1.vss sg13cmos5l_Corner_1.vss sg13_lv_nmos ad=95f pd=0.88u as=95f ps=0.88u w=0.5u l=0.13u
M4539 data[1] a_101776_95060# sg13cmos5l_Corner_1.vss sg13cmos5l_Corner_1.vss sg13_lv_nmos ad=0.2886p pd=2.26u as=0.14875p ps=1.16u w=0.74u l=0.13u
M4540 cko a_118044_42476# sg13cmos5l_Corner_1.iovdd sg13cmos5l_Corner_1.iovdd sg13_hv_pmos ad=3.9294p pd=7.84u as=2.1312p ps=7.3u w=6.66u l=0.6u
M4541 a_92386_94302# adc8b_0.sar12b_0.sg13cmos5l_nand2_1_0.A sg13cmos5l_Corner_1.vss sg13cmos5l_Corner_1.vss sg13_lv_nmos ad=0.1406p pd=1.12u as=0.2516p ps=2.16u w=0.74u l=0.13u
M4542 sg13cmos5l_Corner_1.iovdd a_70044_42476# data[0] sg13cmos5l_Corner_1.iovdd sg13_hv_pmos ad=2.1312p pd=7.3u as=3.9294p ps=7.84u w=6.66u l=0.6u
X4543 sg13cmos5l_Corner_1.vss a_176786_102222# dantenna l=27.78u w=1.26u
M4544 adc8b_0.side_cap8b_1.buf_8_3.z adc8b_0.sar12b_0.nh_sw[3] vddr vddr sg13_lv_pmos ad=0.19p pd=1.38u as=0.19p ps=1.38u w=1u l=0.13u
M4545 a_94748_98084# a_94335_98442# a_94680_98084# vdd sg13_lv_pmos ad=0.191p pd=1.44u as=0.105p ps=1.21u w=1u l=0.13u
M4546 a_86872_96030# adc8b_0.sar12b_0.sg13cmos5l_dfrbp_1_8.RESET_B vdd vdd sg13_lv_pmos ad=79.8f pd=0.8u as=1.2517p ps=7.955u w=0.42u l=0.13u
M4547 sg13cmos5l_IOPadAnalog_12.pad a_131639_164698# sg13cmos5l_Corner_1.iovdd sg13cmos5l_Corner_1.iovdd sg13_hv_pmos ad=3.9294p pd=7.84u as=2.1312p ps=7.3u w=6.66u l=0.6u
M4548 sg13cmos5l_Corner_1.vss adc8b_0.side_cap8b_0.in_h_sw[0] adc8b_0.side_cap8b_0.buf_32_1.z sg13cmos5l_Corner_1.vss sg13_lv_nmos ad=95f pd=0.88u as=95f ps=0.88u w=0.5u l=0.13u
M4549 vddr adc8b_0.side_cap8b_0.in_h_sw[1] adc8b_0.side_cap8b_0.buf_16_3.z vddr sg13_lv_pmos ad=0.19p pd=1.38u as=0.19p ps=1.38u w=1u l=0.13u
M4550 a_94284_97640# a_94258_97545# sg13cmos5l_Corner_1.vss sg13cmos5l_Corner_1.vss sg13_lv_nmos ad=0.2516p pd=2.16u as=0.1626p ps=1.415u w=0.74u l=0.13u
X4551 vip sg13cmos5l_Corner_1.iovdd dpantenna l=27.78u w=1.26u
M4552 sg13cmos5l_Corner_1.vss vdd sg13cmos5l_Corner_1.vss sg13cmos5l_Corner_1.vss sg13_lv_nmos ad=0.1428p pd=1.52u as=0 ps=0 w=0.42u l=1u
M4553 a_98253_98095# adc8b_0.sar12b_0.sg13cmos5l_inv_1_2.A vdd vdd sg13_lv_pmos ad=0.4088p pd=2.97u as=1.07253p ps=6.75u w=1.12u l=0.13u
M4554 sg13cmos5l_Corner_1.vss a_82774_95327# adc8b_0.sar12b_0.sg13cmos5l_dlygate4sd3_1_0.X sg13cmos5l_Corner_1.vss sg13_lv_nmos ad=0.1426p pd=1.16u as=0.2516p ps=2.16u w=0.74u l=0.13u
M4555 data[1] a_86044_42476# sg13cmos5l_Corner_1.iovdd sg13cmos5l_Corner_1.iovdd sg13_hv_pmos ad=3.9294p pd=7.84u as=2.1312p ps=7.3u w=6.66u l=0.6u
M4556 sg13cmos5l_Corner_1.iovdd a_164624_70044# sg13cmos5l_IOPadAnalog_1.pad sg13cmos5l_Corner_1.iovdd sg13_hv_pmos ad=2.1312p pd=7.3u as=3.9294p ps=7.84u w=6.66u l=0.6u
X4557 sg13cmos5l_Corner_1.vss a_33862_102222# dantenna l=27.78u w=1.26u
M4558 sg13cmos5l_Corner_1.iovdd a_164624_102044# sg13cmos5l_IOPadAnalog_16.pad sg13cmos5l_Corner_1.iovdd sg13_hv_pmos ad=2.1312p pd=7.3u as=3.9294p ps=7.84u w=6.66u l=0.6u
M4559 sg13cmos5l_Corner_1.vss adc8b_0.sar12b_0.nh_sw[0] adc8b_0.side_cap8b_1.buf_32_1.z sg13cmos5l_Corner_1.vss sg13_lv_nmos ad=95f pd=0.88u as=95f ps=0.88u w=0.5u l=0.13u
M4560 a_85342_99010# a_85444_99124# sg13cmos5l_Corner_1.vss sg13cmos5l_Corner_1.vss sg13_lv_nmos ad=0.187p pd=1.78u as=0.1491p ps=1.18u w=0.55u l=0.13u
M4561 a_89649_99225# a_89292_99152# vdd vdd sg13_lv_pmos ad=63f pd=0.72u as=0.1563p ps=1.22u w=0.42u l=0.13u
M4562 vdd adc8b_0.cmp_0.sg13cmos5l_inv_1$1_0.Y a_79646_97015# vdd sg13_lv_pmos ad=0.2226p pd=1.535u as=0.1596p ps=1.22u w=0.84u l=0.13u
M4563 sg13cmos5l_Corner_1.vss a_99729_99953# a_99684_99998# sg13cmos5l_Corner_1.vss sg13_lv_nmos ad=0.1428p pd=1.52u as=47.25f ps=0.645u w=0.42u l=0.13u
M4564 a_85437_97480# a_84495_97540# a_85298_97480# sg13cmos5l_Corner_1.vss sg13_lv_nmos ad=79.8f pd=0.8u as=0.2373p ps=1.97u w=0.42u l=0.13u
M4565 a_90428_96572# a_90015_96930# a_90360_96572# vdd sg13_lv_pmos ad=0.191p pd=1.44u as=0.105p ps=1.21u w=1u l=0.13u
M4566 adc8b_0.side_cap8b_1.buf_2_2.z adc8b_0.sar12b_0.nl_sw[9] sg13cmos5l_Corner_1.vss sg13cmos5l_Corner_1.vss sg13_lv_nmos ad=0.17p pd=1.68u as=95f ps=0.88u w=0.5u l=0.13u
M4567 vdd sg13cmos5l_Corner_1.vss vdd vdd sg13_lv_pmos ad=0.19p pd=1.38u as=0 ps=0 w=1u l=1u
M4568 sg13cmos5l_Corner_1.iovdd a_102044_42476# data[2] sg13cmos5l_Corner_1.iovdd sg13_hv_pmos ad=2.1312p pd=7.3u as=3.9294p ps=7.84u w=6.66u l=0.6u
M4569 sg13cmos5l_Corner_1.vss adc8b_0.sar12b_0.sg13cmos5l_buf_1_8.A a_92656_92824# sg13cmos5l_Corner_1.vss sg13_lv_nmos ad=0.14875p pd=1.16u as=0.187p ps=1.78u w=0.55u l=0.13u
M4570 a_98900_100310# adc8b_0.sar12b_0.sg13cmos5l_buf_1_94.X sg13cmos5l_Corner_1.vss sg13cmos5l_Corner_1.vss sg13_lv_nmos ad=0.187p pd=1.78u as=0.14875p ps=1.16u w=0.55u l=0.13u
M4571 a_90553_97314# a_90001_97376# sg13cmos5l_Corner_1.vss sg13cmos5l_Corner_1.vss sg13_lv_nmos ad=71.99999f pd=0.865u as=1.97045p ps=12.335u w=0.64u l=0.13u
M4572 a_90620_97644# a_90338_97332# a_90553_97314# sg13cmos5l_Corner_1.vss sg13_lv_nmos ad=0.141p pd=1.17u as=71.99999f ps=0.865u w=0.64u l=0.13u
M4573 data[0] a_70044_42476# sg13cmos5l_Corner_1.iovdd sg13cmos5l_Corner_1.iovdd sg13_hv_pmos ad=3.9294p pd=7.84u as=2.1312p ps=7.3u w=6.66u l=0.6u
M4574 a_89518_98847# adc8b_0.sar12b_0.sg13cmos5l_dfrbp_1_6.RESET_B sg13cmos5l_Corner_1.vss sg13cmos5l_Corner_1.vss sg13_lv_nmos ad=37.8f pd=0.6u as=0.1701p ps=1.65u w=0.42u l=0.13u
M4575 a_82190_97010# adc8b_0.sar12b_0.sg13cmos5l_dfrbp_1_6.D vdd vdd sg13_lv_pmos ad=79.8f pd=0.8u as=0.1428p ps=1.52u w=0.42u l=0.13u
M4576 vdd adc8b_0.sar12b_0.sg13cmos5l_nand2_1_1.B a_91591_93524# vdd sg13_lv_pmos ad=0.3808p pd=2.92u as=0.2744p ps=1.61u w=1.12u l=0.13u
M4577 a_98340_95421# a_98471_95031# a_97589_95024# vdd sg13_lv_pmos ad=0.34p pd=2.68u as=0.2048p ps=1.63u w=1u l=0.13u
M4578 sg13cmos5l_Corner_1.vss sg13cmos5l_IOPadVdd$1_0.sg13cmos5l_Clamp_N43N43D4R$1_0.gate vdd sg13cmos5l_Corner_1.vss sg13_hv_nmos ad=1.408p pd=5.04u as=2.596p ps=5.58u w=4.4u l=0.6u
M4579 sg13cmos5l_Corner_1.vss adc8b_0.side_cap8b_0.in_l_sw[7] adc8b_0.side_cap8b_0.buf_4_0.z sg13cmos5l_Corner_1.vss sg13_lv_nmos ad=95f pd=0.88u as=0.17p ps=1.68u w=0.5u l=0.13u
M4580 adc8b_0.sar12b_0.sg13cmos5l_a22oi_1_0.B1 adc8b_0.sar12b_0.sg13cmos5l_nand2_1_0.A vdd vdd sg13_lv_pmos ad=0.2128p pd=1.5u as=0.3808p ps=2.92u w=1.12u l=0.13u
M4581 vip a_30676_102044# sg13cmos5l_Corner_1.vss sg13cmos5l_Corner_1.vss sg13_hv_nmos ad=2.596p pd=5.58u as=2.068p ps=9.74u w=4.4u l=0.6u
M4582 a_87374_94736# a_86978_94308# a_87260_94620# vdd sg13_lv_pmos ad=0.1008p pd=0.9u as=0.191p ps=1.44u w=0.42u l=0.13u
M4583 adc8b_0.side_cap8b_1.buf_1_1.z adc8b_0.sar12b_0.nh_sw[10] vddr vddr sg13_lv_pmos ad=0.34p pd=2.68u as=0.34p ps=2.68u w=1u l=0.13u
M4584 data[2] a_102044_30676# sg13cmos5l_Corner_1.vss sg13cmos5l_Corner_1.vss sg13_hv_nmos ad=2.596p pd=5.58u as=1.408p ps=5.04u w=4.4u l=0.6u
M4585 adc8b_0.side_cap8b_0.buf_32_0.z adc8b_0.side_cap8b_0.in_l_sw[0] vddr vddr sg13_lv_pmos ad=0.19p pd=1.38u as=0.19p ps=1.38u w=1u l=0.13u
M4586 a_98516_100310# adc8b_0.sar12b_0.sg13cmos5l_buf_1_93.X vdd vdd sg13_lv_pmos ad=0.2856p pd=2.36u as=0.2114p ps=1.54u w=0.84u l=0.13u
M4587 a_87756_97335# a_87987_97444# a_87442_97545# sg13cmos5l_Corner_1.vss sg13_lv_nmos ad=0.2373p pd=1.97u as=79.8f ps=0.8u w=0.42u l=0.13u
M4588 a_87694_97335# adc8b_0.sar12b_0.sg13cmos5l_dfrbp_1_6.RESET_B sg13cmos5l_Corner_1.vss sg13cmos5l_Corner_1.vss sg13_lv_nmos ad=37.8f pd=0.6u as=0.1701p ps=1.65u w=0.42u l=0.13u
X4589 a_36456_134095# a_40542_133765# sg13cmos5l_Corner_1.vss rppd l=20u w=1u
M4590 sg13cmos5l_Corner_1.vss a_88148_98798# adc8b_0.side_cap8b_0.in_l_sw[3] sg13cmos5l_Corner_1.vss sg13_lv_nmos ad=0.14875p pd=1.16u as=0.2886p ps=2.26u w=0.74u l=0.13u
M4591 sg13cmos5l_Corner_1.iovdd a_164624_118044# sg13cmos5l_IOPadAnalog_11.pad sg13cmos5l_Corner_1.iovdd sg13_hv_pmos ad=2.1312p pd=7.3u as=3.9294p ps=7.84u w=6.66u l=0.6u
M4592 vip a_30676_102044# sg13cmos5l_Corner_1.vss sg13cmos5l_Corner_1.vss sg13_hv_nmos ad=2.596p pd=5.58u as=1.408p ps=5.04u w=4.4u l=0.6u
M4593 sg13cmos5l_Corner_1.vss adc8b_0.sar12b_0.sg13cmos5l_dfrbp_1_8.RESET_B a_97644_98522# sg13cmos5l_Corner_1.vss sg13_lv_nmos ad=0.1626p pd=1.415u as=60.89999f ps=0.71u w=0.42u l=0.13u
M4594 a_94701_97301# adc8b_0.sar12b_0.sg13cmos5l_dfrbp_1_23.CLK vdd vdd sg13_lv_pmos ad=0.4088p pd=2.97u as=1.04815p ps=6.595u w=1.12u l=0.13u
M4595 vdd a_94484_99560# adc8b_0.side_cap8b_0.in_h_sw[5] vdd sg13_lv_pmos ad=0.2114p pd=1.54u as=0.42p ps=2.99u w=1.12u l=0.13u
M4596 a_86615_95887# a_85773_95789# a_86521_95887# sg13cmos5l_Corner_1.vss sg13_lv_nmos ad=0.12665p pd=1.145u as=0.1428p ps=1.52u w=0.42u l=0.13u
M4597 sg13cmos5l_Corner_1.vss a_85809_93905# a_85764_93950# sg13cmos5l_Corner_1.vss sg13_lv_nmos ad=0.1428p pd=1.52u as=47.25f ps=0.645u w=0.42u l=0.13u
M4598 sg13cmos5l_Corner_1.vss adc8b_0.sar12b_0.sg13cmos5l_buf_1_68.X a_82384_100384# sg13cmos5l_Corner_1.vss sg13_lv_nmos ad=0.14875p pd=1.16u as=0.187p ps=1.78u w=0.55u l=0.13u
M4599 adc8b_0.diff_bsw_0.single_bsw_1.sg13cmos5l_inv_1$1_2.Y adc8b_0.diff_bsw_0.single_bsw_1.sg13cmos5l_inv_1$1_2.A vdd vdd sg13_lv_pmos ad=0.3808p pd=2.92u as=0.3808p ps=2.92u w=1.12u l=0.13u
M4600 sg13cmos5l_IOPadAnalog_9.pad a_83639_164698# sg13cmos5l_Corner_1.iovdd sg13cmos5l_Corner_1.iovdd sg13_hv_pmos ad=3.9294p pd=7.84u as=2.1312p ps=7.3u w=6.66u l=0.6u
M4601 adc8b_0.sar12b_0.sg13cmos5l_dfrbp_1_16.Q a_84572_98084# vdd vdd sg13_lv_pmos ad=0.3808p pd=2.92u as=0.2128p ps=1.5u w=1.12u l=0.13u
M4602 vdd a_89588_100310# adc8b_0.sar12b_0.sg13cmos5l_buf_1_73.X vdd sg13_lv_pmos ad=0.2114p pd=1.54u as=0.42p ps=2.99u w=1.12u l=0.13u
M4603 adc8b_0.sar12b_0.sg13cmos5l_a221oi_1_0.A2 a_89660_95060# vdd vdd sg13_lv_pmos ad=0.3808p pd=2.92u as=0.2128p ps=1.5u w=1.12u l=0.13u
M4604 vddr a_42476_70044# sg13cmos5l_Corner_1.iovdd sg13cmos5l_Corner_1.iovdd sg13_hv_pmos ad=3.9294p pd=7.84u as=2.1312p ps=7.3u w=6.66u l=0.6u
M4605 vdd a_96063_98442# a_96194_98448# vdd sg13_lv_pmos ad=1.07253p pd=6.75u as=0.2856p ps=2.36u w=0.84u l=0.13u
M4606 sg13cmos5l_Corner_1.vss a_88984_97542# a_88633_97399# sg13cmos5l_Corner_1.vss sg13_lv_nmos ad=79.8f pd=0.8u as=0.1428p ps=1.52u w=0.42u l=0.13u
M4607 vdd sg13cmos5l_IOPadVdd$1_0.sg13cmos5l_RCClampInverter$1_0.in sg13cmos5l_IOPadVdd$1_0.sg13cmos5l_Clamp_N43N43D4R$1_0.gate vdd sg13_hv_pmos ad=1.33p pd=7.38u as=1.33p ps=7.38u w=7u l=0.5u
M4608 adc8b_0.sar12b_0.sg13cmos5l_or2_1_0.A a_100131_95430# sg13cmos5l_Corner_1.vss sg13cmos5l_Corner_1.vss sg13_lv_nmos ad=0.1406p pd=1.12u as=0.1406p ps=1.12u w=0.74u l=0.13u
M4609 sg13cmos5l_Corner_1.iovdd a_131639_164698# sg13cmos5l_IOPadAnalog_12.pad sg13cmos5l_Corner_1.iovdd sg13_hv_pmos ad=2.1312p pd=7.3u as=3.9294p ps=7.84u w=6.66u l=0.6u
M4610 cks a_42476_118044# sg13cmos5l_Corner_1.iovdd sg13cmos5l_Corner_1.iovdd sg13_hv_pmos ad=3.9294p pd=7.84u as=3.1302p ps=14.26u w=6.66u l=0.6u
M4611 vdd a_86228_100310# adc8b_0.sar12b_0.sg13cmos5l_buf_1_60.X vdd sg13_lv_pmos ad=0.2114p pd=1.54u as=0.42p ps=2.99u w=1.12u l=0.13u
M4612 a_99864_99156# a_99313_98888# vdd vdd sg13_lv_pmos ad=0.105p pd=1.21u as=1.15047p ps=7.175u w=1u l=0.13u
M4613 a_88727_97399# a_87885_97301# a_87468_97640# vdd sg13_lv_pmos ad=0.2048p pd=1.63u as=0.34p ps=2.68u w=1u l=0.13u
M4614 sg13cmos5l_Corner_1.vss adc8b_0.sar12b_0.sg13cmos5l_buf_1_10.A adc8b_0.sar12b_0.sg13cmos5l_inv_1_28.Y sg13cmos5l_Corner_1.vss sg13_lv_nmos ad=0.2516p pd=2.16u as=0.2516p ps=2.16u w=0.74u l=0.13u
M4615 sg13cmos5l_IOPadAnalog_0.pad a_178296_86044# sg13cmos5l_Corner_1.vss sg13cmos5l_Corner_1.vss sg13_hv_nmos ad=2.596p pd=5.58u as=1.408p ps=5.04u w=4.4u l=0.6u
M4616 a_92668_98472# a_92252_98084# a_92433_98441# sg13cmos5l_Corner_1.vss sg13_lv_nmos ad=77.7f pd=0.95u as=0.2516p ps=2.16u w=0.74u l=0.13u
M4617 adc8b_0.sar12b_0.sg13cmos5l_dlhr_1_12.D a_98039_98911# vdd vdd sg13_lv_pmos ad=0.4312p pd=3.01u as=0.2639p ps=1.81u w=1.12u l=0.13u
M4618 a_88984_97542# a_88727_97399# a_89146_97322# sg13cmos5l_Corner_1.vss sg13_lv_nmos ad=0.1428p pd=1.52u as=37.8f ps=0.6u w=0.42u l=0.13u
M4619 vdd a_86900_95024# adc8b_0.sar12b_0.sg13cmos5l_buf_1_44.X vdd sg13_lv_pmos ad=0.2114p pd=1.54u as=0.42p ps=2.99u w=1.12u l=0.13u
M4620 adc8b_0.side_cap8b_1.buf_16_0.z adc8b_0.sar12b_0.nh_sw[2] sg13cmos5l_Corner_1.vss sg13cmos5l_Corner_1.vss sg13_lv_nmos ad=0.17p pd=1.68u as=95f ps=0.88u w=0.5u l=0.13u
M4621 vddr adc8b_0.sar12b_0.nl_sw[2] adc8b_0.side_cap8b_1.buf_16_1.z vddr sg13_lv_pmos ad=0.19p pd=1.38u as=0.19p ps=1.38u w=1u l=0.13u
M4622 sg13cmos5l_Corner_1.iovdd a_42476_86044# vin sg13cmos5l_Corner_1.iovdd sg13_hv_pmos ad=2.1312p pd=7.3u as=3.9294p ps=7.84u w=6.66u l=0.6u
M4623 sg13cmos5l_Corner_1.vss a_95469_94277# a_95571_94420# sg13cmos5l_Corner_1.vss sg13_lv_nmos ad=2.59257p pd=16.445u as=0.2516p ps=2.16u w=0.74u l=0.13u
M4624 adc8b_0.sar12b_0.sg13cmos5l_dlhr_1_1.D a_83735_96933# vdd vdd sg13_lv_pmos ad=0.4312p pd=3.01u as=0.2639p ps=1.81u w=1.12u l=0.13u
M4625 adc8b_0.sar12b_0.sg13cmos5l_dlhr_1_3.Q_N a_86334_93978# sg13cmos5l_Corner_1.vss sg13cmos5l_Corner_1.vss sg13_lv_nmos ad=0.2516p pd=2.16u as=0.1491p ps=1.18u w=0.74u l=0.13u
M4626 sg13cmos5l_Corner_1.vss sg13cmos5l_IOPadVdd$1_0.sg13cmos5l_Clamp_N43N43D4R$1_0.gate vdd sg13cmos5l_Corner_1.vss sg13_hv_nmos ad=1.408p pd=5.04u as=2.596p ps=5.58u w=4.4u l=0.6u
M4627 sg13cmos5l_Corner_1.iovdd a_134044_42476# frame sg13cmos5l_Corner_1.iovdd sg13_hv_pmos ad=2.1312p pd=7.3u as=3.9294p ps=7.84u w=6.66u l=0.6u
M4628 a_98721_93671# a_97779_93559# a_98519_93909# vdd sg13_lv_pmos ad=93.45f pd=0.865u as=0.2048p ps=1.63u w=0.42u l=0.13u
M4629 sg13cmos5l_IOPadAnalog_12.pad a_131639_164698# sg13cmos5l_Corner_1.iovdd sg13cmos5l_Corner_1.iovdd sg13_hv_pmos ad=3.9294p pd=7.84u as=3.1302p ps=14.26u w=6.66u l=0.6u
M4630 sg13cmos5l_IOPadAnalog_13.pad a_115639_164698# sg13cmos5l_Corner_1.iovdd sg13cmos5l_Corner_1.iovdd sg13_hv_pmos ad=3.9294p pd=7.84u as=2.1312p ps=7.3u w=6.66u l=0.6u
M4631 sg13cmos5l_Corner_1.vss a_85432_99838# a_85081_99957# sg13cmos5l_Corner_1.vss sg13_lv_nmos ad=79.8f pd=0.8u as=0.1428p ps=1.52u w=0.42u l=0.13u
M4632 vdd sg13cmos5l_Corner_1.vss vdd vdd sg13_lv_pmos ad=0.34p pd=2.68u as=0 ps=0 w=1u l=1u
M4633 adc8b_0.side_cap8b_1.buf_32_0.z adc8b_0.sar12b_0.nl_sw[0] sg13cmos5l_Corner_1.vss sg13cmos5l_Corner_1.vss sg13_lv_nmos ad=95f pd=0.88u as=95f ps=0.88u w=0.5u l=0.13u
M4634 vdd a_88557_95789# a_88659_95932# vdd sg13_lv_pmos ad=1.28962p pd=8.195u as=0.3864p ps=2.93u w=1.12u l=0.13u
M4635 sg13cmos5l_Corner_1.iovdd a_42476_118044# cks sg13cmos5l_Corner_1.iovdd sg13_hv_pmos ad=2.1312p pd=7.3u as=3.9294p ps=7.84u w=6.66u l=0.6u
M4636 adc8b_0.side_cap8b_0.buf_32_1.z adc8b_0.side_cap8b_0.in_h_sw[0] sg13cmos5l_Corner_1.vss sg13cmos5l_Corner_1.vss sg13_lv_nmos ad=95f pd=0.88u as=95f ps=0.88u w=0.5u l=0.13u
M4637 frame a_134044_30676# sg13cmos5l_Corner_1.vss sg13cmos5l_Corner_1.vss sg13_hv_nmos ad=2.596p pd=5.58u as=1.408p ps=5.04u w=4.4u l=0.6u
M4638 adc8b_0.side_cap8b_0.buf_8_5.z adc8b_0.side_cap8b_0.in_h_sw[5] vddr vddr sg13_lv_pmos ad=0.19p pd=1.38u as=0.19p ps=1.38u w=1u l=0.13u
M4639 vdd a_98900_100310# adc8b_0.side_cap8b_0.in_h_sw[7] vdd sg13_lv_pmos ad=0.2114p pd=1.54u as=0.42p ps=2.99u w=1.12u l=0.13u
M4640 vdd adc8b_0.sar12b_0.sg13cmos5l_buf_1_61.X a_82768_100384# vdd sg13_lv_pmos ad=0.2114p pd=1.54u as=0.2856p ps=2.36u w=0.84u l=0.13u
M4641 vdd sg13cmos5l_IOPadVdd$1_0.sg13cmos5l_Clamp_N43N43D4R$1_0.gate sg13cmos5l_Corner_1.vss sg13cmos5l_Corner_1.vss sg13_hv_nmos ad=2.596p pd=5.58u as=1.408p ps=5.04u w=4.4u l=0.6u
M4642 a_95278_94311# adc8b_0.sar12b_0.sg13cmos5l_dfrbp_1_0.RESET_B sg13cmos5l_Corner_1.vss sg13cmos5l_Corner_1.vss sg13_lv_nmos ad=37.8f pd=0.6u as=0.1701p ps=1.65u w=0.42u l=0.13u
M4643 a_94844_96536# adc8b_0.sar12b_0.sg13cmos5l_inv_1_0.A vdd vdd sg13_lv_pmos ad=0.2856p pd=2.36u as=0.2618p ps=1.63u w=0.84u l=0.13u
M4644 a_100131_95430# adc8b_0.sar12b_0.sg13cmos5l_buf_8_1.A sg13cmos5l_Corner_1.vss sg13cmos5l_Corner_1.vss sg13_lv_nmos ad=0.1406p pd=1.12u as=0.1406p ps=1.12u w=0.74u l=0.13u
M4645 a_93550_92799# adc8b_0.sar12b_0.sg13cmos5l_dfrbp_1_0.RESET_B sg13cmos5l_Corner_1.vss sg13cmos5l_Corner_1.vss sg13_lv_nmos ad=37.8f pd=0.6u as=0.1701p ps=1.65u w=0.42u l=0.13u
M4646 vdd sg13cmos5l_IOPadVdd$1_0.sg13cmos5l_Clamp_N43N43D4R$1_0.gate sg13cmos5l_Corner_1.vss sg13cmos5l_Corner_1.vss sg13_hv_nmos ad=2.596p pd=5.58u as=1.408p ps=5.04u w=4.4u l=0.6u
M4647 vddr adc8b_0.side_cap8b_0.in_h_sw[0] adc8b_0.side_cap8b_0.buf_32_1.z vddr sg13_lv_pmos ad=0.19p pd=1.38u as=0.19p ps=1.38u w=1u l=0.13u
M4648 sg13cmos5l_Corner_1.vss adc8b_0.side_cap8b_0.in_l_sw[5] adc8b_0.side_cap8b_0.buf_8_4.z sg13cmos5l_Corner_1.vss sg13_lv_nmos ad=95f pd=0.88u as=95f ps=0.88u w=0.5u l=0.13u
M4649 a_92493_98813# adc8b_0.sar12b_0.sg13cmos5l_dlhr_1_11.GATE vdd vdd sg13_lv_pmos ad=0.4088p pd=2.97u as=1.12242p ps=7u w=1.12u l=0.13u
M4650 sg13cmos5l_IOPadAnalog_11.pad a_164624_118044# sg13cmos5l_Corner_1.iovdd sg13cmos5l_Corner_1.iovdd sg13_hv_pmos ad=3.9294p pd=7.84u as=2.1312p ps=7.3u w=6.66u l=0.6u
M4651 adc8b_0.side_cap8b_0.buf_8_1.z adc8b_0.side_cap8b_0.in_l_sw[3] sg13cmos5l_Corner_1.vss sg13cmos5l_Corner_1.vss sg13_lv_nmos ad=95f pd=0.88u as=95f ps=0.88u w=0.5u l=0.13u
M4652 vdd a_85175_99957# a_86012_99596# vdd sg13_lv_pmos ad=0.2128p pd=1.5u as=0.3864p ps=2.93u w=1.12u l=0.13u
M4653 vdd sg13cmos5l_Corner_1.vss vdd vdd sg13_lv_pmos ad=0.34p pd=2.68u as=0 ps=0 w=1u l=1u
M4654 sg13cmos5l_Corner_1.vss adc8b_0.sar12b_0.nh_sw[5] adc8b_0.side_cap8b_1.buf_8_5.z sg13cmos5l_Corner_1.vss sg13_lv_nmos ad=95f pd=0.88u as=95f ps=0.88u w=0.5u l=0.13u
M4655 a_98938_93986# adc8b_0.sar12b_0.sg13cmos5l_dfrbp_1_0.RESET_B sg13cmos5l_Corner_1.vss sg13cmos5l_Corner_1.vss sg13_lv_nmos ad=37.8f pd=0.6u as=79.8f ps=0.8u w=0.42u l=0.13u
M4656 adc8b_0.sar12b_0.sg13cmos5l_buf_1_90.X a_93232_100384# vdd vdd sg13_lv_pmos ad=0.42p pd=2.99u as=0.2114p ps=1.54u w=1.12u l=0.13u
M4657 sg13cmos5l_Corner_1.vss a_90225_98441# a_90750_98514# sg13cmos5l_Corner_1.vss sg13_lv_nmos ad=0.1491p pd=1.18u as=0.187p ps=1.78u w=0.55u l=0.13u
M4658 sg13cmos5l_Corner_1.iovdd a_86044_42476# data[1] sg13cmos5l_Corner_1.iovdd sg13_hv_pmos ad=2.1312p pd=7.3u as=3.9294p ps=7.84u w=6.66u l=0.6u
M4659 vddr adc8b_0.sar12b_0.nl_sw[0] adc8b_0.side_cap8b_1.buf_32_0.z vddr sg13_lv_pmos ad=0.19p pd=1.38u as=0.19p ps=1.38u w=1u l=0.13u
M4660 sg13cmos5l_Corner_1.vss adc8b_0.sar12b_0.sg13cmos5l_buf_1_28.A a_91216_92824# sg13cmos5l_Corner_1.vss sg13_lv_nmos ad=0.14875p pd=1.16u as=0.187p ps=1.78u w=0.55u l=0.13u
M4661 vdd a_85215_93906# a_85346_93912# vdd sg13_lv_pmos ad=1.86162p pd=11.935u as=0.2856p ps=2.36u w=0.84u l=0.13u
M4662 a_89080_95302# a_88823_95421# a_89242_95498# sg13cmos5l_Corner_1.vss sg13_lv_nmos ad=0.1428p pd=1.52u as=37.8f ps=0.6u w=0.42u l=0.13u
M4663 adc8b_0.sar12b_0.sg13cmos5l_a22oi_1_0.Y adc8b_0.sar12b_0.sg13cmos5l_inv_1_0.A a_92551_95452# sg13cmos5l_Corner_1.vss sg13_lv_nmos ad=0.2664p pd=1.46u as=0.13875p ps=1.115u w=0.74u l=0.13u
M4664 sg13cmos5l_IOPadAnalog_11.pad a_178296_118044# sg13cmos5l_Corner_1.vss sg13cmos5l_Corner_1.vss sg13_hv_nmos ad=2.596p pd=5.58u as=2.068p ps=9.74u w=4.4u l=0.6u
M4665 sg13cmos5l_Corner_1.vss a_85437_97480# a_84516_97286# sg13cmos5l_Corner_1.vss sg13_lv_nmos ad=0.1626p pd=1.415u as=0.2516p ps=2.16u w=0.74u l=0.13u
M4666 sg13cmos5l_Corner_1.vss a_178296_70044# sg13cmos5l_IOPadAnalog_1.pad sg13cmos5l_Corner_1.vss sg13_hv_nmos ad=1.408p pd=5.04u as=2.596p ps=5.58u w=4.4u l=0.6u
X4667 sg13cmos5l_Corner_1.vss a_140462_57198# dantenna l=3.1u w=0.64u
M4668 adc8b_0.sar12b_0.sg13cmos5l_dfrbp_1_25.Q_N a_97655_99957# sg13cmos5l_Corner_1.vss sg13cmos5l_Corner_1.vss sg13_lv_nmos ad=0.2849p pd=2.25u as=0.2516p ps=2.16u w=0.74u l=0.13u
M4669 sg13cmos5l_Corner_1.iovdd a_118044_42476# cko sg13cmos5l_Corner_1.iovdd sg13_hv_pmos ad=2.1312p pd=7.3u as=3.9294p ps=7.84u w=6.66u l=0.6u
M4670 sg13cmos5l_Corner_1.iovdd a_42476_102044# vip sg13cmos5l_Corner_1.iovdd sg13_hv_pmos ad=2.1312p pd=7.3u as=3.9294p ps=7.84u w=6.66u l=0.6u
M4671 data[2] a_102044_42476# sg13cmos5l_Corner_1.iovdd sg13cmos5l_Corner_1.iovdd sg13_hv_pmos ad=3.9294p pd=7.84u as=2.1312p ps=7.3u w=6.66u l=0.6u
M4672 a_89457_92786# a_89276_93108# vdd vdd sg13_lv_pmos ad=0.2128p pd=1.5u as=0.2387p ps=1.84u w=1.12u l=0.13u
M4673 a_97655_99957# a_96813_99607# a_97561_99957# sg13cmos5l_Corner_1.vss sg13_lv_nmos ad=0.12665p pd=1.145u as=0.1428p ps=1.52u w=0.42u l=0.13u
M4674 adc8b_0.sar12b_0.sg13cmos5l_dfrbp_1_16.Q a_84572_98084# sg13cmos5l_Corner_1.vss sg13cmos5l_Corner_1.vss sg13_lv_nmos ad=0.2516p pd=2.16u as=0.1406p ps=1.12u w=0.74u l=0.13u
M4675 vdd adc8b_0.cmp_0.sg13cmos5l_dlygate4sd3_1$1_0.A a_80424_96641# vdd sg13_lv_pmos ad=0.1523p pd=1.38u as=0.1428p ps=1.52u w=0.42u l=0.13u
M4676 adc8b_0.sar12b_0.sg13cmos5l_dlhr_1_1.Q_N a_84702_95792# vdd vdd sg13_lv_pmos ad=0.3808p pd=2.92u as=0.1974p ps=1.5u w=1.12u l=0.13u
M4677 sg13cmos5l_Corner_1.iovdd a_70044_42476# data[0] sg13cmos5l_Corner_1.iovdd sg13_hv_pmos ad=2.1312p pd=7.3u as=3.9294p ps=7.84u w=6.66u l=0.6u
M4678 vddr adc8b_0.sar12b_0.nl_sw[7] adc8b_0.side_cap8b_1.buf_4_0.z vddr sg13_lv_pmos ad=0.19p pd=1.38u as=0.34p ps=2.68u w=1u l=0.13u
M4679 a_96351_96930# adc8b_0.sar12b_0.sg13cmos5l_dfrbp_1_23.CLK vdd vdd sg13_lv_pmos ad=0.3234p pd=2.45u as=1.28962p ps=8.195u w=0.84u l=0.13u
M4680 adc8b_0.sar12b_0.sg13cmos5l_a221oi_1_0.A2 a_89660_95060# sg13cmos5l_Corner_1.vss sg13cmos5l_Corner_1.vss sg13_lv_nmos ad=0.2516p pd=2.16u as=0.1406p ps=1.12u w=0.74u l=0.13u
M4681 adc8b_0.side_cap8b_0.buf_16_2.z adc8b_0.side_cap8b_0.in_l_sw[1] sg13cmos5l_Corner_1.vss sg13cmos5l_Corner_1.vss sg13_lv_nmos ad=95f pd=0.88u as=95f ps=0.88u w=0.5u l=0.13u
M4682 vdd sg13cmos5l_Corner_1.vss vdd vdd sg13_lv_pmos ad=0.34p pd=2.68u as=0 ps=0 w=1u l=1u
M4683 sg13cmos5l_Corner_1.iovdd a_164624_118044# sg13cmos5l_IOPadAnalog_11.pad sg13cmos5l_Corner_1.iovdd sg13_hv_pmos ad=2.1312p pd=7.3u as=3.9294p ps=7.84u w=6.66u l=0.6u
M4684 adc8b_0.sar12b_0.sg13cmos5l_o21ai_1_0.A1 adc8b_0.sar12b_0.sg13cmos5l_a221oi_1_0.C1 a_93162_96108# vdd sg13_lv_pmos ad=0.3808p pd=2.92u as=0.2128p ps=1.5u w=1.12u l=0.13u
M4685 sg13cmos5l_IOPadAnalog_13.pad a_115639_178370# sg13cmos5l_Corner_1.vss sg13cmos5l_Corner_1.vss sg13_hv_nmos ad=2.596p pd=5.58u as=1.408p ps=5.04u w=4.4u l=0.6u
M4686 sg13cmos5l_IOPadAnalog_9.pad a_83639_164698# sg13cmos5l_Corner_1.iovdd sg13cmos5l_Corner_1.iovdd sg13_hv_pmos ad=3.9294p pd=7.84u as=2.1312p ps=7.3u w=6.66u l=0.6u
M4687 a_85773_95789# adc8b_0.sar12b_0.sg13cmos5l_inv_1_8.A vdd vdd sg13_lv_pmos ad=0.4088p pd=2.97u as=1.2517p ps=7.955u w=1.12u l=0.13u
M4688 frame a_134044_42476# sg13cmos5l_Corner_1.iovdd sg13cmos5l_Corner_1.iovdd sg13_hv_pmos ad=3.9294p pd=7.84u as=2.1312p ps=7.3u w=6.66u l=0.6u
M4689 sg13cmos5l_Corner_1.vss a_86044_30676# data[1] sg13cmos5l_Corner_1.vss sg13_hv_nmos ad=1.408p pd=5.04u as=2.596p ps=5.58u w=4.4u l=0.6u
M4690 sg13cmos5l_IOPadAnalog_12.pad a_131639_178370# sg13cmos5l_Corner_1.vss sg13cmos5l_Corner_1.vss sg13_hv_nmos ad=2.596p pd=5.58u as=1.408p ps=5.04u w=4.4u l=0.6u
M4691 data[0] a_70044_30676# sg13cmos5l_Corner_1.vss sg13cmos5l_Corner_1.vss sg13_hv_nmos ad=2.596p pd=5.58u as=1.408p ps=5.04u w=4.4u l=0.6u
M4692 sg13cmos5l_Corner_1.vss a_178296_118044# sg13cmos5l_IOPadAnalog_11.pad sg13cmos5l_Corner_1.vss sg13_hv_nmos ad=1.408p pd=5.04u as=2.596p ps=5.58u w=4.4u l=0.6u
M4693 adc8b_0.side_cap8b_1.buf_8_0.z adc8b_0.sar12b_0.nl_sw[4] sg13cmos5l_Corner_1.vss sg13cmos5l_Corner_1.vss sg13_lv_nmos ad=0.17p pd=1.68u as=95f ps=0.88u w=0.5u l=0.13u
M4694 a_93298_93009# a_93741_92765# a_93681_93177# vdd sg13_lv_pmos ad=79.8f pd=0.8u as=63f ps=0.72u w=0.42u l=0.13u
M4695 vddr adc8b_0.side_cap8b_0.in_l_sw[2] adc8b_0.side_cap8b_0.buf_16_1.z vddr sg13_lv_pmos ad=0.19p pd=1.38u as=0.19p ps=1.38u w=1u l=0.13u
M4696 sg13cmos5l_Corner_1.vss adc8b_0.cmp_0.rdy a_82192_99596# sg13cmos5l_Corner_1.vss sg13_lv_nmos ad=0.14875p pd=1.16u as=0.187p ps=1.78u w=0.55u l=0.13u
M4697 vdd sg13cmos5l_Corner_1.vss vdd vdd sg13_lv_pmos ad=0.34p pd=2.68u as=0 ps=0 w=1u l=1u
M4698 a_87756_99600# a_87730_99564# sg13cmos5l_Corner_1.vss sg13cmos5l_Corner_1.vss sg13_lv_nmos ad=0.2516p pd=2.16u as=0.1626p ps=1.415u w=0.74u l=0.13u
M4699 a_90808_99054# a_90551_98911# a_90970_98834# sg13cmos5l_Corner_1.vss sg13_lv_nmos ad=0.1428p pd=1.52u as=37.8f ps=0.6u w=0.42u l=0.13u
M4700 adc8b_0.sar12b_0.sg13cmos5l_buf_1_40.X a_82960_92824# sg13cmos5l_Corner_1.vss sg13cmos5l_Corner_1.vss sg13_lv_nmos ad=0.2886p pd=2.26u as=0.14875p ps=1.16u w=0.74u l=0.13u
M4701 sg13cmos5l_Corner_1.iovdd a_115639_164698# sg13cmos5l_IOPadAnalog_13.pad sg13cmos5l_Corner_1.iovdd sg13_hv_pmos ad=2.1312p pd=7.3u as=3.9294p ps=7.84u w=6.66u l=0.6u
M4702 sg13cmos5l_Corner_1.iovdd a_42476_102044# vip sg13cmos5l_Corner_1.iovdd sg13_hv_pmos ad=2.1312p pd=7.3u as=3.9294p ps=7.84u w=6.66u l=0.6u
M4703 adc8b_0.side_cap8b_1.buf_8_4.z adc8b_0.sar12b_0.nl_sw[5] vddr vddr sg13_lv_pmos ad=0.19p pd=1.38u as=0.19p ps=1.38u w=1u l=0.13u
M4704 sg13cmos5l_Corner_1.iovdd a_131639_164698# sg13cmos5l_IOPadAnalog_12.pad sg13cmos5l_Corner_1.iovdd sg13_hv_pmos ad=2.1312p pd=7.3u as=3.9294p ps=7.84u w=6.66u l=0.6u
M4705 sg13cmos5l_Corner_1.vss adc8b_0.sar12b_0.sg13cmos5l_dfrbp_1_8.RESET_B a_87948_95810# sg13cmos5l_Corner_1.vss sg13_lv_nmos ad=0.1626p pd=1.415u as=60.89999f ps=0.71u w=0.42u l=0.13u
X4706 sg13cmos5l_Corner_1.vss a_108462_57198# dantenna l=3.1u w=0.64u
M4707 adc8b_0.diff_bsw_0.single_bsw_1.sg13cmos5l_inv_1$1_0.Y adc8b_0.diff_bsw_0.single_bsw_1.sg13cmos5l_inv_1$1_0.A sg13cmos5l_Corner_1.vss sg13cmos5l_Corner_1.vss sg13_lv_nmos ad=0.2516p pd=2.16u as=0.2516p ps=2.16u w=0.74u l=0.13u
M4708 sg13cmos5l_Corner_1.vss adc8b_0.sar12b_0.sg13cmos5l_dfrbp_1_6.RESET_B a_84412_95796# sg13cmos5l_Corner_1.vss sg13_lv_nmos ad=0.1406p pd=1.12u as=77.7f ps=0.95u w=0.74u l=0.13u
M4709 sg13cmos5l_Corner_1.vss a_86900_95024# adc8b_0.sar12b_0.sg13cmos5l_buf_1_44.X sg13cmos5l_Corner_1.vss sg13_lv_nmos ad=0.14875p pd=1.16u as=0.2886p ps=2.26u w=0.74u l=0.13u
M4710 sg13cmos5l_Corner_1.vss a_83992_96814# a_83641_96933# sg13cmos5l_Corner_1.vss sg13_lv_nmos ad=79.8f pd=0.8u as=0.1428p ps=1.52u w=0.42u l=0.13u
M4711 adc8b_0.sar12b_0.sg13cmos5l_dlhr_1_1.D a_83735_96933# sg13cmos5l_Corner_1.vss sg13cmos5l_Corner_1.vss sg13_lv_nmos ad=0.2849p pd=2.25u as=0.2516p ps=2.16u w=0.74u l=0.13u
M4712 adc8b_0.side_cap8b_1.buf_2_3.z adc8b_0.sar12b_0.nh_sw[9] vddr vddr sg13_lv_pmos ad=0.34p pd=2.68u as=0.19p ps=1.38u w=1u l=0.13u
M4713 vdd sg13cmos5l_IOPadVdd$1_0.sg13cmos5l_Clamp_N43N43D4R$1_0.gate sg13cmos5l_Corner_1.vss sg13cmos5l_Corner_1.vss sg13_hv_nmos ad=2.596p pd=5.58u as=1.408p ps=5.04u w=4.4u l=0.6u
M4714 vdd a_83583_95826# a_83714_95820# vdd sg13_lv_pmos ad=1.28962p pd=8.195u as=0.2856p ps=2.36u w=0.84u l=0.13u
M4715 adc8b_0.sar12b_0.sg13cmos5l_dlhr_1_2.D a_88247_93909# vdd vdd sg13_lv_pmos ad=0.4312p pd=3.01u as=0.2639p ps=1.81u w=1.12u l=0.13u
M4716 a_83937_98207# a_82995_98095# a_83735_98445# vdd sg13_lv_pmos ad=93.45f pd=0.865u as=0.2048p ps=1.63u w=0.42u l=0.13u
M4717 adc8b_0.side_cap8b_1.buf_16_1.z adc8b_0.sar12b_0.nl_sw[2] vddr vddr sg13_lv_pmos ad=0.19p pd=1.38u as=0.19p ps=1.38u w=1u l=0.13u
M4718 sg13cmos5l_Corner_1.vss a_99597_92765# a_99699_92908# sg13cmos5l_Corner_1.vss sg13_lv_nmos ad=7.01497p pd=46.005u as=0.2516p ps=2.16u w=0.74u l=0.13u
M4719 a_83252_100310# adc8b_0.sar12b_0.sg13cmos5l_inv_1_19.A vdd vdd sg13_lv_pmos ad=0.2856p pd=2.36u as=0.2114p ps=1.54u w=0.84u l=0.13u
M4720 adc8b_0.sar12b_0.sg13cmos5l_dlhr_1_15.Q_N a_100638_98816# sg13cmos5l_Corner_1.vss sg13cmos5l_Corner_1.vss sg13_lv_nmos ad=0.2516p pd=2.16u as=0.1491p ps=1.18u w=0.74u l=0.13u
M4721 adc8b_0.sar12b_0.sg13cmos5l_buf_1_59.A a_86193_98441# vdd vdd sg13_lv_pmos ad=0.3808p pd=2.92u as=0.2128p ps=1.5u w=1.12u l=0.13u
M4722 vdd a_89265_94298# a_89198_94736# vdd sg13_lv_pmos ad=0.2387p pd=1.84u as=0.1008p ps=0.9u w=0.42u l=0.13u
M4723 sg13cmos5l_Corner_1.vss adc8b_0.sar12b_0.nh_sw[2] adc8b_0.side_cap8b_1.buf_16_0.z sg13cmos5l_Corner_1.vss sg13_lv_nmos ad=95f pd=0.88u as=95f ps=0.88u w=0.5u l=0.13u
M4724 sg13cmos5l_Corner_1.iovdd a_164624_102044# sg13cmos5l_IOPadAnalog_16.pad sg13cmos5l_Corner_1.iovdd sg13_hv_pmos ad=3.1302p pd=14.26u as=3.9294p ps=7.84u w=6.66u l=0.6u
M4725 vddr adc8b_0.side_cap8b_0.in_l_sw[8] adc8b_0.side_cap8b_0.buf_2_1.z vddr sg13_lv_pmos ad=0.19p pd=1.38u as=0.34p ps=2.68u w=1u l=0.13u
M4726 a_83992_96814# a_83735_96933# a_84154_97010# sg13cmos5l_Corner_1.vss sg13_lv_nmos ad=0.1428p pd=1.52u as=37.8f ps=0.6u w=0.42u l=0.13u
M4727 a_84406_97637# a_84148_97322# vdd vdd sg13_lv_pmos ad=93.45f pd=0.865u as=1.07253p ps=6.75u w=0.42u l=0.13u
M4728 vdd adc8b_0.sar12b_0.sg13cmos5l_inv_1_0.Y a_92950_96108# vdd sg13_lv_pmos ad=0.3808p pd=2.92u as=0.2128p ps=1.5u w=1.12u l=0.13u
M4729 a_83170_95024# adc8b_0.sar12b_0.sg13cmos5l_dlygate4sd2_1_0.X sg13cmos5l_Corner_1.vss sg13cmos5l_Corner_1.vss sg13_lv_nmos ad=0.1428p pd=1.52u as=79.8f ps=0.8u w=0.42u l=0.13u
M4730 sg13cmos5l_Corner_1.vss a_85444_99124# adc8b_0.sar12b_0.sg13cmos5l_dlhr_1_9.Q sg13cmos5l_Corner_1.vss sg13_lv_nmos ad=0.1406p pd=1.12u as=0.2516p ps=2.16u w=0.74u l=0.13u
M4731 sg13cmos5l_Corner_1.vss a_178296_102044# sg13cmos5l_IOPadAnalog_16.pad sg13cmos5l_Corner_1.vss sg13_hv_nmos ad=1.408p pd=5.04u as=2.596p ps=5.58u w=4.4u l=0.6u
M4732 a_88509_96619# a_87567_96659# a_88370_96852# sg13cmos5l_Corner_1.vss sg13_lv_nmos ad=79.8f pd=0.8u as=0.2373p ps=1.97u w=0.42u l=0.13u
M4733 vdd adc8b_0.sar12b_0.sg13cmos5l_dfrbp_1_6.RESET_B a_92241_100346# vdd sg13_lv_pmos ad=0.2128p pd=1.5u as=0.2128p ps=1.5u w=1.12u l=0.13u
M4734 sg13cmos5l_Corner_1.iovdd a_99639_164698# sg13cmos5l_IOPadAnalog_15.pad sg13cmos5l_Corner_1.iovdd sg13_hv_pmos ad=2.1312p pd=7.3u as=3.9294p ps=7.84u w=6.66u l=0.6u
M4735 a_85944_98084# a_85393_98442# vdd vdd sg13_lv_pmos ad=0.105p pd=1.21u as=1.07253p ps=6.75u w=1u l=0.13u
M4736 sg13cmos5l_Corner_1.vss a_92433_98441# a_92958_98514# sg13cmos5l_Corner_1.vss sg13_lv_nmos ad=0.1491p pd=1.18u as=0.187p ps=1.78u w=0.55u l=0.13u
M4737 adc8b_0.side_cap8b_1.buf_32_0.z adc8b_0.sar12b_0.nl_sw[0] vddr vddr sg13_lv_pmos ad=0.34p pd=2.68u as=0.19p ps=1.38u w=1u l=0.13u
M4738 vdd a_88509_96619# a_87588_96933# vdd sg13_lv_pmos ad=0.36237p pd=2.605u as=0.34p ps=2.68u w=1u l=0.13u
M4739 data[0] a_70044_42476# sg13cmos5l_Corner_1.iovdd sg13cmos5l_Corner_1.iovdd sg13_hv_pmos ad=3.9294p pd=7.84u as=2.1312p ps=7.3u w=6.66u l=0.6u
M4740 frame a_134044_42476# sg13cmos5l_Corner_1.iovdd sg13cmos5l_Corner_1.iovdd sg13_hv_pmos ad=3.9294p pd=7.84u as=2.1312p ps=7.3u w=6.66u l=0.6u
M4741 vin a_42476_86044# sg13cmos5l_Corner_1.iovdd sg13cmos5l_Corner_1.iovdd sg13_hv_pmos ad=3.9294p pd=7.84u as=2.1312p ps=7.3u w=6.66u l=0.6u
M4742 a_87756_97335# a_87468_97640# a_87694_97335# sg13cmos5l_Corner_1.vss sg13_lv_nmos ad=0.1428p pd=1.52u as=37.8f ps=0.6u w=0.42u l=0.13u
M4743 vddr adc8b_0.sar12b_0.nh_sw[2] adc8b_0.side_cap8b_1.buf_16_0.z vddr sg13_lv_pmos ad=0.19p pd=1.38u as=0.19p ps=1.38u w=1u l=0.13u
M4744 a_97836_98088# a_97810_98052# vdd vdd sg13_lv_pmos ad=0.34p pd=2.68u as=0.36237p ps=2.605u w=1u l=0.13u
M4745 a_85742_93548# a_85346_93912# a_85628_93548# vdd sg13_lv_pmos ad=0.1008p pd=0.9u as=0.191p ps=1.44u w=0.42u l=0.13u
M4746 sg13cmos5l_IOPadAnalog_9.pad a_83639_178370# sg13cmos5l_Corner_1.vss sg13cmos5l_Corner_1.vss sg13_hv_nmos ad=2.596p pd=5.58u as=1.408p ps=5.04u w=4.4u l=0.6u
M4747 adc8b_0.side_cap8b_0.buf_16_0.z adc8b_0.side_cap8b_0.in_h_sw[2] sg13cmos5l_Corner_1.vss sg13cmos5l_Corner_1.vss sg13_lv_nmos ad=95f pd=0.88u as=95f ps=0.88u w=0.5u l=0.13u
M4748 a_97268_100310# adc8b_0.sar12b_0.sg13cmos5l_buf_1_95.X sg13cmos5l_Corner_1.vss sg13cmos5l_Corner_1.vss sg13_lv_nmos ad=0.187p pd=1.78u as=0.14875p ps=1.16u w=0.55u l=0.13u
M4749 a_94335_98442# adc8b_0.sar12b_0.sg13cmos5l_dlhr_1_11.GATE sg13cmos5l_Corner_1.vss sg13cmos5l_Corner_1.vss sg13_lv_nmos ad=0.2516p pd=2.16u as=0.15055p ps=1.17u w=0.74u l=0.13u
M4750 a_92557_95814# adc8b_0.sar12b_0.sg13cmos5l_a221oi_1_0.C1 sg13cmos5l_Corner_1.vss sg13cmos5l_Corner_1.vss sg13_lv_nmos ad=0.1406p pd=1.12u as=0.14505p ps=1.15u w=0.74u l=0.13u
M4751 sg13cmos5l_IOPadAnalog_15.pad a_99639_164698# sg13cmos5l_Corner_1.iovdd sg13cmos5l_Corner_1.iovdd sg13_hv_pmos ad=3.9294p pd=7.84u as=2.1312p ps=7.3u w=6.66u l=0.6u
M4752 a_101113_97314# a_100561_97376# sg13cmos5l_Corner_1.vss sg13cmos5l_Corner_1.vss sg13_lv_nmos ad=71.99999f pd=0.865u as=1.97045p ps=12.335u w=0.64u l=0.13u
M4753 sg13cmos5l_Corner_1.iovdd a_164624_86044# sg13cmos5l_IOPadAnalog_0.pad sg13cmos5l_Corner_1.iovdd sg13_hv_pmos ad=2.1312p pd=7.3u as=3.9294p ps=7.84u w=6.66u l=0.6u
M4754 sg13cmos5l_Corner_1.vss a_94744_93790# a_94393_93909# sg13cmos5l_Corner_1.vss sg13_lv_nmos ad=79.8f pd=0.8u as=0.1428p ps=1.52u w=0.42u l=0.13u
M4755 sg13cmos5l_IOPadAnalog_13.pad a_115639_164698# sg13cmos5l_Corner_1.iovdd sg13cmos5l_Corner_1.iovdd sg13_hv_pmos ad=3.9294p pd=7.84u as=2.1312p ps=7.3u w=6.66u l=0.6u
M4756 a_96764_96572# a_96482_96936# a_96697_96974# sg13cmos5l_Corner_1.vss sg13_lv_nmos ad=0.141p pd=1.17u as=71.99999f ps=0.865u w=0.64u l=0.13u
M4757 vdd adc8b_0.cmp_0.outn adc8b_0.cmp_0.outp vdd sg13_lv_pmos ad=0.2375p pd=1.63u as=0.425p ps=3.18u w=1.25u l=0.13u
M4758 vddr adc8b_0.sar12b_0.nl_sw[4] adc8b_0.side_cap8b_1.buf_8_0.z vddr sg13_lv_pmos ad=0.19p pd=1.38u as=0.19p ps=1.38u w=1u l=0.13u
M4759 sg13cmos5l_Corner_1.vss a_115639_178370# sg13cmos5l_IOPadAnalog_13.pad sg13cmos5l_Corner_1.vss sg13_hv_nmos ad=1.408p pd=5.04u as=2.596p ps=5.58u w=4.4u l=0.6u
M4760 sg13cmos5l_Corner_1.iovdd a_83639_164698# sg13cmos5l_IOPadAnalog_9.pad sg13cmos5l_Corner_1.iovdd sg13_hv_pmos ad=2.1312p pd=7.3u as=3.9294p ps=7.84u w=6.66u l=0.6u
M4761 sg13cmos5l_Corner_1.vss adc8b_0.sar12b_0.sg13cmos5l_buf_1_65.X a_90256_100384# sg13cmos5l_Corner_1.vss sg13_lv_nmos ad=0.14875p pd=1.16u as=0.187p ps=1.78u w=0.55u l=0.13u
M4762 a_76796_95659# adc8b_0.cmp_0.outp adc8b_0.cmp_0.outn sg13cmos5l_Corner_1.vss sg13_lv_nmos ad=1.7p pd=10.68u as=0.95p ps=5.38u w=5u l=0.13u
X4763 sg13cmos5l_IOPadAnalog_16.padres sg13cmos5l_IOPadAnalog_16.pad sg13cmos5l_Corner_1.vss rppd l=2u w=1u
M4764 sg13cmos5l_Corner_1.vss a_131639_178370# sg13cmos5l_IOPadAnalog_12.pad sg13cmos5l_Corner_1.vss sg13_hv_nmos ad=1.408p pd=5.04u as=2.596p ps=5.58u w=4.4u l=0.6u
M4765 adc8b_0.side_cap8b_1.buf_32_0.z adc8b_0.sar12b_0.nl_sw[0] vddr vddr sg13_lv_pmos ad=0.19p pd=1.38u as=0.19p ps=1.38u w=1u l=0.13u
M4766 adc8b_0.side_cap8b_0.buf_32_0.z adc8b_0.side_cap8b_0.in_l_sw[0] sg13cmos5l_Corner_1.vss sg13cmos5l_Corner_1.vss sg13_lv_nmos ad=95f pd=0.88u as=95f ps=0.88u w=0.5u l=0.13u
M4767 adc8b_0.side_cap8b_0.buf_8_4.z adc8b_0.side_cap8b_0.in_l_sw[5] vddr vddr sg13_lv_pmos ad=0.19p pd=1.38u as=0.19p ps=1.38u w=1u l=0.13u
M4768 a_83630_100034# adc8b_0.sar12b_0.sg13cmos5l_dfrbp_1_17.D vdd vdd sg13_lv_pmos ad=79.8f pd=0.8u as=0.1428p ps=1.52u w=0.42u l=0.13u
M4769 a_98074_100034# adc8b_0.sar12b_0.sg13cmos5l_dfrbp_1_8.RESET_B sg13cmos5l_Corner_1.vss sg13cmos5l_Corner_1.vss sg13_lv_nmos ad=37.8f pd=0.6u as=79.8f ps=0.8u w=0.42u l=0.13u
M4770 a_68892_96252# a_68824_96348# vdd sg13cmos5l_Corner_1.vss sg13_lv_nmos ad=0.442p pd=3.28u as=0.442p ps=3.28u w=1.3u l=0.13u
M4771 sg13cmos5l_Corner_1.iovdd a_118044_42476# cko sg13cmos5l_Corner_1.iovdd sg13_hv_pmos ad=2.1312p pd=7.3u as=3.9294p ps=7.84u w=6.66u l=0.6u
M4772 adc8b_0.sar12b_0.sg13cmos5l_dlhr_1_0.Q_N a_89982_92768# vdd vdd sg13_lv_pmos ad=0.3808p pd=2.92u as=0.1974p ps=1.5u w=1.12u l=0.13u
M4773 vddr adc8b_0.side_cap8b_0.in_l_sw[1] adc8b_0.side_cap8b_0.buf_16_2.z vddr sg13_lv_pmos ad=0.19p pd=1.38u as=0.19p ps=1.38u w=1u l=0.13u
M4774 vdd adc8b_0.sar12b_0.sg13cmos5l_dfrbp_1_6.RESET_B a_97742_97322# vdd sg13_lv_pmos ad=0.36237p pd=2.605u as=79.8f ps=0.8u w=0.42u l=0.13u
M4775 a_84980_92750# adc8b_0.sar12b_0.sg13cmos5l_buf_1_41.A vdd vdd sg13_lv_pmos ad=0.2856p pd=2.36u as=0.2114p ps=1.54u w=0.84u l=0.13u
M4776 a_87405_93559# adc8b_0.sar12b_0.sg13cmos5l_dlhr_1_0.GATE sg13cmos5l_Corner_1.vss sg13cmos5l_Corner_1.vss sg13_lv_nmos ad=0.2516p pd=2.16u as=2.59257p ps=16.445u w=0.74u l=0.13u
M4777 sg13cmos5l_Corner_1.vss sg13cmos5l_IOPadVdd$1_0.sg13cmos5l_Clamp_N43N43D4R$1_0.gate vdd sg13cmos5l_Corner_1.vss sg13_hv_nmos ad=1.408p pd=5.04u as=2.596p ps=5.58u w=4.4u l=0.6u
M4778 adc8b_0.side_cap8b_0.buf_32_0.z adc8b_0.side_cap8b_0.in_l_sw[0] vddr vddr sg13_lv_pmos ad=0.19p pd=1.38u as=0.19p ps=1.38u w=1u l=0.13u
M4779 sg13cmos5l_Corner_1.vss a_89972_100310# adc8b_0.sar12b_0.sg13cmos5l_buf_1_74.X sg13cmos5l_Corner_1.vss sg13_lv_nmos ad=0.14875p pd=1.16u as=0.2886p ps=2.26u w=0.74u l=0.13u
M4780 a_84599_98790# adc8b_0.sar12b_0.sg13cmos5l_dfrbp_1_16.Q_N sg13cmos5l_Corner_1.vss sg13cmos5l_Corner_1.vss sg13_lv_nmos ad=0.187p pd=1.78u as=0.15055p ps=1.17u w=0.55u l=0.13u
M4781 adc8b_0.sar12b_0.sg13cmos5l_dlhr_1_0.D a_89084_93548# sg13cmos5l_Corner_1.vss sg13cmos5l_Corner_1.vss sg13_lv_nmos ad=0.2516p pd=2.16u as=0.1406p ps=1.12u w=0.74u l=0.13u
M4782 sg13cmos5l_Corner_1.vss a_86044_30676# data[1] sg13cmos5l_Corner_1.vss sg13_hv_nmos ad=1.408p pd=5.04u as=2.596p ps=5.58u w=4.4u l=0.6u
M4783 a_93585_93595# a_93228_93552# vdd vdd sg13_lv_pmos ad=63f pd=0.72u as=0.1563p ps=1.22u w=0.42u l=0.13u
M4784 vdd adc8b_0.sar12b_0.sg13cmos5l_inv_1_18.A adc8b_0.sar12b_0.sg13cmos5l_buf_1_28.A vdd sg13_lv_pmos ad=0.3808p pd=2.92u as=0.3808p ps=2.92u w=1.12u l=0.13u
M4785 sg13cmos5l_Corner_1.vss adc8b_0.sar12b_0.sg13cmos5l_buf_1_41.X a_84592_93548# sg13cmos5l_Corner_1.vss sg13_lv_nmos ad=0.14875p pd=1.16u as=0.187p ps=1.78u w=0.55u l=0.13u
M4786 vip a_42476_102044# sg13cmos5l_Corner_1.iovdd sg13cmos5l_Corner_1.iovdd sg13_hv_pmos ad=3.9294p pd=7.84u as=3.1302p ps=14.26u w=6.66u l=0.6u
M4787 sg13cmos5l_Corner_1.vss adc8b_0.side_cap8b_0.in_h_sw[8] adc8b_0.side_cap8b_0.buf_2_0.z sg13cmos5l_Corner_1.vss sg13_lv_nmos ad=95f pd=0.88u as=0.17p ps=1.68u w=0.5u l=0.13u
M4788 sg13cmos5l_Corner_1.iovdd a_86044_42476# data[1] sg13cmos5l_Corner_1.iovdd sg13_hv_pmos ad=3.1302p pd=14.26u as=3.9294p ps=7.84u w=6.66u l=0.6u
M4789 a_87470_100034# a_88275_99607# a_87730_99564# vdd sg13_lv_pmos ad=0.1428p pd=1.52u as=79.8f ps=0.8u w=0.42u l=0.13u
M4790 sg13cmos5l_IOPadAnalog_1.pad a_178296_70044# sg13cmos5l_Corner_1.vss sg13cmos5l_Corner_1.vss sg13_hv_nmos ad=2.596p pd=5.58u as=1.408p ps=5.04u w=4.4u l=0.6u
M4791 sg13cmos5l_Corner_1.iovdd a_164624_118044# sg13cmos5l_IOPadAnalog_11.pad sg13cmos5l_Corner_1.iovdd sg13_hv_pmos ad=2.1312p pd=7.3u as=3.9294p ps=7.84u w=6.66u l=0.6u
M4792 sg13cmos5l_Corner_1.vss a_96692_92750# adc8b_0.sar12b_0.nh_sw[6] sg13cmos5l_Corner_1.vss sg13_lv_nmos ad=0.14875p pd=1.16u as=0.2886p ps=2.26u w=0.74u l=0.13u
M4793 data[0] a_70044_42476# sg13cmos5l_Corner_1.iovdd sg13cmos5l_Corner_1.iovdd sg13_hv_pmos ad=3.9294p pd=7.84u as=2.1312p ps=7.3u w=6.66u l=0.6u
M4794 adc8b_0.sar12b_0.sg13cmos5l_buf_1_18.X a_100144_93548# sg13cmos5l_Corner_1.vss sg13cmos5l_Corner_1.vss sg13_lv_nmos ad=0.2886p pd=2.26u as=0.14875p ps=1.16u w=0.74u l=0.13u
M4795 adc8b_0.side_cap8b_0.buf_16_1.z adc8b_0.side_cap8b_0.in_l_sw[2] vddr vddr sg13_lv_pmos ad=0.19p pd=1.38u as=0.19p ps=1.38u w=1u l=0.13u
M4796 sg13cmos5l_Corner_1.iovdd a_67639_164698# sg13cmos5l_IOPadAnalog_10.pad sg13cmos5l_Corner_1.iovdd sg13_hv_pmos ad=2.1312p pd=7.3u as=3.9294p ps=7.84u w=6.66u l=0.6u
M4797 a_89972_100310# adc8b_0.sar12b_0.sg13cmos5l_buf_1_45.X sg13cmos5l_Corner_1.vss sg13cmos5l_Corner_1.vss sg13_lv_nmos ad=0.187p pd=1.78u as=0.14875p ps=1.16u w=0.55u l=0.13u
M4798 vip a_42476_102044# sg13cmos5l_Corner_1.iovdd sg13cmos5l_Corner_1.iovdd sg13_hv_pmos ad=3.9294p pd=7.84u as=2.1312p ps=7.3u w=6.66u l=0.6u
M4799 sg13cmos5l_Corner_1.iovdd a_42476_70044# vddr sg13cmos5l_Corner_1.iovdd sg13_hv_pmos ad=2.1312p pd=7.3u as=3.9294p ps=7.84u w=6.66u l=0.6u
M4800 adc8b_0.sar12b_0.sg13cmos5l_dlhr_1_11.D a_93335_98911# vdd vdd sg13_lv_pmos ad=0.4312p pd=3.01u as=0.2639p ps=1.81u w=1.12u l=0.13u
M4801 sg13cmos5l_Corner_1.vss a_118044_30676# cko sg13cmos5l_Corner_1.vss sg13_hv_nmos ad=1.408p pd=5.04u as=2.596p ps=5.58u w=4.4u l=0.6u
M4802 adc8b_0.sar12b_0.sg13cmos5l_dlhr_1_11.GATE a_92636_99596# sg13cmos5l_Corner_1.vss sg13cmos5l_Corner_1.vss sg13_lv_nmos ad=0.2516p pd=2.16u as=0.1406p ps=1.12u w=0.74u l=0.13u
M4803 data[2] a_102044_30676# sg13cmos5l_Corner_1.vss sg13cmos5l_Corner_1.vss sg13_hv_nmos ad=2.596p pd=5.58u as=1.408p ps=5.04u w=4.4u l=0.6u
M4804 vddr adc8b_0.sar12b_0.nh_sw[7] adc8b_0.side_cap8b_1.buf_4_2.z vddr sg13_lv_pmos ad=0.19p pd=1.38u as=0.19p ps=1.38u w=1u l=0.13u
M4805 sg13cmos5l_Corner_1.vss adc8b_0.sar12b_0.nl_sw[0] adc8b_0.side_cap8b_1.buf_32_0.z sg13cmos5l_Corner_1.vss sg13_lv_nmos ad=95f pd=0.88u as=95f ps=0.88u w=0.5u l=0.13u
M4806 vdd sg13cmos5l_IOPadVdd$1_0.sg13cmos5l_Clamp_N43N43D4R$1_0.gate sg13cmos5l_Corner_1.vss sg13cmos5l_Corner_1.vss sg13_hv_nmos ad=2.596p pd=5.58u as=1.408p ps=5.04u w=4.4u l=0.6u
M4807 a_96063_98442# adc8b_0.sar12b_0.sg13cmos5l_dfrbp_1_23.CLK vdd vdd sg13_lv_pmos ad=0.3234p pd=2.45u as=1.04815p ps=6.595u w=0.84u l=0.13u
M4808 vdd adc8b_0.sar12b_0.sg13cmos5l_buf_8_1.A a_100131_95430# vdd sg13_lv_pmos ad=0.2128p pd=1.5u as=0.3808p ps=2.92u w=1.12u l=0.13u
M4809 sg13cmos5l_IOPadAnalog_15.pad a_99639_178370# sg13cmos5l_Corner_1.vss sg13cmos5l_Corner_1.vss sg13_hv_nmos ad=2.596p pd=5.58u as=1.408p ps=5.04u w=4.4u l=0.6u
M4810 sg13cmos5l_IOPadAnalog_10.pad a_67639_164698# sg13cmos5l_Corner_1.iovdd sg13cmos5l_Corner_1.iovdd sg13_hv_pmos ad=3.9294p pd=7.84u as=2.1312p ps=7.3u w=6.66u l=0.6u
M4811 adc8b_0.sar12b_0.sg13cmos5l_dlhr_1_15.D a_98876_99132# vdd vdd sg13_lv_pmos ad=0.3808p pd=2.92u as=0.2128p ps=1.5u w=1.12u l=0.13u
M4812 sg13cmos5l_IOPadAnalog_0.pad a_164624_86044# sg13cmos5l_Corner_1.iovdd sg13cmos5l_Corner_1.iovdd sg13_hv_pmos ad=3.9294p pd=7.84u as=3.1302p ps=14.26u w=6.66u l=0.6u
M4813 sg13cmos5l_IOPadAnalog_13.pad a_115639_178370# sg13cmos5l_Corner_1.vss sg13cmos5l_Corner_1.vss sg13_hv_nmos ad=2.596p pd=5.58u as=1.408p ps=5.04u w=4.4u l=0.6u
M4814 sg13cmos5l_IOPadAnalog_9.pad a_83639_164698# sg13cmos5l_Corner_1.iovdd sg13cmos5l_Corner_1.iovdd sg13_hv_pmos ad=3.9294p pd=7.84u as=2.1312p ps=7.3u w=6.66u l=0.6u
M4815 vdd adc8b_0.sar12b_0.sg13cmos5l_inv_1_18.A a_91024_100384# vdd sg13_lv_pmos ad=0.2114p pd=1.54u as=0.2856p ps=2.36u w=0.84u l=0.13u
M4816 vdd a_95409_98834# a_95934_98816# vdd sg13_lv_pmos ad=0.1974p pd=1.5u as=0.2856p ps=2.36u w=0.84u l=0.13u
M4817 a_85694_97335# a_84516_97286# a_85298_97480# sg13cmos5l_Corner_1.vss sg13_lv_nmos ad=37.8f pd=0.6u as=0.1428p ps=1.52u w=0.42u l=0.13u
M4818 vdd adc8b_0.sar12b_0.sg13cmos5l_dfrbp_1_6.RESET_B a_83822_94298# vdd sg13_lv_pmos ad=0.36237p pd=2.605u as=79.8f ps=0.8u w=0.42u l=0.13u
X4819 a_118044_30676# sg13cmos5l_Corner_1.vss sg13cmos5l_Corner_1.vss rppd l=3.54u w=0.5u
M4820 vdd a_95159_100423# a_95996_100644# vdd sg13_lv_pmos ad=0.2128p pd=1.5u as=0.3864p ps=2.93u w=1.12u l=0.13u
M4821 a_93984_96888# adc8b_0.sar12b_0.sg13cmos5l_or2_1_1.B a_94126_96548# vdd sg13_lv_pmos ad=0.2856p pd=2.36u as=0.1596p ps=1.22u w=0.84u l=0.13u
X4822 sg13cmos5l_IOPadAnalog_2.padres sg13cmos5l_Corner_1.iovdd dpantenna l=0.64u w=4.98u
M4823 sg13cmos5l_Corner_1.vss a_83639_178370# sg13cmos5l_IOPadAnalog_9.pad sg13cmos5l_Corner_1.vss sg13_hv_nmos ad=1.408p pd=5.04u as=2.596p ps=5.58u w=4.4u l=0.6u
M4824 sg13cmos5l_Corner_1.vss sg13cmos5l_IOPadVdd$1_0.sg13cmos5l_Clamp_N43N43D4R$1_0.gate vdd sg13cmos5l_Corner_1.vss sg13_hv_nmos ad=1.408p pd=5.04u as=2.596p ps=5.58u w=4.4u l=0.6u
M4825 vddr adc8b_0.sar12b_0.nl_sw[2] adc8b_0.side_cap8b_1.buf_16_1.z vddr sg13_lv_pmos ad=0.19p pd=1.38u as=0.19p ps=1.38u w=1u l=0.13u
M4826 data[2] a_102044_42476# sg13cmos5l_Corner_1.iovdd sg13cmos5l_Corner_1.iovdd sg13_hv_pmos ad=3.9294p pd=7.84u as=3.1302p ps=14.26u w=6.66u l=0.6u
M4827 sg13cmos5l_Corner_1.vss adc8b_0.sar12b_0.nl_sw[7] adc8b_0.side_cap8b_1.buf_4_0.z sg13cmos5l_Corner_1.vss sg13_lv_nmos ad=95f pd=0.88u as=95f ps=0.88u w=0.5u l=0.13u
M4828 sg13cmos5l_Corner_1.iovdd a_115639_164698# sg13cmos5l_IOPadAnalog_13.pad sg13cmos5l_Corner_1.iovdd sg13_hv_pmos ad=2.1312p pd=7.3u as=3.9294p ps=7.84u w=6.66u l=0.6u
M4829 vdd adc8b_0.sar12b_0.sg13cmos5l_buf_1_30.A a_90448_92824# vdd sg13_lv_pmos ad=0.2114p pd=1.54u as=0.2856p ps=2.36u w=0.84u l=0.13u
M4830 adc8b_0.side_cap8b_0.buf_8_5.z adc8b_0.side_cap8b_0.in_h_sw[5] sg13cmos5l_Corner_1.vss sg13cmos5l_Corner_1.vss sg13_lv_nmos ad=95f pd=0.88u as=95f ps=0.88u w=0.5u l=0.13u
M4831 a_85356_96128# a_85875_95932# a_86615_95887# sg13cmos5l_Corner_1.vss sg13_lv_nmos ad=0.3473p pd=2.71u as=0.12665p ps=1.145u w=0.74u l=0.13u
M4832 a_93874_100569# a_94317_100325# a_93614_100346# sg13cmos5l_Corner_1.vss sg13_lv_nmos ad=79.8f pd=0.8u as=0.1296p ps=1.52u w=0.42u l=0.13u
M4833 sg13cmos5l_Corner_1.vss adc8b_0.sar12b_0.sg13cmos5l_a221oi_1_1.C1 adc8b_0.sar12b_0.sg13cmos5l_a22oi_1_2.B2 sg13cmos5l_Corner_1.vss sg13_lv_nmos ad=0.1406p pd=1.12u as=0.2516p ps=2.16u w=0.74u l=0.13u
M4834 adc8b_0.side_cap8b_0.buf_16_3.z adc8b_0.side_cap8b_0.in_h_sw[1] sg13cmos5l_Corner_1.vss sg13cmos5l_Corner_1.vss sg13_lv_nmos ad=95f pd=0.88u as=95f ps=0.88u w=0.5u l=0.13u
M4835 a_93614_100346# a_94419_100468# a_93874_100569# vdd sg13_lv_pmos ad=0.1428p pd=1.52u as=79.8f ps=0.8u w=0.42u l=0.13u
M4836 vddr a_42476_70044# sg13cmos5l_Corner_1.iovdd sg13cmos5l_Corner_1.iovdd sg13_hv_pmos ad=3.9294p pd=7.84u as=2.1312p ps=7.3u w=6.66u l=0.6u
M4837 adc8b_0.sar12b_0.sg13cmos5l_buf_1_111.A a_101008_98872# sg13cmos5l_Corner_1.vss sg13cmos5l_Corner_1.vss sg13_lv_nmos ad=0.2886p pd=2.26u as=0.14875p ps=1.16u w=0.74u l=0.13u
M4838 sg13cmos5l_IOPadAnalog_16.pad a_164624_102044# sg13cmos5l_Corner_1.iovdd sg13cmos5l_Corner_1.iovdd sg13_hv_pmos ad=3.9294p pd=7.84u as=2.1312p ps=7.3u w=6.66u l=0.6u
M4839 a_98230_95498# a_98471_95031# a_97589_95024# sg13cmos5l_Corner_1.vss sg13_lv_nmos ad=0.1428p pd=1.52u as=0.12665p ps=1.145u w=0.42u l=0.13u
M4840 sg13cmos5l_Corner_1.iovdd a_86044_42476# data[1] sg13cmos5l_Corner_1.iovdd sg13_hv_pmos ad=2.1312p pd=7.3u as=3.9294p ps=7.84u w=6.66u l=0.6u
M4841 sg13cmos5l_Corner_1.iovdd a_164624_86044# sg13cmos5l_IOPadAnalog_0.pad sg13cmos5l_Corner_1.iovdd sg13_hv_pmos ad=2.1312p pd=7.3u as=3.9294p ps=7.84u w=6.66u l=0.6u
M4842 vdd sg13cmos5l_IOPadVdd$1_0.sg13cmos5l_Clamp_N43N43D4R$1_0.gate sg13cmos5l_Corner_1.vss sg13cmos5l_Corner_1.vss sg13_hv_nmos ad=2.596p pd=5.58u as=1.408p ps=5.04u w=4.4u l=0.6u
M4843 adc8b_0.side_cap8b_0.buf_16_3.z adc8b_0.side_cap8b_0.in_h_sw[1] vddr vddr sg13_lv_pmos ad=0.19p pd=1.38u as=0.19p ps=1.38u w=1u l=0.13u
M4844 adc8b_0.side_cap8b_0.buf_8_5.z adc8b_0.side_cap8b_0.in_h_sw[5] vddr vddr sg13_lv_pmos ad=0.19p pd=1.38u as=0.19p ps=1.38u w=1u l=0.13u
M4845 sg13cmos5l_Corner_1.vss a_30676_118044# cks sg13cmos5l_Corner_1.vss sg13_hv_nmos ad=1.408p pd=5.04u as=2.596p ps=5.58u w=4.4u l=0.6u
M4846 vdd a_86615_95887# a_86872_96030# vdd sg13_lv_pmos ad=0.2639p pd=1.81u as=79.8f ps=0.8u w=0.42u l=0.13u
M4847 vdd a_94583_95421# a_95420_95060# vdd sg13_lv_pmos ad=0.2128p pd=1.5u as=0.3864p ps=2.93u w=1.12u l=0.13u
M4848 sg13cmos5l_IOPadAnalog_16.pad a_178296_102044# sg13cmos5l_Corner_1.vss sg13cmos5l_Corner_1.vss sg13_hv_nmos ad=2.596p pd=5.58u as=2.068p ps=9.74u w=4.4u l=0.6u
M4849 vdd sg13cmos5l_IOPadVdd$1_0.sg13cmos5l_Clamp_N43N43D4R$1_0.gate sg13cmos5l_Corner_1.vss sg13cmos5l_Corner_1.vss sg13_hv_nmos ad=2.596p pd=5.58u as=1.408p ps=5.04u w=4.4u l=0.6u
M4850 adc8b_0.sar12b_0.sg13cmos5l_dlhr_1_5.D a_88727_97399# vdd vdd sg13_lv_pmos ad=0.4312p pd=3.01u as=0.2639p ps=1.81u w=1.12u l=0.13u
X4851 sg13cmos5l_Corner_1.vss a_118222_175886# dantenna l=1.26u w=27.78u
M4852 vin a_30676_86044# sg13cmos5l_Corner_1.vss sg13cmos5l_Corner_1.vss sg13_hv_nmos ad=2.596p pd=5.58u as=1.408p ps=5.04u w=4.4u l=0.6u
M4853 sg13cmos5l_Corner_1.vss a_97268_100310# adc8b_0.side_cap8b_0.in_h_sw[6] sg13cmos5l_Corner_1.vss sg13_lv_nmos ad=0.14875p pd=1.16u as=0.2886p ps=2.26u w=0.74u l=0.13u
M4854 a_96892_98472# a_96476_98084# a_96657_98441# sg13cmos5l_Corner_1.vss sg13_lv_nmos ad=77.7f pd=0.95u as=0.2516p ps=2.16u w=0.74u l=0.13u
M4855 adc8b_0.sar12b_0.sg13cmos5l_dfrbp_1_4.Q_N a_94487_93909# vdd vdd sg13_lv_pmos ad=0.4312p pd=3.01u as=0.2639p ps=1.81u w=1.12u l=0.13u
M4856 sg13cmos5l_Corner_1.vss adc8b_0.sar12b_0.sg13cmos5l_inv_1_6.A a_101776_99596# sg13cmos5l_Corner_1.vss sg13_lv_nmos ad=0.14875p pd=1.16u as=0.187p ps=1.78u w=0.55u l=0.13u
M4857 a_96494_98834# adc8b_0.sar12b_0.sg13cmos5l_buf_1_57.X vdd vdd sg13_lv_pmos ad=79.8f pd=0.8u as=0.1428p ps=1.52u w=0.42u l=0.13u
M4858 a_86090_97322# adc8b_0.sar12b_0.sg13cmos5l_dfrbp_1_8.RESET_B sg13cmos5l_Corner_1.vss sg13cmos5l_Corner_1.vss sg13_lv_nmos ad=60.89999f pd=0.71u as=0.1626p ps=1.415u w=0.42u l=0.13u
M4859 sg13cmos5l_Corner_1.vss adc8b_0.sar12b_0.sg13cmos5l_inv_1_6.A adc8b_0.sar12b_0.sg13cmos5l_buf_1_0.A sg13cmos5l_Corner_1.vss sg13_lv_nmos ad=0.2516p pd=2.16u as=0.2516p ps=2.16u w=0.74u l=0.13u
M4860 vdd a_94583_95421# a_94840_95302# vdd sg13_lv_pmos ad=0.2639p pd=1.81u as=79.8f ps=0.8u w=0.42u l=0.13u
M4861 adc8b_0.sar12b_0.sg13cmos5l_dlhr_1_2.Q_N a_89790_94280# vdd vdd sg13_lv_pmos ad=0.3808p pd=2.92u as=0.1974p ps=1.5u w=1.12u l=0.13u
M4862 sg13cmos5l_IOPadAnalog_16.pad a_178296_102044# sg13cmos5l_Corner_1.vss sg13cmos5l_Corner_1.vss sg13_hv_nmos ad=2.596p pd=5.58u as=1.408p ps=5.04u w=4.4u l=0.6u
M4863 a_97644_98522# adc8b_0.sar12b_0.sg13cmos5l_dfrbp_1_22.D a_97550_98522# sg13cmos5l_Corner_1.vss sg13_lv_nmos ad=60.89999f pd=0.71u as=0.1428p ps=1.52u w=0.42u l=0.13u
M4864 sg13cmos5l_Corner_1.vss a_90356_93512# adc8b_0.sar12b_0.nl_sw[4] sg13cmos5l_Corner_1.vss sg13_lv_nmos ad=0.14875p pd=1.16u as=0.2886p ps=2.26u w=0.74u l=0.13u
M4865 vddr adc8b_0.sar12b_0.nl_sw[0] adc8b_0.side_cap8b_1.buf_32_0.z vddr sg13_lv_pmos ad=0.19p pd=1.38u as=0.19p ps=1.38u w=1u l=0.13u
M4866 vin a_42476_86044# sg13cmos5l_Corner_1.iovdd sg13cmos5l_Corner_1.iovdd sg13_hv_pmos ad=3.9294p pd=7.84u as=2.1312p ps=7.3u w=6.66u l=0.6u
M4867 sg13cmos5l_Corner_1.vss a_90225_98441# a_90180_98486# sg13cmos5l_Corner_1.vss sg13_lv_nmos ad=0.1428p pd=1.52u as=47.25f ps=0.645u w=0.42u l=0.13u
M4868 sg13cmos5l_Corner_1.vss adc8b_0.sar12b_0.sg13cmos5l_buf_1_25.X a_86224_92824# sg13cmos5l_Corner_1.vss sg13_lv_nmos ad=0.14875p pd=1.16u as=0.187p ps=1.78u w=0.55u l=0.13u
M4869 sg13cmos5l_Corner_1.vss adc8b_0.side_cap8b_0.in_l_sw[0] adc8b_0.side_cap8b_0.buf_32_0.z sg13cmos5l_Corner_1.vss sg13_lv_nmos ad=95f pd=0.88u as=95f ps=0.88u w=0.5u l=0.13u
M4870 sg13cmos5l_Corner_1.vss adc8b_0.sar12b_0.sg13cmos5l_buf_1_98.A a_95536_99596# sg13cmos5l_Corner_1.vss sg13_lv_nmos ad=0.14875p pd=1.16u as=0.187p ps=1.78u w=0.55u l=0.13u
M4871 adc8b_0.sar12b_0.sg13cmos5l_buf_8_0.X a_100995_95814# vdd vdd sg13_lv_pmos ad=0.2128p pd=1.5u as=0.2128p ps=1.5u w=1.12u l=0.13u
M4872 sg13cmos5l_IOPadAnalog_10.pad a_67639_178370# sg13cmos5l_Corner_1.vss sg13cmos5l_Corner_1.vss sg13_hv_nmos ad=2.596p pd=5.58u as=1.408p ps=5.04u w=4.4u l=0.6u
M4873 adc8b_0.side_cap8b_0.buf_32_0.z adc8b_0.side_cap8b_0.in_l_sw[0] vddr vddr sg13_lv_pmos ad=0.19p pd=1.38u as=0.19p ps=1.38u w=1u l=0.13u
X4874 sg13cmos5l_IOPadAnalog_6.padres sg13cmos5l_Corner_1.iovdd dpantenna l=0.64u w=4.98u
M4875 sg13cmos5l_Corner_1.iovdd a_118044_42476# cko sg13cmos5l_Corner_1.iovdd sg13_hv_pmos ad=2.1312p pd=7.3u as=3.9294p ps=7.84u w=6.66u l=0.6u
M4876 a_85215_93906# adc8b_0.sar12b_0.sg13cmos5l_dfrbp_1_9.Q vdd vdd sg13_lv_pmos ad=0.3234p pd=2.45u as=1.86162p ps=11.935u w=0.84u l=0.13u
M4877 sg13cmos5l_IOPadAnalog_9.pad a_83639_178370# sg13cmos5l_Corner_1.vss sg13cmos5l_Corner_1.vss sg13_hv_nmos ad=2.596p pd=5.58u as=1.408p ps=5.04u w=4.4u l=0.6u
M4878 vdd sg13cmos5l_IOPadVdd$1_0.sg13cmos5l_Clamp_N43N43D4R$1_0.gate sg13cmos5l_Corner_1.vss sg13cmos5l_Corner_1.vss sg13_hv_nmos ad=2.596p pd=5.58u as=1.408p ps=5.04u w=4.4u l=0.6u
M4879 vdd a_83614_99010# adc8b_0.sar12b_0.sg13cmos5l_dlhr_1_8.Q_N vdd sg13_lv_pmos ad=0.1974p pd=1.5u as=0.3808p ps=2.92u w=1.12u l=0.13u
M4880 vdd adc8b_0.sar12b_0.sg13cmos5l_dfrbp_1_6.RESET_B a_82190_97010# vdd sg13_lv_pmos ad=0.36237p pd=2.605u as=79.8f ps=0.8u w=0.42u l=0.13u
M4881 a_82926_94302# a_82670_94302# vdd vdd sg13_lv_pmos ad=0.34p pd=2.68u as=0.2481p ps=1.56u w=1u l=0.25u
M4882 a_92184_98084# a_91633_98442# vdd vdd sg13_lv_pmos ad=0.105p pd=1.21u as=1.07253p ps=6.75u w=1u l=0.13u
M4883 sg13cmos5l_Corner_1.iovdd a_164624_70044# sg13cmos5l_IOPadAnalog_1.pad sg13cmos5l_Corner_1.iovdd sg13_hv_pmos ad=2.1312p pd=7.3u as=3.9294p ps=7.84u w=6.66u l=0.6u
M4884 vdd sg13cmos5l_Corner_1.vss vdd vdd sg13_lv_pmos ad=0.34p pd=2.68u as=0 ps=0 w=1u l=1u
M4885 sg13cmos5l_Corner_1.vss a_115639_178370# sg13cmos5l_IOPadAnalog_13.pad sg13cmos5l_Corner_1.vss sg13_hv_nmos ad=1.408p pd=5.04u as=2.596p ps=5.58u w=4.4u l=0.6u
M4886 sg13cmos5l_Corner_1.iovdd a_83639_164698# sg13cmos5l_IOPadAnalog_9.pad sg13cmos5l_Corner_1.iovdd sg13_hv_pmos ad=2.1312p pd=7.3u as=3.9294p ps=7.84u w=6.66u l=0.6u
M4887 sg13cmos5l_IOPadVdd$1_0.sg13cmos5l_Clamp_N43N43D4R$1_0.gate sg13cmos5l_IOPadVdd$1_0.sg13cmos5l_RCClampInverter$1_0.in vdd vdd sg13_hv_pmos ad=1.33p pd=7.38u as=1.33p ps=7.38u w=7u l=0.5u
M4888 sg13cmos5l_Corner_1.vss a_30676_102044# vip sg13cmos5l_Corner_1.vss sg13_hv_nmos ad=1.408p pd=5.04u as=2.596p ps=5.58u w=4.4u l=0.6u
M4889 a_95560_96920# adc8b_0.sar12b_0.sg13cmos5l_or2_1_1.B adc8b_0.sar12b_0.sg13cmos5l_a22oi_1_1.B2 sg13cmos5l_Corner_1.vss sg13_lv_nmos ad=0.1406p pd=1.12u as=0.2516p ps=2.16u w=0.74u l=0.13u
M4890 a_99154_93009# a_99597_92765# a_99537_93177# vdd sg13_lv_pmos ad=79.8f pd=0.8u as=63f ps=0.72u w=0.42u l=0.13u
M4891 sg13cmos5l_Corner_1.vss a_99639_178370# sg13cmos5l_IOPadAnalog_15.pad sg13cmos5l_Corner_1.vss sg13_hv_nmos ad=2.068p pd=9.74u as=2.596p ps=5.58u w=4.4u l=0.6u
M4892 frame a_134044_42476# sg13cmos5l_Corner_1.iovdd sg13cmos5l_Corner_1.iovdd sg13_hv_pmos ad=3.9294p pd=7.84u as=2.1312p ps=7.3u w=6.66u l=0.6u
M4893 adc8b_0.side_cap8b_1.buf_32_1.z adc8b_0.sar12b_0.nh_sw[0] vddr vddr sg13_lv_pmos ad=0.19p pd=1.38u as=0.19p ps=1.38u w=1u l=0.13u
M4894 sg13cmos5l_Corner_1.iovdd a_86044_42476# data[1] sg13cmos5l_Corner_1.iovdd sg13_hv_pmos ad=2.1312p pd=7.3u as=3.9294p ps=7.84u w=6.66u l=0.6u
M4895 vddr a_30676_70044# sg13cmos5l_Corner_1.vss sg13cmos5l_Corner_1.vss sg13_hv_nmos ad=2.596p pd=5.58u as=1.408p ps=5.04u w=4.4u l=0.6u
M4896 vdd adc8b_0.sar12b_0.sg13cmos5l_dfrbp_1_15.D a_85343_97713# vdd sg13_lv_pmos ad=0.1428p pd=1.52u as=79.8f ps=0.8u w=0.42u l=0.13u
M4897 a_84082_94521# a_84525_94277# a_84465_94689# vdd sg13_lv_pmos ad=79.8f pd=0.8u as=63f ps=0.72u w=0.42u l=0.13u
M4898 a_99468_94616# a_99987_94420# a_100727_94375# sg13cmos5l_Corner_1.vss sg13_lv_nmos ad=0.3473p pd=2.71u as=0.12665p ps=1.145u w=0.74u l=0.13u
M4899 vdd adc8b_0.sar12b_0.sg13cmos5l_buf_1_18.A a_100144_93548# vdd sg13_lv_pmos ad=0.2114p pd=1.54u as=0.2856p ps=2.36u w=0.84u l=0.13u
M4900 adc8b_0.sar12b_0.sg13cmos5l_dfrbp_1_18.Q_N a_89015_99957# sg13cmos5l_Corner_1.vss sg13cmos5l_Corner_1.vss sg13_lv_nmos ad=0.2849p pd=2.25u as=0.2516p ps=2.16u w=0.74u l=0.13u
M4901 a_87478_97010# a_87220_97010# sg13cmos5l_Corner_1.vss sg13cmos5l_Corner_1.vss sg13_lv_nmos ad=0.1428p pd=1.52u as=79.8f ps=0.8u w=0.42u l=0.13u
M4902 vdd adc8b_0.sar12b_0.sg13cmos5l_inv_1_26.Y a_99664_100384# vdd sg13_lv_pmos ad=0.2114p pd=1.54u as=0.2856p ps=2.36u w=0.84u l=0.13u
M4903 a_82893_96583# adc8b_0.sar12b_0.sg13cmos5l_dlhr_1_1.GATE sg13cmos5l_Corner_1.vss sg13cmos5l_Corner_1.vss sg13_lv_nmos ad=0.2516p pd=2.16u as=1.97045p ps=12.335u w=0.74u l=0.13u
M4904 adc8b_0.side_cap8b_1.buf_16_2.z adc8b_0.sar12b_0.nl_sw[1] vddr vddr sg13_lv_pmos ad=0.19p pd=1.38u as=0.19p ps=1.38u w=1u l=0.13u
M4905 sg13cmos5l_Corner_1.vss adc8b_0.side_cap8b_0.in_h_sw[0] adc8b_0.side_cap8b_0.buf_32_1.z sg13cmos5l_Corner_1.vss sg13_lv_nmos ad=95f pd=0.88u as=95f ps=0.88u w=0.5u l=0.13u
M4906 a_89015_99957# a_88173_99607# a_88921_99957# sg13cmos5l_Corner_1.vss sg13_lv_nmos ad=0.12665p pd=1.145u as=0.1428p ps=1.52u w=0.42u l=0.13u
M4907 a_84495_97540# a_84647_97592# sg13cmos5l_Corner_1.vss sg13cmos5l_Corner_1.vss sg13_lv_nmos ad=0.2516p pd=2.16u as=1.97045p ps=12.335u w=0.74u l=0.13u
M4908 sg13cmos5l_IOPadAnalog_15.pad a_99639_178370# sg13cmos5l_Corner_1.vss sg13cmos5l_Corner_1.vss sg13_hv_nmos ad=2.596p pd=5.58u as=1.408p ps=5.04u w=4.4u l=0.6u
M4909 adc8b_0.side_cap8b_1.buf_2_1.z adc8b_0.sar12b_0.nl_sw[8] vddr vddr sg13_lv_pmos ad=0.34p pd=2.68u as=0.19p ps=1.38u w=1u l=0.13u
M4910 a_83890_99564# a_84333_99607# a_83630_100034# sg13cmos5l_Corner_1.vss sg13_lv_nmos ad=79.8f pd=0.8u as=0.1296p ps=1.52u w=0.42u l=0.13u
.ends
