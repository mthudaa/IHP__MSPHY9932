* sar12b SPICE
.subckt sar12b VSS VDD ckc cko cks comp_p d_out[0] d_out[1] d_out[2] frame nh_sw[0]
+ nh_sw[10] nh_sw[1] nh_sw[2] nh_sw[3] nh_sw[4] nh_sw[5] nh_sw[6] nh_sw[7] nh_sw[8]
+ nh_sw[9] nl_sw[0] nl_sw[10] nl_sw[1] nl_sw[2] nl_sw[3] nl_sw[4] nl_sw[5] nl_sw[6]
+ nl_sw[7] nl_sw[8] nl_sw[9] ph_sw[0] ph_sw[10] ph_sw[1] ph_sw[2] ph_sw[3] ph_sw[4]
+ ph_sw[5] ph_sw[6] ph_sw[7] ph_sw[8] ph_sw[9] pl_sw[0] pl_sw[10] pl_sw[1] pl_sw[2]
+ pl_sw[3] pl_sw[4] pl_sw[5] pl_sw[6] pl_sw[7] pl_sw[8] pl_sw[9] rdy
XFILLER_10_114 VDD VSS sg13cmos5l_fill_1
XFILLER_6_107 VDD VSS sg13cmos5l_decap_8
XFILLER_6_118 VDD VSS sg13cmos5l_fill_2
X_83_ _83_/X _83_/A VDD VSS sg13cmos5l_buf_1
Xx5.x10 x5.x11/D x5.x10/Q_N x5.x9/CLK x5.x9/Q x5.x14/Y VDD VSS sg13cmos5l_dfrbp_1
XFILLER_5_173 VDD VSS sg13cmos5l_decap_8
X_49_ _49_/X _49_/A _49_/B VDD VSS sg13cmos5l_or2_1
X_66_ _66_/X _66_/A VDD VSS sg13cmos5l_buf_1
Xx6.e0 _44_/A x6.e0/Q_N x6.o2/CLK _40_/Y x6.xi/Y VDD VSS sg13cmos5l_dfrbp_1
Xx3_2.x8 _45_/A1 x3_2.x9/D x5.x4/D x3/D x4/Y VDD VSS sg13cmos5l_dfrbp_1
Xoutput20 nl_sw[0] _88_/X VDD VSS sg13cmos5l_buf_1
Xoutput31 ph_sw[0] _77_/X VDD VSS sg13cmos5l_buf_1
Xoutput42 pl_sw[0] _66_/X VDD VSS sg13cmos5l_buf_1
Xoutput7 d_out[2] _26_/A VDD VSS sg13cmos5l_buf_1
Xx5.x11 x5.x12/D x5.x11/Q_N x5.x9/CLK x5.x11/D x5.x14/Y VDD VSS sg13cmos5l_dfrbp_1
X_65_ _65_/X _65_/A VDD VSS sg13cmos5l_buf_1
X_82_ _82_/X _82_/A VDD VSS sg13cmos5l_buf_1
Xx3_5.x8 _46_/A1 x3_5.x9/D x5.x7/D x3/D x4/Y VDD VSS sg13cmos5l_dfrbp_1
XFILLER_0_14 VDD VSS sg13cmos5l_fill_1
XFILLER_7_203 VDD VSS sg13cmos5l_decap_4
X_48_ _48_/Y _48_/A _48_/B VDD VSS sg13cmos5l_nand2_1
Xx6.e1 _44_/B x6.e1/Q_N x6.o2/CLK _39_/Y x6.xi/Y VDD VSS sg13cmos5l_dfrbp_1
Xx3_2.x9 x3_2.x9/Q x3_2.x9/Q_N x3_2.x9/D x5.x4/D x4/Y VDD VSS sg13cmos5l_dlhr_1
Xoutput10 nh_sw[10] _89_/X VDD VSS sg13cmos5l_buf_1
Xoutput21 nl_sw[10] _78_/X VDD VSS sg13cmos5l_buf_1
Xoutput32 ph_sw[10] _67_/X VDD VSS sg13cmos5l_buf_1
Xoutput43 pl_sw[10] _56_/X VDD VSS sg13cmos5l_buf_1
Xoutput8 frame output8/A VDD VSS sg13cmos5l_buf_1
Xx3_8.x8 _46_/B2 x3_8.x9/D x5.x9/Q x3_9.x8/D x4/Y VDD VSS sg13cmos5l_dfrbp_1
XFILLER_3_14 VDD VSS sg13cmos5l_fill_1
X_81_ _81_/X _81_/A VDD VSS sg13cmos5l_buf_1
Xx5.x12 x3/CLK x5.x12/Q_N x5.x9/CLK x5.x12/D x5.x14/Y VDD VSS sg13cmos5l_dfrbp_1
X_47_ _47_/Y _26_/Y _48_/B _45_/Y _46_/Y VDD VSS sg13cmos5l_a22oi_1
X_64_ _64_/X _64_/A VDD VSS sg13cmos5l_buf_1
Xx6.xi x6.xi/Y cks VDD VSS sg13cmos5l_inv_1
Xx3_5.x9 x3_5.x9/Q x3_5.x9/Q_N x3_5.x9/D x5.x7/D x4/Y VDD VSS sg13cmos5l_dlhr_1
XFILLER_1_0 VDD VSS sg13cmos5l_fill_1
XFILLER_6_47 VDD VSS sg13cmos5l_decap_4
Xx6.c0 _41_/B x6.c0/Q_N x6.o2/CLK _43_/B x6.xi/Y VDD VSS sg13cmos5l_dfrbp_1
Xoutput11 nh_sw[1] _98_/X VDD VSS sg13cmos5l_buf_1
Xoutput22 nl_sw[1] _87_/X VDD VSS sg13cmos5l_buf_1
Xoutput33 ph_sw[1] _76_/X VDD VSS sg13cmos5l_buf_1
Xoutput44 pl_sw[1] _65_/X VDD VSS sg13cmos5l_buf_1
Xoutput9 nh_sw[0] _99_/X VDD VSS sg13cmos5l_buf_1
Xx5.x13 _43_/A x3/CLK VDD VSS sg13cmos5l_buf_8
Xx3_8.x9 x3_8.x9/Q x3_8.x9/Q_N x3_8.x9/D x5.x9/Q x4/Y VDD VSS sg13cmos5l_dlhr_1
XFILLER_5_143 VDD VSS sg13cmos5l_fill_2
X_63_ _63_/X _63_/A VDD VSS sg13cmos5l_buf_1
X_80_ _80_/X _80_/A VDD VSS sg13cmos5l_buf_1
Xx3 x3/Q x3/Q_N x3/CLK x3/D x4/Y VDD VSS sg13cmos5l_dfrbp_1
XFILLER_0_27 VDD VSS sg13cmos5l_fill_1
X_46_ _46_/Y _46_/A1 _31_/Y _49_/B _46_/B2 _44_/X VDD VSS sg13cmos5l_a221oi_1
Xx6.c1 _42_/A x6.c1/Q_N x6.o2/CLK _42_/Y x6.xi/Y VDD VSS sg13cmos5l_dfrbp_1
Xx6.buf_cko output4/A _43_/X VDD VSS sg13cmos5l_buf_8
XFILLER_0_211 VDD VSS sg13cmos5l_fill_1
X_29_ _48_/B _41_/B _42_/A VDD VSS sg13cmos5l_nand2b_1
Xoutput12 nh_sw[2] _97_/X VDD VSS sg13cmos5l_buf_1
Xoutput23 nl_sw[2] _86_/X VDD VSS sg13cmos5l_buf_1
Xoutput34 ph_sw[2] _75_/X VDD VSS sg13cmos5l_buf_1
Xoutput45 pl_sw[2] _64_/X VDD VSS sg13cmos5l_buf_1
Xx5.x14 x5.x14/Y cks VDD VSS sg13cmos5l_inv_1
XFILLER_5_100 VDD VSS sg13cmos5l_fill_2
XFILLER_5_166 VDD VSS sg13cmos5l_decap_8
X_62_ _62_/X _62_/A VDD VSS sg13cmos5l_buf_1
Xx4 x4/Y cks VDD VSS sg13cmos5l_inv_8
XFILLER_4_209 VDD VSS sg13cmos5l_fill_2
X_28_ _53_/A _41_/B _42_/A VDD VSS sg13cmos5l_nor2b_1
X_45_ _45_/Y _45_/A1 _52_/B _48_/B VDD VSS sg13cmos5l_a21oi_1
Xoutput13 nh_sw[3] _96_/X VDD VSS sg13cmos5l_buf_1
Xoutput24 nl_sw[3] _85_/X VDD VSS sg13cmos5l_buf_1
Xoutput35 ph_sw[3] _74_/X VDD VSS sg13cmos5l_buf_1
Xoutput46 pl_sw[3] _63_/X VDD VSS sg13cmos5l_buf_1
X_61_ _61_/X _61_/A VDD VSS sg13cmos5l_buf_1
Xx3_0.x1 x3_0.x3/A x3_0.x1/Q_N _35_/B2 x5.x2/D x4/Y VDD VSS sg13cmos5l_dlhr_1
XFILLER_7_207 VDD VSS sg13cmos5l_fill_1
X_44_ _44_/X _44_/A _44_/B x3/Q VDD VSS sg13cmos5l_and3_1
X_27_ _27_/Y _27_/A VDD VSS sg13cmos5l_inv_1
Xx3_3.x1 x3_3.x3/A x3_3.x1/Q_N _34_/A1 x5.x5/D x4/Y VDD VSS sg13cmos5l_dlhr_1
XFILLER_7_93 VDD VSS sg13cmos5l_fill_1
Xoutput14 nh_sw[4] _95_/X VDD VSS sg13cmos5l_buf_1
Xoutput25 nl_sw[4] _84_/X VDD VSS sg13cmos5l_buf_1
Xoutput36 ph_sw[4] _73_/X VDD VSS sg13cmos5l_buf_1
Xoutput47 pl_sw[4] _62_/X VDD VSS sg13cmos5l_buf_1
Xx3_0.x2 _66_/A _99_/A VDD VSS sg13cmos5l_inv_1
X_60_ _60_/X _60_/A VDD VSS sg13cmos5l_buf_1
Xx5.x1 x5.x2/D x5.x1/Q_N x1.x2/A x5.x1/D x5.x14/Y VDD VSS sg13cmos5l_dfrbp_1
XFILLER_1_95 VDD VSS sg13cmos5l_fill_2
X_26_ _26_/Y _26_/A VDD VSS sg13cmos5l_inv_1
X_43_ _43_/X _43_/A _43_/B VDD VSS sg13cmos5l_or2_1
Xx3_6.x1 x3_6.x3/A x3_6.x1/Q_N _35_/A1 x5.x8/D x4/Y VDD VSS sg13cmos5l_dlhr_1
XFILLER_3_200 VDD VSS sg13cmos5l_fill_1
XFILLER_7_72 VDD VSS sg13cmos5l_fill_2
Xoutput15 nh_sw[5] _94_/X VDD VSS sg13cmos5l_buf_1
Xoutput26 nl_sw[5] _83_/X VDD VSS sg13cmos5l_buf_1
Xoutput37 ph_sw[5] _72_/X VDD VSS sg13cmos5l_buf_1
Xoutput48 pl_sw[5] _61_/X VDD VSS sg13cmos5l_buf_1
Xx3_3.x2 _63_/A _96_/A VDD VSS sg13cmos5l_inv_1
Xx3_0.x3 _77_/A x3_0.x3/A VDD VSS sg13cmos5l_buf_1
Xx3_9.x1 x3_9.x3/A x3_9.x1/Q_N _30_/C x5.x11/D x4/Y VDD VSS sg13cmos5l_dlhr_1
X_42_ _42_/Y _42_/A _41_/B VDD VSS sg13cmos5l_nor2b_1
Xx5.x2 x5.x3/D x5.x2/Q_N x1.x2/A x5.x2/D x5.x14/Y VDD VSS sg13cmos5l_dfrbp_1
Xx3_6.x2 _60_/A _93_/A VDD VSS sg13cmos5l_inv_1
X_25_ _25_/Y _44_/B VDD VSS sg13cmos5l_inv_1
Xx6.buf_frm output8/A cks VDD VSS sg13cmos5l_buf_8
Xx3_3.x3 _74_/A x3_3.x3/A VDD VSS sg13cmos5l_buf_1
XFILLER_7_51 VDD VSS sg13cmos5l_decap_8
Xoutput16 nh_sw[6] _93_/X VDD VSS sg13cmos5l_buf_1
Xoutput27 nl_sw[6] _82_/X VDD VSS sg13cmos5l_buf_1
Xoutput38 ph_sw[6] _71_/X VDD VSS sg13cmos5l_buf_1
Xoutput49 pl_sw[6] _60_/X VDD VSS sg13cmos5l_buf_1
Xx3_0.x4 _88_/A _77_/A VDD VSS sg13cmos5l_inv_1
Xx5.x3 x5.x4/D x5.x3/Q_N x1.x2/A x5.x3/D x5.x14/Y VDD VSS sg13cmos5l_dfrbp_1
Xx3_9.x2 _57_/A _90_/A VDD VSS sg13cmos5l_inv_1
X_24_ _24_/Y _24_/A VDD VSS sg13cmos5l_inv_1
X_41_ _43_/B _42_/A _41_/B VDD VSS sg13cmos5l_nor2_1
Xx3_6.x3 _71_/A x3_6.x3/A VDD VSS sg13cmos5l_buf_1
Xoutput17 nh_sw[7] _92_/X VDD VSS sg13cmos5l_buf_1
Xoutput28 nl_sw[7] _81_/X VDD VSS sg13cmos5l_buf_1
Xoutput39 ph_sw[7] _70_/X VDD VSS sg13cmos5l_buf_1
Xx3_3.x4 _85_/A _74_/A VDD VSS sg13cmos5l_inv_1
XFILLER_5_127 VDD VSS sg13cmos5l_fill_2
XFILLER_7_74 VDD VSS sg13cmos5l_fill_1
Xx3_0.x5 _99_/A x3_0.x9/Q VDD VSS sg13cmos5l_buf_1
Xx3_9.x3 _68_/A x3_9.x3/A VDD VSS sg13cmos5l_buf_1
XFILLER_8_0 VDD VSS sg13cmos5l_fill_1
X_40_ _40_/Y _44_/A _48_/B VDD VSS sg13cmos5l_xnor2_1
Xx5.x4 x5.x5/D x5.x4/Q_N x1.x2/A x5.x4/D x5.x14/Y VDD VSS sg13cmos5l_dfrbp_1
Xx3_6.x4 _82_/A _71_/A VDD VSS sg13cmos5l_inv_1
XFILLER_6_211 VDD VSS sg13cmos5l_fill_1
Xx3_3.x5 _96_/A x3_3.x9/Q VDD VSS sg13cmos5l_buf_1
Xoutput18 nh_sw[8] _91_/X VDD VSS sg13cmos5l_buf_1
Xoutput29 nl_sw[8] _80_/X VDD VSS sg13cmos5l_buf_1
XFILLER_8_147 VDD VSS sg13cmos5l_fill_2
Xx1.x12 x1.x6/A x1.x1/Y VDD VSS sg13cmos5l_dlygate4sd2_1
Xx5.x5 x5.x6/D x5.x5/Q_N x1.x2/A x5.x5/D x5.x14/Y VDD VSS sg13cmos5l_dfrbp_1
Xx3_9.x4 _79_/A _68_/A VDD VSS sg13cmos5l_inv_1
X_99_ _99_/X _99_/A VDD VSS sg13cmos5l_buf_1
Xfanout53 x1.x2/A input2/X VDD VSS sg13cmos5l_buf_1
Xx3_6.x5 _93_/A x3_6.x9/Q VDD VSS sg13cmos5l_buf_1
Xoutput19 nh_sw[9] _90_/X VDD VSS sg13cmos5l_buf_1
XFILLER_7_32 VDD VSS sg13cmos5l_fill_1
XFILLER_7_65 VDD VSS sg13cmos5l_decap_8
Xx3_9.x5 _90_/A x3_9.x9/Q VDD VSS sg13cmos5l_buf_1
XFILLER_4_11 VDD VSS sg13cmos5l_fill_1
XFILLER_5_129 VDD VSS sg13cmos5l_fill_1
Xfanout54 x5.x9/CLK input2/X VDD VSS sg13cmos5l_buf_1
Xx5.x6 x5.x7/D x5.x6/Q_N x1.x2/A x5.x6/D x5.x14/Y VDD VSS sg13cmos5l_dfrbp_1
X_98_ _98_/X _98_/A VDD VSS sg13cmos5l_buf_1
XFILLER_4_141 VDD VSS sg13cmos5l_decap_8
Xx3_0.x8 _35_/B2 x3_0.x9/D x5.x2/D x3/D x4/Y VDD VSS sg13cmos5l_dfrbp_1
XFILLER_1_111 VDD VSS sg13cmos5l_fill_1
XFILLER_6_0 VDD VSS sg13cmos5l_decap_8
X_97_ _97_/X _97_/A VDD VSS sg13cmos5l_buf_1
Xfanout55 x3/D input1/X VDD VSS sg13cmos5l_buf_1
Xx5.x7 x5.x8/D x5.x7/Q_N x1.x2/A x5.x7/D x5.x14/Y VDD VSS sg13cmos5l_dfrbp_1
Xinput1 input1/X comp_p VDD VSS sg13cmos5l_buf_1
Xx3_3.x8 _34_/A1 x3_3.x9/D x5.x5/D x3/D x4/Y VDD VSS sg13cmos5l_dfrbp_1
Xx3_0.x9 x3_0.x9/Q x3_0.x9/Q_N x3_0.x9/D x5.x2/D x4/Y VDD VSS sg13cmos5l_dlhr_1
Xfanout56 x3_9.x8/D input1/X VDD VSS sg13cmos5l_buf_1
Xx5.x8 x5.x9/D x5.x8/Q_N x5.x9/CLK x5.x8/D x5.x14/Y VDD VSS sg13cmos5l_dfrbp_1
X_79_ _79_/X _79_/A VDD VSS sg13cmos5l_buf_1
X_96_ _96_/X _96_/A VDD VSS sg13cmos5l_buf_1
Xinput2 input2/X rdy VDD VSS sg13cmos5l_buf_1
Xx3_6.x8 _35_/A1 x3_6.x9/D x5.x8/D x3/D x4/Y VDD VSS sg13cmos5l_dfrbp_1
Xx3_3.x9 x3_3.x9/Q x3_3.x9/Q_N x3_3.x9/D x5.x5/D x4/Y VDD VSS sg13cmos5l_dlhr_1
XFILLER_4_187 VDD VSS sg13cmos5l_fill_1
Xx3_9.x8 _30_/C x3_9.x9/D x5.x11/D x3_9.x8/D x4/Y VDD VSS sg13cmos5l_dfrbp_1
XFILLER_8_5 VDD VSS sg13cmos5l_fill_2
X_95_ _95_/X _95_/A VDD VSS sg13cmos5l_buf_1
Xx6.inv_rdy x6.o2/CLK x5.x9/CLK VDD VSS sg13cmos5l_inv_1
Xx5.x9 x5.x9/Q x5.x9/Q_N x5.x9/CLK x5.x9/D x5.x14/Y VDD VSS sg13cmos5l_dfrbp_1
Xx3_6.x9 x3_6.x9/Q x3_6.x9/Q_N x3_6.x9/D x5.x8/D x4/Y VDD VSS sg13cmos5l_dlhr_1
X_78_ _78_/X _78_/A VDD VSS sg13cmos5l_buf_1
XFILLER_2_91 VDD VSS sg13cmos5l_decap_8
XFILLER_7_58 VDD VSS sg13cmos5l_decap_8
Xx3_9.x9 x3_9.x9/Q x3_9.x9/Q_N x3_9.x9/D x5.x11/D x4/Y VDD VSS sg13cmos5l_dlhr_1
X_77_ _77_/X _77_/A VDD VSS sg13cmos5l_buf_1
X_94_ _94_/X _94_/A VDD VSS sg13cmos5l_buf_1
XFILLER_10_14 VDD VSS sg13cmos5l_fill_1
XFILLER_8_7 VDD VSS sg13cmos5l_fill_1
X_93_ _93_/X _93_/A VDD VSS sg13cmos5l_buf_1
X_76_ _76_/X _76_/A VDD VSS sg13cmos5l_buf_1
X_59_ _59_/X _59_/A VDD VSS sg13cmos5l_buf_1
XFILLER_7_198 VDD VSS sg13cmos5l_fill_1
Xx3_1.x1 x3_1.x3/A x3_1.x1/Q_N _52_/A_N x5.x3/D x4/Y VDD VSS sg13cmos5l_dlhr_1
XFILLER_1_18 VDD VSS sg13cmos5l_decap_4
X_92_ _92_/X _92_/A VDD VSS sg13cmos5l_buf_1
XFILLER_10_27 VDD VSS sg13cmos5l_fill_2
XFILLER_2_83 VDD VSS sg13cmos5l_fill_2
X_58_ _58_/X _58_/A VDD VSS sg13cmos5l_buf_1
X_75_ _75_/X _75_/A VDD VSS sg13cmos5l_buf_1
Xx5.x1_57 x5.x1/D VDD VSS sg13cmos5l_tiehi
Xx3_4.x1 x3_4.x3/A x3_4.x1/Q_N _51_/A2 x5.x6/D x4/Y VDD VSS sg13cmos5l_dlhr_1
XFILLER_0_172 VDD VSS sg13cmos5l_fill_2
X_91_ _91_/X _91_/A VDD VSS sg13cmos5l_buf_1
Xx3_1.x2 _65_/A _98_/A VDD VSS sg13cmos5l_inv_1
XFILLER_6_209 VDD VSS sg13cmos5l_fill_2
X_74_ _74_/X _74_/A VDD VSS sg13cmos5l_buf_1
Xx3_7.x1 x3_7.x3/A x3_7.x1/Q_N _27_/A x5.x9/D x4/Y VDD VSS sg13cmos5l_dlhr_1
XFILLER_2_0 VDD VSS sg13cmos5l_fill_2
X_57_ _57_/X _57_/A VDD VSS sg13cmos5l_buf_1
Xx3_4.x2 _62_/A _95_/A VDD VSS sg13cmos5l_inv_1
XFILLER_4_126 VDD VSS sg13cmos5l_fill_2
XFILLER_4_148 VDD VSS sg13cmos5l_decap_8
XFILLER_7_189 VDD VSS sg13cmos5l_fill_2
XFILLER_8_50 VDD VSS sg13cmos5l_decap_8
Xx3_1.x3 _76_/A x3_1.x3/A VDD VSS sg13cmos5l_buf_1
XFILLER_6_7 VDD VSS sg13cmos5l_fill_2
X_90_ _90_/X _90_/A VDD VSS sg13cmos5l_buf_1
Xx3_10.x1 x3_10.x3/A x3_10.x1/Q_N _49_/A x5.x12/D x4/Y VDD VSS sg13cmos5l_dlhr_1
X_56_ _56_/X _56_/A VDD VSS sg13cmos5l_buf_1
X_73_ _73_/X _73_/A VDD VSS sg13cmos5l_buf_1
Xx3_7.x2 _59_/A _92_/A VDD VSS sg13cmos5l_inv_1
X_39_ _39_/Y _39_/A VDD VSS sg13cmos5l_inv_1
Xx3_4.x3 _73_/A x3_4.x3/A VDD VSS sg13cmos5l_buf_1
Xx3_1.x4 _87_/A _76_/A VDD VSS sg13cmos5l_inv_1
XFILLER_10_0 VDD VSS sg13cmos5l_fill_2
XFILLER_5_211 VDD VSS sg13cmos5l_fill_1
XFILLER_5_41 VDD VSS sg13cmos5l_decap_4
X_72_ _72_/X _72_/A VDD VSS sg13cmos5l_buf_1
Xx3_7.x3 _70_/A x3_7.x3/A VDD VSS sg13cmos5l_buf_1
Xx3_10.x2 _56_/A _89_/A VDD VSS sg13cmos5l_inv_1
XFILLER_2_64 VDD VSS sg13cmos5l_fill_1
Xx3_4.x4 _84_/A _73_/A VDD VSS sg13cmos5l_inv_1
XFILLER_4_128 VDD VSS sg13cmos5l_fill_1
X_38_ _39_/A _53_/A _31_/Y _37_/Y _44_/B VDD VSS sg13cmos5l_a22oi_1
XFILLER_5_75 VDD VSS sg13cmos5l_decap_4
XFILLER_6_9 VDD VSS sg13cmos5l_fill_1
Xx3_10.x3 _67_/A x3_10.x3/A VDD VSS sg13cmos5l_buf_1
Xx3_1.x5 _98_/A x3_1.x9/Q VDD VSS sg13cmos5l_buf_1
X_54_ _54_/Y _51_/Y _53_/Y _48_/Y VDD VSS sg13cmos5l_o21ai_1
X_71_ _71_/X _71_/A VDD VSS sg13cmos5l_buf_1
Xx3_7.x4 _81_/A _70_/A VDD VSS sg13cmos5l_inv_1
X_37_ _37_/Y _44_/A _53_/A VDD VSS sg13cmos5l_nand2_1
Xx3_4.x5 _95_/A x3_4.x9/Q VDD VSS sg13cmos5l_buf_1
XFILLER_0_154 VDD VSS sg13cmos5l_fill_1
X_70_ _70_/X _70_/A VDD VSS sg13cmos5l_buf_1
Xx3_7.x5 _92_/A x3_7.x9/Q VDD VSS sg13cmos5l_buf_1
Xx3_10.x4 _78_/A _67_/A VDD VSS sg13cmos5l_inv_1
X_53_ _53_/Y _53_/A _53_/B VDD VSS sg13cmos5l_nand2_1
XFILLER_7_116 VDD VSS sg13cmos5l_fill_2
X_36_ _36_/Y _24_/Y _48_/B _34_/Y _35_/Y VDD VSS sg13cmos5l_a22oi_1
XFILLER_5_33 VDD VSS sg13cmos5l_decap_4
XFILLER_2_206 VDD VSS sg13cmos5l_fill_2
X_52_ _53_/B _52_/A_N _52_/B VDD VSS sg13cmos5l_nand2b_1
Xx3_10.x5 _89_/A x3_10.x9/Q VDD VSS sg13cmos5l_buf_1
X_35_ _35_/Y _35_/A1 _49_/B _52_/B _35_/B2 _30_/X VDD VSS sg13cmos5l_a221oi_1
XFILLER_8_11 VDD VSS sg13cmos5l_fill_2
Xx3_1.x8 _52_/A_N x3_1.x9/D x5.x3/D x3/D x4/Y VDD VSS sg13cmos5l_dfrbp_1
XFILLER_5_45 VDD VSS sg13cmos5l_fill_1
X_51_ _51_/Y _25_/Y _51_/A2 _49_/X _50_/Y _52_/B VDD VSS sg13cmos5l_a221oi_1
X_34_ _34_/Y _34_/A1 _31_/Y _48_/B VDD VSS sg13cmos5l_a21oi_1
Xx3_4.x8 _51_/A2 x3_4.x9/D x5.x6/D x3/D x4/Y VDD VSS sg13cmos5l_dfrbp_1
Xx3_1.x9 x3_1.x9/Q x3_1.x9/Q_N x3_1.x9/D x5.x3/D x4/Y VDD VSS sg13cmos5l_dlhr_1
Xx3_7.x8 _27_/A x3_7.x9/D x5.x9/D x3_9.x8/D x4/Y VDD VSS sg13cmos5l_dfrbp_1
X_33_ _52_/B _44_/A _44_/B VDD VSS sg13cmos5l_nor2_1
X_50_ _50_/Y _27_/Y _49_/B _31_/Y VDD VSS sg13cmos5l_a21oi_1
Xx3_4.x9 x3_4.x9/Q x3_4.x9/Q_N x3_4.x9/D x5.x6/D x4/Y VDD VSS sg13cmos5l_dlhr_1
XFILLER_10_181 VDD VSS sg13cmos5l_fill_1
XFILLER_6_152 VDD VSS sg13cmos5l_fill_2
XFILLER_8_13 VDD VSS sg13cmos5l_fill_1
XFILLER_8_57 VDD VSS sg13cmos5l_decap_4
XFILLER_8_203 VDD VSS sg13cmos5l_fill_1
Xx6.o0 _24_/A x6.o0/Q_N x6.o2/CLK _36_/Y x6.xi/Y VDD VSS sg13cmos5l_dfrbp_1
Xx3_10.x8 _49_/A x3_10.x9/D x5.x12/D x3_9.x8/D x4/Y VDD VSS sg13cmos5l_dfrbp_1
Xx3_7.x9 x3_7.x9/Q x3_7.x9/Q_N x3_7.x9/D x5.x9/D x4/Y VDD VSS sg13cmos5l_dlhr_1
X_32_ _49_/B _44_/A _44_/B VDD VSS sg13cmos5l_nor2b_1
Xx6.o1 _48_/A x6.o1/Q_N x6.o2/CLK _54_/Y x6.xi/Y VDD VSS sg13cmos5l_dfrbp_1
Xx3_10.x9 x3_10.x9/Q x3_10.x9/Q_N x3_10.x9/D x5.x12/D x4/Y VDD VSS sg13cmos5l_dlhr_1
X_31_ _31_/Y _44_/B _44_/A VDD VSS sg13cmos5l_nor2b_1
XFILLER_3_92 VDD VSS sg13cmos5l_decap_8
Xx6.o2 _26_/A x6.o2/Q_N x6.o2/CLK _47_/Y x6.xi/Y VDD VSS sg13cmos5l_dfrbp_1
XFILLER_10_195 VDD VSS sg13cmos5l_fill_1
XFILLER_3_82 VDD VSS sg13cmos5l_fill_2
X_30_ _30_/X _44_/A _44_/B _30_/C VDD VSS sg13cmos5l_and3_1
Xx1.x1 x1.x1/Y x1.x2/Y x1.x5/Y VDD VSS sg13cmos5l_nand2_1
XFILLER_5_209 VDD VSS sg13cmos5l_fill_2
Xx3_2.x1 x3_2.x3/A x3_2.x1/Q_N _45_/A1 x5.x4/D x4/Y VDD VSS sg13cmos5l_dlhr_1
X_89_ _89_/X _89_/A VDD VSS sg13cmos5l_buf_1
Xx3_5.x1 x3_5.x3/A x3_5.x1/Q_N _46_/A1 x5.x7/D x4/Y VDD VSS sg13cmos5l_dlhr_1
XFILLER_0_107 VDD VSS sg13cmos5l_fill_2
Xx1.x2 x1.x2/Y x1.x2/A VDD VSS sg13cmos5l_inv_1
Xx3_2.x2 _64_/A _97_/A VDD VSS sg13cmos5l_inv_1
XFILLER_9_143 VDD VSS sg13cmos5l_fill_2
X_88_ _88_/X _88_/A VDD VSS sg13cmos5l_buf_1
Xx3_8.x1 x3_8.x3/A x3_8.x1/Q_N _46_/B2 x5.x9/Q x4/Y VDD VSS sg13cmos5l_dlhr_1
XFILLER_0_85 VDD VSS sg13cmos5l_fill_1
XFILLER_10_164 VDD VSS sg13cmos5l_fill_1
XFILLER_10_186 VDD VSS sg13cmos5l_fill_1
Xx3_5.x2 _61_/A _94_/A VDD VSS sg13cmos5l_inv_1
XFILLER_4_211 VDD VSS sg13cmos5l_fill_1
Xx1.x3 x1.x4/A cks VDD VSS sg13cmos5l_inv_1
Xx3_2.x3 _75_/A x3_2.x3/A VDD VSS sg13cmos5l_buf_1
XFILLER_6_51 VDD VSS sg13cmos5l_fill_1
Xx3_8.x2 _58_/A _91_/A VDD VSS sg13cmos5l_inv_1
XFILLER_3_52 VDD VSS sg13cmos5l_fill_1
XFILLER_5_180 VDD VSS sg13cmos5l_decap_8
XFILLER_6_114 VDD VSS sg13cmos5l_decap_4
X_87_ _87_/X _87_/A VDD VSS sg13cmos5l_buf_1
Xx3_5.x3 _72_/A x3_5.x3/A VDD VSS sg13cmos5l_buf_1
Xx1.x4 x1.x5/A x1.x4/A VDD VSS sg13cmos5l_inv_1
Xx3_2.x4 _86_/A _75_/A VDD VSS sg13cmos5l_inv_1
X_86_ _86_/X _86_/A VDD VSS sg13cmos5l_buf_1
Xoutput3 ckc x1.x7/Y VDD VSS sg13cmos5l_buf_1
Xx3_8.x3 _69_/A x3_8.x3/A VDD VSS sg13cmos5l_buf_1
XFILLER_0_32 VDD VSS sg13cmos5l_fill_2
XFILLER_0_54 VDD VSS sg13cmos5l_fill_1
X_69_ _69_/X _69_/A VDD VSS sg13cmos5l_buf_1
Xx3_5.x4 _83_/A _72_/A VDD VSS sg13cmos5l_inv_1
Xx1.x5 x1.x5/Y x1.x5/A _43_/A VDD VSS sg13cmos5l_nor2_1
Xx3_2.x5 _97_/A x3_2.x9/Q VDD VSS sg13cmos5l_buf_1
Xoutput4 cko output4/A VDD VSS sg13cmos5l_buf_1
Xoutput50 pl_sw[7] _59_/X VDD VSS sg13cmos5l_buf_1
Xx3_8.x4 _80_/A _69_/A VDD VSS sg13cmos5l_inv_1
XFILLER_9_113 VDD VSS sg13cmos5l_fill_2
X_85_ _85_/X _85_/A VDD VSS sg13cmos5l_buf_1
Xx3_5.x5 _94_/A x3_5.x9/Q VDD VSS sg13cmos5l_buf_1
XFILLER_2_130 VDD VSS sg13cmos5l_fill_1
X_68_ _68_/X _68_/A VDD VSS sg13cmos5l_buf_1
Xx1.x6 x1.x7/A x1.x6/A VDD VSS sg13cmos5l_dlygate4sd3_1
XFILLER_3_44 VDD VSS sg13cmos5l_fill_1
X_84_ _84_/X _84_/A VDD VSS sg13cmos5l_buf_1
Xoutput40 ph_sw[8] _69_/X VDD VSS sg13cmos5l_buf_1
Xoutput5 d_out[0] _24_/A VDD VSS sg13cmos5l_buf_1
Xoutput51 pl_sw[8] _58_/X VDD VSS sg13cmos5l_buf_1
Xx3_8.x5 _91_/A x3_8.x9/Q VDD VSS sg13cmos5l_buf_1
XFILLER_2_175 VDD VSS sg13cmos5l_fill_2
XFILLER_3_0 VDD VSS sg13cmos5l_fill_1
X_67_ _67_/X _67_/A VDD VSS sg13cmos5l_buf_1
XFILLER_0_12 VDD VSS sg13cmos5l_fill_2
XFILLER_9_54 VDD VSS sg13cmos5l_fill_1
Xx1.x7 x1.x7/Y x1.x7/A VDD VSS sg13cmos5l_inv_1
XFILLER_1_207 VDD VSS sg13cmos5l_fill_1
Xoutput30 nl_sw[9] _79_/X VDD VSS sg13cmos5l_buf_1
Xoutput41 ph_sw[9] _68_/X VDD VSS sg13cmos5l_buf_1
Xoutput52 pl_sw[9] _57_/X VDD VSS sg13cmos5l_buf_1
Xoutput6 d_out[1] _48_/A VDD VSS sg13cmos5l_buf_1
.ends
